* NGSPICE file created from mesh_tile.ext - technology: gf180mcuD

* Black-box entry subcircuit for gf180mcu_as_sc_mcu7t3v3__fillcap_16 abstract view
.subckt gf180mcu_as_sc_mcu7t3v3__fillcap_16 VDD VNW VPW VSS
.ends

* Black-box entry subcircuit for gf180mcu_as_sc_mcu7t3v3__tap_2 abstract view
.subckt gf180mcu_as_sc_mcu7t3v3__tap_2 VDD VSS
.ends

* Black-box entry subcircuit for gf180mcu_as_sc_mcu7t3v3__ao22_2 abstract view
.subckt gf180mcu_as_sc_mcu7t3v3__ao22_2 VDD VNW VPW VSS A B C D Y
.ends

* Black-box entry subcircuit for gf180mcu_as_sc_mcu7t3v3__or2_2 abstract view
.subckt gf180mcu_as_sc_mcu7t3v3__or2_2 VDD VNW VPW VSS B A Y
.ends

* Black-box entry subcircuit for gf180mcu_as_sc_mcu7t3v3__fillcap_4 abstract view
.subckt gf180mcu_as_sc_mcu7t3v3__fillcap_4 VDD VNW VPW VSS
.ends

* Black-box entry subcircuit for gf180mcu_as_sc_mcu7t3v3__fillcap_8 abstract view
.subckt gf180mcu_as_sc_mcu7t3v3__fillcap_8 VDD VNW VPW VSS
.ends

* Black-box entry subcircuit for gf180mcu_as_sc_mcu7t3v3__nor2_2 abstract view
.subckt gf180mcu_as_sc_mcu7t3v3__nor2_2 VDD VNW VPW VSS Y B A
.ends

* Black-box entry subcircuit for gf180mcu_as_sc_mcu7t3v3__fill_1 abstract view
.subckt gf180mcu_as_sc_mcu7t3v3__fill_1 VDD VNW VPW VSS
.ends

* Black-box entry subcircuit for gf180mcu_as_sc_mcu7t3v3__fill_2 abstract view
.subckt gf180mcu_as_sc_mcu7t3v3__fill_2 VDD VNW VPW VSS
.ends

* Black-box entry subcircuit for gf180mcu_as_sc_mcu7t3v3__buff_2 abstract view
.subckt gf180mcu_as_sc_mcu7t3v3__buff_2 VDD VNW VPW VSS A Y
.ends

* Black-box entry subcircuit for gf180mcu_as_sc_mcu7t3v3__dfxtp_2 abstract view
.subckt gf180mcu_as_sc_mcu7t3v3__dfxtp_2 VDD VNW VPW VSS CLK D Q
.ends

* Black-box entry subcircuit for gf180mcu_as_sc_mcu7t3v3__nand2b_2 abstract view
.subckt gf180mcu_as_sc_mcu7t3v3__nand2b_2 VDD VNW VPW VSS Y B A
.ends

* Black-box entry subcircuit for gf180mcu_as_sc_mcu7t3v3__ao211_2 abstract view
.subckt gf180mcu_as_sc_mcu7t3v3__ao211_2 VDD VNW VPW VSS A B C D Y
.ends

* Black-box entry subcircuit for gf180mcu_as_sc_mcu7t3v3__mux2_2 abstract view
.subckt gf180mcu_as_sc_mcu7t3v3__mux2_2 VDD VNW VPW VSS S B A Y
.ends

* Black-box entry subcircuit for gf180mcu_as_sc_mcu7t3v3__inv_2 abstract view
.subckt gf180mcu_as_sc_mcu7t3v3__inv_2 VDD VNW VPW VSS Y A
.ends

* Black-box entry subcircuit for gf180mcu_as_sc_mcu7t3v3__aoi211_2 abstract view
.subckt gf180mcu_as_sc_mcu7t3v3__aoi211_2 VDD VNW VPW VSS A B C Y D
.ends

* Black-box entry subcircuit for gf180mcu_as_sc_mcu7t3v3__ao21_2 abstract view
.subckt gf180mcu_as_sc_mcu7t3v3__ao21_2 VDD VNW VPW VSS Y A B C
.ends

* Black-box entry subcircuit for gf180mcu_as_sc_mcu7t3v3__aoi21_2 abstract view
.subckt gf180mcu_as_sc_mcu7t3v3__aoi21_2 VDD VNW VPW VSS Y C B A
.ends

* Black-box entry subcircuit for gf180mcu_as_sc_mcu7t3v3__nand2_2 abstract view
.subckt gf180mcu_as_sc_mcu7t3v3__nand2_2 VDD VNW VPW VSS Y B A
.ends

* Black-box entry subcircuit for gf180mcu_as_sc_mcu7t3v3__nor3_2 abstract view
.subckt gf180mcu_as_sc_mcu7t3v3__nor3_2 VDD VNW VPW VSS A B C Y
.ends

* Black-box entry subcircuit for gf180mcu_as_sc_mcu7t3v3__ao31_2 abstract view
.subckt gf180mcu_as_sc_mcu7t3v3__ao31_2 VDD VNW VPW VSS D A B C Y
.ends

* Black-box entry subcircuit for gf180mcu_as_sc_mcu7t3v3__tiel_4 abstract view
.subckt gf180mcu_as_sc_mcu7t3v3__tiel_4 VDD VNW VPW VSS ZERO
.ends

* Black-box entry subcircuit for gf180mcu_as_sc_mcu7t3v3__diode_2 abstract view
.subckt gf180mcu_as_sc_mcu7t3v3__diode_2 VDD VNW VPW VSS DIODE
.ends

* Black-box entry subcircuit for gf180mcu_as_sc_mcu7t3v3__and2_2 abstract view
.subckt gf180mcu_as_sc_mcu7t3v3__and2_2 VDD VNW VPW VSS B A Y
.ends

* Black-box entry subcircuit for gf180mcu_as_sc_mcu7t3v3__clkbuff_12 abstract view
.subckt gf180mcu_as_sc_mcu7t3v3__clkbuff_12 VDD VNW VPW VSS A Y
.ends

* Black-box entry subcircuit for gf180mcu_as_sc_mcu7t3v3__aoi21b_2 abstract view
.subckt gf180mcu_as_sc_mcu7t3v3__aoi21b_2 VDD VNW VPW VSS Y C B A
.ends

* Black-box entry subcircuit for gf180mcu_as_sc_mcu7t3v3__nor2b_2 abstract view
.subckt gf180mcu_as_sc_mcu7t3v3__nor2b_2 VDD VNW VPW VSS Y B A
.ends

* Black-box entry subcircuit for gf180mcu_as_sc_mcu7t3v3__xnor2_2 abstract view
.subckt gf180mcu_as_sc_mcu7t3v3__xnor2_2 VDD VNW VPW VSS B A Y
.ends

* Black-box entry subcircuit for gf180mcu_as_sc_mcu7t3v3__nand3_2 abstract view
.subckt gf180mcu_as_sc_mcu7t3v3__nand3_2 VDD VNW VPW VSS A B C Y
.ends

* Black-box entry subcircuit for gf180mcu_as_sc_mcu7t3v3__oai211_2 abstract view
.subckt gf180mcu_as_sc_mcu7t3v3__oai211_2 VDD VNW VPW VSS A B C Y D
.ends

* Black-box entry subcircuit for gf180mcu_as_sc_mcu7t3v3__inv_4 abstract view
.subckt gf180mcu_as_sc_mcu7t3v3__inv_4 VDD VNW VPW VSS Y A
.ends

* Black-box entry subcircuit for gf180mcu_as_sc_mcu7t3v3__aoi22_2 abstract view
.subckt gf180mcu_as_sc_mcu7t3v3__aoi22_2 VDD VNW VPW VSS Y A B C D
.ends

* Black-box entry subcircuit for gf180mcu_as_sc_mcu7t3v3__buff_8 abstract view
.subckt gf180mcu_as_sc_mcu7t3v3__buff_8 VDD VNW VPW VSS A Y
.ends

* Black-box entry subcircuit for gf180mcu_as_sc_mcu7t3v3__maj3_2 abstract view
.subckt gf180mcu_as_sc_mcu7t3v3__maj3_2 VDD VNW VPW VSS Y A B C
.ends

* Black-box entry subcircuit for gf180mcu_as_sc_mcu7t3v3__clkbuff_4 abstract view
.subckt gf180mcu_as_sc_mcu7t3v3__clkbuff_4 VDD VNW VPW VSS A Y
.ends

* Black-box entry subcircuit for gf180mcu_as_sc_mcu7t3v3__nand4_2 abstract view
.subckt gf180mcu_as_sc_mcu7t3v3__nand4_2 VDD VNW VPW VSS A B C D Y
.ends

* Black-box entry subcircuit for gf180mcu_as_sc_mcu7t3v3__aoi31_2 abstract view
.subckt gf180mcu_as_sc_mcu7t3v3__aoi31_2 VDD VNW VPW VSS A B C Y D
.ends

* Black-box entry subcircuit for gf180mcu_as_sc_mcu7t3v3__inv_6 abstract view
.subckt gf180mcu_as_sc_mcu7t3v3__inv_6 VDD VNW VPW VSS Y A
.ends

* Black-box entry subcircuit for gf180mcu_as_sc_mcu7t3v3__dfsrtp_2 abstract view
.subckt gf180mcu_as_sc_mcu7t3v3__dfsrtp_2 VDD VNW VPW VSS CLK Q RN SN D
.ends

* Black-box entry subcircuit for gf180mcu_as_sc_mcu7t3v3__tieh_4 abstract view
.subckt gf180mcu_as_sc_mcu7t3v3__tieh_4 VDD VNW VPW VSS ONE
.ends

* Black-box entry subcircuit for gf180mcu_ocd_ip_sram__sram1024x8m8wm1 abstract view
.subckt gf180mcu_ocd_ip_sram__sram1024x8m8wm1 A[8] A[7] A[6] A[5] A[4] A[3] A[2] A[1]
+ A[0] CEN CLK D[7] D[6] D[5] D[4] D[3] D[2] D[1] D[0] GWEN Q[7] Q[6] Q[5] Q[4] Q[3]
+ Q[2] Q[1] Q[0] VDD VSS WEN[7] WEN[6] WEN[5] WEN[4] WEN[3] WEN[2] WEN[1] WEN[0] A[9]
.ends

* Black-box entry subcircuit for gf180mcu_as_sc_mcu7t3v3__ao21b_2 abstract view
.subckt gf180mcu_as_sc_mcu7t3v3__ao21b_2 VDD VNW VPW VSS Y C B A
.ends

.subckt mesh_tile VDD VSS boot_addr[0] boot_addr[10] boot_addr[1] boot_addr[2] boot_addr[3]
+ boot_addr[4] boot_addr[5] boot_addr[6] boot_addr[7] boot_addr[8] boot_addr[9] boot_data[0]
+ boot_data[1] boot_data[2] boot_data[3] boot_data[4] boot_data[5] boot_data[6] boot_data[7]
+ boot_mode boot_wen clk dft_addr[0] dft_addr[10] dft_addr[1] dft_addr[2] dft_addr[3]
+ dft_addr[4] dft_addr[5] dft_addr[6] dft_addr[7] dft_addr[8] dft_addr[9] dft_ce dft_mode
+ dft_rdata[0] dft_rdata[1] dft_rdata[2] dft_rdata[3] dft_rdata[4] dft_rdata[5] dft_rdata[6]
+ dft_rdata[7] dft_wdata[0] dft_wdata[1] dft_wdata[2] dft_wdata[3] dft_wdata[4] dft_wdata[5]
+ dft_wdata[6] dft_wdata[7] dft_we east_in[0] east_in[10] east_in[11] east_in[12]
+ east_in[13] east_in[14] east_in[15] east_in[16] east_in[17] east_in[18] east_in[19]
+ east_in[1] east_in[20] east_in[21] east_in[22] east_in[23] east_in[24] east_in[25]
+ east_in[26] east_in[27] east_in[28] east_in[29] east_in[2] east_in[30] east_in[31]
+ east_in[32] east_in[33] east_in[3] east_in[4] east_in[5] east_in[6] east_in[7] east_in[8]
+ east_in[9] east_out[0] east_out[10] east_out[11] east_out[12] east_out[13] east_out[14]
+ east_out[15] east_out[16] east_out[17] east_out[18] east_out[19] east_out[1] east_out[20]
+ east_out[21] east_out[22] east_out[23] east_out[24] east_out[25] east_out[26] east_out[27]
+ east_out[28] east_out[29] east_out[2] east_out[30] east_out[31] east_out[32] east_out[33]
+ east_out[3] east_out[4] east_out[5] east_out[6] east_out[7] east_out[8] east_out[9]
+ ne_in[0] ne_in[10] ne_in[11] ne_in[12] ne_in[13] ne_in[14] ne_in[15] ne_in[16] ne_in[17]
+ ne_in[18] ne_in[19] ne_in[1] ne_in[20] ne_in[21] ne_in[22] ne_in[23] ne_in[24] ne_in[25]
+ ne_in[26] ne_in[27] ne_in[28] ne_in[29] ne_in[2] ne_in[30] ne_in[31] ne_in[32] ne_in[33]
+ ne_in[3] ne_in[4] ne_in[5] ne_in[6] ne_in[7] ne_in[8] ne_in[9] ne_out[0] ne_out[10]
+ ne_out[11] ne_out[12] ne_out[13] ne_out[14] ne_out[15] ne_out[16] ne_out[17] ne_out[18]
+ ne_out[19] ne_out[1] ne_out[20] ne_out[21] ne_out[22] ne_out[23] ne_out[24] ne_out[25]
+ ne_out[26] ne_out[27] ne_out[28] ne_out[29] ne_out[2] ne_out[30] ne_out[31] ne_out[32]
+ ne_out[33] ne_out[3] ne_out[4] ne_out[5] ne_out[6] ne_out[7] ne_out[8] ne_out[9]
+ north_in[0] north_in[10] north_in[11] north_in[12] north_in[13] north_in[14] north_in[15]
+ north_in[16] north_in[17] north_in[18] north_in[19] north_in[1] north_in[20] north_in[21]
+ north_in[22] north_in[23] north_in[24] north_in[25] north_in[26] north_in[27] north_in[28]
+ north_in[29] north_in[2] north_in[30] north_in[31] north_in[32] north_in[33] north_in[3]
+ north_in[4] north_in[5] north_in[6] north_in[7] north_in[8] north_in[9] north_out[0]
+ north_out[10] north_out[11] north_out[12] north_out[13] north_out[14] north_out[15]
+ north_out[16] north_out[17] north_out[18] north_out[19] north_out[1] north_out[20]
+ north_out[21] north_out[22] north_out[23] north_out[24] north_out[25] north_out[26]
+ north_out[27] north_out[28] north_out[29] north_out[2] north_out[30] north_out[31]
+ north_out[32] north_out[33] north_out[3] north_out[4] north_out[5] north_out[6]
+ north_out[7] north_out[8] north_out[9] nw_in[0] nw_in[10] nw_in[11] nw_in[12] nw_in[13]
+ nw_in[14] nw_in[15] nw_in[16] nw_in[17] nw_in[18] nw_in[19] nw_in[1] nw_in[20] nw_in[21]
+ nw_in[22] nw_in[23] nw_in[24] nw_in[25] nw_in[26] nw_in[27] nw_in[28] nw_in[29]
+ nw_in[2] nw_in[30] nw_in[31] nw_in[32] nw_in[33] nw_in[3] nw_in[4] nw_in[5] nw_in[6]
+ nw_in[7] nw_in[8] nw_in[9] nw_out[0] nw_out[10] nw_out[11] nw_out[12] nw_out[13]
+ nw_out[14] nw_out[15] nw_out[16] nw_out[17] nw_out[18] nw_out[19] nw_out[1] nw_out[20]
+ nw_out[21] nw_out[22] nw_out[23] nw_out[24] nw_out[25] nw_out[26] nw_out[27] nw_out[28]
+ nw_out[29] nw_out[2] nw_out[30] nw_out[31] nw_out[32] nw_out[33] nw_out[3] nw_out[4]
+ nw_out[5] nw_out[6] nw_out[7] nw_out[8] nw_out[9] rst se_in[0] se_in[10] se_in[11]
+ se_in[12] se_in[13] se_in[14] se_in[15] se_in[16] se_in[17] se_in[18] se_in[19]
+ se_in[1] se_in[20] se_in[21] se_in[22] se_in[23] se_in[24] se_in[25] se_in[26] se_in[27]
+ se_in[28] se_in[29] se_in[2] se_in[30] se_in[31] se_in[32] se_in[33] se_in[3] se_in[4]
+ se_in[5] se_in[6] se_in[7] se_in[8] se_in[9] se_out[0] se_out[10] se_out[11] se_out[12]
+ se_out[13] se_out[14] se_out[15] se_out[16] se_out[17] se_out[18] se_out[19] se_out[1]
+ se_out[20] se_out[21] se_out[22] se_out[23] se_out[24] se_out[25] se_out[26] se_out[27]
+ se_out[28] se_out[29] se_out[2] se_out[30] se_out[31] se_out[32] se_out[33] se_out[3]
+ se_out[4] se_out[5] se_out[6] se_out[7] se_out[8] se_out[9] south_in[0] south_in[10]
+ south_in[11] south_in[12] south_in[13] south_in[14] south_in[15] south_in[16] south_in[17]
+ south_in[18] south_in[19] south_in[1] south_in[20] south_in[21] south_in[22] south_in[23]
+ south_in[24] south_in[25] south_in[26] south_in[27] south_in[28] south_in[29] south_in[2]
+ south_in[30] south_in[31] south_in[32] south_in[33] south_in[3] south_in[4] south_in[5]
+ south_in[6] south_in[7] south_in[8] south_in[9] south_out[0] south_out[10] south_out[11]
+ south_out[12] south_out[13] south_out[14] south_out[15] south_out[16] south_out[17]
+ south_out[18] south_out[19] south_out[1] south_out[20] south_out[21] south_out[22]
+ south_out[23] south_out[24] south_out[25] south_out[26] south_out[27] south_out[28]
+ south_out[29] south_out[2] south_out[30] south_out[31] south_out[32] south_out[33]
+ south_out[3] south_out[4] south_out[5] south_out[6] south_out[7] south_out[8] south_out[9]
+ sw_in[0] sw_in[10] sw_in[11] sw_in[12] sw_in[13] sw_in[14] sw_in[15] sw_in[16] sw_in[17]
+ sw_in[18] sw_in[19] sw_in[1] sw_in[20] sw_in[21] sw_in[22] sw_in[23] sw_in[24] sw_in[25]
+ sw_in[26] sw_in[27] sw_in[28] sw_in[29] sw_in[2] sw_in[30] sw_in[31] sw_in[32] sw_in[33]
+ sw_in[3] sw_in[4] sw_in[5] sw_in[6] sw_in[7] sw_in[8] sw_in[9] sw_out[0] sw_out[10]
+ sw_out[11] sw_out[12] sw_out[13] sw_out[14] sw_out[15] sw_out[16] sw_out[17] sw_out[18]
+ sw_out[19] sw_out[1] sw_out[20] sw_out[21] sw_out[22] sw_out[23] sw_out[24] sw_out[25]
+ sw_out[26] sw_out[27] sw_out[28] sw_out[29] sw_out[2] sw_out[30] sw_out[31] sw_out[32]
+ sw_out[33] sw_out[3] sw_out[4] sw_out[5] sw_out[6] sw_out[7] sw_out[8] sw_out[9]
+ west_in[0] west_in[10] west_in[11] west_in[12] west_in[13] west_in[14] west_in[15]
+ west_in[16] west_in[17] west_in[18] west_in[19] west_in[1] west_in[20] west_in[21]
+ west_in[22] west_in[23] west_in[24] west_in[25] west_in[26] west_in[27] west_in[28]
+ west_in[29] west_in[2] west_in[30] west_in[31] west_in[32] west_in[33] west_in[3]
+ west_in[4] west_in[5] west_in[6] west_in[7] west_in[8] west_in[9] west_out[0] west_out[10]
+ west_out[11] west_out[12] west_out[13] west_out[14] west_out[15] west_out[16] west_out[17]
+ west_out[18] west_out[19] west_out[1] west_out[20] west_out[21] west_out[22] west_out[23]
+ west_out[24] west_out[25] west_out[26] west_out[27] west_out[28] west_out[29] west_out[2]
+ west_out[30] west_out[31] west_out[32] west_out[33] west_out[3] west_out[4] west_out[5]
+ west_out[6] west_out[7] west_out[8] west_out[9]
XFILLER_39_244 VDD VDD VSS VSS gf180mcu_as_sc_mcu7t3v3__fillcap_16
XPHY_EDGE_ROW_163_Right_297 VDD VSS gf180mcu_as_sc_mcu7t3v3__tap_2
XTAP_TAPCELL_ROW_45_1_817 VDD VSS gf180mcu_as_sc_mcu7t3v3__tap_2
X_3155_ VDD VDD VSS VSS _4131_/A _3241_/B _3155_/C _3155_/D _3156_/C gf180mcu_as_sc_mcu7t3v3__ao22_2
XFILLER_167_1418 VDD VDD VSS VSS gf180mcu_as_sc_mcu7t3v3__fillcap_16
X_3086_ VDD VDD VSS VSS _3137_/B _4931_/Q _3087_/D gf180mcu_as_sc_mcu7t3v3__or2_2
XFILLER_54_247 VDD VDD VSS VSS gf180mcu_as_sc_mcu7t3v3__fillcap_4
XTAP_TAPCELL_ROW_65_3_2447 VDD VSS gf180mcu_as_sc_mcu7t3v3__tap_2
XFILLER_149_842 VDD VDD VSS VSS gf180mcu_as_sc_mcu7t3v3__fillcap_8
XFILLER_168_18 VDD VDD VSS VSS gf180mcu_as_sc_mcu7t3v3__fillcap_16
XFILLER_22_155 VDD VDD VSS VSS gf180mcu_as_sc_mcu7t3v3__fillcap_16
X_3988_ VDD VDD VSS VSS _4984_/Q _4092_/B _4235_/B _4092_/D _4984_/D gf180mcu_as_sc_mcu7t3v3__ao22_2
XFILLER_164_801 VDD VDD VSS VSS gf180mcu_as_sc_mcu7t3v3__fillcap_4
XFILLER_22_177 VDD VDD VSS VSS gf180mcu_as_sc_mcu7t3v3__fillcap_16
X_2939_ VDD VDD VSS VSS _3817_/B _3794_/A _3803_/A gf180mcu_as_sc_mcu7t3v3__nor2_2
XFILLER_148_374 VDD VDD VSS VSS gf180mcu_as_sc_mcu7t3v3__fill_1
XFILLER_176_683 VDD VDD VSS VSS gf180mcu_as_sc_mcu7t3v3__fill_2
XFILLER_163_333 VDD VDD VSS VSS gf180mcu_as_sc_mcu7t3v3__fillcap_4
XFILLER_164_845 VDD VDD VSS VSS gf180mcu_as_sc_mcu7t3v3__fillcap_8
X_4609_ VDD VDD VSS VSS _5203_/Q _4612_/B _4612_/C _5204_/Q _5203_/D gf180mcu_as_sc_mcu7t3v3__ao22_2
XTAP_TAPCELL_ROW_24_1_731 VDD VSS gf180mcu_as_sc_mcu7t3v3__tap_2
XFILLER_117_88 VDD VDD VSS VSS gf180mcu_as_sc_mcu7t3v3__fillcap_4
XFILLER_131_241 VDD VDD VSS VSS gf180mcu_as_sc_mcu7t3v3__fillcap_8
XFILLER_89_144 VDD VDD VSS VSS gf180mcu_as_sc_mcu7t3v3__fill_1
XFILLER_89_155 VDD VDD VSS VSS gf180mcu_as_sc_mcu7t3v3__fillcap_16
XPHY_EDGE_ROW_18_3_Right_337 VDD VSS gf180mcu_as_sc_mcu7t3v3__tap_2
XFILLER_131_263 VDD VDD VSS VSS gf180mcu_as_sc_mcu7t3v3__fill_1
XFILLER_137_1299 VDD VDD VSS VSS gf180mcu_as_sc_mcu7t3v3__fillcap_16
XFILLER_172_1157 VDD VDD VSS VSS gf180mcu_as_sc_mcu7t3v3__fillcap_4
XFILLER_28_1550 VDD VDD VSS VSS gf180mcu_as_sc_mcu7t3v3__fillcap_4
XFILLER_77_48 VDD VDD VSS VSS gf180mcu_as_sc_mcu7t3v3__fill_1
XFILLER_115_1553 VDD VDD VSS VSS gf180mcu_as_sc_mcu7t3v3__fillcap_4
XFILLER_150_1433 VDD VDD VSS VSS gf180mcu_as_sc_mcu7t3v3__fill_2
Xhold1040 VDD VDD VSS VSS _2588_/A _2587_/A gf180mcu_as_sc_mcu7t3v3__buff_2
Xhold1051 VDD VDD VSS VSS _4964_/Q hold1051/Y gf180mcu_as_sc_mcu7t3v3__buff_2
XFILLER_165_2 VDD VDD VSS VSS gf180mcu_as_sc_mcu7t3v3__fillcap_16
XFILLER_60_217 VDD VDD VSS VSS gf180mcu_as_sc_mcu7t3v3__fillcap_4
XFILLER_159_606 VDD VDD VSS VSS gf180mcu_as_sc_mcu7t3v3__fill_2
XFILLER_26_85 VDD VDD VSS VSS gf180mcu_as_sc_mcu7t3v3__fillcap_16
XFILLER_159_628 VDD VDD VSS VSS gf180mcu_as_sc_mcu7t3v3__fill_2
XFILLER_35_1521 VDD VDD VSS VSS gf180mcu_as_sc_mcu7t3v3__fillcap_16
XFILLER_9_104 VDD VDD VSS VSS gf180mcu_as_sc_mcu7t3v3__fillcap_16
XFILLER_122_1502 VDD VDD VSS VSS gf180mcu_as_sc_mcu7t3v3__fillcap_16
XFILLER_139_330 VDD VDD VSS VSS gf180mcu_as_sc_mcu7t3v3__fill_1
XFILLER_139_352 VDD VDD VSS VSS gf180mcu_as_sc_mcu7t3v3__fillcap_16
XFILLER_155_801 VDD VDD VSS VSS gf180mcu_as_sc_mcu7t3v3__fill_2
XFILLER_70_1467 VDD VDD VSS VSS gf180mcu_as_sc_mcu7t3v3__fillcap_16
XFILLER_166_171 VDD VDD VSS VSS gf180mcu_as_sc_mcu7t3v3__fillcap_4
XFILLER_166_193 VDD VDD VSS VSS gf180mcu_as_sc_mcu7t3v3__fillcap_16
XFILLER_182_675 VDD VDD VSS VSS gf180mcu_as_sc_mcu7t3v3__fillcap_4
XFILLER_154_399 VDD VDD VSS VSS gf180mcu_as_sc_mcu7t3v3__fillcap_8
XFILLER_159_1480 VDD VDD VSS VSS gf180mcu_as_sc_mcu7t3v3__fillcap_4
XFILLER_177_1068 VDD VDD VSS VSS gf180mcu_as_sc_mcu7t3v3__fillcap_4
XFILLER_122_241 VDD VDD VSS VSS gf180mcu_as_sc_mcu7t3v3__fillcap_4
XFILLER_151_1208 VDD VDD VSS VSS gf180mcu_as_sc_mcu7t3v3__fillcap_16
XFILLER_3_34 VDD VDD VSS VSS gf180mcu_as_sc_mcu7t3v3__fillcap_16
XTAP_TAPCELL_ROW_85_1_977 VDD VSS gf180mcu_as_sc_mcu7t3v3__tap_2
XTAP_TAPCELL_ROW_182_2268 VDD VSS gf180mcu_as_sc_mcu7t3v3__tap_2
XTAP_TAPCELL_ROW_182_2257 VDD VSS gf180mcu_as_sc_mcu7t3v3__tap_2
XFILLER_149_1104 VDD VDD VSS VSS gf180mcu_as_sc_mcu7t3v3__fillcap_16
XFILLER_36_225 VDD VDD VSS VSS gf180mcu_as_sc_mcu7t3v3__fillcap_16
XTAP_TAPCELL_ROW_41_1_801 VDD VSS gf180mcu_as_sc_mcu7t3v3__tap_2
XFILLER_36_247 VDD VDD VSS VSS gf180mcu_as_sc_mcu7t3v3__fillcap_16
XPHY_EDGE_ROW_20_1_Right_19 VDD VSS gf180mcu_as_sc_mcu7t3v3__tap_2
XFILLER_166_1451 VDD VDD VSS VSS gf180mcu_as_sc_mcu7t3v3__fillcap_16
XFILLER_51_206 VDD VDD VSS VSS gf180mcu_as_sc_mcu7t3v3__fillcap_4
XFILLER_51_228 VDD VDD VSS VSS gf180mcu_as_sc_mcu7t3v3__fill_1
X_4960_ VDD VDD VSS VSS _5164_/CLK _4960_/D _4960_/Q gf180mcu_as_sc_mcu7t3v3__dfxtp_2
X_4891_ VDD VDD VSS VSS _5159_/CLK _4891_/D _4891_/Q gf180mcu_as_sc_mcu7t3v3__dfxtp_2
X_3911_ VDD VDD VSS VSS _4198_/A _4141_/D _4907_/Q gf180mcu_as_sc_mcu7t3v3__nor2_2
X_3842_ VDD VDD VSS VSS _3843_/S _3845_/B _3846_/B gf180mcu_as_sc_mcu7t3v3__nand2b_2
XFILLER_80_2 VDD VDD VSS VSS gf180mcu_as_sc_mcu7t3v3__fillcap_8
XTAP_TAPCELL_ROW_96_1_1019 VDD VSS gf180mcu_as_sc_mcu7t3v3__tap_2
XPHY_EDGE_ROW_116_1_Left_568 VDD VSS gf180mcu_as_sc_mcu7t3v3__tap_2
X_3773_ VDD VDD VSS VSS _4151_/A _3781_/S _3773_/C _3773_/D _3774_/D gf180mcu_as_sc_mcu7t3v3__ao211_2
XFILLER_160_1083 VDD VDD VSS VSS gf180mcu_as_sc_mcu7t3v3__fill_2
X_2724_ VDD VDD VSS VSS _4264_/A _5179_/Q _5171_/Q _2728_/B gf180mcu_as_sc_mcu7t3v3__mux2_2
XTAP_TAPCELL_ROW_64_1_891 VDD VSS gf180mcu_as_sc_mcu7t3v3__tap_2
XTAP_TAPCELL_ROW_154_1647 VDD VSS gf180mcu_as_sc_mcu7t3v3__tap_2
XTAP_TAPCELL_ROW_154_1636 VDD VSS gf180mcu_as_sc_mcu7t3v3__tap_2
XFILLER_161_804 VDD VDD VSS VSS gf180mcu_as_sc_mcu7t3v3__fill_2
XPHY_EDGE_ROW_53_1_Left_505 VDD VSS gf180mcu_as_sc_mcu7t3v3__tap_2
Xoutput401 VDD VDD VSS VSS _4822_/Q south_out[17] gf180mcu_as_sc_mcu7t3v3__buff_2
X_2655_ VDD VDD VSS VSS _2656_/C _2655_/B _4262_/B gf180mcu_as_sc_mcu7t3v3__nor2_2
XFILLER_145_399 VDD VDD VSS VSS gf180mcu_as_sc_mcu7t3v3__fillcap_8
Xoutput412 VDD VDD VSS VSS _4832_/Q south_out[27] gf180mcu_as_sc_mcu7t3v3__buff_2
Xoutput423 VDD VDD VSS VSS _4811_/Q south_out[6] gf180mcu_as_sc_mcu7t3v3__buff_2
Xoutput434 VDD VDD VSS VSS _4889_/Q west_out[16] gf180mcu_as_sc_mcu7t3v3__buff_2
XFILLER_141_550 VDD VDD VSS VSS gf180mcu_as_sc_mcu7t3v3__fillcap_4
Xoutput445 VDD VDD VSS VSS _4899_/Q west_out[26] gf180mcu_as_sc_mcu7t3v3__buff_2
Xoutput456 VDD VDD VSS VSS _4878_/Q west_out[5] gf180mcu_as_sc_mcu7t3v3__buff_2
X_4325_ VDD VDD VSS VSS _4325_/S _5155_/Q _5154_/Q _5154_/D gf180mcu_as_sc_mcu7t3v3__mux2_2
X_2586_ VDD VDD VSS VSS _2730_/A _2586_/B _2586_/A _3906_/S gf180mcu_as_sc_mcu7t3v3__mux2_2
XFILLER_113_252 VDD VDD VSS VSS gf180mcu_as_sc_mcu7t3v3__fillcap_4
XFILLER_173_1488 VDD VDD VSS VSS gf180mcu_as_sc_mcu7t3v3__fillcap_16
X_4256_ VDD VDD VSS VSS _4257_/S _4256_/B _5092_/Q _5092_/D gf180mcu_as_sc_mcu7t3v3__mux2_2
X_4187_ VDD VDD VSS VSS _4247_/B _4187_/B _4190_/C _5025_/Q _5025_/D gf180mcu_as_sc_mcu7t3v3__ao22_2
X_3207_ VDD VDD VSS VSS _3230_/S _3793_/A _3207_/A _3208_/C gf180mcu_as_sc_mcu7t3v3__mux2_2
X_3138_ VDD VDD VSS VSS _4110_/A _3150_/B _3138_/C _3138_/D _3139_/C gf180mcu_as_sc_mcu7t3v3__ao22_2
XFILLER_103_35 VDD VDD VSS VSS gf180mcu_as_sc_mcu7t3v3__fill_2
XFILLER_110_1483 VDD VDD VSS VSS gf180mcu_as_sc_mcu7t3v3__fill_1
XFILLER_167_1259 VDD VDD VSS VSS gf180mcu_as_sc_mcu7t3v3__fill_1
X_3069_ VDD VDD VSS VSS _3178_/A _3069_/B _3069_/C _3178_/D _3071_/C gf180mcu_as_sc_mcu7t3v3__ao211_2
XPHY_EDGE_ROW_77_1_Right_76 VDD VSS gf180mcu_as_sc_mcu7t3v3__tap_2
XFILLER_151_8 VDD VDD VSS VSS gf180mcu_as_sc_mcu7t3v3__fillcap_4
XFILLER_168_403 VDD VDD VSS VSS gf180mcu_as_sc_mcu7t3v3__fillcap_16
XFILLER_180_1404 VDD VDD VSS VSS gf180mcu_as_sc_mcu7t3v3__fill_2
XFILLER_93_1467 VDD VDD VSS VSS gf180mcu_as_sc_mcu7t3v3__fillcap_16
XFILLER_145_1535 VDD VDD VSS VSS gf180mcu_as_sc_mcu7t3v3__fillcap_4
XFILLER_169_948 VDD VDD VSS VSS gf180mcu_as_sc_mcu7t3v3__fill_1
XFILLER_168_469 VDD VDD VSS VSS gf180mcu_as_sc_mcu7t3v3__fill_2
XFILLER_143_1270 VDD VDD VSS VSS gf180mcu_as_sc_mcu7t3v3__fillcap_4
XFILLER_6_107 VDD VDD VSS VSS gf180mcu_as_sc_mcu7t3v3__fillcap_16
XFILLER_148_171 VDD VDD VSS VSS gf180mcu_as_sc_mcu7t3v3__fillcap_4
XFILLER_148_193 VDD VDD VSS VSS gf180mcu_as_sc_mcu7t3v3__fillcap_16
XFILLER_164_675 VDD VDD VSS VSS gf180mcu_as_sc_mcu7t3v3__fillcap_4
XFILLER_178_1344 VDD VDD VSS VSS gf180mcu_as_sc_mcu7t3v3__fill_1
XFILLER_30_1451 VDD VDD VSS VSS gf180mcu_as_sc_mcu7t3v3__fillcap_16
XFILLER_163_174 VDD VDD VSS VSS gf180mcu_as_sc_mcu7t3v3__fillcap_16
XFILLER_128_98 VDD VDD VSS VSS gf180mcu_as_sc_mcu7t3v3__fill_1
XFILLER_137_1052 VDD VDD VSS VSS gf180mcu_as_sc_mcu7t3v3__fillcap_4
XPHY_EDGE_ROW_19_3_Right_338 VDD VSS gf180mcu_as_sc_mcu7t3v3__tap_2
Xfanout650 VDD VDD VSS VSS fanout651/Y _4121_/B gf180mcu_as_sc_mcu7t3v3__buff_2
XTAP_TAPCELL_ROW_73_1_926 VDD VSS gf180mcu_as_sc_mcu7t3v3__tap_2
XFILLER_144_97 VDD VDD VSS VSS gf180mcu_as_sc_mcu7t3v3__fill_1
Xfanout661 VDD VDD VSS VSS _4677_/B _4685_/C gf180mcu_as_sc_mcu7t3v3__buff_2
Xfanout672 VDD VDD VSS VSS fanout675/Y _4129_/B gf180mcu_as_sc_mcu7t3v3__buff_2
Xfanout683 VDD VDD VSS VSS fanout684/Y _3464_/B gf180mcu_as_sc_mcu7t3v3__buff_2
Xfanout694 VDD VDD VSS VSS _3542_/Y _3762_/B gf180mcu_as_sc_mcu7t3v3__buff_2
XTAP_TAPCELL_ROW_81_1_961 VDD VSS gf180mcu_as_sc_mcu7t3v3__tap_2
XFILLER_150_1263 VDD VDD VSS VSS gf180mcu_as_sc_mcu7t3v3__fillcap_4
XFILLER_18_225 VDD VDD VSS VSS gf180mcu_as_sc_mcu7t3v3__fillcap_16
XFILLER_18_247 VDD VDD VSS VSS gf180mcu_as_sc_mcu7t3v3__fillcap_16
XFILLER_85_191 VDD VDD VSS VSS gf180mcu_as_sc_mcu7t3v3__fillcap_16
XFILLER_160_85 VDD VDD VSS VSS gf180mcu_as_sc_mcu7t3v3__fillcap_16
XFILLER_33_206 VDD VDD VSS VSS gf180mcu_as_sc_mcu7t3v3__fillcap_4
XFILLER_33_228 VDD VDD VSS VSS gf180mcu_as_sc_mcu7t3v3__fillcap_16
XFILLER_53_72 VDD VDD VSS VSS gf180mcu_as_sc_mcu7t3v3__fill_2
XFILLER_72_1518 VDD VDD VSS VSS gf180mcu_as_sc_mcu7t3v3__fillcap_16
XFILLER_147_609 VDD VDD VSS VSS gf180mcu_as_sc_mcu7t3v3__fillcap_16
XFILLER_169_50 VDD VDD VSS VSS gf180mcu_as_sc_mcu7t3v3__fillcap_16
XFILLER_169_72 VDD VDD VSS VSS gf180mcu_as_sc_mcu7t3v3__fillcap_16
XFILLER_127_300 VDD VDD VSS VSS gf180mcu_as_sc_mcu7t3v3__fill_1
XFILLER_144_1078 VDD VDD VSS VSS gf180mcu_as_sc_mcu7t3v3__fillcap_4
XTAP_TAPCELL_ROW_123_3_2534 VDD VSS gf180mcu_as_sc_mcu7t3v3__tap_2
XFILLER_142_303 VDD VDD VSS VSS gf180mcu_as_sc_mcu7t3v3__fillcap_4
XFILLER_155_697 VDD VDD VSS VSS gf180mcu_as_sc_mcu7t3v3__fill_2
X_2440_ VDD VDD VSS VSS _4083_/A _2440_/A gf180mcu_as_sc_mcu7t3v3__inv_2
XFILLER_142_358 VDD VDD VSS VSS gf180mcu_as_sc_mcu7t3v3__fill_1
XFILLER_170_667 VDD VDD VSS VSS gf180mcu_as_sc_mcu7t3v3__fillcap_8
XFILLER_68_103 VDD VDD VSS VSS gf180mcu_as_sc_mcu7t3v3__fill_2
XTAP_TAPCELL_ROW_184_2319 VDD VSS gf180mcu_as_sc_mcu7t3v3__tap_2
XTAP_TAPCELL_ROW_184_2308 VDD VSS gf180mcu_as_sc_mcu7t3v3__tap_2
XFILLER_110_211 VDD VDD VSS VSS gf180mcu_as_sc_mcu7t3v3__fillcap_4
XFILLER_78_80 VDD VDD VSS VSS gf180mcu_as_sc_mcu7t3v3__fillcap_16
X_5090_ VDD VDD VSS VSS _5185_/CLK _5090_/D _5090_/Q gf180mcu_as_sc_mcu7t3v3__dfxtp_2
X_4110_ VDD VDD VSS VSS _4110_/A _4127_/B _4110_/C _4115_/C _4110_/D gf180mcu_as_sc_mcu7t3v3__aoi211_2
XFILLER_110_255 VDD VDD VSS VSS gf180mcu_as_sc_mcu7t3v3__fillcap_4
X_4041_ VDD VDD VSS VSS _4041_/A _4122_/B _4041_/C _4041_/D _4042_/B gf180mcu_as_sc_mcu7t3v3__ao211_2
XFILLER_110_288 VDD VDD VSS VSS gf180mcu_as_sc_mcu7t3v3__fillcap_8
XFILLER_133_1483 VDD VDD VSS VSS gf180mcu_as_sc_mcu7t3v3__fillcap_4
XFILLER_94_90 VDD VDD VSS VSS gf180mcu_as_sc_mcu7t3v3__fill_2
XTAP_TAPCELL_ROW_147_1495 VDD VSS gf180mcu_as_sc_mcu7t3v3__tap_2
XTAP_TAPCELL_ROW_147_1484 VDD VSS gf180mcu_as_sc_mcu7t3v3__tap_2
X_4943_ VDD VDD VSS VSS _4943_/CLK _4943_/D _4943_/Q gf180mcu_as_sc_mcu7t3v3__dfxtp_2
XFILLER_166_1292 VDD VDD VSS VSS gf180mcu_as_sc_mcu7t3v3__fill_2
XFILLER_178_723 VDD VDD VSS VSS gf180mcu_as_sc_mcu7t3v3__fillcap_8
XFILLER_177_244 VDD VDD VSS VSS gf180mcu_as_sc_mcu7t3v3__fillcap_16
XPHY_EDGE_ROW_27_3_Left_161 VDD VSS gf180mcu_as_sc_mcu7t3v3__tap_2
X_4874_ VDD VDD VSS VSS _4914_/CLK _4874_/D _4874_/Q gf180mcu_as_sc_mcu7t3v3__dfxtp_2
XFILLER_140_1410 VDD VDD VSS VSS gf180mcu_as_sc_mcu7t3v3__fillcap_16
XFILLER_53_1451 VDD VDD VSS VSS gf180mcu_as_sc_mcu7t3v3__fillcap_16
X_3825_ VDD VDD VSS VSS _3825_/Y _4908_/Q _3826_/B _3825_/C gf180mcu_as_sc_mcu7t3v3__ao21_2
XFILLER_146_620 VDD VDD VSS VSS gf180mcu_as_sc_mcu7t3v3__fillcap_8
X_3756_ VDD VDD VSS VSS _4135_/D _3781_/S _3756_/C _3756_/D _3757_/C gf180mcu_as_sc_mcu7t3v3__ao211_2
XFILLER_140_1498 VDD VDD VSS VSS gf180mcu_as_sc_mcu7t3v3__fillcap_4
X_2707_ VDD VDD VSS VSS _2735_/A _2707_/B _2707_/C _2735_/D _2709_/C gf180mcu_as_sc_mcu7t3v3__ao211_2
XFILLER_175_1539 VDD VDD VSS VSS gf180mcu_as_sc_mcu7t3v3__fill_1
X_3687_ VDD VDD VSS VSS _3691_/B _3687_/C _3726_/B _4064_/A gf180mcu_as_sc_mcu7t3v3__aoi21_2
X_2638_ VDD VDD VSS VSS _2673_/B _5128_/Q _5192_/Q _2639_/B gf180mcu_as_sc_mcu7t3v3__mux2_2
XFILLER_138_1361 VDD VDD VSS VSS gf180mcu_as_sc_mcu7t3v3__fillcap_4
XFILLER_160_155 VDD VDD VSS VSS gf180mcu_as_sc_mcu7t3v3__fillcap_16
XFILLER_160_177 VDD VDD VSS VSS gf180mcu_as_sc_mcu7t3v3__fillcap_16
XFILLER_173_1230 VDD VDD VSS VSS gf180mcu_as_sc_mcu7t3v3__fillcap_8
X_2569_ VDD VDD VSS VSS _2875_/B _2747_/A _2845_/D gf180mcu_as_sc_mcu7t3v3__nor2_2
XTAP_TAPCELL_ROW_120_1_1115 VDD VSS gf180mcu_as_sc_mcu7t3v3__tap_2
XFILLER_134_1236 VDD VDD VSS VSS gf180mcu_as_sc_mcu7t3v3__fill_1
XFILLER_138_1383 VDD VDD VSS VSS gf180mcu_as_sc_mcu7t3v3__fillcap_8
XFILLER_181_18 VDD VDD VSS VSS gf180mcu_as_sc_mcu7t3v3__fillcap_16
X_4308_ VDD VDD VSS VSS _4325_/S _5138_/Q _5137_/Q _5137_/D gf180mcu_as_sc_mcu7t3v3__mux2_2
XFILLER_114_34 VDD VDD VSS VSS gf180mcu_as_sc_mcu7t3v3__fill_1
XFILLER_25_1553 VDD VDD VSS VSS gf180mcu_as_sc_mcu7t3v3__fillcap_16
X_4239_ VDD VDD VSS VSS _4248_/S _4239_/B _5075_/Q _5075_/D gf180mcu_as_sc_mcu7t3v3__mux2_2
XTAP_TAPCELL_ROW_53_3_2429 VDD VSS gf180mcu_as_sc_mcu7t3v3__tap_2
XFILLER_112_1534 VDD VDD VSS VSS gf180mcu_as_sc_mcu7t3v3__fillcap_16
XFILLER_74_139 VDD VDD VSS VSS gf180mcu_as_sc_mcu7t3v3__fillcap_16
XFILLER_74_16 VDD VDD VSS VSS gf180mcu_as_sc_mcu7t3v3__fillcap_4
XFILLER_112_1556 VDD VDD VSS VSS gf180mcu_as_sc_mcu7t3v3__fillcap_8
XFILLER_74_27 VDD VDD VSS VSS gf180mcu_as_sc_mcu7t3v3__fillcap_8
XTAP_TAPCELL_ROW_100_1_1035 VDD VSS gf180mcu_as_sc_mcu7t3v3__tap_2
XFILLER_15_206 VDD VDD VSS VSS gf180mcu_as_sc_mcu7t3v3__fillcap_4
XFILLER_82_150 VDD VDD VSS VSS gf180mcu_as_sc_mcu7t3v3__fillcap_16
XFILLER_15_228 VDD VDD VSS VSS gf180mcu_as_sc_mcu7t3v3__fillcap_16
XFILLER_130_88 VDD VDD VSS VSS gf180mcu_as_sc_mcu7t3v3__fillcap_4
XFILLER_145_1332 VDD VDD VSS VSS gf180mcu_as_sc_mcu7t3v3__fillcap_16
XFILLER_169_723 VDD VDD VSS VSS gf180mcu_as_sc_mcu7t3v3__fillcap_8
XFILLER_180_1223 VDD VDD VSS VSS gf180mcu_as_sc_mcu7t3v3__fill_2
XFILLER_30_209 VDD VDD VSS VSS gf180mcu_as_sc_mcu7t3v3__fillcap_16
XFILLER_90_37 VDD VDD VSS VSS gf180mcu_as_sc_mcu7t3v3__fillcap_4
XFILLER_145_1376 VDD VDD VSS VSS gf180mcu_as_sc_mcu7t3v3__fill_1
XFILLER_180_1267 VDD VDD VSS VSS gf180mcu_as_sc_mcu7t3v3__fill_2
XFILLER_32_1502 VDD VDD VSS VSS gf180mcu_as_sc_mcu7t3v3__fillcap_16
XFILLER_109_300 VDD VDD VSS VSS gf180mcu_as_sc_mcu7t3v3__fill_1
XFILLER_128_2 VDD VDD VSS VSS gf180mcu_as_sc_mcu7t3v3__fillcap_16
XFILLER_164_450 VDD VDD VSS VSS gf180mcu_as_sc_mcu7t3v3__fillcap_4
XFILLER_32_1568 VDD VDD VSS VSS gf180mcu_as_sc_mcu7t3v3__fill_1
XFILLER_99_35 VDD VDD VSS VSS gf180mcu_as_sc_mcu7t3v3__fillcap_4
XFILLER_136_174 VDD VDD VSS VSS gf180mcu_as_sc_mcu7t3v3__fill_1
XFILLER_137_686 VDD VDD VSS VSS gf180mcu_as_sc_mcu7t3v3__fillcap_8
XFILLER_139_1114 VDD VDD VSS VSS gf180mcu_as_sc_mcu7t3v3__fillcap_4
XFILLER_152_634 VDD VDD VSS VSS gf180mcu_as_sc_mcu7t3v3__fillcap_8
XFILLER_164_494 VDD VDD VSS VSS gf180mcu_as_sc_mcu7t3v3__fillcap_16
XFILLER_178_1152 VDD VDD VSS VSS gf180mcu_as_sc_mcu7t3v3__fill_2
XFILLER_136_196 VDD VDD VSS VSS gf180mcu_as_sc_mcu7t3v3__fillcap_4
XFILLER_139_1147 VDD VDD VSS VSS gf180mcu_as_sc_mcu7t3v3__fillcap_16
XFILLER_140_807 VDD VDD VSS VSS gf180mcu_as_sc_mcu7t3v3__fill_2
XFILLER_152_667 VDD VDD VSS VSS gf180mcu_as_sc_mcu7t3v3__fillcap_8
XFILLER_139_1169 VDD VDD VSS VSS gf180mcu_as_sc_mcu7t3v3__fillcap_16
XFILLER_117_1467 VDD VDD VSS VSS gf180mcu_as_sc_mcu7t3v3__fillcap_16
XFILLER_152_1358 VDD VDD VSS VSS gf180mcu_as_sc_mcu7t3v3__fillcap_4
Xfanout491 VDD VDD VSS VSS _4125_/D _4108_/D gf180mcu_as_sc_mcu7t3v3__buff_2
XTAP_TAPCELL_ROW_55_1_855 VDD VSS gf180mcu_as_sc_mcu7t3v3__tap_2
XFILLER_65_139 VDD VDD VSS VSS gf180mcu_as_sc_mcu7t3v3__fill_1
XPHY_EDGE_ROW_92_3_Left_226 VDD VSS gf180mcu_as_sc_mcu7t3v3__tap_2
XFILLER_179_509 VDD VDD VSS VSS gf180mcu_as_sc_mcu7t3v3__fillcap_8
XFILLER_76_1451 VDD VDD VSS VSS gf180mcu_as_sc_mcu7t3v3__fillcap_16
XFILLER_128_1552 VDD VDD VSS VSS gf180mcu_as_sc_mcu7t3v3__fill_2
XTAP_TAPCELL_ROW_177_2145 VDD VSS gf180mcu_as_sc_mcu7t3v3__tap_2
XTAP_TAPCELL_ROW_142_1381 VDD VSS gf180mcu_as_sc_mcu7t3v3__tap_2
XTAP_TAPCELL_ROW_142_1370 VDD VSS gf180mcu_as_sc_mcu7t3v3__tap_2
XTAP_TAPCELL_ROW_177_2156 VDD VSS gf180mcu_as_sc_mcu7t3v3__tap_2
XFILLER_159_255 VDD VDD VSS VSS gf180mcu_as_sc_mcu7t3v3__fill_1
XFILLER_9_66 VDD VDD VSS VSS gf180mcu_as_sc_mcu7t3v3__fillcap_4
XFILLER_9_88 VDD VDD VSS VSS gf180mcu_as_sc_mcu7t3v3__fillcap_16
XFILLER_119_119 VDD VDD VSS VSS gf180mcu_as_sc_mcu7t3v3__fill_1
XFILLER_159_288 VDD VDD VSS VSS gf180mcu_as_sc_mcu7t3v3__fill_1
XFILLER_174_225 VDD VDD VSS VSS gf180mcu_as_sc_mcu7t3v3__fillcap_16
X_4590_ VDD VDD VSS VSS _5157_/Q _4590_/B _4590_/C _5107_/Q _4591_/B gf180mcu_as_sc_mcu7t3v3__ao22_2
X_3610_ VDD VDD VSS VSS _3611_/C _3981_/A _3717_/B _3610_/C gf180mcu_as_sc_mcu7t3v3__ao21_2
XFILLER_174_247 VDD VDD VSS VSS gf180mcu_as_sc_mcu7t3v3__fillcap_16
X_3541_ VDD VDD VSS VSS _3799_/D _3914_/B _4943_/Q gf180mcu_as_sc_mcu7t3v3__nand2_2
XFILLER_143_601 VDD VDD VSS VSS gf180mcu_as_sc_mcu7t3v3__fillcap_16
XFILLER_171_976 VDD VDD VSS VSS gf180mcu_as_sc_mcu7t3v3__fillcap_4
X_3472_ VDD VDD VSS VSS _4939_/Q _3486_/B _3472_/C _4129_/A _3473_/D gf180mcu_as_sc_mcu7t3v3__ao22_2
XFILLER_142_177 VDD VDD VSS VSS gf180mcu_as_sc_mcu7t3v3__fillcap_16
XFILLER_143_678 VDD VDD VSS VSS gf180mcu_as_sc_mcu7t3v3__fillcap_8
XFILLER_48_1564 VDD VDD VSS VSS gf180mcu_as_sc_mcu7t3v3__fillcap_4
X_5211_ VDD VDD VSS VSS clkload0/A _5211_/D _5211_/Q gf180mcu_as_sc_mcu7t3v3__dfxtp_2
X_2423_ VDD VDD VSS VSS _3936_/A _2955_/A gf180mcu_as_sc_mcu7t3v3__inv_2
X_5142_ VDD VDD VSS VSS _5146_/CLK _5142_/D _5142_/Q gf180mcu_as_sc_mcu7t3v3__dfxtp_2
XFILLER_83_1499 VDD VDD VSS VSS gf180mcu_as_sc_mcu7t3v3__fillcap_16
XFILLER_96_264 VDD VDD VSS VSS gf180mcu_as_sc_mcu7t3v3__fillcap_4
XTAP_TAPCELL_ROW_149_1535 VDD VSS gf180mcu_as_sc_mcu7t3v3__tap_2
XTAP_TAPCELL_ROW_149_1524 VDD VSS gf180mcu_as_sc_mcu7t3v3__tap_2
X_5073_ VDD VDD VSS VSS _5088_/CLK _5073_/D _5073_/Q gf180mcu_as_sc_mcu7t3v3__dfxtp_2
X_4024_ VDD VDD VSS VSS _4024_/A _4121_/B _4121_/C _4024_/D _4025_/D gf180mcu_as_sc_mcu7t3v3__ao22_2
XFILLER_168_1321 VDD VDD VSS VSS gf180mcu_as_sc_mcu7t3v3__fill_2
XFILLER_64_150 VDD VDD VSS VSS gf180mcu_as_sc_mcu7t3v3__fillcap_8
XFILLER_20_1483 VDD VDD VSS VSS gf180mcu_as_sc_mcu7t3v3__fill_1
XFILLER_94_1562 VDD VDD VSS VSS gf180mcu_as_sc_mcu7t3v3__fill_1
XFILLER_100_14 VDD VDD VSS VSS gf180mcu_as_sc_mcu7t3v3__fill_1
XFILLER_100_25 VDD VDD VSS VSS gf180mcu_as_sc_mcu7t3v3__fillcap_8
XFILLER_178_520 VDD VDD VSS VSS gf180mcu_as_sc_mcu7t3v3__fillcap_4
X_4926_ VDD VDD VSS VSS _5088_/CLK _4926_/D _4926_/Q gf180mcu_as_sc_mcu7t3v3__dfxtp_2
XFILLER_138_406 VDD VDD VSS VSS gf180mcu_as_sc_mcu7t3v3__fillcap_4
XFILLER_142_1527 VDD VDD VSS VSS gf180mcu_as_sc_mcu7t3v3__fillcap_8
X_4857_ VDD VDD VSS VSS _5053_/CLK _4857_/D _4857_/Q gf180mcu_as_sc_mcu7t3v3__dfxtp_2
XTAP_TAPCELL_ROW_72_1_925 VDD VSS gf180mcu_as_sc_mcu7t3v3__tap_2
XFILLER_138_439 VDD VDD VSS VSS gf180mcu_as_sc_mcu7t3v3__fill_2
XFILLER_165_214 VDD VDD VSS VSS gf180mcu_as_sc_mcu7t3v3__fill_1
XFILLER_166_737 VDD VDD VSS VSS gf180mcu_as_sc_mcu7t3v3__fillcap_8
XFILLER_166_759 VDD VDD VSS VSS gf180mcu_as_sc_mcu7t3v3__fillcap_8
XFILLER_176_18 VDD VDD VSS VSS gf180mcu_as_sc_mcu7t3v3__fillcap_16
XFILLER_178_597 VDD VDD VSS VSS gf180mcu_as_sc_mcu7t3v3__fillcap_8
XFILLER_20_275 VDD VDD VSS VSS gf180mcu_as_sc_mcu7t3v3__fill_2
X_3808_ VDD VDD VSS VSS _3923_/A _3918_/A gf180mcu_as_sc_mcu7t3v3__inv_2
XFILLER_109_23 VDD VDD VSS VSS gf180mcu_as_sc_mcu7t3v3__fillcap_8
X_4788_ VDD VDD VSS VSS _5085_/CLK _4788_/D _4788_/Q gf180mcu_as_sc_mcu7t3v3__dfxtp_2
XFILLER_179_1472 VDD VDD VSS VSS gf180mcu_as_sc_mcu7t3v3__fillcap_8
X_3739_ VDD VDD VSS VSS _4861_/D _3739_/C _3753_/B _4115_/A gf180mcu_as_sc_mcu7t3v3__aoi21_2
XFILLER_134_656 VDD VDD VSS VSS gf180mcu_as_sc_mcu7t3v3__fill_2
XFILLER_146_494 VDD VDD VSS VSS gf180mcu_as_sc_mcu7t3v3__fillcap_4
XFILLER_134_678 VDD VDD VSS VSS gf180mcu_as_sc_mcu7t3v3__fill_2
XFILLER_161_453 VDD VDD VSS VSS gf180mcu_as_sc_mcu7t3v3__fillcap_8
XFILLER_175_1358 VDD VDD VSS VSS gf180mcu_as_sc_mcu7t3v3__fill_1
XFILLER_133_188 VDD VDD VSS VSS gf180mcu_as_sc_mcu7t3v3__fillcap_16
XFILLER_134_1000 VDD VDD VSS VSS gf180mcu_as_sc_mcu7t3v3__fill_2
XFILLER_134_1022 VDD VDD VSS VSS gf180mcu_as_sc_mcu7t3v3__fillcap_16
XFILLER_87_253 VDD VDD VSS VSS gf180mcu_as_sc_mcu7t3v3__fill_2
XFILLER_134_1066 VDD VDD VSS VSS gf180mcu_as_sc_mcu7t3v3__fillcap_16
XFILLER_85_37 VDD VDD VSS VSS gf180mcu_as_sc_mcu7t3v3__fill_1
XFILLER_18_53 VDD VDD VSS VSS gf180mcu_as_sc_mcu7t3v3__fillcap_16
XFILLER_99_1451 VDD VDD VSS VSS gf180mcu_as_sc_mcu7t3v3__fillcap_16
XFILLER_5_1499 VDD VDD VSS VSS gf180mcu_as_sc_mcu7t3v3__fillcap_16
XFILLER_70_142 VDD VDD VSS VSS gf180mcu_as_sc_mcu7t3v3__fill_2
XFILLER_180_1053 VDD VDD VSS VSS gf180mcu_as_sc_mcu7t3v3__fill_2
XFILLER_184_512 VDD VDD VSS VSS gf180mcu_as_sc_mcu7t3v3__fillcap_16
XFILLER_34_85 VDD VDD VSS VSS gf180mcu_as_sc_mcu7t3v3__fillcap_4
XTAP_TAPCELL_ROW_97_1_1024 VDD VSS gf180mcu_as_sc_mcu7t3v3__tap_2
XFILLER_157_737 VDD VDD VSS VSS gf180mcu_as_sc_mcu7t3v3__fill_1
XTAP_TAPCELL_ROW_172_2031 VDD VSS gf180mcu_as_sc_mcu7t3v3__tap_2
XFILLER_156_247 VDD VDD VSS VSS gf180mcu_as_sc_mcu7t3v3__fillcap_8
XFILLER_172_707 VDD VDD VSS VSS gf180mcu_as_sc_mcu7t3v3__fillcap_4
XTAP_TAPCELL_ROW_172_2042 VDD VSS gf180mcu_as_sc_mcu7t3v3__tap_2
XFILLER_137_483 VDD VDD VSS VSS gf180mcu_as_sc_mcu7t3v3__fillcap_4
XFILLER_158_1523 VDD VDD VSS VSS gf180mcu_as_sc_mcu7t3v3__fillcap_16
XFILLER_171_206 VDD VDD VSS VSS gf180mcu_as_sc_mcu7t3v3__fillcap_4
XFILLER_171_228 VDD VDD VSS VSS gf180mcu_as_sc_mcu7t3v3__fillcap_16
XFILLER_153_976 VDD VDD VSS VSS gf180mcu_as_sc_mcu7t3v3__fillcap_4
XFILLER_153_998 VDD VDD VSS VSS gf180mcu_as_sc_mcu7t3v3__fillcap_4
XFILLER_124_188 VDD VDD VSS VSS gf180mcu_as_sc_mcu7t3v3__fillcap_16
XFILLER_140_637 VDD VDD VSS VSS gf180mcu_as_sc_mcu7t3v3__fill_1
XFILLER_180_795 VDD VDD VSS VSS gf180mcu_as_sc_mcu7t3v3__fillcap_4
XFILLER_156_1291 VDD VDD VSS VSS gf180mcu_as_sc_mcu7t3v3__fillcap_4
XFILLER_93_212 VDD VDD VSS VSS gf180mcu_as_sc_mcu7t3v3__fillcap_8
XTAP_TAPCELL_ROW_23_3_2384 VDD VSS gf180mcu_as_sc_mcu7t3v3__tap_2
XFILLER_38_139 VDD VDD VSS VSS gf180mcu_as_sc_mcu7t3v3__fillcap_16
XFILLER_43_1483 VDD VDD VSS VSS gf180mcu_as_sc_mcu7t3v3__fillcap_16
XFILLER_78_1502 VDD VDD VSS VSS gf180mcu_as_sc_mcu7t3v3__fillcap_16
XPHY_EDGE_ROW_125_1_Left_577 VDD VSS gf180mcu_as_sc_mcu7t3v3__tap_2
XPHY_EDGE_ROW_179_Right_313 VDD VSS gf180mcu_as_sc_mcu7t3v3__tap_2
XTAP_TAPCELL_ROW_37_1_784 VDD VSS gf180mcu_as_sc_mcu7t3v3__tap_2
XTAP_TAPCELL_ROW_144_1432 VDD VSS gf180mcu_as_sc_mcu7t3v3__tap_2
XTAP_TAPCELL_ROW_144_1421 VDD VSS gf180mcu_as_sc_mcu7t3v3__tap_2
XFILLER_130_1486 VDD VDD VSS VSS gf180mcu_as_sc_mcu7t3v3__fillcap_8
XFILLER_46_172 VDD VDD VSS VSS gf180mcu_as_sc_mcu7t3v3__fill_2
XFILLER_78_1568 VDD VDD VSS VSS gf180mcu_as_sc_mcu7t3v3__fill_1
XFILLER_61_142 VDD VDD VSS VSS gf180mcu_as_sc_mcu7t3v3__fillcap_8
XTAP_TAPCELL_ROW_161_1790 VDD VSS gf180mcu_as_sc_mcu7t3v3__tap_2
XTAP_TAPCELL_ROW_140_1329 VDD VSS gf180mcu_as_sc_mcu7t3v3__tap_2
XTAP_TAPCELL_ROW_111_3_2516 VDD VSS gf180mcu_as_sc_mcu7t3v3__tap_2
XPHY_EDGE_ROW_62_1_Left_514 VDD VSS gf180mcu_as_sc_mcu7t3v3__tap_2
X_2972_ VDD VDD VSS VSS _3182_/B _2972_/B _2972_/C _2973_/C gf180mcu_as_sc_mcu7t3v3__nor3_2
XFILLER_163_1262 VDD VDD VSS VSS gf180mcu_as_sc_mcu7t3v3__fillcap_16
X_4711_ VDD VDD VSS VSS _4717_/S _5258_/Q _5259_/Q _4712_/B gf180mcu_as_sc_mcu7t3v3__mux2_2
XFILLER_148_737 VDD VDD VSS VSS gf180mcu_as_sc_mcu7t3v3__fillcap_16
X_4642_ VDD VDD VSS VSS _4680_/B _5484_/A _5233_/Q _5233_/D gf180mcu_as_sc_mcu7t3v3__mux2_2
XFILLER_147_247 VDD VDD VSS VSS gf180mcu_as_sc_mcu7t3v3__fillcap_4
X_4573_ VDD VDD VSS VSS _4574_/D _4573_/B _4573_/A gf180mcu_as_sc_mcu7t3v3__nor2_2
X_3524_ VDD VDD VSS VSS _3524_/D _3524_/A _3817_/A _3524_/C _3525_/B gf180mcu_as_sc_mcu7t3v3__ao31_2
XFILLER_115_144 VDD VDD VSS VSS gf180mcu_as_sc_mcu7t3v3__fill_1
XFILLER_144_976 VDD VDD VSS VSS gf180mcu_as_sc_mcu7t3v3__fill_1
X_3455_ VDD VDD VSS VSS _3731_/A _3455_/B _3455_/C _4826_/D _3730_/D gf180mcu_as_sc_mcu7t3v3__aoi211_2
XFILLER_115_188 VDD VDD VSS VSS gf180mcu_as_sc_mcu7t3v3__fillcap_8
XFILLER_143_486 VDD VDD VSS VSS gf180mcu_as_sc_mcu7t3v3__fillcap_4
X_2406_ VDD VDD VSS VSS _2546_/A _4955_/Q gf180mcu_as_sc_mcu7t3v3__inv_2
XPHY_EDGE_ROW_86_1_Right_85 VDD VSS gf180mcu_as_sc_mcu7t3v3__tap_2
XFILLER_135_1364 VDD VDD VSS VSS gf180mcu_as_sc_mcu7t3v3__fillcap_16
X_3386_ VDD VDD VSS VSS _4040_/D _3466_/B _3386_/C _3464_/B _3388_/C gf180mcu_as_sc_mcu7t3v3__ao211_2
XTAP_TAPCELL_ROW_168_1944 VDD VSS gf180mcu_as_sc_mcu7t3v3__tap_2
X_5125_ VDD VDD VSS VSS clkload8/A _5125_/D _5125_/Q gf180mcu_as_sc_mcu7t3v3__dfxtp_2
XTAP_TAPCELL_ROW_168_1955 VDD VSS gf180mcu_as_sc_mcu7t3v3__tap_2
XFILLER_22_1534 VDD VDD VSS VSS gf180mcu_as_sc_mcu7t3v3__fillcap_16
X_5056_ VDD VDD VSS VSS _5088_/CLK _5056_/D _5056_/Q gf180mcu_as_sc_mcu7t3v3__dfxtp_2
XPHY_EDGE_ROW_71_3_Right_390 VDD VSS gf180mcu_as_sc_mcu7t3v3__tap_2
XFILLER_22_1556 VDD VDD VSS VSS gf180mcu_as_sc_mcu7t3v3__fillcap_8
X_4007_ VDD VDD VSS VSS _4007_/A _4101_/C _4007_/C _4007_/D _4009_/C gf180mcu_as_sc_mcu7t3v3__ao211_2
XFILLER_168_1173 VDD VDD VSS VSS gf180mcu_as_sc_mcu7t3v3__fillcap_4
XFILLER_52_142 VDD VDD VSS VSS gf180mcu_as_sc_mcu7t3v3__fill_2
XFILLER_164_1037 VDD VDD VSS VSS gf180mcu_as_sc_mcu7t3v3__fillcap_16
XFILLER_52_186 VDD VDD VSS VSS gf180mcu_as_sc_mcu7t3v3__fillcap_8
XFILLER_146_1471 VDD VDD VSS VSS gf180mcu_as_sc_mcu7t3v3__fillcap_16
XFILLER_179_884 VDD VDD VSS VSS gf180mcu_as_sc_mcu7t3v3__fillcap_8
X_4909_ VDD VDD VSS VSS _5159_/CLK _4909_/D _4909_/Q gf180mcu_as_sc_mcu7t3v3__dfxtp_2
XFILLER_166_534 VDD VDD VSS VSS gf180mcu_as_sc_mcu7t3v3__fillcap_8
XTAP_TAPCELL_ROW_46_1_819 VDD VSS gf180mcu_as_sc_mcu7t3v3__tap_2
XFILLER_107_1499 VDD VDD VSS VSS gf180mcu_as_sc_mcu7t3v3__fillcap_16
XFILLER_138_247 VDD VDD VSS VSS gf180mcu_as_sc_mcu7t3v3__fillcap_8
XFILLER_153_228 VDD VDD VSS VSS gf180mcu_as_sc_mcu7t3v3__fillcap_16
XFILLER_154_729 VDD VDD VSS VSS gf180mcu_as_sc_mcu7t3v3__fillcap_4
XFILLER_106_133 VDD VDD VSS VSS gf180mcu_as_sc_mcu7t3v3__fillcap_8
XFILLER_136_10 VDD VDD VSS VSS gf180mcu_as_sc_mcu7t3v3__fill_2
XFILLER_175_1122 VDD VDD VSS VSS gf180mcu_as_sc_mcu7t3v3__fill_1
XFILLER_181_548 VDD VDD VSS VSS gf180mcu_as_sc_mcu7t3v3__fill_1
XFILLER_135_976 VDD VDD VSS VSS gf180mcu_as_sc_mcu7t3v3__fillcap_4
XFILLER_136_1106 VDD VDD VSS VSS gf180mcu_as_sc_mcu7t3v3__fill_2
XFILLER_136_32 VDD VDD VSS VSS gf180mcu_as_sc_mcu7t3v3__fill_2
XFILLER_106_177 VDD VDD VSS VSS gf180mcu_as_sc_mcu7t3v3__fillcap_16
XFILLER_150_979 VDD VDD VSS VSS gf180mcu_as_sc_mcu7t3v3__fill_2
XFILLER_66_1483 VDD VDD VSS VSS gf180mcu_as_sc_mcu7t3v3__fill_1
Xinput301 VDD VDD VSS VSS west_in[26] _4143_/A gf180mcu_as_sc_mcu7t3v3__buff_2
Xinput312 VDD VDD VSS VSS west_in[5] _3973_/A gf180mcu_as_sc_mcu7t3v3__buff_2
XFILLER_27_1467 VDD VDD VSS VSS gf180mcu_as_sc_mcu7t3v3__fillcap_16
XFILLER_75_201 VDD VDD VSS VSS gf180mcu_as_sc_mcu7t3v3__fillcap_8
XFILLER_152_53 VDD VDD VSS VSS gf180mcu_as_sc_mcu7t3v3__fillcap_16
XFILLER_75_245 VDD VDD VSS VSS gf180mcu_as_sc_mcu7t3v3__fillcap_4
XFILLER_75_278 VDD VDD VSS VSS gf180mcu_as_sc_mcu7t3v3__fill_2
XFILLER_147_1202 VDD VDD VSS VSS gf180mcu_as_sc_mcu7t3v3__fillcap_16
XFILLER_43_142 VDD VDD VSS VSS gf180mcu_as_sc_mcu7t3v3__fill_2
X_4906__961 VDD VDD VSS VSS _4906_/D gf180mcu_as_sc_mcu7t3v3__tiel_4
XFILLER_129_247 VDD VDD VSS VSS gf180mcu_as_sc_mcu7t3v3__fillcap_4
XFILLER_177_50 VDD VDD VSS VSS gf180mcu_as_sc_mcu7t3v3__fillcap_16
XFILLER_184_342 VDD VDD VSS VSS gf180mcu_as_sc_mcu7t3v3__fillcap_16
XFILLER_61_72 VDD VDD VSS VSS gf180mcu_as_sc_mcu7t3v3__fillcap_16
XFILLER_177_72 VDD VDD VSS VSS gf180mcu_as_sc_mcu7t3v3__fillcap_16
XFILLER_6_34 VDD VDD VSS VSS gf180mcu_as_sc_mcu7t3v3__fill_1
XANTENNA_5 VDD VDD VSS VSS _4192_/B gf180mcu_as_sc_mcu7t3v3__diode_2
XFILLER_172_559 VDD VDD VSS VSS gf180mcu_as_sc_mcu7t3v3__fillcap_16
XTAP_TAPCELL_ROW_137_1280 VDD VSS gf180mcu_as_sc_mcu7t3v3__tap_2
XPHY_EDGE_ROW_144_Right_278 VDD VSS gf180mcu_as_sc_mcu7t3v3__tap_2
XFILLER_112_103 VDD VDD VSS VSS gf180mcu_as_sc_mcu7t3v3__fill_2
XFILLER_140_412 VDD VDD VSS VSS gf180mcu_as_sc_mcu7t3v3__fill_1
XFILLER_180_592 VDD VDD VSS VSS gf180mcu_as_sc_mcu7t3v3__fill_2
XFILLER_84_1550 VDD VDD VSS VSS gf180mcu_as_sc_mcu7t3v3__fillcap_4
XTAP_TAPCELL_ROW_121_1_1120 VDD VSS gf180mcu_as_sc_mcu7t3v3__tap_2
XFILLER_140_467 VDD VDD VSS VSS gf180mcu_as_sc_mcu7t3v3__fill_1
XFILLER_171_1520 VDD VDD VSS VSS gf180mcu_as_sc_mcu7t3v3__fillcap_16
XFILLER_171_1542 VDD VDD VSS VSS gf180mcu_as_sc_mcu7t3v3__fillcap_16
XFILLER_3_282 VDD VDD VSS VSS gf180mcu_as_sc_mcu7t3v3__fill_1
X_3240_ VDD VDD VSS VSS _3240_/A _3240_/B _3240_/C _3240_/D _3242_/A gf180mcu_as_sc_mcu7t3v3__ao211_2
XFILLER_171_1564 VDD VDD VSS VSS gf180mcu_as_sc_mcu7t3v3__fill_1
Xmesh_tile_927 VDD VDD VSS VSS sw_out[0] gf180mcu_as_sc_mcu7t3v3__tiel_4
Xmesh_tile_916 VDD VDD VSS VSS nw_out[23] gf180mcu_as_sc_mcu7t3v3__tiel_4
Xmesh_tile_905 VDD VDD VSS VSS nw_out[12] gf180mcu_as_sc_mcu7t3v3__tiel_4
X_3171_ VDD VDD VSS VSS _4146_/A _3240_/B _3171_/C _3171_/D _3172_/D gf180mcu_as_sc_mcu7t3v3__ao22_2
XPHY_EDGE_ROW_36_3_Left_170 VDD VSS gf180mcu_as_sc_mcu7t3v3__tap_2
Xmesh_tile_949 VDD VDD VSS VSS sw_out[22] gf180mcu_as_sc_mcu7t3v3__tiel_4
Xmesh_tile_938 VDD VDD VSS VSS sw_out[11] gf180mcu_as_sc_mcu7t3v3__tiel_4
XTAP_TAPCELL_ROW_163_1841 VDD VSS gf180mcu_as_sc_mcu7t3v3__tap_2
XTAP_TAPCELL_ROW_101_1_1040 VDD VSS gf180mcu_as_sc_mcu7t3v3__tap_2
XTAP_TAPCELL_ROW_163_1852 VDD VSS gf180mcu_as_sc_mcu7t3v3__tap_2
XTAP_TAPCELL_ROW_129_3_2543 VDD VSS gf180mcu_as_sc_mcu7t3v3__tap_2
XFILLER_81_248 VDD VDD VSS VSS gf180mcu_as_sc_mcu7t3v3__fillcap_4
XFILLER_179_136 VDD VDD VSS VSS gf180mcu_as_sc_mcu7t3v3__fillcap_4
XFILLER_91_1521 VDD VDD VSS VSS gf180mcu_as_sc_mcu7t3v3__fillcap_16
XFILLER_179_158 VDD VDD VSS VSS gf180mcu_as_sc_mcu7t3v3__fillcap_16
XTAP_TAPCELL_ROW_86_1_979 VDD VSS gf180mcu_as_sc_mcu7t3v3__tap_2
XFILLER_148_501 VDD VDD VSS VSS gf180mcu_as_sc_mcu7t3v3__fillcap_16
X_2955_ VDD VDD VSS VSS _3194_/S _2955_/B _2955_/A _2956_/B gf180mcu_as_sc_mcu7t3v3__mux2_2
XTAP_TAPCELL_ROW_9_1_670 VDD VSS gf180mcu_as_sc_mcu7t3v3__tap_2
XFILLER_148_545 VDD VDD VSS VSS gf180mcu_as_sc_mcu7t3v3__fillcap_4
X_2886_ VDD VDD VSS VSS _3511_/A _3520_/A _3776_/A gf180mcu_as_sc_mcu7t3v3__or2_2
XFILLER_148_578 VDD VDD VSS VSS gf180mcu_as_sc_mcu7t3v3__fill_1
XFILLER_159_1106 VDD VDD VSS VSS gf180mcu_as_sc_mcu7t3v3__fill_2
X_4625_ VDD VDD VSS VSS _5219_/Q _4629_/B _4629_/C _5220_/Q _5219_/D gf180mcu_as_sc_mcu7t3v3__ao22_2
XTAP_TAPCELL_ROW_42_1_803 VDD VSS gf180mcu_as_sc_mcu7t3v3__tap_2
XFILLER_163_559 VDD VDD VSS VSS gf180mcu_as_sc_mcu7t3v3__fill_1
XFILLER_176_1420 VDD VDD VSS VSS gf180mcu_as_sc_mcu7t3v3__fillcap_8
X_4556_ VDD VDD VSS VSS _5184_/Q _4565_/B _4556_/C _4556_/D _5184_/D gf180mcu_as_sc_mcu7t3v3__ao211_2
XFILLER_150_209 VDD VDD VSS VSS gf180mcu_as_sc_mcu7t3v3__fillcap_8
XFILLER_89_1483 VDD VDD VSS VSS gf180mcu_as_sc_mcu7t3v3__fillcap_16
X_3507_ VDD VDD VSS VSS _3533_/B _3533_/A _3812_/B gf180mcu_as_sc_mcu7t3v3__and2_2
XFILLER_171_570 VDD VDD VSS VSS gf180mcu_as_sc_mcu7t3v3__fillcap_4
XFILLER_171_581 VDD VDD VSS VSS gf180mcu_as_sc_mcu7t3v3__fillcap_4
X_4487_ VDD VDD VSS VSS _4491_/B _5077_/Q _4518_/S gf180mcu_as_sc_mcu7t3v3__nand2_2
XFILLER_103_158 VDD VDD VSS VSS gf180mcu_as_sc_mcu7t3v3__fill_2
Xclkbuf_leaf_9_clk_regs VDD VDD VSS VSS clkbuf_3_2_0_clk_regs/Y clkload8/A gf180mcu_as_sc_mcu7t3v3__clkbuff_12
X_3438_ VDD VDD VSS VSS _4089_/A _3453_/C _3438_/C _3439_/C _3455_/B gf180mcu_as_sc_mcu7t3v3__aoi211_2
X_3369_ VDD VDD VSS VSS _4926_/Q _3440_/B _3440_/C _4023_/A _3370_/C gf180mcu_as_sc_mcu7t3v3__ao22_2
XFILLER_57_212 VDD VDD VSS VSS gf180mcu_as_sc_mcu7t3v3__fillcap_4
XFILLER_6_1550 VDD VDD VSS VSS gf180mcu_as_sc_mcu7t3v3__fillcap_4
X_5108_ VDD VDD VSS VSS _5186_/CLK _5108_/D _5108_/Q gf180mcu_as_sc_mcu7t3v3__dfxtp_2
XPHY_EDGE_ROW_72_3_Right_391 VDD VSS gf180mcu_as_sc_mcu7t3v3__tap_2
XFILLER_72_237 VDD VDD VSS VSS gf180mcu_as_sc_mcu7t3v3__fillcap_8
X_5039_ VDD VDD VSS VSS _5173_/CLK _5039_/D _5039_/Q gf180mcu_as_sc_mcu7t3v3__dfxtp_2
XFILLER_148_1533 VDD VDD VSS VSS gf180mcu_as_sc_mcu7t3v3__fillcap_4
XFILLER_25_120 VDD VDD VSS VSS gf180mcu_as_sc_mcu7t3v3__fillcap_16
XFILLER_25_142 VDD VDD VSS VSS gf180mcu_as_sc_mcu7t3v3__fillcap_16
XFILLER_82_27 VDD VDD VSS VSS gf180mcu_as_sc_mcu7t3v3__fillcap_8
XFILLER_144_1408 VDD VDD VSS VSS gf180mcu_as_sc_mcu7t3v3__fill_1
XFILLER_40_123 VDD VDD VSS VSS gf180mcu_as_sc_mcu7t3v3__fillcap_16
XFILLER_80_292 VDD VDD VSS VSS gf180mcu_as_sc_mcu7t3v3__fillcap_8
XFILLER_139_501 VDD VDD VSS VSS gf180mcu_as_sc_mcu7t3v3__fill_1
XFILLER_139_523 VDD VDD VSS VSS gf180mcu_as_sc_mcu7t3v3__fill_1
XFILLER_142_1154 VDD VDD VSS VSS gf180mcu_as_sc_mcu7t3v3__fill_1
XFILLER_154_504 VDD VDD VSS VSS gf180mcu_as_sc_mcu7t3v3__fillcap_16
XTAP_TAPCELL_ROW_28_1_748 VDD VSS gf180mcu_as_sc_mcu7t3v3__tap_2
XFILLER_110_2 VDD VDD VSS VSS gf180mcu_as_sc_mcu7t3v3__fillcap_8
XFILLER_177_1239 VDD VDD VSS VSS gf180mcu_as_sc_mcu7t3v3__fillcap_4
XTAP_TAPCELL_ROW_59_3_2438 VDD VSS gf180mcu_as_sc_mcu7t3v3__tap_2
XFILLER_141_209 VDD VDD VSS VSS gf180mcu_as_sc_mcu7t3v3__fill_1
XFILLER_155_1504 VDD VDD VSS VSS gf180mcu_as_sc_mcu7t3v3__fillcap_16
XFILLER_68_1534 VDD VDD VSS VSS gf180mcu_as_sc_mcu7t3v3__fillcap_16
XFILLER_68_1556 VDD VDD VSS VSS gf180mcu_as_sc_mcu7t3v3__fillcap_8
XFILLER_162_592 VDD VDD VSS VSS gf180mcu_as_sc_mcu7t3v3__fill_2
XPHY_EDGE_ROW_0_3_Right_319 VDD VSS gf180mcu_as_sc_mcu7t3v3__tap_2
XFILLER_0_252 VDD VDD VSS VSS gf180mcu_as_sc_mcu7t3v3__fill_2
XFILLER_150_787 VDD VDD VSS VSS gf180mcu_as_sc_mcu7t3v3__fill_1
Xinput120 VDD VDD VSS VSS north_in[17] _4071_/A gf180mcu_as_sc_mcu7t3v3__buff_2
XFILLER_0_274 VDD VDD VSS VSS gf180mcu_as_sc_mcu7t3v3__fill_2
Xinput131 VDD VDD VSS VSS north_in[27] _4152_/A gf180mcu_as_sc_mcu7t3v3__buff_2
Xinput142 VDD VDD VSS VSS north_in[6] _3982_/A gf180mcu_as_sc_mcu7t3v3__buff_2
Xinput153 VDD VDD VSS VSS nw_in[16] _4064_/A gf180mcu_as_sc_mcu7t3v3__buff_2
Xinput164 VDD VDD VSS VSS nw_in[26] _4146_/A gf180mcu_as_sc_mcu7t3v3__buff_2
Xinput175 VDD VDD VSS VSS nw_in[5] _3976_/A gf180mcu_as_sc_mcu7t3v3__buff_2
Xinput186 VDD VDD VSS VSS se_in[14] _4049_/A gf180mcu_as_sc_mcu7t3v3__buff_2
Xinput197 VDD VDD VSS VSS se_in[24] _4131_/A gf180mcu_as_sc_mcu7t3v3__buff_2
XFILLER_40_1486 VDD VDD VSS VSS gf180mcu_as_sc_mcu7t3v3__fillcap_16
XFILLER_147_1098 VDD VDD VSS VSS gf180mcu_as_sc_mcu7t3v3__fillcap_16
XFILLER_160_1210 VDD VDD VSS VSS gf180mcu_as_sc_mcu7t3v3__fillcap_8
XFILLER_160_1243 VDD VDD VSS VSS gf180mcu_as_sc_mcu7t3v3__fillcap_4
XFILLER_176_139 VDD VDD VSS VSS gf180mcu_as_sc_mcu7t3v3__fillcap_16
X_2740_ VDD VDD VSS VSS _4947_/Q _2740_/B _2740_/A _5481_/A gf180mcu_as_sc_mcu7t3v3__mux2_2
XTAP_TAPCELL_ROW_82_1_963 VDD VSS gf180mcu_as_sc_mcu7t3v3__tap_2
XTAP_TAPCELL_ROW_139_1320 VDD VSS gf180mcu_as_sc_mcu7t3v3__tap_2
X_2671_ VDD VDD VSS VSS _2672_/D _2709_/A _2736_/B _2671_/A gf180mcu_as_sc_mcu7t3v3__aoi21b_2
XTAP_TAPCELL_ROW_135_1217 VDD VSS gf180mcu_as_sc_mcu7t3v3__tap_2
XFILLER_117_228 VDD VDD VSS VSS gf180mcu_as_sc_mcu7t3v3__fillcap_16
XFILLER_145_559 VDD VDD VSS VSS gf180mcu_as_sc_mcu7t3v3__fill_1
XFILLER_184_172 VDD VDD VSS VSS gf180mcu_as_sc_mcu7t3v3__fill_1
X_4410_ VDD VDD VSS VSS _4414_/B _5068_/Q _4579_/S gf180mcu_as_sc_mcu7t3v3__nand2_2
XTAP_TAPCELL_ROW_135_1228 VDD VSS gf180mcu_as_sc_mcu7t3v3__tap_2
XTAP_TAPCELL_ROW_11_3_2366 VDD VSS gf180mcu_as_sc_mcu7t3v3__tap_2
XFILLER_141_710 VDD VDD VSS VSS gf180mcu_as_sc_mcu7t3v3__fill_1
XFILLER_153_570 VDD VDD VSS VSS gf180mcu_as_sc_mcu7t3v3__fillcap_4
XFILLER_154_1003 VDD VDD VSS VSS gf180mcu_as_sc_mcu7t3v3__fill_1
XFILLER_158_1161 VDD VDD VSS VSS gf180mcu_as_sc_mcu7t3v3__fill_2
X_4341_ VDD VDD VSS VSS _4341_/S _5031_/Q _5060_/Q _4342_/A gf180mcu_as_sc_mcu7t3v3__mux2_2
XTAP_TAPCELL_ROW_152_1597 VDD VSS gf180mcu_as_sc_mcu7t3v3__tap_2
XFILLER_125_294 VDD VDD VSS VSS gf180mcu_as_sc_mcu7t3v3__fillcap_4
X_4272_ VDD VDD VSS VSS _4273_/S _5484_/A _5106_/Q _5106_/D gf180mcu_as_sc_mcu7t3v3__mux2_2
X_3223_ VDD VDD VSS VSS _3223_/D _3508_/A _3223_/B _3223_/C _3225_/A gf180mcu_as_sc_mcu7t3v3__ao31_2
XFILLER_100_139 VDD VDD VSS VSS gf180mcu_as_sc_mcu7t3v3__fillcap_4
XFILLER_39_212 VDD VDD VSS VSS gf180mcu_as_sc_mcu7t3v3__fillcap_16
X_3154_ VDD VDD VSS VSS _3179_/B _4939_/Q _3155_/D gf180mcu_as_sc_mcu7t3v3__or2_2
X_3085_ VDD VDD VSS VSS _3145_/A _3085_/B _3085_/C _3145_/D _3087_/C gf180mcu_as_sc_mcu7t3v3__ao211_2
XFILLER_22_101 VDD VDD VSS VSS gf180mcu_as_sc_mcu7t3v3__fillcap_4
XFILLER_22_123 VDD VDD VSS VSS gf180mcu_as_sc_mcu7t3v3__fillcap_16
XFILLER_108_1550 VDD VDD VSS VSS gf180mcu_as_sc_mcu7t3v3__fillcap_4
XFILLER_143_1430 VDD VDD VSS VSS gf180mcu_as_sc_mcu7t3v3__fill_1
XFILLER_161_1018 VDD VDD VSS VSS gf180mcu_as_sc_mcu7t3v3__fill_2
X_3987_ VDD VDD VSS VSS _3987_/B _4059_/A _4235_/B gf180mcu_as_sc_mcu7t3v3__and2_2
X_2938_ VDD VDD VSS VSS _3243_/A _2947_/A _2947_/B gf180mcu_as_sc_mcu7t3v3__nor2b_2
XFILLER_178_1504 VDD VDD VSS VSS gf180mcu_as_sc_mcu7t3v3__fill_1
XFILLER_17_1499 VDD VDD VSS VSS gf180mcu_as_sc_mcu7t3v3__fillcap_16
XFILLER_108_239 VDD VDD VSS VSS gf180mcu_as_sc_mcu7t3v3__fillcap_4
X_2869_ VDD VDD VSS VSS _4742_/A _2871_/B _2869_/C _4765_/D gf180mcu_as_sc_mcu7t3v3__nor3_2
XFILLER_123_209 VDD VDD VSS VSS gf180mcu_as_sc_mcu7t3v3__fill_1
XFILLER_163_356 VDD VDD VSS VSS gf180mcu_as_sc_mcu7t3v3__fill_2
X_4608_ VDD VDD VSS VSS _5202_/Q _4612_/B _4612_/C _5203_/Q _5202_/D gf180mcu_as_sc_mcu7t3v3__ao22_2
XFILLER_117_34 VDD VDD VSS VSS gf180mcu_as_sc_mcu7t3v3__fillcap_4
XFILLER_144_570 VDD VDD VSS VSS gf180mcu_as_sc_mcu7t3v3__fillcap_4
XFILLER_144_592 VDD VDD VSS VSS gf180mcu_as_sc_mcu7t3v3__fill_2
X_4539_ VDD VDD VSS VSS _5182_/Q _4565_/B _4539_/C _4539_/D _5182_/D gf180mcu_as_sc_mcu7t3v3__ao211_2
XTAP_TAPCELL_ROW_24_1_732 VDD VSS gf180mcu_as_sc_mcu7t3v3__tap_2
XFILLER_131_220 VDD VDD VSS VSS gf180mcu_as_sc_mcu7t3v3__fill_1
XFILLER_176_1294 VDD VDD VSS VSS gf180mcu_as_sc_mcu7t3v3__fill_1
XFILLER_89_134 VDD VDD VSS VSS gf180mcu_as_sc_mcu7t3v3__fillcap_4
XFILLER_115_1521 VDD VDD VSS VSS gf180mcu_as_sc_mcu7t3v3__fillcap_16
XFILLER_172_1169 VDD VDD VSS VSS gf180mcu_as_sc_mcu7t3v3__fillcap_4
XFILLER_77_38 VDD VDD VSS VSS gf180mcu_as_sc_mcu7t3v3__fill_2
XPHY_EDGE_ROW_49_1_Right_48 VDD VSS gf180mcu_as_sc_mcu7t3v3__tap_2
Xhold1030 VDD VDD VSS VSS _5273_/Q _4744_/A gf180mcu_as_sc_mcu7t3v3__buff_2
Xhold1041 VDD VDD VSS VSS _2587_/Y hold1041/Y gf180mcu_as_sc_mcu7t3v3__buff_2
XFILLER_93_37 VDD VDD VSS VSS gf180mcu_as_sc_mcu7t3v3__fill_1
Xhold1052 VDD VDD VSS VSS _4959_/Q hold1052/Y gf180mcu_as_sc_mcu7t3v3__buff_2
XPHY_EDGE_ROW_73_3_Right_392 VDD VSS gf180mcu_as_sc_mcu7t3v3__tap_2
XFILLER_148_1341 VDD VDD VSS VSS gf180mcu_as_sc_mcu7t3v3__fill_2
XFILLER_26_53 VDD VDD VSS VSS gf180mcu_as_sc_mcu7t3v3__fillcap_16
X_4903__964 VDD VDD VSS VSS _4903_/D gf180mcu_as_sc_mcu7t3v3__tiel_4
XFILLER_144_1227 VDD VDD VSS VSS gf180mcu_as_sc_mcu7t3v3__fillcap_8
XFILLER_139_342 VDD VDD VSS VSS gf180mcu_as_sc_mcu7t3v3__fillcap_8
XFILLER_158_139 VDD VDD VSS VSS gf180mcu_as_sc_mcu7t3v3__fillcap_16
XFILLER_42_52 VDD VDD VSS VSS gf180mcu_as_sc_mcu7t3v3__fill_1
XFILLER_167_695 VDD VDD VSS VSS gf180mcu_as_sc_mcu7t3v3__fillcap_4
XFILLER_181_142 VDD VDD VSS VSS gf180mcu_as_sc_mcu7t3v3__fillcap_8
XFILLER_135_570 VDD VDD VSS VSS gf180mcu_as_sc_mcu7t3v3__fillcap_4
XFILLER_154_378 VDD VDD VSS VSS gf180mcu_as_sc_mcu7t3v3__fill_1
XPHY_EDGE_ROW_71_1_Left_523 VDD VSS gf180mcu_as_sc_mcu7t3v3__tap_2
XFILLER_81_1553 VDD VDD VSS VSS gf180mcu_as_sc_mcu7t3v3__fillcap_16
XTAP_TAPCELL_ROW_182_2269 VDD VSS gf180mcu_as_sc_mcu7t3v3__tap_2
XTAP_TAPCELL_ROW_182_2258 VDD VSS gf180mcu_as_sc_mcu7t3v3__tap_2
X_4890_ VDD VDD VSS VSS _4904_/CLK _4890_/D _4890_/Q gf180mcu_as_sc_mcu7t3v3__dfxtp_2
X_3910_ VDD VDD VSS VSS _4059_/A _4141_/D gf180mcu_as_sc_mcu7t3v3__inv_2
XFILLER_178_938 VDD VDD VSS VSS gf180mcu_as_sc_mcu7t3v3__fillcap_4
X_3841_ VDD VDD VSS VSS _3845_/B _4911_/Q _4912_/Q gf180mcu_as_sc_mcu7t3v3__nand2_2
XPHY_EDGE_ROW_95_1_Right_94 VDD VSS gf180mcu_as_sc_mcu7t3v3__tap_2
X_3772_ VDD VDD VSS VSS _4154_/A _3792_/B _3791_/B _4154_/D _3773_/D gf180mcu_as_sc_mcu7t3v3__ao22_2
XTAP_TAPCELL_ROW_158_1740 VDD VSS gf180mcu_as_sc_mcu7t3v3__tap_2
XFILLER_73_2 VDD VDD VSS VSS gf180mcu_as_sc_mcu7t3v3__fillcap_8
X_2723_ VDD VDD VSS VSS _2737_/A _2723_/B _2723_/C _2723_/D _2723_/Y gf180mcu_as_sc_mcu7t3v3__ao22_2
XFILLER_173_632 VDD VDD VSS VSS gf180mcu_as_sc_mcu7t3v3__fill_1
XFILLER_8_171 VDD VDD VSS VSS gf180mcu_as_sc_mcu7t3v3__fillcap_4
XTAP_TAPCELL_ROW_64_1_892 VDD VSS gf180mcu_as_sc_mcu7t3v3__tap_2
XTAP_TAPCELL_ROW_154_1648 VDD VSS gf180mcu_as_sc_mcu7t3v3__tap_2
XTAP_TAPCELL_ROW_154_1637 VDD VSS gf180mcu_as_sc_mcu7t3v3__tap_2
XFILLER_145_356 VDD VDD VSS VSS gf180mcu_as_sc_mcu7t3v3__fill_2
XFILLER_146_868 VDD VDD VSS VSS gf180mcu_as_sc_mcu7t3v3__fillcap_4
XFILLER_8_193 VDD VDD VSS VSS gf180mcu_as_sc_mcu7t3v3__fillcap_16
Xoutput402 VDD VDD VSS VSS _4823_/Q south_out[18] gf180mcu_as_sc_mcu7t3v3__buff_2
X_2654_ VDD VDD VSS VSS _2673_/B _5130_/Q _5194_/Q _2655_/B gf180mcu_as_sc_mcu7t3v3__mux2_2
XTAP_TAPCELL_ROW_29_3_2393 VDD VSS gf180mcu_as_sc_mcu7t3v3__tap_2
Xoutput413 VDD VDD VSS VSS _4833_/Q south_out[28] gf180mcu_as_sc_mcu7t3v3__buff_2
Xoutput424 VDD VDD VSS VSS _4812_/Q south_out[7] gf180mcu_as_sc_mcu7t3v3__buff_2
Xoutput435 VDD VDD VSS VSS _4890_/Q west_out[17] gf180mcu_as_sc_mcu7t3v3__buff_2
X_2585_ VDD VDD VSS VSS _2585_/Y _2585_/B _2692_/S gf180mcu_as_sc_mcu7t3v3__nand2_2
XFILLER_160_348 VDD VDD VSS VSS gf180mcu_as_sc_mcu7t3v3__fillcap_16
XFILLER_86_1486 VDD VDD VSS VSS gf180mcu_as_sc_mcu7t3v3__fillcap_16
Xoutput446 VDD VDD VSS VSS _4900_/Q west_out[27] gf180mcu_as_sc_mcu7t3v3__buff_2
Xoutput457 VDD VDD VSS VSS _4879_/Q west_out[6] gf180mcu_as_sc_mcu7t3v3__buff_2
X_4324_ VDD VDD VSS VSS _4325_/S _5154_/Q _5153_/Q _5153_/D gf180mcu_as_sc_mcu7t3v3__mux2_2
XFILLER_141_562 VDD VDD VSS VSS gf180mcu_as_sc_mcu7t3v3__fillcap_8
XFILLER_86_104 VDD VDD VSS VSS gf180mcu_as_sc_mcu7t3v3__fill_1
XTAP_TAPCELL_ROW_117_3_2525 VDD VSS gf180mcu_as_sc_mcu7t3v3__tap_2
X_4255_ VDD VDD VSS VSS _4257_/S _4255_/B _5091_/Q _5091_/D gf180mcu_as_sc_mcu7t3v3__mux2_2
X_4186_ VDD VDD VSS VSS _4246_/B _4188_/B _4188_/C _5024_/Q _5024_/D gf180mcu_as_sc_mcu7t3v3__ao22_2
X_3206_ VDD VDD VSS VSS _3792_/A _3240_/B _3206_/C _3206_/D _3207_/A gf180mcu_as_sc_mcu7t3v3__ao22_2
XFILLER_103_14 VDD VDD VSS VSS gf180mcu_as_sc_mcu7t3v3__fill_2
X_3137_ VDD VDD VSS VSS _3137_/B _4937_/Q _3138_/D gf180mcu_as_sc_mcu7t3v3__or2_2
XFILLER_110_1451 VDD VDD VSS VSS gf180mcu_as_sc_mcu7t3v3__fillcap_16
XFILLER_167_1216 VDD VDD VSS VSS gf180mcu_as_sc_mcu7t3v3__fillcap_4
XFILLER_3_1553 VDD VDD VSS VSS gf180mcu_as_sc_mcu7t3v3__fillcap_16
XFILLER_103_69 VDD VDD VSS VSS gf180mcu_as_sc_mcu7t3v3__fill_1
X_3068_ VDD VDD VSS VSS _4045_/A _3177_/B _3236_/C _4047_/A _3069_/C gf180mcu_as_sc_mcu7t3v3__ao22_2
XFILLER_179_18 VDD VDD VSS VSS gf180mcu_as_sc_mcu7t3v3__fillcap_16
XFILLER_50_251 VDD VDD VSS VSS gf180mcu_as_sc_mcu7t3v3__fill_2
XFILLER_149_695 VDD VDD VSS VSS gf180mcu_as_sc_mcu7t3v3__fillcap_4
XFILLER_163_120 VDD VDD VSS VSS gf180mcu_as_sc_mcu7t3v3__fillcap_16
XFILLER_163_142 VDD VDD VSS VSS gf180mcu_as_sc_mcu7t3v3__fillcap_16
XFILLER_128_88 VDD VDD VSS VSS gf180mcu_as_sc_mcu7t3v3__fillcap_4
XFILLER_145_890 VDD VDD VSS VSS gf180mcu_as_sc_mcu7t3v3__fillcap_4
XFILLER_178_1367 VDD VDD VSS VSS gf180mcu_as_sc_mcu7t3v3__fillcap_8
XFILLER_88_37 VDD VDD VSS VSS gf180mcu_as_sc_mcu7t3v3__fill_1
XFILLER_151_348 VDD VDD VSS VSS gf180mcu_as_sc_mcu7t3v3__fill_2
XFILLER_65_1515 VDD VDD VSS VSS gf180mcu_as_sc_mcu7t3v3__fillcap_4
XFILLER_65_1537 VDD VDD VSS VSS gf180mcu_as_sc_mcu7t3v3__fillcap_16
XFILLER_152_1507 VDD VDD VSS VSS gf180mcu_as_sc_mcu7t3v3__fillcap_4
XFILLER_144_65 VDD VDD VSS VSS gf180mcu_as_sc_mcu7t3v3__fillcap_16
XFILLER_160_893 VDD VDD VSS VSS gf180mcu_as_sc_mcu7t3v3__fillcap_8
Xfanout640 VDD VDD VSS VSS _4600_/C _4607_/C gf180mcu_as_sc_mcu7t3v3__buff_2
Xfanout651 VDD VDD VSS VSS _3931_/Y fanout651/Y gf180mcu_as_sc_mcu7t3v3__buff_2
XTAP_TAPCELL_ROW_73_1_927 VDD VSS gf180mcu_as_sc_mcu7t3v3__tap_2
XFILLER_150_1231 VDD VDD VSS VSS gf180mcu_as_sc_mcu7t3v3__fill_2
XFILLER_8_1486 VDD VDD VSS VSS gf180mcu_as_sc_mcu7t3v3__fillcap_16
Xfanout662 VDD VDD VSS VSS fanout666/Y _4159_/C gf180mcu_as_sc_mcu7t3v3__buff_2
Xfanout673 VDD VDD VSS VSS fanout675/Y _4102_/B gf180mcu_as_sc_mcu7t3v3__buff_2
Xfanout684 VDD VDD VSS VSS _3270_/Y fanout684/Y gf180mcu_as_sc_mcu7t3v3__buff_2
Xfanout695 VDD VDD VSS VSS _3740_/B _3719_/B gf180mcu_as_sc_mcu7t3v3__buff_2
XFILLER_150_1297 VDD VDD VSS VSS gf180mcu_as_sc_mcu7t3v3__fillcap_16
XFILLER_160_53 VDD VDD VSS VSS gf180mcu_as_sc_mcu7t3v3__fillcap_16
XTAP_TAPCELL_ROW_0_1_2340 VDD VSS gf180mcu_as_sc_mcu7t3v3__tap_2
XPHY_EDGE_ROW_74_3_Right_393 VDD VSS gf180mcu_as_sc_mcu7t3v3__tap_2
XFILLER_175_919 VDD VDD VSS VSS gf180mcu_as_sc_mcu7t3v3__fillcap_4
XFILLER_139_150 VDD VDD VSS VSS gf180mcu_as_sc_mcu7t3v3__fillcap_4
XFILLER_155_632 VDD VDD VSS VSS gf180mcu_as_sc_mcu7t3v3__fillcap_8
XFILLER_161_1393 VDD VDD VSS VSS gf180mcu_as_sc_mcu7t3v3__fill_1
XFILLER_167_470 VDD VDD VSS VSS gf180mcu_as_sc_mcu7t3v3__fillcap_16
XFILLER_167_492 VDD VDD VSS VSS gf180mcu_as_sc_mcu7t3v3__fill_2
XPHY_EDGE_ROW_138_Left_590 VDD VSS gf180mcu_as_sc_mcu7t3v3__tap_2
XFILLER_155_665 VDD VDD VSS VSS gf180mcu_as_sc_mcu7t3v3__fillcap_16
XFILLER_182_451 VDD VDD VSS VSS gf180mcu_as_sc_mcu7t3v3__fillcap_4
XFILLER_183_952 VDD VDD VSS VSS gf180mcu_as_sc_mcu7t3v3__fill_1
XFILLER_143_838 VDD VDD VSS VSS gf180mcu_as_sc_mcu7t3v3__fill_2
XFILLER_157_1418 VDD VDD VSS VSS gf180mcu_as_sc_mcu7t3v3__fillcap_8
XFILLER_170_624 VDD VDD VSS VSS gf180mcu_as_sc_mcu7t3v3__fill_2
XFILLER_182_473 VDD VDD VSS VSS gf180mcu_as_sc_mcu7t3v3__fillcap_16
XFILLER_183_996 VDD VDD VSS VSS gf180mcu_as_sc_mcu7t3v3__fillcap_4
XFILLER_142_348 VDD VDD VSS VSS gf180mcu_as_sc_mcu7t3v3__fillcap_8
XFILLER_5_174 VDD VDD VSS VSS gf180mcu_as_sc_mcu7t3v3__fillcap_16
XFILLER_170_679 VDD VDD VSS VSS gf180mcu_as_sc_mcu7t3v3__fill_2
XTAP_TAPCELL_ROW_184_2309 VDD VSS gf180mcu_as_sc_mcu7t3v3__tap_2
XFILLER_150_370 VDD VDD VSS VSS gf180mcu_as_sc_mcu7t3v3__fillcap_8
XFILLER_155_1186 VDD VDD VSS VSS gf180mcu_as_sc_mcu7t3v3__fillcap_4
XFILLER_68_137 VDD VDD VSS VSS gf180mcu_as_sc_mcu7t3v3__fillcap_8
XTAP_TAPCELL_ROW_3_3_2354 VDD VSS gf180mcu_as_sc_mcu7t3v3__tap_2
XFILLER_133_1451 VDD VDD VSS VSS gf180mcu_as_sc_mcu7t3v3__fillcap_16
X_4040_ VDD VDD VSS VSS _4040_/A _4121_/B _4121_/C _4040_/D _4041_/D gf180mcu_as_sc_mcu7t3v3__ao22_2
XFILLER_168_1503 VDD VDD VSS VSS gf180mcu_as_sc_mcu7t3v3__fill_2
XTAP_TAPCELL_ROW_147_1496 VDD VSS gf180mcu_as_sc_mcu7t3v3__tap_2
XTAP_TAPCELL_ROW_147_1485 VDD VSS gf180mcu_as_sc_mcu7t3v3__tap_2
XFILLER_168_1547 VDD VDD VSS VSS gf180mcu_as_sc_mcu7t3v3__fill_1
X_4942_ VDD VDD VSS VSS _5094_/CLK _4942_/D _4942_/Q gf180mcu_as_sc_mcu7t3v3__dfxtp_2
Xclkbuf_leaf_23_clk_regs VDD VDD VSS VSS clkbuf_3_6_0_clk_regs/Y _5183_/CLK gf180mcu_as_sc_mcu7t3v3__clkbuff_12
XFILLER_177_212 VDD VDD VSS VSS gf180mcu_as_sc_mcu7t3v3__fillcap_16
XFILLER_162_1157 VDD VDD VSS VSS gf180mcu_as_sc_mcu7t3v3__fillcap_16
XFILLER_18_1550 VDD VDD VSS VSS gf180mcu_as_sc_mcu7t3v3__fillcap_4
X_4873_ VDD VDD VSS VSS _4938_/CLK _4873_/D _4873_/Q gf180mcu_as_sc_mcu7t3v3__dfxtp_2
XFILLER_159_960 VDD VDD VSS VSS gf180mcu_as_sc_mcu7t3v3__fillcap_16
XFILLER_159_982 VDD VDD VSS VSS gf180mcu_as_sc_mcu7t3v3__fillcap_16
XFILLER_32_295 VDD VDD VSS VSS gf180mcu_as_sc_mcu7t3v3__fillcap_4
X_3824_ VDD VDD VSS VSS _4907_/D _3824_/C _4168_/A _4907_/Q gf180mcu_as_sc_mcu7t3v3__aoi21b_2
XFILLER_105_1553 VDD VDD VSS VSS gf180mcu_as_sc_mcu7t3v3__fillcap_8
XFILLER_146_632 VDD VDD VSS VSS gf180mcu_as_sc_mcu7t3v3__fill_2
X_3755_ VDD VDD VSS VSS _4138_/A _3779_/B _3778_/B _4138_/D _3756_/D gf180mcu_as_sc_mcu7t3v3__ao22_2
XFILLER_145_142 VDD VDD VSS VSS gf180mcu_as_sc_mcu7t3v3__fillcap_8
X_3686_ VDD VDD VSS VSS _3687_/C _4065_/A _3742_/B _3686_/C gf180mcu_as_sc_mcu7t3v3__ao21_2
X_2706_ VDD VDD VSS VSS _2727_/S _2706_/B _2706_/A _2707_/C gf180mcu_as_sc_mcu7t3v3__mux2_2
XTAP_TAPCELL_ROW_38_1_786 VDD VSS gf180mcu_as_sc_mcu7t3v3__tap_2
XFILLER_134_849 VDD VDD VSS VSS gf180mcu_as_sc_mcu7t3v3__fill_1
XFILLER_160_101 VDD VDD VSS VSS gf180mcu_as_sc_mcu7t3v3__fillcap_4
XFILLER_161_624 VDD VDD VSS VSS gf180mcu_as_sc_mcu7t3v3__fillcap_4
X_2637_ VDD VDD VSS VSS _2639_/A _2637_/A gf180mcu_as_sc_mcu7t3v3__inv_2
XFILLER_160_123 VDD VDD VSS VSS gf180mcu_as_sc_mcu7t3v3__fillcap_16
XFILLER_161_646 VDD VDD VSS VSS gf180mcu_as_sc_mcu7t3v3__fillcap_16
XFILLER_173_1242 VDD VDD VSS VSS gf180mcu_as_sc_mcu7t3v3__fill_2
XFILLER_99_251 VDD VDD VSS VSS gf180mcu_as_sc_mcu7t3v3__fill_1
X_2568_ VDD VDD VSS VSS _5227_/Q _5126_/Q _2806_/D _5125_/Q _2855_/A gf180mcu_as_sc_mcu7t3v3__ao22_2
XTAP_TAPCELL_ROW_120_1_1116 VDD VSS gf180mcu_as_sc_mcu7t3v3__tap_2
XFILLER_101_212 VDD VDD VSS VSS gf180mcu_as_sc_mcu7t3v3__fillcap_8
XFILLER_134_1226 VDD VDD VSS VSS gf180mcu_as_sc_mcu7t3v3__fillcap_8
XFILLER_142_893 VDD VDD VSS VSS gf180mcu_as_sc_mcu7t3v3__fillcap_8
XFILLER_59_137 VDD VDD VSS VSS gf180mcu_as_sc_mcu7t3v3__fill_2
XFILLER_99_273 VDD VDD VSS VSS gf180mcu_as_sc_mcu7t3v3__fillcap_4
X_4307_ VDD VDD VSS VSS _4325_/S _5137_/Q _5136_/Q _5136_/D gf180mcu_as_sc_mcu7t3v3__mux2_2
X_2499_ VDD VDD VSS VSS _4708_/A _2747_/A _4684_/A gf180mcu_as_sc_mcu7t3v3__nand2_2
XFILLER_101_256 VDD VDD VSS VSS gf180mcu_as_sc_mcu7t3v3__fill_1
XFILLER_112_1502 VDD VDD VSS VSS gf180mcu_as_sc_mcu7t3v3__fillcap_16
XFILLER_25_1521 VDD VDD VSS VSS gf180mcu_as_sc_mcu7t3v3__fillcap_16
X_4238_ VDD VDD VSS VSS _4250_/S _4238_/B _5074_/Q _5074_/D gf180mcu_as_sc_mcu7t3v3__mux2_2
XFILLER_60_1467 VDD VDD VSS VSS gf180mcu_as_sc_mcu7t3v3__fillcap_16
XFILLER_74_107 VDD VDD VSS VSS gf180mcu_as_sc_mcu7t3v3__fillcap_16
XFILLER_112_1568 VDD VDD VSS VSS gf180mcu_as_sc_mcu7t3v3__fill_1
X_4169_ VDD VDD VSS VSS _4229_/B _4197_/B _4197_/C _5007_/Q _5007_/D gf180mcu_as_sc_mcu7t3v3__ao22_2
XTAP_TAPCELL_ROW_100_1_1036 VDD VSS gf180mcu_as_sc_mcu7t3v3__tap_2
XFILLER_130_34 VDD VDD VSS VSS gf180mcu_as_sc_mcu7t3v3__fill_1
XFILLER_167_1068 VDD VDD VSS VSS gf180mcu_as_sc_mcu7t3v3__fillcap_16
XFILLER_169_702 VDD VDD VSS VSS gf180mcu_as_sc_mcu7t3v3__fillcap_8
XFILLER_180_1202 VDD VDD VSS VSS gf180mcu_as_sc_mcu7t3v3__fillcap_8
XFILLER_90_16 VDD VDD VSS VSS gf180mcu_as_sc_mcu7t3v3__fill_1
XFILLER_90_27 VDD VDD VSS VSS gf180mcu_as_sc_mcu7t3v3__fillcap_8
XFILLER_145_1366 VDD VDD VSS VSS gf180mcu_as_sc_mcu7t3v3__fillcap_8
XFILLER_169_757 VDD VDD VSS VSS gf180mcu_as_sc_mcu7t3v3__fill_1
XFILLER_184_1393 VDD VDD VSS VSS gf180mcu_as_sc_mcu7t3v3__fill_1
XFILLER_145_1388 VDD VDD VSS VSS gf180mcu_as_sc_mcu7t3v3__fillcap_8
XFILLER_157_919 VDD VDD VSS VSS gf180mcu_as_sc_mcu7t3v3__fill_1
XFILLER_184_716 VDD VDD VSS VSS gf180mcu_as_sc_mcu7t3v3__fill_1
X_4900__967 VDD VDD VSS VSS _4900_/D gf180mcu_as_sc_mcu7t3v3__tiel_4
XFILLER_149_492 VDD VDD VSS VSS gf180mcu_as_sc_mcu7t3v3__fillcap_16
XFILLER_136_142 VDD VDD VSS VSS gf180mcu_as_sc_mcu7t3v3__fill_2
XFILLER_99_14 VDD VDD VSS VSS gf180mcu_as_sc_mcu7t3v3__fill_2
XFILLER_137_698 VDD VDD VSS VSS gf180mcu_as_sc_mcu7t3v3__fill_2
XFILLER_152_613 VDD VDD VSS VSS gf180mcu_as_sc_mcu7t3v3__fillcap_8
XFILLER_180_922 VDD VDD VSS VSS gf180mcu_as_sc_mcu7t3v3__fill_2
XFILLER_180_944 VDD VDD VSS VSS gf180mcu_as_sc_mcu7t3v3__fill_1
XFILLER_152_679 VDD VDD VSS VSS gf180mcu_as_sc_mcu7t3v3__fill_2
XFILLER_180_988 VDD VDD VSS VSS gf180mcu_as_sc_mcu7t3v3__fillcap_8
XFILLER_3_2 VDD VDD VSS VSS gf180mcu_as_sc_mcu7t3v3__fillcap_16
XFILLER_156_1473 VDD VDD VSS VSS gf180mcu_as_sc_mcu7t3v3__fillcap_16
XFILLER_156_1495 VDD VDD VSS VSS gf180mcu_as_sc_mcu7t3v3__fill_1
XFILLER_2_177 VDD VDD VSS VSS gf180mcu_as_sc_mcu7t3v3__fillcap_16
Xfanout470 VDD VDD VSS VSS _4199_/Y _4223_/C gf180mcu_as_sc_mcu7t3v3__buff_2
Xfanout481 VDD VDD VSS VSS fanout485/Y _4562_/A gf180mcu_as_sc_mcu7t3v3__buff_2
Xfanout492 VDD VDD VSS VSS _4125_/D _4092_/D gf180mcu_as_sc_mcu7t3v3__buff_2
XTAP_TAPCELL_ROW_55_1_856 VDD VSS gf180mcu_as_sc_mcu7t3v3__tap_2
XFILLER_150_1083 VDD VDD VSS VSS gf180mcu_as_sc_mcu7t3v3__fill_2
XFILLER_0_36 VDD VDD VSS VSS gf180mcu_as_sc_mcu7t3v3__fillcap_16
XFILLER_128_1542 VDD VDD VSS VSS gf180mcu_as_sc_mcu7t3v3__fillcap_4
XTAP_TAPCELL_ROW_142_1382 VDD VSS gf180mcu_as_sc_mcu7t3v3__tap_2
XTAP_TAPCELL_ROW_142_1371 VDD VSS gf180mcu_as_sc_mcu7t3v3__tap_2
XPHY_EDGE_ROW_75_3_Right_394 VDD VSS gf180mcu_as_sc_mcu7t3v3__tap_2
XFILLER_9_34 VDD VDD VSS VSS gf180mcu_as_sc_mcu7t3v3__fillcap_16
XTAP_TAPCELL_ROW_177_2157 VDD VSS gf180mcu_as_sc_mcu7t3v3__tap_2
XTAP_TAPCELL_ROW_177_2146 VDD VSS gf180mcu_as_sc_mcu7t3v3__tap_2
XFILLER_147_418 VDD VDD VSS VSS gf180mcu_as_sc_mcu7t3v3__fill_2
XFILLER_14_295 VDD VDD VSS VSS gf180mcu_as_sc_mcu7t3v3__fillcap_4
XFILLER_163_1488 VDD VDD VSS VSS gf180mcu_as_sc_mcu7t3v3__fillcap_16
XFILLER_127_142 VDD VDD VSS VSS gf180mcu_as_sc_mcu7t3v3__fill_2
XFILLER_156_963 VDD VDD VSS VSS gf180mcu_as_sc_mcu7t3v3__fill_1
X_3540_ VDD VDD VSS VSS _3914_/B _4977_/Q _3792_/D gf180mcu_as_sc_mcu7t3v3__and2_2
XFILLER_183_782 VDD VDD VSS VSS gf180mcu_as_sc_mcu7t3v3__fillcap_4
XFILLER_142_134 VDD VDD VSS VSS gf180mcu_as_sc_mcu7t3v3__fillcap_16
XFILLER_143_646 VDD VDD VSS VSS gf180mcu_as_sc_mcu7t3v3__fillcap_16
X_5210_ VDD VDD VSS VSS clkload0/A _5210_/D _5210_/Q gf180mcu_as_sc_mcu7t3v3__dfxtp_2
X_3471_ VDD VDD VSS VSS _3471_/B _4130_/A _3473_/C gf180mcu_as_sc_mcu7t3v3__and2_2
XTAP_TAPCELL_ROW_34_1_770 VDD VSS gf180mcu_as_sc_mcu7t3v3__tap_2
XFILLER_100_1483 VDD VDD VSS VSS gf180mcu_as_sc_mcu7t3v3__fill_1
XFILLER_157_1259 VDD VDD VSS VSS gf180mcu_as_sc_mcu7t3v3__fill_1
XFILLER_171_999 VDD VDD VSS VSS gf180mcu_as_sc_mcu7t3v3__fill_2
X_2422_ VDD VDD VSS VSS _2663_/A input8/Y gf180mcu_as_sc_mcu7t3v3__inv_2
XFILLER_170_1426 VDD VDD VSS VSS gf180mcu_as_sc_mcu7t3v3__fillcap_8
XFILLER_83_1467 VDD VDD VSS VSS gf180mcu_as_sc_mcu7t3v3__fillcap_16
X_5141_ VDD VDD VSS VSS clkload9/A _5141_/D _5141_/Q gf180mcu_as_sc_mcu7t3v3__dfxtp_2
XFILLER_170_1437 VDD VDD VSS VSS gf180mcu_as_sc_mcu7t3v3__fillcap_16
X_5072_ VDD VDD VSS VSS _5172_/CLK _5072_/D _5072_/Q gf180mcu_as_sc_mcu7t3v3__dfxtp_2
XTAP_TAPCELL_ROW_149_1536 VDD VSS gf180mcu_as_sc_mcu7t3v3__tap_2
XTAP_TAPCELL_ROW_149_1525 VDD VSS gf180mcu_as_sc_mcu7t3v3__tap_2
XFILLER_56_129 VDD VDD VSS VSS gf180mcu_as_sc_mcu7t3v3__fillcap_16
X_4023_ VDD VDD VSS VSS _4023_/A _4120_/B _4120_/C _4926_/Q _4025_/C gf180mcu_as_sc_mcu7t3v3__ao22_2
XFILLER_20_1451 VDD VDD VSS VSS gf180mcu_as_sc_mcu7t3v3__fillcap_16
XFILLER_168_1399 VDD VDD VSS VSS gf180mcu_as_sc_mcu7t3v3__fillcap_16
XFILLER_181_1511 VDD VDD VSS VSS gf180mcu_as_sc_mcu7t3v3__fillcap_16
XFILLER_94_1552 VDD VDD VSS VSS gf180mcu_as_sc_mcu7t3v3__fill_2
XFILLER_100_37 VDD VDD VSS VSS gf180mcu_as_sc_mcu7t3v3__fill_1
X_4925_ VDD VDD VSS VSS _5080_/CLK _4925_/D _4925_/Q gf180mcu_as_sc_mcu7t3v3__dfxtp_2
XTAP_TAPCELL_ROW_17_3_2375 VDD VSS gf180mcu_as_sc_mcu7t3v3__tap_2
XFILLER_178_565 VDD VDD VSS VSS gf180mcu_as_sc_mcu7t3v3__fillcap_8
X_4856_ VDD VDD VSS VSS _4928_/CLK _4856_/D _4856_/Q gf180mcu_as_sc_mcu7t3v3__dfxtp_2
X_3807_ VDD VDD VSS VSS _3918_/A _3807_/B _3807_/A gf180mcu_as_sc_mcu7t3v3__nand2_2
XPHY_EDGE_ROW_58_1_Right_57 VDD VSS gf180mcu_as_sc_mcu7t3v3__tap_2
X_4787_ VDD VDD VSS VSS _4858_/CLK _4787_/D _4787_/Q gf180mcu_as_sc_mcu7t3v3__dfxtp_2
XTAP_TAPCELL_ROW_105_3_2507 VDD VSS gf180mcu_as_sc_mcu7t3v3__tap_2
XFILLER_109_35 VDD VDD VSS VSS gf180mcu_as_sc_mcu7t3v3__fill_2
X_3738_ VDD VDD VSS VSS _3753_/D _3794_/S _3738_/B _3738_/C _3739_/C gf180mcu_as_sc_mcu7t3v3__ao31_2
XFILLER_162_944 VDD VDD VSS VSS gf180mcu_as_sc_mcu7t3v3__fill_1
X_3669_ VDD VDD VSS VSS _4852_/D _3669_/C _3723_/B _4043_/A gf180mcu_as_sc_mcu7t3v3__aoi21_2
XFILLER_161_465 VDD VDD VSS VSS gf180mcu_as_sc_mcu7t3v3__fill_2
XFILLER_125_34 VDD VDD VSS VSS gf180mcu_as_sc_mcu7t3v3__fillcap_8
XFILLER_134_1012 VDD VDD VSS VSS gf180mcu_as_sc_mcu7t3v3__fillcap_8
XFILLER_62_1518 VDD VDD VSS VSS gf180mcu_as_sc_mcu7t3v3__fillcap_16
XFILLER_173_1072 VDD VDD VSS VSS gf180mcu_as_sc_mcu7t3v3__fill_1
XFILLER_85_27 VDD VDD VSS VSS gf180mcu_as_sc_mcu7t3v3__fillcap_8
XFILLER_5_1467 VDD VDD VSS VSS gf180mcu_as_sc_mcu7t3v3__fillcap_16
XFILLER_87_298 VDD VDD VSS VSS gf180mcu_as_sc_mcu7t3v3__fill_2
XTAP_TAPCELL_ROW_51_1_840 VDD VSS gf180mcu_as_sc_mcu7t3v3__tap_2
XFILLER_141_66 VDD VDD VSS VSS gf180mcu_as_sc_mcu7t3v3__fillcap_4
XFILLER_141_88 VDD VDD VSS VSS gf180mcu_as_sc_mcu7t3v3__fillcap_16
XFILLER_70_121 VDD VDD VSS VSS gf180mcu_as_sc_mcu7t3v3__fillcap_4
XFILLER_145_1130 VDD VDD VSS VSS gf180mcu_as_sc_mcu7t3v3__fillcap_4
XFILLER_169_521 VDD VDD VSS VSS gf180mcu_as_sc_mcu7t3v3__fill_2
XFILLER_34_53 VDD VDD VSS VSS gf180mcu_as_sc_mcu7t3v3__fillcap_16
XTAP_TAPCELL_ROW_97_1_1025 VDD VSS gf180mcu_as_sc_mcu7t3v3__tap_2
XPHY_EDGE_ROW_80_1_Left_532 VDD VSS gf180mcu_as_sc_mcu7t3v3__tap_2
XFILLER_141_1049 VDD VDD VSS VSS gf180mcu_as_sc_mcu7t3v3__fill_1
XTAP_TAPCELL_ROW_172_2032 VDD VSS gf180mcu_as_sc_mcu7t3v3__tap_2
XFILLER_11_276 VDD VDD VSS VSS gf180mcu_as_sc_mcu7t3v3__fillcap_4
XFILLER_11_298 VDD VDD VSS VSS gf180mcu_as_sc_mcu7t3v3__fill_2
XFILLER_184_546 VDD VDD VSS VSS gf180mcu_as_sc_mcu7t3v3__fillcap_16
XFILLER_50_41 VDD VDD VSS VSS gf180mcu_as_sc_mcu7t3v3__fill_2
XTAP_TAPCELL_ROW_172_2043 VDD VSS gf180mcu_as_sc_mcu7t3v3__tap_2
XFILLER_109_142 VDD VDD VSS VSS gf180mcu_as_sc_mcu7t3v3__fill_2
XFILLER_123_1483 VDD VDD VSS VSS gf180mcu_as_sc_mcu7t3v3__fillcap_16
XFILLER_164_292 VDD VDD VSS VSS gf180mcu_as_sc_mcu7t3v3__fillcap_16
XFILLER_166_85 VDD VDD VSS VSS gf180mcu_as_sc_mcu7t3v3__fillcap_16
XFILLER_140_616 VDD VDD VSS VSS gf180mcu_as_sc_mcu7t3v3__fillcap_8
XFILLER_158_1568 VDD VDD VSS VSS gf180mcu_as_sc_mcu7t3v3__fill_1
XFILLER_180_785 VDD VDD VSS VSS gf180mcu_as_sc_mcu7t3v3__fill_2
XPHY_EDGE_ROW_171_Right_305 VDD VSS gf180mcu_as_sc_mcu7t3v3__tap_2
XFILLER_59_72 VDD VDD VSS VSS gf180mcu_as_sc_mcu7t3v3__fillcap_16
XFILLER_38_107 VDD VDD VSS VSS gf180mcu_as_sc_mcu7t3v3__fillcap_16
XFILLER_43_1451 VDD VDD VSS VSS gf180mcu_as_sc_mcu7t3v3__fillcap_16
XFILLER_78_265 VDD VDD VSS VSS gf180mcu_as_sc_mcu7t3v3__fill_2
XFILLER_93_246 VDD VDD VSS VSS gf180mcu_as_sc_mcu7t3v3__fillcap_8
XTAP_TAPCELL_ROW_37_1_785 VDD VSS gf180mcu_as_sc_mcu7t3v3__tap_2
XTAP_TAPCELL_ROW_144_1433 VDD VSS gf180mcu_as_sc_mcu7t3v3__tap_2
XTAP_TAPCELL_ROW_144_1422 VDD VSS gf180mcu_as_sc_mcu7t3v3__tap_2
XFILLER_130_1498 VDD VDD VSS VSS gf180mcu_as_sc_mcu7t3v3__fill_2
XFILLER_61_154 VDD VDD VSS VSS gf180mcu_as_sc_mcu7t3v3__fill_1
X_2971_ VDD VDD VSS VSS _3952_/A _3230_/S _2971_/C _2971_/D _2972_/C gf180mcu_as_sc_mcu7t3v3__ao22_2
XTAP_TAPCELL_ROW_161_1791 VDD VSS gf180mcu_as_sc_mcu7t3v3__tap_2
XPHY_EDGE_ROW_76_3_Right_395 VDD VSS gf180mcu_as_sc_mcu7t3v3__tap_2
X_4710_ VDD VDD VSS VSS _4749_/B _4710_/B _5104_/Q _5257_/D gf180mcu_as_sc_mcu7t3v3__mux2_2
X_4641_ VDD VDD VSS VSS _4733_/C _5480_/A _5232_/Q _5232_/D gf180mcu_as_sc_mcu7t3v3__mux2_2
XFILLER_15_1553 VDD VDD VSS VSS gf180mcu_as_sc_mcu7t3v3__fillcap_16
XFILLER_102_1534 VDD VDD VSS VSS gf180mcu_as_sc_mcu7t3v3__fillcap_16
XFILLER_102_1556 VDD VDD VSS VSS gf180mcu_as_sc_mcu7t3v3__fillcap_8
XFILLER_156_760 VDD VDD VSS VSS gf180mcu_as_sc_mcu7t3v3__fillcap_4
X_4572_ VDD VDD VSS VSS _4572_/D _4572_/A _4572_/B _4572_/C _4573_/B gf180mcu_as_sc_mcu7t3v3__ao31_2
XFILLER_144_944 VDD VDD VSS VSS gf180mcu_as_sc_mcu7t3v3__fill_1
X_3523_ VDD VDD VSS VSS _3524_/D _3523_/C _3523_/B _3523_/A gf180mcu_as_sc_mcu7t3v3__aoi21b_2
XFILLER_115_134 VDD VDD VSS VSS gf180mcu_as_sc_mcu7t3v3__fillcap_4
XFILLER_171_785 VDD VDD VSS VSS gf180mcu_as_sc_mcu7t3v3__fill_2
X_3454_ VDD VDD VSS VSS _3455_/B _3454_/B _3454_/C _3455_/C gf180mcu_as_sc_mcu7t3v3__nor3_2
XFILLER_130_104 VDD VDD VSS VSS gf180mcu_as_sc_mcu7t3v3__fill_1
XFILLER_170_295 VDD VDD VSS VSS gf180mcu_as_sc_mcu7t3v3__fillcap_16
X_2405_ VDD VDD VSS VSS _4704_/A _5222_/Q gf180mcu_as_sc_mcu7t3v3__inv_2
XFILLER_130_159 VDD VDD VSS VSS gf180mcu_as_sc_mcu7t3v3__fill_2
XFILLER_135_1332 VDD VDD VSS VSS gf180mcu_as_sc_mcu7t3v3__fillcap_16
X_3385_ VDD VDD VSS VSS _4928_/Q _3440_/B _3440_/C _4039_/A _3386_/C gf180mcu_as_sc_mcu7t3v3__ao22_2
XTAP_TAPCELL_ROW_168_1945 VDD VSS gf180mcu_as_sc_mcu7t3v3__tap_2
XPHY_EDGE_ROW_7_1_Right_6 VDD VSS gf180mcu_as_sc_mcu7t3v3__tap_2
XFILLER_170_1267 VDD VDD VSS VSS gf180mcu_as_sc_mcu7t3v3__fillcap_4
XFILLER_22_1502 VDD VDD VSS VSS gf180mcu_as_sc_mcu7t3v3__fillcap_16
X_5124_ VDD VDD VSS VSS clkload8/A _5124_/D _5124_/Q gf180mcu_as_sc_mcu7t3v3__dfxtp_2
XTAP_TAPCELL_ROW_168_1956 VDD VSS gf180mcu_as_sc_mcu7t3v3__tap_2
XFILLER_69_298 VDD VDD VSS VSS gf180mcu_as_sc_mcu7t3v3__fill_2
X_5055_ VDD VDD VSS VSS _5084_/CLK _5055_/D _5055_/Q gf180mcu_as_sc_mcu7t3v3__dfxtp_2
XFILLER_22_1568 VDD VDD VSS VSS gf180mcu_as_sc_mcu7t3v3__fill_1
X_4006_ VDD VDD VSS VSS _4006_/A _4101_/B _4103_/B _4006_/D _4007_/D gf180mcu_as_sc_mcu7t3v3__ao22_2
XFILLER_168_1152 VDD VDD VSS VSS gf180mcu_as_sc_mcu7t3v3__fill_2
XFILLER_111_69 VDD VDD VSS VSS gf180mcu_as_sc_mcu7t3v3__fill_1
XFILLER_71_18 VDD VDD VSS VSS gf180mcu_as_sc_mcu7t3v3__fill_2
XFILLER_52_198 VDD VDD VSS VSS gf180mcu_as_sc_mcu7t3v3__fill_2
X_4908_ VDD VDD VSS VSS _5074_/CLK _4908_/D _4908_/Q gf180mcu_as_sc_mcu7t3v3__dfxtp_2
XFILLER_107_1467 VDD VDD VSS VSS gf180mcu_as_sc_mcu7t3v3__fillcap_16
XFILLER_138_204 VDD VDD VSS VSS gf180mcu_as_sc_mcu7t3v3__fillcap_4
XFILLER_166_524 VDD VDD VSS VSS gf180mcu_as_sc_mcu7t3v3__fill_1
XFILLER_181_1374 VDD VDD VSS VSS gf180mcu_as_sc_mcu7t3v3__fill_2
XFILLER_138_259 VDD VDD VSS VSS gf180mcu_as_sc_mcu7t3v3__fill_1
X_4839_ VDD VDD VSS VSS _5053_/CLK _4839_/D _4839_/Q gf180mcu_as_sc_mcu7t3v3__dfxtp_2
XFILLER_181_505 VDD VDD VSS VSS gf180mcu_as_sc_mcu7t3v3__fillcap_16
XFILLER_134_410 VDD VDD VSS VSS gf180mcu_as_sc_mcu7t3v3__fill_2
XFILLER_140_1082 VDD VDD VSS VSS gf180mcu_as_sc_mcu7t3v3__fill_2
XFILLER_4_217 VDD VDD VSS VSS gf180mcu_as_sc_mcu7t3v3__fill_1
Xclkbuf_3_7_0_clk_regs VDD VDD VSS VSS clkbuf_0_clk_regs/Y clkbuf_3_7_0_clk_regs/Y
+ gf180mcu_as_sc_mcu7t3v3__clkbuff_12
XFILLER_135_999 VDD VDD VSS VSS gf180mcu_as_sc_mcu7t3v3__fill_2
XFILLER_121_104 VDD VDD VSS VSS gf180mcu_as_sc_mcu7t3v3__fill_2
XFILLER_150_947 VDD VDD VSS VSS gf180mcu_as_sc_mcu7t3v3__fill_2
XFILLER_175_1178 VDD VDD VSS VSS gf180mcu_as_sc_mcu7t3v3__fill_1
XFILLER_66_1451 VDD VDD VSS VSS gf180mcu_as_sc_mcu7t3v3__fillcap_16
XFILLER_161_295 VDD VDD VSS VSS gf180mcu_as_sc_mcu7t3v3__fillcap_8
XFILLER_96_37 VDD VDD VSS VSS gf180mcu_as_sc_mcu7t3v3__fill_1
XFILLER_96_48 VDD VDD VSS VSS gf180mcu_as_sc_mcu7t3v3__fillcap_16
Xinput302 VDD VDD VSS VSS west_in[27] _4151_/A gf180mcu_as_sc_mcu7t3v3__buff_2
Xinput313 VDD VDD VSS VSS west_in[6] _3981_/A gf180mcu_as_sc_mcu7t3v3__buff_2
XTAP_TAPCELL_ROW_25_1_734 VDD VSS gf180mcu_as_sc_mcu7t3v3__tap_2
XFILLER_43_176 VDD VDD VSS VSS gf180mcu_as_sc_mcu7t3v3__fill_1
XFILLER_38_1564 VDD VDD VSS VSS gf180mcu_as_sc_mcu7t3v3__fillcap_4
XFILLER_101_80 VDD VDD VSS VSS gf180mcu_as_sc_mcu7t3v3__fillcap_16
XFILLER_129_204 VDD VDD VSS VSS gf180mcu_as_sc_mcu7t3v3__fillcap_4
XFILLER_157_524 VDD VDD VSS VSS gf180mcu_as_sc_mcu7t3v3__fill_2
XFILLER_169_384 VDD VDD VSS VSS gf180mcu_as_sc_mcu7t3v3__fillcap_16
XFILLER_73_1499 VDD VDD VSS VSS gf180mcu_as_sc_mcu7t3v3__fillcap_16
XFILLER_160_1469 VDD VDD VSS VSS gf180mcu_as_sc_mcu7t3v3__fillcap_16
XPHY_EDGE_ROW_73_3_Left_207 VDD VSS gf180mcu_as_sc_mcu7t3v3__tap_2
XFILLER_172_527 VDD VDD VSS VSS gf180mcu_as_sc_mcu7t3v3__fill_1
XFILLER_184_376 VDD VDD VSS VSS gf180mcu_as_sc_mcu7t3v3__fillcap_16
XANTENNA_6 VDD VDD VSS VSS _3909_/A gf180mcu_as_sc_mcu7t3v3__diode_2
XFILLER_172_549 VDD VDD VSS VSS gf180mcu_as_sc_mcu7t3v3__fill_2
XTAP_TAPCELL_ROW_137_1281 VDD VSS gf180mcu_as_sc_mcu7t3v3__tap_2
XTAP_TAPCELL_ROW_137_1270 VDD VSS gf180mcu_as_sc_mcu7t3v3__tap_2
XFILLER_153_752 VDD VDD VSS VSS gf180mcu_as_sc_mcu7t3v3__fillcap_16
XFILLER_10_1483 VDD VDD VSS VSS gf180mcu_as_sc_mcu7t3v3__fill_1
XFILLER_140_402 VDD VDD VSS VSS gf180mcu_as_sc_mcu7t3v3__fillcap_8
XFILLER_180_571 VDD VDD VSS VSS gf180mcu_as_sc_mcu7t3v3__fill_2
XTAP_TAPCELL_ROW_121_1_1121 VDD VSS gf180mcu_as_sc_mcu7t3v3__tap_2
XFILLER_140_457 VDD VDD VSS VSS gf180mcu_as_sc_mcu7t3v3__fillcap_8
XPHY_EDGE_ROW_3_1_Left_455 VDD VSS gf180mcu_as_sc_mcu7t3v3__tap_2
XFILLER_132_1527 VDD VDD VSS VSS gf180mcu_as_sc_mcu7t3v3__fillcap_8
Xmesh_tile_917 VDD VDD VSS VSS nw_out[24] gf180mcu_as_sc_mcu7t3v3__tiel_4
Xmesh_tile_906 VDD VDD VSS VSS nw_out[13] gf180mcu_as_sc_mcu7t3v3__tiel_4
X_3170_ VDD VDD VSS VSS _3178_/A _3170_/B _3170_/C _3178_/D _3171_/D gf180mcu_as_sc_mcu7t3v3__ao211_2
XFILLER_66_213 VDD VDD VSS VSS gf180mcu_as_sc_mcu7t3v3__fillcap_8
Xmesh_tile_939 VDD VDD VSS VSS sw_out[12] gf180mcu_as_sc_mcu7t3v3__tiel_4
Xmesh_tile_928 VDD VDD VSS VSS sw_out[1] gf180mcu_as_sc_mcu7t3v3__tiel_4
XTAP_TAPCELL_ROW_163_1842 VDD VSS gf180mcu_as_sc_mcu7t3v3__tap_2
XTAP_TAPCELL_ROW_101_1_1041 VDD VSS gf180mcu_as_sc_mcu7t3v3__tap_2
XTAP_TAPCELL_ROW_163_1853 VDD VSS gf180mcu_as_sc_mcu7t3v3__tap_2
XFILLER_165_1303 VDD VDD VSS VSS gf180mcu_as_sc_mcu7t3v3__fill_2
XFILLER_169_1472 VDD VDD VSS VSS gf180mcu_as_sc_mcu7t3v3__fillcap_16
XFILLER_179_104 VDD VDD VSS VSS gf180mcu_as_sc_mcu7t3v3__fillcap_16
X_2954_ VDD VDD VSS VSS _3934_/A _3241_/B _2954_/C _2954_/D _2955_/B gf180mcu_as_sc_mcu7t3v3__ao211_2
XTAP_TAPCELL_ROW_9_1_671 VDD VSS gf180mcu_as_sc_mcu7t3v3__tap_2
XPHY_EDGE_ROW_77_3_Right_396 VDD VSS gf180mcu_as_sc_mcu7t3v3__tap_2
X_2885_ VDD VDD VSS VSS _3780_/A _3511_/A _3520_/A gf180mcu_as_sc_mcu7t3v3__nor2_2
X_4624_ VDD VDD VSS VSS _5218_/Q _4629_/B _4629_/C _5219_/Q _5218_/D gf180mcu_as_sc_mcu7t3v3__ao22_2
XTAP_TAPCELL_ROW_9_3_2363 VDD VSS gf180mcu_as_sc_mcu7t3v3__tap_2
XTAP_TAPCELL_ROW_42_1_804 VDD VSS gf180mcu_as_sc_mcu7t3v3__tap_2
XFILLER_89_1451 VDD VDD VSS VSS gf180mcu_as_sc_mcu7t3v3__fillcap_16
X_4555_ VDD VDD VSS VSS _4555_/B _4576_/A _4556_/D gf180mcu_as_sc_mcu7t3v3__and2_2
XFILLER_176_1454 VDD VDD VSS VSS gf180mcu_as_sc_mcu7t3v3__fillcap_8
X_3506_ VDD VDD VSS VSS _3506_/B _3795_/A _4833_/D gf180mcu_as_sc_mcu7t3v3__and2_2
XFILLER_144_785 VDD VDD VSS VSS gf180mcu_as_sc_mcu7t3v3__fillcap_8
X_4486_ VDD VDD VSS VSS _5176_/Q _4548_/B _4486_/C _4486_/D _5176_/D gf180mcu_as_sc_mcu7t3v3__ao211_2
XFILLER_103_137 VDD VDD VSS VSS gf180mcu_as_sc_mcu7t3v3__fill_2
X_3437_ VDD VDD VSS VSS _4085_/D _3451_/B _3437_/C _3437_/D _3438_/C gf180mcu_as_sc_mcu7t3v3__ao211_2
XFILLER_135_1162 VDD VDD VSS VSS gf180mcu_as_sc_mcu7t3v3__fill_1
X_3368_ VDD VDD VSS VSS _3647_/A _3424_/B _3368_/C _4815_/D _3691_/D gf180mcu_as_sc_mcu7t3v3__aoi211_2
XFILLER_170_1053 VDD VDD VSS VSS gf180mcu_as_sc_mcu7t3v3__fill_2
X_5107_ VDD VDD VSS VSS _5186_/CLK _5107_/D _5107_/Q gf180mcu_as_sc_mcu7t3v3__dfxtp_2
X_3299_ VDD VDD VSS VSS _3949_/A _3503_/B _3299_/C _3299_/D _3301_/C gf180mcu_as_sc_mcu7t3v3__ao211_2
XTAP_TAPCELL_ROW_65_1_894 VDD VSS gf180mcu_as_sc_mcu7t3v3__tap_2
X_5038_ VDD VDD VSS VSS _5074_/CLK _5038_/D _5038_/Q gf180mcu_as_sc_mcu7t3v3__dfxtp_2
XFILLER_2_1459 VDD VDD VSS VSS gf180mcu_as_sc_mcu7t3v3__fillcap_16
XFILLER_148_1567 VDD VDD VSS VSS gf180mcu_as_sc_mcu7t3v3__fill_2
XFILLER_15_66 VDD VDD VSS VSS gf180mcu_as_sc_mcu7t3v3__fillcap_4
XFILLER_15_88 VDD VDD VSS VSS gf180mcu_as_sc_mcu7t3v3__fillcap_16
XFILLER_179_693 VDD VDD VSS VSS gf180mcu_as_sc_mcu7t3v3__fill_1
XFILLER_142_1177 VDD VDD VSS VSS gf180mcu_as_sc_mcu7t3v3__fill_1
XFILLER_166_365 VDD VDD VSS VSS gf180mcu_as_sc_mcu7t3v3__fillcap_16
XTAP_TAPCELL_ROW_28_1_749 VDD VSS gf180mcu_as_sc_mcu7t3v3__tap_2
XFILLER_147_32 VDD VDD VSS VSS gf180mcu_as_sc_mcu7t3v3__fillcap_4
XFILLER_154_527 VDD VDD VSS VSS gf180mcu_as_sc_mcu7t3v3__fill_2
XFILLER_166_387 VDD VDD VSS VSS gf180mcu_as_sc_mcu7t3v3__fillcap_16
XFILLER_33_1483 VDD VDD VSS VSS gf180mcu_as_sc_mcu7t3v3__fillcap_16
XFILLER_68_1502 VDD VDD VSS VSS gf180mcu_as_sc_mcu7t3v3__fillcap_16
XFILLER_103_2 VDD VDD VSS VSS gf180mcu_as_sc_mcu7t3v3__fillcap_8
XFILLER_120_1486 VDD VDD VSS VSS gf180mcu_as_sc_mcu7t3v3__fillcap_16
XFILLER_134_240 VDD VDD VSS VSS gf180mcu_as_sc_mcu7t3v3__fillcap_8
XFILLER_147_65 VDD VDD VSS VSS gf180mcu_as_sc_mcu7t3v3__fillcap_4
XFILLER_181_346 VDD VDD VSS VSS gf180mcu_as_sc_mcu7t3v3__fillcap_4
XFILLER_181_368 VDD VDD VSS VSS gf180mcu_as_sc_mcu7t3v3__fillcap_16
XFILLER_135_796 VDD VDD VSS VSS gf180mcu_as_sc_mcu7t3v3__fillcap_4
XFILLER_155_1527 VDD VDD VSS VSS gf180mcu_as_sc_mcu7t3v3__fillcap_8
XFILLER_68_1568 VDD VDD VSS VSS gf180mcu_as_sc_mcu7t3v3__fill_1
XFILLER_134_295 VDD VDD VSS VSS gf180mcu_as_sc_mcu7t3v3__fillcap_8
XFILLER_150_777 VDD VDD VSS VSS gf180mcu_as_sc_mcu7t3v3__fillcap_8
XFILLER_150_799 VDD VDD VSS VSS gf180mcu_as_sc_mcu7t3v3__fillcap_4
XFILLER_153_1262 VDD VDD VSS VSS gf180mcu_as_sc_mcu7t3v3__fillcap_8
Xinput110 VDD VDD VSS VSS ne_in[8] _3997_/A gf180mcu_as_sc_mcu7t3v3__buff_2
XFILLER_48_213 VDD VDD VSS VSS gf180mcu_as_sc_mcu7t3v3__fillcap_16
Xinput121 VDD VDD VSS VSS north_in[18] _4079_/A gf180mcu_as_sc_mcu7t3v3__buff_2
Xinput132 VDD VDD VSS VSS north_in[28] _4160_/D gf180mcu_as_sc_mcu7t3v3__buff_2
Xinput143 VDD VDD VSS VSS north_in[7] _3990_/A gf180mcu_as_sc_mcu7t3v3__buff_2
Xinput154 VDD VDD VSS VSS nw_in[17] _4070_/A gf180mcu_as_sc_mcu7t3v3__buff_2
Xinput165 VDD VDD VSS VSS nw_in[27] _4154_/A gf180mcu_as_sc_mcu7t3v3__buff_2
Xinput176 VDD VDD VSS VSS nw_in[6] _3984_/A gf180mcu_as_sc_mcu7t3v3__buff_2
Xinput187 VDD VDD VSS VSS se_in[15] _4057_/A gf180mcu_as_sc_mcu7t3v3__buff_2
XFILLER_48_279 VDD VDD VSS VSS gf180mcu_as_sc_mcu7t3v3__fillcap_16
XFILLER_63_216 VDD VDD VSS VSS gf180mcu_as_sc_mcu7t3v3__fill_2
Xinput198 VDD VDD VSS VSS se_in[25] _4139_/A gf180mcu_as_sc_mcu7t3v3__buff_2
XFILLER_71_282 VDD VDD VSS VSS gf180mcu_as_sc_mcu7t3v3__fillcap_16
XFILLER_160_1222 VDD VDD VSS VSS gf180mcu_as_sc_mcu7t3v3__fill_2
XFILLER_164_1391 VDD VDD VSS VSS gf180mcu_as_sc_mcu7t3v3__fill_2
XFILLER_176_107 VDD VDD VSS VSS gf180mcu_as_sc_mcu7t3v3__fillcap_16
XPHY_EDGE_ROW_106_1_Left_558 VDD VSS gf180mcu_as_sc_mcu7t3v3__tap_2
XTAP_TAPCELL_ROW_139_1310 VDD VSS gf180mcu_as_sc_mcu7t3v3__tap_2
XTAP_TAPCELL_ROW_82_1_964 VDD VSS gf180mcu_as_sc_mcu7t3v3__tap_2
XTAP_TAPCELL_ROW_139_1321 VDD VSS gf180mcu_as_sc_mcu7t3v3__tap_2
XFILLER_145_516 VDD VDD VSS VSS gf180mcu_as_sc_mcu7t3v3__fillcap_4
XFILLER_158_877 VDD VDD VSS VSS gf180mcu_as_sc_mcu7t3v3__fillcap_16
X_2670_ VDD VDD VSS VSS _5197_/Q _2858_/B _2674_/C _2670_/D _2672_/C gf180mcu_as_sc_mcu7t3v3__ao211_2
XFILLER_12_1534 VDD VDD VSS VSS gf180mcu_as_sc_mcu7t3v3__fillcap_16
XFILLER_12_1556 VDD VDD VSS VSS gf180mcu_as_sc_mcu7t3v3__fillcap_8
XTAP_TAPCELL_ROW_156_1690 VDD VSS gf180mcu_as_sc_mcu7t3v3__tap_2
XTAP_TAPCELL_ROW_135_1229 VDD VSS gf180mcu_as_sc_mcu7t3v3__tap_2
XTAP_TAPCELL_ROW_135_1218 VDD VSS gf180mcu_as_sc_mcu7t3v3__tap_2
XFILLER_160_519 VDD VDD VSS VSS gf180mcu_as_sc_mcu7t3v3__fillcap_4
XFILLER_125_251 VDD VDD VSS VSS gf180mcu_as_sc_mcu7t3v3__fill_1
XFILLER_141_722 VDD VDD VSS VSS gf180mcu_as_sc_mcu7t3v3__fillcap_16
X_4340_ VDD VDD VSS VSS _4341_/S _5089_/Q _5002_/Q _4342_/B gf180mcu_as_sc_mcu7t3v3__mux2_2
X_4271_ VDD VDD VSS VSS _4273_/S _5483_/A _5105_/Q _5105_/D gf180mcu_as_sc_mcu7t3v3__mux2_2
XTAP_TAPCELL_ROW_152_1598 VDD VSS gf180mcu_as_sc_mcu7t3v3__tap_2
XFILLER_100_107 VDD VDD VSS VSS gf180mcu_as_sc_mcu7t3v3__fillcap_16
XFILLER_140_243 VDD VDD VSS VSS gf180mcu_as_sc_mcu7t3v3__fill_2
XFILLER_141_788 VDD VDD VSS VSS gf180mcu_as_sc_mcu7t3v3__fillcap_8
XFILLER_97_80 VDD VDD VSS VSS gf180mcu_as_sc_mcu7t3v3__fillcap_8
XFILLER_98_157 VDD VDD VSS VSS gf180mcu_as_sc_mcu7t3v3__fill_2
X_3222_ VDD VDD VSS VSS _3233_/B _3253_/A _3787_/A _3544_/C _3223_/D gf180mcu_as_sc_mcu7t3v3__ao31_2
XFILLER_171_1384 VDD VDD VSS VSS gf180mcu_as_sc_mcu7t3v3__fill_1
X_3153_ VDD VDD VSS VSS _3153_/A _3153_/B _3153_/C _3153_/D _3155_/C gf180mcu_as_sc_mcu7t3v3__ao211_2
XFILLER_54_227 VDD VDD VSS VSS gf180mcu_as_sc_mcu7t3v3__fillcap_16
X_3084_ VDD VDD VSS VSS _4061_/A _3152_/B _3152_/C _4062_/A _3085_/C gf180mcu_as_sc_mcu7t3v3__ao22_2
XPHY_EDGE_ROW_67_1_Right_66 VDD VSS gf180mcu_as_sc_mcu7t3v3__tap_2
XFILLER_165_1122 VDD VDD VSS VSS gf180mcu_as_sc_mcu7t3v3__fillcap_4
XFILLER_165_1177 VDD VDD VSS VSS gf180mcu_as_sc_mcu7t3v3__fill_2
XFILLER_143_1420 VDD VDD VSS VSS gf180mcu_as_sc_mcu7t3v3__fillcap_8
XFILLER_149_800 VDD VDD VSS VSS gf180mcu_as_sc_mcu7t3v3__fill_2
XFILLER_56_1483 VDD VDD VSS VSS gf180mcu_as_sc_mcu7t3v3__fill_1
X_3986_ VDD VDD VSS VSS _4050_/S _3986_/B _3986_/A _3987_/B gf180mcu_as_sc_mcu7t3v3__mux2_2
XFILLER_143_1442 VDD VDD VSS VSS gf180mcu_as_sc_mcu7t3v3__fill_1
XFILLER_17_1467 VDD VDD VSS VSS gf180mcu_as_sc_mcu7t3v3__fillcap_16
X_2937_ VDD VDD VSS VSS _2947_/B _3281_/B _3559_/A gf180mcu_as_sc_mcu7t3v3__nand2_2
XPHY_EDGE_ROW_78_3_Right_397 VDD VSS gf180mcu_as_sc_mcu7t3v3__tap_2
XFILLER_148_354 VDD VDD VSS VSS gf180mcu_as_sc_mcu7t3v3__fillcap_16
XFILLER_136_527 VDD VDD VSS VSS gf180mcu_as_sc_mcu7t3v3__fill_2
XFILLER_148_387 VDD VDD VSS VSS gf180mcu_as_sc_mcu7t3v3__fill_2
X_4607_ VDD VDD VSS VSS _5201_/Q _4612_/B _4607_/C _5202_/Q _5201_/D gf180mcu_as_sc_mcu7t3v3__ao22_2
X_2868_ VDD VDD VSS VSS _2868_/B _4765_/Q _2869_/C gf180mcu_as_sc_mcu7t3v3__xnor2_2
X_2799_ VDD VDD VSS VSS _2845_/D _4626_/B _2799_/C _4655_/B _2800_/B gf180mcu_as_sc_mcu7t3v3__ao211_2
X_4538_ VDD VDD VSS VSS _4553_/A _4538_/B _4538_/C _4539_/D _4573_/A gf180mcu_as_sc_mcu7t3v3__aoi211_2
XTAP_TAPCELL_ROW_24_1_733 VDD VSS gf180mcu_as_sc_mcu7t3v3__tap_2
XFILLER_116_295 VDD VDD VSS VSS gf180mcu_as_sc_mcu7t3v3__fillcap_4
Xfanout800 VDD VDD VSS VSS _3805_/C _3601_/D gf180mcu_as_sc_mcu7t3v3__buff_2
X_4469_ VDD VDD VSS VSS _5174_/Q _4548_/B _4469_/C _4469_/D _5174_/D gf180mcu_as_sc_mcu7t3v3__ao211_2
XFILLER_131_276 VDD VDD VSS VSS gf180mcu_as_sc_mcu7t3v3__fillcap_4
XFILLER_133_34 VDD VDD VSS VSS gf180mcu_as_sc_mcu7t3v3__fillcap_8
Xhold1020 VDD VDD VSS VSS hold1052/Y _4958_/D gf180mcu_as_sc_mcu7t3v3__buff_2
Xhold1031 VDD VDD VSS VSS _5096_/Q _4258_/C gf180mcu_as_sc_mcu7t3v3__buff_2
Xhold1042 VDD VDD VSS VSS _4965_/Q hold1042/Y gf180mcu_as_sc_mcu7t3v3__buff_2
XFILLER_93_27 VDD VDD VSS VSS gf180mcu_as_sc_mcu7t3v3__fillcap_8
Xhold1053 VDD VDD VSS VSS _4963_/Q hold1053/Y gf180mcu_as_sc_mcu7t3v3__buff_2
XFILLER_144_1217 VDD VDD VSS VSS gf180mcu_as_sc_mcu7t3v3__fillcap_8
XFILLER_159_608 VDD VDD VSS VSS gf180mcu_as_sc_mcu7t3v3__fill_1
XFILLER_53_282 VDD VDD VSS VSS gf180mcu_as_sc_mcu7t3v3__fillcap_16
XFILLER_158_107 VDD VDD VSS VSS gf180mcu_as_sc_mcu7t3v3__fillcap_16
XFILLER_161_1520 VDD VDD VSS VSS gf180mcu_as_sc_mcu7t3v3__fillcap_16
XFILLER_74_1550 VDD VDD VSS VSS gf180mcu_as_sc_mcu7t3v3__fillcap_4
XFILLER_161_1542 VDD VDD VSS VSS gf180mcu_as_sc_mcu7t3v3__fillcap_4
XFILLER_21_190 VDD VDD VSS VSS gf180mcu_as_sc_mcu7t3v3__fillcap_16
XFILLER_155_869 VDD VDD VSS VSS gf180mcu_as_sc_mcu7t3v3__fillcap_16
XFILLER_158_97 VDD VDD VSS VSS gf180mcu_as_sc_mcu7t3v3__fillcap_8
XFILLER_177_1048 VDD VDD VSS VSS gf180mcu_as_sc_mcu7t3v3__fill_2
XFILLER_181_154 VDD VDD VSS VSS gf180mcu_as_sc_mcu7t3v3__fill_2
XFILLER_107_240 VDD VDD VSS VSS gf180mcu_as_sc_mcu7t3v3__fillcap_16
XFILLER_155_1313 VDD VDD VSS VSS gf180mcu_as_sc_mcu7t3v3__fillcap_16
XFILLER_163_880 VDD VDD VSS VSS gf180mcu_as_sc_mcu7t3v3__fillcap_16
XFILLER_170_828 VDD VDD VSS VSS gf180mcu_as_sc_mcu7t3v3__fillcap_8
XFILLER_174_85 VDD VDD VSS VSS gf180mcu_as_sc_mcu7t3v3__fillcap_16
XFILLER_81_1521 VDD VDD VSS VSS gf180mcu_as_sc_mcu7t3v3__fillcap_16
XFILLER_95_105 VDD VDD VSS VSS gf180mcu_as_sc_mcu7t3v3__fillcap_8
XFILLER_95_138 VDD VDD VSS VSS gf180mcu_as_sc_mcu7t3v3__fill_2
XTAP_TAPCELL_ROW_182_2259 VDD VSS gf180mcu_as_sc_mcu7t3v3__tap_2
XFILLER_91_300 VDD VDD VSS VSS gf180mcu_as_sc_mcu7t3v3__fill_1
XFILLER_166_1431 VDD VDD VSS VSS gf180mcu_as_sc_mcu7t3v3__fillcap_4
XFILLER_79_1483 VDD VDD VSS VSS gf180mcu_as_sc_mcu7t3v3__fillcap_16
XFILLER_162_1339 VDD VDD VSS VSS gf180mcu_as_sc_mcu7t3v3__fill_2
XFILLER_177_416 VDD VDD VSS VSS gf180mcu_as_sc_mcu7t3v3__fillcap_4
XPHY_EDGE_ROW_17_3_Left_151 VDD VSS gf180mcu_as_sc_mcu7t3v3__tap_2
X_3840_ VDD VDD VSS VSS _4912_/Q _3845_/A _3843_/B _3844_/A gf180mcu_as_sc_mcu7t3v3__nand3_2
XFILLER_177_438 VDD VDD VSS VSS gf180mcu_as_sc_mcu7t3v3__fillcap_16
X_3771_ VDD VDD VSS VSS _4153_/A _3779_/B _3771_/C _3771_/D _3773_/C gf180mcu_as_sc_mcu7t3v3__ao211_2
XTAP_TAPCELL_ROW_158_1741 VDD VSS gf180mcu_as_sc_mcu7t3v3__tap_2
XTAP_TAPCELL_ROW_158_1730 VDD VSS gf180mcu_as_sc_mcu7t3v3__tap_2
XFILLER_146_803 VDD VDD VSS VSS gf180mcu_as_sc_mcu7t3v3__fill_2
X_2722_ VDD VDD VSS VSS _2723_/D _2737_/A _2736_/B _2722_/A gf180mcu_as_sc_mcu7t3v3__aoi21b_2
XTAP_TAPCELL_ROW_56_1_858 VDD VSS gf180mcu_as_sc_mcu7t3v3__tap_2
XFILLER_146_836 VDD VDD VSS VSS gf180mcu_as_sc_mcu7t3v3__fillcap_16
XFILLER_173_611 VDD VDD VSS VSS gf180mcu_as_sc_mcu7t3v3__fillcap_16
XTAP_TAPCELL_ROW_64_1_893 VDD VSS gf180mcu_as_sc_mcu7t3v3__tap_2
XTAP_TAPCELL_ROW_154_1638 VDD VSS gf180mcu_as_sc_mcu7t3v3__tap_2
XFILLER_161_806 VDD VDD VSS VSS gf180mcu_as_sc_mcu7t3v3__fill_1
XFILLER_66_2 VDD VDD VSS VSS gf180mcu_as_sc_mcu7t3v3__fill_2
X_2653_ VDD VDD VSS VSS _2653_/S _2653_/B _5265_/Q _2656_/B gf180mcu_as_sc_mcu7t3v3__mux2_2
XTAP_TAPCELL_ROW_154_1649 VDD VSS gf180mcu_as_sc_mcu7t3v3__tap_2
XFILLER_173_1402 VDD VDD VSS VSS gf180mcu_as_sc_mcu7t3v3__fillcap_16
Xoutput403 VDD VDD VSS VSS _4824_/Q south_out[19] gf180mcu_as_sc_mcu7t3v3__buff_2
Xoutput414 VDD VDD VSS VSS _4834_/Q south_out[29] gf180mcu_as_sc_mcu7t3v3__buff_2
Xoutput425 VDD VDD VSS VSS _4813_/Q south_out[8] gf180mcu_as_sc_mcu7t3v3__buff_2
X_2584_ VDD VDD VSS VSS _2584_/B _4952_/D _2584_/Y gf180mcu_as_sc_mcu7t3v3__or2_2
Xoutput436 VDD VDD VSS VSS _4891_/Q west_out[18] gf180mcu_as_sc_mcu7t3v3__buff_2
Xoutput447 VDD VDD VSS VSS _4901_/Q west_out[28] gf180mcu_as_sc_mcu7t3v3__buff_2
Xoutput458 VDD VDD VSS VSS _4880_/Q west_out[7] gf180mcu_as_sc_mcu7t3v3__buff_2
X_4323_ VDD VDD VSS VSS _4325_/S _5153_/Q _5152_/Q _5152_/D gf180mcu_as_sc_mcu7t3v3__mux2_2
XFILLER_141_574 VDD VDD VSS VSS gf180mcu_as_sc_mcu7t3v3__fill_2
XFILLER_113_298 VDD VDD VSS VSS gf180mcu_as_sc_mcu7t3v3__fill_2
X_4254_ VDD VDD VSS VSS _4257_/S _4254_/B _5090_/Q _5090_/D gf180mcu_as_sc_mcu7t3v3__mux2_2
XFILLER_171_1192 VDD VDD VSS VSS gf180mcu_as_sc_mcu7t3v3__fill_1
X_4185_ VDD VDD VSS VSS _4245_/B _4188_/B _4188_/C _5023_/Q _5023_/D gf180mcu_as_sc_mcu7t3v3__ao22_2
X_3205_ VDD VDD VSS VSS _3213_/A _3205_/B _3228_/A _3206_/D gf180mcu_as_sc_mcu7t3v3__nand3_2
XFILLER_3_1521 VDD VDD VSS VSS gf180mcu_as_sc_mcu7t3v3__fillcap_16
XFILLER_82_300 VDD VDD VSS VSS gf180mcu_as_sc_mcu7t3v3__fill_1
X_3136_ VDD VDD VSS VSS _3153_/A _3136_/B _3136_/C _3153_/D _3138_/C gf180mcu_as_sc_mcu7t3v3__ao211_2
XFILLER_103_37 VDD VDD VSS VSS gf180mcu_as_sc_mcu7t3v3__fill_1
X_3067_ VDD VDD VSS VSS _3151_/S _4046_/A _4046_/D _3069_/B gf180mcu_as_sc_mcu7t3v3__mux2_2
XFILLER_184_1520 VDD VDD VSS VSS gf180mcu_as_sc_mcu7t3v3__fillcap_8
XFILLER_58_1534 VDD VDD VSS VSS gf180mcu_as_sc_mcu7t3v3__fillcap_16
XFILLER_97_1561 VDD VDD VSS VSS gf180mcu_as_sc_mcu7t3v3__fillcap_4
XFILLER_145_1504 VDD VDD VSS VSS gf180mcu_as_sc_mcu7t3v3__fillcap_4
XFILLER_35_260 VDD VDD VSS VSS gf180mcu_as_sc_mcu7t3v3__fillcap_16
XFILLER_35_282 VDD VDD VSS VSS gf180mcu_as_sc_mcu7t3v3__fillcap_16
XFILLER_58_1556 VDD VDD VSS VSS gf180mcu_as_sc_mcu7t3v3__fillcap_8
XFILLER_180_1428 VDD VDD VSS VSS gf180mcu_as_sc_mcu7t3v3__fill_2
XFILLER_149_663 VDD VDD VSS VSS gf180mcu_as_sc_mcu7t3v3__fillcap_16
X_3969_ VDD VDD VSS VSS _3969_/A _4131_/B _3969_/C _3969_/D _3970_/B gf180mcu_as_sc_mcu7t3v3__ao211_2
XFILLER_12_34 VDD VDD VSS VSS gf180mcu_as_sc_mcu7t3v3__fill_1
XPHY_EDGE_ROW_79_3_Right_398 VDD VSS gf180mcu_as_sc_mcu7t3v3__tap_2
XFILLER_128_34 VDD VDD VSS VSS gf180mcu_as_sc_mcu7t3v3__fill_1
XFILLER_164_699 VDD VDD VSS VSS gf180mcu_as_sc_mcu7t3v3__fill_2
XFILLER_178_1379 VDD VDD VSS VSS gf180mcu_as_sc_mcu7t3v3__fill_2
XFILLER_30_1486 VDD VDD VSS VSS gf180mcu_as_sc_mcu7t3v3__fillcap_16
XFILLER_88_27 VDD VDD VSS VSS gf180mcu_as_sc_mcu7t3v3__fillcap_8
XFILLER_160_861 VDD VDD VSS VSS gf180mcu_as_sc_mcu7t3v3__fill_2
XFILLER_137_1098 VDD VDD VSS VSS gf180mcu_as_sc_mcu7t3v3__fillcap_8
XFILLER_77_138 VDD VDD VSS VSS gf180mcu_as_sc_mcu7t3v3__fill_2
Xfanout630 VDD VDD VSS VSS fanout631/Y _3142_/C gf180mcu_as_sc_mcu7t3v3__buff_2
Xfanout641 VDD VDD VSS VSS _4594_/Y _4600_/C gf180mcu_as_sc_mcu7t3v3__buff_2
XTAP_TAPCELL_ROW_73_1_928 VDD VSS gf180mcu_as_sc_mcu7t3v3__tap_2
XFILLER_150_1221 VDD VDD VSS VSS gf180mcu_as_sc_mcu7t3v3__fillcap_4
Xfanout652 VDD VDD VSS VSS _3747_/B _3778_/B gf180mcu_as_sc_mcu7t3v3__buff_2
Xfanout663 VDD VDD VSS VSS fanout666/Y _4128_/B gf180mcu_as_sc_mcu7t3v3__buff_2
Xfanout674 VDD VDD VSS VSS fanout675/Y _4120_/B gf180mcu_as_sc_mcu7t3v3__buff_2
Xfanout685 VDD VDD VSS VSS _3268_/Y _3501_/B gf180mcu_as_sc_mcu7t3v3__buff_2
XFILLER_37_42 VDD VDD VSS VSS gf180mcu_as_sc_mcu7t3v3__fillcap_16
XFILLER_73_300 VDD VDD VSS VSS gf180mcu_as_sc_mcu7t3v3__fill_1
XFILLER_85_160 VDD VDD VSS VSS gf180mcu_as_sc_mcu7t3v3__fill_1
Xfanout696 VDD VDD VSS VSS _3542_/Y _3740_/B gf180mcu_as_sc_mcu7t3v3__buff_2
XFILLER_170_2 VDD VDD VSS VSS gf180mcu_as_sc_mcu7t3v3__fillcap_16
XPHY_EDGE_ROW_82_3_Left_216 VDD VSS gf180mcu_as_sc_mcu7t3v3__tap_2
XTAP_TAPCELL_ROW_0_1_2341 VDD VSS gf180mcu_as_sc_mcu7t3v3__tap_2
XFILLER_183_1041 VDD VDD VSS VSS gf180mcu_as_sc_mcu7t3v3__fillcap_8
XFILLER_26_271 VDD VDD VSS VSS gf180mcu_as_sc_mcu7t3v3__fillcap_4
XFILLER_183_1052 VDD VDD VSS VSS gf180mcu_as_sc_mcu7t3v3__fillcap_4
XFILLER_174_419 VDD VDD VSS VSS gf180mcu_as_sc_mcu7t3v3__fillcap_16
XFILLER_139_184 VDD VDD VSS VSS gf180mcu_as_sc_mcu7t3v3__fillcap_16
XTAP_TAPCELL_ROW_175_2096 VDD VSS gf180mcu_as_sc_mcu7t3v3__tap_2
XFILLER_5_120 VDD VDD VSS VSS gf180mcu_as_sc_mcu7t3v3__fillcap_16
XTAP_TAPCELL_ROW_52_1_842 VDD VSS gf180mcu_as_sc_mcu7t3v3__tap_2
XFILLER_155_699 VDD VDD VSS VSS gf180mcu_as_sc_mcu7t3v3__fill_1
XFILLER_52_8 VDD VDD VSS VSS gf180mcu_as_sc_mcu7t3v3__fill_1
XFILLER_5_142 VDD VDD VSS VSS gf180mcu_as_sc_mcu7t3v3__fillcap_16
XFILLER_170_658 VDD VDD VSS VSS gf180mcu_as_sc_mcu7t3v3__fillcap_4
XFILLER_151_850 VDD VDD VSS VSS gf180mcu_as_sc_mcu7t3v3__fillcap_4
XFILLER_155_1154 VDD VDD VSS VSS gf180mcu_as_sc_mcu7t3v3__fillcap_16
XFILLER_150_382 VDD VDD VSS VSS gf180mcu_as_sc_mcu7t3v3__fill_2
XFILLER_151_894 VDD VDD VSS VSS gf180mcu_as_sc_mcu7t3v3__fill_1
XFILLER_68_149 VDD VDD VSS VSS gf180mcu_as_sc_mcu7t3v3__fill_2
XTAP_TAPCELL_ROW_147_1486 VDD VSS gf180mcu_as_sc_mcu7t3v3__tap_2
XTAP_TAPCELL_ROW_147_1497 VDD VSS gf180mcu_as_sc_mcu7t3v3__tap_2
XFILLER_17_260 VDD VDD VSS VSS gf180mcu_as_sc_mcu7t3v3__fill_2
XFILLER_17_282 VDD VDD VSS VSS gf180mcu_as_sc_mcu7t3v3__fillcap_16
XFILLER_91_196 VDD VDD VSS VSS gf180mcu_as_sc_mcu7t3v3__fill_2
X_4941_ VDD VDD VSS VSS _5185_/CLK _4941_/D _4941_/Q gf180mcu_as_sc_mcu7t3v3__dfxtp_2
XFILLER_162_1103 VDD VDD VSS VSS gf180mcu_as_sc_mcu7t3v3__fillcap_4
XFILLER_32_241 VDD VDD VSS VSS gf180mcu_as_sc_mcu7t3v3__fillcap_4
X_4872_ VDD VDD VSS VSS _5046_/CLK _4872_/D _4872_/Q gf180mcu_as_sc_mcu7t3v3__dfxtp_2
XFILLER_166_1294 VDD VDD VSS VSS gf180mcu_as_sc_mcu7t3v3__fill_1
XFILLER_166_909 VDD VDD VSS VSS gf180mcu_as_sc_mcu7t3v3__fill_2
XFILLER_32_263 VDD VDD VSS VSS gf180mcu_as_sc_mcu7t3v3__fillcap_16
X_3823_ VDD VDD VSS VSS _3826_/B _3825_/C _3824_/C gf180mcu_as_sc_mcu7t3v3__or2_2
XFILLER_105_1521 VDD VDD VSS VSS gf180mcu_as_sc_mcu7t3v3__fillcap_16
XFILLER_140_1434 VDD VDD VSS VSS gf180mcu_as_sc_mcu7t3v3__fill_1
XFILLER_174_942 VDD VDD VSS VSS gf180mcu_as_sc_mcu7t3v3__fill_2
X_3754_ VDD VDD VSS VSS _4940_/Q _3799_/B _3770_/C _4137_/A _3756_/C gf180mcu_as_sc_mcu7t3v3__ao22_2
XFILLER_140_1467 VDD VDD VSS VSS gf180mcu_as_sc_mcu7t3v3__fillcap_16
X_3685_ VDD VDD VSS VSS _4063_/A _3741_/B _3740_/C _4061_/A _3686_/C gf180mcu_as_sc_mcu7t3v3__ao22_2
X_2705_ VDD VDD VSS VSS _5160_/Q _4269_/S _4278_/S _5184_/Q _2706_/B gf180mcu_as_sc_mcu7t3v3__ao22_2
XTAP_TAPCELL_ROW_38_1_787 VDD VSS gf180mcu_as_sc_mcu7t3v3__tap_2
XFILLER_134_828 VDD VDD VSS VSS gf180mcu_as_sc_mcu7t3v3__fillcap_8
X_2636_ VDD VDD VSS VSS _2653_/S _2636_/B _2636_/A _2637_/A gf180mcu_as_sc_mcu7t3v3__mux2_2
XFILLER_173_496 VDD VDD VSS VSS gf180mcu_as_sc_mcu7t3v3__fill_1
X_2567_ VDD VDD VSS VSS _2852_/B _4745_/B _5278_/Q gf180mcu_as_sc_mcu7t3v3__nand2_2
XTAP_TAPCELL_ROW_120_1_1117 VDD VSS gf180mcu_as_sc_mcu7t3v3__tap_2
XFILLER_101_202 VDD VDD VSS VSS gf180mcu_as_sc_mcu7t3v3__fill_1
XFILLER_141_360 VDD VDD VSS VSS gf180mcu_as_sc_mcu7t3v3__fillcap_4
X_4306_ VDD VDD VSS VSS _4325_/S _5136_/Q _5135_/Q _5135_/D gf180mcu_as_sc_mcu7t3v3__mux2_2
X_2498_ VDD VDD VSS VSS _2747_/A _2845_/D _2525_/A gf180mcu_as_sc_mcu7t3v3__and2_2
XFILLER_141_393 VDD VDD VSS VSS gf180mcu_as_sc_mcu7t3v3__fillcap_16
X_4237_ VDD VDD VSS VSS _4248_/S _4237_/B _5073_/Q _5073_/D gf180mcu_as_sc_mcu7t3v3__mux2_2
XFILLER_101_279 VDD VDD VSS VSS gf180mcu_as_sc_mcu7t3v3__fill_1
XFILLER_55_300 VDD VDD VSS VSS gf180mcu_as_sc_mcu7t3v3__fill_1
XFILLER_67_182 VDD VDD VSS VSS gf180mcu_as_sc_mcu7t3v3__fillcap_16
X_4168_ VDD VDD VSS VSS _4168_/Y _4199_/A _4197_/B _4168_/A gf180mcu_as_sc_mcu7t3v3__aoi21b_2
XFILLER_167_1014 VDD VDD VSS VSS gf180mcu_as_sc_mcu7t3v3__fill_1
X_4099_ VDD VDD VSS VSS _4099_/A _4099_/B _4099_/C _4249_/B _4124_/D gf180mcu_as_sc_mcu7t3v3__aoi211_2
X_3119_ VDD VDD VSS VSS _4095_/A _3144_/B _3169_/C _4096_/D _3120_/C gf180mcu_as_sc_mcu7t3v3__ao22_2
XTAP_TAPCELL_ROW_100_1_1037 VDD VSS gf180mcu_as_sc_mcu7t3v3__tap_2
XFILLER_82_174 VDD VDD VSS VSS gf180mcu_as_sc_mcu7t3v3__fill_1
XFILLER_180_1214 VDD VDD VSS VSS gf180mcu_as_sc_mcu7t3v3__fill_2
XFILLER_145_1356 VDD VDD VSS VSS gf180mcu_as_sc_mcu7t3v3__fill_2
XFILLER_169_747 VDD VDD VSS VSS gf180mcu_as_sc_mcu7t3v3__fillcap_8
XFILLER_169_769 VDD VDD VSS VSS gf180mcu_as_sc_mcu7t3v3__fill_1
XFILLER_180_1269 VDD VDD VSS VSS gf180mcu_as_sc_mcu7t3v3__fill_1
XFILLER_71_1553 VDD VDD VSS VSS gf180mcu_as_sc_mcu7t3v3__fillcap_16
XFILLER_168_279 VDD VDD VSS VSS gf180mcu_as_sc_mcu7t3v3__fillcap_16
XFILLER_23_66 VDD VDD VSS VSS gf180mcu_as_sc_mcu7t3v3__fillcap_4
XFILLER_23_88 VDD VDD VSS VSS gf180mcu_as_sc_mcu7t3v3__fillcap_16
XFILLER_139_66 VDD VDD VSS VSS gf180mcu_as_sc_mcu7t3v3__fillcap_4
XFILLER_139_88 VDD VDD VSS VSS gf180mcu_as_sc_mcu7t3v3__fillcap_4
XFILLER_165_975 VDD VDD VSS VSS gf180mcu_as_sc_mcu7t3v3__fillcap_4
XFILLER_152_625 VDD VDD VSS VSS gf180mcu_as_sc_mcu7t3v3__fill_2
XFILLER_178_1154 VDD VDD VSS VSS gf180mcu_as_sc_mcu7t3v3__fill_1
XFILLER_174_1029 VDD VDD VSS VSS gf180mcu_as_sc_mcu7t3v3__fillcap_4
XFILLER_2_101 VDD VDD VSS VSS gf180mcu_as_sc_mcu7t3v3__fillcap_4
XFILLER_140_809 VDD VDD VSS VSS gf180mcu_as_sc_mcu7t3v3__fill_1
XFILLER_155_65 VDD VDD VSS VSS gf180mcu_as_sc_mcu7t3v3__fillcap_4
XFILLER_2_123 VDD VDD VSS VSS gf180mcu_as_sc_mcu7t3v3__fillcap_4
XFILLER_2_134 VDD VDD VSS VSS gf180mcu_as_sc_mcu7t3v3__fillcap_8
XFILLER_48_41 VDD VDD VSS VSS gf180mcu_as_sc_mcu7t3v3__fill_2
XFILLER_150_1040 VDD VDD VSS VSS gf180mcu_as_sc_mcu7t3v3__fillcap_16
XPHY_EDGE_ROW_115_1_Left_567 VDD VSS gf180mcu_as_sc_mcu7t3v3__tap_2
Xfanout471 VDD VDD VSS VSS _4117_/B _4166_/B gf180mcu_as_sc_mcu7t3v3__buff_2
Xfanout482 VDD VDD VSS VSS fanout485/Y _4547_/A gf180mcu_as_sc_mcu7t3v3__buff_2
Xfanout493 VDD VDD VSS VSS _3912_/Y _4125_/D gf180mcu_as_sc_mcu7t3v3__buff_2
XTAP_TAPCELL_ROW_55_1_857 VDD VSS gf180mcu_as_sc_mcu7t3v3__tap_2
XFILLER_58_193 VDD VDD VSS VSS gf180mcu_as_sc_mcu7t3v3__fillcap_4
XFILLER_104_80 VDD VDD VSS VSS gf180mcu_as_sc_mcu7t3v3__fillcap_16
XPHY_EDGE_ROW_52_1_Left_504 VDD VSS gf180mcu_as_sc_mcu7t3v3__tap_2
XFILLER_73_196 VDD VDD VSS VSS gf180mcu_as_sc_mcu7t3v3__fill_2
XTAP_TAPCELL_ROW_142_1383 VDD VSS gf180mcu_as_sc_mcu7t3v3__tap_2
XTAP_TAPCELL_ROW_142_1372 VDD VSS gf180mcu_as_sc_mcu7t3v3__tap_2
XFILLER_14_241 VDD VDD VSS VSS gf180mcu_as_sc_mcu7t3v3__fillcap_4
XFILLER_14_263 VDD VDD VSS VSS gf180mcu_as_sc_mcu7t3v3__fillcap_16
XFILLER_76_1486 VDD VDD VSS VSS gf180mcu_as_sc_mcu7t3v3__fillcap_16
XTAP_TAPCELL_ROW_177_2158 VDD VSS gf180mcu_as_sc_mcu7t3v3__tap_2
XTAP_TAPCELL_ROW_177_2147 VDD VSS gf180mcu_as_sc_mcu7t3v3__tap_2
XFILLER_163_1467 VDD VDD VSS VSS gf180mcu_as_sc_mcu7t3v3__fill_2
XFILLER_159_279 VDD VDD VSS VSS gf180mcu_as_sc_mcu7t3v3__fill_1
XFILLER_156_942 VDD VDD VSS VSS gf180mcu_as_sc_mcu7t3v3__fill_2
XFILLER_156_953 VDD VDD VSS VSS gf180mcu_as_sc_mcu7t3v3__fillcap_8
XPHY_EDGE_ROW_5_3_Left_139 VDD VSS gf180mcu_as_sc_mcu7t3v3__tap_2
XFILLER_143_625 VDD VDD VSS VSS gf180mcu_as_sc_mcu7t3v3__fillcap_4
XFILLER_100_1451 VDD VDD VSS VSS gf180mcu_as_sc_mcu7t3v3__fillcap_16
XFILLER_127_187 VDD VDD VSS VSS gf180mcu_as_sc_mcu7t3v3__fillcap_8
XFILLER_157_1216 VDD VDD VSS VSS gf180mcu_as_sc_mcu7t3v3__fill_1
X_3470_ VDD VDD VSS VSS _4124_/A _3470_/B _3470_/C _4828_/D _3746_/D gf180mcu_as_sc_mcu7t3v3__aoi211_2
XTAP_TAPCELL_ROW_34_1_771 VDD VSS gf180mcu_as_sc_mcu7t3v3__tap_2
XPHY_EDGE_ROW_76_1_Right_75 VDD VSS gf180mcu_as_sc_mcu7t3v3__tap_2
X_2421_ VDD VDD VSS VSS _2657_/B _2421_/A gf180mcu_as_sc_mcu7t3v3__inv_2
XFILLER_174_1563 VDD VDD VSS VSS gf180mcu_as_sc_mcu7t3v3__fill_2
XPHY_EDGE_ROW_47_1_Left_499 VDD VSS gf180mcu_as_sc_mcu7t3v3__tap_2
X_5140_ VDD VDD VSS VSS _5146_/CLK _5140_/D _5140_/Q gf180mcu_as_sc_mcu7t3v3__dfxtp_2
XFILLER_29_2 VDD VDD VSS VSS gf180mcu_as_sc_mcu7t3v3__fillcap_16
XFILLER_96_222 VDD VDD VSS VSS gf180mcu_as_sc_mcu7t3v3__fill_1
XFILLER_96_233 VDD VDD VSS VSS gf180mcu_as_sc_mcu7t3v3__fillcap_8
X_5071_ VDD VDD VSS VSS _5080_/CLK _5071_/D _5071_/Q gf180mcu_as_sc_mcu7t3v3__dfxtp_2
XTAP_TAPCELL_ROW_149_1537 VDD VSS gf180mcu_as_sc_mcu7t3v3__tap_2
XTAP_TAPCELL_ROW_149_1526 VDD VSS gf180mcu_as_sc_mcu7t3v3__tap_2
XFILLER_37_300 VDD VDD VSS VSS gf180mcu_as_sc_mcu7t3v3__fill_1
X_4022_ VDD VDD VSS VSS _4022_/A _4104_/B _4124_/B _4022_/D _4026_/A gf180mcu_as_sc_mcu7t3v3__ao211_2
XFILLER_168_1301 VDD VDD VSS VSS gf180mcu_as_sc_mcu7t3v3__fill_1
XFILLER_49_160 VDD VDD VSS VSS gf180mcu_as_sc_mcu7t3v3__fill_1
XFILLER_96_299 VDD VDD VSS VSS gf180mcu_as_sc_mcu7t3v3__fill_2
XFILLER_168_1323 VDD VDD VSS VSS gf180mcu_as_sc_mcu7t3v3__fill_1
XFILLER_0_1535 VDD VDD VSS VSS gf180mcu_as_sc_mcu7t3v3__fillcap_16
XFILLER_168_1367 VDD VDD VSS VSS gf180mcu_as_sc_mcu7t3v3__fillcap_8
XFILLER_64_174 VDD VDD VSS VSS gf180mcu_as_sc_mcu7t3v3__fill_1
XFILLER_55_1515 VDD VDD VSS VSS gf180mcu_as_sc_mcu7t3v3__fillcap_4
XFILLER_64_196 VDD VDD VSS VSS gf180mcu_as_sc_mcu7t3v3__fillcap_4
XFILLER_94_1542 VDD VDD VSS VSS gf180mcu_as_sc_mcu7t3v3__fillcap_4
X_4924_ VDD VDD VSS VSS _5053_/CLK _4924_/D _4924_/Q gf180mcu_as_sc_mcu7t3v3__dfxtp_2
XFILLER_142_1507 VDD VDD VSS VSS gf180mcu_as_sc_mcu7t3v3__fillcap_4
XFILLER_55_1537 VDD VDD VSS VSS gf180mcu_as_sc_mcu7t3v3__fillcap_16
X_4855_ VDD VDD VSS VSS _5052_/CLK _4855_/D _4855_/Q gf180mcu_as_sc_mcu7t3v3__dfxtp_2
X_4786_ VDD VDD VSS VSS _4858_/CLK _4786_/D _4786_/Q gf180mcu_as_sc_mcu7t3v3__dfxtp_2
X_3806_ VDD VDD VSS VSS _3846_/B _4913_/Q _3929_/A gf180mcu_as_sc_mcu7t3v3__and2_2
XFILLER_146_441 VDD VDD VSS VSS gf180mcu_as_sc_mcu7t3v3__fill_1
XFILLER_20_299 VDD VDD VSS VSS gf180mcu_as_sc_mcu7t3v3__fill_2
X_3737_ VDD VDD VSS VSS _3738_/C _3737_/C _3752_/B _4114_/A gf180mcu_as_sc_mcu7t3v3__aoi21_2
XFILLER_134_614 VDD VDD VSS VSS gf180mcu_as_sc_mcu7t3v3__fillcap_16
XFILLER_140_1275 VDD VDD VSS VSS gf180mcu_as_sc_mcu7t3v3__fill_1
XFILLER_140_1297 VDD VDD VSS VSS gf180mcu_as_sc_mcu7t3v3__fillcap_16
XFILLER_146_452 VDD VDD VSS VSS gf180mcu_as_sc_mcu7t3v3__fill_2
XFILLER_173_260 VDD VDD VSS VSS gf180mcu_as_sc_mcu7t3v3__fillcap_16
XFILLER_109_69 VDD VDD VSS VSS gf180mcu_as_sc_mcu7t3v3__fill_1
XFILLER_118_187 VDD VDD VSS VSS gf180mcu_as_sc_mcu7t3v3__fillcap_8
XFILLER_134_658 VDD VDD VSS VSS gf180mcu_as_sc_mcu7t3v3__fill_1
XFILLER_161_422 VDD VDD VSS VSS gf180mcu_as_sc_mcu7t3v3__fillcap_8
XFILLER_173_282 VDD VDD VSS VSS gf180mcu_as_sc_mcu7t3v3__fillcap_16
X_3668_ VDD VDD VSS VSS _3722_/D _3730_/A _3668_/B _3668_/C _3669_/C gf180mcu_as_sc_mcu7t3v3__ao31_2
XFILLER_133_146 VDD VDD VSS VSS gf180mcu_as_sc_mcu7t3v3__fill_2
X_3599_ VDD VDD VSS VSS _3966_/A _3726_/B _3599_/C _3707_/B _3600_/C gf180mcu_as_sc_mcu7t3v3__ao211_2
X_2619_ VDD VDD VSS VSS _2620_/D _5257_/Q _2634_/B _2619_/C gf180mcu_as_sc_mcu7t3v3__ao21_2
XFILLER_125_79 VDD VDD VSS VSS gf180mcu_as_sc_mcu7t3v3__fillcap_16
XFILLER_87_255 VDD VDD VSS VSS gf180mcu_as_sc_mcu7t3v3__fill_1
X_5269_ VDD VDD VSS VSS clkload5/A _5269_/D _5269_/Q gf180mcu_as_sc_mcu7t3v3__dfxtp_2
XFILLER_151_1382 VDD VDD VSS VSS gf180mcu_as_sc_mcu7t3v3__fillcap_4
XFILLER_169_1109 VDD VDD VSS VSS gf180mcu_as_sc_mcu7t3v3__fillcap_4
XTAP_TAPCELL_ROW_43_1_806 VDD VSS gf180mcu_as_sc_mcu7t3v3__tap_2
XFILLER_141_34 VDD VDD VSS VSS gf180mcu_as_sc_mcu7t3v3__fillcap_16
XPHY_EDGE_ROW_147_Right_281 VDD VSS gf180mcu_as_sc_mcu7t3v3__tap_2
XFILLER_147_1418 VDD VDD VSS VSS gf180mcu_as_sc_mcu7t3v3__fillcap_16
XTAP_TAPCELL_ROW_51_1_841 VDD VSS gf180mcu_as_sc_mcu7t3v3__tap_2
XFILLER_169_500 VDD VDD VSS VSS gf180mcu_as_sc_mcu7t3v3__fill_2
XFILLER_70_144 VDD VDD VSS VSS gf180mcu_as_sc_mcu7t3v3__fill_1
XFILLER_180_1000 VDD VDD VSS VSS gf180mcu_as_sc_mcu7t3v3__fill_2
XFILLER_34_32 VDD VDD VSS VSS gf180mcu_as_sc_mcu7t3v3__fill_2
XFILLER_180_1055 VDD VDD VSS VSS gf180mcu_as_sc_mcu7t3v3__fill_1
XFILLER_34_98 VDD VDD VSS VSS gf180mcu_as_sc_mcu7t3v3__fillcap_4
XFILLER_11_244 VDD VDD VSS VSS gf180mcu_as_sc_mcu7t3v3__fillcap_16
XFILLER_133_2 VDD VDD VSS VSS gf180mcu_as_sc_mcu7t3v3__fillcap_16
XFILLER_123_1451 VDD VDD VSS VSS gf180mcu_as_sc_mcu7t3v3__fillcap_16
XFILLER_138_942 VDD VDD VSS VSS gf180mcu_as_sc_mcu7t3v3__fill_2
XTAP_TAPCELL_ROW_172_2044 VDD VSS gf180mcu_as_sc_mcu7t3v3__tap_2
XTAP_TAPCELL_ROW_172_2033 VDD VSS gf180mcu_as_sc_mcu7t3v3__tap_2
XFILLER_153_912 VDD VDD VSS VSS gf180mcu_as_sc_mcu7t3v3__fill_1
XFILLER_158_1503 VDD VDD VSS VSS gf180mcu_as_sc_mcu7t3v3__fill_2
XFILLER_165_761 VDD VDD VSS VSS gf180mcu_as_sc_mcu7t3v3__fillcap_4
XFILLER_165_772 VDD VDD VSS VSS gf180mcu_as_sc_mcu7t3v3__fillcap_16
XFILLER_166_53 VDD VDD VSS VSS gf180mcu_as_sc_mcu7t3v3__fillcap_16
XFILLER_180_731 VDD VDD VSS VSS gf180mcu_as_sc_mcu7t3v3__fillcap_4
XFILLER_140_628 VDD VDD VSS VSS gf180mcu_as_sc_mcu7t3v3__fill_2
XPHY_EDGE_ROW_26_3_Left_160 VDD VSS gf180mcu_as_sc_mcu7t3v3__tap_2
XFILLER_152_1157 VDD VDD VSS VSS gf180mcu_as_sc_mcu7t3v3__fillcap_4
XFILLER_19_300 VDD VDD VSS VSS gf180mcu_as_sc_mcu7t3v3__fill_1
XFILLER_78_299 VDD VDD VSS VSS gf180mcu_as_sc_mcu7t3v3__fill_2
XFILLER_75_72 VDD VDD VSS VSS gf180mcu_as_sc_mcu7t3v3__fillcap_16
XTAP_TAPCELL_ROW_144_1434 VDD VSS gf180mcu_as_sc_mcu7t3v3__tap_2
XTAP_TAPCELL_ROW_144_1423 VDD VSS gf180mcu_as_sc_mcu7t3v3__tap_2
XFILLER_46_174 VDD VDD VSS VSS gf180mcu_as_sc_mcu7t3v3__fill_1
XFILLER_163_1220 VDD VDD VSS VSS gf180mcu_as_sc_mcu7t3v3__fillcap_4
XFILLER_61_166 VDD VDD VSS VSS gf180mcu_as_sc_mcu7t3v3__fillcap_8
X_2970_ VDD VDD VSS VSS _3236_/B _4917_/Q _2971_/D gf180mcu_as_sc_mcu7t3v3__or2_2
XTAP_TAPCELL_ROW_161_1792 VDD VSS gf180mcu_as_sc_mcu7t3v3__tap_2
XFILLER_61_188 VDD VDD VSS VSS gf180mcu_as_sc_mcu7t3v3__fillcap_16
XFILLER_15_1521 VDD VDD VSS VSS gf180mcu_as_sc_mcu7t3v3__fillcap_16
XFILLER_163_1286 VDD VDD VSS VSS gf180mcu_as_sc_mcu7t3v3__fillcap_4
XFILLER_175_525 VDD VDD VSS VSS gf180mcu_as_sc_mcu7t3v3__fillcap_8
X_4640_ VDD VDD VSS VSS _4720_/A _5106_/Q _5231_/Q _5231_/D gf180mcu_as_sc_mcu7t3v3__mux2_2
XFILLER_102_1502 VDD VDD VSS VSS gf180mcu_as_sc_mcu7t3v3__fillcap_16
XFILLER_50_1467 VDD VDD VSS VSS gf180mcu_as_sc_mcu7t3v3__fillcap_16
X_4571_ VDD VDD VSS VSS _4572_/D _4571_/B _4572_/A gf180mcu_as_sc_mcu7t3v3__nor2_2
XFILLER_102_1568 VDD VDD VSS VSS gf180mcu_as_sc_mcu7t3v3__fill_1
XFILLER_155_282 VDD VDD VSS VSS gf180mcu_as_sc_mcu7t3v3__fill_1
XFILLER_157_1002 VDD VDD VSS VSS gf180mcu_as_sc_mcu7t3v3__fill_1
XFILLER_171_731 VDD VDD VSS VSS gf180mcu_as_sc_mcu7t3v3__fillcap_4
X_3522_ VDD VDD VSS VSS _3522_/A _3522_/B _3523_/B _3523_/C _3522_/D gf180mcu_as_sc_mcu7t3v3__aoi211_2
XFILLER_143_455 VDD VDD VSS VSS gf180mcu_as_sc_mcu7t3v3__fillcap_8
XFILLER_170_241 VDD VDD VSS VSS gf180mcu_as_sc_mcu7t3v3__fillcap_4
X_3453_ VDD VDD VSS VSS _4104_/A _3453_/B _3453_/C _4105_/A _3454_/C gf180mcu_as_sc_mcu7t3v3__ao22_2
XFILLER_157_1068 VDD VDD VSS VSS gf180mcu_as_sc_mcu7t3v3__fillcap_4
XFILLER_170_263 VDD VDD VSS VSS gf180mcu_as_sc_mcu7t3v3__fillcap_16
X_2404_ VDD VDD VSS VSS _4746_/A _4703_/B gf180mcu_as_sc_mcu7t3v3__inv_2
XFILLER_170_1213 VDD VDD VSS VSS gf180mcu_as_sc_mcu7t3v3__fillcap_4
XFILLER_170_1224 VDD VDD VSS VSS gf180mcu_as_sc_mcu7t3v3__fill_1
X_5123_ VDD VDD VSS VSS _5164_/CLK _5123_/D _5123_/Q gf180mcu_as_sc_mcu7t3v3__dfxtp_2
X_3384_ VDD VDD VSS VSS _3661_/A _3447_/B _3384_/C _4817_/D _3661_/D gf180mcu_as_sc_mcu7t3v3__aoi211_2
XTAP_TAPCELL_ROW_83_1_966 VDD VSS gf180mcu_as_sc_mcu7t3v3__tap_2
XTAP_TAPCELL_ROW_168_1957 VDD VSS gf180mcu_as_sc_mcu7t3v3__tap_2
XTAP_TAPCELL_ROW_168_1946 VDD VSS gf180mcu_as_sc_mcu7t3v3__tap_2
XFILLER_84_225 VDD VDD VSS VSS gf180mcu_as_sc_mcu7t3v3__fillcap_4
X_5054_ VDD VDD VSS VSS _5183_/CLK _5054_/D _5054_/Q gf180mcu_as_sc_mcu7t3v3__dfxtp_2
XFILLER_84_247 VDD VDD VSS VSS gf180mcu_as_sc_mcu7t3v3__fillcap_4
X_4005_ VDD VDD VSS VSS _4005_/A _4102_/B _4102_/C _4924_/Q _4007_/C gf180mcu_as_sc_mcu7t3v3__ao22_2
XFILLER_37_174 VDD VDD VSS VSS gf180mcu_as_sc_mcu7t3v3__fillcap_16
XPHY_EDGE_ROW_156_Left_608 VDD VSS gf180mcu_as_sc_mcu7t3v3__tap_2
XFILLER_52_144 VDD VDD VSS VSS gf180mcu_as_sc_mcu7t3v3__fill_1
XFILLER_146_1451 VDD VDD VSS VSS gf180mcu_as_sc_mcu7t3v3__fillcap_8
XFILLER_179_875 VDD VDD VSS VSS gf180mcu_as_sc_mcu7t3v3__fill_2
X_4907_ VDD VDD VSS VSS _5074_/CLK _4907_/D _4907_/Q gf180mcu_as_sc_mcu7t3v3__dfxtp_2
XFILLER_139_739 VDD VDD VSS VSS gf180mcu_as_sc_mcu7t3v3__fillcap_8
X_4838_ VDD VDD VSS VSS _4869_/CLK _4838_/D _4838_/Q gf180mcu_as_sc_mcu7t3v3__dfxtp_2
XFILLER_138_238 VDD VDD VSS VSS gf180mcu_as_sc_mcu7t3v3__fillcap_4
XFILLER_166_569 VDD VDD VSS VSS gf180mcu_as_sc_mcu7t3v3__fillcap_4
XFILLER_135_912 VDD VDD VSS VSS gf180mcu_as_sc_mcu7t3v3__fillcap_8
XFILLER_147_772 VDD VDD VSS VSS gf180mcu_as_sc_mcu7t3v3__fillcap_16
X_4769_ VDD VDD VSS VSS _5266_/CLK _4769_/D _4769_/Q gf180mcu_as_sc_mcu7t3v3__dfxtp_2
XFILLER_146_271 VDD VDD VSS VSS gf180mcu_as_sc_mcu7t3v3__fill_1
XFILLER_162_731 VDD VDD VSS VSS gf180mcu_as_sc_mcu7t3v3__fillcap_4
XFILLER_179_1282 VDD VDD VSS VSS gf180mcu_as_sc_mcu7t3v3__fill_2
XFILLER_20_34 VDD VDD VSS VSS gf180mcu_as_sc_mcu7t3v3__fill_1
XPHY_EDGE_ROW_165_Left_617 VDD VSS gf180mcu_as_sc_mcu7t3v3__tap_2
XPHY_EDGE_ROW_91_3_Left_225 VDD VSS gf180mcu_as_sc_mcu7t3v3__tap_2
XFILLER_134_444 VDD VDD VSS VSS gf180mcu_as_sc_mcu7t3v3__fillcap_16
XFILLER_136_34 VDD VDD VSS VSS gf180mcu_as_sc_mcu7t3v3__fill_1
XFILLER_161_241 VDD VDD VSS VSS gf180mcu_as_sc_mcu7t3v3__fillcap_16
XFILLER_162_753 VDD VDD VSS VSS gf180mcu_as_sc_mcu7t3v3__fillcap_8
XFILLER_106_168 VDD VDD VSS VSS gf180mcu_as_sc_mcu7t3v3__fillcap_4
XFILLER_136_1108 VDD VDD VSS VSS gf180mcu_as_sc_mcu7t3v3__fill_1
XFILLER_150_926 VDD VDD VSS VSS gf180mcu_as_sc_mcu7t3v3__fill_1
XFILLER_121_138 VDD VDD VSS VSS gf180mcu_as_sc_mcu7t3v3__fill_2
XFILLER_96_27 VDD VDD VSS VSS gf180mcu_as_sc_mcu7t3v3__fillcap_8
Xinput303 VDD VDD VSS VSS west_in[28] _4161_/A gf180mcu_as_sc_mcu7t3v3__buff_2
Xinput314 VDD VDD VSS VSS west_in[7] _3989_/A gf180mcu_as_sc_mcu7t3v3__buff_2
XFILLER_153_1488 VDD VDD VSS VSS gf180mcu_as_sc_mcu7t3v3__fillcap_4
XPHY_EDGE_ROW_174_Left_626 VDD VSS gf180mcu_as_sc_mcu7t3v3__tap_2
XTAP_TAPCELL_ROW_25_1_735 VDD VSS gf180mcu_as_sc_mcu7t3v3__tap_2
XFILLER_43_122 VDD VDD VSS VSS gf180mcu_as_sc_mcu7t3v3__fill_1
XFILLER_147_1259 VDD VDD VSS VSS gf180mcu_as_sc_mcu7t3v3__fill_1
XFILLER_43_144 VDD VDD VSS VSS gf180mcu_as_sc_mcu7t3v3__fill_1
XFILLER_169_330 VDD VDD VSS VSS gf180mcu_as_sc_mcu7t3v3__fillcap_16
XFILLER_169_352 VDD VDD VSS VSS gf180mcu_as_sc_mcu7t3v3__fillcap_16
XFILLER_43_188 VDD VDD VSS VSS gf180mcu_as_sc_mcu7t3v3__fillcap_16
XFILLER_160_1437 VDD VDD VSS VSS gf180mcu_as_sc_mcu7t3v3__fillcap_16
XFILLER_73_1467 VDD VDD VSS VSS gf180mcu_as_sc_mcu7t3v3__fillcap_16
XPHY_EDGE_ROW_183_Left_635 VDD VSS gf180mcu_as_sc_mcu7t3v3__tap_2
XFILLER_137_282 VDD VDD VSS VSS gf180mcu_as_sc_mcu7t3v3__fillcap_16
XFILLER_153_731 VDD VDD VSS VSS gf180mcu_as_sc_mcu7t3v3__fill_2
XTAP_TAPCELL_ROW_137_1271 VDD VSS gf180mcu_as_sc_mcu7t3v3__tap_2
XTAP_TAPCELL_ROW_137_1260 VDD VSS gf180mcu_as_sc_mcu7t3v3__tap_2
XFILLER_10_1451 VDD VDD VSS VSS gf180mcu_as_sc_mcu7t3v3__fillcap_16
XFILLER_152_241 VDD VDD VSS VSS gf180mcu_as_sc_mcu7t3v3__fillcap_4
XFILLER_6_69 VDD VDD VSS VSS gf180mcu_as_sc_mcu7t3v3__fillcap_16
XFILLER_141_948 VDD VDD VSS VSS gf180mcu_as_sc_mcu7t3v3__fill_1
XFILLER_152_263 VDD VDD VSS VSS gf180mcu_as_sc_mcu7t3v3__fill_2
XFILLER_158_1399 VDD VDD VSS VSS gf180mcu_as_sc_mcu7t3v3__fillcap_16
XFILLER_180_594 VDD VDD VSS VSS gf180mcu_as_sc_mcu7t3v3__fill_1
XFILLER_3_295 VDD VDD VSS VSS gf180mcu_as_sc_mcu7t3v3__fillcap_4
XFILLER_105_190 VDD VDD VSS VSS gf180mcu_as_sc_mcu7t3v3__fillcap_8
Xmesh_tile_918 VDD VDD VSS VSS nw_out[25] gf180mcu_as_sc_mcu7t3v3__tiel_4
Xmesh_tile_907 VDD VDD VSS VSS nw_out[14] gf180mcu_as_sc_mcu7t3v3__tiel_4
XFILLER_132_1539 VDD VDD VSS VSS gf180mcu_as_sc_mcu7t3v3__fill_1
Xmesh_tile_929 VDD VDD VSS VSS sw_out[2] gf180mcu_as_sc_mcu7t3v3__tiel_4
XFILLER_120_193 VDD VDD VSS VSS gf180mcu_as_sc_mcu7t3v3__fillcap_4
XFILLER_66_247 VDD VDD VSS VSS gf180mcu_as_sc_mcu7t3v3__fillcap_4
XTAP_TAPCELL_ROW_163_1832 VDD VSS gf180mcu_as_sc_mcu7t3v3__tap_2
XFILLER_19_174 VDD VDD VSS VSS gf180mcu_as_sc_mcu7t3v3__fillcap_16
XTAP_TAPCELL_ROW_163_1843 VDD VSS gf180mcu_as_sc_mcu7t3v3__tap_2
XFILLER_165_1348 VDD VDD VSS VSS gf180mcu_as_sc_mcu7t3v3__fillcap_16
XFILLER_34_155 VDD VDD VSS VSS gf180mcu_as_sc_mcu7t3v3__fillcap_16
XFILLER_34_177 VDD VDD VSS VSS gf180mcu_as_sc_mcu7t3v3__fillcap_16
XFILLER_96_2 VDD VDD VSS VSS gf180mcu_as_sc_mcu7t3v3__fillcap_8
X_2953_ VDD VDD VSS VSS _4915_/Q _3178_/D _3150_/B _3926_/A _2954_/D gf180mcu_as_sc_mcu7t3v3__ao22_2
XFILLER_52_1518 VDD VDD VSS VSS gf180mcu_as_sc_mcu7t3v3__fillcap_16
XTAP_TAPCELL_ROW_9_1_672 VDD VSS gf180mcu_as_sc_mcu7t3v3__tap_2
XFILLER_148_558 VDD VDD VSS VSS gf180mcu_as_sc_mcu7t3v3__fillcap_16
X_2884_ VDD VDD VSS VSS _4763_/Q _2884_/B _4770_/Q _4770_/D gf180mcu_as_sc_mcu7t3v3__mux2_2
XFILLER_135_208 VDD VDD VSS VSS gf180mcu_as_sc_mcu7t3v3__fill_2
XFILLER_159_1108 VDD VDD VSS VSS gf180mcu_as_sc_mcu7t3v3__fill_1
X_4623_ VDD VDD VSS VSS _5217_/Q _4623_/B _4623_/C _5218_/Q _5217_/D gf180mcu_as_sc_mcu7t3v3__ao22_2
XFILLER_135_219 VDD VDD VSS VSS gf180mcu_as_sc_mcu7t3v3__fill_2
XFILLER_144_731 VDD VDD VSS VSS gf180mcu_as_sc_mcu7t3v3__fillcap_4
X_4554_ VDD VDD VSS VSS _5185_/Q _4575_/B _4566_/C _5103_/Q _4555_/B gf180mcu_as_sc_mcu7t3v3__ao22_2
XTAP_TAPCELL_ROW_42_1_805 VDD VSS gf180mcu_as_sc_mcu7t3v3__tap_2
XFILLER_144_753 VDD VDD VSS VSS gf180mcu_as_sc_mcu7t3v3__fillcap_16
X_3505_ VDD VDD VSS VSS _3505_/S _3505_/B _4164_/A _3506_/B gf180mcu_as_sc_mcu7t3v3__mux2_2
X_4485_ VDD VDD VSS VSS _4572_/A _4485_/B _4485_/C _4486_/D _4589_/A gf180mcu_as_sc_mcu7t3v3__aoi211_2
X_3436_ VDD VDD VSS VSS _4085_/A _3452_/S _3453_/B _4086_/A _3437_/D gf180mcu_as_sc_mcu7t3v3__ao22_2
XFILLER_106_37 VDD VDD VSS VSS gf180mcu_as_sc_mcu7t3v3__fill_1
XFILLER_135_1152 VDD VDD VSS VSS gf180mcu_as_sc_mcu7t3v3__fillcap_8
XPHY_EDGE_ROW_39_1_Right_38 VDD VSS gf180mcu_as_sc_mcu7t3v3__tap_2
X_3367_ VDD VDD VSS VSS _3424_/B _3367_/B _3367_/C _3368_/C gf180mcu_as_sc_mcu7t3v3__nor3_2
XFILLER_140_992 VDD VDD VSS VSS gf180mcu_as_sc_mcu7t3v3__fillcap_8
X_5106_ VDD VDD VSS VSS _5186_/CLK _5106_/D _5106_/Q gf180mcu_as_sc_mcu7t3v3__dfxtp_2
X_5037_ VDD VDD VSS VSS _5074_/CLK _5037_/D _5037_/Q gf180mcu_as_sc_mcu7t3v3__dfxtp_2
X_3298_ VDD VDD VSS VSS _3947_/D _3500_/B _3501_/C _3951_/A _3299_/D gf180mcu_as_sc_mcu7t3v3__ao22_2
XTAP_TAPCELL_ROW_65_1_895 VDD VSS gf180mcu_as_sc_mcu7t3v3__tap_2
XFILLER_113_1483 VDD VDD VSS VSS gf180mcu_as_sc_mcu7t3v3__fillcap_16
XFILLER_96_1467 VDD VDD VSS VSS gf180mcu_as_sc_mcu7t3v3__fillcap_16
XFILLER_15_34 VDD VDD VSS VSS gf180mcu_as_sc_mcu7t3v3__fillcap_16
XFILLER_146_1270 VDD VDD VSS VSS gf180mcu_as_sc_mcu7t3v3__fill_2
XFILLER_146_1292 VDD VDD VSS VSS gf180mcu_as_sc_mcu7t3v3__fill_2
XFILLER_181_1161 VDD VDD VSS VSS gf180mcu_as_sc_mcu7t3v3__fill_2
XFILLER_166_311 VDD VDD VSS VSS gf180mcu_as_sc_mcu7t3v3__fillcap_4
XFILLER_166_333 VDD VDD VSS VSS gf180mcu_as_sc_mcu7t3v3__fillcap_16
XFILLER_178_171 VDD VDD VSS VSS gf180mcu_as_sc_mcu7t3v3__fillcap_4
XFILLER_178_193 VDD VDD VSS VSS gf180mcu_as_sc_mcu7t3v3__fillcap_16
XFILLER_167_889 VDD VDD VSS VSS gf180mcu_as_sc_mcu7t3v3__fillcap_16
XFILLER_182_826 VDD VDD VSS VSS gf180mcu_as_sc_mcu7t3v3__fillcap_16
XFILLER_33_1451 VDD VDD VSS VSS gf180mcu_as_sc_mcu7t3v3__fillcap_16
XPHY_EDGE_ROW_124_1_Left_576 VDD VSS gf180mcu_as_sc_mcu7t3v3__tap_2
XFILLER_181_314 VDD VDD VSS VSS gf180mcu_as_sc_mcu7t3v3__fillcap_16
XFILLER_31_66 VDD VDD VSS VSS gf180mcu_as_sc_mcu7t3v3__fillcap_4
XFILLER_31_88 VDD VDD VSS VSS gf180mcu_as_sc_mcu7t3v3__fillcap_16
XFILLER_134_252 VDD VDD VSS VSS gf180mcu_as_sc_mcu7t3v3__fill_2
XFILLER_134_274 VDD VDD VSS VSS gf180mcu_as_sc_mcu7t3v3__fillcap_4
XFILLER_147_88 VDD VDD VSS VSS gf180mcu_as_sc_mcu7t3v3__fillcap_16
XFILLER_150_723 VDD VDD VSS VSS gf180mcu_as_sc_mcu7t3v3__fillcap_8
XFILLER_162_561 VDD VDD VSS VSS gf180mcu_as_sc_mcu7t3v3__fillcap_16
XPHY_EDGE_ROW_61_1_Left_513 VDD VSS gf180mcu_as_sc_mcu7t3v3__tap_2
XFILLER_155_1539 VDD VDD VSS VSS gf180mcu_as_sc_mcu7t3v3__fill_1
XFILLER_162_594 VDD VDD VSS VSS gf180mcu_as_sc_mcu7t3v3__fill_1
Xinput100 VDD VDD VSS VSS ne_in[2] _3947_/A gf180mcu_as_sc_mcu7t3v3__buff_2
Xinput111 VDD VDD VSS VSS ne_in[9] _4008_/D gf180mcu_as_sc_mcu7t3v3__buff_2
XFILLER_0_276 VDD VDD VSS VSS gf180mcu_as_sc_mcu7t3v3__fill_1
XFILLER_153_1274 VDD VDD VSS VSS gf180mcu_as_sc_mcu7t3v3__fill_1
Xinput122 VDD VDD VSS VSS north_in[19] _4087_/A gf180mcu_as_sc_mcu7t3v3__buff_2
Xinput133 VDD VDD VSS VSS north_in[29] _3790_/A gf180mcu_as_sc_mcu7t3v3__buff_2
Xinput144 VDD VDD VSS VSS north_in[8] _3999_/A gf180mcu_as_sc_mcu7t3v3__buff_2
XFILLER_102_193 VDD VDD VSS VSS gf180mcu_as_sc_mcu7t3v3__fillcap_4
XFILLER_48_247 VDD VDD VSS VSS gf180mcu_as_sc_mcu7t3v3__fillcap_8
Xinput155 VDD VDD VSS VSS nw_in[18] _4078_/A gf180mcu_as_sc_mcu7t3v3__buff_2
Xinput166 VDD VDD VSS VSS nw_in[28] _4162_/A gf180mcu_as_sc_mcu7t3v3__buff_2
Xinput177 VDD VDD VSS VSS nw_in[7] _3992_/A gf180mcu_as_sc_mcu7t3v3__buff_2
Xinput188 VDD VDD VSS VSS se_in[16] _4066_/A gf180mcu_as_sc_mcu7t3v3__buff_2
Xinput199 VDD VDD VSS VSS se_in[26] _4147_/A gf180mcu_as_sc_mcu7t3v3__buff_2
XFILLER_56_96 VDD VDD VSS VSS gf180mcu_as_sc_mcu7t3v3__fill_2
XFILLER_63_239 VDD VDD VSS VSS gf180mcu_as_sc_mcu7t3v3__fillcap_16
XFILLER_16_155 VDD VDD VSS VSS gf180mcu_as_sc_mcu7t3v3__fillcap_16
XFILLER_112_80 VDD VDD VSS VSS gf180mcu_as_sc_mcu7t3v3__fillcap_8
XFILLER_147_1067 VDD VDD VSS VSS gf180mcu_as_sc_mcu7t3v3__fillcap_4
XFILLER_16_177 VDD VDD VSS VSS gf180mcu_as_sc_mcu7t3v3__fillcap_16
XPHY_EDGE_ROW_85_1_Right_84 VDD VSS gf180mcu_as_sc_mcu7t3v3__tap_2
XFILLER_158_801 VDD VDD VSS VSS gf180mcu_as_sc_mcu7t3v3__fillcap_4
XFILLER_31_136 VDD VDD VSS VSS gf180mcu_as_sc_mcu7t3v3__fillcap_4
XFILLER_31_158 VDD VDD VSS VSS gf180mcu_as_sc_mcu7t3v3__fillcap_16
XFILLER_157_333 VDD VDD VSS VSS gf180mcu_as_sc_mcu7t3v3__fillcap_4
XTAP_TAPCELL_ROW_82_1_965 VDD VSS gf180mcu_as_sc_mcu7t3v3__tap_2
XTAP_TAPCELL_ROW_139_1322 VDD VSS gf180mcu_as_sc_mcu7t3v3__tap_2
XTAP_TAPCELL_ROW_139_1311 VDD VSS gf180mcu_as_sc_mcu7t3v3__tap_2
XFILLER_117_208 VDD VDD VSS VSS gf180mcu_as_sc_mcu7t3v3__fill_2
XFILLER_12_1502 VDD VDD VSS VSS gf180mcu_as_sc_mcu7t3v3__fillcap_16
XFILLER_160_1267 VDD VDD VSS VSS gf180mcu_as_sc_mcu7t3v3__fill_2
XFILLER_160_1289 VDD VDD VSS VSS gf180mcu_as_sc_mcu7t3v3__fillcap_4
XFILLER_173_859 VDD VDD VSS VSS gf180mcu_as_sc_mcu7t3v3__fill_2
XFILLER_184_163 VDD VDD VSS VSS gf180mcu_as_sc_mcu7t3v3__fill_2
XFILLER_184_185 VDD VDD VSS VSS gf180mcu_as_sc_mcu7t3v3__fillcap_16
XTAP_TAPCELL_ROW_156_1680 VDD VSS gf180mcu_as_sc_mcu7t3v3__tap_2
XTAP_TAPCELL_ROW_135_1219 VDD VSS gf180mcu_as_sc_mcu7t3v3__tap_2
XFILLER_12_1568 VDD VDD VSS VSS gf180mcu_as_sc_mcu7t3v3__fill_1
XFILLER_138_591 VDD VDD VSS VSS gf180mcu_as_sc_mcu7t3v3__fillcap_4
XTAP_TAPCELL_ROW_156_1691 VDD VSS gf180mcu_as_sc_mcu7t3v3__tap_2
XFILLER_125_241 VDD VDD VSS VSS gf180mcu_as_sc_mcu7t3v3__fillcap_8
XFILLER_158_1152 VDD VDD VSS VSS gf180mcu_as_sc_mcu7t3v3__fill_2
XFILLER_181_892 VDD VDD VSS VSS gf180mcu_as_sc_mcu7t3v3__fill_2
XFILLER_158_1185 VDD VDD VSS VSS gf180mcu_as_sc_mcu7t3v3__fill_1
X_4270_ VDD VDD VSS VSS _4273_/S _5482_/A _5104_/Q _5104_/D gf180mcu_as_sc_mcu7t3v3__mux2_2
XTAP_TAPCELL_ROW_152_1599 VDD VSS gf180mcu_as_sc_mcu7t3v3__tap_2
X_3221_ VDD VDD VSS VSS _3558_/B _3243_/A _3241_/C gf180mcu_as_sc_mcu7t3v3__and2_2
XFILLER_39_203 VDD VDD VSS VSS gf180mcu_as_sc_mcu7t3v3__fillcap_4
Xclkbuf_leaf_17_clk_regs VDD VDD VSS VSS clkbuf_3_3_0_clk_regs/Y _4943_/CLK gf180mcu_as_sc_mcu7t3v3__clkbuff_12
X_3152_ VDD VDD VSS VSS _4129_/A _3152_/B _3152_/C _4128_/A _3153_/C gf180mcu_as_sc_mcu7t3v3__ao22_2
XFILLER_11_2 VDD VDD VSS VSS gf180mcu_as_sc_mcu7t3v3__fillcap_16
X_3083_ VDD VDD VSS VSS _3143_/S _4065_/A _4063_/A _3085_/B gf180mcu_as_sc_mcu7t3v3__mux2_2
XFILLER_169_1292 VDD VDD VSS VSS gf180mcu_as_sc_mcu7t3v3__fillcap_8
XFILLER_62_261 VDD VDD VSS VSS gf180mcu_as_sc_mcu7t3v3__fill_1
XFILLER_143_1410 VDD VDD VSS VSS gf180mcu_as_sc_mcu7t3v3__fill_2
XFILLER_182_1470 VDD VDD VSS VSS gf180mcu_as_sc_mcu7t3v3__fillcap_8
XFILLER_56_1451 VDD VDD VSS VSS gf180mcu_as_sc_mcu7t3v3__fillcap_16
X_3985_ VDD VDD VSS VSS _3985_/A _4105_/B _3985_/C _3985_/D _3986_/B gf180mcu_as_sc_mcu7t3v3__ao211_2
X_2936_ VDD VDD VSS VSS _3528_/B _3528_/A _3281_/B gf180mcu_as_sc_mcu7t3v3__and2_2
XFILLER_164_815 VDD VDD VSS VSS gf180mcu_as_sc_mcu7t3v3__fill_1
X_2867_ VDD VDD VSS VSS _2868_/B _4765_/Q _2870_/B gf180mcu_as_sc_mcu7t3v3__and2_2
XFILLER_175_174 VDD VDD VSS VSS gf180mcu_as_sc_mcu7t3v3__fillcap_16
XFILLER_178_1539 VDD VDD VSS VSS gf180mcu_as_sc_mcu7t3v3__fillcap_16
X_4606_ VDD VDD VSS VSS _5200_/Q _4612_/B _4607_/C _5201_/Q _5200_/D gf180mcu_as_sc_mcu7t3v3__ao22_2
XFILLER_151_509 VDD VDD VSS VSS gf180mcu_as_sc_mcu7t3v3__fillcap_16
XFILLER_163_358 VDD VDD VSS VSS gf180mcu_as_sc_mcu7t3v3__fill_1
X_2798_ VDD VDD VSS VSS _2799_/C _2798_/B _2845_/D gf180mcu_as_sc_mcu7t3v3__nor2_2
XFILLER_116_263 VDD VDD VSS VSS gf180mcu_as_sc_mcu7t3v3__fillcap_4
XFILLER_89_103 VDD VDD VSS VSS gf180mcu_as_sc_mcu7t3v3__fillcap_16
X_4537_ VDD VDD VSS VSS _4538_/B _4537_/A gf180mcu_as_sc_mcu7t3v3__inv_2
XFILLER_117_69 VDD VDD VSS VSS gf180mcu_as_sc_mcu7t3v3__fill_1
XFILLER_144_594 VDD VDD VSS VSS gf180mcu_as_sc_mcu7t3v3__fill_1
XFILLER_77_18 VDD VDD VSS VSS gf180mcu_as_sc_mcu7t3v3__fillcap_16
X_4468_ VDD VDD VSS VSS _4468_/B _4591_/A _4469_/D gf180mcu_as_sc_mcu7t3v3__and2_2
XFILLER_28_1564 VDD VDD VSS VSS gf180mcu_as_sc_mcu7t3v3__fillcap_4
Xfanout801 VDD VDD VSS VSS _3573_/D _3805_/C gf180mcu_as_sc_mcu7t3v3__buff_2
X_3419_ VDD VDD VSS VSS _3442_/B _4072_/A _3420_/D gf180mcu_as_sc_mcu7t3v3__or2_2
XFILLER_131_299 VDD VDD VSS VSS gf180mcu_as_sc_mcu7t3v3__fill_2
X_4399_ VDD VDD VSS VSS _5168_/Q _4470_/B _4493_/C _5118_/Q _4400_/B gf180mcu_as_sc_mcu7t3v3__ao22_2
XFILLER_133_46 VDD VDD VSS VSS gf180mcu_as_sc_mcu7t3v3__fill_2
XFILLER_63_1499 VDD VDD VSS VSS gf180mcu_as_sc_mcu7t3v3__fillcap_16
XFILLER_98_1518 VDD VDD VSS VSS gf180mcu_as_sc_mcu7t3v3__fillcap_16
Xhold1010 VDD VDD VSS VSS hold1042/Y _4964_/D gf180mcu_as_sc_mcu7t3v3__buff_2
Xhold1021 VDD VDD VSS VSS hold1056/Y _4967_/D gf180mcu_as_sc_mcu7t3v3__buff_2
Xhold1032 VDD VDD VSS VSS _4762_/Q _4741_/C gf180mcu_as_sc_mcu7t3v3__buff_2
XFILLER_133_68 VDD VDD VSS VSS gf180mcu_as_sc_mcu7t3v3__fill_2
Xhold1043 VDD VDD VSS VSS _4971_/Q hold1043/Y gf180mcu_as_sc_mcu7t3v3__buff_2
Xhold1054 VDD VDD VSS VSS _4973_/Q hold1054/Y gf180mcu_as_sc_mcu7t3v3__buff_2
XFILLER_45_228 VDD VDD VSS VSS gf180mcu_as_sc_mcu7t3v3__fillcap_16
XFILLER_148_1321 VDD VDD VSS VSS gf180mcu_as_sc_mcu7t3v3__fillcap_4
XFILLER_148_1343 VDD VDD VSS VSS gf180mcu_as_sc_mcu7t3v3__fill_1
XFILLER_183_1212 VDD VDD VSS VSS gf180mcu_as_sc_mcu7t3v3__fillcap_4
XFILLER_60_209 VDD VDD VSS VSS gf180mcu_as_sc_mcu7t3v3__fillcap_8
XFILLER_183_1256 VDD VDD VSS VSS gf180mcu_as_sc_mcu7t3v3__fillcap_4
XFILLER_13_136 VDD VDD VSS VSS gf180mcu_as_sc_mcu7t3v3__fillcap_4
XFILLER_13_158 VDD VDD VSS VSS gf180mcu_as_sc_mcu7t3v3__fillcap_16
XFILLER_158_32 VDD VDD VSS VSS gf180mcu_as_sc_mcu7t3v3__fill_2
XTAP_TAPCELL_ROW_70_1_914 VDD VSS gf180mcu_as_sc_mcu7t3v3__tap_2
XFILLER_158_65 VDD VDD VSS VSS gf180mcu_as_sc_mcu7t3v3__fillcap_16
XFILLER_142_509 VDD VDD VSS VSS gf180mcu_as_sc_mcu7t3v3__fillcap_16
XFILLER_182_645 VDD VDD VSS VSS gf180mcu_as_sc_mcu7t3v3__fill_2
XFILLER_182_667 VDD VDD VSS VSS gf180mcu_as_sc_mcu7t3v3__fillcap_8
XFILLER_159_1472 VDD VDD VSS VSS gf180mcu_as_sc_mcu7t3v3__fillcap_8
XFILLER_150_531 VDD VDD VSS VSS gf180mcu_as_sc_mcu7t3v3__fill_1
XFILLER_174_53 VDD VDD VSS VSS gf180mcu_as_sc_mcu7t3v3__fillcap_16
XFILLER_122_255 VDD VDD VSS VSS gf180mcu_as_sc_mcu7t3v3__fill_1
XFILLER_107_80 VDD VDD VSS VSS gf180mcu_as_sc_mcu7t3v3__fillcap_8
XFILLER_122_299 VDD VDD VSS VSS gf180mcu_as_sc_mcu7t3v3__fill_2
XFILLER_150_597 VDD VDD VSS VSS gf180mcu_as_sc_mcu7t3v3__fillcap_4
XFILLER_153_1060 VDD VDD VSS VSS gf180mcu_as_sc_mcu7t3v3__fill_2
XFILLER_95_117 VDD VDD VSS VSS gf180mcu_as_sc_mcu7t3v3__fill_2
XFILLER_79_1451 VDD VDD VSS VSS gf180mcu_as_sc_mcu7t3v3__fillcap_16
X_3770_ VDD VDD VSS VSS _4942_/Q _3799_/B _3770_/C _4152_/A _3771_/D gf180mcu_as_sc_mcu7t3v3__ao22_2
XTAP_TAPCELL_ROW_158_1731 VDD VSS gf180mcu_as_sc_mcu7t3v3__tap_2
XFILLER_158_653 VDD VDD VSS VSS gf180mcu_as_sc_mcu7t3v3__fill_1
XFILLER_158_675 VDD VDD VSS VSS gf180mcu_as_sc_mcu7t3v3__fillcap_4
X_2721_ VDD VDD VSS VSS _2735_/A _2721_/B _2721_/C _2735_/D _2723_/C gf180mcu_as_sc_mcu7t3v3__ao211_2
XTAP_TAPCELL_ROW_56_1_859 VDD VSS gf180mcu_as_sc_mcu7t3v3__tap_2
XTAP_TAPCELL_ROW_158_1742 VDD VSS gf180mcu_as_sc_mcu7t3v3__tap_2
XFILLER_145_303 VDD VDD VSS VSS gf180mcu_as_sc_mcu7t3v3__fillcap_4
XFILLER_157_174 VDD VDD VSS VSS gf180mcu_as_sc_mcu7t3v3__fillcap_16
XTAP_TAPCELL_ROW_154_1639 VDD VSS gf180mcu_as_sc_mcu7t3v3__tap_2
XFILLER_145_358 VDD VDD VSS VSS gf180mcu_as_sc_mcu7t3v3__fill_1
X_2652_ VDD VDD VSS VSS _2658_/S _5260_/Q _5248_/Q _2653_/B gf180mcu_as_sc_mcu7t3v3__mux2_2
XFILLER_160_306 VDD VDD VSS VSS gf180mcu_as_sc_mcu7t3v3__fill_2
XFILLER_172_155 VDD VDD VSS VSS gf180mcu_as_sc_mcu7t3v3__fillcap_16
XFILLER_172_177 VDD VDD VSS VSS gf180mcu_as_sc_mcu7t3v3__fillcap_16
XFILLER_173_678 VDD VDD VSS VSS gf180mcu_as_sc_mcu7t3v3__fillcap_8
Xoutput404 VDD VDD VSS VSS _4806_/Q south_out[1] gf180mcu_as_sc_mcu7t3v3__buff_2
Xoutput415 VDD VDD VSS VSS _4807_/Q south_out[2] gf180mcu_as_sc_mcu7t3v3__buff_2
Xoutput426 VDD VDD VSS VSS _4814_/Q south_out[9] gf180mcu_as_sc_mcu7t3v3__buff_2
X_2583_ VDD VDD VSS VSS _2709_/A _2583_/B _2583_/C _2583_/D _3906_/B gf180mcu_as_sc_mcu7t3v3__ao22_2
Xoutput437 VDD VDD VSS VSS _4892_/Q west_out[19] gf180mcu_as_sc_mcu7t3v3__buff_2
Xoutput448 VDD VDD VSS VSS _4902_/Q west_out[29] gf180mcu_as_sc_mcu7t3v3__buff_2
Xoutput459 VDD VDD VSS VSS _4881_/Q west_out[8] gf180mcu_as_sc_mcu7t3v3__buff_2
X_4322_ VDD VDD VSS VSS _4325_/S _5152_/Q _5151_/Q _5151_/D gf180mcu_as_sc_mcu7t3v3__mux2_2
XFILLER_113_244 VDD VDD VSS VSS gf180mcu_as_sc_mcu7t3v3__fillcap_8
XFILLER_141_542 VDD VDD VSS VSS gf180mcu_as_sc_mcu7t3v3__fillcap_8
XFILLER_173_1458 VDD VDD VSS VSS gf180mcu_as_sc_mcu7t3v3__fillcap_4
XFILLER_173_1469 VDD VDD VSS VSS gf180mcu_as_sc_mcu7t3v3__fill_1
X_4253_ VDD VDD VSS VSS _4257_/S _4253_/B _5089_/Q _5089_/D gf180mcu_as_sc_mcu7t3v3__mux2_2
X_3204_ VDD VDD VSS VSS _3228_/A _3227_/S _3216_/B _3204_/C gf180mcu_as_sc_mcu7t3v3__ao21_2
X_4184_ VDD VDD VSS VSS _4244_/B _4188_/B _4188_/C _5022_/Q _5022_/D gf180mcu_as_sc_mcu7t3v3__ao22_2
XFILLER_27_206 VDD VDD VSS VSS gf180mcu_as_sc_mcu7t3v3__fillcap_4
X_3135_ VDD VDD VSS VSS _4112_/A _3152_/B _3152_/C _4111_/A _3136_/C gf180mcu_as_sc_mcu7t3v3__ao22_2
XFILLER_103_16 VDD VDD VSS VSS gf180mcu_as_sc_mcu7t3v3__fill_1
XFILLER_103_27 VDD VDD VSS VSS gf180mcu_as_sc_mcu7t3v3__fillcap_8
XFILLER_23_1483 VDD VDD VSS VSS gf180mcu_as_sc_mcu7t3v3__fillcap_16
XFILLER_27_228 VDD VDD VSS VSS gf180mcu_as_sc_mcu7t3v3__fillcap_16
X_3066_ VDD VDD VSS VSS _4048_/A _3150_/B _3150_/C _4048_/D _3072_/B gf180mcu_as_sc_mcu7t3v3__ao22_2
XFILLER_184_1532 VDD VDD VSS VSS gf180mcu_as_sc_mcu7t3v3__fillcap_16
XFILLER_58_1502 VDD VDD VSS VSS gf180mcu_as_sc_mcu7t3v3__fillcap_16
XFILLER_110_1486 VDD VDD VSS VSS gf180mcu_as_sc_mcu7t3v3__fillcap_16
XFILLER_169_907 VDD VDD VSS VSS gf180mcu_as_sc_mcu7t3v3__fill_2
XFILLER_58_1568 VDD VDD VSS VSS gf180mcu_as_sc_mcu7t3v3__fill_1
XFILLER_145_1527 VDD VDD VSS VSS gf180mcu_as_sc_mcu7t3v3__fillcap_8
X_3968_ VDD VDD VSS VSS _3968_/A _4159_/B _4159_/C _3968_/D _3969_/D gf180mcu_as_sc_mcu7t3v3__ao22_2
XFILLER_10_139 VDD VDD VSS VSS gf180mcu_as_sc_mcu7t3v3__fillcap_16
XFILLER_143_1262 VDD VDD VSS VSS gf180mcu_as_sc_mcu7t3v3__fillcap_8
X_2919_ VDD VDD VSS VSS _3792_/A _3801_/A _3554_/A gf180mcu_as_sc_mcu7t3v3__or2_2
XFILLER_136_303 VDD VDD VSS VSS gf180mcu_as_sc_mcu7t3v3__fillcap_4
XFILLER_164_623 VDD VDD VSS VSS gf180mcu_as_sc_mcu7t3v3__fillcap_4
X_3899_ VDD VDD VSS VSS _3908_/B _5157_/Q _4939_/D gf180mcu_as_sc_mcu7t3v3__and2_2
XFILLER_164_667 VDD VDD VSS VSS gf180mcu_as_sc_mcu7t3v3__fillcap_8
XFILLER_151_306 VDD VDD VSS VSS gf180mcu_as_sc_mcu7t3v3__fill_1
XFILLER_152_818 VDD VDD VSS VSS gf180mcu_as_sc_mcu7t3v3__fillcap_16
XFILLER_144_391 VDD VDD VSS VSS gf180mcu_as_sc_mcu7t3v3__fill_2
XFILLER_104_244 VDD VDD VSS VSS gf180mcu_as_sc_mcu7t3v3__fill_1
XFILLER_176_1093 VDD VDD VSS VSS gf180mcu_as_sc_mcu7t3v3__fillcap_16
XFILLER_144_34 VDD VDD VSS VSS gf180mcu_as_sc_mcu7t3v3__fill_1
Xfanout620 VDD VDD VSS VSS fanout622/Y _3451_/B gf180mcu_as_sc_mcu7t3v3__buff_2
Xfanout631 VDD VDD VSS VSS _2930_/Y fanout631/Y gf180mcu_as_sc_mcu7t3v3__buff_2
Xfanout642 VDD VDD VSS VSS _4605_/B _4612_/B gf180mcu_as_sc_mcu7t3v3__buff_2
XTAP_TAPCELL_ROW_73_1_929 VDD VSS gf180mcu_as_sc_mcu7t3v3__tap_2
XFILLER_104_299 VDD VDD VSS VSS gf180mcu_as_sc_mcu7t3v3__fill_2
XFILLER_150_1233 VDD VDD VSS VSS gf180mcu_as_sc_mcu7t3v3__fill_1
Xfanout653 VDD VDD VSS VSS _3741_/C _3719_/C gf180mcu_as_sc_mcu7t3v3__buff_2
Xfanout664 VDD VDD VSS VSS fanout666/Y _4101_/C gf180mcu_as_sc_mcu7t3v3__buff_2
Xfanout675 VDD VDD VSS VSS _3928_/Y fanout675/Y gf180mcu_as_sc_mcu7t3v3__buff_2
XFILLER_150_1255 VDD VDD VSS VSS gf180mcu_as_sc_mcu7t3v3__fillcap_8
Xfanout686 VDD VDD VSS VSS _3268_/Y _3472_/C gf180mcu_as_sc_mcu7t3v3__buff_2
Xfanout697 VDD VDD VSS VSS _3728_/B _3736_/B gf180mcu_as_sc_mcu7t3v3__buff_2
XFILLER_150_1277 VDD VDD VSS VSS gf180mcu_as_sc_mcu7t3v3__fillcap_16
XTAP_TAPCELL_ROW_0_1_2342 VDD VSS gf180mcu_as_sc_mcu7t3v3__tap_2
XFILLER_148_1151 VDD VDD VSS VSS gf180mcu_as_sc_mcu7t3v3__fillcap_4
XFILLER_163_2 VDD VDD VSS VSS gf180mcu_as_sc_mcu7t3v3__fillcap_16
XFILLER_159_417 VDD VDD VSS VSS gf180mcu_as_sc_mcu7t3v3__fill_2
XTAP_TAPCELL_ROW_175_2097 VDD VSS gf180mcu_as_sc_mcu7t3v3__tap_2
XFILLER_167_494 VDD VDD VSS VSS gf180mcu_as_sc_mcu7t3v3__fill_1
XTAP_TAPCELL_ROW_52_1_843 VDD VSS gf180mcu_as_sc_mcu7t3v3__tap_2
XFILLER_154_155 VDD VDD VSS VSS gf180mcu_as_sc_mcu7t3v3__fillcap_16
XFILLER_154_177 VDD VDD VSS VSS gf180mcu_as_sc_mcu7t3v3__fillcap_16
XFILLER_170_626 VDD VDD VSS VSS gf180mcu_as_sc_mcu7t3v3__fill_1
XFILLER_136_881 VDD VDD VSS VSS gf180mcu_as_sc_mcu7t3v3__fillcap_8
XFILLER_155_1122 VDD VDD VSS VSS gf180mcu_as_sc_mcu7t3v3__fillcap_16
XFILLER_45_8 VDD VDD VSS VSS gf180mcu_as_sc_mcu7t3v3__fill_2
XFILLER_78_50 VDD VDD VSS VSS gf180mcu_as_sc_mcu7t3v3__fillcap_16
XFILLER_110_247 VDD VDD VSS VSS gf180mcu_as_sc_mcu7t3v3__fillcap_8
XFILLER_46_1483 VDD VDD VSS VSS gf180mcu_as_sc_mcu7t3v3__fill_1
XFILLER_76_183 VDD VDD VSS VSS gf180mcu_as_sc_mcu7t3v3__fillcap_16
XFILLER_94_60 VDD VDD VSS VSS gf180mcu_as_sc_mcu7t3v3__fillcap_4
XTAP_TAPCELL_ROW_147_1487 VDD VSS gf180mcu_as_sc_mcu7t3v3__tap_2
XFILLER_24_209 VDD VDD VSS VSS gf180mcu_as_sc_mcu7t3v3__fillcap_16
XFILLER_91_142 VDD VDD VSS VSS gf180mcu_as_sc_mcu7t3v3__fillcap_16
XTAP_TAPCELL_ROW_147_1498 VDD VSS gf180mcu_as_sc_mcu7t3v3__tap_2
X_4940_ VDD VDD VSS VSS _5173_/CLK _4940_/D _4940_/Q gf180mcu_as_sc_mcu7t3v3__dfxtp_2
X_4871_ VDD VDD VSS VSS _4914_/CLK _4871_/D _4871_/Q gf180mcu_as_sc_mcu7t3v3__dfxtp_2
XFILLER_162_1137 VDD VDD VSS VSS gf180mcu_as_sc_mcu7t3v3__fillcap_16
XFILLER_178_737 VDD VDD VSS VSS gf180mcu_as_sc_mcu7t3v3__fillcap_4
X_3822_ VDD VDD VSS VSS _3826_/B _4168_/A _4907_/Q gf180mcu_as_sc_mcu7t3v3__nor2b_2
XFILLER_92_1481 VDD VDD VSS VSS gf180mcu_as_sc_mcu7t3v3__fill_2
XTAP_TAPCELL_ROW_127_1_1142 VDD VSS gf180mcu_as_sc_mcu7t3v3__tap_2
XPHY_EDGE_ROW_48_1_Right_47 VDD VSS gf180mcu_as_sc_mcu7t3v3__tap_2
X_3753_ VDD VDD VSS VSS _4132_/A _3753_/B _3753_/C _4863_/D _3753_/D gf180mcu_as_sc_mcu7t3v3__aoi211_2
XPHY_EDGE_ROW_100_1_Right_99 VDD VSS gf180mcu_as_sc_mcu7t3v3__tap_2
X_3684_ VDD VDD VSS VSS _4854_/D _3684_/C _3731_/B _3684_/A gf180mcu_as_sc_mcu7t3v3__aoi21_2
X_2704_ VDD VDD VSS VSS _2711_/S _4960_/Q _4969_/Q _2706_/A gf180mcu_as_sc_mcu7t3v3__mux2_2
XTAP_TAPCELL_ROW_38_1_788 VDD VSS gf180mcu_as_sc_mcu7t3v3__tap_2
XFILLER_146_667 VDD VDD VSS VSS gf180mcu_as_sc_mcu7t3v3__fillcap_16
X_2635_ VDD VDD VSS VSS _2658_/S _2635_/B _5246_/Q _2636_/B gf180mcu_as_sc_mcu7t3v3__mux2_2
XFILLER_145_188 VDD VDD VSS VSS gf180mcu_as_sc_mcu7t3v3__fillcap_16
Xclkbuf_leaf_32_clk_regs VDD VDD VSS VSS clkbuf_3_4_0_clk_regs/Y _5085_/CLK gf180mcu_as_sc_mcu7t3v3__clkbuff_12
XTAP_TAPCELL_ROW_107_1_1062 VDD VSS gf180mcu_as_sc_mcu7t3v3__tap_2
XFILLER_142_840 VDD VDD VSS VSS gf180mcu_as_sc_mcu7t3v3__fill_2
XFILLER_142_873 VDD VDD VSS VSS gf180mcu_as_sc_mcu7t3v3__fill_2
XFILLER_99_231 VDD VDD VSS VSS gf180mcu_as_sc_mcu7t3v3__fillcap_16
X_4305_ VDD VDD VSS VSS _4305_/S _5135_/Q _5134_/Q _5134_/D gf180mcu_as_sc_mcu7t3v3__mux2_2
X_2566_ VDD VDD VSS VSS _4745_/B _5278_/Q _2858_/B gf180mcu_as_sc_mcu7t3v3__and2_2
XFILLER_64_1550 VDD VDD VSS VSS gf180mcu_as_sc_mcu7t3v3__fillcap_4
X_5285_ VDD VDD VSS VSS clkload2/A _5285_/D _5285_/Q gf180mcu_as_sc_mcu7t3v3__dfxtp_2
X_2497_ VDD VDD VSS VSS _4662_/C _5222_/Q _2747_/A gf180mcu_as_sc_mcu7t3v3__nor2_2
XFILLER_59_139 VDD VDD VSS VSS gf180mcu_as_sc_mcu7t3v3__fill_1
X_4236_ VDD VDD VSS VSS _4257_/S _4236_/B _5072_/Q _5072_/D gf180mcu_as_sc_mcu7t3v3__mux2_2
XFILLER_114_26 VDD VDD VSS VSS gf180mcu_as_sc_mcu7t3v3__fillcap_8
XFILLER_114_37 VDD VDD VSS VSS gf180mcu_as_sc_mcu7t3v3__fill_2
X_4167_ VDD VDD VSS VSS _4167_/Y _4908_/Q _4907_/Q gf180mcu_as_sc_mcu7t3v3__nor2b_2
XPHY_EDGE_ROW_133_1_Left_585 VDD VSS gf180mcu_as_sc_mcu7t3v3__tap_2
X_3118_ VDD VDD VSS VSS _3118_/S _4093_/D _4096_/A _3120_/B gf180mcu_as_sc_mcu7t3v3__mux2_2
X_4098_ VDD VDD VSS VSS _4099_/C _4098_/B _4098_/A gf180mcu_as_sc_mcu7t3v3__nor2_2
X_3049_ VDD VDD VSS VSS _4027_/A _3149_/B _3049_/C _4782_/D _3746_/D gf180mcu_as_sc_mcu7t3v3__aoi211_2
XFILLER_145_1313 VDD VDD VSS VSS gf180mcu_as_sc_mcu7t3v3__fillcap_16
XPHY_EDGE_ROW_70_1_Left_522 VDD VSS gf180mcu_as_sc_mcu7t3v3__tap_2
XFILLER_168_225 VDD VDD VSS VSS gf180mcu_as_sc_mcu7t3v3__fillcap_16
XFILLER_71_1521 VDD VDD VSS VSS gf180mcu_as_sc_mcu7t3v3__fillcap_16
XFILLER_168_247 VDD VDD VSS VSS gf180mcu_as_sc_mcu7t3v3__fillcap_16
XFILLER_180_1259 VDD VDD VSS VSS gf180mcu_as_sc_mcu7t3v3__fillcap_8
XFILLER_23_34 VDD VDD VSS VSS gf180mcu_as_sc_mcu7t3v3__fillcap_16
XFILLER_139_34 VDD VDD VSS VSS gf180mcu_as_sc_mcu7t3v3__fillcap_16
XFILLER_183_228 VDD VDD VSS VSS gf180mcu_as_sc_mcu7t3v3__fillcap_16
XFILLER_99_16 VDD VDD VSS VSS gf180mcu_as_sc_mcu7t3v3__fill_1
XFILLER_99_27 VDD VDD VSS VSS gf180mcu_as_sc_mcu7t3v3__fillcap_8
XFILLER_136_144 VDD VDD VSS VSS gf180mcu_as_sc_mcu7t3v3__fill_1
XFILLER_165_998 VDD VDD VSS VSS gf180mcu_as_sc_mcu7t3v3__fillcap_8
XFILLER_136_177 VDD VDD VSS VSS gf180mcu_as_sc_mcu7t3v3__fillcap_4
XFILLER_136_188 VDD VDD VSS VSS gf180mcu_as_sc_mcu7t3v3__fillcap_8
XFILLER_155_22 VDD VDD VSS VSS gf180mcu_as_sc_mcu7t3v3__fillcap_16
XFILLER_151_136 VDD VDD VSS VSS gf180mcu_as_sc_mcu7t3v3__fillcap_4
XFILLER_151_158 VDD VDD VSS VSS gf180mcu_as_sc_mcu7t3v3__fillcap_16
XFILLER_156_1431 VDD VDD VSS VSS gf180mcu_as_sc_mcu7t3v3__fillcap_4
XFILLER_69_1483 VDD VDD VSS VSS gf180mcu_as_sc_mcu7t3v3__fillcap_16
XFILLER_155_88 VDD VDD VSS VSS gf180mcu_as_sc_mcu7t3v3__fillcap_16
XPHY_EDGE_ROW_94_1_Right_93 VDD VSS gf180mcu_as_sc_mcu7t3v3__tap_2
XFILLER_48_86 VDD VDD VSS VSS gf180mcu_as_sc_mcu7t3v3__fillcap_4
Xfanout472 VDD VDD VSS VSS _4125_/B _4117_/B gf180mcu_as_sc_mcu7t3v3__buff_2
Xfanout483 VDD VDD VSS VSS fanout485/Y _4589_/A gf180mcu_as_sc_mcu7t3v3__buff_2
XFILLER_58_172 VDD VDD VSS VSS gf180mcu_as_sc_mcu7t3v3__fill_2
Xfanout494 VDD VDD VSS VSS _3803_/B _3802_/C gf180mcu_as_sc_mcu7t3v3__buff_2
XFILLER_73_142 VDD VDD VSS VSS gf180mcu_as_sc_mcu7t3v3__fillcap_4
XTAP_TAPCELL_ROW_142_1384 VDD VSS gf180mcu_as_sc_mcu7t3v3__tap_2
XTAP_TAPCELL_ROW_142_1373 VDD VSS gf180mcu_as_sc_mcu7t3v3__tap_2
XFILLER_163_1424 VDD VDD VSS VSS gf180mcu_as_sc_mcu7t3v3__fillcap_4
XTAP_TAPCELL_ROW_177_2159 VDD VSS gf180mcu_as_sc_mcu7t3v3__tap_2
XTAP_TAPCELL_ROW_177_2148 VDD VSS gf180mcu_as_sc_mcu7t3v3__tap_2
XFILLER_120_80 VDD VDD VSS VSS gf180mcu_as_sc_mcu7t3v3__fillcap_8
XFILLER_156_921 VDD VDD VSS VSS gf180mcu_as_sc_mcu7t3v3__fillcap_4
XFILLER_161_1192 VDD VDD VSS VSS gf180mcu_as_sc_mcu7t3v3__fillcap_16
XFILLER_127_144 VDD VDD VSS VSS gf180mcu_as_sc_mcu7t3v3__fill_1
XFILLER_171_946 VDD VDD VSS VSS gf180mcu_as_sc_mcu7t3v3__fill_2
X_2420_ VDD VDD VSS VSS _2650_/B _2420_/A gf180mcu_as_sc_mcu7t3v3__inv_2
XFILLER_48_1534 VDD VDD VSS VSS gf180mcu_as_sc_mcu7t3v3__fillcap_16
XTAP_TAPCELL_ROW_34_1_772 VDD VSS gf180mcu_as_sc_mcu7t3v3__tap_2
XFILLER_135_1537 VDD VDD VSS VSS gf180mcu_as_sc_mcu7t3v3__fill_2
XFILLER_151_670 VDD VDD VSS VSS gf180mcu_as_sc_mcu7t3v3__fillcap_16
XFILLER_48_1556 VDD VDD VSS VSS gf180mcu_as_sc_mcu7t3v3__fillcap_8
X_5070_ VDD VDD VSS VSS _5084_/CLK _5070_/D _5070_/Q gf180mcu_as_sc_mcu7t3v3__dfxtp_2
XTAP_TAPCELL_ROW_149_1538 VDD VSS gf180mcu_as_sc_mcu7t3v3__tap_2
XTAP_TAPCELL_ROW_149_1527 VDD VSS gf180mcu_as_sc_mcu7t3v3__tap_2
XFILLER_1_190 VDD VDD VSS VSS gf180mcu_as_sc_mcu7t3v3__fillcap_8
X_4021_ VDD VDD VSS VSS _4021_/A _4118_/B _4118_/C _4021_/D _4022_/D gf180mcu_as_sc_mcu7t3v3__ao22_2
XFILLER_168_1313 VDD VDD VSS VSS gf180mcu_as_sc_mcu7t3v3__fillcap_8
XFILLER_0_1514 VDD VDD VSS VSS gf180mcu_as_sc_mcu7t3v3__fill_2
XFILLER_20_1486 VDD VDD VSS VSS gf180mcu_as_sc_mcu7t3v3__fillcap_16
X_4923_ VDD VDD VSS VSS _5088_/CLK _4923_/D _4923_/Q gf180mcu_as_sc_mcu7t3v3__dfxtp_2
XFILLER_181_1535 VDD VDD VSS VSS gf180mcu_as_sc_mcu7t3v3__fillcap_4
X_4854_ VDD VDD VSS VSS _4858_/CLK _4854_/D _4854_/Q gf180mcu_as_sc_mcu7t3v3__dfxtp_2
XFILLER_165_206 VDD VDD VSS VSS gf180mcu_as_sc_mcu7t3v3__fillcap_4
XFILLER_178_589 VDD VDD VSS VSS gf180mcu_as_sc_mcu7t3v3__fillcap_4
X_4785_ VDD VDD VSS VSS _4869_/CLK _4785_/D _4785_/Q gf180mcu_as_sc_mcu7t3v3__dfxtp_2
X_3805_ VDD VDD VSS VSS _4872_/D _3805_/C _3805_/B _3805_/A gf180mcu_as_sc_mcu7t3v3__aoi21b_2
XFILLER_165_239 VDD VDD VSS VSS gf180mcu_as_sc_mcu7t3v3__fillcap_16
XFILLER_179_1420 VDD VDD VSS VSS gf180mcu_as_sc_mcu7t3v3__fillcap_8
X_3736_ VDD VDD VSS VSS _3736_/D _4109_/A _3736_/B _3800_/C _3737_/C gf180mcu_as_sc_mcu7t3v3__ao31_2
XFILLER_109_37 VDD VDD VSS VSS gf180mcu_as_sc_mcu7t3v3__fill_1
XFILLER_147_998 VDD VDD VSS VSS gf180mcu_as_sc_mcu7t3v3__fillcap_4
XFILLER_174_784 VDD VDD VSS VSS gf180mcu_as_sc_mcu7t3v3__fillcap_4
XFILLER_180_209 VDD VDD VSS VSS gf180mcu_as_sc_mcu7t3v3__fillcap_16
XFILLER_118_177 VDD VDD VSS VSS gf180mcu_as_sc_mcu7t3v3__fillcap_4
XFILLER_134_648 VDD VDD VSS VSS gf180mcu_as_sc_mcu7t3v3__fillcap_8
XFILLER_161_434 VDD VDD VSS VSS gf180mcu_as_sc_mcu7t3v3__fill_2
X_3667_ VDD VDD VSS VSS _3668_/C _3667_/C _3745_/B _4041_/A gf180mcu_as_sc_mcu7t3v3__aoi21_2
XFILLER_161_467 VDD VDD VSS VSS gf180mcu_as_sc_mcu7t3v3__fill_1
X_3598_ VDD VDD VSS VSS _3599_/C _3965_/A _3750_/C _3598_/C gf180mcu_as_sc_mcu7t3v3__ao21_2
X_2618_ VDD VDD VSS VSS _2621_/B _2883_/B _4655_/B _2619_/C _2658_/S gf180mcu_as_sc_mcu7t3v3__oai211_2
XFILLER_138_1161 VDD VDD VSS VSS gf180mcu_as_sc_mcu7t3v3__fill_2
XFILLER_142_681 VDD VDD VSS VSS gf180mcu_as_sc_mcu7t3v3__fill_1
XFILLER_173_1052 VDD VDD VSS VSS gf180mcu_as_sc_mcu7t3v3__fillcap_4
X_2549_ VDD VDD VSS VSS _4705_/A _4746_/A _2845_/D gf180mcu_as_sc_mcu7t3v3__nand2_2
X_5268_ VDD VDD VSS VSS clkload4/A _5268_/D _5268_/Q gf180mcu_as_sc_mcu7t3v3__dfxtp_2
XFILLER_151_1350 VDD VDD VSS VSS gf180mcu_as_sc_mcu7t3v3__fillcap_4
XFILLER_173_1096 VDD VDD VSS VSS gf180mcu_as_sc_mcu7t3v3__fillcap_8
X_4219_ VDD VDD VSS VSS _4248_/B _4219_/B _4219_/C _5055_/Q _5055_/D gf180mcu_as_sc_mcu7t3v3__ao22_2
XFILLER_18_34 VDD VDD VSS VSS gf180mcu_as_sc_mcu7t3v3__fill_1
X_5199_ VDD VDD VSS VSS _5199_/CLK _5199_/D _5199_/Q gf180mcu_as_sc_mcu7t3v3__dfxtp_2
XTAP_TAPCELL_ROW_43_1_807 VDD VSS gf180mcu_as_sc_mcu7t3v3__tap_2
XFILLER_55_142 VDD VDD VSS VSS gf180mcu_as_sc_mcu7t3v3__fill_2
XFILLER_70_134 VDD VDD VSS VSS gf180mcu_as_sc_mcu7t3v3__fillcap_8
XFILLER_169_523 VDD VDD VSS VSS gf180mcu_as_sc_mcu7t3v3__fill_1
XFILLER_169_534 VDD VDD VSS VSS gf180mcu_as_sc_mcu7t3v3__fillcap_4
XFILLER_70_156 VDD VDD VSS VSS gf180mcu_as_sc_mcu7t3v3__fillcap_16
XFILLER_11_212 VDD VDD VSS VSS gf180mcu_as_sc_mcu7t3v3__fillcap_16
XFILLER_145_1165 VDD VDD VSS VSS gf180mcu_as_sc_mcu7t3v3__fillcap_16
XFILLER_180_1045 VDD VDD VSS VSS gf180mcu_as_sc_mcu7t3v3__fillcap_8
XFILLER_141_1029 VDD VDD VSS VSS gf180mcu_as_sc_mcu7t3v3__fillcap_4
XFILLER_169_578 VDD VDD VSS VSS gf180mcu_as_sc_mcu7t3v3__fillcap_4
XFILLER_169_589 VDD VDD VSS VSS gf180mcu_as_sc_mcu7t3v3__fillcap_16
XFILLER_126_2 VDD VDD VSS VSS gf180mcu_as_sc_mcu7t3v3__fillcap_8
XFILLER_50_10 VDD VDD VSS VSS gf180mcu_as_sc_mcu7t3v3__fill_1
XTAP_TAPCELL_ROW_172_2045 VDD VSS gf180mcu_as_sc_mcu7t3v3__tap_2
XTAP_TAPCELL_ROW_172_2034 VDD VSS gf180mcu_as_sc_mcu7t3v3__tap_2
XFILLER_109_144 VDD VDD VSS VSS gf180mcu_as_sc_mcu7t3v3__fill_1
XFILLER_153_924 VDD VDD VSS VSS gf180mcu_as_sc_mcu7t3v3__fill_2
XFILLER_50_43 VDD VDD VSS VSS gf180mcu_as_sc_mcu7t3v3__fill_1
XFILLER_109_188 VDD VDD VSS VSS gf180mcu_as_sc_mcu7t3v3__fillcap_16
XFILLER_153_946 VDD VDD VSS VSS gf180mcu_as_sc_mcu7t3v3__fill_2
XFILLER_50_87 VDD VDD VSS VSS gf180mcu_as_sc_mcu7t3v3__fillcap_16
XFILLER_180_787 VDD VDD VSS VSS gf180mcu_as_sc_mcu7t3v3__fill_1
XFILLER_152_1147 VDD VDD VSS VSS gf180mcu_as_sc_mcu7t3v3__fillcap_8
XFILLER_182_97 VDD VDD VSS VSS gf180mcu_as_sc_mcu7t3v3__fillcap_8
XFILLER_59_96 VDD VDD VSS VSS gf180mcu_as_sc_mcu7t3v3__fillcap_4
XFILLER_130_1467 VDD VDD VSS VSS gf180mcu_as_sc_mcu7t3v3__fillcap_16
XFILLER_46_142 VDD VDD VSS VSS gf180mcu_as_sc_mcu7t3v3__fill_2
XTAP_TAPCELL_ROW_144_1435 VDD VSS gf180mcu_as_sc_mcu7t3v3__tap_2
XTAP_TAPCELL_ROW_144_1424 VDD VSS gf180mcu_as_sc_mcu7t3v3__tap_2
XFILLER_61_134 VDD VDD VSS VSS gf180mcu_as_sc_mcu7t3v3__fillcap_4
XTAP_TAPCELL_ROW_161_1793 VDD VSS gf180mcu_as_sc_mcu7t3v3__tap_2
XFILLER_91_72 VDD VDD VSS VSS gf180mcu_as_sc_mcu7t3v3__fillcap_16
XFILLER_148_729 VDD VDD VSS VSS gf180mcu_as_sc_mcu7t3v3__fillcap_4
XFILLER_147_239 VDD VDD VSS VSS gf180mcu_as_sc_mcu7t3v3__fillcap_8
XFILLER_175_548 VDD VDD VSS VSS gf180mcu_as_sc_mcu7t3v3__fillcap_4
X_4570_ VDD VDD VSS VSS _4570_/S _5028_/Q _5057_/Q _4571_/B gf180mcu_as_sc_mcu7t3v3__mux2_2
X_3521_ VDD VDD VSS VSS _3522_/D _3521_/A _3521_/B _3521_/C gf180mcu_as_sc_mcu7t3v3__ao21_2
XFILLER_157_1014 VDD VDD VSS VSS gf180mcu_as_sc_mcu7t3v3__fill_2
XFILLER_143_445 VDD VDD VSS VSS gf180mcu_as_sc_mcu7t3v3__fill_2
XFILLER_157_1047 VDD VDD VSS VSS gf180mcu_as_sc_mcu7t3v3__fill_2
X_3452_ VDD VDD VSS VSS _3452_/S _4104_/D _3452_/A _3454_/B gf180mcu_as_sc_mcu7t3v3__mux2_2
XFILLER_143_478 VDD VDD VSS VSS gf180mcu_as_sc_mcu7t3v3__fillcap_8
XFILLER_171_787 VDD VDD VSS VSS gf180mcu_as_sc_mcu7t3v3__fill_1
XFILLER_174_1350 VDD VDD VSS VSS gf180mcu_as_sc_mcu7t3v3__fill_2
X_3383_ VDD VDD VSS VSS _3470_/B _3383_/B _3383_/C _3384_/C gf180mcu_as_sc_mcu7t3v3__nor3_2
X_2403_ VDD VDD VSS VSS _4691_/A _4652_/B gf180mcu_as_sc_mcu7t3v3__inv_2
X_5122_ VDD VDD VSS VSS _5186_/CLK _5122_/D _5122_/Q gf180mcu_as_sc_mcu7t3v3__dfxtp_2
XTAP_TAPCELL_ROW_83_1_967 VDD VSS gf180mcu_as_sc_mcu7t3v3__tap_2
XTAP_TAPCELL_ROW_168_1958 VDD VSS gf180mcu_as_sc_mcu7t3v3__tap_2
XTAP_TAPCELL_ROW_168_1947 VDD VSS gf180mcu_as_sc_mcu7t3v3__tap_2
XFILLER_61_1553 VDD VDD VSS VSS gf180mcu_as_sc_mcu7t3v3__fillcap_16
X_5053_ VDD VDD VSS VSS _5053_/CLK _5053_/D _5053_/Q gf180mcu_as_sc_mcu7t3v3__dfxtp_2
XFILLER_37_120 VDD VDD VSS VSS gf180mcu_as_sc_mcu7t3v3__fillcap_16
XFILLER_37_142 VDD VDD VSS VSS gf180mcu_as_sc_mcu7t3v3__fillcap_16
X_4004_ VDD VDD VSS VSS _4986_/Q _4092_/B _4237_/B _4092_/D _4986_/D gf180mcu_as_sc_mcu7t3v3__ao22_2
XFILLER_168_1143 VDD VDD VSS VSS gf180mcu_as_sc_mcu7t3v3__fill_2
XFILLER_168_1154 VDD VDD VSS VSS gf180mcu_as_sc_mcu7t3v3__fill_1
XFILLER_52_134 VDD VDD VSS VSS gf180mcu_as_sc_mcu7t3v3__fillcap_8
XFILLER_181_1321 VDD VDD VSS VSS gf180mcu_as_sc_mcu7t3v3__fill_2
X_4906_ VDD VDD VSS VSS _4943_/CLK _4906_/D _4906_/Q gf180mcu_as_sc_mcu7t3v3__dfxtp_2
XFILLER_142_1338 VDD VDD VSS VSS gf180mcu_as_sc_mcu7t3v3__fillcap_16
XFILLER_181_1376 VDD VDD VSS VSS gf180mcu_as_sc_mcu7t3v3__fill_1
X_4837_ VDD VDD VSS VSS _4869_/CLK _4837_/D _4837_/Q gf180mcu_as_sc_mcu7t3v3__dfxtp_2
X_4768_ VDD VDD VSS VSS _5199_/CLK _4768_/D _4768_/Q gf180mcu_as_sc_mcu7t3v3__dfxtp_2
XFILLER_134_401 VDD VDD VSS VSS gf180mcu_as_sc_mcu7t3v3__fillcap_4
XFILLER_134_412 VDD VDD VSS VSS gf180mcu_as_sc_mcu7t3v3__fill_1
XFILLER_135_924 VDD VDD VSS VSS gf180mcu_as_sc_mcu7t3v3__fill_2
XFILLER_135_946 VDD VDD VSS VSS gf180mcu_as_sc_mcu7t3v3__fill_2
XFILLER_140_1084 VDD VDD VSS VSS gf180mcu_as_sc_mcu7t3v3__fill_1
XFILLER_174_570 VDD VDD VSS VSS gf180mcu_as_sc_mcu7t3v3__fillcap_16
X_4699_ VDD VDD VSS VSS _4707_/S _5254_/Q _4699_/A _5254_/D gf180mcu_as_sc_mcu7t3v3__mux2_2
X_3719_ VDD VDD VSS VSS _4935_/Q _3719_/B _3719_/C _4096_/D _3720_/D gf180mcu_as_sc_mcu7t3v3__ao22_2
XPHY_EDGE_ROW_91_3_Right_410 VDD VSS gf180mcu_as_sc_mcu7t3v3__tap_2
XFILLER_121_106 VDD VDD VSS VSS gf180mcu_as_sc_mcu7t3v3__fill_1
XFILLER_134_489 VDD VDD VSS VSS gf180mcu_as_sc_mcu7t3v3__fill_2
XFILLER_150_938 VDD VDD VSS VSS gf180mcu_as_sc_mcu7t3v3__fillcap_4
XFILLER_150_949 VDD VDD VSS VSS gf180mcu_as_sc_mcu7t3v3__fill_1
XFILLER_175_1158 VDD VDD VSS VSS gf180mcu_as_sc_mcu7t3v3__fillcap_4
XFILLER_66_1486 VDD VDD VSS VSS gf180mcu_as_sc_mcu7t3v3__fillcap_16
XFILLER_153_1456 VDD VDD VSS VSS gf180mcu_as_sc_mcu7t3v3__fill_2
Xinput304 VDD VDD VSS VSS west_in[29] _3788_/A gf180mcu_as_sc_mcu7t3v3__buff_2
Xinput315 VDD VDD VSS VSS west_in[8] _3997_/D gf180mcu_as_sc_mcu7t3v3__buff_2
XFILLER_152_34 VDD VDD VSS VSS gf180mcu_as_sc_mcu7t3v3__fill_1
XFILLER_29_66 VDD VDD VSS VSS gf180mcu_as_sc_mcu7t3v3__fillcap_4
XFILLER_29_88 VDD VDD VSS VSS gf180mcu_as_sc_mcu7t3v3__fillcap_16
XFILLER_45_10 VDD VDD VSS VSS gf180mcu_as_sc_mcu7t3v3__fill_1
XFILLER_43_134 VDD VDD VSS VSS gf180mcu_as_sc_mcu7t3v3__fillcap_4
XFILLER_45_32 VDD VDD VSS VSS gf180mcu_as_sc_mcu7t3v3__fillcap_4
XTAP_TAPCELL_ROW_25_1_736 VDD VSS gf180mcu_as_sc_mcu7t3v3__tap_2
XFILLER_164_1563 VDD VDD VSS VSS gf180mcu_as_sc_mcu7t3v3__fillcap_4
XFILLER_157_526 VDD VDD VSS VSS gf180mcu_as_sc_mcu7t3v3__fill_1
XFILLER_129_239 VDD VDD VSS VSS gf180mcu_as_sc_mcu7t3v3__fillcap_8
XFILLER_138_751 VDD VDD VSS VSS gf180mcu_as_sc_mcu7t3v3__fill_1
XFILLER_144_209 VDD VDD VSS VSS gf180mcu_as_sc_mcu7t3v3__fill_1
XFILLER_172_507 VDD VDD VSS VSS gf180mcu_as_sc_mcu7t3v3__fillcap_16
XFILLER_138_784 VDD VDD VSS VSS gf180mcu_as_sc_mcu7t3v3__fillcap_16
XFILLER_153_710 VDD VDD VSS VSS gf180mcu_as_sc_mcu7t3v3__fill_1
XFILLER_165_570 VDD VDD VSS VSS gf180mcu_as_sc_mcu7t3v3__fillcap_4
XFILLER_165_581 VDD VDD VSS VSS gf180mcu_as_sc_mcu7t3v3__fill_2
XFILLER_6_37 VDD VDD VSS VSS gf180mcu_as_sc_mcu7t3v3__fillcap_16
XTAP_TAPCELL_ROW_137_1272 VDD VSS gf180mcu_as_sc_mcu7t3v3__tap_2
XTAP_TAPCELL_ROW_137_1261 VDD VSS gf180mcu_as_sc_mcu7t3v3__tap_2
XFILLER_141_905 VDD VDD VSS VSS gf180mcu_as_sc_mcu7t3v3__fillcap_4
XFILLER_158_1345 VDD VDD VSS VSS gf180mcu_as_sc_mcu7t3v3__fillcap_16
XFILLER_158_1367 VDD VDD VSS VSS gf180mcu_as_sc_mcu7t3v3__fillcap_16
XFILLER_180_573 VDD VDD VSS VSS gf180mcu_as_sc_mcu7t3v3__fill_1
XFILLER_3_241 VDD VDD VSS VSS gf180mcu_as_sc_mcu7t3v3__fillcap_8
XFILLER_140_448 VDD VDD VSS VSS gf180mcu_as_sc_mcu7t3v3__fill_1
XFILLER_45_1515 VDD VDD VSS VSS gf180mcu_as_sc_mcu7t3v3__fillcap_4
XFILLER_45_1537 VDD VDD VSS VSS gf180mcu_as_sc_mcu7t3v3__fillcap_16
XFILLER_84_1564 VDD VDD VSS VSS gf180mcu_as_sc_mcu7t3v3__fillcap_4
XPHY_EDGE_ROW_120_1_Right_119 VDD VSS gf180mcu_as_sc_mcu7t3v3__tap_2
Xmesh_tile_908 VDD VDD VSS VSS nw_out[15] gf180mcu_as_sc_mcu7t3v3__tiel_4
XFILLER_120_150 VDD VDD VSS VSS gf180mcu_as_sc_mcu7t3v3__fillcap_8
Xmesh_tile_919 VDD VDD VSS VSS nw_out[26] gf180mcu_as_sc_mcu7t3v3__tiel_4
XFILLER_19_120 VDD VDD VSS VSS gf180mcu_as_sc_mcu7t3v3__fillcap_16
XFILLER_86_94 VDD VDD VSS VSS gf180mcu_as_sc_mcu7t3v3__fillcap_8
XPHY_EDGE_ROW_57_1_Right_56 VDD VSS gf180mcu_as_sc_mcu7t3v3__tap_2
XTAP_TAPCELL_ROW_163_1833 VDD VSS gf180mcu_as_sc_mcu7t3v3__tap_2
XFILLER_19_142 VDD VDD VSS VSS gf180mcu_as_sc_mcu7t3v3__fillcap_16
XTAP_TAPCELL_ROW_163_1844 VDD VSS gf180mcu_as_sc_mcu7t3v3__tap_2
XFILLER_34_123 VDD VDD VSS VSS gf180mcu_as_sc_mcu7t3v3__fillcap_16
X_2952_ VDD VDD VSS VSS _3925_/A _3239_/A _2952_/C _3179_/B _2954_/C gf180mcu_as_sc_mcu7t3v3__ao22_2
XTAP_TAPCELL_ROW_9_1_673 VDD VSS gf180mcu_as_sc_mcu7t3v3__tap_2
XFILLER_176_835 VDD VDD VSS VSS gf180mcu_as_sc_mcu7t3v3__fillcap_4
XFILLER_89_2 VDD VDD VSS VSS gf180mcu_as_sc_mcu7t3v3__fillcap_16
X_2883_ VDD VDD VSS VSS _2884_/B _4708_/C _2883_/B _4655_/B gf180mcu_as_sc_mcu7t3v3__aoi21_2
X_4622_ VDD VDD VSS VSS _5216_/Q _4623_/B _4623_/C _5217_/Q _5216_/D gf180mcu_as_sc_mcu7t3v3__ao22_2
XFILLER_141_1393 VDD VDD VSS VSS gf180mcu_as_sc_mcu7t3v3__fillcap_4
XFILLER_156_570 VDD VDD VSS VSS gf180mcu_as_sc_mcu7t3v3__fillcap_4
XFILLER_176_1401 VDD VDD VSS VSS gf180mcu_as_sc_mcu7t3v3__fill_2
X_4553_ VDD VDD VSS VSS _4553_/A _4553_/B _4553_/C _4556_/C _4573_/A gf180mcu_as_sc_mcu7t3v3__aoi211_2
X_4484_ VDD VDD VSS VSS _4485_/B _4484_/A gf180mcu_as_sc_mcu7t3v3__inv_2
X_3504_ VDD VDD VSS VSS _4162_/A _3504_/B _3504_/C _3504_/D _3505_/B gf180mcu_as_sc_mcu7t3v3__ao211_2
XFILLER_137_1418 VDD VDD VSS VSS gf180mcu_as_sc_mcu7t3v3__fillcap_16
XFILLER_171_562 VDD VDD VSS VSS gf180mcu_as_sc_mcu7t3v3__fillcap_8
X_3435_ VDD VDD VSS VSS _4088_/D _3449_/B _3435_/C _3435_/D _3437_/C gf180mcu_as_sc_mcu7t3v3__ao211_2
XFILLER_103_139 VDD VDD VSS VSS gf180mcu_as_sc_mcu7t3v3__fill_1
XFILLER_170_1033 VDD VDD VSS VSS gf180mcu_as_sc_mcu7t3v3__fill_1
X_3366_ VDD VDD VSS VSS _4016_/A _3453_/B _3453_/C _4017_/A _3367_/C gf180mcu_as_sc_mcu7t3v3__ao22_2
XFILLER_135_1186 VDD VDD VSS VSS gf180mcu_as_sc_mcu7t3v3__fillcap_4
XFILLER_170_1055 VDD VDD VSS VSS gf180mcu_as_sc_mcu7t3v3__fill_1
XPHY_EDGE_ROW_130_3_Right_449 VDD VSS gf180mcu_as_sc_mcu7t3v3__tap_2
X_5105_ VDD VDD VSS VSS clkload6/A _5105_/D _5105_/Q gf180mcu_as_sc_mcu7t3v3__dfxtp_2
X_3297_ VDD VDD VSS VSS _4917_/Q _3493_/B _3501_/B _3950_/A _3299_/C gf180mcu_as_sc_mcu7t3v3__ao22_2
XFILLER_113_1451 VDD VDD VSS VSS gf180mcu_as_sc_mcu7t3v3__fillcap_16
XFILLER_6_1564 VDD VDD VSS VSS gf180mcu_as_sc_mcu7t3v3__fillcap_4
X_5036_ VDD VDD VSS VSS _5172_/CLK _5036_/D _5036_/Q gf180mcu_as_sc_mcu7t3v3__dfxtp_2
XTAP_TAPCELL_ROW_65_1_896 VDD VSS gf180mcu_as_sc_mcu7t3v3__tap_2
XFILLER_122_37 VDD VDD VSS VSS gf180mcu_as_sc_mcu7t3v3__fill_2
XFILLER_148_1525 VDD VDD VSS VSS gf180mcu_as_sc_mcu7t3v3__fillcap_8
XFILLER_80_251 VDD VDD VSS VSS gf180mcu_as_sc_mcu7t3v3__fill_2
XFILLER_179_651 VDD VDD VSS VSS gf180mcu_as_sc_mcu7t3v3__fill_1
XFILLER_40_104 VDD VDD VSS VSS gf180mcu_as_sc_mcu7t3v3__fill_1
XTAP_TAPCELL_ROW_21_1_720 VDD VSS gf180mcu_as_sc_mcu7t3v3__tap_2
XFILLER_142_1157 VDD VDD VSS VSS gf180mcu_as_sc_mcu7t3v3__fillcap_16
XFILLER_167_846 VDD VDD VSS VSS gf180mcu_as_sc_mcu7t3v3__fill_2
XFILLER_139_559 VDD VDD VSS VSS gf180mcu_as_sc_mcu7t3v3__fill_1
XFILLER_31_34 VDD VDD VSS VSS gf180mcu_as_sc_mcu7t3v3__fillcap_16
XTAP_TAPCELL_ROW_126_1_1138 VDD VSS gf180mcu_as_sc_mcu7t3v3__tap_2
XFILLER_162_584 VDD VDD VSS VSS gf180mcu_as_sc_mcu7t3v3__fill_1
XPHY_EDGE_ROW_92_3_Right_411 VDD VSS gf180mcu_as_sc_mcu7t3v3__tap_2
XTAP_TAPCELL_ROW_106_1_1058 VDD VSS gf180mcu_as_sc_mcu7t3v3__tap_2
Xinput101 VDD VDD VSS VSS ne_in[30] _3800_/A gf180mcu_as_sc_mcu7t3v3__buff_2
XFILLER_102_150 VDD VDD VSS VSS gf180mcu_as_sc_mcu7t3v3__fillcap_4
XFILLER_163_66 VDD VDD VSS VSS gf180mcu_as_sc_mcu7t3v3__fillcap_4
XFILLER_163_88 VDD VDD VSS VSS gf180mcu_as_sc_mcu7t3v3__fillcap_16
Xinput112 VDD VDD VSS VSS north_in[0] _3930_/A gf180mcu_as_sc_mcu7t3v3__buff_2
Xinput123 VDD VDD VSS VSS north_in[1] _3940_/A gf180mcu_as_sc_mcu7t3v3__buff_2
Xinput134 VDD VDD VSS VSS north_in[2] _3950_/A gf180mcu_as_sc_mcu7t3v3__buff_2
Xinput145 VDD VDD VSS VSS north_in[9] _4005_/A gf180mcu_as_sc_mcu7t3v3__buff_2
XFILLER_0_299 VDD VDD VSS VSS gf180mcu_as_sc_mcu7t3v3__fill_2
Xinput156 VDD VDD VSS VSS nw_in[19] _4086_/A gf180mcu_as_sc_mcu7t3v3__buff_2
Xinput167 VDD VDD VSS VSS nw_in[29] _3792_/A gf180mcu_as_sc_mcu7t3v3__buff_2
Xinput178 VDD VDD VSS VSS nw_in[8] _3998_/A gf180mcu_as_sc_mcu7t3v3__buff_2
XFILLER_40_1467 VDD VDD VSS VSS gf180mcu_as_sc_mcu7t3v3__fillcap_16
Xinput189 VDD VDD VSS VSS se_in[17] _4073_/A gf180mcu_as_sc_mcu7t3v3__buff_2
XFILLER_16_101 VDD VDD VSS VSS gf180mcu_as_sc_mcu7t3v3__fillcap_4
XFILLER_16_123 VDD VDD VSS VSS gf180mcu_as_sc_mcu7t3v3__fillcap_16
XFILLER_31_104 VDD VDD VSS VSS gf180mcu_as_sc_mcu7t3v3__fillcap_16
XFILLER_158_846 VDD VDD VSS VSS gf180mcu_as_sc_mcu7t3v3__fill_1
XFILLER_160_1224 VDD VDD VSS VSS gf180mcu_as_sc_mcu7t3v3__fill_1
XFILLER_72_96 VDD VDD VSS VSS gf180mcu_as_sc_mcu7t3v3__fillcap_8
XTAP_TAPCELL_ROW_139_1323 VDD VSS gf180mcu_as_sc_mcu7t3v3__tap_2
XTAP_TAPCELL_ROW_139_1312 VDD VSS gf180mcu_as_sc_mcu7t3v3__tap_2
XFILLER_184_131 VDD VDD VSS VSS gf180mcu_as_sc_mcu7t3v3__fillcap_4
XFILLER_184_142 VDD VDD VSS VSS gf180mcu_as_sc_mcu7t3v3__fill_2
XFILLER_173_838 VDD VDD VSS VSS gf180mcu_as_sc_mcu7t3v3__fill_2
XTAP_TAPCELL_ROW_156_1681 VDD VSS gf180mcu_as_sc_mcu7t3v3__tap_2
XTAP_TAPCELL_ROW_156_1692 VDD VSS gf180mcu_as_sc_mcu7t3v3__tap_2
XFILLER_141_702 VDD VDD VSS VSS gf180mcu_as_sc_mcu7t3v3__fillcap_8
XFILLER_153_562 VDD VDD VSS VSS gf180mcu_as_sc_mcu7t3v3__fillcap_8
XFILLER_140_201 VDD VDD VSS VSS gf180mcu_as_sc_mcu7t3v3__fillcap_4
XFILLER_180_381 VDD VDD VSS VSS gf180mcu_as_sc_mcu7t3v3__fillcap_4
XFILLER_98_115 VDD VDD VSS VSS gf180mcu_as_sc_mcu7t3v3__fillcap_4
XFILLER_140_267 VDD VDD VSS VSS gf180mcu_as_sc_mcu7t3v3__fill_1
XFILLER_97_60 VDD VDD VSS VSS gf180mcu_as_sc_mcu7t3v3__fill_2
X_3220_ VDD VDD VSS VSS _3283_/A _3817_/A _3558_/B gf180mcu_as_sc_mcu7t3v3__and2_2
XFILLER_171_1364 VDD VDD VSS VSS gf180mcu_as_sc_mcu7t3v3__fillcap_16
X_3151_ VDD VDD VSS VSS _3151_/S _4126_/D _4130_/A _3153_/B gf180mcu_as_sc_mcu7t3v3__mux2_2
XFILLER_171_1397 VDD VDD VSS VSS gf180mcu_as_sc_mcu7t3v3__fill_2
X_3082_ VDD VDD VSS VSS _4064_/A _3125_/B _3125_/C _4064_/D _3088_/B gf180mcu_as_sc_mcu7t3v3__ao22_2
XTAP_TAPCELL_ROW_61_1_880 VDD VSS gf180mcu_as_sc_mcu7t3v3__tap_2
XFILLER_1_1483 VDD VDD VSS VSS gf180mcu_as_sc_mcu7t3v3__fillcap_16
XFILLER_149_802 VDD VDD VSS VSS gf180mcu_as_sc_mcu7t3v3__fill_1
X_3984_ VDD VDD VSS VSS _3984_/A _4104_/B _4104_/C _3984_/D _3985_/D gf180mcu_as_sc_mcu7t3v3__ao22_2
XFILLER_108_1564 VDD VDD VSS VSS gf180mcu_as_sc_mcu7t3v3__fill_1
XFILLER_182_1482 VDD VDD VSS VSS gf180mcu_as_sc_mcu7t3v3__fill_2
X_2935_ VDD VDD VSS VSS _3514_/A _3523_/A _3528_/B gf180mcu_as_sc_mcu7t3v3__or2_2
XFILLER_143_1466 VDD VDD VSS VSS gf180mcu_as_sc_mcu7t3v3__fillcap_4
XFILLER_175_120 VDD VDD VSS VSS gf180mcu_as_sc_mcu7t3v3__fillcap_16
XFILLER_175_142 VDD VDD VSS VSS gf180mcu_as_sc_mcu7t3v3__fillcap_16
X_2866_ VDD VDD VSS VSS _4742_/A _2871_/B _2866_/C _4764_/D gf180mcu_as_sc_mcu7t3v3__nor3_2
XFILLER_148_389 VDD VDD VSS VSS gf180mcu_as_sc_mcu7t3v3__fill_1
XFILLER_178_1507 VDD VDD VSS VSS gf180mcu_as_sc_mcu7t3v3__fillcap_16
X_4605_ VDD VDD VSS VSS _5199_/Q _4605_/B _4607_/C _5200_/Q _5199_/D gf180mcu_as_sc_mcu7t3v3__ao22_2
XFILLER_163_348 VDD VDD VSS VSS gf180mcu_as_sc_mcu7t3v3__fill_2
X_2797_ VDD VDD VSS VSS _2797_/A _4626_/B _2806_/A _2797_/D _2800_/A gf180mcu_as_sc_mcu7t3v3__ao211_2
XFILLER_116_242 VDD VDD VSS VSS gf180mcu_as_sc_mcu7t3v3__fill_2
XFILLER_137_1204 VDD VDD VSS VSS gf180mcu_as_sc_mcu7t3v3__fillcap_16
XFILLER_144_562 VDD VDD VSS VSS gf180mcu_as_sc_mcu7t3v3__fillcap_8
X_4536_ VDD VDD VSS VSS _4536_/S _5082_/Q _4995_/Q _4537_/A gf180mcu_as_sc_mcu7t3v3__mux2_2
XFILLER_131_212 VDD VDD VSS VSS gf180mcu_as_sc_mcu7t3v3__fillcap_8
XFILLER_144_584 VDD VDD VSS VSS gf180mcu_as_sc_mcu7t3v3__fillcap_8
XFILLER_172_893 VDD VDD VSS VSS gf180mcu_as_sc_mcu7t3v3__fillcap_8
X_4467_ VDD VDD VSS VSS _5175_/Q _4470_/B _4505_/C _5109_/Q _4468_/B gf180mcu_as_sc_mcu7t3v3__ao22_2
XFILLER_137_1259 VDD VDD VSS VSS gf180mcu_as_sc_mcu7t3v3__fill_1
Xfanout802 VDD VDD VSS VSS fanout808/Y _3573_/D gf180mcu_as_sc_mcu7t3v3__buff_2
X_4398_ VDD VDD VSS VSS _5166_/Q _4592_/B _4398_/C _4398_/D _5166_/D gf180mcu_as_sc_mcu7t3v3__ao211_2
X_3418_ VDD VDD VSS VSS _4072_/D _3449_/B _3418_/C _3450_/B _3420_/C gf180mcu_as_sc_mcu7t3v3__ao211_2
XFILLER_63_1467 VDD VDD VSS VSS gf180mcu_as_sc_mcu7t3v3__fillcap_16
XFILLER_97_170 VDD VDD VSS VSS gf180mcu_as_sc_mcu7t3v3__fill_2
X_3349_ VDD VDD VSS VSS _3467_/B _3997_/A _3349_/A _3351_/B gf180mcu_as_sc_mcu7t3v3__mux2_2
XFILLER_140_790 VDD VDD VSS VSS gf180mcu_as_sc_mcu7t3v3__fillcap_4
XFILLER_150_1437 VDD VDD VSS VSS gf180mcu_as_sc_mcu7t3v3__fill_1
Xhold1011 VDD VDD VSS VSS hold1043/Y _4970_/D gf180mcu_as_sc_mcu7t3v3__buff_2
Xhold1022 VDD VDD VSS VSS hold1054/Y _4972_/D gf180mcu_as_sc_mcu7t3v3__buff_2
Xhold1033 VDD VDD VSS VSS _5115_/Q _4676_/A gf180mcu_as_sc_mcu7t3v3__buff_2
XPHY_EDGE_ROW_72_3_Left_206 VDD VSS gf180mcu_as_sc_mcu7t3v3__tap_2
XFILLER_93_18 VDD VDD VSS VSS gf180mcu_as_sc_mcu7t3v3__fill_2
Xhold1044 VDD VDD VSS VSS _4967_/Q hold1044/Y gf180mcu_as_sc_mcu7t3v3__buff_2
Xhold1055 VDD VDD VSS VSS _4962_/Q hold1055/Y gf180mcu_as_sc_mcu7t3v3__buff_2
X_5019_ VDD VDD VSS VSS _5080_/CLK _5019_/D _5019_/Q gf180mcu_as_sc_mcu7t3v3__dfxtp_2
XFILLER_26_34 VDD VDD VSS VSS gf180mcu_as_sc_mcu7t3v3__fill_1
XFILLER_13_104 VDD VDD VSS VSS gf180mcu_as_sc_mcu7t3v3__fillcap_16
XFILLER_148_1399 VDD VDD VSS VSS gf180mcu_as_sc_mcu7t3v3__fill_2
XPHY_EDGE_ROW_2_1_Left_454 VDD VSS gf180mcu_as_sc_mcu7t3v3__tap_2
XFILLER_167_632 VDD VDD VSS VSS gf180mcu_as_sc_mcu7t3v3__fill_2
XFILLER_179_470 VDD VDD VSS VSS gf180mcu_as_sc_mcu7t3v3__fillcap_16
XFILLER_179_492 VDD VDD VSS VSS gf180mcu_as_sc_mcu7t3v3__fill_2
XTAP_TAPCELL_ROW_70_1_915 VDD VSS gf180mcu_as_sc_mcu7t3v3__tap_2
XFILLER_155_838 VDD VDD VSS VSS gf180mcu_as_sc_mcu7t3v3__fill_2
XFILLER_167_687 VDD VDD VSS VSS gf180mcu_as_sc_mcu7t3v3__fillcap_8
XFILLER_182_624 VDD VDD VSS VSS gf180mcu_as_sc_mcu7t3v3__fill_2
XFILLER_42_88 VDD VDD VSS VSS gf180mcu_as_sc_mcu7t3v3__fillcap_4
XFILLER_154_348 VDD VDD VSS VSS gf180mcu_as_sc_mcu7t3v3__fillcap_16
XFILLER_181_134 VDD VDD VSS VSS gf180mcu_as_sc_mcu7t3v3__fillcap_4
XFILLER_107_264 VDD VDD VSS VSS gf180mcu_as_sc_mcu7t3v3__fillcap_4
XFILLER_135_562 VDD VDD VSS VSS gf180mcu_as_sc_mcu7t3v3__fillcap_8
XFILLER_181_156 VDD VDD VSS VSS gf180mcu_as_sc_mcu7t3v3__fill_1
XFILLER_182_679 VDD VDD VSS VSS gf180mcu_as_sc_mcu7t3v3__fill_2
XFILLER_122_223 VDD VDD VSS VSS gf180mcu_as_sc_mcu7t3v3__fillcap_4
XFILLER_155_1348 VDD VDD VSS VSS gf180mcu_as_sc_mcu7t3v3__fillcap_16
XPHY_EDGE_ROW_93_3_Right_412 VDD VSS gf180mcu_as_sc_mcu7t3v3__tap_2
XFILLER_150_576 VDD VDD VSS VSS gf180mcu_as_sc_mcu7t3v3__fillcap_4
XFILLER_42_1518 VDD VDD VSS VSS gf180mcu_as_sc_mcu7t3v3__fillcap_16
XFILLER_83_95 VDD VDD VSS VSS gf180mcu_as_sc_mcu7t3v3__fillcap_16
XFILLER_166_1499 VDD VDD VSS VSS gf180mcu_as_sc_mcu7t3v3__fillcap_4
XFILLER_44_295 VDD VDD VSS VSS gf180mcu_as_sc_mcu7t3v3__fillcap_4
XFILLER_158_610 VDD VDD VSS VSS gf180mcu_as_sc_mcu7t3v3__fill_2
XFILLER_158_632 VDD VDD VSS VSS gf180mcu_as_sc_mcu7t3v3__fillcap_4
XFILLER_164_1190 VDD VDD VSS VSS gf180mcu_as_sc_mcu7t3v3__fill_1
XTAP_TAPCELL_ROW_158_1732 VDD VSS gf180mcu_as_sc_mcu7t3v3__tap_2
XFILLER_157_142 VDD VDD VSS VSS gf180mcu_as_sc_mcu7t3v3__fillcap_16
XFILLER_160_1032 VDD VDD VSS VSS gf180mcu_as_sc_mcu7t3v3__fillcap_16
X_2720_ VDD VDD VSS VSS _2727_/S _2720_/B _2720_/A _2721_/C gf180mcu_as_sc_mcu7t3v3__mux2_2
XTAP_TAPCELL_ROW_158_1743 VDD VSS gf180mcu_as_sc_mcu7t3v3__tap_2
XFILLER_160_1087 VDD VDD VSS VSS gf180mcu_as_sc_mcu7t3v3__fillcap_16
X_2651_ VDD VDD VSS VSS _2657_/C _2737_/A _2736_/B input7/Y gf180mcu_as_sc_mcu7t3v3__aoi21_2
XFILLER_145_348 VDD VDD VSS VSS gf180mcu_as_sc_mcu7t3v3__fill_2
XFILLER_172_123 VDD VDD VSS VSS gf180mcu_as_sc_mcu7t3v3__fillcap_16
XFILLER_66_4 VDD VDD VSS VSS gf180mcu_as_sc_mcu7t3v3__fill_1
XFILLER_103_1483 VDD VDD VSS VSS gf180mcu_as_sc_mcu7t3v3__fillcap_16
Xoutput405 VDD VDD VSS VSS _4825_/Q south_out[20] gf180mcu_as_sc_mcu7t3v3__buff_2
Xoutput416 VDD VDD VSS VSS _4835_/Q south_out[30] gf180mcu_as_sc_mcu7t3v3__buff_2
X_2582_ VDD VDD VSS VSS _2583_/D _2709_/A _2736_/B input2/Y gf180mcu_as_sc_mcu7t3v3__aoi21b_2
XFILLER_113_212 VDD VDD VSS VSS gf180mcu_as_sc_mcu7t3v3__fillcap_16
XFILLER_138_1535 VDD VDD VSS VSS gf180mcu_as_sc_mcu7t3v3__fillcap_4
XFILLER_154_893 VDD VDD VSS VSS gf180mcu_as_sc_mcu7t3v3__fill_2
XFILLER_173_1426 VDD VDD VSS VSS gf180mcu_as_sc_mcu7t3v3__fillcap_4
XFILLER_86_1467 VDD VDD VSS VSS gf180mcu_as_sc_mcu7t3v3__fillcap_16
Xoutput427 VDD VDD VSS VSS _4873_/Q west_out[0] gf180mcu_as_sc_mcu7t3v3__buff_2
Xoutput438 VDD VDD VSS VSS _4874_/Q west_out[1] gf180mcu_as_sc_mcu7t3v3__buff_2
Xoutput449 VDD VDD VSS VSS _4875_/Q west_out[2] gf180mcu_as_sc_mcu7t3v3__buff_2
X_4321_ VDD VDD VSS VSS _4321_/S _5151_/Q _5150_/Q _5150_/D gf180mcu_as_sc_mcu7t3v3__mux2_2
XFILLER_138_1568 VDD VDD VSS VSS gf180mcu_as_sc_mcu7t3v3__fill_1
X_4252_ VDD VDD VSS VSS _4252_/S _4252_/B _5088_/Q _5088_/D gf180mcu_as_sc_mcu7t3v3__mux2_2
XFILLER_136_1270 VDD VDD VSS VSS gf180mcu_as_sc_mcu7t3v3__fillcap_4
X_3203_ VDD VDD VSS VSS _3213_/D _3203_/A _3203_/B _3210_/B _3205_/B gf180mcu_as_sc_mcu7t3v3__ao31_2
XFILLER_136_1292 VDD VDD VSS VSS gf180mcu_as_sc_mcu7t3v3__fill_2
XFILLER_171_1161 VDD VDD VSS VSS gf180mcu_as_sc_mcu7t3v3__fill_2
X_4183_ VDD VDD VSS VSS _4243_/B _4187_/B _4190_/C _5021_/Q _5021_/D gf180mcu_as_sc_mcu7t3v3__ao22_2
XFILLER_23_1451 VDD VDD VSS VSS gf180mcu_as_sc_mcu7t3v3__fillcap_16
X_3134_ VDD VDD VSS VSS _3151_/S _4109_/D _4113_/A _3136_/B gf180mcu_as_sc_mcu7t3v3__mux2_2
XFILLER_167_1208 VDD VDD VSS VSS gf180mcu_as_sc_mcu7t3v3__fillcap_8
X_3065_ VDD VDD VSS VSS _4043_/A _3124_/B _3065_/C _4784_/D _3661_/D gf180mcu_as_sc_mcu7t3v3__aoi211_2
XTAP_TAPCELL_ROW_35_1_774 VDD VSS gf180mcu_as_sc_mcu7t3v3__tap_2
XFILLER_145_1539 VDD VDD VSS VSS gf180mcu_as_sc_mcu7t3v3__fill_1
XFILLER_184_1566 VDD VDD VSS VSS gf180mcu_as_sc_mcu7t3v3__fill_2
XFILLER_10_107 VDD VDD VSS VSS gf180mcu_as_sc_mcu7t3v3__fillcap_16
XFILLER_149_632 VDD VDD VSS VSS gf180mcu_as_sc_mcu7t3v3__fillcap_16
XFILLER_50_243 VDD VDD VSS VSS gf180mcu_as_sc_mcu7t3v3__fill_2
X_3967_ VDD VDD VSS VSS _3967_/A _4160_/C _4152_/C _4919_/Q _3969_/C gf180mcu_as_sc_mcu7t3v3__ao22_2
XFILLER_176_451 VDD VDD VSS VSS gf180mcu_as_sc_mcu7t3v3__fillcap_4
X_2918_ VDD VDD VSS VSS _3280_/B _3792_/A _3801_/A gf180mcu_as_sc_mcu7t3v3__nor2_2
XFILLER_137_838 VDD VDD VSS VSS gf180mcu_as_sc_mcu7t3v3__fill_2
XFILLER_176_473 VDD VDD VSS VSS gf180mcu_as_sc_mcu7t3v3__fillcap_16
XFILLER_177_996 VDD VDD VSS VSS gf180mcu_as_sc_mcu7t3v3__fillcap_4
X_3898_ VDD VDD VSS VSS _4946_/D _5188_/Q _4938_/D gf180mcu_as_sc_mcu7t3v3__and2_2
XFILLER_12_69 VDD VDD VSS VSS gf180mcu_as_sc_mcu7t3v3__fillcap_16
XFILLER_136_348 VDD VDD VSS VSS gf180mcu_as_sc_mcu7t3v3__fillcap_16
X_2849_ VDD VDD VSS VSS _2851_/B _3868_/C _4338_/A _2849_/A gf180mcu_as_sc_mcu7t3v3__aoi21_2
XFILLER_164_679 VDD VDD VSS VSS gf180mcu_as_sc_mcu7t3v3__fill_2
XFILLER_88_18 VDD VDD VSS VSS gf180mcu_as_sc_mcu7t3v3__fill_2
XFILLER_145_882 VDD VDD VSS VSS gf180mcu_as_sc_mcu7t3v3__fillcap_8
X_4519_ VDD VDD VSS VSS _4520_/D _4519_/B _4520_/A gf180mcu_as_sc_mcu7t3v3__nor2_2
XFILLER_104_256 VDD VDD VSS VSS gf180mcu_as_sc_mcu7t3v3__fillcap_4
XFILLER_137_1045 VDD VDD VSS VSS gf180mcu_as_sc_mcu7t3v3__fillcap_4
XFILLER_160_841 VDD VDD VSS VSS gf180mcu_as_sc_mcu7t3v3__fill_1
XPHY_EDGE_ROW_105_1_Left_557 VDD VSS gf180mcu_as_sc_mcu7t3v3__tap_2
Xfanout610 VDD VDD VSS VSS _3562_/Y _3751_/B gf180mcu_as_sc_mcu7t3v3__buff_2
Xfanout621 VDD VDD VSS VSS fanout622/Y _3468_/B gf180mcu_as_sc_mcu7t3v3__buff_2
Xfanout632 VDD VDD VSS VSS _4328_/A _4321_/S gf180mcu_as_sc_mcu7t3v3__buff_2
XFILLER_8_1467 VDD VDD VSS VSS gf180mcu_as_sc_mcu7t3v3__fillcap_16
Xfanout643 VDD VDD VSS VSS _4629_/B _4623_/B gf180mcu_as_sc_mcu7t3v3__buff_2
Xfanout654 VDD VDD VSS VSS _3747_/B _3741_/C gf180mcu_as_sc_mcu7t3v3__buff_2
Xfanout665 VDD VDD VSS VSS fanout666/Y _4121_/C gf180mcu_as_sc_mcu7t3v3__buff_2
Xfanout676 VDD VDD VSS VSS _3748_/C _3770_/C gf180mcu_as_sc_mcu7t3v3__buff_2
XFILLER_150_1267 VDD VDD VSS VSS gf180mcu_as_sc_mcu7t3v3__fill_2
Xfanout687 VDD VDD VSS VSS _3465_/C _3440_/C gf180mcu_as_sc_mcu7t3v3__buff_2
Xfanout698 VDD VDD VSS VSS _3250_/Y _3493_/B gf180mcu_as_sc_mcu7t3v3__buff_2
XFILLER_160_34 VDD VDD VSS VSS gf180mcu_as_sc_mcu7t3v3__fill_1
XFILLER_37_66 VDD VDD VSS VSS gf180mcu_as_sc_mcu7t3v3__fillcap_4
XFILLER_37_88 VDD VDD VSS VSS gf180mcu_as_sc_mcu7t3v3__fillcap_16
XTAP_TAPCELL_ROW_0_1_2343 VDD VSS gf180mcu_as_sc_mcu7t3v3__tap_2
XFILLER_156_2 VDD VDD VSS VSS gf180mcu_as_sc_mcu7t3v3__fillcap_16
XFILLER_26_295 VDD VDD VSS VSS gf180mcu_as_sc_mcu7t3v3__fillcap_4
Xclkbuf_leaf_2_clk_regs VDD VDD VSS VSS clkbuf_3_0_0_clk_regs/Y clkload2/A gf180mcu_as_sc_mcu7t3v3__clkbuff_12
XFILLER_144_1049 VDD VDD VSS VSS gf180mcu_as_sc_mcu7t3v3__fillcap_4
XFILLER_183_1098 VDD VDD VSS VSS gf180mcu_as_sc_mcu7t3v3__fillcap_8
XTAP_TAPCELL_ROW_179_2190 VDD VSS gf180mcu_as_sc_mcu7t3v3__tap_2
XFILLER_126_1483 VDD VDD VSS VSS gf180mcu_as_sc_mcu7t3v3__fill_1
XFILLER_168_963 VDD VDD VSS VSS gf180mcu_as_sc_mcu7t3v3__fillcap_16
XFILLER_41_276 VDD VDD VSS VSS gf180mcu_as_sc_mcu7t3v3__fillcap_4
XFILLER_41_298 VDD VDD VSS VSS gf180mcu_as_sc_mcu7t3v3__fill_2
XPHY_EDGE_ROW_153_Right_287 VDD VSS gf180mcu_as_sc_mcu7t3v3__tap_2
XFILLER_139_142 VDD VDD VSS VSS gf180mcu_as_sc_mcu7t3v3__fillcap_8
XFILLER_155_624 VDD VDD VSS VSS gf180mcu_as_sc_mcu7t3v3__fillcap_4
XFILLER_161_1374 VDD VDD VSS VSS gf180mcu_as_sc_mcu7t3v3__fillcap_4
XTAP_TAPCELL_ROW_175_2098 VDD VSS gf180mcu_as_sc_mcu7t3v3__tap_2
XFILLER_154_123 VDD VDD VSS VSS gf180mcu_as_sc_mcu7t3v3__fillcap_16
XTAP_TAPCELL_ROW_52_1_844 VDD VSS gf180mcu_as_sc_mcu7t3v3__tap_2
XFILLER_142_307 VDD VDD VSS VSS gf180mcu_as_sc_mcu7t3v3__fill_1
XFILLER_170_616 VDD VDD VSS VSS gf180mcu_as_sc_mcu7t3v3__fillcap_8
XFILLER_183_988 VDD VDD VSS VSS gf180mcu_as_sc_mcu7t3v3__fillcap_8
XPHY_EDGE_ROW_66_1_Right_65 VDD VSS gf180mcu_as_sc_mcu7t3v3__tap_2
XFILLER_136_893 VDD VDD VSS VSS gf180mcu_as_sc_mcu7t3v3__fill_2
XFILLER_142_329 VDD VDD VSS VSS gf180mcu_as_sc_mcu7t3v3__fillcap_4
XFILLER_118_80 VDD VDD VSS VSS gf180mcu_as_sc_mcu7t3v3__fillcap_8
XPHY_EDGE_ROW_37_1_Left_489 VDD VSS gf180mcu_as_sc_mcu7t3v3__tap_2
XFILLER_38_8 VDD VDD VSS VSS gf180mcu_as_sc_mcu7t3v3__fill_2
XFILLER_46_1451 VDD VDD VSS VSS gf180mcu_as_sc_mcu7t3v3__fillcap_16
XFILLER_68_107 VDD VDD VSS VSS gf180mcu_as_sc_mcu7t3v3__fillcap_4
XPHY_EDGE_ROW_94_3_Right_413 VDD VSS gf180mcu_as_sc_mcu7t3v3__tap_2
XFILLER_110_237 VDD VDD VSS VSS gf180mcu_as_sc_mcu7t3v3__fillcap_8
XFILLER_150_384 VDD VDD VSS VSS gf180mcu_as_sc_mcu7t3v3__fill_1
XFILLER_110_259 VDD VDD VSS VSS gf180mcu_as_sc_mcu7t3v3__fill_2
XFILLER_133_1487 VDD VDD VSS VSS gf180mcu_as_sc_mcu7t3v3__fill_2
XFILLER_168_1539 VDD VDD VSS VSS gf180mcu_as_sc_mcu7t3v3__fillcap_8
XFILLER_91_121 VDD VDD VSS VSS gf180mcu_as_sc_mcu7t3v3__fill_2
XTAP_TAPCELL_ROW_147_1499 VDD VSS gf180mcu_as_sc_mcu7t3v3__tap_2
XTAP_TAPCELL_ROW_147_1488 VDD VSS gf180mcu_as_sc_mcu7t3v3__tap_2
XPHY_EDGE_ROW_99_1_Left_551 VDD VSS gf180mcu_as_sc_mcu7t3v3__tap_2
XFILLER_166_1263 VDD VDD VSS VSS gf180mcu_as_sc_mcu7t3v3__fillcap_4
XFILLER_91_198 VDD VDD VSS VSS gf180mcu_as_sc_mcu7t3v3__fill_1
X_4870_ VDD VDD VSS VSS _4943_/CLK _4870_/D _4870_/Q gf180mcu_as_sc_mcu7t3v3__dfxtp_2
X_3821_ VDD VDD VSS VSS _3929_/A _3918_/A _3917_/A _3821_/C _4168_/A gf180mcu_as_sc_mcu7t3v3__ao31_2
XFILLER_18_1564 VDD VDD VSS VSS gf180mcu_as_sc_mcu7t3v3__fillcap_4
XTAP_TAPCELL_ROW_127_1_1143 VDD VSS gf180mcu_as_sc_mcu7t3v3__tap_2
XFILLER_158_473 VDD VDD VSS VSS gf180mcu_as_sc_mcu7t3v3__fillcap_4
XFILLER_174_922 VDD VDD VSS VSS gf180mcu_as_sc_mcu7t3v3__fillcap_4
XFILLER_71_2 VDD VDD VSS VSS gf180mcu_as_sc_mcu7t3v3__fillcap_16
X_3752_ VDD VDD VSS VSS _4131_/A _3752_/B _3753_/B _3753_/C _3752_/D gf180mcu_as_sc_mcu7t3v3__aoi211_2
XFILLER_145_134 VDD VDD VSS VSS gf180mcu_as_sc_mcu7t3v3__fillcap_4
XFILLER_174_944 VDD VDD VSS VSS gf180mcu_as_sc_mcu7t3v3__fill_1
XFILLER_53_1499 VDD VDD VSS VSS gf180mcu_as_sc_mcu7t3v3__fillcap_16
XFILLER_88_1518 VDD VDD VSS VSS gf180mcu_as_sc_mcu7t3v3__fillcap_16
X_3683_ VDD VDD VSS VSS _3730_/D _3730_/A _3683_/B _3683_/C _3684_/C gf180mcu_as_sc_mcu7t3v3__ao31_2
X_2703_ VDD VDD VSS VSS _2717_/S _5176_/Q _5168_/Q _2707_/B gf180mcu_as_sc_mcu7t3v3__mux2_2
XTAP_TAPCELL_ROW_61_3_2441 VDD VSS gf180mcu_as_sc_mcu7t3v3__tap_2
XTAP_TAPCELL_ROW_38_1_789 VDD VSS gf180mcu_as_sc_mcu7t3v3__tap_2
XFILLER_161_616 VDD VDD VSS VSS gf180mcu_as_sc_mcu7t3v3__fillcap_8
XFILLER_173_454 VDD VDD VSS VSS gf180mcu_as_sc_mcu7t3v3__fillcap_16
XFILLER_174_999 VDD VDD VSS VSS gf180mcu_as_sc_mcu7t3v3__fill_2
X_2634_ VDD VDD VSS VSS _2635_/B _5258_/Q _2634_/B _2634_/C gf180mcu_as_sc_mcu7t3v3__ao21_2
X_2565_ VDD VDD VSS VSS _2565_/B _2730_/A _4742_/C gf180mcu_as_sc_mcu7t3v3__or2_2
XTAP_TAPCELL_ROW_107_1_1063 VDD VSS gf180mcu_as_sc_mcu7t3v3__tap_2
X_4304_ VDD VDD VSS VSS _4305_/S _5134_/Q _5133_/Q _5133_/D gf180mcu_as_sc_mcu7t3v3__mux2_2
XFILLER_134_1218 VDD VDD VSS VSS gf180mcu_as_sc_mcu7t3v3__fillcap_4
XFILLER_173_1256 VDD VDD VSS VSS gf180mcu_as_sc_mcu7t3v3__fillcap_4
XFILLER_99_265 VDD VDD VSS VSS gf180mcu_as_sc_mcu7t3v3__fillcap_8
X_5284_ VDD VDD VSS VSS clkload2/A _5284_/D _5284_/Q gf180mcu_as_sc_mcu7t3v3__dfxtp_2
X_2496_ VDD VDD VSS VSS _2876_/B _4703_/B _2747_/A gf180mcu_as_sc_mcu7t3v3__nor2_2
XFILLER_59_129 VDD VDD VSS VSS gf180mcu_as_sc_mcu7t3v3__fillcap_8
XFILLER_99_298 VDD VDD VSS VSS gf180mcu_as_sc_mcu7t3v3__fill_2
X_4235_ VDD VDD VSS VSS _4248_/S _4235_/B _5071_/Q _5071_/D gf180mcu_as_sc_mcu7t3v3__mux2_2
X_4166_ VDD VDD VSS VSS _5006_/Q _4166_/B _4257_/B _4166_/D _5006_/D gf180mcu_as_sc_mcu7t3v3__ao22_2
X_3117_ VDD VDD VSS VSS _4094_/A _3142_/B _3142_/C _4093_/A _3123_/B gf180mcu_as_sc_mcu7t3v3__ao22_2
X_4097_ VDD VDD VSS VSS _4097_/A _4122_/B _4097_/C _4097_/D _4098_/B gf180mcu_as_sc_mcu7t3v3__ao211_2
X_3048_ VDD VDD VSS VSS _3149_/B _3048_/B _3048_/C _3049_/C gf180mcu_as_sc_mcu7t3v3__nor3_2
XFILLER_130_37 VDD VDD VSS VSS gf180mcu_as_sc_mcu7t3v3__fillcap_4
XFILLER_149_1472 VDD VDD VSS VSS gf180mcu_as_sc_mcu7t3v3__fillcap_16
XFILLER_184_1374 VDD VDD VSS VSS gf180mcu_as_sc_mcu7t3v3__fill_2
XFILLER_145_1358 VDD VDD VSS VSS gf180mcu_as_sc_mcu7t3v3__fill_1
XFILLER_180_1216 VDD VDD VSS VSS gf180mcu_as_sc_mcu7t3v3__fill_1
XFILLER_23_276 VDD VDD VSS VSS gf180mcu_as_sc_mcu7t3v3__fillcap_4
XFILLER_23_298 VDD VDD VSS VSS gf180mcu_as_sc_mcu7t3v3__fill_2
X_4999_ VDD VDD VSS VSS _5188_/CLK _4999_/D _4999_/Q gf180mcu_as_sc_mcu7t3v3__dfxtp_2
XFILLER_165_900 VDD VDD VSS VSS gf180mcu_as_sc_mcu7t3v3__fillcap_8
XFILLER_136_101 VDD VDD VSS VSS gf180mcu_as_sc_mcu7t3v3__fillcap_4
XFILLER_137_624 VDD VDD VSS VSS gf180mcu_as_sc_mcu7t3v3__fillcap_4
XFILLER_137_657 VDD VDD VSS VSS gf180mcu_as_sc_mcu7t3v3__fill_1
XFILLER_136_134 VDD VDD VSS VSS gf180mcu_as_sc_mcu7t3v3__fillcap_8
XFILLER_164_454 VDD VDD VSS VSS gf180mcu_as_sc_mcu7t3v3__fill_1
XFILLER_164_465 VDD VDD VSS VSS gf180mcu_as_sc_mcu7t3v3__fill_2
XFILLER_99_39 VDD VDD VSS VSS gf180mcu_as_sc_mcu7t3v3__fill_2
XFILLER_139_1118 VDD VDD VSS VSS gf180mcu_as_sc_mcu7t3v3__fill_2
XFILLER_151_104 VDD VDD VSS VSS gf180mcu_as_sc_mcu7t3v3__fillcap_16
XFILLER_180_947 VDD VDD VSS VSS gf180mcu_as_sc_mcu7t3v3__fill_2
XFILLER_69_1451 VDD VDD VSS VSS gf180mcu_as_sc_mcu7t3v3__fillcap_16
XPHY_EDGE_ROW_16_3_Left_150 VDD VSS gf180mcu_as_sc_mcu7t3v3__tap_2
XPHY_EDGE_ROW_2_1_Right_1 VDD VSS gf180mcu_as_sc_mcu7t3v3__tap_2
Xfanout473 VDD VDD VSS VSS _4125_/B _4092_/B gf180mcu_as_sc_mcu7t3v3__buff_2
Xfanout484 VDD VDD VSS VSS fanout485/Y _4573_/A gf180mcu_as_sc_mcu7t3v3__buff_2
XFILLER_171_66 VDD VDD VSS VSS gf180mcu_as_sc_mcu7t3v3__fillcap_4
Xfanout495 VDD VDD VSS VSS _3707_/B _3753_/B gf180mcu_as_sc_mcu7t3v3__buff_2
XFILLER_171_88 VDD VDD VSS VSS gf180mcu_as_sc_mcu7t3v3__fillcap_16
XFILLER_128_1534 VDD VDD VSS VSS gf180mcu_as_sc_mcu7t3v3__fillcap_8
XFILLER_73_198 VDD VDD VSS VSS gf180mcu_as_sc_mcu7t3v3__fill_1
XTAP_TAPCELL_ROW_142_1374 VDD VSS gf180mcu_as_sc_mcu7t3v3__tap_2
XFILLER_128_1556 VDD VDD VSS VSS gf180mcu_as_sc_mcu7t3v3__fill_2
XTAP_TAPCELL_ROW_177_2149 VDD VSS gf180mcu_as_sc_mcu7t3v3__tap_2
XTAP_TAPCELL_ROW_142_1385 VDD VSS gf180mcu_as_sc_mcu7t3v3__tap_2
XFILLER_163_1469 VDD VDD VSS VSS gf180mcu_as_sc_mcu7t3v3__fill_1
XFILLER_175_708 VDD VDD VSS VSS gf180mcu_as_sc_mcu7t3v3__fillcap_8
XFILLER_161_1160 VDD VDD VSS VSS gf180mcu_as_sc_mcu7t3v3__fill_2
XFILLER_156_944 VDD VDD VSS VSS gf180mcu_as_sc_mcu7t3v3__fill_1
XFILLER_168_793 VDD VDD VSS VSS gf180mcu_as_sc_mcu7t3v3__fillcap_8
XFILLER_127_134 VDD VDD VSS VSS gf180mcu_as_sc_mcu7t3v3__fillcap_4
XFILLER_155_454 VDD VDD VSS VSS gf180mcu_as_sc_mcu7t3v3__fillcap_16
XFILLER_156_999 VDD VDD VSS VSS gf180mcu_as_sc_mcu7t3v3__fillcap_4
XFILLER_182_251 VDD VDD VSS VSS gf180mcu_as_sc_mcu7t3v3__fill_1
XFILLER_183_774 VDD VDD VSS VSS gf180mcu_as_sc_mcu7t3v3__fillcap_8
XTAP_TAPCELL_ROW_26_1_738 VDD VSS gf180mcu_as_sc_mcu7t3v3__tap_2
XFILLER_13_1483 VDD VDD VSS VSS gf180mcu_as_sc_mcu7t3v3__fillcap_16
XFILLER_170_435 VDD VDD VSS VSS gf180mcu_as_sc_mcu7t3v3__fillcap_16
XFILLER_48_1502 VDD VDD VSS VSS gf180mcu_as_sc_mcu7t3v3__fillcap_16
XTAP_TAPCELL_ROW_92_1_1002 VDD VSS gf180mcu_as_sc_mcu7t3v3__tap_2
XFILLER_100_1486 VDD VDD VSS VSS gf180mcu_as_sc_mcu7t3v3__fillcap_16
XFILLER_170_457 VDD VDD VSS VSS gf180mcu_as_sc_mcu7t3v3__fillcap_16
XFILLER_182_295 VDD VDD VSS VSS gf180mcu_as_sc_mcu7t3v3__fillcap_16
XFILLER_89_72 VDD VDD VSS VSS gf180mcu_as_sc_mcu7t3v3__fillcap_16
XTAP_TAPCELL_ROW_34_1_773 VDD VSS gf180mcu_as_sc_mcu7t3v3__tap_2
XFILLER_48_1568 VDD VDD VSS VSS gf180mcu_as_sc_mcu7t3v3__fill_1
XTAP_TAPCELL_ROW_149_1539 VDD VSS gf180mcu_as_sc_mcu7t3v3__tap_2
XTAP_TAPCELL_ROW_149_1528 VDD VSS gf180mcu_as_sc_mcu7t3v3__tap_2
X_4020_ VDD VDD VSS VSS _4988_/Q _4092_/B _4239_/B _4092_/D _4988_/D gf180mcu_as_sc_mcu7t3v3__ao22_2
XPHY_EDGE_ROW_95_3_Right_414 VDD VSS gf180mcu_as_sc_mcu7t3v3__tap_2
XFILLER_168_1347 VDD VDD VSS VSS gf180mcu_as_sc_mcu7t3v3__fillcap_16
X_4922_ VDD VDD VSS VSS _5183_/CLK _4922_/D _4922_/Q gf180mcu_as_sc_mcu7t3v3__dfxtp_2
XFILLER_178_524 VDD VDD VSS VSS gf180mcu_as_sc_mcu7t3v3__fill_1
XFILLER_178_535 VDD VDD VSS VSS gf180mcu_as_sc_mcu7t3v3__fillcap_4
XFILLER_181_1558 VDD VDD VSS VSS gf180mcu_as_sc_mcu7t3v3__fill_2
X_4853_ VDD VDD VSS VSS _4863_/CLK _4853_/D _4853_/Q gf180mcu_as_sc_mcu7t3v3__dfxtp_2
X_4784_ VDD VDD VSS VSS _4904_/CLK _4784_/D _4784_/Q gf180mcu_as_sc_mcu7t3v3__dfxtp_2
X_3804_ VDD VDD VSS VSS _3804_/B _3804_/A _4869_/D gf180mcu_as_sc_mcu7t3v3__and2_2
X_3735_ VDD VDD VSS VSS _4937_/Q _3762_/B _3747_/B _4111_/A _3736_/D gf180mcu_as_sc_mcu7t3v3__ao22_2
XFILLER_118_134 VDD VDD VSS VSS gf180mcu_as_sc_mcu7t3v3__fillcap_16
XFILLER_140_1288 VDD VDD VSS VSS gf180mcu_as_sc_mcu7t3v3__fillcap_4
XFILLER_146_454 VDD VDD VSS VSS gf180mcu_as_sc_mcu7t3v3__fill_1
XFILLER_146_465 VDD VDD VSS VSS gf180mcu_as_sc_mcu7t3v3__fill_2
XFILLER_174_763 VDD VDD VSS VSS gf180mcu_as_sc_mcu7t3v3__fill_1
XFILLER_179_1432 VDD VDD VSS VSS gf180mcu_as_sc_mcu7t3v3__fill_2
XPHY_EDGE_ROW_81_3_Left_215 VDD VSS gf180mcu_as_sc_mcu7t3v3__tap_2
XFILLER_134_638 VDD VDD VSS VSS gf180mcu_as_sc_mcu7t3v3__fillcap_8
XFILLER_146_498 VDD VDD VSS VSS gf180mcu_as_sc_mcu7t3v3__fill_2
XFILLER_161_402 VDD VDD VSS VSS gf180mcu_as_sc_mcu7t3v3__fillcap_16
XFILLER_162_947 VDD VDD VSS VSS gf180mcu_as_sc_mcu7t3v3__fill_2
X_3666_ VDD VDD VSS VSS _3666_/D _4037_/A _3736_/B _3728_/C _3667_/C gf180mcu_as_sc_mcu7t3v3__ao31_2
XFILLER_133_148 VDD VDD VSS VSS gf180mcu_as_sc_mcu7t3v3__fill_1
XFILLER_162_969 VDD VDD VSS VSS gf180mcu_as_sc_mcu7t3v3__fillcap_16
X_3597_ VDD VDD VSS VSS _3965_/D _3742_/B _3597_/C _3597_/D _3598_/C gf180mcu_as_sc_mcu7t3v3__ao211_2
X_2617_ VDD VDD VSS VSS _2643_/C _2634_/B gf180mcu_as_sc_mcu7t3v3__inv_2
XFILLER_138_1140 VDD VDD VSS VSS gf180mcu_as_sc_mcu7t3v3__fill_1
XFILLER_138_1173 VDD VDD VSS VSS gf180mcu_as_sc_mcu7t3v3__fillcap_4
XFILLER_173_1042 VDD VDD VSS VSS gf180mcu_as_sc_mcu7t3v3__fillcap_8
X_2548_ VDD VDD VSS VSS _2556_/B _5222_/Q _4634_/A gf180mcu_as_sc_mcu7t3v3__nand2_2
XFILLER_142_693 VDD VDD VSS VSS gf180mcu_as_sc_mcu7t3v3__fill_2
XFILLER_170_991 VDD VDD VSS VSS gf180mcu_as_sc_mcu7t3v3__fillcap_8
XFILLER_87_224 VDD VDD VSS VSS gf180mcu_as_sc_mcu7t3v3__fillcap_4
X_5267_ VDD VDD VSS VSS clkload8/A _5267_/D _5267_/Q gf180mcu_as_sc_mcu7t3v3__dfxtp_2
X_4218_ VDD VDD VSS VSS _4247_/B _4218_/B _4221_/C _5054_/Q _5054_/D gf180mcu_as_sc_mcu7t3v3__ao22_2
X_2479_ VDD VDD VSS VSS _5272_/Q _5273_/Q _4291_/A gf180mcu_as_sc_mcu7t3v3__or2_2
X_5198_ VDD VDD VSS VSS _5199_/CLK _5198_/D _5198_/Q gf180mcu_as_sc_mcu7t3v3__dfxtp_2
XTAP_TAPCELL_ROW_43_1_808 VDD VSS gf180mcu_as_sc_mcu7t3v3__tap_2
X_4149_ VDD VDD VSS VSS _4149_/B _4165_/A _4255_/B gf180mcu_as_sc_mcu7t3v3__and2_2
XFILLER_99_1499 VDD VDD VSS VSS gf180mcu_as_sc_mcu7t3v3__fillcap_16
XFILLER_55_187 VDD VDD VSS VSS gf180mcu_as_sc_mcu7t3v3__fillcap_16
XFILLER_145_1122 VDD VDD VSS VSS gf180mcu_as_sc_mcu7t3v3__fillcap_8
XFILLER_34_34 VDD VDD VSS VSS gf180mcu_as_sc_mcu7t3v3__fill_1
XFILLER_169_546 VDD VDD VSS VSS gf180mcu_as_sc_mcu7t3v3__fill_2
XFILLER_34_89 VDD VDD VSS VSS gf180mcu_as_sc_mcu7t3v3__fill_2
X_4898__969 VDD VDD VSS VSS _4898_/D gf180mcu_as_sc_mcu7t3v3__tiel_4
XFILLER_138_922 VDD VDD VSS VSS gf180mcu_as_sc_mcu7t3v3__fillcap_16
XFILLER_138_944 VDD VDD VSS VSS gf180mcu_as_sc_mcu7t3v3__fill_1
XFILLER_138_955 VDD VDD VSS VSS gf180mcu_as_sc_mcu7t3v3__fill_1
XFILLER_36_1483 VDD VDD VSS VSS gf180mcu_as_sc_mcu7t3v3__fill_1
XFILLER_50_33 VDD VDD VSS VSS gf180mcu_as_sc_mcu7t3v3__fill_2
XFILLER_7_206 VDD VDD VSS VSS gf180mcu_as_sc_mcu7t3v3__fillcap_4
XFILLER_7_228 VDD VDD VSS VSS gf180mcu_as_sc_mcu7t3v3__fillcap_16
Xclkload0 VDD VDD VSS VSS clkload0/Y clkload0/A gf180mcu_as_sc_mcu7t3v3__inv_4
XTAP_TAPCELL_ROW_66_1_898 VDD VSS gf180mcu_as_sc_mcu7t3v3__tap_2
XTAP_TAPCELL_ROW_172_2046 VDD VSS gf180mcu_as_sc_mcu7t3v3__tap_2
XTAP_TAPCELL_ROW_172_2035 VDD VSS gf180mcu_as_sc_mcu7t3v3__tap_2
XFILLER_137_465 VDD VDD VSS VSS gf180mcu_as_sc_mcu7t3v3__fillcap_4
XFILLER_119_2 VDD VDD VSS VSS gf180mcu_as_sc_mcu7t3v3__fillcap_16
XFILLER_124_104 VDD VDD VSS VSS gf180mcu_as_sc_mcu7t3v3__fill_1
XFILLER_124_115 VDD VDD VSS VSS gf180mcu_as_sc_mcu7t3v3__fill_2
XFILLER_137_487 VDD VDD VSS VSS gf180mcu_as_sc_mcu7t3v3__fill_2
XFILLER_138_999 VDD VDD VSS VSS gf180mcu_as_sc_mcu7t3v3__fillcap_4
XFILLER_152_402 VDD VDD VSS VSS gf180mcu_as_sc_mcu7t3v3__fillcap_16
XFILLER_152_457 VDD VDD VSS VSS gf180mcu_as_sc_mcu7t3v3__fillcap_16
XFILLER_180_777 VDD VDD VSS VSS gf180mcu_as_sc_mcu7t3v3__fillcap_8
XFILLER_1_2 VDD VDD VSS VSS gf180mcu_as_sc_mcu7t3v3__fillcap_16
XFILLER_59_20 VDD VDD VSS VSS gf180mcu_as_sc_mcu7t3v3__fillcap_16
X_4835__997 VDD VDD VSS VSS _4835_/D gf180mcu_as_sc_mcu7t3v3__tiel_4
XTAP_TAPCELL_ROW_22_1_722 VDD VSS gf180mcu_as_sc_mcu7t3v3__tap_2
XFILLER_132_170 VDD VDD VSS VSS gf180mcu_as_sc_mcu7t3v3__fillcap_4
XFILLER_78_213 VDD VDD VSS VSS gf180mcu_as_sc_mcu7t3v3__fill_1
XFILLER_78_279 VDD VDD VSS VSS gf180mcu_as_sc_mcu7t3v3__fillcap_16
XFILLER_93_205 VDD VDD VSS VSS gf180mcu_as_sc_mcu7t3v3__fillcap_4
XTAP_TAPCELL_ROW_144_1425 VDD VSS gf180mcu_as_sc_mcu7t3v3__tap_2
XTAP_TAPCELL_ROW_144_1414 VDD VSS gf180mcu_as_sc_mcu7t3v3__tap_2
XFILLER_131_80 VDD VDD VSS VSS gf180mcu_as_sc_mcu7t3v3__fillcap_8
XTAP_TAPCELL_ROW_161_1794 VDD VSS gf180mcu_as_sc_mcu7t3v3__tap_2
XFILLER_163_1233 VDD VDD VSS VSS gf180mcu_as_sc_mcu7t3v3__fillcap_16
XFILLER_54_1550 VDD VDD VSS VSS gf180mcu_as_sc_mcu7t3v3__fillcap_4
XFILLER_144_914 VDD VDD VSS VSS gf180mcu_as_sc_mcu7t3v3__fillcap_16
X_3520_ VDD VDD VSS VSS _3520_/A _3520_/B _3520_/C _3520_/D _3521_/C gf180mcu_as_sc_mcu7t3v3__ao211_2
XFILLER_143_402 VDD VDD VSS VSS gf180mcu_as_sc_mcu7t3v3__fillcap_16
XFILLER_144_947 VDD VDD VSS VSS gf180mcu_as_sc_mcu7t3v3__fill_2
XFILLER_183_582 VDD VDD VSS VSS gf180mcu_as_sc_mcu7t3v3__fill_1
XFILLER_155_295 VDD VDD VSS VSS gf180mcu_as_sc_mcu7t3v3__fillcap_8
X_3451_ VDD VDD VSS VSS _4101_/A _3451_/B _3451_/C _3451_/D _3452_/A gf180mcu_as_sc_mcu7t3v3__ao211_2
XFILLER_135_1302 VDD VDD VSS VSS gf180mcu_as_sc_mcu7t3v3__fillcap_16
XFILLER_171_777 VDD VDD VSS VSS gf180mcu_as_sc_mcu7t3v3__fillcap_8
X_3382_ VDD VDD VSS VSS _4032_/A _3467_/C _3469_/B _4033_/A _3383_/C gf180mcu_as_sc_mcu7t3v3__ao22_2
X_2402_ VDD VDD VSS VSS _2815_/A _4976_/Q gf180mcu_as_sc_mcu7t3v3__inv_2
XPHY_EDGE_ROW_29_1_Right_28 VDD VSS gf180mcu_as_sc_mcu7t3v3__tap_2
X_5121_ VDD VDD VSS VSS clkload9/A _5121_/D _5121_/Q gf180mcu_as_sc_mcu7t3v3__dfxtp_2
XFILLER_170_1237 VDD VDD VSS VSS gf180mcu_as_sc_mcu7t3v3__fillcap_4
XFILLER_170_1259 VDD VDD VSS VSS gf180mcu_as_sc_mcu7t3v3__fillcap_8
XFILLER_61_1521 VDD VDD VSS VSS gf180mcu_as_sc_mcu7t3v3__fillcap_16
XTAP_TAPCELL_ROW_83_1_968 VDD VSS gf180mcu_as_sc_mcu7t3v3__tap_2
XTAP_TAPCELL_ROW_168_1959 VDD VSS gf180mcu_as_sc_mcu7t3v3__tap_2
XTAP_TAPCELL_ROW_168_1948 VDD VSS gf180mcu_as_sc_mcu7t3v3__tap_2
XFILLER_69_279 VDD VDD VSS VSS gf180mcu_as_sc_mcu7t3v3__fill_1
X_5052_ VDD VDD VSS VSS _5052_/CLK _5052_/D _5052_/Q gf180mcu_as_sc_mcu7t3v3__dfxtp_2
XPHY_EDGE_ROW_96_3_Right_415 VDD VSS gf180mcu_as_sc_mcu7t3v3__tap_2
X_4003_ VDD VDD VSS VSS _4003_/A _4124_/B _4003_/C _4237_/B _4091_/D gf180mcu_as_sc_mcu7t3v3__aoi211_2
XFILLER_168_1111 VDD VDD VSS VSS gf180mcu_as_sc_mcu7t3v3__fillcap_4
XFILLER_179_800 VDD VDD VSS VSS gf180mcu_as_sc_mcu7t3v3__fill_1
XFILLER_168_1199 VDD VDD VSS VSS gf180mcu_as_sc_mcu7t3v3__fill_2
XFILLER_59_1483 VDD VDD VSS VSS gf180mcu_as_sc_mcu7t3v3__fillcap_16
XFILLER_142_1306 VDD VDD VSS VSS gf180mcu_as_sc_mcu7t3v3__fillcap_16
XFILLER_179_855 VDD VDD VSS VSS gf180mcu_as_sc_mcu7t3v3__fill_1
X_4905_ VDD VDD VSS VSS _5159_/CLK _4905_/D _4905_/Q gf180mcu_as_sc_mcu7t3v3__dfxtp_2
XFILLER_178_365 VDD VDD VSS VSS gf180mcu_as_sc_mcu7t3v3__fillcap_16
XFILLER_181_1366 VDD VDD VSS VSS gf180mcu_as_sc_mcu7t3v3__fillcap_8
X_4836_ VDD VDD VSS VSS _4869_/CLK _4836_/D _4836_/Q gf180mcu_as_sc_mcu7t3v3__dfxtp_2
XFILLER_178_387 VDD VDD VSS VSS gf180mcu_as_sc_mcu7t3v3__fillcap_16
XFILLER_181_1399 VDD VDD VSS VSS gf180mcu_as_sc_mcu7t3v3__fill_1
XPHY_EDGE_ROW_114_1_Left_566 VDD VSS gf180mcu_as_sc_mcu7t3v3__tap_2
X_4767_ VDD VDD VSS VSS clkload4/A _4767_/D _4767_/Q gf180mcu_as_sc_mcu7t3v3__dfxtp_2
XFILLER_106_104 VDD VDD VSS VSS gf180mcu_as_sc_mcu7t3v3__fill_1
XFILLER_106_115 VDD VDD VSS VSS gf180mcu_as_sc_mcu7t3v3__fillcap_4
XFILLER_179_1251 VDD VDD VSS VSS gf180mcu_as_sc_mcu7t3v3__fill_1
XFILLER_179_1262 VDD VDD VSS VSS gf180mcu_as_sc_mcu7t3v3__fillcap_8
XFILLER_4_209 VDD VDD VSS VSS gf180mcu_as_sc_mcu7t3v3__fillcap_8
XPHY_EDGE_ROW_51_1_Left_503 VDD VSS gf180mcu_as_sc_mcu7t3v3__tap_2
X_4698_ VDD VDD VSS VSS _4733_/C _5482_/A _5255_/Q _4699_/A gf180mcu_as_sc_mcu7t3v3__mux2_2
X_3718_ VDD VDD VSS VSS _3722_/B _3718_/C _3744_/B _4094_/A gf180mcu_as_sc_mcu7t3v3__aoi21_2
XTAP_TAPCELL_ROW_62_1_882 VDD VSS gf180mcu_as_sc_mcu7t3v3__tap_2
XFILLER_146_295 VDD VDD VSS VSS gf180mcu_as_sc_mcu7t3v3__fillcap_16
XFILLER_150_906 VDD VDD VSS VSS gf180mcu_as_sc_mcu7t3v3__fillcap_16
XFILLER_175_1115 VDD VDD VSS VSS gf180mcu_as_sc_mcu7t3v3__fillcap_4
X_3649_ VDD VDD VSS VSS _4024_/A _3716_/B _3719_/C _4024_/D _3650_/D gf180mcu_as_sc_mcu7t3v3__ao22_2
XFILLER_162_777 VDD VDD VSS VSS gf180mcu_as_sc_mcu7t3v3__fillcap_16
XFILLER_20_69 VDD VDD VSS VSS gf180mcu_as_sc_mcu7t3v3__fillcap_16
XFILLER_136_69 VDD VDD VSS VSS gf180mcu_as_sc_mcu7t3v3__fillcap_16
XFILLER_153_1413 VDD VDD VSS VSS gf180mcu_as_sc_mcu7t3v3__fillcap_16
XFILLER_29_34 VDD VDD VSS VSS gf180mcu_as_sc_mcu7t3v3__fillcap_16
Xinput305 VDD VDD VSS VSS west_in[2] _3947_/D gf180mcu_as_sc_mcu7t3v3__buff_2
Xinput316 VDD VDD VSS VSS west_in[9] _4006_/A gf180mcu_as_sc_mcu7t3v3__buff_2
XFILLER_151_1192 VDD VDD VSS VSS gf180mcu_as_sc_mcu7t3v3__fillcap_16
XFILLER_75_249 VDD VDD VSS VSS gf180mcu_as_sc_mcu7t3v3__fill_2
XPHY_EDGE_ROW_4_3_Left_138 VDD VSS gf180mcu_as_sc_mcu7t3v3__tap_2
XFILLER_83_282 VDD VDD VSS VSS gf180mcu_as_sc_mcu7t3v3__fillcap_16
XTAP_TAPCELL_ROW_25_1_737 VDD VSS gf180mcu_as_sc_mcu7t3v3__tap_2
XPHY_EDGE_ROW_75_1_Right_74 VDD VSS gf180mcu_as_sc_mcu7t3v3__tap_2
XFILLER_38_1534 VDD VDD VSS VSS gf180mcu_as_sc_mcu7t3v3__fillcap_16
XFILLER_45_88 VDD VDD VSS VSS gf180mcu_as_sc_mcu7t3v3__fillcap_4
XFILLER_125_1515 VDD VDD VSS VSS gf180mcu_as_sc_mcu7t3v3__fillcap_4
XFILLER_38_1556 VDD VDD VSS VSS gf180mcu_as_sc_mcu7t3v3__fillcap_8
XPHY_EDGE_ROW_46_1_Left_498 VDD VSS gf180mcu_as_sc_mcu7t3v3__tap_2
XFILLER_101_72 VDD VDD VSS VSS gf180mcu_as_sc_mcu7t3v3__fill_1
XFILLER_125_1537 VDD VDD VSS VSS gf180mcu_as_sc_mcu7t3v3__fillcap_16
XFILLER_160_1417 VDD VDD VSS VSS gf180mcu_as_sc_mcu7t3v3__fillcap_16
XFILLER_61_10 VDD VDD VSS VSS gf180mcu_as_sc_mcu7t3v3__fill_1
XFILLER_61_43 VDD VDD VSS VSS gf180mcu_as_sc_mcu7t3v3__fill_2
XFILLER_184_324 VDD VDD VSS VSS gf180mcu_as_sc_mcu7t3v3__fillcap_16
XFILLER_137_251 VDD VDD VSS VSS gf180mcu_as_sc_mcu7t3v3__fill_1
XFILLER_158_1313 VDD VDD VSS VSS gf180mcu_as_sc_mcu7t3v3__fillcap_16
XTAP_TAPCELL_ROW_137_1273 VDD VSS gf180mcu_as_sc_mcu7t3v3__tap_2
XTAP_TAPCELL_ROW_137_1262 VDD VSS gf180mcu_as_sc_mcu7t3v3__tap_2
XFILLER_153_733 VDD VDD VSS VSS gf180mcu_as_sc_mcu7t3v3__fill_1
XFILLER_180_541 VDD VDD VSS VSS gf180mcu_as_sc_mcu7t3v3__fillcap_8
XFILLER_10_1486 VDD VDD VSS VSS gf180mcu_as_sc_mcu7t3v3__fillcap_16
XFILLER_112_107 VDD VDD VSS VSS gf180mcu_as_sc_mcu7t3v3__fillcap_16
XFILLER_141_928 VDD VDD VSS VSS gf180mcu_as_sc_mcu7t3v3__fillcap_16
XFILLER_152_265 VDD VDD VSS VSS gf180mcu_as_sc_mcu7t3v3__fill_1
XFILLER_153_788 VDD VDD VSS VSS gf180mcu_as_sc_mcu7t3v3__fillcap_16
XFILLER_180_563 VDD VDD VSS VSS gf180mcu_as_sc_mcu7t3v3__fillcap_8
XFILLER_3_253 VDD VDD VSS VSS gf180mcu_as_sc_mcu7t3v3__fill_2
XFILLER_126_80 VDD VDD VSS VSS gf180mcu_as_sc_mcu7t3v3__fillcap_16
Xmesh_tile_909 VDD VDD VSS VSS nw_out[16] gf180mcu_as_sc_mcu7t3v3__tiel_4
XFILLER_169_1442 VDD VDD VSS VSS gf180mcu_as_sc_mcu7t3v3__fillcap_16
XTAP_TAPCELL_ROW_163_1845 VDD VSS gf180mcu_as_sc_mcu7t3v3__tap_2
XTAP_TAPCELL_ROW_163_1834 VDD VSS gf180mcu_as_sc_mcu7t3v3__tap_2
XFILLER_34_102 VDD VDD VSS VSS gf180mcu_as_sc_mcu7t3v3__fill_2
XFILLER_165_1328 VDD VDD VSS VSS gf180mcu_as_sc_mcu7t3v3__fill_2
X_2951_ VDD VDD VSS VSS _2952_/C _3178_/A _2951_/B _2951_/C gf180mcu_as_sc_mcu7t3v3__ao21_2
XFILLER_163_1052 VDD VDD VSS VSS gf180mcu_as_sc_mcu7t3v3__fillcap_16
XFILLER_148_527 VDD VDD VSS VSS gf180mcu_as_sc_mcu7t3v3__fillcap_4
XFILLER_148_549 VDD VDD VSS VSS gf180mcu_as_sc_mcu7t3v3__fill_2
X_4621_ VDD VDD VSS VSS _5215_/Q _4629_/B _4629_/C _5216_/Q _5215_/D gf180mcu_as_sc_mcu7t3v3__ao22_2
X_2882_ VDD VDD VSS VSS _2882_/A _2882_/B _2882_/C _2882_/D _4769_/D gf180mcu_as_sc_mcu7t3v3__ao22_2
XFILLER_128_240 VDD VDD VSS VSS gf180mcu_as_sc_mcu7t3v3__fillcap_4
XFILLER_163_508 VDD VDD VSS VSS gf180mcu_as_sc_mcu7t3v3__fillcap_16
XFILLER_175_346 VDD VDD VSS VSS gf180mcu_as_sc_mcu7t3v3__fillcap_4
XFILLER_175_368 VDD VDD VSS VSS gf180mcu_as_sc_mcu7t3v3__fillcap_16
XFILLER_128_251 VDD VDD VSS VSS gf180mcu_as_sc_mcu7t3v3__fill_1
X_4552_ VDD VDD VSS VSS _4553_/C _4552_/C _5055_/Q _4552_/A gf180mcu_as_sc_mcu7t3v3__aoi21b_2
XFILLER_128_295 VDD VDD VSS VSS gf180mcu_as_sc_mcu7t3v3__fillcap_4
XFILLER_143_232 VDD VDD VSS VSS gf180mcu_as_sc_mcu7t3v3__fillcap_16
XFILLER_156_593 VDD VDD VSS VSS gf180mcu_as_sc_mcu7t3v3__fill_2
X_4483_ VDD VDD VSS VSS _4568_/A _5076_/Q _4989_/Q _4484_/A gf180mcu_as_sc_mcu7t3v3__mux2_2
X_3503_ VDD VDD VSS VSS _4159_/D _3503_/B _3514_/B _4163_/A _3504_/D gf180mcu_as_sc_mcu7t3v3__ao22_2
X_3434_ VDD VDD VSS VSS _4934_/Q _3440_/B _3440_/C _4087_/A _3435_/D gf180mcu_as_sc_mcu7t3v3__ao22_2
XFILLER_103_129 VDD VDD VSS VSS gf180mcu_as_sc_mcu7t3v3__fillcap_8
XFILLER_143_298 VDD VDD VSS VSS gf180mcu_as_sc_mcu7t3v3__fillcap_8
XFILLER_170_1001 VDD VDD VSS VSS gf180mcu_as_sc_mcu7t3v3__fill_1
XFILLER_171_585 VDD VDD VSS VSS gf180mcu_as_sc_mcu7t3v3__fill_1
X_3365_ VDD VDD VSS VSS _3452_/S _4016_/D _3365_/A _3367_/B gf180mcu_as_sc_mcu7t3v3__mux2_2
XFILLER_170_1045 VDD VDD VSS VSS gf180mcu_as_sc_mcu7t3v3__fillcap_8
XFILLER_57_216 VDD VDD VSS VSS gf180mcu_as_sc_mcu7t3v3__fill_2
X_4888__979 VDD VDD VSS VSS _4888_/D gf180mcu_as_sc_mcu7t3v3__tiel_4
X_5104_ VDD VDD VSS VSS _5164_/CLK _5104_/D _5104_/Q gf180mcu_as_sc_mcu7t3v3__dfxtp_2
X_3296_ VDD VDD VSS VSS _3944_/A _3462_/A _3296_/C _4806_/D _3706_/D gf180mcu_as_sc_mcu7t3v3__aoi211_2
XFILLER_57_249 VDD VDD VSS VSS gf180mcu_as_sc_mcu7t3v3__fillcap_4
X_5035_ VDD VDD VSS VSS _5094_/CLK _5035_/D _5035_/Q gf180mcu_as_sc_mcu7t3v3__dfxtp_2
XTAP_TAPCELL_ROW_65_1_897 VDD VSS gf180mcu_as_sc_mcu7t3v3__tap_2
XFILLER_122_27 VDD VDD VSS VSS gf180mcu_as_sc_mcu7t3v3__fillcap_8
XPHY_EDGE_ROW_97_3_Right_416 VDD VSS gf180mcu_as_sc_mcu7t3v3__tap_2
XFILLER_65_260 VDD VDD VSS VSS gf180mcu_as_sc_mcu7t3v3__fillcap_4
XFILLER_65_282 VDD VDD VSS VSS gf180mcu_as_sc_mcu7t3v3__fillcap_16
XTAP_TAPCELL_ROW_67_3_2450 VDD VSS gf180mcu_as_sc_mcu7t3v3__tap_2
XFILLER_148_1537 VDD VDD VSS VSS gf180mcu_as_sc_mcu7t3v3__fill_2
XFILLER_183_1428 VDD VDD VSS VSS gf180mcu_as_sc_mcu7t3v3__fill_2
XFILLER_80_241 VDD VDD VSS VSS gf180mcu_as_sc_mcu7t3v3__fillcap_4
XTAP_TAPCELL_ROW_21_1_721 VDD VSS gf180mcu_as_sc_mcu7t3v3__tap_2
XFILLER_142_1103 VDD VDD VSS VSS gf180mcu_as_sc_mcu7t3v3__fillcap_16
XFILLER_33_190 VDD VDD VSS VSS gf180mcu_as_sc_mcu7t3v3__fillcap_16
XFILLER_146_1294 VDD VDD VSS VSS gf180mcu_as_sc_mcu7t3v3__fill_1
X_4819_ VDD VDD VSS VSS _4869_/CLK _4819_/D _4819_/Q gf180mcu_as_sc_mcu7t3v3__dfxtp_2
XTAP_TAPCELL_ROW_126_1_1139 VDD VSS gf180mcu_as_sc_mcu7t3v3__tap_2
XFILLER_119_251 VDD VDD VSS VSS gf180mcu_as_sc_mcu7t3v3__fill_1
XFILLER_135_722 VDD VDD VSS VSS gf180mcu_as_sc_mcu7t3v3__fillcap_16
XFILLER_147_24 VDD VDD VSS VSS gf180mcu_as_sc_mcu7t3v3__fillcap_8
XPHY_EDGE_ROW_169_Right_303 VDD VSS gf180mcu_as_sc_mcu7t3v3__tap_2
XFILLER_120_1467 VDD VDD VSS VSS gf180mcu_as_sc_mcu7t3v3__fillcap_16
XFILLER_135_788 VDD VDD VSS VSS gf180mcu_as_sc_mcu7t3v3__fillcap_8
XFILLER_153_1210 VDD VDD VSS VSS gf180mcu_as_sc_mcu7t3v3__fillcap_4
XTAP_TAPCELL_ROW_106_1_1059 VDD VSS gf180mcu_as_sc_mcu7t3v3__tap_2
XFILLER_0_223 VDD VDD VSS VSS gf180mcu_as_sc_mcu7t3v3__fill_2
XFILLER_163_34 VDD VDD VSS VSS gf180mcu_as_sc_mcu7t3v3__fillcap_16
Xinput102 VDD VDD VSS VSS ne_in[31] _3512_/A gf180mcu_as_sc_mcu7t3v3__buff_2
Xinput113 VDD VDD VSS VSS north_in[10] _4014_/A gf180mcu_as_sc_mcu7t3v3__buff_2
Xinput124 VDD VDD VSS VSS north_in[20] _4095_/A gf180mcu_as_sc_mcu7t3v3__buff_2
Xinput135 VDD VDD VSS VSS north_in[30] _3535_/A gf180mcu_as_sc_mcu7t3v3__buff_2
XFILLER_44_1560 VDD VDD VSS VSS gf180mcu_as_sc_mcu7t3v3__fill_2
Xinput146 VDD VDD VSS VSS nw_in[0] _3926_/A gf180mcu_as_sc_mcu7t3v3__buff_2
Xinput157 VDD VDD VSS VSS nw_in[1] _3939_/A gf180mcu_as_sc_mcu7t3v3__buff_2
Xinput168 VDD VDD VSS VSS nw_in[2] _3948_/A gf180mcu_as_sc_mcu7t3v3__buff_2
Xinput179 VDD VDD VSS VSS nw_in[9] _4008_/A gf180mcu_as_sc_mcu7t3v3__buff_2
XFILLER_158_858 VDD VDD VSS VSS gf180mcu_as_sc_mcu7t3v3__fillcap_16
XFILLER_160_1247 VDD VDD VSS VSS gf180mcu_as_sc_mcu7t3v3__fill_2
XFILLER_164_1383 VDD VDD VSS VSS gf180mcu_as_sc_mcu7t3v3__fillcap_8
XTAP_TAPCELL_ROW_139_1324 VDD VSS gf180mcu_as_sc_mcu7t3v3__tap_2
XTAP_TAPCELL_ROW_139_1313 VDD VSS gf180mcu_as_sc_mcu7t3v3__tap_2
XFILLER_145_508 VDD VDD VSS VSS gf180mcu_as_sc_mcu7t3v3__fillcap_8
XFILLER_157_368 VDD VDD VSS VSS gf180mcu_as_sc_mcu7t3v3__fillcap_4
XFILLER_160_1269 VDD VDD VSS VSS gf180mcu_as_sc_mcu7t3v3__fill_1
XFILLER_51_1553 VDD VDD VSS VSS gf180mcu_as_sc_mcu7t3v3__fillcap_16
XFILLER_158_1121 VDD VDD VSS VSS gf180mcu_as_sc_mcu7t3v3__fillcap_8
XFILLER_172_349 VDD VDD VSS VSS gf180mcu_as_sc_mcu7t3v3__fillcap_16
XFILLER_68_8 VDD VDD VSS VSS gf180mcu_as_sc_mcu7t3v3__fillcap_4
XTAP_TAPCELL_ROW_156_1693 VDD VSS gf180mcu_as_sc_mcu7t3v3__tap_2
XTAP_TAPCELL_ROW_156_1682 VDD VSS gf180mcu_as_sc_mcu7t3v3__tap_2
XFILLER_158_1154 VDD VDD VSS VSS gf180mcu_as_sc_mcu7t3v3__fill_1
XFILLER_125_298 VDD VDD VSS VSS gf180mcu_as_sc_mcu7t3v3__fill_2
XFILLER_181_894 VDD VDD VSS VSS gf180mcu_as_sc_mcu7t3v3__fill_1
XFILLER_140_235 VDD VDD VSS VSS gf180mcu_as_sc_mcu7t3v3__fillcap_8
XFILLER_171_1332 VDD VDD VSS VSS gf180mcu_as_sc_mcu7t3v3__fillcap_16
XFILLER_97_72 VDD VDD VSS VSS gf180mcu_as_sc_mcu7t3v3__fill_1
XFILLER_136_1485 VDD VDD VSS VSS gf180mcu_as_sc_mcu7t3v3__fillcap_16
XFILLER_94_300 VDD VDD VSS VSS gf180mcu_as_sc_mcu7t3v3__fill_1
X_3150_ VDD VDD VSS VSS _4127_/A _3150_/B _3150_/C _4126_/A _3156_/B gf180mcu_as_sc_mcu7t3v3__ao22_2
X_3081_ VDD VDD VSS VSS _3684_/A _3132_/B _3081_/C _4786_/D _3730_/D gf180mcu_as_sc_mcu7t3v3__aoi211_2
XTAP_TAPCELL_ROW_53_1_846 VDD VSS gf180mcu_as_sc_mcu7t3v3__tap_2
XFILLER_47_260 VDD VDD VSS VSS gf180mcu_as_sc_mcu7t3v3__fillcap_16
XFILLER_47_282 VDD VDD VSS VSS gf180mcu_as_sc_mcu7t3v3__fillcap_16
Xclkbuf_3_6_0_clk_regs VDD VDD VSS VSS clkbuf_0_clk_regs/Y clkbuf_3_6_0_clk_regs/Y
+ gf180mcu_as_sc_mcu7t3v3__clkbuff_12
XPHY_EDGE_ROW_90_3_Left_224 VDD VSS gf180mcu_as_sc_mcu7t3v3__tap_2
XFILLER_62_241 VDD VDD VSS VSS gf180mcu_as_sc_mcu7t3v3__fillcap_4
XTAP_TAPCELL_ROW_61_1_881 VDD VSS gf180mcu_as_sc_mcu7t3v3__tap_2
XFILLER_143_1412 VDD VDD VSS VSS gf180mcu_as_sc_mcu7t3v3__fill_1
Xclkbuf_leaf_26_clk_regs VDD VDD VSS VSS clkbuf_3_5_0_clk_regs/Y _5080_/CLK gf180mcu_as_sc_mcu7t3v3__clkbuff_12
X_3983_ VDD VDD VSS VSS _3983_/A _4103_/B _3983_/C _3983_/D _3985_/C gf180mcu_as_sc_mcu7t3v3__ao211_2
XFILLER_15_190 VDD VDD VSS VSS gf180mcu_as_sc_mcu7t3v3__fillcap_16
XFILLER_56_1486 VDD VDD VSS VSS gf180mcu_as_sc_mcu7t3v3__fillcap_16
X_2934_ VDD VDD VSS VSS _3793_/A _3802_/A _3559_/A gf180mcu_as_sc_mcu7t3v3__or2_2
X_2865_ VDD VDD VSS VSS _2865_/B _4764_/Q _2866_/C gf180mcu_as_sc_mcu7t3v3__xnor2_2
XFILLER_157_880 VDD VDD VSS VSS gf180mcu_as_sc_mcu7t3v3__fillcap_8
XFILLER_30_193 VDD VDD VSS VSS gf180mcu_as_sc_mcu7t3v3__fillcap_16
X_4604_ VDD VDD VSS VSS _5198_/Q _4605_/B _4612_/C _5199_/Q _5198_/D gf180mcu_as_sc_mcu7t3v3__ao22_2
X_4535_ VDD VDD VSS VSS _4538_/C _4535_/C _5053_/Q _4536_/S gf180mcu_as_sc_mcu7t3v3__aoi21b_2
X_2796_ VDD VDD VSS VSS _2845_/A _2796_/B _2796_/C _2796_/D _2797_/D gf180mcu_as_sc_mcu7t3v3__ao211_2
XFILLER_172_872 VDD VDD VSS VSS gf180mcu_as_sc_mcu7t3v3__fill_2
XPHY_EDGE_ROW_21_3_Right_340 VDD VSS gf180mcu_as_sc_mcu7t3v3__tap_2
X_4466_ VDD VDD VSS VSS _4469_/C _4466_/B _4589_/A gf180mcu_as_sc_mcu7t3v3__nor2_2
XFILLER_89_138 VDD VDD VSS VSS gf180mcu_as_sc_mcu7t3v3__fill_2
Xfanout803 VDD VDD VSS VSS _3699_/D _3730_/D gf180mcu_as_sc_mcu7t3v3__buff_2
X_4397_ VDD VDD VSS VSS _4397_/B _4591_/A _4398_/D gf180mcu_as_sc_mcu7t3v3__and2_2
X_3417_ VDD VDD VSS VSS _4932_/Q _3465_/B _3465_/C _4071_/A _3418_/C gf180mcu_as_sc_mcu7t3v3__ao22_2
XFILLER_85_300 VDD VDD VSS VSS gf180mcu_as_sc_mcu7t3v3__fill_1
X_3348_ VDD VDD VSS VSS _3349_/A _3997_/D _3468_/B _3348_/C gf180mcu_as_sc_mcu7t3v3__ao21_2
XFILLER_150_1449 VDD VDD VSS VSS gf180mcu_as_sc_mcu7t3v3__fill_1
Xhold1001 VDD VDD VSS VSS hold1035/Y hold1036/A gf180mcu_as_sc_mcu7t3v3__buff_2
Xhold1012 VDD VDD VSS VSS hold1044/Y _4966_/D gf180mcu_as_sc_mcu7t3v3__buff_2
Xhold1023 VDD VDD VSS VSS hold1053/Y _4962_/D gf180mcu_as_sc_mcu7t3v3__buff_2
Xhold1034 VDD VDD VSS VSS _4769_/Q _2882_/B gf180mcu_as_sc_mcu7t3v3__buff_2
Xhold1045 VDD VDD VSS VSS _4970_/Q hold1045/Y gf180mcu_as_sc_mcu7t3v3__buff_2
Xhold1056 VDD VDD VSS VSS _4968_/Q hold1056/Y gf180mcu_as_sc_mcu7t3v3__buff_2
X_3279_ VDD VDD VSS VSS _3502_/B _3925_/A _3279_/A _3288_/A gf180mcu_as_sc_mcu7t3v3__mux2_2
X_5018_ VDD VDD VSS VSS _5173_/CLK _5018_/D _5018_/Q gf180mcu_as_sc_mcu7t3v3__dfxtp_2
XPHY_EDGE_ROW_98_3_Right_417 VDD VSS gf180mcu_as_sc_mcu7t3v3__tap_2
XPHY_EDGE_ROW_134_Right_268 VDD VSS gf180mcu_as_sc_mcu7t3v3__tap_2
XFILLER_148_1367 VDD VDD VSS VSS gf180mcu_as_sc_mcu7t3v3__fillcap_16
XFILLER_35_1515 VDD VDD VSS VSS gf180mcu_as_sc_mcu7t3v3__fillcap_4
XFILLER_74_1564 VDD VDD VSS VSS gf180mcu_as_sc_mcu7t3v3__fillcap_4
XFILLER_35_1537 VDD VDD VSS VSS gf180mcu_as_sc_mcu7t3v3__fillcap_16
XFILLER_42_34 VDD VDD VSS VSS gf180mcu_as_sc_mcu7t3v3__fill_1
XFILLER_122_1518 VDD VDD VSS VSS gf180mcu_as_sc_mcu7t3v3__fillcap_16
XFILLER_158_34 VDD VDD VSS VSS gf180mcu_as_sc_mcu7t3v3__fill_1
XPHY_EDGE_ROW_180_Right_314 VDD VSS gf180mcu_as_sc_mcu7t3v3__tap_2
XTAP_TAPCELL_ROW_70_1_916 VDD VSS gf180mcu_as_sc_mcu7t3v3__tap_2
XFILLER_139_368 VDD VDD VSS VSS gf180mcu_as_sc_mcu7t3v3__fillcap_16
XFILLER_167_699 VDD VDD VSS VSS gf180mcu_as_sc_mcu7t3v3__fill_1
XTAP_TAPCELL_ROW_134_1210 VDD VSS gf180mcu_as_sc_mcu7t3v3__tap_2
XFILLER_101_2 VDD VDD VSS VSS gf180mcu_as_sc_mcu7t3v3__fillcap_8
XFILLER_135_585 VDD VDD VSS VSS gf180mcu_as_sc_mcu7t3v3__fillcap_4
XFILLER_162_360 VDD VDD VSS VSS gf180mcu_as_sc_mcu7t3v3__fill_2
XFILLER_150_544 VDD VDD VSS VSS gf180mcu_as_sc_mcu7t3v3__fillcap_16
XFILLER_88_160 VDD VDD VSS VSS gf180mcu_as_sc_mcu7t3v3__fillcap_4
XFILLER_153_1073 VDD VDD VSS VSS gf180mcu_as_sc_mcu7t3v3__fill_1
XFILLER_67_86 VDD VDD VSS VSS gf180mcu_as_sc_mcu7t3v3__fillcap_4
XFILLER_29_260 VDD VDD VSS VSS gf180mcu_as_sc_mcu7t3v3__fillcap_16
XFILLER_29_282 VDD VDD VSS VSS gf180mcu_as_sc_mcu7t3v3__fillcap_16
XFILLER_166_1423 VDD VDD VSS VSS gf180mcu_as_sc_mcu7t3v3__fillcap_8
XFILLER_166_1467 VDD VDD VSS VSS gf180mcu_as_sc_mcu7t3v3__fillcap_16
XFILLER_44_263 VDD VDD VSS VSS gf180mcu_as_sc_mcu7t3v3__fillcap_16
XFILLER_160_1000 VDD VDD VSS VSS gf180mcu_as_sc_mcu7t3v3__fillcap_4
XPHY_EDGE_ROW_38_1_Right_37 VDD VSS gf180mcu_as_sc_mcu7t3v3__tap_2
XTAP_TAPCELL_ROW_158_1722 VDD VSS gf180mcu_as_sc_mcu7t3v3__tap_2
XFILLER_12_171 VDD VDD VSS VSS gf180mcu_as_sc_mcu7t3v3__fillcap_4
XTAP_TAPCELL_ROW_158_1733 VDD VSS gf180mcu_as_sc_mcu7t3v3__tap_2
XPHY_EDGE_ROW_60_3_Right_379 VDD VSS gf180mcu_as_sc_mcu7t3v3__tap_2
X_4878__989 VDD VDD VSS VSS _4878_/D gf180mcu_as_sc_mcu7t3v3__tiel_4
X_2650_ VDD VDD VSS VSS _2650_/Y _2737_/A _2650_/B _2650_/C _2650_/D gf180mcu_as_sc_mcu7t3v3__aoi22_2
XFILLER_103_1451 VDD VDD VSS VSS gf180mcu_as_sc_mcu7t3v3__fillcap_16
XFILLER_157_198 VDD VDD VSS VSS gf180mcu_as_sc_mcu7t3v3__fillcap_4
XFILLER_154_861 VDD VDD VSS VSS gf180mcu_as_sc_mcu7t3v3__fill_2
XFILLER_160_308 VDD VDD VSS VSS gf180mcu_as_sc_mcu7t3v3__fill_1
XFILLER_177_1552 VDD VDD VSS VSS gf180mcu_as_sc_mcu7t3v3__fill_2
Xoutput406 VDD VDD VSS VSS _4826_/Q south_out[21] gf180mcu_as_sc_mcu7t3v3__buff_2
Xoutput417 VDD VDD VSS VSS _4836_/Q south_out[31] gf180mcu_as_sc_mcu7t3v3__buff_2
X_2581_ VDD VDD VSS VSS _2581_/A _2858_/B _2674_/C _2581_/D _2581_/Y gf180mcu_as_sc_mcu7t3v3__ao211_2
XFILLER_181_680 VDD VDD VSS VSS gf180mcu_as_sc_mcu7t3v3__fill_1
XFILLER_181_691 VDD VDD VSS VSS gf180mcu_as_sc_mcu7t3v3__fill_2
Xoutput428 VDD VDD VSS VSS _4883_/Q west_out[10] gf180mcu_as_sc_mcu7t3v3__buff_2
Xoutput439 VDD VDD VSS VSS _4893_/Q west_out[20] gf180mcu_as_sc_mcu7t3v3__buff_2
X_4320_ VDD VDD VSS VSS _4321_/S _5150_/Q _5149_/Q _5149_/D gf180mcu_as_sc_mcu7t3v3__mux2_2
X_4251_ VDD VDD VSS VSS _4252_/S _4251_/B _5087_/Q _5087_/D gf180mcu_as_sc_mcu7t3v3__mux2_2
XFILLER_67_300 VDD VDD VSS VSS gf180mcu_as_sc_mcu7t3v3__fill_1
X_3202_ VDD VDD VSS VSS _3210_/B _3202_/B _3790_/A gf180mcu_as_sc_mcu7t3v3__nand2_2
X_4182_ VDD VDD VSS VSS _4242_/B _4188_/B _4188_/C _5020_/Q _5020_/D gf180mcu_as_sc_mcu7t3v3__ao22_2
XPHY_EDGE_ROW_123_1_Left_575 VDD VSS gf180mcu_as_sc_mcu7t3v3__tap_2
X_3133_ VDD VDD VSS VSS _3140_/B _3241_/B _4114_/A gf180mcu_as_sc_mcu7t3v3__nand2_2
XFILLER_94_163 VDD VDD VSS VSS gf180mcu_as_sc_mcu7t3v3__fillcap_4
XFILLER_94_174 VDD VDD VSS VSS gf180mcu_as_sc_mcu7t3v3__fill_1
X_3064_ VDD VDD VSS VSS _3124_/B _3064_/B _3064_/C _3065_/C gf180mcu_as_sc_mcu7t3v3__nor3_2
XFILLER_97_1553 VDD VDD VSS VSS gf180mcu_as_sc_mcu7t3v3__fillcap_8
XTAP_TAPCELL_ROW_35_1_775 VDD VSS gf180mcu_as_sc_mcu7t3v3__tap_2
XFILLER_184_1556 VDD VDD VSS VSS gf180mcu_as_sc_mcu7t3v3__fillcap_4
XPHY_EDGE_ROW_60_1_Left_512 VDD VSS gf180mcu_as_sc_mcu7t3v3__tap_2
XFILLER_169_909 VDD VDD VSS VSS gf180mcu_as_sc_mcu7t3v3__fill_1
XFILLER_143_1231 VDD VDD VSS VSS gf180mcu_as_sc_mcu7t3v3__fill_2
XFILLER_168_419 VDD VDD VSS VSS gf180mcu_as_sc_mcu7t3v3__fillcap_16
XFILLER_177_920 VDD VDD VSS VSS gf180mcu_as_sc_mcu7t3v3__fill_1
XFILLER_182_1280 VDD VDD VSS VSS gf180mcu_as_sc_mcu7t3v3__fill_1
X_3966_ VDD VDD VSS VSS _3966_/A _4127_/B _4110_/C _3966_/D _3970_/A gf180mcu_as_sc_mcu7t3v3__ao211_2
X_2917_ VDD VDD VSS VSS _2930_/A _3233_/C _3236_/B gf180mcu_as_sc_mcu7t3v3__nand2_2
XFILLER_149_699 VDD VDD VSS VSS gf180mcu_as_sc_mcu7t3v3__fill_1
X_3897_ VDD VDD VSS VSS _3897_/B _5187_/Q _4937_/D gf180mcu_as_sc_mcu7t3v3__and2_2
XFILLER_128_37 VDD VDD VSS VSS gf180mcu_as_sc_mcu7t3v3__fill_1
XFILLER_12_37 VDD VDD VSS VSS gf180mcu_as_sc_mcu7t3v3__fillcap_16
X_2848_ VDD VDD VSS VSS _4948_/Q _4952_/D _3868_/C gf180mcu_as_sc_mcu7t3v3__and2_2
XFILLER_30_1467 VDD VDD VSS VSS gf180mcu_as_sc_mcu7t3v3__fillcap_16
X_2779_ VDD VDD VSS VSS _5269_/Q _5275_/Q _4734_/B gf180mcu_as_sc_mcu7t3v3__or2_2
XFILLER_144_371 VDD VDD VSS VSS gf180mcu_as_sc_mcu7t3v3__fillcap_8
XFILLER_145_894 VDD VDD VSS VSS gf180mcu_as_sc_mcu7t3v3__fill_1
XFILLER_151_319 VDD VDD VSS VSS gf180mcu_as_sc_mcu7t3v3__fill_2
XFILLER_172_691 VDD VDD VSS VSS gf180mcu_as_sc_mcu7t3v3__fill_2
X_4518_ VDD VDD VSS VSS _4518_/S _5022_/Q _5051_/Q _4519_/B gf180mcu_as_sc_mcu7t3v3__mux2_2
XFILLER_144_393 VDD VDD VSS VSS gf180mcu_as_sc_mcu7t3v3__fill_1
XFILLER_160_853 VDD VDD VSS VSS gf180mcu_as_sc_mcu7t3v3__fillcap_8
XFILLER_171_190 VDD VDD VSS VSS gf180mcu_as_sc_mcu7t3v3__fillcap_16
XFILLER_176_1084 VDD VDD VSS VSS gf180mcu_as_sc_mcu7t3v3__fill_1
X_4449_ VDD VDD VSS VSS _4449_/D _4510_/A _4449_/B _4449_/C _4450_/B gf180mcu_as_sc_mcu7t3v3__ao31_2
XPHY_EDGE_ROW_84_1_Right_83 VDD VSS gf180mcu_as_sc_mcu7t3v3__tap_2
XFILLER_137_1068 VDD VDD VSS VSS gf180mcu_as_sc_mcu7t3v3__fill_2
XFILLER_58_300 VDD VDD VSS VSS gf180mcu_as_sc_mcu7t3v3__fill_1
XFILLER_77_119 VDD VDD VSS VSS gf180mcu_as_sc_mcu7t3v3__fill_2
XPHY_EDGE_ROW_22_3_Right_341 VDD VSS gf180mcu_as_sc_mcu7t3v3__tap_2
Xfanout600 VDD VDD VSS VSS fanout602/Y _4104_/C gf180mcu_as_sc_mcu7t3v3__buff_2
Xfanout611 VDD VDD VSS VSS _3800_/C _3728_/C gf180mcu_as_sc_mcu7t3v3__buff_2
Xfanout622 VDD VDD VSS VSS _3262_/Y fanout622/Y gf180mcu_as_sc_mcu7t3v3__buff_2
Xfanout633 VDD VDD VSS VSS _4325_/S _4313_/S gf180mcu_as_sc_mcu7t3v3__buff_2
XTAP_TAPCELL_ROW_55_3_2432 VDD VSS gf180mcu_as_sc_mcu7t3v3__tap_2
Xfanout644 VDD VDD VSS VSS _4605_/B _4629_/B gf180mcu_as_sc_mcu7t3v3__buff_2
Xfanout655 VDD VDD VSS VSS _3564_/Y _3747_/B gf180mcu_as_sc_mcu7t3v3__buff_2
Xfanout666 VDD VDD VSS VSS _3932_/Y fanout666/Y gf180mcu_as_sc_mcu7t3v3__buff_2
Xfanout677 VDD VDD VSS VSS _3740_/C _3716_/C gf180mcu_as_sc_mcu7t3v3__buff_2
Xfanout688 VDD VDD VSS VSS _3268_/Y _3465_/C gf180mcu_as_sc_mcu7t3v3__buff_2
Xfanout699 VDD VDD VSS VSS _3250_/Y _3486_/B gf180mcu_as_sc_mcu7t3v3__buff_2
XTAP_TAPCELL_ROW_181_2240 VDD VSS gf180mcu_as_sc_mcu7t3v3__tap_2
XTAP_TAPCELL_ROW_0_1_2344 VDD VSS gf180mcu_as_sc_mcu7t3v3__tap_2
XPHY_EDGE_ROW_99_3_Right_418 VDD VSS gf180mcu_as_sc_mcu7t3v3__tap_2
XFILLER_148_1120 VDD VDD VSS VSS gf180mcu_as_sc_mcu7t3v3__fill_1
XFILLER_183_1000 VDD VDD VSS VSS gf180mcu_as_sc_mcu7t3v3__fill_2
XFILLER_26_241 VDD VDD VSS VSS gf180mcu_as_sc_mcu7t3v3__fillcap_4
XFILLER_26_263 VDD VDD VSS VSS gf180mcu_as_sc_mcu7t3v3__fillcap_8
XFILLER_144_1017 VDD VDD VSS VSS gf180mcu_as_sc_mcu7t3v3__fillcap_16
XFILLER_53_44 VDD VDD VSS VSS gf180mcu_as_sc_mcu7t3v3__fill_1
XFILLER_149_2 VDD VDD VSS VSS gf180mcu_as_sc_mcu7t3v3__fillcap_16
XFILLER_159_419 VDD VDD VSS VSS gf180mcu_as_sc_mcu7t3v3__fill_1
XFILLER_41_244 VDD VDD VSS VSS gf180mcu_as_sc_mcu7t3v3__fillcap_16
XFILLER_53_88 VDD VDD VSS VSS gf180mcu_as_sc_mcu7t3v3__fillcap_4
XTAP_TAPCELL_ROW_179_2191 VDD VSS gf180mcu_as_sc_mcu7t3v3__tap_2
XFILLER_126_1451 VDD VDD VSS VSS gf180mcu_as_sc_mcu7t3v3__fillcap_16
XFILLER_168_942 VDD VDD VSS VSS gf180mcu_as_sc_mcu7t3v3__fill_2
XFILLER_169_66 VDD VDD VSS VSS gf180mcu_as_sc_mcu7t3v3__fillcap_4
XFILLER_169_88 VDD VDD VSS VSS gf180mcu_as_sc_mcu7t3v3__fillcap_16
XFILLER_139_154 VDD VDD VSS VSS gf180mcu_as_sc_mcu7t3v3__fill_2
XTAP_TAPCELL_ROW_175_2099 VDD VSS gf180mcu_as_sc_mcu7t3v3__tap_2
XTAP_TAPCELL_ROW_52_1_845 VDD VSS gf180mcu_as_sc_mcu7t3v3__tap_2
XTAP_TAPCELL_ROW_153_1630 VDD VSS gf180mcu_as_sc_mcu7t3v3__tap_2
XFILLER_135_360 VDD VDD VSS VSS gf180mcu_as_sc_mcu7t3v3__fillcap_4
XFILLER_151_842 VDD VDD VSS VSS gf180mcu_as_sc_mcu7t3v3__fillcap_8
XFILLER_159_1293 VDD VDD VSS VSS gf180mcu_as_sc_mcu7t3v3__fillcap_8
XFILLER_78_41 VDD VDD VSS VSS gf180mcu_as_sc_mcu7t3v3__fill_2
XTAP_TAPCELL_ROW_90_3_2484 VDD VSS gf180mcu_as_sc_mcu7t3v3__tap_2
XFILLER_172_1460 VDD VDD VSS VSS gf180mcu_as_sc_mcu7t3v3__fill_2
XFILLER_49_300 VDD VDD VSS VSS gf180mcu_as_sc_mcu7t3v3__fill_1
XFILLER_78_96 VDD VDD VSS VSS gf180mcu_as_sc_mcu7t3v3__fillcap_8
XFILLER_134_80 VDD VDD VSS VSS gf180mcu_as_sc_mcu7t3v3__fillcap_16
XFILLER_168_1507 VDD VDD VSS VSS gf180mcu_as_sc_mcu7t3v3__fillcap_16
XFILLER_91_133 VDD VDD VSS VSS gf180mcu_as_sc_mcu7t3v3__fillcap_4
XTAP_TAPCELL_ROW_147_1489 VDD VSS gf180mcu_as_sc_mcu7t3v3__tap_2
XFILLER_91_166 VDD VDD VSS VSS gf180mcu_as_sc_mcu7t3v3__fill_2
XFILLER_91_188 VDD VDD VSS VSS gf180mcu_as_sc_mcu7t3v3__fillcap_8
XFILLER_166_1297 VDD VDD VSS VSS gf180mcu_as_sc_mcu7t3v3__fillcap_8
XFILLER_92_1461 VDD VDD VSS VSS gf180mcu_as_sc_mcu7t3v3__fillcap_16
X_3820_ VDD VDD VSS VSS _3821_/C _3820_/B _3915_/A gf180mcu_as_sc_mcu7t3v3__nor2_2
XFILLER_144_1540 VDD VDD VSS VSS gf180mcu_as_sc_mcu7t3v3__fill_1
XFILLER_32_299 VDD VDD VSS VSS gf180mcu_as_sc_mcu7t3v3__fill_2
XFILLER_92_1483 VDD VDD VSS VSS gf180mcu_as_sc_mcu7t3v3__fill_1
X_3751_ VDD VDD VSS VSS _4126_/D _3751_/B _3751_/C _3751_/D _3752_/D gf180mcu_as_sc_mcu7t3v3__ao211_2
XTAP_TAPCELL_ROW_127_1_1144 VDD VSS gf180mcu_as_sc_mcu7t3v3__tap_2
XFILLER_140_1426 VDD VDD VSS VSS gf180mcu_as_sc_mcu7t3v3__fillcap_8
XFILLER_173_400 VDD VDD VSS VSS gf180mcu_as_sc_mcu7t3v3__fillcap_16
XFILLER_53_1467 VDD VDD VSS VSS gf180mcu_as_sc_mcu7t3v3__fillcap_16
X_2702_ VDD VDD VSS VSS _2832_/S _2702_/B _2702_/A _2702_/Y gf180mcu_as_sc_mcu7t3v3__mux2_2
XFILLER_173_422 VDD VDD VSS VSS gf180mcu_as_sc_mcu7t3v3__fillcap_16
X_3682_ VDD VDD VSS VSS _3683_/C _3682_/C _3729_/B _4057_/A gf180mcu_as_sc_mcu7t3v3__aoi21_2
XFILLER_174_967 VDD VDD VSS VSS gf180mcu_as_sc_mcu7t3v3__fill_1
XFILLER_64_2 VDD VDD VSS VSS gf180mcu_as_sc_mcu7t3v3__fill_2
X_2633_ VDD VDD VSS VSS _4646_/C _5232_/Q _5229_/Q _2776_/A _2634_/C gf180mcu_as_sc_mcu7t3v3__ao31_2
XFILLER_161_628 VDD VDD VSS VSS gf180mcu_as_sc_mcu7t3v3__fill_2
X_2564_ VDD VDD VSS VSS _2564_/Y _2565_/B _2730_/A gf180mcu_as_sc_mcu7t3v3__nor2_2
XFILLER_173_1213 VDD VDD VSS VSS gf180mcu_as_sc_mcu7t3v3__fillcap_4
X_4303_ VDD VDD VSS VSS _4305_/S _5133_/Q _5132_/Q _5132_/D gf180mcu_as_sc_mcu7t3v3__mux2_2
XTAP_TAPCELL_ROW_107_1_1064 VDD VSS gf180mcu_as_sc_mcu7t3v3__tap_2
XFILLER_141_352 VDD VDD VSS VSS gf180mcu_as_sc_mcu7t3v3__fillcap_8
XFILLER_99_277 VDD VDD VSS VSS gf180mcu_as_sc_mcu7t3v3__fill_2
X_5283_ VDD VDD VSS VSS clkload1/A _5283_/D _5283_/Q gf180mcu_as_sc_mcu7t3v3__dfxtp_2
X_2495_ VDD VDD VSS VSS _4954_/D _4594_/A _2495_/A gf180mcu_as_sc_mcu7t3v3__nor2b_2
X_4234_ VDD VDD VSS VSS _4248_/S _4234_/B _5070_/Q _5070_/D gf180mcu_as_sc_mcu7t3v3__mux2_2
XFILLER_67_130 VDD VDD VSS VSS gf180mcu_as_sc_mcu7t3v3__fillcap_8
X_4165_ VDD VDD VSS VSS _4165_/B _4165_/A _4257_/B gf180mcu_as_sc_mcu7t3v3__and2_2
X_3116_ VDD VDD VSS VSS _4790_/D _3116_/C _3132_/B _4091_/A gf180mcu_as_sc_mcu7t3v3__aoi21_2
X_4096_ VDD VDD VSS VSS _4096_/A _4121_/B _4121_/C _4096_/D _4097_/D gf180mcu_as_sc_mcu7t3v3__ao22_2
XFILLER_149_1451 VDD VDD VSS VSS gf180mcu_as_sc_mcu7t3v3__fill_1
XFILLER_184_1320 VDD VDD VSS VSS gf180mcu_as_sc_mcu7t3v3__fillcap_4
XFILLER_82_166 VDD VDD VSS VSS gf180mcu_as_sc_mcu7t3v3__fillcap_8
XFILLER_82_177 VDD VDD VSS VSS gf180mcu_as_sc_mcu7t3v3__fill_1
X_3047_ VDD VDD VSS VSS _4025_/A _3147_/B _3047_/C _3047_/D _3048_/C gf180mcu_as_sc_mcu7t3v3__ao22_2
XFILLER_82_188 VDD VDD VSS VSS gf180mcu_as_sc_mcu7t3v3__fillcap_16
XFILLER_145_1348 VDD VDD VSS VSS gf180mcu_as_sc_mcu7t3v3__fillcap_8
XFILLER_23_244 VDD VDD VSS VSS gf180mcu_as_sc_mcu7t3v3__fillcap_16
X_4998_ VDD VDD VSS VSS _5085_/CLK _4998_/D _4998_/Q gf180mcu_as_sc_mcu7t3v3__dfxtp_2
XFILLER_135_8 VDD VDD VSS VSS gf180mcu_as_sc_mcu7t3v3__fillcap_16
XFILLER_177_772 VDD VDD VSS VSS gf180mcu_as_sc_mcu7t3v3__fillcap_16
XFILLER_183_208 VDD VDD VSS VSS gf180mcu_as_sc_mcu7t3v3__fill_2
XFILLER_32_1518 VDD VDD VSS VSS gf180mcu_as_sc_mcu7t3v3__fillcap_16
X_3949_ VDD VDD VSS VSS _4159_/C _3949_/A _3951_/C gf180mcu_as_sc_mcu7t3v3__and2_2
XFILLER_165_945 VDD VDD VSS VSS gf180mcu_as_sc_mcu7t3v3__fillcap_4
XFILLER_136_168 VDD VDD VSS VSS gf180mcu_as_sc_mcu7t3v3__fillcap_4
XFILLER_178_1157 VDD VDD VSS VSS gf180mcu_as_sc_mcu7t3v3__fillcap_4
XFILLER_160_683 VDD VDD VSS VSS gf180mcu_as_sc_mcu7t3v3__fillcap_16
XPHY_EDGE_ROW_23_3_Right_342 VDD VSS gf180mcu_as_sc_mcu7t3v3__tap_2
XFILLER_171_34 VDD VDD VSS VSS gf180mcu_as_sc_mcu7t3v3__fillcap_16
Xfanout474 VDD VDD VSS VSS _3913_/Y _4125_/B gf180mcu_as_sc_mcu7t3v3__buff_2
XFILLER_58_174 VDD VDD VSS VSS gf180mcu_as_sc_mcu7t3v3__fill_1
Xfanout485 VDD VDD VSS VSS _4347_/Y fanout485/Y gf180mcu_as_sc_mcu7t3v3__buff_2
Xfanout496 VDD VDD VSS VSS _3803_/B _3707_/B gf180mcu_as_sc_mcu7t3v3__buff_2
XFILLER_0_18 VDD VDD VSS VSS gf180mcu_as_sc_mcu7t3v3__fillcap_16
XFILLER_104_50 VDD VDD VSS VSS gf180mcu_as_sc_mcu7t3v3__fill_2
XFILLER_150_1087 VDD VDD VSS VSS gf180mcu_as_sc_mcu7t3v3__fillcap_16
XFILLER_64_32 VDD VDD VSS VSS gf180mcu_as_sc_mcu7t3v3__fill_2
XFILLER_128_1502 VDD VDD VSS VSS gf180mcu_as_sc_mcu7t3v3__fillcap_16
XFILLER_73_188 VDD VDD VSS VSS gf180mcu_as_sc_mcu7t3v3__fillcap_8
XTAP_TAPCELL_ROW_142_1375 VDD VSS gf180mcu_as_sc_mcu7t3v3__tap_2
XFILLER_128_1546 VDD VDD VSS VSS gf180mcu_as_sc_mcu7t3v3__fill_2
XFILLER_76_1467 VDD VDD VSS VSS gf180mcu_as_sc_mcu7t3v3__fillcap_16
XTAP_TAPCELL_ROW_142_1386 VDD VSS gf180mcu_as_sc_mcu7t3v3__tap_2
XFILLER_159_249 VDD VDD VSS VSS gf180mcu_as_sc_mcu7t3v3__fillcap_4
XFILLER_163_1459 VDD VDD VSS VSS gf180mcu_as_sc_mcu7t3v3__fillcap_8
XFILLER_14_299 VDD VDD VSS VSS gf180mcu_as_sc_mcu7t3v3__fill_2
XFILLER_155_422 VDD VDD VSS VSS gf180mcu_as_sc_mcu7t3v3__fill_2
XFILLER_167_282 VDD VDD VSS VSS gf180mcu_as_sc_mcu7t3v3__fillcap_16
XFILLER_183_731 VDD VDD VSS VSS gf180mcu_as_sc_mcu7t3v3__fill_2
XFILLER_13_1451 VDD VDD VSS VSS gf180mcu_as_sc_mcu7t3v3__fillcap_16
XFILLER_182_241 VDD VDD VSS VSS gf180mcu_as_sc_mcu7t3v3__fillcap_4
XTAP_TAPCELL_ROW_26_1_739 VDD VSS gf180mcu_as_sc_mcu7t3v3__tap_2
XFILLER_129_80 VDD VDD VSS VSS gf180mcu_as_sc_mcu7t3v3__fillcap_8
XFILLER_143_617 VDD VDD VSS VSS gf180mcu_as_sc_mcu7t3v3__fillcap_8
XFILLER_157_1208 VDD VDD VSS VSS gf180mcu_as_sc_mcu7t3v3__fillcap_8
XFILLER_170_403 VDD VDD VSS VSS gf180mcu_as_sc_mcu7t3v3__fillcap_16
XFILLER_171_948 VDD VDD VSS VSS gf180mcu_as_sc_mcu7t3v3__fill_1
XFILLER_183_786 VDD VDD VSS VSS gf180mcu_as_sc_mcu7t3v3__fill_2
XFILLER_50_8 VDD VDD VSS VSS gf180mcu_as_sc_mcu7t3v3__fill_2
XTAP_TAPCELL_ROW_92_1_1003 VDD VSS gf180mcu_as_sc_mcu7t3v3__tap_2
XFILLER_135_1517 VDD VDD VSS VSS gf180mcu_as_sc_mcu7t3v3__fillcap_16
XFILLER_159_1090 VDD VDD VSS VSS gf180mcu_as_sc_mcu7t3v3__fill_1
XFILLER_174_1555 VDD VDD VSS VSS gf180mcu_as_sc_mcu7t3v3__fillcap_8
XFILLER_96_203 VDD VDD VSS VSS gf180mcu_as_sc_mcu7t3v3__fillcap_8
XFILLER_135_1539 VDD VDD VSS VSS gf180mcu_as_sc_mcu7t3v3__fill_1
XTAP_TAPCELL_ROW_149_1529 VDD VSS gf180mcu_as_sc_mcu7t3v3__tap_2
XFILLER_150_193 VDD VDD VSS VSS gf180mcu_as_sc_mcu7t3v3__fillcap_16
XFILLER_96_247 VDD VDD VSS VSS gf180mcu_as_sc_mcu7t3v3__fillcap_4
XTAP_TAPCELL_ROW_166_1898 VDD VSS gf180mcu_as_sc_mcu7t3v3__tap_2
XFILLER_0_1516 VDD VDD VSS VSS gf180mcu_as_sc_mcu7t3v3__fill_1
XFILLER_64_188 VDD VDD VSS VSS gf180mcu_as_sc_mcu7t3v3__fillcap_8
XFILLER_94_1534 VDD VDD VSS VSS gf180mcu_as_sc_mcu7t3v3__fillcap_8
XFILLER_94_1556 VDD VDD VSS VSS gf180mcu_as_sc_mcu7t3v3__fillcap_4
X_4921_ VDD VDD VSS VSS _5085_/CLK _4921_/D _4921_/Q gf180mcu_as_sc_mcu7t3v3__dfxtp_2
X_4852_ VDD VDD VSS VSS _4904_/CLK _4852_/D _4852_/Q gf180mcu_as_sc_mcu7t3v3__dfxtp_2
X_3803_ VDD VDD VSS VSS _3804_/B _3805_/C _3803_/B _3803_/A gf180mcu_as_sc_mcu7t3v3__aoi21b_2
XFILLER_140_1201 VDD VDD VSS VSS gf180mcu_as_sc_mcu7t3v3__fillcap_16
XFILLER_159_772 VDD VDD VSS VSS gf180mcu_as_sc_mcu7t3v3__fillcap_16
XFILLER_20_225 VDD VDD VSS VSS gf180mcu_as_sc_mcu7t3v3__fillcap_16
XFILLER_20_247 VDD VDD VSS VSS gf180mcu_as_sc_mcu7t3v3__fillcap_16
X_4783_ VDD VDD VSS VSS _4904_/CLK _4783_/D _4783_/Q gf180mcu_as_sc_mcu7t3v3__dfxtp_2
X_3734_ VDD VDD VSS VSS _3738_/B _3734_/C _3750_/B _4110_/A gf180mcu_as_sc_mcu7t3v3__aoi21_2
XTAP_TAPCELL_ROW_80_1_954 VDD VSS gf180mcu_as_sc_mcu7t3v3__tap_2
X_3665_ VDD VDD VSS VSS _4928_/Q _3719_/B _3719_/C _4040_/D _3666_/D gf180mcu_as_sc_mcu7t3v3__ao22_2
X_2616_ VDD VDD VSS VSS _4628_/S _2883_/B _2634_/B gf180mcu_as_sc_mcu7t3v3__and2_2
XFILLER_133_138 VDD VDD VSS VSS gf180mcu_as_sc_mcu7t3v3__fill_2
X_3596_ VDD VDD VSS VSS _3968_/A _3741_/B _3741_/C _3968_/D _3597_/D gf180mcu_as_sc_mcu7t3v3__ao22_2
XFILLER_138_1152 VDD VDD VSS VSS gf180mcu_as_sc_mcu7t3v3__fill_2
X_2547_ VDD VDD VSS VSS _4955_/D _2547_/B _4594_/A gf180mcu_as_sc_mcu7t3v3__nor2_2
XFILLER_134_1038 VDD VDD VSS VSS gf180mcu_as_sc_mcu7t3v3__fillcap_16
XFILLER_141_171 VDD VDD VSS VSS gf180mcu_as_sc_mcu7t3v3__fillcap_4
X_5266_ VDD VDD VSS VSS _5266_/CLK _5266_/D _5266_/Q gf180mcu_as_sc_mcu7t3v3__dfxtp_2
X_2478_ VDD VDD VSS VSS _4947_/Q _2478_/B _2478_/A _5478_/A gf180mcu_as_sc_mcu7t3v3__mux2_2
X_4217_ VDD VDD VSS VSS _4246_/B _4219_/B _4219_/C _5053_/Q _5053_/D gf180mcu_as_sc_mcu7t3v3__ao22_2
XFILLER_116_1483 VDD VDD VSS VSS gf180mcu_as_sc_mcu7t3v3__fill_1
X_5197_ VDD VDD VSS VSS _5199_/CLK _5197_/D _5197_/Q gf180mcu_as_sc_mcu7t3v3__dfxtp_2
XFILLER_99_1467 VDD VDD VSS VSS gf180mcu_as_sc_mcu7t3v3__fillcap_16
X_4148_ VDD VDD VSS VSS _4164_/S _4148_/B _4148_/A _4149_/B gf180mcu_as_sc_mcu7t3v3__mux2_2
XTAP_TAPCELL_ROW_43_1_809 VDD VSS gf180mcu_as_sc_mcu7t3v3__tap_2
XFILLER_18_69 VDD VDD VSS VSS gf180mcu_as_sc_mcu7t3v3__fillcap_16
XFILLER_55_144 VDD VDD VSS VSS gf180mcu_as_sc_mcu7t3v3__fill_1
X_4079_ VDD VDD VSS VSS _4079_/A _4129_/B _4129_/C _4933_/Q _4081_/C gf180mcu_as_sc_mcu7t3v3__ao22_2
XFILLER_70_125 VDD VDD VSS VSS gf180mcu_as_sc_mcu7t3v3__fill_2
XFILLER_149_1270 VDD VDD VSS VSS gf180mcu_as_sc_mcu7t3v3__fill_1
XFILLER_34_24 VDD VDD VSS VSS gf180mcu_as_sc_mcu7t3v3__fillcap_8
XFILLER_145_1134 VDD VDD VSS VSS gf180mcu_as_sc_mcu7t3v3__fill_1
XFILLER_180_1014 VDD VDD VSS VSS gf180mcu_as_sc_mcu7t3v3__fill_1
XFILLER_145_1189 VDD VDD VSS VSS gf180mcu_as_sc_mcu7t3v3__fill_1
XFILLER_36_1451 VDD VDD VSS VSS gf180mcu_as_sc_mcu7t3v3__fillcap_16
XPHY_EDGE_ROW_135_Left_587 VDD VSS gf180mcu_as_sc_mcu7t3v3__tap_2
XFILLER_149_282 VDD VDD VSS VSS gf180mcu_as_sc_mcu7t3v3__fillcap_16
XFILLER_156_219 VDD VDD VSS VSS gf180mcu_as_sc_mcu7t3v3__fillcap_16
XFILLER_162_1492 VDD VDD VSS VSS gf180mcu_as_sc_mcu7t3v3__fillcap_8
XFILLER_184_528 VDD VDD VSS VSS gf180mcu_as_sc_mcu7t3v3__fillcap_16
Xclkload1 VDD VDD VSS VSS clkload1/Y clkload1/A gf180mcu_as_sc_mcu7t3v3__inv_4
XTAP_TAPCELL_ROW_66_1_899 VDD VSS gf180mcu_as_sc_mcu7t3v3__tap_2
XTAP_TAPCELL_ROW_172_2047 VDD VSS gf180mcu_as_sc_mcu7t3v3__tap_2
XTAP_TAPCELL_ROW_172_2036 VDD VSS gf180mcu_as_sc_mcu7t3v3__tap_2
XFILLER_109_135 VDD VDD VSS VSS gf180mcu_as_sc_mcu7t3v3__fillcap_4
XFILLER_164_241 VDD VDD VSS VSS gf180mcu_as_sc_mcu7t3v3__fillcap_4
XFILLER_165_753 VDD VDD VSS VSS gf180mcu_as_sc_mcu7t3v3__fillcap_8
XFILLER_166_34 VDD VDD VSS VSS gf180mcu_as_sc_mcu7t3v3__fill_1
XTAP_TAPCELL_ROW_43_3_2414 VDD VSS gf180mcu_as_sc_mcu7t3v3__tap_2
XFILLER_153_926 VDD VDD VSS VSS gf180mcu_as_sc_mcu7t3v3__fill_1
XFILLER_153_948 VDD VDD VSS VSS gf180mcu_as_sc_mcu7t3v3__fill_1
XFILLER_158_1539 VDD VDD VSS VSS gf180mcu_as_sc_mcu7t3v3__fill_2
XFILLER_164_263 VDD VDD VSS VSS gf180mcu_as_sc_mcu7t3v3__fill_2
XFILLER_180_723 VDD VDD VSS VSS gf180mcu_as_sc_mcu7t3v3__fillcap_8
XFILLER_161_970 VDD VDD VSS VSS gf180mcu_as_sc_mcu7t3v3__fillcap_8
XTAP_TAPCELL_ROW_22_1_723 VDD VSS gf180mcu_as_sc_mcu7t3v3__tap_2
XFILLER_120_300 VDD VDD VSS VSS gf180mcu_as_sc_mcu7t3v3__fill_1
XPHY_EDGE_ROW_144_Left_596 VDD VSS gf180mcu_as_sc_mcu7t3v3__tap_2
XFILLER_182_88 VDD VDD VSS VSS gf180mcu_as_sc_mcu7t3v3__fillcap_4
XFILLER_78_247 VDD VDD VSS VSS gf180mcu_as_sc_mcu7t3v3__fillcap_4
XPHY_EDGE_ROW_24_3_Right_343 VDD VSS gf180mcu_as_sc_mcu7t3v3__tap_2
XPHY_EDGE_ROW_47_1_Right_46 VDD VSS gf180mcu_as_sc_mcu7t3v3__tap_2
XFILLER_43_1499 VDD VDD VSS VSS gf180mcu_as_sc_mcu7t3v3__fillcap_16
XFILLER_78_1518 VDD VDD VSS VSS gf180mcu_as_sc_mcu7t3v3__fillcap_16
XTAP_TAPCELL_ROW_144_1426 VDD VSS gf180mcu_as_sc_mcu7t3v3__tap_2
XTAP_TAPCELL_ROW_144_1415 VDD VSS gf180mcu_as_sc_mcu7t3v3__tap_2
XFILLER_46_144 VDD VDD VSS VSS gf180mcu_as_sc_mcu7t3v3__fill_1
XFILLER_46_188 VDD VDD VSS VSS gf180mcu_as_sc_mcu7t3v3__fillcap_16
XTAP_TAPCELL_ROW_161_1795 VDD VSS gf180mcu_as_sc_mcu7t3v3__tap_2
XFILLER_141_1510 VDD VDD VSS VSS gf180mcu_as_sc_mcu7t3v3__fill_2
XFILLER_163_1278 VDD VDD VSS VSS gf180mcu_as_sc_mcu7t3v3__fillcap_8
XFILLER_91_96 VDD VDD VSS VSS gf180mcu_as_sc_mcu7t3v3__fill_1
XFILLER_156_764 VDD VDD VSS VSS gf180mcu_as_sc_mcu7t3v3__fill_1
XFILLER_183_550 VDD VDD VSS VSS gf180mcu_as_sc_mcu7t3v3__fillcap_8
XPHY_EDGE_ROW_132_1_Left_584 VDD VSS gf180mcu_as_sc_mcu7t3v3__tap_2
XFILLER_155_252 VDD VDD VSS VSS gf180mcu_as_sc_mcu7t3v3__fill_1
XFILLER_171_723 VDD VDD VSS VSS gf180mcu_as_sc_mcu7t3v3__fillcap_8
XFILLER_115_138 VDD VDD VSS VSS gf180mcu_as_sc_mcu7t3v3__fill_2
XFILLER_143_447 VDD VDD VSS VSS gf180mcu_as_sc_mcu7t3v3__fill_1
XFILLER_157_1016 VDD VDD VSS VSS gf180mcu_as_sc_mcu7t3v3__fill_1
XFILLER_157_1027 VDD VDD VSS VSS gf180mcu_as_sc_mcu7t3v3__fillcap_16
XFILLER_6_295 VDD VDD VSS VSS gf180mcu_as_sc_mcu7t3v3__fillcap_4
X_3450_ VDD VDD VSS VSS _3450_/B _4103_/A _3451_/D gf180mcu_as_sc_mcu7t3v3__and2_2
XFILLER_139_1450 VDD VDD VSS VSS gf180mcu_as_sc_mcu7t3v3__fillcap_16
XFILLER_139_1472 VDD VDD VSS VSS gf180mcu_as_sc_mcu7t3v3__fillcap_16
XFILLER_157_1049 VDD VDD VSS VSS gf180mcu_as_sc_mcu7t3v3__fill_1
XFILLER_174_1352 VDD VDD VSS VSS gf180mcu_as_sc_mcu7t3v3__fill_1
X_3381_ VDD VDD VSS VSS _3467_/B _4032_/D _3381_/A _3383_/B gf180mcu_as_sc_mcu7t3v3__mux2_2
X_2401_ VDD VDD VSS VSS _2765_/D _4754_/Q gf180mcu_as_sc_mcu7t3v3__inv_2
XFILLER_111_300 VDD VDD VSS VSS gf180mcu_as_sc_mcu7t3v3__fill_1
XFILLER_123_171 VDD VDD VSS VSS gf180mcu_as_sc_mcu7t3v3__fill_2
XFILLER_170_1205 VDD VDD VSS VSS gf180mcu_as_sc_mcu7t3v3__fillcap_8
X_5120_ VDD VDD VSS VSS _5164_/CLK _5120_/D _5120_/Q gf180mcu_as_sc_mcu7t3v3__dfxtp_2
XFILLER_27_2 VDD VDD VSS VSS gf180mcu_as_sc_mcu7t3v3__fillcap_16
XFILLER_69_247 VDD VDD VSS VSS gf180mcu_as_sc_mcu7t3v3__fillcap_4
X_5051_ VDD VDD VSS VSS _5084_/CLK _5051_/D _5051_/Q gf180mcu_as_sc_mcu7t3v3__dfxtp_2
XTAP_TAPCELL_ROW_83_1_969 VDD VSS gf180mcu_as_sc_mcu7t3v3__tap_2
XTAP_TAPCELL_ROW_168_1949 VDD VSS gf180mcu_as_sc_mcu7t3v3__tap_2
X_4002_ VDD VDD VSS VSS _4003_/C _4002_/B _4002_/A gf180mcu_as_sc_mcu7t3v3__nor2_2
XTAP_TAPCELL_ROW_6_1_660 VDD VSS gf180mcu_as_sc_mcu7t3v3__tap_2
XFILLER_1_50 VDD VDD VSS VSS gf180mcu_as_sc_mcu7t3v3__fillcap_16
XFILLER_1_72 VDD VDD VSS VSS gf180mcu_as_sc_mcu7t3v3__fillcap_16
XFILLER_111_18 VDD VDD VSS VSS gf180mcu_as_sc_mcu7t3v3__fillcap_16
XFILLER_168_1145 VDD VDD VSS VSS gf180mcu_as_sc_mcu7t3v3__fill_1
XFILLER_146_1432 VDD VDD VSS VSS gf180mcu_as_sc_mcu7t3v3__fill_2
XFILLER_59_1451 VDD VDD VSS VSS gf180mcu_as_sc_mcu7t3v3__fillcap_16
XFILLER_178_311 VDD VDD VSS VSS gf180mcu_as_sc_mcu7t3v3__fillcap_4
XFILLER_178_333 VDD VDD VSS VSS gf180mcu_as_sc_mcu7t3v3__fillcap_16
XFILLER_179_834 VDD VDD VSS VSS gf180mcu_as_sc_mcu7t3v3__fillcap_4
XFILLER_181_1323 VDD VDD VSS VSS gf180mcu_as_sc_mcu7t3v3__fill_1
X_4904_ VDD VDD VSS VSS _4904_/CLK _4904_/D _4904_/Q gf180mcu_as_sc_mcu7t3v3__dfxtp_2
XPHY_EDGE_ROW_93_1_Right_92 VDD VSS gf180mcu_as_sc_mcu7t3v3__tap_2
XFILLER_138_208 VDD VDD VSS VSS gf180mcu_as_sc_mcu7t3v3__fill_1
XFILLER_146_1487 VDD VDD VSS VSS gf180mcu_as_sc_mcu7t3v3__fillcap_16
X_4835_ VDD VDD VSS VSS _4943_/CLK _4835_/D _4835_/Q gf180mcu_as_sc_mcu7t3v3__dfxtp_2
XFILLER_147_731 VDD VDD VSS VSS gf180mcu_as_sc_mcu7t3v3__fillcap_8
X_4897__970 VDD VDD VSS VSS _4897_/D gf180mcu_as_sc_mcu7t3v3__tiel_4
X_4766_ VDD VDD VSS VSS clkload4/A _4766_/D _4766_/Q gf180mcu_as_sc_mcu7t3v3__dfxtp_2
XFILLER_140_1053 VDD VDD VSS VSS gf180mcu_as_sc_mcu7t3v3__fill_2
XFILLER_146_241 VDD VDD VSS VSS gf180mcu_as_sc_mcu7t3v3__fillcap_4
X_3717_ VDD VDD VSS VSS _3718_/C _4093_/D _3717_/B _3717_/C gf180mcu_as_sc_mcu7t3v3__ao21_2
XFILLER_146_263 VDD VDD VSS VSS gf180mcu_as_sc_mcu7t3v3__fillcap_8
XFILLER_162_723 VDD VDD VSS VSS gf180mcu_as_sc_mcu7t3v3__fillcap_8
X_4697_ VDD VDD VSS VSS _4707_/S _5253_/Q _4697_/A _5253_/D gf180mcu_as_sc_mcu7t3v3__mux2_2
XTAP_TAPCELL_ROW_62_1_883 VDD VSS gf180mcu_as_sc_mcu7t3v3__tap_2
XFILLER_134_436 VDD VDD VSS VSS gf180mcu_as_sc_mcu7t3v3__fillcap_4
XFILLER_135_948 VDD VDD VSS VSS gf180mcu_as_sc_mcu7t3v3__fill_1
XFILLER_161_233 VDD VDD VSS VSS gf180mcu_as_sc_mcu7t3v3__fill_1
XFILLER_174_594 VDD VDD VSS VSS gf180mcu_as_sc_mcu7t3v3__fill_1
XFILLER_175_1105 VDD VDD VSS VSS gf180mcu_as_sc_mcu7t3v3__fillcap_4
XFILLER_20_37 VDD VDD VSS VSS gf180mcu_as_sc_mcu7t3v3__fillcap_16
X_3648_ VDD VDD VSS VSS _4926_/Q _3719_/B _3716_/C _4023_/A _3650_/C gf180mcu_as_sc_mcu7t3v3__ao22_2
XFILLER_106_149 VDD VDD VSS VSS gf180mcu_as_sc_mcu7t3v3__fillcap_4
XFILLER_136_37 VDD VDD VSS VSS gf180mcu_as_sc_mcu7t3v3__fillcap_16
X_3579_ VDD VDD VSS VSS _3580_/C _3579_/C _3752_/B _3943_/A gf180mcu_as_sc_mcu7t3v3__aoi21_2
XFILLER_114_171 VDD VDD VSS VSS gf180mcu_as_sc_mcu7t3v3__fillcap_4
XFILLER_118_1534 VDD VDD VSS VSS gf180mcu_as_sc_mcu7t3v3__fillcap_16
XFILLER_114_193 VDD VDD VSS VSS gf180mcu_as_sc_mcu7t3v3__fillcap_8
XFILLER_118_1556 VDD VDD VSS VSS gf180mcu_as_sc_mcu7t3v3__fill_1
XFILLER_153_1458 VDD VDD VSS VSS gf180mcu_as_sc_mcu7t3v3__fill_1
Xinput306 VDD VDD VSS VSS west_in[30] _3796_/A gf180mcu_as_sc_mcu7t3v3__buff_2
X_5249_ VDD VDD VSS VSS clkload7/A _5249_/D _5249_/Q gf180mcu_as_sc_mcu7t3v3__dfxtp_2
XFILLER_152_69 VDD VDD VSS VSS gf180mcu_as_sc_mcu7t3v3__fillcap_16
XFILLER_28_155 VDD VDD VSS VSS gf180mcu_as_sc_mcu7t3v3__fillcap_16
XFILLER_90_209 VDD VDD VSS VSS gf180mcu_as_sc_mcu7t3v3__fillcap_4
XFILLER_147_1218 VDD VDD VSS VSS gf180mcu_as_sc_mcu7t3v3__fill_2
XFILLER_28_177 VDD VDD VSS VSS gf180mcu_as_sc_mcu7t3v3__fillcap_16
XFILLER_38_1502 VDD VDD VSS VSS gf180mcu_as_sc_mcu7t3v3__fillcap_16
XFILLER_129_208 VDD VDD VSS VSS gf180mcu_as_sc_mcu7t3v3__fill_2
XFILLER_38_1568 VDD VDD VSS VSS gf180mcu_as_sc_mcu7t3v3__fill_1
XFILLER_138_731 VDD VDD VSS VSS gf180mcu_as_sc_mcu7t3v3__fillcap_4
XFILLER_177_66 VDD VDD VSS VSS gf180mcu_as_sc_mcu7t3v3__fillcap_4
XFILLER_184_358 VDD VDD VSS VSS gf180mcu_as_sc_mcu7t3v3__fillcap_16
XFILLER_61_88 VDD VDD VSS VSS gf180mcu_as_sc_mcu7t3v3__fillcap_4
XFILLER_137_241 VDD VDD VSS VSS gf180mcu_as_sc_mcu7t3v3__fillcap_8
XFILLER_137_263 VDD VDD VSS VSS gf180mcu_as_sc_mcu7t3v3__fillcap_4
XFILLER_153_723 VDD VDD VSS VSS gf180mcu_as_sc_mcu7t3v3__fillcap_8
XFILLER_177_88 VDD VDD VSS VSS gf180mcu_as_sc_mcu7t3v3__fillcap_16
XTAP_TAPCELL_ROW_137_1274 VDD VSS gf180mcu_as_sc_mcu7t3v3__tap_2
XTAP_TAPCELL_ROW_137_1263 VDD VSS gf180mcu_as_sc_mcu7t3v3__tap_2
XFILLER_180_553 VDD VDD VSS VSS gf180mcu_as_sc_mcu7t3v3__fill_2
XPHY_EDGE_ROW_152_Left_604 VDD VSS gf180mcu_as_sc_mcu7t3v3__tap_2
XFILLER_156_1060 VDD VDD VSS VSS gf180mcu_as_sc_mcu7t3v3__fillcap_16
XFILLER_180_597 VDD VDD VSS VSS gf180mcu_as_sc_mcu7t3v3__fill_1
XFILLER_171_1536 VDD VDD VSS VSS gf180mcu_as_sc_mcu7t3v3__fillcap_4
XFILLER_171_1558 VDD VDD VSS VSS gf180mcu_as_sc_mcu7t3v3__fillcap_4
XTAP_TAPCELL_ROW_71_1_918 VDD VSS gf180mcu_as_sc_mcu7t3v3__tap_2
XPHY_EDGE_ROW_25_3_Right_344 VDD VSS gf180mcu_as_sc_mcu7t3v3__tap_2
XTAP_TAPCELL_ROW_163_1846 VDD VSS gf180mcu_as_sc_mcu7t3v3__tap_2
XTAP_TAPCELL_ROW_163_1835 VDD VSS gf180mcu_as_sc_mcu7t3v3__tap_2
XPHY_EDGE_ROW_161_Left_613 VDD VSS gf180mcu_as_sc_mcu7t3v3__tap_2
XFILLER_91_1515 VDD VDD VSS VSS gf180mcu_as_sc_mcu7t3v3__fillcap_4
XFILLER_91_1537 VDD VDD VSS VSS gf180mcu_as_sc_mcu7t3v3__fillcap_16
X_2950_ VDD VDD VSS VSS _3930_/A _3177_/B _3236_/C _3933_/D _2951_/C gf180mcu_as_sc_mcu7t3v3__ao22_2
X_2881_ VDD VDD VSS VSS _4719_/A _4763_/Q _2882_/D gf180mcu_as_sc_mcu7t3v3__and2_2
XFILLER_148_517 VDD VDD VSS VSS gf180mcu_as_sc_mcu7t3v3__fillcap_8
XFILLER_175_314 VDD VDD VSS VSS gf180mcu_as_sc_mcu7t3v3__fillcap_16
X_4620_ VDD VDD VSS VSS _5214_/Q _4629_/B _4629_/C _5215_/Q _5214_/D gf180mcu_as_sc_mcu7t3v3__ao22_2
XTAP_TAPCELL_ROW_96_3_2493 VDD VSS gf180mcu_as_sc_mcu7t3v3__tap_2
XFILLER_128_263 VDD VDD VSS VSS gf180mcu_as_sc_mcu7t3v3__fillcap_4
XFILLER_144_712 VDD VDD VSS VSS gf180mcu_as_sc_mcu7t3v3__fill_1
X_4551_ VDD VDD VSS VSS _4552_/C _4552_/A _5026_/Q _4553_/A gf180mcu_as_sc_mcu7t3v3__ao21_2
XFILLER_144_723 VDD VDD VSS VSS gf180mcu_as_sc_mcu7t3v3__fillcap_8
XFILLER_171_531 VDD VDD VSS VSS gf180mcu_as_sc_mcu7t3v3__fillcap_8
XPHY_EDGE_ROW_170_Left_622 VDD VSS gf180mcu_as_sc_mcu7t3v3__tap_2
Xwire480 VDD VDD VSS VSS _2716_/Y wire480/Y gf180mcu_as_sc_mcu7t3v3__buff_8
X_4482_ VDD VDD VSS VSS _4485_/C _4482_/C _5047_/Q _4568_/A gf180mcu_as_sc_mcu7t3v3__aoi21b_2
X_3502_ VDD VDD VSS VSS _4160_/A _3502_/B _3502_/C _3502_/D _3504_/C gf180mcu_as_sc_mcu7t3v3__ao211_2
XFILLER_89_1499 VDD VDD VSS VSS gf180mcu_as_sc_mcu7t3v3__fillcap_16
XPHY_EDGE_ROW_125_3_Left_259 VDD VSS gf180mcu_as_sc_mcu7t3v3__tap_2
X_3433_ VDD VDD VSS VSS _3450_/B _4088_/A _3435_/C gf180mcu_as_sc_mcu7t3v3__and2_2
XFILLER_106_18 VDD VDD VSS VSS gf180mcu_as_sc_mcu7t3v3__fillcap_16
XFILLER_171_597 VDD VDD VSS VSS gf180mcu_as_sc_mcu7t3v3__fill_2
XFILLER_135_1122 VDD VDD VSS VSS gf180mcu_as_sc_mcu7t3v3__fill_2
XFILLER_170_1013 VDD VDD VSS VSS gf180mcu_as_sc_mcu7t3v3__fill_2
XFILLER_174_1193 VDD VDD VSS VSS gf180mcu_as_sc_mcu7t3v3__fill_2
X_5103_ VDD VDD VSS VSS _5186_/CLK _5103_/D _5103_/Q gf180mcu_as_sc_mcu7t3v3__dfxtp_2
X_3364_ VDD VDD VSS VSS _4013_/A _3451_/B _3364_/C _3364_/D _3365_/A gf180mcu_as_sc_mcu7t3v3__ao211_2
XTAP_TAPCELL_ROW_101_3_2501 VDD VSS gf180mcu_as_sc_mcu7t3v3__tap_2
X_3295_ VDD VDD VSS VSS _3943_/A _3523_/B _3295_/C _3296_/C _3462_/A gf180mcu_as_sc_mcu7t3v3__aoi211_2
XFILLER_26_1483 VDD VDD VSS VSS gf180mcu_as_sc_mcu7t3v3__fill_1
X_5034_ VDD VDD VSS VSS _5094_/CLK _5034_/D _5034_/Q gf180mcu_as_sc_mcu7t3v3__dfxtp_2
XFILLER_25_136 VDD VDD VSS VSS gf180mcu_as_sc_mcu7t3v3__fillcap_4
XFILLER_25_158 VDD VDD VSS VSS gf180mcu_as_sc_mcu7t3v3__fillcap_16
XFILLER_167_815 VDD VDD VSS VSS gf180mcu_as_sc_mcu7t3v3__fillcap_4
XFILLER_40_139 VDD VDD VSS VSS gf180mcu_as_sc_mcu7t3v3__fillcap_16
XTAP_TAPCELL_ROW_114_1_1090 VDD VSS gf180mcu_as_sc_mcu7t3v3__tap_2
XFILLER_139_517 VDD VDD VSS VSS gf180mcu_as_sc_mcu7t3v3__fillcap_4
XFILLER_146_1284 VDD VDD VSS VSS gf180mcu_as_sc_mcu7t3v3__fillcap_8
XFILLER_167_859 VDD VDD VSS VSS gf180mcu_as_sc_mcu7t3v3__fill_1
X_4818_ VDD VDD VSS VSS _4904_/CLK _4818_/D _4818_/Q gf180mcu_as_sc_mcu7t3v3__dfxtp_2
XFILLER_119_241 VDD VDD VSS VSS gf180mcu_as_sc_mcu7t3v3__fillcap_8
X_4749_ VDD VDD VSS VSS _4750_/C _4749_/B _4749_/A gf180mcu_as_sc_mcu7t3v3__nand2_2
XFILLER_119_296 VDD VDD VSS VSS gf180mcu_as_sc_mcu7t3v3__fillcap_4
XFILLER_147_36 VDD VDD VSS VSS gf180mcu_as_sc_mcu7t3v3__fill_2
XFILLER_147_69 VDD VDD VSS VSS gf180mcu_as_sc_mcu7t3v3__fill_1
XFILLER_179_1071 VDD VDD VSS VSS gf180mcu_as_sc_mcu7t3v3__fill_1
XFILLER_134_233 VDD VDD VSS VSS gf180mcu_as_sc_mcu7t3v3__fillcap_4
XFILLER_134_266 VDD VDD VSS VSS gf180mcu_as_sc_mcu7t3v3__fillcap_4
XFILLER_179_1093 VDD VDD VSS VSS gf180mcu_as_sc_mcu7t3v3__fillcap_16
XFILLER_150_737 VDD VDD VSS VSS gf180mcu_as_sc_mcu7t3v3__fillcap_16
X_4871__995 VDD VDD VSS VSS _4871_/D gf180mcu_as_sc_mcu7t3v3__tiel_4
Xinput103 VDD VDD VSS VSS ne_in[32] _3521_/A gf180mcu_as_sc_mcu7t3v3__buff_2
Xinput114 VDD VDD VSS VSS north_in[11] _4023_/A gf180mcu_as_sc_mcu7t3v3__buff_2
Xinput125 VDD VDD VSS VSS north_in[21] _4102_/A gf180mcu_as_sc_mcu7t3v3__buff_2
Xinput136 VDD VDD VSS VSS north_in[31] _3510_/A gf180mcu_as_sc_mcu7t3v3__buff_2
Xinput147 VDD VDD VSS VSS nw_in[10] _4016_/A gf180mcu_as_sc_mcu7t3v3__buff_2
Xinput158 VDD VDD VSS VSS nw_in[20] _4094_/A gf180mcu_as_sc_mcu7t3v3__buff_2
Xinput169 VDD VDD VSS VSS nw_in[30] _3801_/A gf180mcu_as_sc_mcu7t3v3__buff_2
XFILLER_56_33 VDD VDD VSS VSS gf180mcu_as_sc_mcu7t3v3__fill_2
XFILLER_179_2 VDD VDD VSS VSS gf180mcu_as_sc_mcu7t3v3__fillcap_16
XFILLER_56_294 VDD VDD VSS VSS gf180mcu_as_sc_mcu7t3v3__fillcap_4
XFILLER_72_10 VDD VDD VSS VSS gf180mcu_as_sc_mcu7t3v3__fillcap_4
XFILLER_71_264 VDD VDD VSS VSS gf180mcu_as_sc_mcu7t3v3__fillcap_4
XFILLER_72_32 VDD VDD VSS VSS gf180mcu_as_sc_mcu7t3v3__fill_2
XFILLER_158_815 VDD VDD VSS VSS gf180mcu_as_sc_mcu7t3v3__fillcap_4
XFILLER_164_1362 VDD VDD VSS VSS gf180mcu_as_sc_mcu7t3v3__fill_2
XFILLER_72_65 VDD VDD VSS VSS gf180mcu_as_sc_mcu7t3v3__fill_1
XFILLER_157_303 VDD VDD VSS VSS gf180mcu_as_sc_mcu7t3v3__fill_2
XFILLER_169_174 VDD VDD VSS VSS gf180mcu_as_sc_mcu7t3v3__fillcap_16
XTAP_TAPCELL_ROW_139_1325 VDD VSS gf180mcu_as_sc_mcu7t3v3__tap_2
XTAP_TAPCELL_ROW_139_1314 VDD VSS gf180mcu_as_sc_mcu7t3v3__tap_2
XFILLER_160_1259 VDD VDD VSS VSS gf180mcu_as_sc_mcu7t3v3__fillcap_8
XFILLER_184_144 VDD VDD VSS VSS gf180mcu_as_sc_mcu7t3v3__fill_1
XFILLER_51_1521 VDD VDD VSS VSS gf180mcu_as_sc_mcu7t3v3__fillcap_16
XFILLER_172_317 VDD VDD VSS VSS gf180mcu_as_sc_mcu7t3v3__fillcap_16
XTAP_TAPCELL_ROW_156_1694 VDD VSS gf180mcu_as_sc_mcu7t3v3__tap_2
XTAP_TAPCELL_ROW_156_1683 VDD VSS gf180mcu_as_sc_mcu7t3v3__tap_2
XFILLER_158_1133 VDD VDD VSS VSS gf180mcu_as_sc_mcu7t3v3__fill_1
XFILLER_125_277 VDD VDD VSS VSS gf180mcu_as_sc_mcu7t3v3__fill_2
XFILLER_181_884 VDD VDD VSS VSS gf180mcu_as_sc_mcu7t3v3__fillcap_8
XFILLER_136_1420 VDD VDD VSS VSS gf180mcu_as_sc_mcu7t3v3__fillcap_8
XFILLER_136_1453 VDD VDD VSS VSS gf180mcu_as_sc_mcu7t3v3__fillcap_16
XFILLER_140_247 VDD VDD VSS VSS gf180mcu_as_sc_mcu7t3v3__fillcap_16
XFILLER_175_1480 VDD VDD VSS VSS gf180mcu_as_sc_mcu7t3v3__fillcap_4
XFILLER_49_1483 VDD VDD VSS VSS gf180mcu_as_sc_mcu7t3v3__fillcap_16
XFILLER_97_62 VDD VDD VSS VSS gf180mcu_as_sc_mcu7t3v3__fill_1
XFILLER_171_1399 VDD VDD VSS VSS gf180mcu_as_sc_mcu7t3v3__fill_1
XFILLER_39_228 VDD VDD VSS VSS gf180mcu_as_sc_mcu7t3v3__fillcap_16
X_4887__980 VDD VDD VSS VSS _4887_/D gf180mcu_as_sc_mcu7t3v3__tiel_4
X_3080_ VDD VDD VSS VSS _3132_/B _3080_/B _3080_/C _3081_/C gf180mcu_as_sc_mcu7t3v3__nor3_2
XTAP_TAPCELL_ROW_53_1_847 VDD VSS gf180mcu_as_sc_mcu7t3v3__tap_2
XPHY_EDGE_ROW_26_3_Right_345 VDD VSS gf180mcu_as_sc_mcu7t3v3__tap_2
XFILLER_169_1262 VDD VDD VSS VSS gf180mcu_as_sc_mcu7t3v3__fillcap_8
XFILLER_165_1126 VDD VDD VSS VSS gf180mcu_as_sc_mcu7t3v3__fill_1
X_3982_ VDD VDD VSS VSS _3982_/A _4102_/B _4102_/C _4921_/Q _3983_/D gf180mcu_as_sc_mcu7t3v3__ao22_2
XFILLER_143_1402 VDD VDD VSS VSS gf180mcu_as_sc_mcu7t3v3__fillcap_8
XFILLER_22_139 VDD VDD VSS VSS gf180mcu_as_sc_mcu7t3v3__fillcap_16
XFILLER_62_297 VDD VDD VSS VSS gf180mcu_as_sc_mcu7t3v3__fillcap_4
XFILLER_94_2 VDD VDD VSS VSS gf180mcu_as_sc_mcu7t3v3__fillcap_16
X_2933_ VDD VDD VSS VSS _3922_/A _3793_/A _3802_/A gf180mcu_as_sc_mcu7t3v3__nor2_2
XFILLER_164_807 VDD VDD VSS VSS gf180mcu_as_sc_mcu7t3v3__fillcap_8
XFILLER_176_667 VDD VDD VSS VSS gf180mcu_as_sc_mcu7t3v3__fillcap_16
XFILLER_30_150 VDD VDD VSS VSS gf180mcu_as_sc_mcu7t3v3__fillcap_16
X_2864_ VDD VDD VSS VSS _2865_/B _4764_/Q _2868_/B gf180mcu_as_sc_mcu7t3v3__and2_2
XFILLER_136_509 VDD VDD VSS VSS gf180mcu_as_sc_mcu7t3v3__fillcap_16
XFILLER_164_829 VDD VDD VSS VSS gf180mcu_as_sc_mcu7t3v3__fillcap_16
X_4894__973 VDD VDD VSS VSS _4894_/D gf180mcu_as_sc_mcu7t3v3__tiel_4
X_4603_ VDD VDD VSS VSS _5197_/Q _4605_/B _4612_/C _5198_/Q _5197_/D gf180mcu_as_sc_mcu7t3v3__ao22_2
X_2795_ VDD VDD VSS VSS _4643_/B _2845_/D _4703_/B _4626_/A _2796_/D gf180mcu_as_sc_mcu7t3v3__ao31_2
XFILLER_116_211 VDD VDD VSS VSS gf180mcu_as_sc_mcu7t3v3__fill_1
XFILLER_141_1192 VDD VDD VSS VSS gf180mcu_as_sc_mcu7t3v3__fill_1
XFILLER_157_892 VDD VDD VSS VSS gf180mcu_as_sc_mcu7t3v3__fill_2
XFILLER_176_1200 VDD VDD VSS VSS gf180mcu_as_sc_mcu7t3v3__fillcap_16
X_4534_ VDD VDD VSS VSS _4535_/C _4536_/S _5024_/Q _4553_/A gf180mcu_as_sc_mcu7t3v3__ao21_2
XFILLER_116_244 VDD VDD VSS VSS gf180mcu_as_sc_mcu7t3v3__fill_1
XFILLER_116_255 VDD VDD VSS VSS gf180mcu_as_sc_mcu7t3v3__fill_2
X_4465_ VDD VDD VSS VSS _4465_/D _4581_/A _4465_/B _4465_/C _4466_/B gf180mcu_as_sc_mcu7t3v3__ao31_2
XFILLER_116_299 VDD VDD VSS VSS gf180mcu_as_sc_mcu7t3v3__fill_2
XFILLER_131_225 VDD VDD VSS VSS gf180mcu_as_sc_mcu7t3v3__fillcap_16
XFILLER_154_1531 VDD VDD VSS VSS gf180mcu_as_sc_mcu7t3v3__fillcap_4
XFILLER_28_1534 VDD VDD VSS VSS gf180mcu_as_sc_mcu7t3v3__fillcap_16
Xfanout804 VDD VDD VSS VSS fanout808/Y _3699_/D gf180mcu_as_sc_mcu7t3v3__buff_2
X_4396_ VDD VDD VSS VSS _5167_/Q _4470_/B _4493_/C _5117_/Q _4397_/B gf180mcu_as_sc_mcu7t3v3__ao22_2
X_3416_ VDD VDD VSS VSS _4067_/A _3477_/B _3416_/C _4821_/D _3730_/D gf180mcu_as_sc_mcu7t3v3__aoi211_2
XFILLER_115_1515 VDD VDD VSS VSS gf180mcu_as_sc_mcu7t3v3__fillcap_4
XFILLER_28_1556 VDD VDD VSS VSS gf180mcu_as_sc_mcu7t3v3__fillcap_8
XPHY_EDGE_ROW_156_Right_290 VDD VSS gf180mcu_as_sc_mcu7t3v3__tap_2
X_3347_ VDD VDD VSS VSS _4000_/D _3466_/B _3347_/C _3347_/D _3348_/C gf180mcu_as_sc_mcu7t3v3__ao211_2
XFILLER_115_1537 VDD VDD VSS VSS gf180mcu_as_sc_mcu7t3v3__fillcap_16
XFILLER_150_1417 VDD VDD VSS VSS gf180mcu_as_sc_mcu7t3v3__fillcap_16
Xhold1002 VDD VDD VSS VSS hold1037/Y hold1038/A gf180mcu_as_sc_mcu7t3v3__buff_2
Xhold1013 VDD VDD VSS VSS hold1047/Y _4957_/D gf180mcu_as_sc_mcu7t3v3__buff_2
Xhold1024 VDD VDD VSS VSS hold1055/Y _4961_/D gf180mcu_as_sc_mcu7t3v3__buff_2
X_5017_ VDD VDD VSS VSS _5173_/CLK _5017_/D _5017_/Q gf180mcu_as_sc_mcu7t3v3__dfxtp_2
Xhold1035 VDD VDD VSS VSS _5199_/Q hold1035/Y gf180mcu_as_sc_mcu7t3v3__buff_2
Xhold1046 VDD VDD VSS VSS _4972_/Q hold1046/Y gf180mcu_as_sc_mcu7t3v3__buff_2
Xhold1057 VDD VDD VSS VSS _4950_/Q _3907_/B gf180mcu_as_sc_mcu7t3v3__buff_2
X_3278_ VDD VDD VSS VSS _3522_/B _3814_/A _3278_/Y gf180mcu_as_sc_mcu7t3v3__and2_2
XFILLER_148_1313 VDD VDD VSS VSS gf180mcu_as_sc_mcu7t3v3__fillcap_8
XFILLER_183_1204 VDD VDD VSS VSS gf180mcu_as_sc_mcu7t3v3__fillcap_8
XFILLER_53_220 VDD VDD VSS VSS gf180mcu_as_sc_mcu7t3v3__fillcap_4
XFILLER_26_69 VDD VDD VSS VSS gf180mcu_as_sc_mcu7t3v3__fillcap_16
XFILLER_139_303 VDD VDD VSS VSS gf180mcu_as_sc_mcu7t3v3__fill_2
XFILLER_161_1546 VDD VDD VSS VSS gf180mcu_as_sc_mcu7t3v3__fill_1
XFILLER_167_623 VDD VDD VSS VSS gf180mcu_as_sc_mcu7t3v3__fillcap_4
XFILLER_167_634 VDD VDD VSS VSS gf180mcu_as_sc_mcu7t3v3__fill_1
XFILLER_179_494 VDD VDD VSS VSS gf180mcu_as_sc_mcu7t3v3__fill_1
XTAP_TAPCELL_ROW_70_1_917 VDD VSS gf180mcu_as_sc_mcu7t3v3__tap_2
XFILLER_148_870 VDD VDD VSS VSS gf180mcu_as_sc_mcu7t3v3__fillcap_4
XFILLER_166_155 VDD VDD VSS VSS gf180mcu_as_sc_mcu7t3v3__fillcap_16
XFILLER_167_678 VDD VDD VSS VSS gf180mcu_as_sc_mcu7t3v3__fill_2
XFILLER_182_626 VDD VDD VSS VSS gf180mcu_as_sc_mcu7t3v3__fill_1
XPHY_EDGE_ROW_56_1_Right_55 VDD VSS gf180mcu_as_sc_mcu7t3v3__tap_2
XFILLER_154_328 VDD VDD VSS VSS gf180mcu_as_sc_mcu7t3v3__fill_1
XFILLER_166_177 VDD VDD VSS VSS gf180mcu_as_sc_mcu7t3v3__fillcap_16
XTAP_TAPCELL_ROW_134_1211 VDD VSS gf180mcu_as_sc_mcu7t3v3__tap_2
XTAP_TAPCELL_ROW_134_1200 VDD VSS gf180mcu_as_sc_mcu7t3v3__tap_2
XPHY_EDGE_ROW_27_1_Left_479 VDD VSS gf180mcu_as_sc_mcu7t3v3__tap_2
XFILLER_150_523 VDD VDD VSS VSS gf180mcu_as_sc_mcu7t3v3__fill_2
XFILLER_174_34 VDD VDD VSS VSS gf180mcu_as_sc_mcu7t3v3__fill_1
XFILLER_107_50 VDD VDD VSS VSS gf180mcu_as_sc_mcu7t3v3__fillcap_16
XFILLER_122_247 VDD VDD VSS VSS gf180mcu_as_sc_mcu7t3v3__fillcap_8
XFILLER_3_18 VDD VDD VSS VSS gf180mcu_as_sc_mcu7t3v3__fillcap_16
XTAP_TAPCELL_ROW_151_1580 VDD VSS gf180mcu_as_sc_mcu7t3v3__tap_2
XFILLER_107_72 VDD VDD VSS VSS gf180mcu_as_sc_mcu7t3v3__fill_1
XFILLER_153_1052 VDD VDD VSS VSS gf180mcu_as_sc_mcu7t3v3__fillcap_8
XFILLER_67_10 VDD VDD VSS VSS gf180mcu_as_sc_mcu7t3v3__fill_2
XPHY_EDGE_ROW_89_1_Left_541 VDD VSS gf180mcu_as_sc_mcu7t3v3__tap_2
XFILLER_36_209 VDD VDD VSS VSS gf180mcu_as_sc_mcu7t3v3__fillcap_16
XFILLER_44_242 VDD VDD VSS VSS gf180mcu_as_sc_mcu7t3v3__fill_2
XTAP_TAPCELL_ROW_49_3_2423 VDD VSS gf180mcu_as_sc_mcu7t3v3__tap_2
XFILLER_158_601 VDD VDD VSS VSS gf180mcu_as_sc_mcu7t3v3__fill_2
XTAP_TAPCELL_ROW_158_1723 VDD VSS gf180mcu_as_sc_mcu7t3v3__tap_2
XFILLER_157_133 VDD VDD VSS VSS gf180mcu_as_sc_mcu7t3v3__fillcap_4
XTAP_TAPCELL_ROW_158_1734 VDD VSS gf180mcu_as_sc_mcu7t3v3__tap_2
XFILLER_12_183 VDD VDD VSS VSS gf180mcu_as_sc_mcu7t3v3__fillcap_16
XFILLER_146_807 VDD VDD VSS VSS gf180mcu_as_sc_mcu7t3v3__fill_2
XFILLER_158_667 VDD VDD VSS VSS gf180mcu_as_sc_mcu7t3v3__fillcap_8
XFILLER_139_881 VDD VDD VSS VSS gf180mcu_as_sc_mcu7t3v3__fillcap_8
XFILLER_138_1504 VDD VDD VSS VSS gf180mcu_as_sc_mcu7t3v3__fill_1
XFILLER_177_1542 VDD VDD VSS VSS gf180mcu_as_sc_mcu7t3v3__fillcap_4
Xoutput407 VDD VDD VSS VSS _4827_/Q south_out[22] gf180mcu_as_sc_mcu7t3v3__buff_2
X_2580_ VDD VDD VSS VSS _2673_/B _5135_/Q _2581_/D gf180mcu_as_sc_mcu7t3v3__and2_2
XFILLER_138_1515 VDD VDD VSS VSS gf180mcu_as_sc_mcu7t3v3__fillcap_4
XFILLER_153_372 VDD VDD VSS VSS gf180mcu_as_sc_mcu7t3v3__fill_2
XFILLER_181_670 VDD VDD VSS VSS gf180mcu_as_sc_mcu7t3v3__fillcap_8
Xoutput418 VDD VDD VSS VSS _4837_/Q south_out[32] gf180mcu_as_sc_mcu7t3v3__buff_2
Xoutput429 VDD VDD VSS VSS _4884_/Q west_out[11] gf180mcu_as_sc_mcu7t3v3__buff_2
X_4250_ VDD VDD VSS VSS _4250_/S _4250_/B _5086_/Q _5086_/D gf180mcu_as_sc_mcu7t3v3__mux2_2
XFILLER_79_150 VDD VDD VSS VSS gf180mcu_as_sc_mcu7t3v3__fillcap_4
X_4181_ VDD VDD VSS VSS _4241_/B _4188_/B _4188_/C _5019_/Q _5019_/D gf180mcu_as_sc_mcu7t3v3__ao22_2
X_3201_ VDD VDD VSS VSS _3789_/A _3223_/B _3201_/C _3203_/B gf180mcu_as_sc_mcu7t3v3__nand3_2
XFILLER_136_1294 VDD VDD VSS VSS gf180mcu_as_sc_mcu7t3v3__fill_1
X_3132_ VDD VDD VSS VSS _3731_/A _3132_/B _3132_/C _4792_/D _3730_/D gf180mcu_as_sc_mcu7t3v3__aoi211_2
XFILLER_94_142 VDD VDD VSS VSS gf180mcu_as_sc_mcu7t3v3__fillcap_4
XFILLER_97_1521 VDD VDD VSS VSS gf180mcu_as_sc_mcu7t3v3__fillcap_16
X_3063_ VDD VDD VSS VSS _4041_/A _3147_/B _3063_/C _3063_/D _3064_/C gf180mcu_as_sc_mcu7t3v3__ao22_2
XPHY_EDGE_ROW_27_3_Right_346 VDD VSS gf180mcu_as_sc_mcu7t3v3__tap_2
XTAP_TAPCELL_ROW_84_3_2475 VDD VSS gf180mcu_as_sc_mcu7t3v3__tap_2
XFILLER_110_1467 VDD VDD VSS VSS gf180mcu_as_sc_mcu7t3v3__fillcap_16
XTAP_TAPCELL_ROW_35_1_776 VDD VSS gf180mcu_as_sc_mcu7t3v3__tap_2
XFILLER_145_1508 VDD VDD VSS VSS gf180mcu_as_sc_mcu7t3v3__fill_2
XFILLER_184_1568 VDD VDD VSS VSS gf180mcu_as_sc_mcu7t3v3__fill_1
XFILLER_149_601 VDD VDD VSS VSS gf180mcu_as_sc_mcu7t3v3__fillcap_4
X_3965_ VDD VDD VSS VSS _3965_/A _4104_/C _4101_/B _3965_/D _3966_/D gf180mcu_as_sc_mcu7t3v3__ao22_2
X_3896_ VDD VDD VSS VSS _3905_/B _5186_/Q _4936_/D gf180mcu_as_sc_mcu7t3v3__and2_2
X_2916_ VDD VDD VSS VSS _3201_/C _2948_/B _3233_/C gf180mcu_as_sc_mcu7t3v3__and2_2
XFILLER_148_155 VDD VDD VSS VSS gf180mcu_as_sc_mcu7t3v3__fillcap_16
XFILLER_164_615 VDD VDD VSS VSS gf180mcu_as_sc_mcu7t3v3__fillcap_8
X_2847_ VDD VDD VSS VSS _2847_/A _4372_/D _2847_/C _4371_/B _2853_/A gf180mcu_as_sc_mcu7t3v3__ao211_2
XFILLER_136_317 VDD VDD VSS VSS gf180mcu_as_sc_mcu7t3v3__fillcap_4
XFILLER_148_177 VDD VDD VSS VSS gf180mcu_as_sc_mcu7t3v3__fillcap_16
XFILLER_128_49 VDD VDD VSS VSS gf180mcu_as_sc_mcu7t3v3__fillcap_4
XFILLER_163_136 VDD VDD VSS VSS gf180mcu_as_sc_mcu7t3v3__fillcap_4
XFILLER_163_158 VDD VDD VSS VSS gf180mcu_as_sc_mcu7t3v3__fillcap_16
X_2778_ VDD VDD VSS VSS _2778_/B _5270_/Q _2781_/B gf180mcu_as_sc_mcu7t3v3__and2_2
XFILLER_160_821 VDD VDD VSS VSS gf180mcu_as_sc_mcu7t3v3__fill_1
XFILLER_176_1041 VDD VDD VSS VSS gf180mcu_as_sc_mcu7t3v3__fillcap_8
X_4517_ VDD VDD VSS VSS _4520_/C _4993_/Q _4518_/S gf180mcu_as_sc_mcu7t3v3__nand2b_2
XFILLER_104_247 VDD VDD VSS VSS gf180mcu_as_sc_mcu7t3v3__fillcap_4
XFILLER_144_383 VDD VDD VSS VSS gf180mcu_as_sc_mcu7t3v3__fill_2
X_4448_ VDD VDD VSS VSS _4449_/D _4448_/B _4448_/A gf180mcu_as_sc_mcu7t3v3__nor2_2
XFILLER_144_37 VDD VDD VSS VSS gf180mcu_as_sc_mcu7t3v3__fill_1
Xfanout601 VDD VDD VSS VSS fanout602/Y _4118_/B gf180mcu_as_sc_mcu7t3v3__buff_2
Xfanout612 VDD VDD VSS VSS _3550_/Y _3800_/C gf180mcu_as_sc_mcu7t3v3__buff_2
Xfanout623 VDD VDD VSS VSS _3241_/B _3230_/S gf180mcu_as_sc_mcu7t3v3__buff_2
XFILLER_154_1383 VDD VDD VSS VSS gf180mcu_as_sc_mcu7t3v3__fillcap_16
Xfanout634 VDD VDD VSS VSS _4328_/A _4325_/S gf180mcu_as_sc_mcu7t3v3__buff_2
Xfanout645 VDD VDD VSS VSS _4750_/D _4605_/B gf180mcu_as_sc_mcu7t3v3__buff_2
Xfanout656 VDD VDD VSS VSS fanout660/Y _3503_/B gf180mcu_as_sc_mcu7t3v3__buff_2
Xfanout667 VDD VDD VSS VSS _4129_/C _4152_/C gf180mcu_as_sc_mcu7t3v3__buff_2
X_4379_ VDD VDD VSS VSS _4379_/B _5164_/Q _4380_/B gf180mcu_as_sc_mcu7t3v3__or2_2
XTAP_TAPCELL_ROW_14_1_690 VDD VSS gf180mcu_as_sc_mcu7t3v3__tap_2
XFILLER_85_142 VDD VDD VSS VSS gf180mcu_as_sc_mcu7t3v3__fillcap_16
Xfanout678 VDD VDD VSS VSS _3748_/C _3740_/C gf180mcu_as_sc_mcu7t3v3__buff_2
Xfanout689 VDD VDD VSS VSS _3153_/A _3178_/A gf180mcu_as_sc_mcu7t3v3__buff_2
XTAP_TAPCELL_ROW_181_2241 VDD VSS gf180mcu_as_sc_mcu7t3v3__tap_2
XTAP_TAPCELL_ROW_181_2230 VDD VSS gf180mcu_as_sc_mcu7t3v3__tap_2
XFILLER_150_1269 VDD VDD VSS VSS gf180mcu_as_sc_mcu7t3v3__fill_1
XFILLER_18_209 VDD VDD VSS VSS gf180mcu_as_sc_mcu7t3v3__fillcap_16
XFILLER_41_1553 VDD VDD VSS VSS gf180mcu_as_sc_mcu7t3v3__fillcap_16
XFILLER_85_175 VDD VDD VSS VSS gf180mcu_as_sc_mcu7t3v3__fillcap_16
XFILLER_160_69 VDD VDD VSS VSS gf180mcu_as_sc_mcu7t3v3__fillcap_16
XTAP_TAPCELL_ROW_0_1_2345 VDD VSS gf180mcu_as_sc_mcu7t3v3__tap_2
XFILLER_148_1143 VDD VDD VSS VSS gf180mcu_as_sc_mcu7t3v3__fillcap_8
XFILLER_144_1007 VDD VDD VSS VSS gf180mcu_as_sc_mcu7t3v3__fillcap_8
XFILLER_148_1165 VDD VDD VSS VSS gf180mcu_as_sc_mcu7t3v3__fill_2
XFILLER_26_275 VDD VDD VSS VSS gf180mcu_as_sc_mcu7t3v3__fill_2
XFILLER_41_212 VDD VDD VSS VSS gf180mcu_as_sc_mcu7t3v3__fillcap_16
XFILLER_53_34 VDD VDD VSS VSS gf180mcu_as_sc_mcu7t3v3__fillcap_4
XFILLER_169_34 VDD VDD VSS VSS gf180mcu_as_sc_mcu7t3v3__fillcap_16
XFILLER_183_1067 VDD VDD VSS VSS gf180mcu_as_sc_mcu7t3v3__fillcap_4
XFILLER_53_67 VDD VDD VSS VSS gf180mcu_as_sc_mcu7t3v3__fill_2
XTAP_TAPCELL_ROW_179_2192 VDD VSS gf180mcu_as_sc_mcu7t3v3__tap_2
XFILLER_161_1321 VDD VDD VSS VSS gf180mcu_as_sc_mcu7t3v3__fill_2
XFILLER_161_1343 VDD VDD VSS VSS gf180mcu_as_sc_mcu7t3v3__fillcap_4
XFILLER_168_998 VDD VDD VSS VSS gf180mcu_as_sc_mcu7t3v3__fillcap_4
XFILLER_167_486 VDD VDD VSS VSS gf180mcu_as_sc_mcu7t3v3__fillcap_4
X_4877__990 VDD VDD VSS VSS _4877_/D gf180mcu_as_sc_mcu7t3v3__tiel_4
XTAP_TAPCELL_ROW_153_1631 VDD VSS gf180mcu_as_sc_mcu7t3v3__tap_2
XTAP_TAPCELL_ROW_153_1620 VDD VSS gf180mcu_as_sc_mcu7t3v3__tap_2
XFILLER_163_670 VDD VDD VSS VSS gf180mcu_as_sc_mcu7t3v3__fillcap_8
XFILLER_182_489 VDD VDD VSS VSS gf180mcu_as_sc_mcu7t3v3__fill_2
XFILLER_135_394 VDD VDD VSS VSS gf180mcu_as_sc_mcu7t3v3__fill_2
XFILLER_151_854 VDD VDD VSS VSS gf180mcu_as_sc_mcu7t3v3__fill_2
XTAP_TAPCELL_ROW_90_3_2485 VDD VSS gf180mcu_as_sc_mcu7t3v3__tap_2
XFILLER_46_1486 VDD VDD VSS VSS gf180mcu_as_sc_mcu7t3v3__fillcap_16
XFILLER_133_1467 VDD VDD VSS VSS gf180mcu_as_sc_mcu7t3v3__fillcap_16
XFILLER_134_70 VDD VDD VSS VSS gf180mcu_as_sc_mcu7t3v3__fillcap_4
XFILLER_76_142 VDD VDD VSS VSS gf180mcu_as_sc_mcu7t3v3__fill_2
XFILLER_94_52 VDD VDD VSS VSS gf180mcu_as_sc_mcu7t3v3__fillcap_8
X_4884__983 VDD VDD VSS VSS _4884_/D gf180mcu_as_sc_mcu7t3v3__tiel_4
XFILLER_162_1107 VDD VDD VSS VSS gf180mcu_as_sc_mcu7t3v3__fill_2
XFILLER_177_206 VDD VDD VSS VSS gf180mcu_as_sc_mcu7t3v3__fillcap_4
XTAP_TAPCELL_ROW_31_1_760 VDD VSS gf180mcu_as_sc_mcu7t3v3__tap_2
XFILLER_177_228 VDD VDD VSS VSS gf180mcu_as_sc_mcu7t3v3__fillcap_16
X_3750_ VDD VDD VSS VSS _4127_/A _3750_/B _3750_/C _4126_/A _3751_/D gf180mcu_as_sc_mcu7t3v3__ao22_2
XFILLER_146_604 VDD VDD VSS VSS gf180mcu_as_sc_mcu7t3v3__fillcap_16
XFILLER_159_976 VDD VDD VSS VSS gf180mcu_as_sc_mcu7t3v3__fillcap_4
XFILLER_159_998 VDD VDD VSS VSS gf180mcu_as_sc_mcu7t3v3__fillcap_4
X_2701_ VDD VDD VSS VSS _2701_/D _2701_/A _2701_/B _2701_/C _2702_/A gf180mcu_as_sc_mcu7t3v3__ao31_2
XTAP_TAPCELL_ROW_127_1_1145 VDD VSS gf180mcu_as_sc_mcu7t3v3__tap_2
XPHY_EDGE_ROW_71_3_Left_205 VDD VSS gf180mcu_as_sc_mcu7t3v3__tap_2
XFILLER_158_497 VDD VDD VSS VSS gf180mcu_as_sc_mcu7t3v3__fillcap_16
X_3681_ VDD VDD VSS VSS _3681_/D _4056_/D _3736_/B _3728_/C _3682_/C gf180mcu_as_sc_mcu7t3v3__ao31_2
X_2632_ VDD VDD VSS VSS _2632_/B _5230_/Q _4646_/C gf180mcu_as_sc_mcu7t3v3__and2_2
XFILLER_173_478 VDD VDD VSS VSS gf180mcu_as_sc_mcu7t3v3__fillcap_4
XFILLER_182_990 VDD VDD VSS VSS gf180mcu_as_sc_mcu7t3v3__fillcap_8
X_4891__976 VDD VDD VSS VSS _4891_/D gf180mcu_as_sc_mcu7t3v3__tiel_4
X_2563_ VDD VDD VSS VSS _4952_/D _4199_/A _2565_/B gf180mcu_as_sc_mcu7t3v3__or2_2
XFILLER_138_1345 VDD VDD VSS VSS gf180mcu_as_sc_mcu7t3v3__fillcap_16
XFILLER_154_692 VDD VDD VSS VSS gf180mcu_as_sc_mcu7t3v3__fill_2
XFILLER_160_139 VDD VDD VSS VSS gf180mcu_as_sc_mcu7t3v3__fillcap_16
X_5282_ VDD VDD VSS VSS clkload1/A _5282_/D _5282_/Q gf180mcu_as_sc_mcu7t3v3__dfxtp_2
X_4302_ VDD VDD VSS VSS _4305_/S _5132_/Q _5131_/Q _5131_/D gf180mcu_as_sc_mcu7t3v3__mux2_2
XTAP_TAPCELL_ROW_107_1_1065 VDD VSS gf180mcu_as_sc_mcu7t3v3__tap_2
XFILLER_138_1367 VDD VDD VSS VSS gf180mcu_as_sc_mcu7t3v3__fillcap_16
XFILLER_141_364 VDD VDD VSS VSS gf180mcu_as_sc_mcu7t3v3__fill_2
XFILLER_142_865 VDD VDD VSS VSS gf180mcu_as_sc_mcu7t3v3__fillcap_8
XPHY_EDGE_ROW_1_1_Left_453 VDD VSS gf180mcu_as_sc_mcu7t3v3__tap_2
X_4233_ VDD VDD VSS VSS _4250_/S _4233_/B _5069_/Q _5069_/D gf180mcu_as_sc_mcu7t3v3__mux2_2
X_2494_ VDD VDD VSS VSS _2495_/A _4954_/Q _5189_/Q _2794_/A gf180mcu_as_sc_mcu7t3v3__maj3_2
XFILLER_101_228 VDD VDD VSS VSS gf180mcu_as_sc_mcu7t3v3__fillcap_4
XFILLER_25_1515 VDD VDD VSS VSS gf180mcu_as_sc_mcu7t3v3__fillcap_4
XFILLER_64_1564 VDD VDD VSS VSS gf180mcu_as_sc_mcu7t3v3__fillcap_4
XFILLER_25_1537 VDD VDD VSS VSS gf180mcu_as_sc_mcu7t3v3__fillcap_16
XFILLER_67_142 VDD VDD VSS VSS gf180mcu_as_sc_mcu7t3v3__fillcap_4
X_4164_ VDD VDD VSS VSS _4164_/S _4164_/B _4164_/A _4165_/B gf180mcu_as_sc_mcu7t3v3__mux2_2
XFILLER_112_1518 VDD VDD VSS VSS gf180mcu_as_sc_mcu7t3v3__fillcap_16
X_4095_ VDD VDD VSS VSS _4095_/A _4120_/B _4120_/C _4935_/Q _4097_/C gf180mcu_as_sc_mcu7t3v3__ao22_2
X_3115_ VDD VDD VSS VSS _3699_/D _3140_/A _3115_/B _3115_/C _3116_/C gf180mcu_as_sc_mcu7t3v3__ao31_2
XFILLER_82_123 VDD VDD VSS VSS gf180mcu_as_sc_mcu7t3v3__fill_1
XFILLER_82_134 VDD VDD VSS VSS gf180mcu_as_sc_mcu7t3v3__fillcap_16
X_3046_ VDD VDD VSS VSS _3121_/B _4926_/Q _3047_/D gf180mcu_as_sc_mcu7t3v3__or2_2
XFILLER_149_1463 VDD VDD VSS VSS gf180mcu_as_sc_mcu7t3v3__fillcap_4
XFILLER_23_212 VDD VDD VSS VSS gf180mcu_as_sc_mcu7t3v3__fillcap_16
XPHY_EDGE_ROW_28_3_Right_347 VDD VSS gf180mcu_as_sc_mcu7t3v3__tap_2
XFILLER_149_1496 VDD VDD VSS VSS gf180mcu_as_sc_mcu7t3v3__fillcap_4
XFILLER_184_1376 VDD VDD VSS VSS gf180mcu_as_sc_mcu7t3v3__fill_1
X_4997_ VDD VDD VSS VSS _5084_/CLK _4997_/D _4997_/Q gf180mcu_as_sc_mcu7t3v3__dfxtp_2
Xclkbuf_leaf_10_clk_regs VDD VDD VSS VSS clkbuf_3_2_0_clk_regs/Y clkload9/A gf180mcu_as_sc_mcu7t3v3__clkbuff_12
X_3948_ VDD VDD VSS VSS _3948_/A _4162_/B _4141_/B _3953_/C _3948_/D gf180mcu_as_sc_mcu7t3v3__aoi211_2
XTAP_TAPCELL_ROW_7_1_662 VDD VSS gf180mcu_as_sc_mcu7t3v3__tap_2
XTAP_TAPCELL_ROW_107_3_2510 VDD VSS gf180mcu_as_sc_mcu7t3v3__tap_2
XFILLER_136_114 VDD VDD VSS VSS gf180mcu_as_sc_mcu7t3v3__fill_2
X_3879_ VDD VDD VSS VSS _3897_/B _5169_/Q _4919_/D gf180mcu_as_sc_mcu7t3v3__and2_2
XFILLER_164_434 VDD VDD VSS VSS gf180mcu_as_sc_mcu7t3v3__fillcap_16
XFILLER_165_979 VDD VDD VSS VSS gf180mcu_as_sc_mcu7t3v3__fill_1
XFILLER_178_1136 VDD VDD VSS VSS gf180mcu_as_sc_mcu7t3v3__fill_1
XFILLER_180_938 VDD VDD VSS VSS gf180mcu_as_sc_mcu7t3v3__fillcap_4
XFILLER_2_127 VDD VDD VSS VSS gf180mcu_as_sc_mcu7t3v3__fill_1
XFILLER_155_69 VDD VDD VSS VSS gf180mcu_as_sc_mcu7t3v3__fill_1
XFILLER_156_1456 VDD VDD VSS VSS gf180mcu_as_sc_mcu7t3v3__fillcap_4
XFILLER_156_1489 VDD VDD VSS VSS gf180mcu_as_sc_mcu7t3v3__fillcap_4
Xfanout475 VDD VDD VSS VSS _3560_/Y _3794_/S gf180mcu_as_sc_mcu7t3v3__buff_2
XFILLER_58_153 VDD VDD VSS VSS gf180mcu_as_sc_mcu7t3v3__fill_1
Xfanout486 VDD VDD VSS VSS _4218_/B _4228_/B gf180mcu_as_sc_mcu7t3v3__buff_2
Xfanout497 VDD VDD VSS VSS _3731_/B _3746_/B gf180mcu_as_sc_mcu7t3v3__buff_2
XFILLER_100_294 VDD VDD VSS VSS gf180mcu_as_sc_mcu7t3v3__fillcap_4
XFILLER_58_197 VDD VDD VSS VSS gf180mcu_as_sc_mcu7t3v3__fill_2
Xmesh_tile_890 VDD VDD VSS VSS north_out[31] gf180mcu_as_sc_mcu7t3v3__tiel_4
XTAP_TAPCELL_ROW_133_1_1166 VDD VSS gf180mcu_as_sc_mcu7t3v3__tap_2
XFILLER_161_2 VDD VDD VSS VSS gf180mcu_as_sc_mcu7t3v3__fillcap_16
XFILLER_64_88 VDD VDD VSS VSS gf180mcu_as_sc_mcu7t3v3__fillcap_4
XFILLER_128_1558 VDD VDD VSS VSS gf180mcu_as_sc_mcu7t3v3__fill_1
XFILLER_159_206 VDD VDD VSS VSS gf180mcu_as_sc_mcu7t3v3__fillcap_4
XFILLER_163_1416 VDD VDD VSS VSS gf180mcu_as_sc_mcu7t3v3__fillcap_8
XTAP_TAPCELL_ROW_142_1387 VDD VSS gf180mcu_as_sc_mcu7t3v3__tap_2
XTAP_TAPCELL_ROW_142_1376 VDD VSS gf180mcu_as_sc_mcu7t3v3__tap_2
XFILLER_80_10 VDD VDD VSS VSS gf180mcu_as_sc_mcu7t3v3__fillcap_4
XFILLER_156_913 VDD VDD VSS VSS gf180mcu_as_sc_mcu7t3v3__fillcap_8
XFILLER_161_1140 VDD VDD VSS VSS gf180mcu_as_sc_mcu7t3v3__fill_1
XFILLER_161_1162 VDD VDD VSS VSS gf180mcu_as_sc_mcu7t3v3__fill_1
XFILLER_168_751 VDD VDD VSS VSS gf180mcu_as_sc_mcu7t3v3__fillcap_8
XFILLER_174_209 VDD VDD VSS VSS gf180mcu_as_sc_mcu7t3v3__fillcap_16
XFILLER_80_65 VDD VDD VSS VSS gf180mcu_as_sc_mcu7t3v3__fillcap_4
XTAP_TAPCELL_ROW_113_1_1086 VDD VSS gf180mcu_as_sc_mcu7t3v3__tap_2
XFILLER_129_92 VDD VDD VSS VSS gf180mcu_as_sc_mcu7t3v3__fill_2
XFILLER_143_629 VDD VDD VSS VSS gf180mcu_as_sc_mcu7t3v3__fill_1
XFILLER_171_938 VDD VDD VSS VSS gf180mcu_as_sc_mcu7t3v3__fillcap_8
XFILLER_87_1553 VDD VDD VSS VSS gf180mcu_as_sc_mcu7t3v3__fillcap_16
XTAP_TAPCELL_ROW_92_1_1004 VDD VSS gf180mcu_as_sc_mcu7t3v3__tap_2
XFILLER_164_990 VDD VDD VSS VSS gf180mcu_as_sc_mcu7t3v3__fillcap_8
XFILLER_174_1523 VDD VDD VSS VSS gf180mcu_as_sc_mcu7t3v3__fillcap_16
XPHY_EDGE_ROW_19_1_Right_18 VDD VSS gf180mcu_as_sc_mcu7t3v3__tap_2
XFILLER_150_172 VDD VDD VSS VSS gf180mcu_as_sc_mcu7t3v3__fill_2
XTAP_TAPCELL_ROW_37_3_2405 VDD VSS gf180mcu_as_sc_mcu7t3v3__tap_2
XFILLER_49_142 VDD VDD VSS VSS gf180mcu_as_sc_mcu7t3v3__fillcap_16
XFILLER_64_134 VDD VDD VSS VSS gf180mcu_as_sc_mcu7t3v3__fillcap_16
XTAP_TAPCELL_ROW_166_1899 VDD VSS gf180mcu_as_sc_mcu7t3v3__tap_2
XFILLER_94_1502 VDD VDD VSS VSS gf180mcu_as_sc_mcu7t3v3__fillcap_16
XFILLER_20_1467 VDD VDD VSS VSS gf180mcu_as_sc_mcu7t3v3__fillcap_16
XFILLER_94_1546 VDD VDD VSS VSS gf180mcu_as_sc_mcu7t3v3__fill_2
X_4920_ VDD VDD VSS VSS _5088_/CLK _4920_/D _4920_/Q gf180mcu_as_sc_mcu7t3v3__dfxtp_2
XFILLER_178_504 VDD VDD VSS VSS gf180mcu_as_sc_mcu7t3v3__fillcap_16
XFILLER_181_1527 VDD VDD VSS VSS gf180mcu_as_sc_mcu7t3v3__fillcap_8
X_4851_ VDD VDD VSS VSS _4928_/CLK _4851_/D _4851_/Q gf180mcu_as_sc_mcu7t3v3__dfxtp_2
XPHY_EDGE_ROW_104_1_Left_556 VDD VSS gf180mcu_as_sc_mcu7t3v3__tap_2
X_3802_ VDD VDD VSS VSS _3802_/A _3802_/B _3802_/C _3802_/D _3804_/A gf180mcu_as_sc_mcu7t3v3__ao211_2
XFILLER_159_740 VDD VDD VSS VSS gf180mcu_as_sc_mcu7t3v3__fill_2
X_4782_ VDD VDD VSS VSS _4938_/CLK _4782_/D _4782_/Q gf180mcu_as_sc_mcu7t3v3__dfxtp_2
XFILLER_147_924 VDD VDD VSS VSS gf180mcu_as_sc_mcu7t3v3__fill_2
XFILLER_147_946 VDD VDD VSS VSS gf180mcu_as_sc_mcu7t3v3__fill_2
XFILLER_174_710 VDD VDD VSS VSS gf180mcu_as_sc_mcu7t3v3__fillcap_16
XFILLER_9_260 VDD VDD VSS VSS gf180mcu_as_sc_mcu7t3v3__fillcap_16
X_3733_ VDD VDD VSS VSS _3734_/C _4109_/D _3751_/B _3733_/C gf180mcu_as_sc_mcu7t3v3__ao21_2
XTAP_TAPCELL_ROW_80_1_955 VDD VSS gf180mcu_as_sc_mcu7t3v3__tap_2
XFILLER_158_294 VDD VDD VSS VSS gf180mcu_as_sc_mcu7t3v3__fillcap_8
XFILLER_179_1434 VDD VDD VSS VSS gf180mcu_as_sc_mcu7t3v3__fill_1
XFILLER_9_282 VDD VDD VSS VSS gf180mcu_as_sc_mcu7t3v3__fillcap_16
X_3664_ VDD VDD VSS VSS _3668_/B _3664_/C _3744_/B _4038_/A gf180mcu_as_sc_mcu7t3v3__aoi21_2
XFILLER_134_607 VDD VDD VSS VSS gf180mcu_as_sc_mcu7t3v3__fillcap_4
XFILLER_162_938 VDD VDD VSS VSS gf180mcu_as_sc_mcu7t3v3__fillcap_4
XFILLER_174_776 VDD VDD VSS VSS gf180mcu_as_sc_mcu7t3v3__fillcap_8
Xclkload30 VDD VDD VSS VSS _4869_/CLK clkload30/Y gf180mcu_as_sc_mcu7t3v3__clkbuff_4
X_2615_ VDD VDD VSS VSS _4628_/S _2632_/B _5268_/Q gf180mcu_as_sc_mcu7t3v3__nor2_2
X_3595_ VDD VDD VSS VSS _4919_/Q _3740_/B _3770_/C _3967_/A _3597_/C gf180mcu_as_sc_mcu7t3v3__ao22_2
XFILLER_170_960 VDD VDD VSS VSS gf180mcu_as_sc_mcu7t3v3__fillcap_8
X_2546_ VDD VDD VSS VSS _2547_/B _2546_/A _2546_/B _2745_/B gf180mcu_as_sc_mcu7t3v3__maj3_2
XFILLER_142_695 VDD VDD VSS VSS gf180mcu_as_sc_mcu7t3v3__fill_1
X_5265_ VDD VDD VSS VSS _5266_/CLK _5265_/D _5265_/Q gf180mcu_as_sc_mcu7t3v3__dfxtp_2
X_2477_ VDD VDD VSS VSS _2477_/B _3907_/A _4950_/D gf180mcu_as_sc_mcu7t3v3__and2_2
XTAP_TAPCELL_ROW_72_3_2457 VDD VSS gf180mcu_as_sc_mcu7t3v3__tap_2
XFILLER_116_1451 VDD VDD VSS VSS gf180mcu_as_sc_mcu7t3v3__fillcap_16
XFILLER_9_1553 VDD VDD VSS VSS gf180mcu_as_sc_mcu7t3v3__fillcap_16
X_5196_ VDD VDD VSS VSS _5199_/CLK _5196_/D _5196_/Q gf180mcu_as_sc_mcu7t3v3__dfxtp_2
X_4216_ VDD VDD VSS VSS _4245_/B _4219_/B _4219_/C _5052_/Q _5052_/D gf180mcu_as_sc_mcu7t3v3__ao22_2
X_4147_ VDD VDD VSS VSS _4147_/A _4163_/B _4147_/C _4147_/D _4148_/B gf180mcu_as_sc_mcu7t3v3__ao211_2
XFILLER_151_1386 VDD VDD VSS VSS gf180mcu_as_sc_mcu7t3v3__fill_2
XFILLER_18_37 VDD VDD VSS VSS gf180mcu_as_sc_mcu7t3v3__fillcap_16
XFILLER_55_156 VDD VDD VSS VSS gf180mcu_as_sc_mcu7t3v3__fillcap_4
X_4078_ VDD VDD VSS VSS _4078_/A _4127_/B _4110_/C _4078_/D _4082_/A gf180mcu_as_sc_mcu7t3v3__ao211_2
XPHY_EDGE_ROW_65_1_Right_64 VDD VSS gf180mcu_as_sc_mcu7t3v3__tap_2
X_3029_ VDD VDD VSS VSS _4008_/A _3125_/B _3029_/C _3029_/D _3030_/C gf180mcu_as_sc_mcu7t3v3__ao22_2
XFILLER_149_1282 VDD VDD VSS VSS gf180mcu_as_sc_mcu7t3v3__fillcap_16
XFILLER_184_1162 VDD VDD VSS VSS gf180mcu_as_sc_mcu7t3v3__fill_1
XPHY_EDGE_ROW_29_3_Right_348 VDD VSS gf180mcu_as_sc_mcu7t3v3__tap_2
XPHY_EDGE_ROW_36_1_Left_488 VDD VSS gf180mcu_as_sc_mcu7t3v3__tap_2
XFILLER_169_548 VDD VDD VSS VSS gf180mcu_as_sc_mcu7t3v3__fill_1
XFILLER_34_69 VDD VDD VSS VSS gf180mcu_as_sc_mcu7t3v3__fillcap_16
XFILLER_162_1460 VDD VDD VSS VSS gf180mcu_as_sc_mcu7t3v3__fillcap_16
XFILLER_137_401 VDD VDD VSS VSS gf180mcu_as_sc_mcu7t3v3__fillcap_16
XFILLER_165_721 VDD VDD VSS VSS gf180mcu_as_sc_mcu7t3v3__fillcap_16
XFILLER_177_570 VDD VDD VSS VSS gf180mcu_as_sc_mcu7t3v3__fillcap_4
Xclkload2 VDD VDD VSS VSS clkload2/A clkload2/Y gf180mcu_as_sc_mcu7t3v3__clkbuff_4
XTAP_TAPCELL_ROW_172_2048 VDD VSS gf180mcu_as_sc_mcu7t3v3__tap_2
XTAP_TAPCELL_ROW_172_2037 VDD VSS gf180mcu_as_sc_mcu7t3v3__tap_2
XFILLER_165_765 VDD VDD VSS VSS gf180mcu_as_sc_mcu7t3v3__fill_1
XFILLER_109_158 VDD VDD VSS VSS gf180mcu_as_sc_mcu7t3v3__fill_2
XFILLER_123_1499 VDD VDD VSS VSS gf180mcu_as_sc_mcu7t3v3__fillcap_16
XFILLER_137_489 VDD VDD VSS VSS gf180mcu_as_sc_mcu7t3v3__fill_1
XFILLER_153_938 VDD VDD VSS VSS gf180mcu_as_sc_mcu7t3v3__fillcap_8
XFILLER_158_1507 VDD VDD VSS VSS gf180mcu_as_sc_mcu7t3v3__fillcap_4
XPHY_EDGE_ROW_98_1_Left_550 VDD VSS gf180mcu_as_sc_mcu7t3v3__tap_2
XFILLER_152_426 VDD VDD VSS VSS gf180mcu_as_sc_mcu7t3v3__fill_2
X_4874__993 VDD VDD VSS VSS _4874_/D gf180mcu_as_sc_mcu7t3v3__tiel_4
XTAP_TAPCELL_ROW_22_1_724 VDD VSS gf180mcu_as_sc_mcu7t3v3__tap_2
XFILLER_152_1106 VDD VDD VSS VSS gf180mcu_as_sc_mcu7t3v3__fill_2
XFILLER_156_1275 VDD VDD VSS VSS gf180mcu_as_sc_mcu7t3v3__fillcap_16
XFILLER_161_982 VDD VDD VSS VSS gf180mcu_as_sc_mcu7t3v3__fillcap_16
XFILLER_182_34 VDD VDD VSS VSS gf180mcu_as_sc_mcu7t3v3__fill_1
XFILLER_156_1297 VDD VDD VSS VSS gf180mcu_as_sc_mcu7t3v3__fillcap_16
XFILLER_59_88 VDD VDD VSS VSS gf180mcu_as_sc_mcu7t3v3__fillcap_8
XFILLER_82_1483 VDD VDD VSS VSS gf180mcu_as_sc_mcu7t3v3__fill_1
XPHY_EDGE_ROW_175_Right_309 VDD VSS gf180mcu_as_sc_mcu7t3v3__tap_2
XFILLER_115_72 VDD VDD VSS VSS gf180mcu_as_sc_mcu7t3v3__fillcap_16
XFILLER_43_1467 VDD VDD VSS VSS gf180mcu_as_sc_mcu7t3v3__fillcap_16
XTAP_TAPCELL_ROW_144_1416 VDD VSS gf180mcu_as_sc_mcu7t3v3__tap_2
XFILLER_46_134 VDD VDD VSS VSS gf180mcu_as_sc_mcu7t3v3__fillcap_8
XTAP_TAPCELL_ROW_144_1427 VDD VSS gf180mcu_as_sc_mcu7t3v3__tap_2
X_4881__986 VDD VDD VSS VSS _4881_/D gf180mcu_as_sc_mcu7t3v3__tiel_4
XFILLER_167_1371 VDD VDD VSS VSS gf180mcu_as_sc_mcu7t3v3__fillcap_4
XTAP_TAPCELL_ROW_161_1796 VDD VSS gf180mcu_as_sc_mcu7t3v3__tap_2
XFILLER_163_1224 VDD VDD VSS VSS gf180mcu_as_sc_mcu7t3v3__fill_2
XFILLER_91_64 VDD VDD VSS VSS gf180mcu_as_sc_mcu7t3v3__fillcap_4
XFILLER_144_938 VDD VDD VSS VSS gf180mcu_as_sc_mcu7t3v3__fillcap_4
XFILLER_155_275 VDD VDD VSS VSS gf180mcu_as_sc_mcu7t3v3__fillcap_4
XFILLER_171_702 VDD VDD VSS VSS gf180mcu_as_sc_mcu7t3v3__fillcap_4
XFILLER_183_562 VDD VDD VSS VSS gf180mcu_as_sc_mcu7t3v3__fillcap_16
XFILLER_6_241 VDD VDD VSS VSS gf180mcu_as_sc_mcu7t3v3__fillcap_4
XFILLER_171_735 VDD VDD VSS VSS gf180mcu_as_sc_mcu7t3v3__fill_2
X_2400_ VDD VDD VSS VSS _2792_/A _2847_/A gf180mcu_as_sc_mcu7t3v3__inv_2
X_3380_ VDD VDD VSS VSS _4030_/A _3468_/B _3380_/C _3380_/D _3381_/A gf180mcu_as_sc_mcu7t3v3__ao211_2
XFILLER_135_1326 VDD VDD VSS VSS gf180mcu_as_sc_mcu7t3v3__fillcap_4
XFILLER_174_1375 VDD VDD VSS VSS gf180mcu_as_sc_mcu7t3v3__fill_2
XFILLER_135_1348 VDD VDD VSS VSS gf180mcu_as_sc_mcu7t3v3__fillcap_16
XFILLER_151_492 VDD VDD VSS VSS gf180mcu_as_sc_mcu7t3v3__fillcap_4
X_5050_ VDD VDD VSS VSS _5074_/CLK _5050_/D _5050_/Q gf180mcu_as_sc_mcu7t3v3__dfxtp_2
X_4001_ VDD VDD VSS VSS _4001_/A _4105_/B _4001_/C _4001_/D _4002_/B gf180mcu_as_sc_mcu7t3v3__ao211_2
XFILLER_22_1518 VDD VDD VSS VSS gf180mcu_as_sc_mcu7t3v3__fillcap_16
XTAP_TAPCELL_ROW_6_1_661 VDD VSS gf180mcu_as_sc_mcu7t3v3__tap_2
XFILLER_168_1135 VDD VDD VSS VSS gf180mcu_as_sc_mcu7t3v3__fillcap_8
XFILLER_92_240 VDD VDD VSS VSS gf180mcu_as_sc_mcu7t3v3__fillcap_4
XFILLER_168_1157 VDD VDD VSS VSS gf180mcu_as_sc_mcu7t3v3__fillcap_4
XFILLER_4_1483 VDD VDD VSS VSS gf180mcu_as_sc_mcu7t3v3__fill_1
XFILLER_52_104 VDD VDD VSS VSS gf180mcu_as_sc_mcu7t3v3__fill_1
XFILLER_92_295 VDD VDD VSS VSS gf180mcu_as_sc_mcu7t3v3__fillcap_4
X_4903_ VDD VDD VSS VSS _4914_/CLK _4903_/D _4903_/Q gf180mcu_as_sc_mcu7t3v3__dfxtp_2
XFILLER_181_1313 VDD VDD VSS VSS gf180mcu_as_sc_mcu7t3v3__fillcap_8
X_4834_ VDD VDD VSS VSS _4914_/CLK _4834_/D _4834_/Q gf180mcu_as_sc_mcu7t3v3__dfxtp_2
X_4765_ VDD VDD VSS VSS clkload1/A _4765_/D _4765_/Q gf180mcu_as_sc_mcu7t3v3__dfxtp_2
XFILLER_147_743 VDD VDD VSS VSS gf180mcu_as_sc_mcu7t3v3__fill_1
X_3716_ VDD VDD VSS VSS _4096_/A _3716_/B _3716_/C _4095_/A _3717_/C gf180mcu_as_sc_mcu7t3v3__ao22_2
XFILLER_135_938 VDD VDD VSS VSS gf180mcu_as_sc_mcu7t3v3__fillcap_8
X_4696_ VDD VDD VSS VSS _4733_/C _5481_/A _5254_/Q _4697_/A gf180mcu_as_sc_mcu7t3v3__mux2_2
XTAP_TAPCELL_ROW_62_1_884 VDD VSS gf180mcu_as_sc_mcu7t3v3__tap_2
XFILLER_136_16 VDD VDD VSS VSS gf180mcu_as_sc_mcu7t3v3__fillcap_16
XFILLER_140_1098 VDD VDD VSS VSS gf180mcu_as_sc_mcu7t3v3__fillcap_8
XFILLER_161_212 VDD VDD VSS VSS gf180mcu_as_sc_mcu7t3v3__fillcap_4
X_3647_ VDD VDD VSS VSS _4849_/D _3647_/C _3707_/B _3647_/A gf180mcu_as_sc_mcu7t3v3__aoi21_2
XFILLER_118_1502 VDD VDD VSS VSS gf180mcu_as_sc_mcu7t3v3__fillcap_16
X_3578_ VDD VDD VSS VSS _3939_/A _3792_/B _3578_/C _3753_/B _3579_/C gf180mcu_as_sc_mcu7t3v3__ao211_2
XFILLER_143_982 VDD VDD VSS VSS gf180mcu_as_sc_mcu7t3v3__fillcap_16
XFILLER_66_1467 VDD VDD VSS VSS gf180mcu_as_sc_mcu7t3v3__fillcap_16
X_2529_ VDD VDD VSS VSS _2534_/A _5268_/Q _4684_/A _2530_/B gf180mcu_as_sc_mcu7t3v3__nor3_2
XFILLER_153_1437 VDD VDD VSS VSS gf180mcu_as_sc_mcu7t3v3__fillcap_4
Xinput307 VDD VDD VSS VSS west_in[31] _3511_/A gf180mcu_as_sc_mcu7t3v3__buff_2
XFILLER_152_37 VDD VDD VSS VSS gf180mcu_as_sc_mcu7t3v3__fillcap_16
X_5248_ VDD VDD VSS VSS clkload7/A _5248_/D _5248_/Q gf180mcu_as_sc_mcu7t3v3__dfxtp_2
XFILLER_151_1161 VDD VDD VSS VSS gf180mcu_as_sc_mcu7t3v3__fill_2
XFILLER_28_101 VDD VDD VSS VSS gf180mcu_as_sc_mcu7t3v3__fillcap_4
XFILLER_28_123 VDD VDD VSS VSS gf180mcu_as_sc_mcu7t3v3__fillcap_16
XFILLER_75_229 VDD VDD VSS VSS gf180mcu_as_sc_mcu7t3v3__fillcap_16
X_5179_ VDD VDD VSS VSS clkload6/A _5179_/D _5179_/Q gf180mcu_as_sc_mcu7t3v3__dfxtp_2
XFILLER_83_240 VDD VDD VSS VSS gf180mcu_as_sc_mcu7t3v3__fillcap_16
XFILLER_45_24 VDD VDD VSS VSS gf180mcu_as_sc_mcu7t3v3__fillcap_8
XFILLER_45_68 VDD VDD VSS VSS gf180mcu_as_sc_mcu7t3v3__fill_2
XFILLER_164_1555 VDD VDD VSS VSS gf180mcu_as_sc_mcu7t3v3__fillcap_8
XFILLER_61_23 VDD VDD VSS VSS gf180mcu_as_sc_mcu7t3v3__fillcap_16
XFILLER_101_96 VDD VDD VSS VSS gf180mcu_as_sc_mcu7t3v3__fillcap_16
XFILLER_177_34 VDD VDD VSS VSS gf180mcu_as_sc_mcu7t3v3__fillcap_16
XFILLER_124_2 VDD VDD VSS VSS gf180mcu_as_sc_mcu7t3v3__fillcap_8
XFILLER_153_702 VDD VDD VSS VSS gf180mcu_as_sc_mcu7t3v3__fillcap_8
XFILLER_165_562 VDD VDD VSS VSS gf180mcu_as_sc_mcu7t3v3__fillcap_8
XFILLER_6_18 VDD VDD VSS VSS gf180mcu_as_sc_mcu7t3v3__fillcap_16
XTAP_TAPCELL_ROW_137_1264 VDD VSS gf180mcu_as_sc_mcu7t3v3__tap_2
XTAP_TAPCELL_ROW_137_1275 VDD VSS gf180mcu_as_sc_mcu7t3v3__tap_2
XFILLER_153_768 VDD VDD VSS VSS gf180mcu_as_sc_mcu7t3v3__fill_2
XFILLER_84_1534 VDD VDD VSS VSS gf180mcu_as_sc_mcu7t3v3__fillcap_16
XFILLER_171_1504 VDD VDD VSS VSS gf180mcu_as_sc_mcu7t3v3__fillcap_16
XFILLER_84_1556 VDD VDD VSS VSS gf180mcu_as_sc_mcu7t3v3__fillcap_8
XFILLER_3_299 VDD VDD VSS VSS gf180mcu_as_sc_mcu7t3v3__fill_2
XTAP_TAPCELL_ROW_71_1_919 VDD VSS gf180mcu_as_sc_mcu7t3v3__tap_2
XFILLER_120_197 VDD VDD VSS VSS gf180mcu_as_sc_mcu7t3v3__fill_2
XTAP_TAPCELL_ROW_163_1847 VDD VSS gf180mcu_as_sc_mcu7t3v3__tap_2
XTAP_TAPCELL_ROW_163_1836 VDD VSS gf180mcu_as_sc_mcu7t3v3__tap_2
XTAP_TAPCELL_ROW_130_3_2544 VDD VSS gf180mcu_as_sc_mcu7t3v3__tap_2
XPHY_EDGE_ROW_80_3_Left_214 VDD VSS gf180mcu_as_sc_mcu7t3v3__tap_2
XFILLER_142_81 VDD VDD VSS VSS gf180mcu_as_sc_mcu7t3v3__fillcap_16
XFILLER_34_104 VDD VDD VSS VSS gf180mcu_as_sc_mcu7t3v3__fill_1
XFILLER_169_1488 VDD VDD VSS VSS gf180mcu_as_sc_mcu7t3v3__fillcap_16
X_2880_ VDD VDD VSS VSS _2882_/C _4329_/A _2880_/B _4643_/B gf180mcu_as_sc_mcu7t3v3__ao21_2
XFILLER_163_1076 VDD VDD VSS VSS gf180mcu_as_sc_mcu7t3v3__fill_1
XFILLER_163_1087 VDD VDD VSS VSS gf180mcu_as_sc_mcu7t3v3__fillcap_4
XFILLER_163_1098 VDD VDD VSS VSS gf180mcu_as_sc_mcu7t3v3__fillcap_8
XFILLER_176_827 VDD VDD VSS VSS gf180mcu_as_sc_mcu7t3v3__fillcap_8
XFILLER_176_849 VDD VDD VSS VSS gf180mcu_as_sc_mcu7t3v3__fill_2
XTAP_TAPCELL_ROW_96_3_2494 VDD VSS gf180mcu_as_sc_mcu7t3v3__tap_2
XFILLER_106_1483 VDD VDD VSS VSS gf180mcu_as_sc_mcu7t3v3__fill_1
XFILLER_141_1374 VDD VDD VSS VSS gf180mcu_as_sc_mcu7t3v3__fillcap_4
XFILLER_156_562 VDD VDD VSS VSS gf180mcu_as_sc_mcu7t3v3__fillcap_8
XPHY_EDGE_ROW_137_Right_271 VDD VSS gf180mcu_as_sc_mcu7t3v3__tap_2
X_4550_ VDD VDD VSS VSS _4553_/B _4550_/A gf180mcu_as_sc_mcu7t3v3__inv_2
XFILLER_143_212 VDD VDD VSS VSS gf180mcu_as_sc_mcu7t3v3__fill_2
XFILLER_89_1467 VDD VDD VSS VSS gf180mcu_as_sc_mcu7t3v3__fillcap_16
X_4481_ VDD VDD VSS VSS _4482_/C _4568_/A _5018_/Q _4572_/A gf180mcu_as_sc_mcu7t3v3__ao21_2
X_3501_ VDD VDD VSS VSS _4160_/D _3501_/B _3501_/C _4159_/A _3502_/D gf180mcu_as_sc_mcu7t3v3__ao22_2
XFILLER_171_543 VDD VDD VSS VSS gf180mcu_as_sc_mcu7t3v3__fill_2
X_3432_ VDD VDD VSS VSS _4083_/A _3462_/A _3432_/C _4823_/D _3573_/D gf180mcu_as_sc_mcu7t3v3__aoi211_2
XFILLER_139_1270 VDD VDD VSS VSS gf180mcu_as_sc_mcu7t3v3__fillcap_4
X_3363_ VDD VDD VSS VSS _3449_/B _4013_/D _3363_/A _3364_/D gf180mcu_as_sc_mcu7t3v3__mux2_2
XFILLER_174_1161 VDD VDD VSS VSS gf180mcu_as_sc_mcu7t3v3__fill_2
X_5102_ VDD VDD VSS VSS clkload6/A _5102_/D _5102_/Q gf180mcu_as_sc_mcu7t3v3__dfxtp_2
XFILLER_111_142 VDD VDD VSS VSS gf180mcu_as_sc_mcu7t3v3__fillcap_4
XFILLER_26_1451 VDD VDD VSS VSS gf180mcu_as_sc_mcu7t3v3__fillcap_16
X_3294_ VDD VDD VSS VSS _3938_/D _3500_/B _3294_/C _3294_/D _3295_/C gf180mcu_as_sc_mcu7t3v3__ao211_2
XFILLER_111_175 VDD VDD VSS VSS gf180mcu_as_sc_mcu7t3v3__fill_1
XFILLER_152_1470 VDD VDD VSS VSS gf180mcu_as_sc_mcu7t3v3__fillcap_8
XFILLER_6_1534 VDD VDD VSS VSS gf180mcu_as_sc_mcu7t3v3__fillcap_16
XFILLER_6_1556 VDD VDD VSS VSS gf180mcu_as_sc_mcu7t3v3__fillcap_8
X_5033_ VDD VDD VSS VSS _5094_/CLK _5033_/D _5033_/Q gf180mcu_as_sc_mcu7t3v3__dfxtp_2
XFILLER_122_18 VDD VDD VSS VSS gf180mcu_as_sc_mcu7t3v3__fill_2
XFILLER_152_1492 VDD VDD VSS VSS gf180mcu_as_sc_mcu7t3v3__fill_2
XFILLER_25_104 VDD VDD VSS VSS gf180mcu_as_sc_mcu7t3v3__fillcap_16
XFILLER_148_1539 VDD VDD VSS VSS gf180mcu_as_sc_mcu7t3v3__fill_1
XFILLER_80_221 VDD VDD VSS VSS gf180mcu_as_sc_mcu7t3v3__fillcap_8
XFILLER_179_610 VDD VDD VSS VSS gf180mcu_as_sc_mcu7t3v3__fill_2
XFILLER_179_632 VDD VDD VSS VSS gf180mcu_as_sc_mcu7t3v3__fillcap_4
XFILLER_40_107 VDD VDD VSS VSS gf180mcu_as_sc_mcu7t3v3__fillcap_16
XTAP_TAPCELL_ROW_114_1_1091 VDD VSS gf180mcu_as_sc_mcu7t3v3__tap_2
XFILLER_167_838 VDD VDD VSS VSS gf180mcu_as_sc_mcu7t3v3__fill_2
X_4817_ VDD VDD VSS VSS _4928_/CLK _4817_/D _4817_/Q gf180mcu_as_sc_mcu7t3v3__dfxtp_2
XFILLER_124_1550 VDD VDD VSS VSS gf180mcu_as_sc_mcu7t3v3__fillcap_4
XFILLER_135_702 VDD VDD VSS VSS gf180mcu_as_sc_mcu7t3v3__fillcap_8
XFILLER_147_562 VDD VDD VSS VSS gf180mcu_as_sc_mcu7t3v3__fillcap_16
X_4748_ VDD VDD VSS VSS _4748_/A _4748_/B _4750_/B _5277_/Q _5277_/D gf180mcu_as_sc_mcu7t3v3__ao22_2
XTAP_TAPCELL_ROW_60_3_2439 VDD VSS gf180mcu_as_sc_mcu7t3v3__tap_2
XFILLER_135_746 VDD VDD VSS VSS gf180mcu_as_sc_mcu7t3v3__fill_2
XFILLER_174_381 VDD VDD VSS VSS gf180mcu_as_sc_mcu7t3v3__fillcap_4
XFILLER_175_893 VDD VDD VSS VSS gf180mcu_as_sc_mcu7t3v3__fillcap_8
XFILLER_33_1499 VDD VDD VSS VSS gf180mcu_as_sc_mcu7t3v3__fillcap_16
XFILLER_68_1518 VDD VDD VSS VSS gf180mcu_as_sc_mcu7t3v3__fillcap_16
X_4679_ VDD VDD VSS VSS _5247_/Q _4685_/C _4681_/C _5248_/Q _4680_/C gf180mcu_as_sc_mcu7t3v3__ao22_2
XTAP_TAPCELL_ROW_36_1_778 VDD VSS gf180mcu_as_sc_mcu7t3v3__tap_2
XFILLER_135_768 VDD VDD VSS VSS gf180mcu_as_sc_mcu7t3v3__fill_2
XFILLER_0_225 VDD VDD VSS VSS gf180mcu_as_sc_mcu7t3v3__fill_1
XFILLER_153_1256 VDD VDD VSS VSS gf180mcu_as_sc_mcu7t3v3__fillcap_4
Xinput104 VDD VDD VSS VSS ne_in[33] _3530_/A gf180mcu_as_sc_mcu7t3v3__buff_2
Xinput115 VDD VDD VSS VSS north_in[12] _4029_/A gf180mcu_as_sc_mcu7t3v3__buff_2
Xinput126 VDD VDD VSS VSS north_in[22] _4112_/A gf180mcu_as_sc_mcu7t3v3__buff_2
XFILLER_102_197 VDD VDD VSS VSS gf180mcu_as_sc_mcu7t3v3__fill_2
XFILLER_131_1521 VDD VDD VSS VSS gf180mcu_as_sc_mcu7t3v3__fillcap_16
XFILLER_44_1562 VDD VDD VSS VSS gf180mcu_as_sc_mcu7t3v3__fill_1
XFILLER_48_229 VDD VDD VSS VSS gf180mcu_as_sc_mcu7t3v3__fillcap_16
XFILLER_56_12 VDD VDD VSS VSS gf180mcu_as_sc_mcu7t3v3__fill_1
Xinput137 VDD VDD VSS VSS north_in[32] _3519_/A gf180mcu_as_sc_mcu7t3v3__buff_2
Xinput148 VDD VDD VSS VSS nw_in[11] _4022_/A gf180mcu_as_sc_mcu7t3v3__buff_2
Xinput159 VDD VDD VSS VSS nw_in[21] _4104_/A gf180mcu_as_sc_mcu7t3v3__buff_2
XTAP_TAPCELL_ROW_184_2294 VDD VSS gf180mcu_as_sc_mcu7t3v3__tap_2
XFILLER_56_240 VDD VDD VSS VSS gf180mcu_as_sc_mcu7t3v3__fillcap_4
XFILLER_56_45 VDD VDD VSS VSS gf180mcu_as_sc_mcu7t3v3__fill_2
XFILLER_129_1483 VDD VDD VSS VSS gf180mcu_as_sc_mcu7t3v3__fillcap_16
XFILLER_169_120 VDD VDD VSS VSS gf180mcu_as_sc_mcu7t3v3__fillcap_16
XFILLER_169_142 VDD VDD VSS VSS gf180mcu_as_sc_mcu7t3v3__fillcap_16
XFILLER_71_298 VDD VDD VSS VSS gf180mcu_as_sc_mcu7t3v3__fill_2
XPHY_EDGE_ROW_28_1_Right_27 VDD VSS gf180mcu_as_sc_mcu7t3v3__tap_2
XFILLER_160_1227 VDD VDD VSS VSS gf180mcu_as_sc_mcu7t3v3__fillcap_16
XTAP_TAPCELL_ROW_139_1315 VDD VSS gf180mcu_as_sc_mcu7t3v3__tap_2
XTAP_TAPCELL_ROW_139_1304 VDD VSS gf180mcu_as_sc_mcu7t3v3__tap_2
XFILLER_157_348 VDD VDD VSS VSS gf180mcu_as_sc_mcu7t3v3__fill_2
XFILLER_173_819 VDD VDD VSS VSS gf180mcu_as_sc_mcu7t3v3__fillcap_4
XFILLER_125_212 VDD VDD VSS VSS gf180mcu_as_sc_mcu7t3v3__fill_2
XFILLER_166_893 VDD VDD VSS VSS gf180mcu_as_sc_mcu7t3v3__fillcap_16
XFILLER_181_830 VDD VDD VSS VSS gf180mcu_as_sc_mcu7t3v3__fillcap_8
XTAP_TAPCELL_ROW_156_1695 VDD VSS gf180mcu_as_sc_mcu7t3v3__tap_2
XTAP_TAPCELL_ROW_156_1684 VDD VSS gf180mcu_as_sc_mcu7t3v3__tap_2
XFILLER_153_543 VDD VDD VSS VSS gf180mcu_as_sc_mcu7t3v3__fillcap_16
XFILLER_181_852 VDD VDD VSS VSS gf180mcu_as_sc_mcu7t3v3__fillcap_4
XFILLER_141_738 VDD VDD VSS VSS gf180mcu_as_sc_mcu7t3v3__fillcap_4
XFILLER_49_1451 VDD VDD VSS VSS gf180mcu_as_sc_mcu7t3v3__fillcap_16
XFILLER_98_107 VDD VDD VSS VSS gf180mcu_as_sc_mcu7t3v3__fillcap_8
XFILLER_134_790 VDD VDD VSS VSS gf180mcu_as_sc_mcu7t3v3__fill_1
XFILLER_136_1432 VDD VDD VSS VSS gf180mcu_as_sc_mcu7t3v3__fill_2
XFILLER_171_1323 VDD VDD VSS VSS gf180mcu_as_sc_mcu7t3v3__fillcap_4
XFILLER_97_52 VDD VDD VSS VSS gf180mcu_as_sc_mcu7t3v3__fillcap_8
XFILLER_39_207 VDD VDD VSS VSS gf180mcu_as_sc_mcu7t3v3__fill_2
XPHY_EDGE_ROW_113_1_Left_565 VDD VSS gf180mcu_as_sc_mcu7t3v3__tap_2
XTAP_TAPCELL_ROW_53_1_848 VDD VSS gf180mcu_as_sc_mcu7t3v3__tap_2
XPHY_EDGE_ROW_50_1_Left_502 VDD VSS gf180mcu_as_sc_mcu7t3v3__tap_2
XFILLER_22_107 VDD VDD VSS VSS gf180mcu_as_sc_mcu7t3v3__fillcap_16
X_3981_ VDD VDD VSS VSS _3981_/A _4101_/B _4101_/C _3981_/D _3983_/C gf180mcu_as_sc_mcu7t3v3__ao22_2
XFILLER_182_1430 VDD VDD VSS VSS gf180mcu_as_sc_mcu7t3v3__fill_1
X_2932_ VDD VDD VSS VSS _3236_/B _3233_/C _2932_/C _3216_/B _2947_/A gf180mcu_as_sc_mcu7t3v3__nand4_2
XFILLER_108_1534 VDD VDD VSS VSS gf180mcu_as_sc_mcu7t3v3__fillcap_16
XFILLER_108_1556 VDD VDD VSS VSS gf180mcu_as_sc_mcu7t3v3__fillcap_8
XFILLER_149_838 VDD VDD VSS VSS gf180mcu_as_sc_mcu7t3v3__fill_2
XFILLER_176_624 VDD VDD VSS VSS gf180mcu_as_sc_mcu7t3v3__fill_2
XFILLER_87_2 VDD VDD VSS VSS gf180mcu_as_sc_mcu7t3v3__fillcap_16
X_2863_ VDD VDD VSS VSS _4767_/Q _4763_/Q _2865_/B gf180mcu_as_sc_mcu7t3v3__and2_2
XFILLER_141_1160 VDD VDD VSS VSS gf180mcu_as_sc_mcu7t3v3__fill_2
XPHY_EDGE_ROW_3_3_Left_137 VDD VSS gf180mcu_as_sc_mcu7t3v3__tap_2
X_4602_ VDD VDD VSS VSS _5196_/Q _4612_/B _4612_/C _5197_/Q _5196_/D gf180mcu_as_sc_mcu7t3v3__ao22_2
X_2794_ VDD VDD VSS VSS _2794_/B _2794_/A _4626_/A gf180mcu_as_sc_mcu7t3v3__xnor2_2
XFILLER_156_370 VDD VDD VSS VSS gf180mcu_as_sc_mcu7t3v3__fillcap_4
XFILLER_7_50 VDD VDD VSS VSS gf180mcu_as_sc_mcu7t3v3__fillcap_16
XFILLER_7_72 VDD VDD VSS VSS gf180mcu_as_sc_mcu7t3v3__fillcap_16
X_4533_ VDD VDD VSS VSS _4533_/B _4576_/A _4539_/C gf180mcu_as_sc_mcu7t3v3__and2_2
XFILLER_117_18 VDD VDD VSS VSS gf180mcu_as_sc_mcu7t3v3__fillcap_16
XFILLER_172_841 VDD VDD VSS VSS gf180mcu_as_sc_mcu7t3v3__fill_1
XFILLER_176_1223 VDD VDD VSS VSS gf180mcu_as_sc_mcu7t3v3__fill_2
XPHY_EDGE_ROW_74_1_Right_73 VDD VSS gf180mcu_as_sc_mcu7t3v3__tap_2
XFILLER_116_267 VDD VDD VSS VSS gf180mcu_as_sc_mcu7t3v3__fill_1
XFILLER_131_204 VDD VDD VSS VSS gf180mcu_as_sc_mcu7t3v3__fillcap_4
XFILLER_172_874 VDD VDD VSS VSS gf180mcu_as_sc_mcu7t3v3__fill_1
XFILLER_176_1267 VDD VDD VSS VSS gf180mcu_as_sc_mcu7t3v3__fill_2
XFILLER_28_1502 VDD VDD VSS VSS gf180mcu_as_sc_mcu7t3v3__fillcap_16
X_4464_ VDD VDD VSS VSS _4465_/D _4464_/B _4581_/A gf180mcu_as_sc_mcu7t3v3__nor2_2
XFILLER_171_384 VDD VDD VSS VSS gf180mcu_as_sc_mcu7t3v3__fillcap_16
XPHY_EDGE_ROW_45_1_Left_497 VDD VSS gf180mcu_as_sc_mcu7t3v3__tap_2
Xclkbuf_leaf_35_clk_regs VDD VDD VSS VSS clkbuf_3_5_0_clk_regs/Y _4928_/CLK gf180mcu_as_sc_mcu7t3v3__clkbuff_12
Xfanout805 VDD VDD VSS VSS fanout808/Y _3661_/D gf180mcu_as_sc_mcu7t3v3__buff_2
X_4395_ VDD VDD VSS VSS _4398_/C _4395_/B _4562_/A gf180mcu_as_sc_mcu7t3v3__nor2_2
X_3415_ VDD VDD VSS VSS _3424_/B _3415_/B _3415_/C _3416_/C gf180mcu_as_sc_mcu7t3v3__nor3_2
XTAP_TAPCELL_ROW_32_1_762 VDD VSS gf180mcu_as_sc_mcu7t3v3__tap_2
XFILLER_131_259 VDD VDD VSS VSS gf180mcu_as_sc_mcu7t3v3__fillcap_4
XFILLER_28_1568 VDD VDD VSS VSS gf180mcu_as_sc_mcu7t3v3__fill_1
X_3346_ VDD VDD VSS VSS _3464_/B _4000_/A _3347_/D gf180mcu_as_sc_mcu7t3v3__and2_2
Xhold1003 VDD VDD VSS VSS hold1039/Y _2588_/A gf180mcu_as_sc_mcu7t3v3__buff_2
Xhold1014 VDD VDD VSS VSS hold1045/Y _4969_/D gf180mcu_as_sc_mcu7t3v3__buff_2
X_5016_ VDD VDD VSS VSS _5074_/CLK _5016_/D _5016_/Q gf180mcu_as_sc_mcu7t3v3__dfxtp_2
Xhold1025 VDD VDD VSS VSS _4950_/Q _2589_/C gf180mcu_as_sc_mcu7t3v3__buff_2
Xhold1036 VDD VDD VSS VSS hold1036/A _2581_/A gf180mcu_as_sc_mcu7t3v3__buff_2
Xhold1047 VDD VDD VSS VSS _4958_/Q hold1047/Y gf180mcu_as_sc_mcu7t3v3__buff_2
X_3277_ VDD VDD VSS VSS _3522_/B _3814_/B _3280_/D gf180mcu_as_sc_mcu7t3v3__nor2_2
XFILLER_148_1325 VDD VDD VSS VSS gf180mcu_as_sc_mcu7t3v3__fill_1
XFILLER_26_37 VDD VDD VSS VSS gf180mcu_as_sc_mcu7t3v3__fillcap_16
XFILLER_38_295 VDD VDD VSS VSS gf180mcu_as_sc_mcu7t3v3__fillcap_4
XFILLER_183_1216 VDD VDD VSS VSS gf180mcu_as_sc_mcu7t3v3__fill_1
XFILLER_53_298 VDD VDD VSS VSS gf180mcu_as_sc_mcu7t3v3__fill_2
XFILLER_146_1082 VDD VDD VSS VSS gf180mcu_as_sc_mcu7t3v3__fill_2
XFILLER_161_1536 VDD VDD VSS VSS gf180mcu_as_sc_mcu7t3v3__fillcap_4
XFILLER_167_602 VDD VDD VSS VSS gf180mcu_as_sc_mcu7t3v3__fillcap_4
XFILLER_139_326 VDD VDD VSS VSS gf180mcu_as_sc_mcu7t3v3__fillcap_4
XFILLER_166_101 VDD VDD VSS VSS gf180mcu_as_sc_mcu7t3v3__fillcap_4
XFILLER_166_123 VDD VDD VSS VSS gf180mcu_as_sc_mcu7t3v3__fillcap_16
XFILLER_182_616 VDD VDD VSS VSS gf180mcu_as_sc_mcu7t3v3__fillcap_8
XTAP_TAPCELL_ROW_78_3_2466 VDD VSS gf180mcu_as_sc_mcu7t3v3__tap_2
XFILLER_107_212 VDD VDD VSS VSS gf180mcu_as_sc_mcu7t3v3__fillcap_16
XFILLER_148_893 VDD VDD VSS VSS gf180mcu_as_sc_mcu7t3v3__fill_2
XFILLER_163_830 VDD VDD VSS VSS gf180mcu_as_sc_mcu7t3v3__fillcap_8
XFILLER_181_104 VDD VDD VSS VSS gf180mcu_as_sc_mcu7t3v3__fill_2
XTAP_TAPCELL_ROW_134_1212 VDD VSS gf180mcu_as_sc_mcu7t3v3__tap_2
XTAP_TAPCELL_ROW_134_1201 VDD VSS gf180mcu_as_sc_mcu7t3v3__tap_2
XFILLER_107_256 VDD VDD VSS VSS gf180mcu_as_sc_mcu7t3v3__fillcap_8
XFILLER_162_362 VDD VDD VSS VSS gf180mcu_as_sc_mcu7t3v3__fill_1
XFILLER_163_896 VDD VDD VSS VSS gf180mcu_as_sc_mcu7t3v3__fillcap_8
XFILLER_155_1329 VDD VDD VSS VSS gf180mcu_as_sc_mcu7t3v3__fill_1
XFILLER_81_1515 VDD VDD VSS VSS gf180mcu_as_sc_mcu7t3v3__fillcap_4
XTAP_TAPCELL_ROW_151_1581 VDD VSS gf180mcu_as_sc_mcu7t3v3__tap_2
XTAP_TAPCELL_ROW_151_1570 VDD VSS gf180mcu_as_sc_mcu7t3v3__tap_2
XFILLER_153_1020 VDD VDD VSS VSS gf180mcu_as_sc_mcu7t3v3__fillcap_16
XFILLER_67_22 VDD VDD VSS VSS gf180mcu_as_sc_mcu7t3v3__fillcap_16
XFILLER_81_1537 VDD VDD VSS VSS gf180mcu_as_sc_mcu7t3v3__fillcap_16
XFILLER_88_173 VDD VDD VSS VSS gf180mcu_as_sc_mcu7t3v3__fill_2
XFILLER_123_72 VDD VDD VSS VSS gf180mcu_as_sc_mcu7t3v3__fillcap_16
XFILLER_79_1499 VDD VDD VSS VSS gf180mcu_as_sc_mcu7t3v3__fillcap_16
XFILLER_164_1182 VDD VDD VSS VSS gf180mcu_as_sc_mcu7t3v3__fillcap_8
XTAP_TAPCELL_ROW_158_1735 VDD VSS gf180mcu_as_sc_mcu7t3v3__tap_2
XTAP_TAPCELL_ROW_158_1724 VDD VSS gf180mcu_as_sc_mcu7t3v3__tap_2
XFILLER_145_307 VDD VDD VSS VSS gf180mcu_as_sc_mcu7t3v3__fill_2
XFILLER_158_679 VDD VDD VSS VSS gf180mcu_as_sc_mcu7t3v3__fill_2
XFILLER_160_1079 VDD VDD VSS VSS gf180mcu_as_sc_mcu7t3v3__fillcap_4
XFILLER_139_893 VDD VDD VSS VSS gf180mcu_as_sc_mcu7t3v3__fill_2
XFILLER_142_1480 VDD VDD VSS VSS gf180mcu_as_sc_mcu7t3v3__fillcap_4
XFILLER_154_830 VDD VDD VSS VSS gf180mcu_as_sc_mcu7t3v3__fillcap_8
XFILLER_16_1483 VDD VDD VSS VSS gf180mcu_as_sc_mcu7t3v3__fill_1
XFILLER_173_627 VDD VDD VSS VSS gf180mcu_as_sc_mcu7t3v3__fill_2
XFILLER_8_155 VDD VDD VSS VSS gf180mcu_as_sc_mcu7t3v3__fillcap_16
XFILLER_8_177 VDD VDD VSS VSS gf180mcu_as_sc_mcu7t3v3__fillcap_16
XTAP_TAPCELL_ROW_30_3_2394 VDD VSS gf180mcu_as_sc_mcu7t3v3__tap_2
Xoutput408 VDD VDD VSS VSS _4828_/Q south_out[23] gf180mcu_as_sc_mcu7t3v3__buff_2
XFILLER_113_204 VDD VDD VSS VSS gf180mcu_as_sc_mcu7t3v3__fillcap_4
XFILLER_138_1527 VDD VDD VSS VSS gf180mcu_as_sc_mcu7t3v3__fillcap_8
XFILLER_173_1418 VDD VDD VSS VSS gf180mcu_as_sc_mcu7t3v3__fillcap_8
XFILLER_177_1554 VDD VDD VSS VSS gf180mcu_as_sc_mcu7t3v3__fill_1
Xoutput419 VDD VDD VSS VSS _4838_/Q south_out[33] gf180mcu_as_sc_mcu7t3v3__buff_2
XFILLER_181_693 VDD VDD VSS VSS gf180mcu_as_sc_mcu7t3v3__fill_1
X_4180_ VDD VDD VSS VSS _4240_/B _4187_/B _4190_/C _5018_/Q _5018_/D gf180mcu_as_sc_mcu7t3v3__ao22_2
X_3200_ VDD VDD VSS VSS _3203_/A _3236_/C _3788_/D gf180mcu_as_sc_mcu7t3v3__nand2_2
XFILLER_171_1175 VDD VDD VSS VSS gf180mcu_as_sc_mcu7t3v3__fill_2
X_3131_ VDD VDD VSS VSS _3132_/B _3131_/B _3131_/C _3132_/C gf180mcu_as_sc_mcu7t3v3__nor3_2
XFILLER_114_1560 VDD VDD VSS VSS gf180mcu_as_sc_mcu7t3v3__fill_1
XFILLER_3_1515 VDD VDD VSS VSS gf180mcu_as_sc_mcu7t3v3__fillcap_4
XFILLER_3_1537 VDD VDD VSS VSS gf180mcu_as_sc_mcu7t3v3__fillcap_16
X_3062_ VDD VDD VSS VSS _3121_/B _4928_/Q _3063_/D gf180mcu_as_sc_mcu7t3v3__or2_2
XFILLER_94_187 VDD VDD VSS VSS gf180mcu_as_sc_mcu7t3v3__fillcap_16
XTAP_TAPCELL_ROW_84_3_2476 VDD VSS gf180mcu_as_sc_mcu7t3v3__tap_2
XFILLER_169_1093 VDD VDD VSS VSS gf180mcu_as_sc_mcu7t3v3__fillcap_16
XTAP_TAPCELL_ROW_35_1_777 VDD VSS gf180mcu_as_sc_mcu7t3v3__tap_2
XFILLER_35_276 VDD VDD VSS VSS gf180mcu_as_sc_mcu7t3v3__fillcap_4
XFILLER_35_298 VDD VDD VSS VSS gf180mcu_as_sc_mcu7t3v3__fill_2
XFILLER_50_235 VDD VDD VSS VSS gf180mcu_as_sc_mcu7t3v3__fillcap_8
X_3964_ VDD VDD VSS VSS _4981_/Q _4117_/B _4232_/B _4108_/D _4981_/D gf180mcu_as_sc_mcu7t3v3__ao22_2
XFILLER_143_1233 VDD VDD VSS VSS gf180mcu_as_sc_mcu7t3v3__fill_1
XFILLER_148_101 VDD VDD VSS VSS gf180mcu_as_sc_mcu7t3v3__fillcap_4
XFILLER_148_123 VDD VDD VSS VSS gf180mcu_as_sc_mcu7t3v3__fillcap_16
XFILLER_149_624 VDD VDD VSS VSS gf180mcu_as_sc_mcu7t3v3__fillcap_4
X_3895_ VDD VDD VSS VSS _3908_/B _5185_/Q _4935_/D gf180mcu_as_sc_mcu7t3v3__and2_2
X_2915_ VDD VDD VSS VSS _3787_/A _3255_/B _3544_/C _3201_/C _3233_/B gf180mcu_as_sc_mcu7t3v3__aoi31_2
XFILLER_136_307 VDD VDD VSS VSS gf180mcu_as_sc_mcu7t3v3__fill_1
XFILLER_149_679 VDD VDD VSS VSS gf180mcu_as_sc_mcu7t3v3__fillcap_16
XFILLER_177_988 VDD VDD VSS VSS gf180mcu_as_sc_mcu7t3v3__fillcap_8
XFILLER_34_1550 VDD VDD VSS VSS gf180mcu_as_sc_mcu7t3v3__fillcap_4
X_2846_ VDD VDD VSS VSS _5277_/Q _2847_/A _4708_/C _2847_/C _4748_/B gf180mcu_as_sc_mcu7t3v3__aoi31_2
XFILLER_163_104 VDD VDD VSS VSS gf180mcu_as_sc_mcu7t3v3__fillcap_16
XFILLER_164_627 VDD VDD VSS VSS gf180mcu_as_sc_mcu7t3v3__fill_2
X_2777_ VDD VDD VSS VSS _2778_/B _4739_/A _5269_/Q _5272_/Q gf180mcu_as_sc_mcu7t3v3__aoi21b_2
XFILLER_176_1053 VDD VDD VSS VSS gf180mcu_as_sc_mcu7t3v3__fill_2
X_4516_ VDD VDD VSS VSS _4520_/B _5080_/Q _4518_/S gf180mcu_as_sc_mcu7t3v3__nand2_2
XFILLER_104_226 VDD VDD VSS VSS gf180mcu_as_sc_mcu7t3v3__fill_2
X_4447_ VDD VDD VSS VSS _4447_/S _5014_/Q _5043_/Q _4448_/B gf180mcu_as_sc_mcu7t3v3__mux2_2
XFILLER_160_877 VDD VDD VSS VSS gf180mcu_as_sc_mcu7t3v3__fillcap_16
Xfanout602 VDD VDD VSS VSS _3923_/Y fanout602/Y gf180mcu_as_sc_mcu7t3v3__buff_2
Xfanout613 VDD VDD VSS VSS fanout617/Y _3502_/B gf180mcu_as_sc_mcu7t3v3__buff_2
Xfanout624 VDD VDD VSS VSS _2947_/Y _3241_/B gf180mcu_as_sc_mcu7t3v3__buff_2
XFILLER_154_1362 VDD VDD VSS VSS gf180mcu_as_sc_mcu7t3v3__fill_2
Xfanout635 VDD VDD VSS VSS _4305_/S _4328_/A gf180mcu_as_sc_mcu7t3v3__buff_2
Xfanout646 VDD VDD VSS VSS _4593_/Y _4750_/D gf180mcu_as_sc_mcu7t3v3__buff_2
Xfanout657 VDD VDD VSS VSS fanout660/Y _3473_/B gf180mcu_as_sc_mcu7t3v3__buff_2
X_4378_ VDD VDD VSS VSS _5485_/A _4590_/C _4378_/C _4378_/D _4380_/A gf180mcu_as_sc_mcu7t3v3__ao211_2
XTAP_TAPCELL_ROW_14_1_691 VDD VSS gf180mcu_as_sc_mcu7t3v3__tap_2
XFILLER_41_1521 VDD VDD VSS VSS gf180mcu_as_sc_mcu7t3v3__fillcap_16
Xfanout668 VDD VDD VSS VSS _4129_/C _4102_/C gf180mcu_as_sc_mcu7t3v3__buff_2
Xfanout679 VDD VDD VSS VSS _3566_/Y _3748_/C gf180mcu_as_sc_mcu7t3v3__buff_2
X_3329_ VDD VDD VSS VSS _3981_/D _3449_/B _3329_/C _3450_/B _3331_/C gf180mcu_as_sc_mcu7t3v3__ao211_2
XTAP_TAPCELL_ROW_181_2231 VDD VSS gf180mcu_as_sc_mcu7t3v3__tap_2
XFILLER_37_58 VDD VDD VSS VSS gf180mcu_as_sc_mcu7t3v3__fillcap_8
XTAP_TAPCELL_ROW_181_2242 VDD VSS gf180mcu_as_sc_mcu7t3v3__tap_2
XFILLER_160_37 VDD VDD VSS VSS gf180mcu_as_sc_mcu7t3v3__fillcap_16
XTAP_TAPCELL_ROW_0_1_2346 VDD VSS gf180mcu_as_sc_mcu7t3v3__tap_2
XFILLER_39_1483 VDD VDD VSS VSS gf180mcu_as_sc_mcu7t3v3__fillcap_16
XTAP_TAPCELL_ROW_179_2193 VDD VSS gf180mcu_as_sc_mcu7t3v3__tap_2
XFILLER_168_944 VDD VDD VSS VSS gf180mcu_as_sc_mcu7t3v3__fill_1
XFILLER_126_1486 VDD VDD VSS VSS gf180mcu_as_sc_mcu7t3v3__fillcap_16
XFILLER_139_156 VDD VDD VSS VSS gf180mcu_as_sc_mcu7t3v3__fill_1
XFILLER_167_454 VDD VDD VSS VSS gf180mcu_as_sc_mcu7t3v3__fillcap_16
XFILLER_155_616 VDD VDD VSS VSS gf180mcu_as_sc_mcu7t3v3__fillcap_8
XFILLER_155_649 VDD VDD VSS VSS gf180mcu_as_sc_mcu7t3v3__fillcap_16
XFILLER_183_936 VDD VDD VSS VSS gf180mcu_as_sc_mcu7t3v3__fillcap_16
XFILLER_136_841 VDD VDD VSS VSS gf180mcu_as_sc_mcu7t3v3__fill_1
XFILLER_182_435 VDD VDD VSS VSS gf180mcu_as_sc_mcu7t3v3__fillcap_16
XFILLER_182_457 VDD VDD VSS VSS gf180mcu_as_sc_mcu7t3v3__fillcap_16
XFILLER_5_136 VDD VDD VSS VSS gf180mcu_as_sc_mcu7t3v3__fillcap_4
XTAP_TAPCELL_ROW_153_1632 VDD VSS gf180mcu_as_sc_mcu7t3v3__tap_2
XTAP_TAPCELL_ROW_153_1621 VDD VSS gf180mcu_as_sc_mcu7t3v3__tap_2
XFILLER_151_811 VDD VDD VSS VSS gf180mcu_as_sc_mcu7t3v3__fillcap_16
XFILLER_159_1262 VDD VDD VSS VSS gf180mcu_as_sc_mcu7t3v3__fillcap_8
XFILLER_5_158 VDD VDD VSS VSS gf180mcu_as_sc_mcu7t3v3__fillcap_16
XFILLER_118_61 VDD VDD VSS VSS gf180mcu_as_sc_mcu7t3v3__fillcap_8
XFILLER_150_310 VDD VDD VSS VSS gf180mcu_as_sc_mcu7t3v3__fillcap_4
XFILLER_155_1115 VDD VDD VSS VSS gf180mcu_as_sc_mcu7t3v3__fillcap_4
XFILLER_163_682 VDD VDD VSS VSS gf180mcu_as_sc_mcu7t3v3__fill_1
XTAP_TAPCELL_ROW_170_1990 VDD VSS gf180mcu_as_sc_mcu7t3v3__tap_2
XFILLER_150_387 VDD VDD VSS VSS gf180mcu_as_sc_mcu7t3v3__fill_1
XFILLER_172_1473 VDD VDD VSS VSS gf180mcu_as_sc_mcu7t3v3__fillcap_16
XFILLER_103_292 VDD VDD VSS VSS gf180mcu_as_sc_mcu7t3v3__fillcap_8
XFILLER_76_165 VDD VDD VSS VSS gf180mcu_as_sc_mcu7t3v3__fill_2
XFILLER_91_113 VDD VDD VSS VSS gf180mcu_as_sc_mcu7t3v3__fillcap_8
XFILLER_94_86 VDD VDD VSS VSS gf180mcu_as_sc_mcu7t3v3__fillcap_4
XFILLER_150_81 VDD VDD VSS VSS gf180mcu_as_sc_mcu7t3v3__fillcap_16
XFILLER_166_1255 VDD VDD VSS VSS gf180mcu_as_sc_mcu7t3v3__fillcap_8
XTAP_TAPCELL_ROW_23_1_726 VDD VSS gf180mcu_as_sc_mcu7t3v3__tap_2
XFILLER_166_1288 VDD VDD VSS VSS gf180mcu_as_sc_mcu7t3v3__fillcap_4
XFILLER_17_298 VDD VDD VSS VSS gf180mcu_as_sc_mcu7t3v3__fill_2
XTAP_TAPCELL_ROW_31_1_761 VDD VSS gf180mcu_as_sc_mcu7t3v3__tap_2
XFILLER_158_410 VDD VDD VSS VSS gf180mcu_as_sc_mcu7t3v3__fill_2
XFILLER_159_944 VDD VDD VSS VSS gf180mcu_as_sc_mcu7t3v3__fillcap_16
XFILLER_18_1534 VDD VDD VSS VSS gf180mcu_as_sc_mcu7t3v3__fillcap_16
XFILLER_18_1556 VDD VDD VSS VSS gf180mcu_as_sc_mcu7t3v3__fillcap_8
XFILLER_32_279 VDD VDD VSS VSS gf180mcu_as_sc_mcu7t3v3__fillcap_16
XFILLER_105_1515 VDD VDD VSS VSS gf180mcu_as_sc_mcu7t3v3__fillcap_4
XFILLER_105_1537 VDD VDD VSS VSS gf180mcu_as_sc_mcu7t3v3__fillcap_16
X_2700_ VDD VDD VSS VSS _2735_/D _2700_/A _2701_/D gf180mcu_as_sc_mcu7t3v3__and2_2
XFILLER_145_104 VDD VDD VSS VSS gf180mcu_as_sc_mcu7t3v3__fill_2
XFILLER_174_947 VDD VDD VSS VSS gf180mcu_as_sc_mcu7t3v3__fill_2
X_3680_ VDD VDD VSS VSS _4930_/Q _3719_/B _3719_/C _4053_/D _3681_/D gf180mcu_as_sc_mcu7t3v3__ao22_2
XFILLER_64_4 VDD VDD VSS VSS gf180mcu_as_sc_mcu7t3v3__fill_1
X_2631_ VDD VDD VSS VSS _2631_/D _5232_/Q _5229_/Q _2711_/S _2636_/A gf180mcu_as_sc_mcu7t3v3__ao31_2
XFILLER_138_1313 VDD VDD VSS VSS gf180mcu_as_sc_mcu7t3v3__fillcap_16
XFILLER_160_107 VDD VDD VSS VSS gf180mcu_as_sc_mcu7t3v3__fillcap_16
X_2562_ VDD VDD VSS VSS _4975_/D _4769_/Q _4770_/Q _2711_/S _2601_/D gf180mcu_as_sc_mcu7t3v3__ao22_2
XFILLER_153_170 VDD VDD VSS VSS gf180mcu_as_sc_mcu7t3v3__fillcap_16
XFILLER_177_1373 VDD VDD VSS VSS gf180mcu_as_sc_mcu7t3v3__fillcap_4
X_5281_ VDD VDD VSS VSS clkload1/A _5281_/D _5281_/Q gf180mcu_as_sc_mcu7t3v3__dfxtp_2
X_4301_ VDD VDD VSS VSS _4305_/S _5131_/Q _5130_/Q _5130_/D gf180mcu_as_sc_mcu7t3v3__mux2_2
XFILLER_142_877 VDD VDD VSS VSS gf180mcu_as_sc_mcu7t3v3__fillcap_16
X_4232_ VDD VDD VSS VSS _4250_/S _4232_/B _5068_/Q _5068_/D gf180mcu_as_sc_mcu7t3v3__mux2_2
X_2493_ VDD VDD VSS VSS _5189_/Q _4954_/Q _2794_/B gf180mcu_as_sc_mcu7t3v3__xnor2_2
XFILLER_99_279 VDD VDD VSS VSS gf180mcu_as_sc_mcu7t3v3__fill_1
XFILLER_151_1535 VDD VDD VSS VSS gf180mcu_as_sc_mcu7t3v3__fillcap_4
XFILLER_67_110 VDD VDD VSS VSS gf180mcu_as_sc_mcu7t3v3__fill_2
X_4163_ VDD VDD VSS VSS _4163_/A _4163_/B _4163_/C _4163_/D _4164_/B gf180mcu_as_sc_mcu7t3v3__ao211_2
X_4094_ VDD VDD VSS VSS _4094_/A _4119_/B _4124_/B _4094_/D _4098_/A gf180mcu_as_sc_mcu7t3v3__ao211_2
X_3114_ VDD VDD VSS VSS _3115_/C _3114_/C _3125_/C _4085_/A gf180mcu_as_sc_mcu7t3v3__aoi21_2
XFILLER_67_198 VDD VDD VSS VSS gf180mcu_as_sc_mcu7t3v3__fillcap_8
X_3045_ VDD VDD VSS VSS _3120_/A _3045_/B _3045_/C _3120_/D _3047_/C gf180mcu_as_sc_mcu7t3v3__ao211_2
XFILLER_130_18 VDD VDD VSS VSS gf180mcu_as_sc_mcu7t3v3__fillcap_16
XFILLER_184_1366 VDD VDD VSS VSS gf180mcu_as_sc_mcu7t3v3__fillcap_8
X_4996_ VDD VDD VSS VSS _5183_/CLK _4996_/D _4996_/Q gf180mcu_as_sc_mcu7t3v3__dfxtp_2
X_3947_ VDD VDD VSS VSS _3947_/A _4160_/B _4161_/B _3947_/D _3948_/D gf180mcu_as_sc_mcu7t3v3__ao22_2
XFILLER_143_1052 VDD VDD VSS VSS gf180mcu_as_sc_mcu7t3v3__fillcap_4
XTAP_TAPCELL_ROW_7_1_663 VDD VSS gf180mcu_as_sc_mcu7t3v3__tap_2
XFILLER_137_616 VDD VDD VSS VSS gf180mcu_as_sc_mcu7t3v3__fillcap_8
XFILLER_164_402 VDD VDD VSS VSS gf180mcu_as_sc_mcu7t3v3__fillcap_16
X_3878_ VDD VDD VSS VSS _3897_/B _5168_/Q _4918_/D gf180mcu_as_sc_mcu7t3v3__and2_2
XFILLER_164_457 VDD VDD VSS VSS gf180mcu_as_sc_mcu7t3v3__fillcap_8
XFILLER_176_295 VDD VDD VSS VSS gf180mcu_as_sc_mcu7t3v3__fillcap_16
XFILLER_178_1115 VDD VDD VSS VSS gf180mcu_as_sc_mcu7t3v3__fillcap_4
X_2829_ VDD VDD VSS VSS _4751_/A _2829_/B _5284_/Q _5283_/D gf180mcu_as_sc_mcu7t3v3__mux2_2
XTAP_TAPCELL_ROW_174_2090 VDD VSS gf180mcu_as_sc_mcu7t3v3__tap_2
XFILLER_145_682 VDD VDD VSS VSS gf180mcu_as_sc_mcu7t3v3__fill_2
XFILLER_173_991 VDD VDD VSS VSS gf180mcu_as_sc_mcu7t3v3__fillcap_8
X_5479_ VDD VDD VSS VSS _5479_/A _5479_/Y gf180mcu_as_sc_mcu7t3v3__buff_2
XPHY_EDGE_ROW_37_1_Right_36 VDD VSS gf180mcu_as_sc_mcu7t3v3__tap_2
XFILLER_150_1001 VDD VDD VSS VSS gf180mcu_as_sc_mcu7t3v3__fill_1
XFILLER_150_1012 VDD VDD VSS VSS gf180mcu_as_sc_mcu7t3v3__fill_2
XFILLER_58_121 VDD VDD VSS VSS gf180mcu_as_sc_mcu7t3v3__fillcap_16
XFILLER_100_251 VDD VDD VSS VSS gf180mcu_as_sc_mcu7t3v3__fill_1
XFILLER_150_1067 VDD VDD VSS VSS gf180mcu_as_sc_mcu7t3v3__fillcap_16
Xfanout476 VDD VDD VSS VSS _3560_/Y _3730_/A gf180mcu_as_sc_mcu7t3v3__buff_2
Xfanout487 VDD VDD VSS VSS _4223_/B _4218_/B gf180mcu_as_sc_mcu7t3v3__buff_2
Xfanout498 VDD VDD VSS VSS _3731_/B _3723_/B gf180mcu_as_sc_mcu7t3v3__buff_2
XFILLER_104_52 VDD VDD VSS VSS gf180mcu_as_sc_mcu7t3v3__fill_1
XFILLER_73_135 VDD VDD VSS VSS gf180mcu_as_sc_mcu7t3v3__fillcap_4
Xmesh_tile_880 VDD VDD VSS VSS north_out[21] gf180mcu_as_sc_mcu7t3v3__tiel_4
XTAP_TAPCELL_ROW_63_1_886 VDD VSS gf180mcu_as_sc_mcu7t3v3__tap_2
XFILLER_104_96 VDD VDD VSS VSS gf180mcu_as_sc_mcu7t3v3__fill_2
XFILLER_167_1520 VDD VDD VSS VSS gf180mcu_as_sc_mcu7t3v3__fillcap_16
XFILLER_64_34 VDD VDD VSS VSS gf180mcu_as_sc_mcu7t3v3__fill_1
XFILLER_73_146 VDD VDD VSS VSS gf180mcu_as_sc_mcu7t3v3__fill_2
Xmesh_tile_891 VDD VDD VSS VSS north_out[32] gf180mcu_as_sc_mcu7t3v3__tiel_4
XTAP_TAPCELL_ROW_133_1_1167 VDD VSS gf180mcu_as_sc_mcu7t3v3__tap_2
XFILLER_167_1542 VDD VDD VSS VSS gf180mcu_as_sc_mcu7t3v3__fillcap_16
XTAP_TAPCELL_ROW_66_3_2448 VDD VSS gf180mcu_as_sc_mcu7t3v3__tap_2
XFILLER_154_2 VDD VDD VSS VSS gf180mcu_as_sc_mcu7t3v3__fillcap_16
XFILLER_163_1428 VDD VDD VSS VSS gf180mcu_as_sc_mcu7t3v3__fill_2
XFILLER_9_18 VDD VDD VSS VSS gf180mcu_as_sc_mcu7t3v3__fillcap_16
XTAP_TAPCELL_ROW_142_1388 VDD VSS gf180mcu_as_sc_mcu7t3v3__tap_2
XTAP_TAPCELL_ROW_142_1377 VDD VSS gf180mcu_as_sc_mcu7t3v3__tap_2
XFILLER_120_73 VDD VDD VSS VSS gf180mcu_as_sc_mcu7t3v3__fill_1
XFILLER_14_279 VDD VDD VSS VSS gf180mcu_as_sc_mcu7t3v3__fillcap_16
XFILLER_161_1152 VDD VDD VSS VSS gf180mcu_as_sc_mcu7t3v3__fillcap_8
XFILLER_168_763 VDD VDD VSS VSS gf180mcu_as_sc_mcu7t3v3__fill_2
XTAP_TAPCELL_ROW_113_1_1087 VDD VSS gf180mcu_as_sc_mcu7t3v3__tap_2
XFILLER_127_104 VDD VDD VSS VSS gf180mcu_as_sc_mcu7t3v3__fill_2
XFILLER_155_424 VDD VDD VSS VSS gf180mcu_as_sc_mcu7t3v3__fill_1
XFILLER_156_925 VDD VDD VSS VSS gf180mcu_as_sc_mcu7t3v3__fill_2
XFILLER_156_947 VDD VDD VSS VSS gf180mcu_as_sc_mcu7t3v3__fill_2
XFILLER_161_1174 VDD VDD VSS VSS gf180mcu_as_sc_mcu7t3v3__fillcap_16
XFILLER_183_733 VDD VDD VSS VSS gf180mcu_as_sc_mcu7t3v3__fill_1
XFILLER_80_88 VDD VDD VSS VSS gf180mcu_as_sc_mcu7t3v3__fillcap_4
XPHY_EDGE_ROW_122_1_Left_574 VDD VSS gf180mcu_as_sc_mcu7t3v3__tap_2
XFILLER_127_159 VDD VDD VSS VSS gf180mcu_as_sc_mcu7t3v3__fillcap_4
XFILLER_87_1521 VDD VDD VSS VSS gf180mcu_as_sc_mcu7t3v3__fillcap_16
XTAP_TAPCELL_ROW_92_1_1005 VDD VSS gf180mcu_as_sc_mcu7t3v3__tap_2
XFILLER_100_1467 VDD VDD VSS VSS gf180mcu_as_sc_mcu7t3v3__fillcap_16
X_4850_ VDD VDD VSS VSS _4938_/CLK _4850_/D _4850_/Q gf180mcu_as_sc_mcu7t3v3__dfxtp_2
XPHY_EDGE_ROW_83_1_Right_82 VDD VSS gf180mcu_as_sc_mcu7t3v3__tap_2
XFILLER_159_730 VDD VDD VSS VSS gf180mcu_as_sc_mcu7t3v3__fillcap_4
XFILLER_178_527 VDD VDD VSS VSS gf180mcu_as_sc_mcu7t3v3__fillcap_8
XFILLER_178_549 VDD VDD VSS VSS gf180mcu_as_sc_mcu7t3v3__fillcap_16
XFILLER_181_1539 VDD VDD VSS VSS gf180mcu_as_sc_mcu7t3v3__fill_1
X_3801_ VDD VDD VSS VSS _3801_/D _3801_/A _3801_/B _3801_/C _3802_/D gf180mcu_as_sc_mcu7t3v3__ao31_2
XFILLER_144_1361 VDD VDD VSS VSS gf180mcu_as_sc_mcu7t3v3__fillcap_4
X_4781_ VDD VDD VSS VSS _5052_/CLK _4781_/D _4781_/Q gf180mcu_as_sc_mcu7t3v3__dfxtp_2
XFILLER_118_104 VDD VDD VSS VSS gf180mcu_as_sc_mcu7t3v3__fill_1
XFILLER_146_402 VDD VDD VSS VSS gf180mcu_as_sc_mcu7t3v3__fillcap_16
XFILLER_158_251 VDD VDD VSS VSS gf180mcu_as_sc_mcu7t3v3__fill_1
XFILLER_159_796 VDD VDD VSS VSS gf180mcu_as_sc_mcu7t3v3__fillcap_4
X_3732_ VDD VDD VSS VSS _4113_/A _3749_/B _3748_/C _4112_/A _3733_/C gf180mcu_as_sc_mcu7t3v3__ao22_2
XTAP_TAPCELL_ROW_80_1_956 VDD VSS gf180mcu_as_sc_mcu7t3v3__tap_2
XFILLER_146_457 VDD VDD VSS VSS gf180mcu_as_sc_mcu7t3v3__fillcap_8
XFILLER_174_744 VDD VDD VSS VSS gf180mcu_as_sc_mcu7t3v3__fillcap_4
Xclkload20 VDD VDD VSS VSS _5088_/CLK clkload20/Y gf180mcu_as_sc_mcu7t3v3__clkbuff_4
X_3663_ VDD VDD VSS VSS _3664_/C _4037_/D _3717_/B _3663_/C gf180mcu_as_sc_mcu7t3v3__ao21_2
XFILLER_173_276 VDD VDD VSS VSS gf180mcu_as_sc_mcu7t3v3__fillcap_4
XFILLER_174_788 VDD VDD VSS VSS gf180mcu_as_sc_mcu7t3v3__fill_2
XFILLER_31_1553 VDD VDD VSS VSS gf180mcu_as_sc_mcu7t3v3__fillcap_16
X_2614_ VDD VDD VSS VSS _2883_/B _2614_/B _2776_/A gf180mcu_as_sc_mcu7t3v3__nand2_2
XFILLER_173_1001 VDD VDD VSS VSS gf180mcu_as_sc_mcu7t3v3__fill_1
XFILLER_173_298 VDD VDD VSS VSS gf180mcu_as_sc_mcu7t3v3__fillcap_16
X_3594_ VDD VDD VSS VSS _3962_/A _3753_/B _3594_/C _4842_/D _3753_/D gf180mcu_as_sc_mcu7t3v3__aoi211_2
XFILLER_138_1154 VDD VDD VSS VSS gf180mcu_as_sc_mcu7t3v3__fill_1
X_2545_ VDD VDD VSS VSS _5125_/Q _2545_/B _4328_/A _2745_/B _2545_/D gf180mcu_as_sc_mcu7t3v3__aoi31_2
XFILLER_125_18 VDD VDD VSS VSS gf180mcu_as_sc_mcu7t3v3__fillcap_16
XFILLER_9_1521 VDD VDD VSS VSS gf180mcu_as_sc_mcu7t3v3__fillcap_16
X_5264_ VDD VDD VSS VSS clkload7/A _5264_/D _5264_/Q gf180mcu_as_sc_mcu7t3v3__dfxtp_2
X_2476_ VDD VDD VSS VSS _2476_/B _3907_/A _4951_/D gf180mcu_as_sc_mcu7t3v3__and2_2
XTAP_TAPCELL_ROW_72_3_2458 VDD VSS gf180mcu_as_sc_mcu7t3v3__tap_2
XFILLER_87_249 VDD VDD VSS VSS gf180mcu_as_sc_mcu7t3v3__fillcap_4
X_5195_ VDD VDD VSS VSS clkload2/A _5195_/D _5195_/Q gf180mcu_as_sc_mcu7t3v3__dfxtp_2
X_4215_ VDD VDD VSS VSS _4244_/B _4219_/B _4219_/C _5051_/Q _5051_/D gf180mcu_as_sc_mcu7t3v3__ao22_2
XFILLER_151_1354 VDD VDD VSS VSS gf180mcu_as_sc_mcu7t3v3__fill_2
X_4146_ VDD VDD VSS VSS _4146_/A _4162_/B _4160_/B _4146_/D _4147_/D gf180mcu_as_sc_mcu7t3v3__ao22_2
XFILLER_95_282 VDD VDD VSS VSS gf180mcu_as_sc_mcu7t3v3__fillcap_16
XFILLER_55_135 VDD VDD VSS VSS gf180mcu_as_sc_mcu7t3v3__fillcap_4
X_4077_ VDD VDD VSS VSS _4077_/A _4126_/B _4126_/C _4077_/D _4078_/D gf180mcu_as_sc_mcu7t3v3__ao22_2
X_3028_ VDD VDD VSS VSS _3137_/B _4924_/Q _3029_/D gf180mcu_as_sc_mcu7t3v3__or2_2
XFILLER_184_1152 VDD VDD VSS VSS gf180mcu_as_sc_mcu7t3v3__fillcap_4
XFILLER_34_37 VDD VDD VSS VSS gf180mcu_as_sc_mcu7t3v3__fillcap_16
XFILLER_169_538 VDD VDD VSS VSS gf180mcu_as_sc_mcu7t3v3__fill_2
XTAP_TAPCELL_ROW_176_2130 VDD VSS gf180mcu_as_sc_mcu7t3v3__tap_2
XFILLER_140_8 VDD VDD VSS VSS gf180mcu_as_sc_mcu7t3v3__fillcap_4
X_4979_ VDD VDD VSS VSS _5172_/CLK _4979_/D _4979_/Q gf180mcu_as_sc_mcu7t3v3__dfxtp_2
XFILLER_36_1486 VDD VDD VSS VSS gf180mcu_as_sc_mcu7t3v3__fillcap_16
Xclkload3 VDD VDD VSS VSS clkload3/Y clkload3/A gf180mcu_as_sc_mcu7t3v3__inv_6
XTAP_TAPCELL_ROW_172_2038 VDD VSS gf180mcu_as_sc_mcu7t3v3__tap_2
XFILLER_123_1467 VDD VDD VSS VSS gf180mcu_as_sc_mcu7t3v3__fillcap_16
XFILLER_138_947 VDD VDD VSS VSS gf180mcu_as_sc_mcu7t3v3__fillcap_8
XFILLER_153_906 VDD VDD VSS VSS gf180mcu_as_sc_mcu7t3v3__fillcap_4
XFILLER_50_25 VDD VDD VSS VSS gf180mcu_as_sc_mcu7t3v3__fillcap_8
XTAP_TAPCELL_ROW_172_2049 VDD VSS gf180mcu_as_sc_mcu7t3v3__tap_2
XFILLER_124_107 VDD VDD VSS VSS gf180mcu_as_sc_mcu7t3v3__fillcap_8
XFILLER_124_129 VDD VDD VSS VSS gf180mcu_as_sc_mcu7t3v3__fillcap_16
XFILLER_166_69 VDD VDD VSS VSS gf180mcu_as_sc_mcu7t3v3__fillcap_16
XFILLER_156_1243 VDD VDD VSS VSS gf180mcu_as_sc_mcu7t3v3__fillcap_16
XTAP_TAPCELL_ROW_22_1_725 VDD VSS gf180mcu_as_sc_mcu7t3v3__tap_2
XFILLER_132_195 VDD VDD VSS VSS gf180mcu_as_sc_mcu7t3v3__fillcap_4
XFILLER_82_1451 VDD VDD VSS VSS gf180mcu_as_sc_mcu7t3v3__fillcap_16
XTAP_TAPCELL_ROW_148_1520 VDD VSS gf180mcu_as_sc_mcu7t3v3__tap_2
XTAP_TAPCELL_ROW_144_1417 VDD VSS gf180mcu_as_sc_mcu7t3v3__tap_2
XFILLER_75_66 VDD VDD VSS VSS gf180mcu_as_sc_mcu7t3v3__fillcap_4
XFILLER_75_88 VDD VDD VSS VSS gf180mcu_as_sc_mcu7t3v3__fillcap_4
XTAP_TAPCELL_ROW_144_1428 VDD VSS gf180mcu_as_sc_mcu7t3v3__tap_2
XFILLER_131_72 VDD VDD VSS VSS gf180mcu_as_sc_mcu7t3v3__fill_2
XFILLER_61_138 VDD VDD VSS VSS gf180mcu_as_sc_mcu7t3v3__fill_2
XFILLER_91_10 VDD VDD VSS VSS gf180mcu_as_sc_mcu7t3v3__fillcap_4
XTAP_TAPCELL_ROW_161_1797 VDD VSS gf180mcu_as_sc_mcu7t3v3__tap_2
XFILLER_141_1534 VDD VDD VSS VSS gf180mcu_as_sc_mcu7t3v3__fillcap_4
XFILLER_15_1515 VDD VDD VSS VSS gf180mcu_as_sc_mcu7t3v3__fillcap_4
XFILLER_15_1537 VDD VDD VSS VSS gf180mcu_as_sc_mcu7t3v3__fillcap_16
XFILLER_54_1564 VDD VDD VSS VSS gf180mcu_as_sc_mcu7t3v3__fillcap_4
XFILLER_102_1518 VDD VDD VSS VSS gf180mcu_as_sc_mcu7t3v3__fillcap_16
XFILLER_10_271 VDD VDD VSS VSS gf180mcu_as_sc_mcu7t3v3__fillcap_4
XFILLER_156_777 VDD VDD VSS VSS gf180mcu_as_sc_mcu7t3v3__fillcap_16
XFILLER_183_596 VDD VDD VSS VSS gf180mcu_as_sc_mcu7t3v3__fill_2
XFILLER_40_80 VDD VDD VSS VSS gf180mcu_as_sc_mcu7t3v3__fillcap_16
XPHY_EDGE_ROW_115_3_Left_249 VDD VSS gf180mcu_as_sc_mcu7t3v3__tap_2
XFILLER_171_769 VDD VDD VSS VSS gf180mcu_as_sc_mcu7t3v3__fill_1
XFILLER_174_1321 VDD VDD VSS VSS gf180mcu_as_sc_mcu7t3v3__fill_2
XFILLER_123_151 VDD VDD VSS VSS gf180mcu_as_sc_mcu7t3v3__fill_2
XFILLER_152_972 VDD VDD VSS VSS gf180mcu_as_sc_mcu7t3v3__fillcap_16
XFILLER_156_91 VDD VDD VSS VSS gf180mcu_as_sc_mcu7t3v3__fill_1
XFILLER_170_279 VDD VDD VSS VSS gf180mcu_as_sc_mcu7t3v3__fillcap_16
XFILLER_123_173 VDD VDD VSS VSS gf180mcu_as_sc_mcu7t3v3__fill_1
XFILLER_174_1398 VDD VDD VSS VSS gf180mcu_as_sc_mcu7t3v3__fillcap_8
X_4000_ VDD VDD VSS VSS _4000_/A _4121_/B _4121_/C _4000_/D _4001_/D gf180mcu_as_sc_mcu7t3v3__ao22_2
XFILLER_77_282 VDD VDD VSS VSS gf180mcu_as_sc_mcu7t3v3__fillcap_16
XFILLER_168_1103 VDD VDD VSS VSS gf180mcu_as_sc_mcu7t3v3__fillcap_8
XFILLER_4_1451 VDD VDD VSS VSS gf180mcu_as_sc_mcu7t3v3__fillcap_16
X_4902_ VDD VDD VSS VSS clkload3/A _4902_/D _4902_/Q gf180mcu_as_sc_mcu7t3v3__dfxtp_2
XFILLER_146_1434 VDD VDD VSS VSS gf180mcu_as_sc_mcu7t3v3__fill_1
XFILLER_166_508 VDD VDD VSS VSS gf180mcu_as_sc_mcu7t3v3__fillcap_16
X_4833_ VDD VDD VSS VSS _4867_/CLK _4833_/D _4833_/Q gf180mcu_as_sc_mcu7t3v3__dfxtp_2
XFILLER_140_1000 VDD VDD VSS VSS gf180mcu_as_sc_mcu7t3v3__fill_2
XFILLER_60_193 VDD VDD VSS VSS gf180mcu_as_sc_mcu7t3v3__fillcap_8
X_4764_ VDD VDD VSS VSS clkload1/A _4764_/D _4764_/Q gf180mcu_as_sc_mcu7t3v3__dfxtp_2
XTAP_TAPCELL_ROW_124_3_2535 VDD VSS gf180mcu_as_sc_mcu7t3v3__tap_2
XFILLER_140_1033 VDD VDD VSS VSS gf180mcu_as_sc_mcu7t3v3__fillcap_16
XFILLER_179_1210 VDD VDD VSS VSS gf180mcu_as_sc_mcu7t3v3__fillcap_4
X_3715_ VDD VDD VSS VSS _4858_/D _3715_/C _3731_/B _4091_/A gf180mcu_as_sc_mcu7t3v3__aoi21_2
XFILLER_134_405 VDD VDD VSS VSS gf180mcu_as_sc_mcu7t3v3__fill_2
XFILLER_135_906 VDD VDD VSS VSS gf180mcu_as_sc_mcu7t3v3__fillcap_4
XFILLER_140_1055 VDD VDD VSS VSS gf180mcu_as_sc_mcu7t3v3__fill_1
XFILLER_147_766 VDD VDD VSS VSS gf180mcu_as_sc_mcu7t3v3__fillcap_4
X_4695_ VDD VDD VSS VSS _4707_/S _5252_/Q _4695_/A _5252_/D gf180mcu_as_sc_mcu7t3v3__mux2_2
XFILLER_106_107 VDD VDD VSS VSS gf180mcu_as_sc_mcu7t3v3__fillcap_8
XFILLER_147_799 VDD VDD VSS VSS gf180mcu_as_sc_mcu7t3v3__fill_1
X_3646_ VDD VDD VSS VSS _3691_/D _3794_/S _3646_/B _3646_/C _3647_/C gf180mcu_as_sc_mcu7t3v3__ao31_2
XTAP_TAPCELL_ROW_62_1_885 VDD VSS gf180mcu_as_sc_mcu7t3v3__tap_2
X_3577_ VDD VDD VSS VSS _3578_/C _3938_/A _3791_/B _3577_/C gf180mcu_as_sc_mcu7t3v3__ao21_2
XFILLER_161_279 VDD VDD VSS VSS gf180mcu_as_sc_mcu7t3v3__fill_1
X_2528_ VDD VDD VSS VSS _4657_/B _5268_/Q _4643_/B gf180mcu_as_sc_mcu7t3v3__or2_2
X_5247_ VDD VDD VSS VSS clkload7/A _5247_/D _5247_/Q gf180mcu_as_sc_mcu7t3v3__dfxtp_2
Xinput308 VDD VDD VSS VSS west_in[32] _3520_/A gf180mcu_as_sc_mcu7t3v3__buff_2
X_2459_ VDD VDD VSS VSS _4952_/D _4353_/A _3869_/A _2474_/A gf180mcu_as_sc_mcu7t3v3__nand3_2
XFILLER_68_282 VDD VDD VSS VSS gf180mcu_as_sc_mcu7t3v3__fillcap_16
X_5178_ VDD VDD VSS VSS _5183_/CLK _5178_/D _5178_/Q gf180mcu_as_sc_mcu7t3v3__dfxtp_2
X_4129_ VDD VDD VSS VSS _4129_/A _4129_/B _4129_/C _4939_/Q _4130_/D gf180mcu_as_sc_mcu7t3v3__ao22_2
XFILLER_45_36 VDD VDD VSS VSS gf180mcu_as_sc_mcu7t3v3__fill_2
XFILLER_164_1501 VDD VDD VSS VSS gf180mcu_as_sc_mcu7t3v3__fillcap_4
XFILLER_43_138 VDD VDD VSS VSS gf180mcu_as_sc_mcu7t3v3__fill_2
XFILLER_77_1553 VDD VDD VSS VSS gf180mcu_as_sc_mcu7t3v3__fillcap_16
XPHY_EDGE_ROW_162_Right_296 VDD VSS gf180mcu_as_sc_mcu7t3v3__tap_2
XFILLER_164_1523 VDD VDD VSS VSS gf180mcu_as_sc_mcu7t3v3__fillcap_16
XFILLER_101_53 VDD VDD VSS VSS gf180mcu_as_sc_mcu7t3v3__fillcap_4
XFILLER_157_508 VDD VDD VSS VSS gf180mcu_as_sc_mcu7t3v3__fillcap_16
XFILLER_164_1567 VDD VDD VSS VSS gf180mcu_as_sc_mcu7t3v3__fill_2
XFILLER_169_346 VDD VDD VSS VSS gf180mcu_as_sc_mcu7t3v3__fillcap_4
XFILLER_51_160 VDD VDD VSS VSS gf180mcu_as_sc_mcu7t3v3__fill_1
XFILLER_169_368 VDD VDD VSS VSS gf180mcu_as_sc_mcu7t3v3__fillcap_16
XFILLER_165_541 VDD VDD VSS VSS gf180mcu_as_sc_mcu7t3v3__fillcap_8
XTAP_TAPCELL_ROW_137_1265 VDD VSS gf180mcu_as_sc_mcu7t3v3__tap_2
XFILLER_117_2 VDD VDD VSS VSS gf180mcu_as_sc_mcu7t3v3__fillcap_16
XFILLER_137_298 VDD VDD VSS VSS gf180mcu_as_sc_mcu7t3v3__fillcap_16
XTAP_TAPCELL_ROW_137_1276 VDD VSS gf180mcu_as_sc_mcu7t3v3__tap_2
XFILLER_10_1467 VDD VDD VSS VSS gf180mcu_as_sc_mcu7t3v3__fillcap_16
XFILLER_141_909 VDD VDD VSS VSS gf180mcu_as_sc_mcu7t3v3__fill_1
XFILLER_180_555 VDD VDD VSS VSS gf180mcu_as_sc_mcu7t3v3__fill_1
XFILLER_3_212 VDD VDD VSS VSS gf180mcu_as_sc_mcu7t3v3__fill_2
XFILLER_84_1502 VDD VDD VSS VSS gf180mcu_as_sc_mcu7t3v3__fillcap_16
XFILLER_84_1568 VDD VDD VSS VSS gf180mcu_as_sc_mcu7t3v3__fill_1
XFILLER_126_50 VDD VDD VSS VSS gf180mcu_as_sc_mcu7t3v3__fill_2
XFILLER_156_1084 VDD VDD VSS VSS gf180mcu_as_sc_mcu7t3v3__fill_1
XFILLER_160_290 VDD VDD VSS VSS gf180mcu_as_sc_mcu7t3v3__fillcap_16
XFILLER_86_65 VDD VDD VSS VSS gf180mcu_as_sc_mcu7t3v3__fill_2
XTAP_TAPCELL_ROW_167_1940 VDD VSS gf180mcu_as_sc_mcu7t3v3__tap_2
XFILLER_59_282 VDD VDD VSS VSS gf180mcu_as_sc_mcu7t3v3__fillcap_16
XTAP_TAPCELL_ROW_163_1848 VDD VSS gf180mcu_as_sc_mcu7t3v3__tap_2
XTAP_TAPCELL_ROW_163_1837 VDD VSS gf180mcu_as_sc_mcu7t3v3__tap_2
XTAP_TAPCELL_ROW_130_3_2545 VDD VSS gf180mcu_as_sc_mcu7t3v3__tap_2
XFILLER_74_296 VDD VDD VSS VSS gf180mcu_as_sc_mcu7t3v3__fillcap_4
XFILLER_27_190 VDD VDD VSS VSS gf180mcu_as_sc_mcu7t3v3__fillcap_16
XFILLER_176_839 VDD VDD VSS VSS gf180mcu_as_sc_mcu7t3v3__fill_2
XFILLER_106_1451 VDD VDD VSS VSS gf180mcu_as_sc_mcu7t3v3__fillcap_16
X_3500_ VDD VDD VSS VSS _3500_/B _4161_/A _3502_/C gf180mcu_as_sc_mcu7t3v3__and2_2
XFILLER_141_1397 VDD VDD VSS VSS gf180mcu_as_sc_mcu7t3v3__fill_2
XFILLER_156_574 VDD VDD VSS VSS gf180mcu_as_sc_mcu7t3v3__fill_2
XFILLER_184_894 VDD VDD VSS VSS gf180mcu_as_sc_mcu7t3v3__fill_1
X_4480_ VDD VDD VSS VSS _4480_/B _4591_/A _4486_/C gf180mcu_as_sc_mcu7t3v3__and2_2
XTAP_TAPCELL_ROW_50_1_834 VDD VSS gf180mcu_as_sc_mcu7t3v3__tap_2
XFILLER_144_769 VDD VDD VSS VSS gf180mcu_as_sc_mcu7t3v3__fillcap_16
X_3431_ VDD VDD VSS VSS _3462_/A _3431_/B _3431_/C _3432_/C gf180mcu_as_sc_mcu7t3v3__nor3_2
XFILLER_171_599 VDD VDD VSS VSS gf180mcu_as_sc_mcu7t3v3__fill_1
XFILLER_97_300 VDD VDD VSS VSS gf180mcu_as_sc_mcu7t3v3__fill_1
X_3362_ VDD VDD VSS VSS _4925_/Q _3465_/B _3465_/C _4014_/A _3363_/A gf180mcu_as_sc_mcu7t3v3__ao22_2
XFILLER_135_1124 VDD VDD VSS VSS gf180mcu_as_sc_mcu7t3v3__fill_1
XFILLER_140_942 VDD VDD VSS VSS gf180mcu_as_sc_mcu7t3v3__fill_2
XFILLER_32_2 VDD VDD VSS VSS gf180mcu_as_sc_mcu7t3v3__fillcap_16
X_5101_ VDD VDD VSS VSS clkload6/A _5101_/D _5101_/Q gf180mcu_as_sc_mcu7t3v3__dfxtp_2
XFILLER_6_1502 VDD VDD VSS VSS gf180mcu_as_sc_mcu7t3v3__fillcap_16
X_3293_ VDD VDD VSS VSS _3938_/A _3502_/B _3504_/B _3939_/A _3294_/D gf180mcu_as_sc_mcu7t3v3__ao22_2
XFILLER_152_1482 VDD VDD VSS VSS gf180mcu_as_sc_mcu7t3v3__fill_2
X_5032_ VDD VDD VSS VSS _5185_/CLK _5032_/D _5032_/Q gf180mcu_as_sc_mcu7t3v3__dfxtp_2
XFILLER_6_1568 VDD VDD VSS VSS gf180mcu_as_sc_mcu7t3v3__fill_1
XFILLER_113_1499 VDD VDD VSS VSS gf180mcu_as_sc_mcu7t3v3__fillcap_16
XFILLER_148_1507 VDD VDD VSS VSS gf180mcu_as_sc_mcu7t3v3__fill_2
XFILLER_65_252 VDD VDD VSS VSS gf180mcu_as_sc_mcu7t3v3__fillcap_8
XFILLER_179_666 VDD VDD VSS VSS gf180mcu_as_sc_mcu7t3v3__fillcap_16
XFILLER_21_300 VDD VDD VSS VSS gf180mcu_as_sc_mcu7t3v3__fill_1
XFILLER_146_1297 VDD VDD VSS VSS gf180mcu_as_sc_mcu7t3v3__fillcap_16
X_4816_ VDD VDD VSS VSS _4928_/CLK _4816_/D _4816_/Q gf180mcu_as_sc_mcu7t3v3__dfxtp_2
XTAP_TAPCELL_ROW_114_1_1092 VDD VSS gf180mcu_as_sc_mcu7t3v3__tap_2
XFILLER_166_349 VDD VDD VSS VSS gf180mcu_as_sc_mcu7t3v3__fillcap_16
XFILLER_72_1483 VDD VDD VSS VSS gf180mcu_as_sc_mcu7t3v3__fill_1
XPHY_EDGE_ROW_46_1_Right_45 VDD VSS gf180mcu_as_sc_mcu7t3v3__tap_2
XFILLER_33_1467 VDD VDD VSS VSS gf180mcu_as_sc_mcu7t3v3__fillcap_16
X_4747_ VDD VDD VSS VSS _5276_/Q _4750_/B _4747_/C _4748_/A _5276_/D gf180mcu_as_sc_mcu7t3v3__ao22_2
XPHY_EDGE_ROW_17_1_Left_469 VDD VSS gf180mcu_as_sc_mcu7t3v3__tap_2
X_4678_ VDD VDD VSS VSS _5246_/D _5100_/Q _4680_/B _4678_/C gf180mcu_as_sc_mcu7t3v3__ao21_2
XTAP_TAPCELL_ROW_36_1_779 VDD VSS gf180mcu_as_sc_mcu7t3v3__tap_2
X_3629_ VDD VDD VSS VSS _3998_/A _3744_/B _3629_/C _3746_/B _3630_/C gf180mcu_as_sc_mcu7t3v3__ao211_2
XFILLER_162_577 VDD VDD VSS VSS gf180mcu_as_sc_mcu7t3v3__fill_1
XFILLER_153_1202 VDD VDD VSS VSS gf180mcu_as_sc_mcu7t3v3__fillcap_8
XFILLER_157_1382 VDD VDD VSS VSS gf180mcu_as_sc_mcu7t3v3__fillcap_16
XFILLER_0_248 VDD VDD VSS VSS gf180mcu_as_sc_mcu7t3v3__fillcap_4
XFILLER_102_154 VDD VDD VSS VSS gf180mcu_as_sc_mcu7t3v3__fill_2
Xinput105 VDD VDD VSS VSS ne_in[3] _3956_/A gf180mcu_as_sc_mcu7t3v3__buff_2
Xinput116 VDD VDD VSS VSS north_in[13] _4039_/A gf180mcu_as_sc_mcu7t3v3__buff_2
Xinput127 VDD VDD VSS VSS north_in[23] _4120_/A gf180mcu_as_sc_mcu7t3v3__buff_2
XFILLER_44_1552 VDD VDD VSS VSS gf180mcu_as_sc_mcu7t3v3__fill_2
Xinput138 VDD VDD VSS VSS north_in[33] _3534_/A gf180mcu_as_sc_mcu7t3v3__buff_2
Xinput149 VDD VDD VSS VSS nw_in[12] _4032_/A gf180mcu_as_sc_mcu7t3v3__buff_2
XPHY_EDGE_ROW_79_1_Left_531 VDD VSS gf180mcu_as_sc_mcu7t3v3__tap_2
XTAP_TAPCELL_ROW_184_2295 VDD VSS gf180mcu_as_sc_mcu7t3v3__tap_2
XPHY_EDGE_ROW_131_1_Left_583 VDD VSS gf180mcu_as_sc_mcu7t3v3__tap_2
XFILLER_112_52 VDD VDD VSS VSS gf180mcu_as_sc_mcu7t3v3__fill_1
XFILLER_71_244 VDD VDD VSS VSS gf180mcu_as_sc_mcu7t3v3__fillcap_8
XFILLER_72_34 VDD VDD VSS VSS gf180mcu_as_sc_mcu7t3v3__fill_1
XFILLER_129_1451 VDD VDD VSS VSS gf180mcu_as_sc_mcu7t3v3__fillcap_16
XFILLER_164_1364 VDD VDD VSS VSS gf180mcu_as_sc_mcu7t3v3__fill_1
XFILLER_24_171 VDD VDD VSS VSS gf180mcu_as_sc_mcu7t3v3__fillcap_4
XFILLER_157_305 VDD VDD VSS VSS gf180mcu_as_sc_mcu7t3v3__fill_1
XFILLER_24_193 VDD VDD VSS VSS gf180mcu_as_sc_mcu7t3v3__fillcap_16
XFILLER_90_1550 VDD VDD VSS VSS gf180mcu_as_sc_mcu7t3v3__fillcap_4
Xclkbuf_leaf_5_clk_regs VDD VDD VSS VSS clkbuf_3_1_0_clk_regs/Y clkload5/A gf180mcu_as_sc_mcu7t3v3__clkbuff_12
XTAP_TAPCELL_ROW_139_1316 VDD VSS gf180mcu_as_sc_mcu7t3v3__tap_2
XTAP_TAPCELL_ROW_139_1305 VDD VSS gf180mcu_as_sc_mcu7t3v3__tap_2
XFILLER_184_135 VDD VDD VSS VSS gf180mcu_as_sc_mcu7t3v3__fill_1
XFILLER_12_1518 VDD VDD VSS VSS gf180mcu_as_sc_mcu7t3v3__fillcap_16
XTAP_TAPCELL_ROW_90_1_994 VDD VSS gf180mcu_as_sc_mcu7t3v3__tap_2
XTAP_TAPCELL_ROW_156_1696 VDD VSS gf180mcu_as_sc_mcu7t3v3__tap_2
XTAP_TAPCELL_ROW_156_1685 VDD VSS gf180mcu_as_sc_mcu7t3v3__tap_2
XFILLER_125_279 VDD VDD VSS VSS gf180mcu_as_sc_mcu7t3v3__fill_1
XFILLER_140_205 VDD VDD VSS VSS gf180mcu_as_sc_mcu7t3v3__fill_1
XFILLER_158_1157 VDD VDD VSS VSS gf180mcu_as_sc_mcu7t3v3__fillcap_4
XFILLER_79_300 VDD VDD VSS VSS gf180mcu_as_sc_mcu7t3v3__fill_1
XFILLER_98_119 VDD VDD VSS VSS gf180mcu_as_sc_mcu7t3v3__fill_2
XPHY_EDGE_ROW_92_1_Right_91 VDD VSS gf180mcu_as_sc_mcu7t3v3__tap_2
XTAP_TAPCELL_ROW_53_1_849 VDD VSS gf180mcu_as_sc_mcu7t3v3__tap_2
XFILLER_165_1106 VDD VDD VSS VSS gf180mcu_as_sc_mcu7t3v3__fill_2
XFILLER_182_1420 VDD VDD VSS VSS gf180mcu_as_sc_mcu7t3v3__fillcap_8
XFILLER_62_255 VDD VDD VSS VSS gf180mcu_as_sc_mcu7t3v3__fillcap_4
X_3980_ VDD VDD VSS VSS _4983_/Q _4092_/B _4234_/B _4092_/D _4983_/D gf180mcu_as_sc_mcu7t3v3__ao22_2
XFILLER_108_1502 VDD VDD VSS VSS gf180mcu_as_sc_mcu7t3v3__fillcap_16
XFILLER_95_1483 VDD VDD VSS VSS gf180mcu_as_sc_mcu7t3v3__fillcap_16
X_2931_ VDD VDD VSS VSS _2931_/Y _3223_/C _3233_/B gf180mcu_as_sc_mcu7t3v3__nor2_2
XFILLER_56_1467 VDD VDD VSS VSS gf180mcu_as_sc_mcu7t3v3__fillcap_16
Xclkbuf_0_clk VDD VDD VSS VSS clkbuf_0_clk/A clkbuf_0_clk/Y gf180mcu_as_sc_mcu7t3v3__clkbuff_12
XFILLER_148_338 VDD VDD VSS VSS gf180mcu_as_sc_mcu7t3v3__fillcap_16
X_4601_ VDD VDD VSS VSS _5195_/Q _4612_/B _4612_/C _5196_/Q _5195_/D gf180mcu_as_sc_mcu7t3v3__ao22_2
X_2862_ VDD VDD VSS VSS _4763_/Q _4742_/A _2871_/B _4763_/D gf180mcu_as_sc_mcu7t3v3__nor3_2
XFILLER_157_850 VDD VDD VSS VSS gf180mcu_as_sc_mcu7t3v3__fill_1
X_2793_ VDD VDD VSS VSS _2793_/B _2876_/B _2796_/C gf180mcu_as_sc_mcu7t3v3__and2_2
XFILLER_157_894 VDD VDD VSS VSS gf180mcu_as_sc_mcu7t3v3__fill_1
X_4532_ VDD VDD VSS VSS _5183_/Q _4566_/B _4566_/C _5101_/Q _4533_/B gf180mcu_as_sc_mcu7t3v3__ao22_2
XFILLER_116_224 VDD VDD VSS VSS gf180mcu_as_sc_mcu7t3v3__fill_2
XFILLER_171_330 VDD VDD VSS VSS gf180mcu_as_sc_mcu7t3v3__fillcap_16
XFILLER_172_853 VDD VDD VSS VSS gf180mcu_as_sc_mcu7t3v3__fillcap_8
X_4463_ VDD VDD VSS VSS _4568_/A _5016_/Q _5045_/Q _4464_/B gf180mcu_as_sc_mcu7t3v3__mux2_2
XFILLER_171_352 VDD VDD VSS VSS gf180mcu_as_sc_mcu7t3v3__fillcap_16
XFILLER_89_119 VDD VDD VSS VSS gf180mcu_as_sc_mcu7t3v3__fillcap_8
X_3414_ VDD VDD VSS VSS _4064_/A _3453_/B _3453_/C _4066_/A _3415_/C gf180mcu_as_sc_mcu7t3v3__ao22_2
Xfanout806 VDD VDD VSS VSS fanout808/Y _3722_/D gf180mcu_as_sc_mcu7t3v3__buff_2
X_4394_ VDD VDD VSS VSS _4394_/D _4510_/A _4394_/B _4394_/C _4395_/B gf180mcu_as_sc_mcu7t3v3__ao31_2
XTAP_TAPCELL_ROW_32_1_763 VDD VSS gf180mcu_as_sc_mcu7t3v3__tap_2
XFILLER_131_249 VDD VDD VSS VSS gf180mcu_as_sc_mcu7t3v3__fill_2
X_3345_ VDD VDD VSS VSS _4923_/Q _3440_/B _3440_/C _3999_/A _3347_/C gf180mcu_as_sc_mcu7t3v3__ao22_2
XFILLER_133_18 VDD VDD VSS VSS gf180mcu_as_sc_mcu7t3v3__fillcap_16
Xhold1004 VDD VDD VSS VSS hold1041/Y hold1004/Y gf180mcu_as_sc_mcu7t3v3__buff_2
Xhold1015 VDD VDD VSS VSS hold1046/Y _4971_/D gf180mcu_as_sc_mcu7t3v3__buff_2
X_3276_ VDD VDD VSS VSS _3814_/B _3280_/B _3553_/A gf180mcu_as_sc_mcu7t3v3__nand2_2
XTAP_TAPCELL_ROW_24_3_2385 VDD VSS gf180mcu_as_sc_mcu7t3v3__tap_2
XFILLER_152_1290 VDD VDD VSS VSS gf180mcu_as_sc_mcu7t3v3__fillcap_4
X_5015_ VDD VDD VSS VSS _5088_/CLK _5015_/D _5015_/Q gf180mcu_as_sc_mcu7t3v3__dfxtp_2
Xhold1026 VDD VDD VSS VSS _2589_/Y _2590_/B gf180mcu_as_sc_mcu7t3v3__buff_2
Xhold1037 VDD VDD VSS VSS _2581_/Y hold1037/Y gf180mcu_as_sc_mcu7t3v3__buff_2
Xhold1048 VDD VDD VSS VSS _4969_/Q hold1048/Y gf180mcu_as_sc_mcu7t3v3__buff_2
XFILLER_38_241 VDD VDD VSS VSS gf180mcu_as_sc_mcu7t3v3__fillcap_4
XFILLER_38_263 VDD VDD VSS VSS gf180mcu_as_sc_mcu7t3v3__fillcap_16
XTAP_TAPCELL_ROW_112_3_2517 VDD VSS gf180mcu_as_sc_mcu7t3v3__tap_2
XFILLER_148_1337 VDD VDD VSS VSS gf180mcu_as_sc_mcu7t3v3__fillcap_4
XFILLER_53_233 VDD VDD VSS VSS gf180mcu_as_sc_mcu7t3v3__fillcap_16
XFILLER_74_1534 VDD VDD VSS VSS gf180mcu_as_sc_mcu7t3v3__fillcap_16
XFILLER_139_305 VDD VDD VSS VSS gf180mcu_as_sc_mcu7t3v3__fill_1
XFILLER_161_1504 VDD VDD VSS VSS gf180mcu_as_sc_mcu7t3v3__fillcap_16
XFILLER_42_26 VDD VDD VSS VSS gf180mcu_as_sc_mcu7t3v3__fillcap_8
XFILLER_74_1556 VDD VDD VSS VSS gf180mcu_as_sc_mcu7t3v3__fillcap_8
XFILLER_42_37 VDD VDD VSS VSS gf180mcu_as_sc_mcu7t3v3__fill_1
XFILLER_154_308 VDD VDD VSS VSS gf180mcu_as_sc_mcu7t3v3__fill_1
XFILLER_158_37 VDD VDD VSS VSS gf180mcu_as_sc_mcu7t3v3__fill_1
XFILLER_21_174 VDD VDD VSS VSS gf180mcu_as_sc_mcu7t3v3__fillcap_16
XTAP_TAPCELL_ROW_78_3_2467 VDD VSS gf180mcu_as_sc_mcu7t3v3__tap_2
XTAP_TAPCELL_ROW_134_1213 VDD VSS gf180mcu_as_sc_mcu7t3v3__tap_2
XTAP_TAPCELL_ROW_134_1202 VDD VSS gf180mcu_as_sc_mcu7t3v3__tap_2
XFILLER_163_864 VDD VDD VSS VSS gf180mcu_as_sc_mcu7t3v3__fillcap_16
XFILLER_181_138 VDD VDD VSS VSS gf180mcu_as_sc_mcu7t3v3__fill_2
XFILLER_107_268 VDD VDD VSS VSS gf180mcu_as_sc_mcu7t3v3__fill_2
XFILLER_150_503 VDD VDD VSS VSS gf180mcu_as_sc_mcu7t3v3__fillcap_16
XFILLER_122_227 VDD VDD VSS VSS gf180mcu_as_sc_mcu7t3v3__fill_2
XFILLER_174_69 VDD VDD VSS VSS gf180mcu_as_sc_mcu7t3v3__fillcap_16
XTAP_TAPCELL_ROW_151_1582 VDD VSS gf180mcu_as_sc_mcu7t3v3__tap_2
XTAP_TAPCELL_ROW_151_1571 VDD VSS gf180mcu_as_sc_mcu7t3v3__tap_2
XFILLER_88_152 VDD VDD VSS VSS gf180mcu_as_sc_mcu7t3v3__fillcap_8
XFILLER_130_293 VDD VDD VSS VSS gf180mcu_as_sc_mcu7t3v3__fillcap_8
XFILLER_153_1098 VDD VDD VSS VSS gf180mcu_as_sc_mcu7t3v3__fillcap_16
XFILLER_67_78 VDD VDD VSS VSS gf180mcu_as_sc_mcu7t3v3__fillcap_8
XFILLER_88_196 VDD VDD VSS VSS gf180mcu_as_sc_mcu7t3v3__fillcap_4
XTAP_TAPCELL_ROW_116_1_1100 VDD VSS gf180mcu_as_sc_mcu7t3v3__tap_2
XFILLER_79_1467 VDD VDD VSS VSS gf180mcu_as_sc_mcu7t3v3__fillcap_16
XFILLER_44_244 VDD VDD VSS VSS gf180mcu_as_sc_mcu7t3v3__fill_1
XPHY_EDGE_ROW_124_3_Left_258 VDD VSS gf180mcu_as_sc_mcu7t3v3__tap_2
XFILLER_44_299 VDD VDD VSS VSS gf180mcu_as_sc_mcu7t3v3__fill_2
XFILLER_158_636 VDD VDD VSS VSS gf180mcu_as_sc_mcu7t3v3__fill_2
XFILLER_8_101 VDD VDD VSS VSS gf180mcu_as_sc_mcu7t3v3__fillcap_4
XTAP_TAPCELL_ROW_158_1736 VDD VSS gf180mcu_as_sc_mcu7t3v3__tap_2
XTAP_TAPCELL_ROW_158_1725 VDD VSS gf180mcu_as_sc_mcu7t3v3__tap_2
XFILLER_16_1451 VDD VDD VSS VSS gf180mcu_as_sc_mcu7t3v3__fillcap_16
XFILLER_8_123 VDD VDD VSS VSS gf180mcu_as_sc_mcu7t3v3__fillcap_16
XPHY_EDGE_ROW_149_Left_601 VDD VSS gf180mcu_as_sc_mcu7t3v3__tap_2
XTAP_TAPCELL_ROW_30_3_2395 VDD VSS gf180mcu_as_sc_mcu7t3v3__tap_2
XFILLER_138_382 VDD VDD VSS VSS gf180mcu_as_sc_mcu7t3v3__fill_2
XFILLER_165_190 VDD VDD VSS VSS gf180mcu_as_sc_mcu7t3v3__fillcap_16
XFILLER_177_1511 VDD VDD VSS VSS gf180mcu_as_sc_mcu7t3v3__fillcap_16
XFILLER_153_352 VDD VDD VSS VSS gf180mcu_as_sc_mcu7t3v3__fillcap_16
Xoutput409 VDD VDD VSS VSS _4829_/Q south_out[24] gf180mcu_as_sc_mcu7t3v3__buff_2
XFILLER_138_1539 VDD VDD VSS VSS gf180mcu_as_sc_mcu7t3v3__fill_2
XFILLER_153_374 VDD VDD VSS VSS gf180mcu_as_sc_mcu7t3v3__fill_1
XFILLER_180_193 VDD VDD VSS VSS gf180mcu_as_sc_mcu7t3v3__fillcap_16
XFILLER_136_1274 VDD VDD VSS VSS gf180mcu_as_sc_mcu7t3v3__fill_2
XFILLER_79_163 VDD VDD VSS VSS gf180mcu_as_sc_mcu7t3v3__fill_1
XPHY_EDGE_ROW_158_Left_610 VDD VSS gf180mcu_as_sc_mcu7t3v3__tap_2
X_3130_ VDD VDD VSS VSS _4105_/A _3130_/B _3130_/C _3130_/D _3131_/C gf180mcu_as_sc_mcu7t3v3__ao22_2
XFILLER_114_1550 VDD VDD VSS VSS gf180mcu_as_sc_mcu7t3v3__fillcap_4
XFILLER_121_282 VDD VDD VSS VSS gf180mcu_as_sc_mcu7t3v3__fillcap_16
XFILLER_79_196 VDD VDD VSS VSS gf180mcu_as_sc_mcu7t3v3__fill_2
XFILLER_94_155 VDD VDD VSS VSS gf180mcu_as_sc_mcu7t3v3__fillcap_8
X_3061_ VDD VDD VSS VSS _3120_/A _3061_/B _3061_/C _3120_/D _3063_/C gf180mcu_as_sc_mcu7t3v3__ao211_2
XFILLER_23_1499 VDD VDD VSS VSS gf180mcu_as_sc_mcu7t3v3__fillcap_16
XFILLER_35_244 VDD VDD VSS VSS gf180mcu_as_sc_mcu7t3v3__fillcap_16
XFILLER_58_1518 VDD VDD VSS VSS gf180mcu_as_sc_mcu7t3v3__fillcap_16
XFILLER_184_1548 VDD VDD VSS VSS gf180mcu_as_sc_mcu7t3v3__fillcap_8
XFILLER_50_247 VDD VDD VSS VSS gf180mcu_as_sc_mcu7t3v3__fillcap_4
X_3963_ VDD VDD VSS VSS _4232_/B _3963_/B _4141_/D gf180mcu_as_sc_mcu7t3v3__nor2_2
X_3894_ VDD VDD VSS VSS _3908_/B _5184_/Q VSS gf180mcu_as_sc_mcu7t3v3__and2_2
X_2914_ VDD VDD VSS VSS _3787_/A _3255_/B _3544_/C _3223_/C gf180mcu_as_sc_mcu7t3v3__nand3_2
XFILLER_12_18 VDD VDD VSS VSS gf180mcu_as_sc_mcu7t3v3__fillcap_16
XFILLER_143_1256 VDD VDD VSS VSS gf180mcu_as_sc_mcu7t3v3__fillcap_4
XFILLER_177_967 VDD VDD VSS VSS gf180mcu_as_sc_mcu7t3v3__fill_2
X_2845_ VDD VDD VSS VSS _2845_/A _2845_/B _2856_/A _2845_/D _2854_/B gf180mcu_as_sc_mcu7t3v3__ao22_2
XFILLER_121_1521 VDD VDD VSS VSS gf180mcu_as_sc_mcu7t3v3__fillcap_16
XFILLER_128_18 VDD VDD VSS VSS gf180mcu_as_sc_mcu7t3v3__fillcap_16
XFILLER_178_1308 VDD VDD VSS VSS gf180mcu_as_sc_mcu7t3v3__fillcap_16
XFILLER_145_842 VDD VDD VSS VSS gf180mcu_as_sc_mcu7t3v3__fillcap_16
X_4515_ VDD VDD VSS VSS _4515_/B _4576_/A _4522_/C gf180mcu_as_sc_mcu7t3v3__and2_2
X_2776_ VDD VDD VSS VSS _2776_/B _2776_/A _2783_/A gf180mcu_as_sc_mcu7t3v3__and2_2
XFILLER_160_801 VDD VDD VSS VSS gf180mcu_as_sc_mcu7t3v3__fillcap_4
XFILLER_172_683 VDD VDD VSS VSS gf180mcu_as_sc_mcu7t3v3__fillcap_8
X_4446_ VDD VDD VSS VSS _4449_/C _4985_/Q _4447_/S gf180mcu_as_sc_mcu7t3v3__nand2b_2
XFILLER_137_1049 VDD VDD VSS VSS gf180mcu_as_sc_mcu7t3v3__fill_1
Xfanout603 VDD VDD VSS VSS _3749_/B _3779_/B gf180mcu_as_sc_mcu7t3v3__buff_2
Xfanout614 VDD VDD VSS VSS fanout617/Y _3474_/B gf180mcu_as_sc_mcu7t3v3__buff_2
X_4377_ VDD VDD VSS VSS _4590_/B _4377_/A _4378_/C gf180mcu_as_sc_mcu7t3v3__and2_2
XFILLER_119_1483 VDD VDD VSS VSS gf180mcu_as_sc_mcu7t3v3__fillcap_16
XFILLER_150_1205 VDD VDD VSS VSS gf180mcu_as_sc_mcu7t3v3__fillcap_16
Xfanout625 VDD VDD VSS VSS _2947_/Y _3130_/B gf180mcu_as_sc_mcu7t3v3__buff_2
Xfanout636 VDD VDD VSS VSS _2541_/Y _4305_/S gf180mcu_as_sc_mcu7t3v3__buff_2
Xfanout647 VDD VDD VSS VSS fanout651/Y _4159_/B gf180mcu_as_sc_mcu7t3v3__buff_2
Xfanout658 VDD VDD VSS VSS fanout660/Y _3449_/B gf180mcu_as_sc_mcu7t3v3__buff_2
X_3328_ VDD VDD VSS VSS _4921_/Q _3440_/B _3440_/C _3982_/A _3329_/C gf180mcu_as_sc_mcu7t3v3__ao22_2
XTAP_TAPCELL_ROW_14_1_692 VDD VSS gf180mcu_as_sc_mcu7t3v3__tap_2
XFILLER_150_1227 VDD VDD VSS VSS gf180mcu_as_sc_mcu7t3v3__fillcap_4
Xfanout669 VDD VDD VSS VSS _4129_/C _4120_/C gf180mcu_as_sc_mcu7t3v3__buff_2
XTAP_TAPCELL_ROW_81_1_958 VDD VSS gf180mcu_as_sc_mcu7t3v3__tap_2
XTAP_TAPCELL_ROW_181_2232 VDD VSS gf180mcu_as_sc_mcu7t3v3__tap_2
XFILLER_37_26 VDD VDD VSS VSS gf180mcu_as_sc_mcu7t3v3__fillcap_16
X_3259_ VDD VDD VSS VSS _3811_/A _3548_/A _3261_/B gf180mcu_as_sc_mcu7t3v3__and2_2
XTAP_TAPCELL_ROW_181_2243 VDD VSS gf180mcu_as_sc_mcu7t3v3__tap_2
XTAP_TAPCELL_ROW_0_1_2347 VDD VSS gf180mcu_as_sc_mcu7t3v3__tap_2
XFILLER_148_1167 VDD VDD VSS VSS gf180mcu_as_sc_mcu7t3v3__fill_1
XFILLER_148_1178 VDD VDD VSS VSS gf180mcu_as_sc_mcu7t3v3__fill_2
XFILLER_26_299 VDD VDD VSS VSS gf180mcu_as_sc_mcu7t3v3__fill_2
XFILLER_39_1451 VDD VDD VSS VSS gf180mcu_as_sc_mcu7t3v3__fillcap_16
XFILLER_53_69 VDD VDD VSS VSS gf180mcu_as_sc_mcu7t3v3__fill_1
XFILLER_161_1323 VDD VDD VSS VSS gf180mcu_as_sc_mcu7t3v3__fill_1
XFILLER_167_400 VDD VDD VSS VSS gf180mcu_as_sc_mcu7t3v3__fillcap_16
XFILLER_167_422 VDD VDD VSS VSS gf180mcu_as_sc_mcu7t3v3__fillcap_16
XFILLER_168_934 VDD VDD VSS VSS gf180mcu_as_sc_mcu7t3v3__fillcap_8
XFILLER_179_260 VDD VDD VSS VSS gf180mcu_as_sc_mcu7t3v3__fillcap_16
XFILLER_179_282 VDD VDD VSS VSS gf180mcu_as_sc_mcu7t3v3__fillcap_16
XTAP_TAPCELL_ROW_179_2194 VDD VSS gf180mcu_as_sc_mcu7t3v3__tap_2
XFILLER_155_628 VDD VDD VSS VSS gf180mcu_as_sc_mcu7t3v3__fill_2
XFILLER_182_403 VDD VDD VSS VSS gf180mcu_as_sc_mcu7t3v3__fillcap_16
XFILLER_5_104 VDD VDD VSS VSS gf180mcu_as_sc_mcu7t3v3__fillcap_16
Xclkbuf_3_5_0_clk_regs VDD VDD VSS VSS clkbuf_0_clk_regs/Y clkbuf_3_5_0_clk_regs/Y
+ gf180mcu_as_sc_mcu7t3v3__clkbuff_12
XTAP_TAPCELL_ROW_153_1633 VDD VSS gf180mcu_as_sc_mcu7t3v3__tap_2
XTAP_TAPCELL_ROW_153_1622 VDD VSS gf180mcu_as_sc_mcu7t3v3__tap_2
XFILLER_135_352 VDD VDD VSS VSS gf180mcu_as_sc_mcu7t3v3__fillcap_8
XFILLER_159_1241 VDD VDD VSS VSS gf180mcu_as_sc_mcu7t3v3__fill_1
XFILLER_118_73 VDD VDD VSS VSS gf180mcu_as_sc_mcu7t3v3__fill_1
XFILLER_162_171 VDD VDD VSS VSS gf180mcu_as_sc_mcu7t3v3__fillcap_4
XFILLER_151_878 VDD VDD VSS VSS gf180mcu_as_sc_mcu7t3v3__fillcap_16
XFILLER_155_1138 VDD VDD VSS VSS gf180mcu_as_sc_mcu7t3v3__fillcap_16
XFILLER_162_193 VDD VDD VSS VSS gf180mcu_as_sc_mcu7t3v3__fillcap_4
XFILLER_78_66 VDD VDD VSS VSS gf180mcu_as_sc_mcu7t3v3__fillcap_4
XTAP_TAPCELL_ROW_170_1991 VDD VSS gf180mcu_as_sc_mcu7t3v3__tap_2
XFILLER_150_399 VDD VDD VSS VSS gf180mcu_as_sc_mcu7t3v3__fillcap_16
XFILLER_76_144 VDD VDD VSS VSS gf180mcu_as_sc_mcu7t3v3__fill_1
XFILLER_76_177 VDD VDD VSS VSS gf180mcu_as_sc_mcu7t3v3__fill_2
XFILLER_76_199 VDD VDD VSS VSS gf180mcu_as_sc_mcu7t3v3__fillcap_8
XFILLER_17_244 VDD VDD VSS VSS gf180mcu_as_sc_mcu7t3v3__fillcap_16
XFILLER_91_158 VDD VDD VSS VSS gf180mcu_as_sc_mcu7t3v3__fillcap_8
XTAP_TAPCELL_ROW_23_1_727 VDD VSS gf180mcu_as_sc_mcu7t3v3__tap_2
XFILLER_159_912 VDD VDD VSS VSS gf180mcu_as_sc_mcu7t3v3__fillcap_16
XFILLER_166_1267 VDD VDD VSS VSS gf180mcu_as_sc_mcu7t3v3__fill_2
XFILLER_18_1502 VDD VDD VSS VSS gf180mcu_as_sc_mcu7t3v3__fillcap_16
XFILLER_32_225 VDD VDD VSS VSS gf180mcu_as_sc_mcu7t3v3__fillcap_16
XFILLER_32_247 VDD VDD VSS VSS gf180mcu_as_sc_mcu7t3v3__fillcap_16
XFILLER_18_1568 VDD VDD VSS VSS gf180mcu_as_sc_mcu7t3v3__fill_1
XFILLER_146_628 VDD VDD VSS VSS gf180mcu_as_sc_mcu7t3v3__fillcap_4
XFILLER_158_477 VDD VDD VSS VSS gf180mcu_as_sc_mcu7t3v3__fill_1
XFILLER_174_926 VDD VDD VSS VSS gf180mcu_as_sc_mcu7t3v3__fill_1
X_2630_ VDD VDD VSS VSS _2631_/D _5263_/Q _2695_/A _4643_/B gf180mcu_as_sc_mcu7t3v3__ao21_2
XFILLER_145_127 VDD VDD VSS VSS gf180mcu_as_sc_mcu7t3v3__fill_1
XFILLER_145_138 VDD VDD VSS VSS gf180mcu_as_sc_mcu7t3v3__fill_2
X_2561_ VDD VDD VSS VSS _2701_/A _4952_/D _2831_/B gf180mcu_as_sc_mcu7t3v3__nand2b_2
XFILLER_141_311 VDD VDD VSS VSS gf180mcu_as_sc_mcu7t3v3__fillcap_8
XFILLER_154_694 VDD VDD VSS VSS gf180mcu_as_sc_mcu7t3v3__fill_1
XFILLER_173_1205 VDD VDD VSS VSS gf180mcu_as_sc_mcu7t3v3__fillcap_8
X_5280_ VDD VDD VSS VSS clkload2/A _5280_/D _5280_/Q gf180mcu_as_sc_mcu7t3v3__dfxtp_2
X_4300_ VDD VDD VSS VSS _4305_/S _5130_/Q _5129_/Q _5129_/D gf180mcu_as_sc_mcu7t3v3__mux2_2
X_2492_ VDD VDD VSS VSS _4649_/A _5274_/Q _2794_/A gf180mcu_as_sc_mcu7t3v3__and2_2
XFILLER_173_1238 VDD VDD VSS VSS gf180mcu_as_sc_mcu7t3v3__fillcap_4
XFILLER_177_1396 VDD VDD VSS VSS gf180mcu_as_sc_mcu7t3v3__fillcap_4
XFILLER_99_247 VDD VDD VSS VSS gf180mcu_as_sc_mcu7t3v3__fillcap_4
X_4231_ VDD VDD VSS VSS _4250_/S _4231_/B _5067_/Q _5067_/D gf180mcu_as_sc_mcu7t3v3__mux2_2
XFILLER_4_85 VDD VDD VSS VSS gf180mcu_as_sc_mcu7t3v3__fillcap_16
X_4162_ VDD VDD VSS VSS _4162_/B _4162_/A _4163_/D gf180mcu_as_sc_mcu7t3v3__and2_2
XPHY_EDGE_ROW_55_1_Right_54 VDD VSS gf180mcu_as_sc_mcu7t3v3__tap_2
X_4093_ VDD VDD VSS VSS _4093_/A _4118_/B _4118_/C _4093_/D _4094_/D gf180mcu_as_sc_mcu7t3v3__ao22_2
X_3113_ VDD VDD VSS VSS _4086_/A _3125_/B _3113_/C _3113_/D _3114_/C gf180mcu_as_sc_mcu7t3v3__ao22_2
X_3044_ VDD VDD VSS VSS _4023_/A _3127_/B _3127_/C _4024_/D _3045_/C gf180mcu_as_sc_mcu7t3v3__ao22_2
XFILLER_184_1312 VDD VDD VSS VSS gf180mcu_as_sc_mcu7t3v3__fillcap_8
XPHY_EDGE_ROW_26_1_Left_478 VDD VSS gf180mcu_as_sc_mcu7t3v3__tap_2
XFILLER_145_1329 VDD VDD VSS VSS gf180mcu_as_sc_mcu7t3v3__fill_1
XPHY_EDGE_ROW_178_Right_312 VDD VSS gf180mcu_as_sc_mcu7t3v3__tap_2
X_4995_ VDD VDD VSS VSS _5084_/CLK _4995_/D _4995_/Q gf180mcu_as_sc_mcu7t3v3__dfxtp_2
XFILLER_149_422 VDD VDD VSS VSS gf180mcu_as_sc_mcu7t3v3__fillcap_4
XFILLER_177_731 VDD VDD VSS VSS gf180mcu_as_sc_mcu7t3v3__fillcap_4
XFILLER_71_1515 VDD VDD VSS VSS gf180mcu_as_sc_mcu7t3v3__fillcap_4
X_3946_ VDD VDD VSS VSS _4979_/Q _4166_/B _4230_/B _4166_/D _4979_/D gf180mcu_as_sc_mcu7t3v3__ao22_2
XFILLER_149_455 VDD VDD VSS VSS gf180mcu_as_sc_mcu7t3v3__fillcap_16
XFILLER_176_241 VDD VDD VSS VSS gf180mcu_as_sc_mcu7t3v3__fillcap_4
XFILLER_71_1537 VDD VDD VSS VSS gf180mcu_as_sc_mcu7t3v3__fillcap_16
XTAP_TAPCELL_ROW_7_1_664 VDD VSS gf180mcu_as_sc_mcu7t3v3__tap_2
XFILLER_137_628 VDD VDD VSS VSS gf180mcu_as_sc_mcu7t3v3__fill_2
XFILLER_176_263 VDD VDD VSS VSS gf180mcu_as_sc_mcu7t3v3__fillcap_16
X_3877_ VDD VDD VSS VSS _4946_/D _5167_/Q _4917_/D gf180mcu_as_sc_mcu7t3v3__and2_2
XTAP_TAPCELL_ROW_174_2080 VDD VSS gf180mcu_as_sc_mcu7t3v3__tap_2
XPHY_EDGE_ROW_88_1_Left_540 VDD VSS gf180mcu_as_sc_mcu7t3v3__tap_2
XFILLER_136_116 VDD VDD VSS VSS gf180mcu_as_sc_mcu7t3v3__fill_1
X_2828_ VDD VDD VSS VSS _4751_/A _2828_/B _5283_/Q _5282_/D gf180mcu_as_sc_mcu7t3v3__mux2_2
XTAP_TAPCELL_ROW_174_2091 VDD VSS gf180mcu_as_sc_mcu7t3v3__tap_2
X_2759_ VDD VDD VSS VSS _4652_/B _5233_/Q _2806_/D _4634_/A _2761_/D gf180mcu_as_sc_mcu7t3v3__ao211_2
XTAP_TAPCELL_ROW_12_3_2367 VDD VSS gf180mcu_as_sc_mcu7t3v3__tap_2
XFILLER_2_107 VDD VDD VSS VSS gf180mcu_as_sc_mcu7t3v3__fillcap_16
X_5478_ VDD VDD VSS VSS _5478_/A _5478_/Y gf180mcu_as_sc_mcu7t3v3__buff_2
XFILLER_144_193 VDD VDD VSS VSS gf180mcu_as_sc_mcu7t3v3__fillcap_16
XFILLER_160_653 VDD VDD VSS VSS gf180mcu_as_sc_mcu7t3v3__fill_1
XFILLER_172_491 VDD VDD VSS VSS gf180mcu_as_sc_mcu7t3v3__fill_1
XFILLER_69_1499 VDD VDD VSS VSS gf180mcu_as_sc_mcu7t3v3__fillcap_16
X_4429_ VDD VDD VSS VSS _4552_/A _5012_/Q _5041_/Q _4430_/B gf180mcu_as_sc_mcu7t3v3__mux2_2
XFILLER_48_14 VDD VDD VSS VSS gf180mcu_as_sc_mcu7t3v3__fill_2
XFILLER_58_111 VDD VDD VSS VSS gf180mcu_as_sc_mcu7t3v3__fill_2
Xfanout488 VDD VDD VSS VSS _4223_/B _4219_/B gf180mcu_as_sc_mcu7t3v3__buff_2
Xfanout499 VDD VDD VSS VSS _3803_/B _3731_/B gf180mcu_as_sc_mcu7t3v3__buff_2
XFILLER_58_177 VDD VDD VSS VSS gf180mcu_as_sc_mcu7t3v3__fillcap_16
Xmesh_tile_881 VDD VDD VSS VSS north_out[22] gf180mcu_as_sc_mcu7t3v3__tiel_4
Xmesh_tile_870 VDD VDD VSS VSS north_out[11] gf180mcu_as_sc_mcu7t3v3__tiel_4
XTAP_TAPCELL_ROW_63_1_887 VDD VSS gf180mcu_as_sc_mcu7t3v3__tap_2
XFILLER_64_24 VDD VDD VSS VSS gf180mcu_as_sc_mcu7t3v3__fillcap_8
XFILLER_73_158 VDD VDD VSS VSS gf180mcu_as_sc_mcu7t3v3__fill_2
Xmesh_tile_892 VDD VDD VSS VSS north_out[33] gf180mcu_as_sc_mcu7t3v3__tiel_4
XTAP_TAPCELL_ROW_146_1470 VDD VSS gf180mcu_as_sc_mcu7t3v3__tap_2
XTAP_TAPCELL_ROW_133_1_1168 VDD VSS gf180mcu_as_sc_mcu7t3v3__tap_2
XTAP_TAPCELL_ROW_66_3_2449 VDD VSS gf180mcu_as_sc_mcu7t3v3__tap_2
XFILLER_14_225 VDD VDD VSS VSS gf180mcu_as_sc_mcu7t3v3__fillcap_16
XFILLER_14_247 VDD VDD VSS VSS gf180mcu_as_sc_mcu7t3v3__fillcap_16
XTAP_TAPCELL_ROW_99_1_1030 VDD VSS gf180mcu_as_sc_mcu7t3v3__tap_2
XTAP_TAPCELL_ROW_142_1389 VDD VSS gf180mcu_as_sc_mcu7t3v3__tap_2
XTAP_TAPCELL_ROW_142_1378 VDD VSS gf180mcu_as_sc_mcu7t3v3__tap_2
XFILLER_168_731 VDD VDD VSS VSS gf180mcu_as_sc_mcu7t3v3__fillcap_4
XTAP_TAPCELL_ROW_113_1_1088 VDD VSS gf180mcu_as_sc_mcu7t3v3__tap_2
XFILLER_13_50 VDD VDD VSS VSS gf180mcu_as_sc_mcu7t3v3__fillcap_16
XFILLER_155_414 VDD VDD VSS VSS gf180mcu_as_sc_mcu7t3v3__fillcap_4
XFILLER_183_723 VDD VDD VSS VSS gf180mcu_as_sc_mcu7t3v3__fillcap_8
XFILLER_127_138 VDD VDD VSS VSS gf180mcu_as_sc_mcu7t3v3__fill_2
XFILLER_13_72 VDD VDD VSS VSS gf180mcu_as_sc_mcu7t3v3__fillcap_16
XFILLER_129_72 VDD VDD VSS VSS gf180mcu_as_sc_mcu7t3v3__fill_2
XFILLER_129_94 VDD VDD VSS VSS gf180mcu_as_sc_mcu7t3v3__fill_1
XFILLER_171_929 VDD VDD VSS VSS gf180mcu_as_sc_mcu7t3v3__fill_2
XFILLER_123_300 VDD VDD VSS VSS gf180mcu_as_sc_mcu7t3v3__fill_1
XFILLER_136_683 VDD VDD VSS VSS gf180mcu_as_sc_mcu7t3v3__fill_2
XFILLER_159_1060 VDD VDD VSS VSS gf180mcu_as_sc_mcu7t3v3__fill_2
XFILLER_89_65 VDD VDD VSS VSS gf180mcu_as_sc_mcu7t3v3__fillcap_4
XFILLER_150_152 VDD VDD VSS VSS gf180mcu_as_sc_mcu7t3v3__fillcap_16
XFILLER_150_174 VDD VDD VSS VSS gf180mcu_as_sc_mcu7t3v3__fill_1
XFILLER_151_686 VDD VDD VSS VSS gf180mcu_as_sc_mcu7t3v3__fill_2
XFILLER_137_1380 VDD VDD VSS VSS gf180mcu_as_sc_mcu7t3v3__fillcap_16
XFILLER_24_1550 VDD VDD VSS VSS gf180mcu_as_sc_mcu7t3v3__fillcap_4
XFILLER_49_188 VDD VDD VSS VSS gf180mcu_as_sc_mcu7t3v3__fillcap_16
XFILLER_0_1519 VDD VDD VSS VSS gf180mcu_as_sc_mcu7t3v3__fillcap_16
XFILLER_111_1553 VDD VDD VSS VSS gf180mcu_as_sc_mcu7t3v3__fillcap_16
XFILLER_166_1053 VDD VDD VSS VSS gf180mcu_as_sc_mcu7t3v3__fillcap_4
XFILLER_178_539 VDD VDD VSS VSS gf180mcu_as_sc_mcu7t3v3__fill_2
X_4780_ VDD VDD VSS VSS _5052_/CLK _4780_/D _4780_/Q gf180mcu_as_sc_mcu7t3v3__dfxtp_2
X_3800_ VDD VDD VSS VSS _3800_/D _3800_/A _3807_/B _3800_/C _3801_/D gf180mcu_as_sc_mcu7t3v3__ao31_2
X_3731_ VDD VDD VSS VSS _4860_/D _3731_/C _3731_/B _3731_/A gf180mcu_as_sc_mcu7t3v3__aoi21_2
XFILLER_144_1395 VDD VDD VSS VSS gf180mcu_as_sc_mcu7t3v3__fillcap_4
XFILLER_147_926 VDD VDD VSS VSS gf180mcu_as_sc_mcu7t3v3__fill_1
XFILLER_158_241 VDD VDD VSS VSS gf180mcu_as_sc_mcu7t3v3__fillcap_4
XFILLER_158_263 VDD VDD VSS VSS gf180mcu_as_sc_mcu7t3v3__fillcap_4
XTAP_TAPCELL_ROW_80_1_957 VDD VSS gf180mcu_as_sc_mcu7t3v3__tap_2
XFILLER_140_1248 VDD VDD VSS VSS gf180mcu_as_sc_mcu7t3v3__fillcap_4
XFILLER_140_1259 VDD VDD VSS VSS gf180mcu_as_sc_mcu7t3v3__fillcap_16
XFILLER_147_948 VDD VDD VSS VSS gf180mcu_as_sc_mcu7t3v3__fill_1
XFILLER_174_734 VDD VDD VSS VSS gf180mcu_as_sc_mcu7t3v3__fill_1
XFILLER_31_1521 VDD VDD VSS VSS gf180mcu_as_sc_mcu7t3v3__fillcap_16
Xclkload10 VDD VDD VSS VSS clkload10/Y _5164_/CLK gf180mcu_as_sc_mcu7t3v3__inv_6
X_3662_ VDD VDD VSS VSS _4040_/A _3716_/B _3716_/C _4039_/A _3663_/C gf180mcu_as_sc_mcu7t3v3__ao22_2
XFILLER_173_244 VDD VDD VSS VSS gf180mcu_as_sc_mcu7t3v3__fillcap_16
Xclkload21 VDD VDD VSS VSS clkload21/Y _4938_/CLK gf180mcu_as_sc_mcu7t3v3__inv_4
X_3593_ VDD VDD VSS VSS _3961_/A _3752_/B _3753_/B _3594_/C _3593_/D gf180mcu_as_sc_mcu7t3v3__aoi211_2
X_2613_ VDD VDD VSS VSS _2621_/B _5229_/Q _2614_/B gf180mcu_as_sc_mcu7t3v3__or2_2
X_2544_ VDD VDD VSS VSS _2771_/D _2798_/B gf180mcu_as_sc_mcu7t3v3__inv_2
XFILLER_138_1177 VDD VDD VSS VSS gf180mcu_as_sc_mcu7t3v3__fill_1
XFILLER_142_675 VDD VDD VSS VSS gf180mcu_as_sc_mcu7t3v3__fillcap_4
X_5263_ VDD VDD VSS VSS clkload7/A _5263_/D _5263_/Q gf180mcu_as_sc_mcu7t3v3__dfxtp_2
X_2475_ VDD VDD VSS VSS _2589_/A _4949_/Q _2476_/B gf180mcu_as_sc_mcu7t3v3__and2_2
XFILLER_29_1483 VDD VDD VSS VSS gf180mcu_as_sc_mcu7t3v3__fillcap_16
XFILLER_87_228 VDD VDD VSS VSS gf180mcu_as_sc_mcu7t3v3__fill_1
XPHY_EDGE_ROW_143_Right_277 VDD VSS gf180mcu_as_sc_mcu7t3v3__tap_2
X_5194_ VDD VDD VSS VSS clkload2/A _5194_/D _5194_/Q gf180mcu_as_sc_mcu7t3v3__dfxtp_2
X_4214_ VDD VDD VSS VSS _4243_/B _4218_/B _4221_/C _5050_/Q _5050_/D gf180mcu_as_sc_mcu7t3v3__ao22_2
XFILLER_116_1486 VDD VDD VSS VSS gf180mcu_as_sc_mcu7t3v3__fillcap_16
XFILLER_151_1366 VDD VDD VSS VSS gf180mcu_as_sc_mcu7t3v3__fillcap_16
X_4145_ VDD VDD VSS VSS _4145_/A _4159_/B _4145_/C _4145_/D _4147_/C gf180mcu_as_sc_mcu7t3v3__ao211_2
XFILLER_141_18 VDD VDD VSS VSS gf180mcu_as_sc_mcu7t3v3__fillcap_16
XFILLER_151_1388 VDD VDD VSS VSS gf180mcu_as_sc_mcu7t3v3__fill_1
X_4076_ VDD VDD VSS VSS _4995_/Q _4092_/B _4246_/B _4092_/D _4995_/D gf180mcu_as_sc_mcu7t3v3__ao22_2
X_3027_ VDD VDD VSS VSS _3145_/A _3027_/B _3027_/C _3145_/D _3029_/C gf180mcu_as_sc_mcu7t3v3__ao211_2
XFILLER_145_1104 VDD VDD VSS VSS gf180mcu_as_sc_mcu7t3v3__fillcap_16
XFILLER_149_1262 VDD VDD VSS VSS gf180mcu_as_sc_mcu7t3v3__fillcap_8
XFILLER_169_517 VDD VDD VSS VSS gf180mcu_as_sc_mcu7t3v3__fillcap_4
XFILLER_180_1017 VDD VDD VSS VSS gf180mcu_as_sc_mcu7t3v3__fill_1
XTAP_TAPCELL_ROW_176_2131 VDD VSS gf180mcu_as_sc_mcu7t3v3__tap_2
XTAP_TAPCELL_ROW_176_2120 VDD VSS gf180mcu_as_sc_mcu7t3v3__tap_2
XFILLER_11_206 VDD VDD VSS VSS gf180mcu_as_sc_mcu7t3v3__fillcap_4
XFILLER_11_228 VDD VDD VSS VSS gf180mcu_as_sc_mcu7t3v3__fillcap_16
X_4978_ VDD VDD VSS VSS _5172_/CLK _4978_/D _4978_/Q gf180mcu_as_sc_mcu7t3v3__dfxtp_2
XFILLER_149_252 VDD VDD VSS VSS gf180mcu_as_sc_mcu7t3v3__fill_1
Xclkload4 VDD VDD VSS VSS clkload4/Y clkload4/A gf180mcu_as_sc_mcu7t3v3__inv_4
X_3929_ VDD VDD VSS VSS _3929_/Y _3929_/B _3929_/A gf180mcu_as_sc_mcu7t3v3__nor2_2
XTAP_TAPCELL_ROW_172_2039 VDD VSS gf180mcu_as_sc_mcu7t3v3__tap_2
XFILLER_164_233 VDD VDD VSS VSS gf180mcu_as_sc_mcu7t3v3__fillcap_8
XFILLER_177_594 VDD VDD VSS VSS gf180mcu_as_sc_mcu7t3v3__fillcap_8
XFILLER_50_37 VDD VDD VSS VSS gf180mcu_as_sc_mcu7t3v3__fillcap_4
XFILLER_137_469 VDD VDD VSS VSS gf180mcu_as_sc_mcu7t3v3__fill_2
XFILLER_166_37 VDD VDD VSS VSS gf180mcu_as_sc_mcu7t3v3__fillcap_16
XFILLER_105_300 VDD VDD VSS VSS gf180mcu_as_sc_mcu7t3v3__fill_1
XFILLER_180_737 VDD VDD VSS VSS gf180mcu_as_sc_mcu7t3v3__fill_2
XFILLER_132_141 VDD VDD VSS VSS gf180mcu_as_sc_mcu7t3v3__fillcap_4
XFILLER_152_1108 VDD VDD VSS VSS gf180mcu_as_sc_mcu7t3v3__fill_1
XPHY_EDGE_ROW_133_3_Left_267 VDD VSS gf180mcu_as_sc_mcu7t3v3__tap_2
XTAP_TAPCELL_ROW_118_3_2526 VDD VSS gf180mcu_as_sc_mcu7t3v3__tap_2
XFILLER_132_174 VDD VDD VSS VSS gf180mcu_as_sc_mcu7t3v3__fill_1
XTAP_TAPCELL_ROW_148_1510 VDD VSS gf180mcu_as_sc_mcu7t3v3__tap_2
XFILLER_93_209 VDD VDD VSS VSS gf180mcu_as_sc_mcu7t3v3__fill_1
XTAP_TAPCELL_ROW_148_1521 VDD VSS gf180mcu_as_sc_mcu7t3v3__tap_2
XPHY_EDGE_ROW_70_3_Left_204 VDD VSS gf180mcu_as_sc_mcu7t3v3__tap_2
XFILLER_46_103 VDD VDD VSS VSS gf180mcu_as_sc_mcu7t3v3__fill_2
XFILLER_86_261 VDD VDD VSS VSS gf180mcu_as_sc_mcu7t3v3__fill_1
XTAP_TAPCELL_ROW_144_1429 VDD VSS gf180mcu_as_sc_mcu7t3v3__tap_2
XTAP_TAPCELL_ROW_144_1418 VDD VSS gf180mcu_as_sc_mcu7t3v3__tap_2
XTAP_TAPCELL_ROW_165_1890 VDD VSS gf180mcu_as_sc_mcu7t3v3__tap_2
XFILLER_163_1204 VDD VDD VSS VSS gf180mcu_as_sc_mcu7t3v3__fillcap_16
XTAP_TAPCELL_ROW_161_1798 VDD VSS gf180mcu_as_sc_mcu7t3v3__tap_2
XFILLER_141_1502 VDD VDD VSS VSS gf180mcu_as_sc_mcu7t3v3__fillcap_8
XFILLER_163_1259 VDD VDD VSS VSS gf180mcu_as_sc_mcu7t3v3__fill_1
XFILLER_175_509 VDD VDD VSS VSS gf180mcu_as_sc_mcu7t3v3__fillcap_16
XFILLER_91_88 VDD VDD VSS VSS gf180mcu_as_sc_mcu7t3v3__fillcap_8
XFILLER_156_745 VDD VDD VSS VSS gf180mcu_as_sc_mcu7t3v3__fillcap_4
XFILLER_155_244 VDD VDD VSS VSS gf180mcu_as_sc_mcu7t3v3__fillcap_8
XFILLER_170_225 VDD VDD VSS VSS gf180mcu_as_sc_mcu7t3v3__fillcap_16
XPHY_EDGE_ROW_65_3_Left_199 VDD VSS gf180mcu_as_sc_mcu7t3v3__tap_2
XFILLER_108_193 VDD VDD VSS VSS gf180mcu_as_sc_mcu7t3v3__fillcap_4
XFILLER_170_247 VDD VDD VSS VSS gf180mcu_as_sc_mcu7t3v3__fillcap_16
XFILLER_123_163 VDD VDD VSS VSS gf180mcu_as_sc_mcu7t3v3__fillcap_8
XFILLER_151_450 VDD VDD VSS VSS gf180mcu_as_sc_mcu7t3v3__fillcap_16
XFILLER_123_196 VDD VDD VSS VSS gf180mcu_as_sc_mcu7t3v3__fill_2
XFILLER_69_239 VDD VDD VSS VSS gf180mcu_as_sc_mcu7t3v3__fillcap_8
XFILLER_84_209 VDD VDD VSS VSS gf180mcu_as_sc_mcu7t3v3__fillcap_4
XFILLER_168_1115 VDD VDD VSS VSS gf180mcu_as_sc_mcu7t3v3__fill_2
XFILLER_37_136 VDD VDD VSS VSS gf180mcu_as_sc_mcu7t3v3__fillcap_4
XFILLER_37_158 VDD VDD VSS VSS gf180mcu_as_sc_mcu7t3v3__fillcap_16
X_4901_ VDD VDD VSS VSS _4943_/CLK _4901_/D _4901_/Q gf180mcu_as_sc_mcu7t3v3__dfxtp_2
XFILLER_179_826 VDD VDD VSS VSS gf180mcu_as_sc_mcu7t3v3__fillcap_8
X_4832_ VDD VDD VSS VSS _4867_/CLK _4832_/D _4832_/Q gf180mcu_as_sc_mcu7t3v3__dfxtp_2
XPHY_EDGE_ROW_140_Left_592 VDD VSS gf180mcu_as_sc_mcu7t3v3__tap_2
Xclkbuf_leaf_29_clk_regs VDD VDD VSS VSS clkbuf_3_7_0_clk_regs/Y _4869_/CLK gf180mcu_as_sc_mcu7t3v3__clkbuff_12
X_4763_ VDD VDD VSS VSS clkload4/A _4763_/D _4763_/Q gf180mcu_as_sc_mcu7t3v3__dfxtp_2
XTAP_TAPCELL_ROW_124_3_2536 VDD VSS gf180mcu_as_sc_mcu7t3v3__tap_2
X_4694_ VDD VDD VSS VSS _4733_/C _5480_/A _5253_/Q _4695_/A gf180mcu_as_sc_mcu7t3v3__mux2_2
X_3714_ VDD VDD VSS VSS _3730_/D _3730_/A _3714_/B _3714_/C _3715_/C gf180mcu_as_sc_mcu7t3v3__ao31_2
XFILLER_162_737 VDD VDD VSS VSS gf180mcu_as_sc_mcu7t3v3__fillcap_16
XFILLER_174_586 VDD VDD VSS VSS gf180mcu_as_sc_mcu7t3v3__fillcap_8
XFILLER_174_597 VDD VDD VSS VSS gf180mcu_as_sc_mcu7t3v3__fillcap_16
XFILLER_175_1119 VDD VDD VSS VSS gf180mcu_as_sc_mcu7t3v3__fill_1
XFILLER_20_18 VDD VDD VSS VSS gf180mcu_as_sc_mcu7t3v3__fillcap_16
X_3645_ VDD VDD VSS VSS _3646_/C _3645_/C _3729_/B _4017_/A gf180mcu_as_sc_mcu7t3v3__aoi21_2
X_3576_ VDD VDD VSS VSS _3938_/D _3781_/S _3576_/C _3576_/D _3577_/C gf180mcu_as_sc_mcu7t3v3__ao211_2
X_2527_ VDD VDD VSS VSS _4655_/B _4657_/B _5268_/Q gf180mcu_as_sc_mcu7t3v3__nor2_2
X_5246_ VDD VDD VSS VSS clkload7/A _5246_/D _5246_/Q gf180mcu_as_sc_mcu7t3v3__dfxtp_2
Xinput309 VDD VDD VSS VSS west_in[33] _3548_/A gf180mcu_as_sc_mcu7t3v3__buff_2
X_2458_ VDD VDD VSS VSS _3869_/A _3846_/B _3847_/A gf180mcu_as_sc_mcu7t3v3__nand2_2
XTAP_TAPCELL_ROW_4_3_2355 VDD VSS gf180mcu_as_sc_mcu7t3v3__tap_2
XFILLER_75_209 VDD VDD VSS VSS gf180mcu_as_sc_mcu7t3v3__fill_1
XFILLER_151_1174 VDD VDD VSS VSS gf180mcu_as_sc_mcu7t3v3__fillcap_16
X_5177_ VDD VDD VSS VSS _5188_/CLK _5177_/D _5177_/Q gf180mcu_as_sc_mcu7t3v3__dfxtp_2
X_4128_ VDD VDD VSS VSS _4128_/B _4128_/A _4130_/C gf180mcu_as_sc_mcu7t3v3__and2_2
XFILLER_77_1521 VDD VDD VSS VSS gf180mcu_as_sc_mcu7t3v3__fillcap_16
X_4059_ VDD VDD VSS VSS _4059_/B _4059_/A _4244_/B gf180mcu_as_sc_mcu7t3v3__and2_2
XPHY_EDGE_ROW_18_1_Right_17 VDD VSS gf180mcu_as_sc_mcu7t3v3__tap_2
XFILLER_101_10 VDD VDD VSS VSS gf180mcu_as_sc_mcu7t3v3__fillcap_4
XFILLER_169_314 VDD VDD VSS VSS gf180mcu_as_sc_mcu7t3v3__fillcap_16
XFILLER_138_723 VDD VDD VSS VSS gf180mcu_as_sc_mcu7t3v3__fillcap_8
XFILLER_138_745 VDD VDD VSS VSS gf180mcu_as_sc_mcu7t3v3__fillcap_4
XFILLER_178_892 VDD VDD VSS VSS gf180mcu_as_sc_mcu7t3v3__fill_2
XTAP_TAPCELL_ROW_137_1277 VDD VSS gf180mcu_as_sc_mcu7t3v3__tap_2
XTAP_TAPCELL_ROW_137_1266 VDD VSS gf180mcu_as_sc_mcu7t3v3__tap_2
XFILLER_152_225 VDD VDD VSS VSS gf180mcu_as_sc_mcu7t3v3__fillcap_16
XFILLER_152_247 VDD VDD VSS VSS gf180mcu_as_sc_mcu7t3v3__fillcap_16
XFILLER_105_174 VDD VDD VSS VSS gf180mcu_as_sc_mcu7t3v3__fillcap_16
XPHY_EDGE_ROW_103_1_Left_555 VDD VSS gf180mcu_as_sc_mcu7t3v3__tap_2
Xclkbuf_regs_0_clk VDD VDD VSS VSS clk clkbuf_regs_0_clk/Y gf180mcu_as_sc_mcu7t3v3__clkbuff_12
XFILLER_120_122 VDD VDD VSS VSS gf180mcu_as_sc_mcu7t3v3__fill_1
XTAP_TAPCELL_ROW_167_1941 VDD VSS gf180mcu_as_sc_mcu7t3v3__tap_2
XTAP_TAPCELL_ROW_167_1930 VDD VSS gf180mcu_as_sc_mcu7t3v3__tap_2
XFILLER_120_177 VDD VDD VSS VSS gf180mcu_as_sc_mcu7t3v3__fillcap_16
XFILLER_19_136 VDD VDD VSS VSS gf180mcu_as_sc_mcu7t3v3__fillcap_4
XFILLER_74_231 VDD VDD VSS VSS gf180mcu_as_sc_mcu7t3v3__fillcap_8
XTAP_TAPCELL_ROW_163_1838 VDD VSS gf180mcu_as_sc_mcu7t3v3__tap_2
XFILLER_19_158 VDD VDD VSS VSS gf180mcu_as_sc_mcu7t3v3__fillcap_16
XFILLER_21_1553 VDD VDD VSS VSS gf180mcu_as_sc_mcu7t3v3__fillcap_16
XTAP_TAPCELL_ROW_163_1849 VDD VSS gf180mcu_as_sc_mcu7t3v3__tap_2
XFILLER_34_139 VDD VDD VSS VSS gf180mcu_as_sc_mcu7t3v3__fillcap_16
XFILLER_167_1192 VDD VDD VSS VSS gf180mcu_as_sc_mcu7t3v3__fillcap_16
XFILLER_176_807 VDD VDD VSS VSS gf180mcu_as_sc_mcu7t3v3__fill_1
XFILLER_42_172 VDD VDD VSS VSS gf180mcu_as_sc_mcu7t3v3__fill_2
XFILLER_141_1332 VDD VDD VSS VSS gf180mcu_as_sc_mcu7t3v3__fillcap_4
XFILLER_156_520 VDD VDD VSS VSS gf180mcu_as_sc_mcu7t3v3__fillcap_4
XFILLER_169_892 VDD VDD VSS VSS gf180mcu_as_sc_mcu7t3v3__fillcap_4
XFILLER_128_244 VDD VDD VSS VSS gf180mcu_as_sc_mcu7t3v3__fill_1
XFILLER_144_737 VDD VDD VSS VSS gf180mcu_as_sc_mcu7t3v3__fillcap_16
XFILLER_176_1428 VDD VDD VSS VSS gf180mcu_as_sc_mcu7t3v3__fill_2
Xwire461 VDD VDD VSS VSS _2664_/Y wire461/Y gf180mcu_as_sc_mcu7t3v3__buff_8
XPHY_EDGE_ROW_64_1_Right_63 VDD VSS gf180mcu_as_sc_mcu7t3v3__tap_2
XFILLER_128_299 VDD VDD VSS VSS gf180mcu_as_sc_mcu7t3v3__fill_2
XFILLER_171_545 VDD VDD VSS VSS gf180mcu_as_sc_mcu7t3v3__fill_1
X_3430_ VDD VDD VSS VSS _4078_/A _3474_/C _3523_/B _4081_/A _3431_/C gf180mcu_as_sc_mcu7t3v3__ao22_2
XTAP_TAPCELL_ROW_50_1_835 VDD VSS gf180mcu_as_sc_mcu7t3v3__tap_2
XPHY_EDGE_ROW_35_1_Left_487 VDD VSS gf180mcu_as_sc_mcu7t3v3__tap_2
X_3361_ VDD VDD VSS VSS _3450_/B _4015_/A _3364_/C gf180mcu_as_sc_mcu7t3v3__and2_2
XFILLER_135_1114 VDD VDD VSS VSS gf180mcu_as_sc_mcu7t3v3__fillcap_4
XFILLER_174_1152 VDD VDD VSS VSS gf180mcu_as_sc_mcu7t3v3__fill_2
X_5100_ VDD VDD VSS VSS clkload6/A _5100_/D _5100_/Q gf180mcu_as_sc_mcu7t3v3__dfxtp_2
XFILLER_140_976 VDD VDD VSS VSS gf180mcu_as_sc_mcu7t3v3__fillcap_16
X_5031_ VDD VDD VSS VSS _5094_/CLK _5031_/D _5031_/Q gf180mcu_as_sc_mcu7t3v3__dfxtp_2
X_3292_ VDD VDD VSS VSS _3941_/A _3503_/B _3292_/C _3292_/D _3294_/C gf180mcu_as_sc_mcu7t3v3__ao211_2
XFILLER_111_188 VDD VDD VSS VSS gf180mcu_as_sc_mcu7t3v3__fillcap_16
XFILLER_25_2 VDD VDD VSS VSS gf180mcu_as_sc_mcu7t3v3__fillcap_16
XFILLER_113_1467 VDD VDD VSS VSS gf180mcu_as_sc_mcu7t3v3__fillcap_16
XFILLER_26_1486 VDD VDD VSS VSS gf180mcu_as_sc_mcu7t3v3__fillcap_16
XFILLER_65_264 VDD VDD VSS VSS gf180mcu_as_sc_mcu7t3v3__fill_2
XFILLER_146_1221 VDD VDD VSS VSS gf180mcu_as_sc_mcu7t3v3__fillcap_4
XFILLER_15_18 VDD VDD VSS VSS gf180mcu_as_sc_mcu7t3v3__fillcap_16
XFILLER_146_1254 VDD VDD VSS VSS gf180mcu_as_sc_mcu7t3v3__fillcap_16
XFILLER_139_509 VDD VDD VSS VSS gf180mcu_as_sc_mcu7t3v3__fillcap_8
XFILLER_178_155 VDD VDD VSS VSS gf180mcu_as_sc_mcu7t3v3__fillcap_16
XFILLER_179_689 VDD VDD VSS VSS gf180mcu_as_sc_mcu7t3v3__fillcap_4
XFILLER_72_1451 VDD VDD VSS VSS gf180mcu_as_sc_mcu7t3v3__fillcap_16
X_4815_ VDD VDD VSS VSS _4863_/CLK _4815_/D _4815_/Q gf180mcu_as_sc_mcu7t3v3__dfxtp_2
XTAP_TAPCELL_ROW_114_1_1093 VDD VSS gf180mcu_as_sc_mcu7t3v3__tap_2
XFILLER_166_317 VDD VDD VSS VSS gf180mcu_as_sc_mcu7t3v3__fillcap_16
XFILLER_178_177 VDD VDD VSS VSS gf180mcu_as_sc_mcu7t3v3__fillcap_16
X_4746_ VDD VDD VSS VSS _4746_/A _4746_/B _4746_/C _4747_/C _4746_/D gf180mcu_as_sc_mcu7t3v3__aoi211_2
XFILLER_119_288 VDD VDD VSS VSS gf180mcu_as_sc_mcu7t3v3__fillcap_8
XFILLER_162_501 VDD VDD VSS VSS gf180mcu_as_sc_mcu7t3v3__fill_1
XFILLER_179_1052 VDD VDD VSS VSS gf180mcu_as_sc_mcu7t3v3__fillcap_4
X_4677_ VDD VDD VSS VSS _5246_/Q _4677_/B _4681_/C _5247_/Q _4678_/C gf180mcu_as_sc_mcu7t3v3__ao22_2
XFILLER_135_748 VDD VDD VSS VSS gf180mcu_as_sc_mcu7t3v3__fill_1
X_3628_ VDD VDD VSS VSS _3629_/C _3997_/A _3750_/C _3628_/C gf180mcu_as_sc_mcu7t3v3__ao21_2
XFILLER_102_111 VDD VDD VSS VSS gf180mcu_as_sc_mcu7t3v3__fill_2
XFILLER_153_1214 VDD VDD VSS VSS gf180mcu_as_sc_mcu7t3v3__fill_1
X_3559_ VDD VDD VSS VSS _3559_/A _3922_/B _3559_/C _3559_/Y _3805_/B gf180mcu_as_sc_mcu7t3v3__aoi211_2
Xinput106 VDD VDD VSS VSS ne_in[4] _3965_/A gf180mcu_as_sc_mcu7t3v3__buff_2
Xinput117 VDD VDD VSS VSS north_in[14] _4045_/A gf180mcu_as_sc_mcu7t3v3__buff_2
XFILLER_102_177 VDD VDD VSS VSS gf180mcu_as_sc_mcu7t3v3__fillcap_16
XFILLER_44_1542 VDD VDD VSS VSS gf180mcu_as_sc_mcu7t3v3__fillcap_4
X_5229_ VDD VDD VSS VSS _5266_/CLK _5229_/D _5229_/Q gf180mcu_as_sc_mcu7t3v3__dfxtp_2
Xinput128 VDD VDD VSS VSS north_in[24] _4129_/A gf180mcu_as_sc_mcu7t3v3__buff_2
Xinput139 VDD VDD VSS VSS north_in[3] _3959_/A gf180mcu_as_sc_mcu7t3v3__buff_2
XFILLER_56_25 VDD VDD VSS VSS gf180mcu_as_sc_mcu7t3v3__fillcap_8
XTAP_TAPCELL_ROW_184_2296 VDD VSS gf180mcu_as_sc_mcu7t3v3__tap_2
XFILLER_16_139 VDD VDD VSS VSS gf180mcu_as_sc_mcu7t3v3__fillcap_16
XFILLER_71_212 VDD VDD VSS VSS gf180mcu_as_sc_mcu7t3v3__fillcap_16
XFILLER_147_1029 VDD VDD VSS VSS gf180mcu_as_sc_mcu7t3v3__fill_2
XFILLER_164_1321 VDD VDD VSS VSS gf180mcu_as_sc_mcu7t3v3__fill_2
XFILLER_72_24 VDD VDD VSS VSS gf180mcu_as_sc_mcu7t3v3__fillcap_8
XTAP_TAPCELL_ROW_18_3_2376 VDD VSS gf180mcu_as_sc_mcu7t3v3__tap_2
XFILLER_158_807 VDD VDD VSS VSS gf180mcu_as_sc_mcu7t3v3__fillcap_8
XFILLER_160_1218 VDD VDD VSS VSS gf180mcu_as_sc_mcu7t3v3__fillcap_4
XTAP_TAPCELL_ROW_15_1_694 VDD VSS gf180mcu_as_sc_mcu7t3v3__tap_2
XTAP_TAPCELL_ROW_139_1306 VDD VSS gf180mcu_as_sc_mcu7t3v3__tap_2
XTAP_TAPCELL_ROW_139_1317 VDD VSS gf180mcu_as_sc_mcu7t3v3__tap_2
XTAP_TAPCELL_ROW_90_1_995 VDD VSS gf180mcu_as_sc_mcu7t3v3__tap_2
XTAP_TAPCELL_ROW_106_3_2508 VDD VSS gf180mcu_as_sc_mcu7t3v3__tap_2
XFILLER_138_575 VDD VDD VSS VSS gf180mcu_as_sc_mcu7t3v3__fillcap_16
XFILLER_184_169 VDD VDD VSS VSS gf180mcu_as_sc_mcu7t3v3__fill_1
XTAP_TAPCELL_ROW_156_1686 VDD VSS gf180mcu_as_sc_mcu7t3v3__tap_2
XFILLER_21_50 VDD VDD VSS VSS gf180mcu_as_sc_mcu7t3v3__fillcap_16
XFILLER_21_72 VDD VDD VSS VSS gf180mcu_as_sc_mcu7t3v3__fillcap_16
XTAP_TAPCELL_ROW_156_1697 VDD VSS gf180mcu_as_sc_mcu7t3v3__tap_2
XFILLER_137_50 VDD VDD VSS VSS gf180mcu_as_sc_mcu7t3v3__fillcap_16
XFILLER_137_72 VDD VDD VSS VSS gf180mcu_as_sc_mcu7t3v3__fillcap_16
XFILLER_97_10 VDD VDD VSS VSS gf180mcu_as_sc_mcu7t3v3__fillcap_4
XFILLER_134_781 VDD VDD VSS VSS gf180mcu_as_sc_mcu7t3v3__fill_1
XFILLER_136_1434 VDD VDD VSS VSS gf180mcu_as_sc_mcu7t3v3__fill_1
XFILLER_140_217 VDD VDD VSS VSS gf180mcu_as_sc_mcu7t3v3__fill_2
XFILLER_175_1472 VDD VDD VSS VSS gf180mcu_as_sc_mcu7t3v3__fillcap_8
XFILLER_39_209 VDD VDD VSS VSS gf180mcu_as_sc_mcu7t3v3__fill_1
XFILLER_46_80 VDD VDD VSS VSS gf180mcu_as_sc_mcu7t3v3__fillcap_8
XFILLER_95_1451 VDD VDD VSS VSS gf180mcu_as_sc_mcu7t3v3__fillcap_16
XFILLER_1_1499 VDD VDD VSS VSS gf180mcu_as_sc_mcu7t3v3__fillcap_16
XFILLER_62_289 VDD VDD VSS VSS gf180mcu_as_sc_mcu7t3v3__fillcap_8
X_2930_ VDD VDD VSS VSS _2930_/Y _3216_/B _2930_/A gf180mcu_as_sc_mcu7t3v3__nor2_2
XTAP_TAPCELL_ROW_98_1_1026 VDD VSS gf180mcu_as_sc_mcu7t3v3__tap_2
XFILLER_176_626 VDD VDD VSS VSS gf180mcu_as_sc_mcu7t3v3__fill_1
XFILLER_62_90 VDD VDD VSS VSS gf180mcu_as_sc_mcu7t3v3__fill_2
X_4600_ VDD VDD VSS VSS _5194_/Q _4629_/B _4600_/C _5195_/Q _5194_/D gf180mcu_as_sc_mcu7t3v3__ao22_2
X_2861_ VDD VDD VSS VSS _2871_/B _2861_/B _4733_/B gf180mcu_as_sc_mcu7t3v3__nand2_2
XFILLER_175_136 VDD VDD VSS VSS gf180mcu_as_sc_mcu7t3v3__fillcap_4
XFILLER_175_158 VDD VDD VSS VSS gf180mcu_as_sc_mcu7t3v3__fillcap_16
X_2792_ VDD VDD VSS VSS _4732_/C _2792_/A _5267_/Q _4732_/B _2793_/B gf180mcu_as_sc_mcu7t3v3__ao31_2
XFILLER_141_1162 VDD VDD VSS VSS gf180mcu_as_sc_mcu7t3v3__fill_1
XFILLER_184_670 VDD VDD VSS VSS gf180mcu_as_sc_mcu7t3v3__fillcap_8
X_4531_ VDD VDD VSS VSS _5181_/Q _4565_/B _4531_/C _4531_/D _5181_/D gf180mcu_as_sc_mcu7t3v3__ao211_2
X_4462_ VDD VDD VSS VSS _4465_/C _4987_/Q _4568_/A gf180mcu_as_sc_mcu7t3v3__nand2b_2
XFILLER_116_247 VDD VDD VSS VSS gf180mcu_as_sc_mcu7t3v3__fillcap_8
XFILLER_176_1269 VDD VDD VSS VSS gf180mcu_as_sc_mcu7t3v3__fill_1
X_3413_ VDD VDD VSS VSS _3452_/S _4064_/D _3413_/A _3415_/B gf180mcu_as_sc_mcu7t3v3__mux2_2
XFILLER_154_1523 VDD VDD VSS VSS gf180mcu_as_sc_mcu7t3v3__fillcap_8
XFILLER_67_1553 VDD VDD VSS VSS gf180mcu_as_sc_mcu7t3v3__fillcap_16
Xfanout807 VDD VDD VSS VSS fanout808/Y _3746_/D gf180mcu_as_sc_mcu7t3v3__buff_2
X_4393_ VDD VDD VSS VSS _4394_/D _4393_/B _4510_/A gf180mcu_as_sc_mcu7t3v3__nor2_2
XTAP_TAPCELL_ROW_32_1_764 VDD VSS gf180mcu_as_sc_mcu7t3v3__tap_2
XFILLER_97_142 VDD VDD VSS VSS gf180mcu_as_sc_mcu7t3v3__fillcap_16
X_3344_ VDD VDD VSS VSS _3344_/B _3624_/A _4812_/D gf180mcu_as_sc_mcu7t3v3__and2_2
XFILLER_97_186 VDD VDD VSS VSS gf180mcu_as_sc_mcu7t3v3__fillcap_16
Xhold1005 VDD VDD VSS VSS _4952_/Q _2584_/B gf180mcu_as_sc_mcu7t3v3__buff_2
X_3275_ VDD VDD VSS VSS _3280_/D _3275_/B _3275_/A gf180mcu_as_sc_mcu7t3v3__nand2_2
XTAP_TAPCELL_ROW_24_3_2386 VDD VSS gf180mcu_as_sc_mcu7t3v3__tap_2
X_5014_ VDD VDD VSS VSS _5172_/CLK _5014_/D _5014_/Q gf180mcu_as_sc_mcu7t3v3__dfxtp_2
Xhold1016 VDD VDD VSS VSS hold1048/Y _4968_/D gf180mcu_as_sc_mcu7t3v3__buff_2
Xhold1027 VDD VDD VSS VSS _4768_/Q _2835_/A gf180mcu_as_sc_mcu7t3v3__buff_2
Xhold1038 VDD VDD VSS VSS hold1038/A _2583_/C gf180mcu_as_sc_mcu7t3v3__buff_2
Xhold1049 VDD VDD VSS VSS _4960_/Q hold1049/Y gf180mcu_as_sc_mcu7t3v3__buff_2
XFILLER_53_212 VDD VDD VSS VSS gf180mcu_as_sc_mcu7t3v3__fillcap_8
XTAP_TAPCELL_ROW_112_3_2518 VDD VSS gf180mcu_as_sc_mcu7t3v3__tap_2
XFILLER_74_1502 VDD VDD VSS VSS gf180mcu_as_sc_mcu7t3v3__fillcap_16
XFILLER_167_615 VDD VDD VSS VSS gf180mcu_as_sc_mcu7t3v3__fillcap_8
XFILLER_21_120 VDD VDD VSS VSS gf180mcu_as_sc_mcu7t3v3__fillcap_16
XFILLER_74_1568 VDD VDD VSS VSS gf180mcu_as_sc_mcu7t3v3__fill_1
XFILLER_139_317 VDD VDD VSS VSS gf180mcu_as_sc_mcu7t3v3__fill_2
XFILLER_146_1084 VDD VDD VSS VSS gf180mcu_as_sc_mcu7t3v3__fill_1
XFILLER_158_16 VDD VDD VSS VSS gf180mcu_as_sc_mcu7t3v3__fillcap_16
XFILLER_167_648 VDD VDD VSS VSS gf180mcu_as_sc_mcu7t3v3__fillcap_4
XFILLER_179_486 VDD VDD VSS VSS gf180mcu_as_sc_mcu7t3v3__fillcap_4
XFILLER_21_142 VDD VDD VSS VSS gf180mcu_as_sc_mcu7t3v3__fillcap_16
XFILLER_147_372 VDD VDD VSS VSS gf180mcu_as_sc_mcu7t3v3__fill_2
XFILLER_181_106 VDD VDD VSS VSS gf180mcu_as_sc_mcu7t3v3__fill_1
X_4729_ VDD VDD VSS VSS _5265_/D _5265_/Q _4730_/C _4729_/C gf180mcu_as_sc_mcu7t3v3__ao21_2
XTAP_TAPCELL_ROW_134_1203 VDD VSS gf180mcu_as_sc_mcu7t3v3__tap_2
XFILLER_159_1434 VDD VDD VSS VSS gf180mcu_as_sc_mcu7t3v3__fill_2
XTAP_TAPCELL_ROW_134_1214 VDD VSS gf180mcu_as_sc_mcu7t3v3__tap_2
XFILLER_135_556 VDD VDD VSS VSS gf180mcu_as_sc_mcu7t3v3__fillcap_4
XFILLER_174_37 VDD VDD VSS VSS gf180mcu_as_sc_mcu7t3v3__fillcap_16
XTAP_TAPCELL_ROW_151_1583 VDD VSS gf180mcu_as_sc_mcu7t3v3__tap_2
XTAP_TAPCELL_ROW_151_1572 VDD VSS gf180mcu_as_sc_mcu7t3v3__tap_2
XFILLER_153_1044 VDD VDD VSS VSS gf180mcu_as_sc_mcu7t3v3__fillcap_4
XFILLER_88_164 VDD VDD VSS VSS gf180mcu_as_sc_mcu7t3v3__fill_2
XTAP_TAPCELL_ROW_8_1_666 VDD VSS gf180mcu_as_sc_mcu7t3v3__tap_2
XTAP_TAPCELL_ROW_116_1_1101 VDD VSS gf180mcu_as_sc_mcu7t3v3__tap_2
XFILLER_177_2 VDD VDD VSS VSS gf180mcu_as_sc_mcu7t3v3__fillcap_16
XFILLER_160_1004 VDD VDD VSS VSS gf180mcu_as_sc_mcu7t3v3__fill_1
XTAP_TAPCELL_ROW_158_1737 VDD VSS gf180mcu_as_sc_mcu7t3v3__tap_2
XTAP_TAPCELL_ROW_158_1726 VDD VSS gf180mcu_as_sc_mcu7t3v3__tap_2
XFILLER_142_1460 VDD VDD VSS VSS gf180mcu_as_sc_mcu7t3v3__fill_1
XFILLER_157_158 VDD VDD VSS VSS gf180mcu_as_sc_mcu7t3v3__fillcap_16
XFILLER_160_1048 VDD VDD VSS VSS gf180mcu_as_sc_mcu7t3v3__fillcap_8
XFILLER_139_895 VDD VDD VSS VSS gf180mcu_as_sc_mcu7t3v3__fill_1
XFILLER_173_629 VDD VDD VSS VSS gf180mcu_as_sc_mcu7t3v3__fill_1
XFILLER_172_139 VDD VDD VSS VSS gf180mcu_as_sc_mcu7t3v3__fillcap_16
XFILLER_103_1499 VDD VDD VSS VSS gf180mcu_as_sc_mcu7t3v3__fillcap_16
XFILLER_138_1507 VDD VDD VSS VSS gf180mcu_as_sc_mcu7t3v3__fillcap_8
XFILLER_113_228 VDD VDD VSS VSS gf180mcu_as_sc_mcu7t3v3__fillcap_16
XFILLER_141_515 VDD VDD VSS VSS gf180mcu_as_sc_mcu7t3v3__fillcap_4
XFILLER_171_1122 VDD VDD VSS VSS gf180mcu_as_sc_mcu7t3v3__fill_2
XFILLER_79_142 VDD VDD VSS VSS gf180mcu_as_sc_mcu7t3v3__fillcap_8
XFILLER_121_272 VDD VDD VSS VSS gf180mcu_as_sc_mcu7t3v3__fillcap_8
XFILLER_136_1297 VDD VDD VSS VSS gf180mcu_as_sc_mcu7t3v3__fillcap_16
XFILLER_171_1177 VDD VDD VSS VSS gf180mcu_as_sc_mcu7t3v3__fill_1
XFILLER_94_134 VDD VDD VSS VSS gf180mcu_as_sc_mcu7t3v3__fillcap_8
X_3060_ VDD VDD VSS VSS _4039_/A _3127_/B _3127_/C _4040_/D _3061_/C gf180mcu_as_sc_mcu7t3v3__ao22_2
XFILLER_23_1467 VDD VDD VSS VSS gf180mcu_as_sc_mcu7t3v3__fillcap_16
XFILLER_62_1483 VDD VDD VSS VSS gf180mcu_as_sc_mcu7t3v3__fill_1
XFILLER_35_212 VDD VDD VSS VSS gf180mcu_as_sc_mcu7t3v3__fillcap_16
XFILLER_169_1084 VDD VDD VSS VSS gf180mcu_as_sc_mcu7t3v3__fill_2
XFILLER_50_204 VDD VDD VSS VSS gf180mcu_as_sc_mcu7t3v3__fillcap_4
XFILLER_92_2 VDD VDD VSS VSS gf180mcu_as_sc_mcu7t3v3__fillcap_16
X_3962_ VDD VDD VSS VSS _3962_/A _4110_/C _3962_/C _3962_/D _3963_/B gf180mcu_as_sc_mcu7t3v3__ao22_2
XFILLER_147_1382 VDD VDD VSS VSS gf180mcu_as_sc_mcu7t3v3__fillcap_4
XFILLER_177_946 VDD VDD VSS VSS gf180mcu_as_sc_mcu7t3v3__fill_2
X_3893_ VDD VDD VSS VSS _3897_/B _5183_/Q _4933_/D gf180mcu_as_sc_mcu7t3v3__and2_2
X_2913_ VDD VDD VSS VSS _3788_/D _3796_/D _3544_/C gf180mcu_as_sc_mcu7t3v3__or2_2
XFILLER_149_648 VDD VDD VSS VSS gf180mcu_as_sc_mcu7t3v3__fillcap_4
X_2844_ VDD VDD VSS VSS _4746_/A _4746_/B _2844_/C _4746_/D _2856_/A gf180mcu_as_sc_mcu7t3v3__ao211_2
XFILLER_176_489 VDD VDD VSS VSS gf180mcu_as_sc_mcu7t3v3__fill_2
X_4514_ VDD VDD VSS VSS _5181_/Q _4566_/B _4590_/C _5115_/Q _4515_/B gf180mcu_as_sc_mcu7t3v3__ao22_2
X_2775_ VDD VDD VSS VSS _5232_/Q _5231_/Q _5229_/Q _2776_/B gf180mcu_as_sc_mcu7t3v3__nor3_2
XFILLER_144_342 VDD VDD VSS VSS gf180mcu_as_sc_mcu7t3v3__fillcap_16
XFILLER_7_190 VDD VDD VSS VSS gf180mcu_as_sc_mcu7t3v3__fillcap_16
XFILLER_104_228 VDD VDD VSS VSS gf180mcu_as_sc_mcu7t3v3__fill_1
XFILLER_176_1055 VDD VDD VSS VSS gf180mcu_as_sc_mcu7t3v3__fill_1
X_4445_ VDD VDD VSS VSS _4449_/B _5072_/Q _4447_/S gf180mcu_as_sc_mcu7t3v3__nand2_2
XTAP_TAPCELL_ROW_122_1_1122 VDD VSS gf180mcu_as_sc_mcu7t3v3__tap_2
XFILLER_119_1451 VDD VDD VSS VSS gf180mcu_as_sc_mcu7t3v3__fillcap_16
XFILLER_144_18 VDD VDD VSS VSS gf180mcu_as_sc_mcu7t3v3__fillcap_16
XPHY_EDGE_ROW_27_1_Right_26 VDD VSS gf180mcu_as_sc_mcu7t3v3__tap_2
Xfanout604 VDD VDD VSS VSS _3741_/B _3716_/B gf180mcu_as_sc_mcu7t3v3__buff_2
Xfanout615 VDD VDD VSS VSS fanout617/Y _3452_/S gf180mcu_as_sc_mcu7t3v3__buff_2
X_4376_ VDD VDD VSS VSS _4379_/B _4376_/B _5163_/Q _5163_/D gf180mcu_as_sc_mcu7t3v3__mux2_2
XFILLER_140_570 VDD VDD VSS VSS gf180mcu_as_sc_mcu7t3v3__fillcap_4
XFILLER_154_1364 VDD VDD VSS VSS gf180mcu_as_sc_mcu7t3v3__fill_1
Xfanout626 VDD VDD VSS VSS _2947_/Y _3147_/B gf180mcu_as_sc_mcu7t3v3__buff_2
Xfanout637 VDD VDD VSS VSS _4607_/C _4612_/C gf180mcu_as_sc_mcu7t3v3__buff_2
Xfanout648 VDD VDD VSS VSS fanout651/Y _4130_/B gf180mcu_as_sc_mcu7t3v3__buff_2
X_3327_ VDD VDD VSS VSS _3608_/A _3470_/B _3327_/C _4810_/D _3661_/D gf180mcu_as_sc_mcu7t3v3__aoi211_2
XTAP_TAPCELL_ROW_14_1_693 VDD VSS gf180mcu_as_sc_mcu7t3v3__tap_2
XFILLER_80_1550 VDD VDD VSS VSS gf180mcu_as_sc_mcu7t3v3__fillcap_4
XFILLER_85_134 VDD VDD VSS VSS gf180mcu_as_sc_mcu7t3v3__fillcap_4
Xfanout659 VDD VDD VSS VSS fanout660/Y _3466_/B gf180mcu_as_sc_mcu7t3v3__buff_2
XTAP_TAPCELL_ROW_81_1_959 VDD VSS gf180mcu_as_sc_mcu7t3v3__tap_2
X_3258_ VDD VDD VSS VSS _3263_/A _3271_/A _3271_/B gf180mcu_as_sc_mcu7t3v3__nor2b_2
XTAP_TAPCELL_ROW_4_1_650 VDD VSS gf180mcu_as_sc_mcu7t3v3__tap_2
XTAP_TAPCELL_ROW_181_2244 VDD VSS gf180mcu_as_sc_mcu7t3v3__tap_2
XTAP_TAPCELL_ROW_181_2233 VDD VSS gf180mcu_as_sc_mcu7t3v3__tap_2
XTAP_TAPCELL_ROW_102_1_1042 VDD VSS gf180mcu_as_sc_mcu7t3v3__tap_2
X_3189_ VDD VDD VSS VSS _3239_/A _3216_/C _3238_/C gf180mcu_as_sc_mcu7t3v3__or2_2
XFILLER_148_1157 VDD VDD VSS VSS gf180mcu_as_sc_mcu7t3v3__fillcap_8
XFILLER_41_204 VDD VDD VSS VSS gf180mcu_as_sc_mcu7t3v3__fillcap_4
XFILLER_53_26 VDD VDD VSS VSS gf180mcu_as_sc_mcu7t3v3__fillcap_8
XTAP_TAPCELL_ROW_179_2184 VDD VSS gf180mcu_as_sc_mcu7t3v3__tap_2
XFILLER_161_1313 VDD VDD VSS VSS gf180mcu_as_sc_mcu7t3v3__fillcap_8
XTAP_TAPCELL_ROW_179_2195 VDD VSS gf180mcu_as_sc_mcu7t3v3__tap_2
XPHY_EDGE_ROW_112_1_Left_564 VDD VSS gf180mcu_as_sc_mcu7t3v3__tap_2
XFILLER_135_320 VDD VDD VSS VSS gf180mcu_as_sc_mcu7t3v3__fill_1
XFILLER_154_139 VDD VDD VSS VSS gf180mcu_as_sc_mcu7t3v3__fillcap_16
XTAP_TAPCELL_ROW_153_1623 VDD VSS gf180mcu_as_sc_mcu7t3v3__tap_2
XTAP_TAPCELL_ROW_153_1612 VDD VSS gf180mcu_as_sc_mcu7t3v3__tap_2
XFILLER_135_364 VDD VDD VSS VSS gf180mcu_as_sc_mcu7t3v3__fill_2
XFILLER_151_835 VDD VDD VSS VSS gf180mcu_as_sc_mcu7t3v3__fillcap_4
XFILLER_150_356 VDD VDD VSS VSS gf180mcu_as_sc_mcu7t3v3__fill_2
XFILLER_78_34 VDD VDD VSS VSS gf180mcu_as_sc_mcu7t3v3__fill_1
XFILLER_85_1483 VDD VDD VSS VSS gf180mcu_as_sc_mcu7t3v3__fillcap_16
XTAP_TAPCELL_ROW_170_1992 VDD VSS gf180mcu_as_sc_mcu7t3v3__tap_2
XFILLER_150_378 VDD VDD VSS VSS gf180mcu_as_sc_mcu7t3v3__fillcap_4
XFILLER_46_1467 VDD VDD VSS VSS gf180mcu_as_sc_mcu7t3v3__fillcap_16
XFILLER_134_40 VDD VDD VSS VSS gf180mcu_as_sc_mcu7t3v3__fill_1
XFILLER_76_134 VDD VDD VSS VSS gf180mcu_as_sc_mcu7t3v3__fillcap_8
XFILLER_76_167 VDD VDD VSS VSS gf180mcu_as_sc_mcu7t3v3__fill_1
XPHY_EDGE_ROW_2_3_Left_136 VDD VSS gf180mcu_as_sc_mcu7t3v3__tap_2
XFILLER_17_212 VDD VDD VSS VSS gf180mcu_as_sc_mcu7t3v3__fillcap_16
XFILLER_91_104 VDD VDD VSS VSS gf180mcu_as_sc_mcu7t3v3__fillcap_4
XFILLER_2_1550 VDD VDD VSS VSS gf180mcu_as_sc_mcu7t3v3__fillcap_4
XFILLER_91_137 VDD VDD VSS VSS gf180mcu_as_sc_mcu7t3v3__fill_2
XPHY_EDGE_ROW_73_1_Right_72 VDD VSS gf180mcu_as_sc_mcu7t3v3__tap_2
XTAP_TAPCELL_ROW_23_1_728 VDD VSS gf180mcu_as_sc_mcu7t3v3__tap_2
XFILLER_144_1511 VDD VDD VSS VSS gf180mcu_as_sc_mcu7t3v3__fill_2
XPHY_EDGE_ROW_44_1_Left_496 VDD VSS gf180mcu_as_sc_mcu7t3v3__tap_2
XFILLER_158_412 VDD VDD VSS VSS gf180mcu_as_sc_mcu7t3v3__fill_1
XFILLER_158_423 VDD VDD VSS VSS gf180mcu_as_sc_mcu7t3v3__fillcap_4
XFILLER_43_92 VDD VDD VSS VSS gf180mcu_as_sc_mcu7t3v3__fill_2
XFILLER_139_670 VDD VDD VSS VSS gf180mcu_as_sc_mcu7t3v3__fillcap_16
XFILLER_145_106 VDD VDD VSS VSS gf180mcu_as_sc_mcu7t3v3__fill_1
XFILLER_174_938 VDD VDD VSS VSS gf180mcu_as_sc_mcu7t3v3__fillcap_4
X_2560_ VDD VDD VSS VSS _2560_/Y _2831_/B _4952_/D gf180mcu_as_sc_mcu7t3v3__nor2b_2
XFILLER_142_824 VDD VDD VSS VSS gf180mcu_as_sc_mcu7t3v3__fillcap_16
XFILLER_173_1217 VDD VDD VSS VSS gf180mcu_as_sc_mcu7t3v3__fill_2
XFILLER_181_470 VDD VDD VSS VSS gf180mcu_as_sc_mcu7t3v3__fillcap_16
X_2491_ VDD VDD VSS VSS _4649_/A _5269_/Q _4371_/A gf180mcu_as_sc_mcu7t3v3__nor2b_2
XFILLER_181_492 VDD VDD VSS VSS gf180mcu_as_sc_mcu7t3v3__fill_2
XFILLER_4_171 VDD VDD VSS VSS gf180mcu_as_sc_mcu7t3v3__fillcap_4
XFILLER_4_193 VDD VDD VSS VSS gf180mcu_as_sc_mcu7t3v3__fillcap_16
X_4230_ VDD VDD VSS VSS _4257_/S _4230_/B _5066_/Q _5066_/D gf180mcu_as_sc_mcu7t3v3__mux2_2
XFILLER_101_209 VDD VDD VSS VSS gf180mcu_as_sc_mcu7t3v3__fill_1
XFILLER_4_53 VDD VDD VSS VSS gf180mcu_as_sc_mcu7t3v3__fillcap_16
XFILLER_64_1534 VDD VDD VSS VSS gf180mcu_as_sc_mcu7t3v3__fillcap_16
XFILLER_64_1556 VDD VDD VSS VSS gf180mcu_as_sc_mcu7t3v3__fillcap_8
X_4161_ VDD VDD VSS VSS _4161_/A _4161_/B _4161_/C _4161_/D _4163_/C gf180mcu_as_sc_mcu7t3v3__ao211_2
XFILLER_136_1083 VDD VDD VSS VSS gf180mcu_as_sc_mcu7t3v3__fill_2
XFILLER_67_112 VDD VDD VSS VSS gf180mcu_as_sc_mcu7t3v3__fill_1
XPHY_EDGE_ROW_170_Right_304 VDD VSS gf180mcu_as_sc_mcu7t3v3__tap_2
X_4092_ VDD VDD VSS VSS _4997_/Q _4092_/B _4248_/B _4092_/D _4997_/D gf180mcu_as_sc_mcu7t3v3__ao22_2
X_3112_ VDD VDD VSS VSS _3120_/A _3112_/B _3112_/C _3120_/D _3113_/D gf180mcu_as_sc_mcu7t3v3__ao211_2
XFILLER_7_1483 VDD VDD VSS VSS gf180mcu_as_sc_mcu7t3v3__fillcap_16
XFILLER_82_104 VDD VDD VSS VSS gf180mcu_as_sc_mcu7t3v3__fill_1
X_3043_ VDD VDD VSS VSS _3118_/S _4021_/D _4024_/A _3045_/B gf180mcu_as_sc_mcu7t3v3__mux2_2
XFILLER_184_1324 VDD VDD VSS VSS gf180mcu_as_sc_mcu7t3v3__fill_2
XFILLER_149_1488 VDD VDD VSS VSS gf180mcu_as_sc_mcu7t3v3__fillcap_8
XFILLER_168_209 VDD VDD VSS VSS gf180mcu_as_sc_mcu7t3v3__fillcap_16
X_4994_ VDD VDD VSS VSS _5080_/CLK _4994_/D _4994_/Q gf180mcu_as_sc_mcu7t3v3__dfxtp_2
XFILLER_23_18 VDD VDD VSS VSS gf180mcu_as_sc_mcu7t3v3__fillcap_16
X_3945_ VDD VDD VSS VSS _4230_/B _3945_/B _4141_/D gf180mcu_as_sc_mcu7t3v3__nor2_2
XFILLER_139_18 VDD VDD VSS VSS gf180mcu_as_sc_mcu7t3v3__fillcap_16
X_3876_ VDD VDD VSS VSS _4946_/D _5166_/Q _4916_/D gf180mcu_as_sc_mcu7t3v3__and2_2
XTAP_TAPCELL_ROW_7_1_665 VDD VSS gf180mcu_as_sc_mcu7t3v3__tap_2
XFILLER_143_1098 VDD VDD VSS VSS gf180mcu_as_sc_mcu7t3v3__fillcap_16
XFILLER_178_1106 VDD VDD VSS VSS gf180mcu_as_sc_mcu7t3v3__fill_2
X_2827_ VDD VDD VSS VSS _4751_/A _2827_/B _5282_/Q _5281_/D gf180mcu_as_sc_mcu7t3v3__mux2_2
XTAP_TAPCELL_ROW_174_2092 VDD VSS gf180mcu_as_sc_mcu7t3v3__tap_2
XTAP_TAPCELL_ROW_174_2081 VDD VSS gf180mcu_as_sc_mcu7t3v3__tap_2
X_2758_ VDD VDD VSS VSS _4652_/B _5233_/Q _2806_/D _2809_/B _4634_/A gf180mcu_as_sc_mcu7t3v3__aoi211_2
XTAP_TAPCELL_ROW_12_3_2368 VDD VSS gf180mcu_as_sc_mcu7t3v3__tap_2
XFILLER_145_684 VDD VDD VSS VSS gf180mcu_as_sc_mcu7t3v3__fill_1
XFILLER_156_1415 VDD VDD VSS VSS gf180mcu_as_sc_mcu7t3v3__fillcap_16
XFILLER_173_982 VDD VDD VSS VSS gf180mcu_as_sc_mcu7t3v3__fill_2
XFILLER_69_1467 VDD VDD VSS VSS gf180mcu_as_sc_mcu7t3v3__fillcap_16
XFILLER_156_1448 VDD VDD VSS VSS gf180mcu_as_sc_mcu7t3v3__fillcap_8
X_4428_ VDD VDD VSS VSS _4431_/C _4983_/Q _4552_/A gf180mcu_as_sc_mcu7t3v3__nand2b_2
X_2689_ VDD VDD VSS VSS _5158_/Q _4269_/S _4278_/S _5182_/Q _2690_/C gf180mcu_as_sc_mcu7t3v3__ao22_2
XFILLER_150_1014 VDD VDD VSS VSS gf180mcu_as_sc_mcu7t3v3__fill_1
XFILLER_48_37 VDD VDD VSS VSS gf180mcu_as_sc_mcu7t3v3__fillcap_4
X_4359_ VDD VDD VSS VSS _4364_/B _4364_/A _4360_/A gf180mcu_as_sc_mcu7t3v3__xnor2_2
XFILLER_104_10 VDD VDD VSS VSS gf180mcu_as_sc_mcu7t3v3__fillcap_4
XFILLER_150_1025 VDD VDD VSS VSS gf180mcu_as_sc_mcu7t3v3__fillcap_4
Xfanout467 VDD VDD VSS VSS _4221_/C _4228_/C gf180mcu_as_sc_mcu7t3v3__buff_2
Xfanout489 VDD VDD VSS VSS _4198_/Y _4223_/B gf180mcu_as_sc_mcu7t3v3__buff_2
XFILLER_100_286 VDD VDD VSS VSS gf180mcu_as_sc_mcu7t3v3__fillcap_8
Xmesh_tile_871 VDD VDD VSS VSS north_out[12] gf180mcu_as_sc_mcu7t3v3__tiel_4
Xmesh_tile_860 VDD VDD VSS VSS north_out[1] gf180mcu_as_sc_mcu7t3v3__tiel_4
XTAP_TAPCELL_ROW_63_1_888 VDD VSS gf180mcu_as_sc_mcu7t3v3__tap_2
XPHY_EDGE_ROW_6_1_Right_5 VDD VSS gf180mcu_as_sc_mcu7t3v3__tap_2
Xmesh_tile_893 VDD VDD VSS VSS nw_out[0] gf180mcu_as_sc_mcu7t3v3__tiel_4
Xmesh_tile_882 VDD VDD VSS VSS north_out[23] gf180mcu_as_sc_mcu7t3v3__tiel_4
XTAP_TAPCELL_ROW_146_1471 VDD VSS gf180mcu_as_sc_mcu7t3v3__tap_2
XTAP_TAPCELL_ROW_146_1460 VDD VSS gf180mcu_as_sc_mcu7t3v3__tap_2
XTAP_TAPCELL_ROW_133_1_1169 VDD VSS gf180mcu_as_sc_mcu7t3v3__tap_2
XPHY_EDGE_ROW_177_Left_629 VDD VSS gf180mcu_as_sc_mcu7t3v3__tap_2
XFILLER_167_1566 VDD VDD VSS VSS gf180mcu_as_sc_mcu7t3v3__fill_2
XTAP_TAPCELL_ROW_99_1_1031 VDD VSS gf180mcu_as_sc_mcu7t3v3__tap_2
XTAP_TAPCELL_ROW_142_1379 VDD VSS gf180mcu_as_sc_mcu7t3v3__tap_2
XTAP_TAPCELL_ROW_113_1_1089 VDD VSS gf180mcu_as_sc_mcu7t3v3__tap_2
XFILLER_127_106 VDD VDD VSS VSS gf180mcu_as_sc_mcu7t3v3__fill_1
XFILLER_156_938 VDD VDD VSS VSS gf180mcu_as_sc_mcu7t3v3__fillcap_4
XFILLER_168_765 VDD VDD VSS VSS gf180mcu_as_sc_mcu7t3v3__fill_1
XFILLER_183_702 VDD VDD VSS VSS gf180mcu_as_sc_mcu7t3v3__fill_1
XFILLER_104_1550 VDD VDD VSS VSS gf180mcu_as_sc_mcu7t3v3__fillcap_4
XPHY_EDGE_ROW_105_3_Left_239 VDD VSS gf180mcu_as_sc_mcu7t3v3__tap_2
XFILLER_13_1499 VDD VDD VSS VSS gf180mcu_as_sc_mcu7t3v3__fillcap_16
XFILLER_174_1504 VDD VDD VSS VSS gf180mcu_as_sc_mcu7t3v3__fill_1
XFILLER_48_1518 VDD VDD VSS VSS gf180mcu_as_sc_mcu7t3v3__fillcap_16
XFILLER_163_492 VDD VDD VSS VSS gf180mcu_as_sc_mcu7t3v3__fillcap_16
XFILLER_89_88 VDD VDD VSS VSS gf180mcu_as_sc_mcu7t3v3__fillcap_4
XFILLER_145_72 VDD VDD VSS VSS gf180mcu_as_sc_mcu7t3v3__fillcap_16
XFILLER_96_218 VDD VDD VSS VSS gf180mcu_as_sc_mcu7t3v3__fillcap_4
XFILLER_1_174 VDD VDD VSS VSS gf180mcu_as_sc_mcu7t3v3__fillcap_16
XFILLER_172_1294 VDD VDD VSS VSS gf180mcu_as_sc_mcu7t3v3__fill_1
XFILLER_49_134 VDD VDD VSS VSS gf180mcu_as_sc_mcu7t3v3__fillcap_4
XFILLER_111_1521 VDD VDD VSS VSS gf180mcu_as_sc_mcu7t3v3__fillcap_16
XFILLER_166_1010 VDD VDD VSS VSS gf180mcu_as_sc_mcu7t3v3__fillcap_4
XPHY_EDGE_ROW_10_3_Right_329 VDD VSS gf180mcu_as_sc_mcu7t3v3__tap_2
XFILLER_159_710 VDD VDD VSS VSS gf180mcu_as_sc_mcu7t3v3__fill_1
XFILLER_166_1087 VDD VDD VSS VSS gf180mcu_as_sc_mcu7t3v3__fillcap_16
XFILLER_54_80 VDD VDD VSS VSS gf180mcu_as_sc_mcu7t3v3__fillcap_16
X_3730_ VDD VDD VSS VSS _3730_/D _3730_/A _3730_/B _3730_/C _3731_/C gf180mcu_as_sc_mcu7t3v3__ao31_2
XFILLER_109_1483 VDD VDD VSS VSS gf180mcu_as_sc_mcu7t3v3__fillcap_16
XFILLER_140_1227 VDD VDD VSS VSS gf180mcu_as_sc_mcu7t3v3__fill_2
XFILLER_147_916 VDD VDD VSS VSS gf180mcu_as_sc_mcu7t3v3__fillcap_8
XFILLER_147_938 VDD VDD VSS VSS gf180mcu_as_sc_mcu7t3v3__fillcap_8
XFILLER_173_212 VDD VDD VSS VSS gf180mcu_as_sc_mcu7t3v3__fillcap_16
X_3661_ VDD VDD VSS VSS _3661_/A _3723_/B _3661_/C _4851_/D _3661_/D gf180mcu_as_sc_mcu7t3v3__aoi211_2
XFILLER_155_960 VDD VDD VSS VSS gf180mcu_as_sc_mcu7t3v3__fill_2
Xclkload11 VDD VDD VSS VSS clkload11/Y _4914_/CLK gf180mcu_as_sc_mcu7t3v3__inv_6
Xclkload22 VDD VDD VSS VSS clkload22/Y _5081_/CLK gf180mcu_as_sc_mcu7t3v3__inv_6
X_3592_ VDD VDD VSS VSS _3956_/D _3742_/B _3592_/C _3592_/D _3593_/D gf180mcu_as_sc_mcu7t3v3__ao211_2
X_2612_ VDD VDD VSS VSS _2621_/B _5230_/Q _5232_/Q gf180mcu_as_sc_mcu7t3v3__nor2b_2
XFILLER_142_621 VDD VDD VSS VSS gf180mcu_as_sc_mcu7t3v3__fillcap_4
XFILLER_155_982 VDD VDD VSS VSS gf180mcu_as_sc_mcu7t3v3__fillcap_16
XFILLER_161_418 VDD VDD VSS VSS gf180mcu_as_sc_mcu7t3v3__fill_2
X_2543_ VDD VDD VSS VSS _2798_/B _4328_/A _5125_/Q gf180mcu_as_sc_mcu7t3v3__nand2_2
XFILLER_141_142 VDD VDD VSS VSS gf180mcu_as_sc_mcu7t3v3__fill_2
XFILLER_29_1451 VDD VDD VSS VSS gf180mcu_as_sc_mcu7t3v3__fillcap_16
X_5262_ VDD VDD VSS VSS _5266_/CLK _5262_/D _5262_/Q gf180mcu_as_sc_mcu7t3v3__dfxtp_2
X_2474_ VDD VDD VSS VSS _2474_/A _4350_/D _2474_/C _2589_/A gf180mcu_as_sc_mcu7t3v3__nor3_2
XPHY_EDGE_ROW_99_3_Left_233 VDD VSS gf180mcu_as_sc_mcu7t3v3__tap_2
X_5193_ VDD VDD VSS VSS clkload2/A _5193_/D _5193_/Q gf180mcu_as_sc_mcu7t3v3__dfxtp_2
X_4213_ VDD VDD VSS VSS _4242_/B _4219_/B _4219_/C _5049_/Q _5049_/D gf180mcu_as_sc_mcu7t3v3__ao22_2
X_4144_ VDD VDD VSS VSS _4144_/A _4160_/C _4152_/C _4941_/Q _4145_/D gf180mcu_as_sc_mcu7t3v3__ao22_2
XFILLER_18_18 VDD VDD VSS VSS gf180mcu_as_sc_mcu7t3v3__fillcap_16
X_4075_ VDD VDD VSS VSS _4075_/A _4099_/B _4075_/C _4246_/B _4091_/D gf180mcu_as_sc_mcu7t3v3__aoi211_2
XFILLER_184_1121 VDD VDD VSS VSS gf180mcu_as_sc_mcu7t3v3__fill_1
XFILLER_70_107 VDD VDD VSS VSS gf180mcu_as_sc_mcu7t3v3__fillcap_8
X_3026_ VDD VDD VSS VSS _4005_/A _3152_/B _3152_/C _4007_/A _3027_/C gf180mcu_as_sc_mcu7t3v3__ao22_2
XFILLER_145_1149 VDD VDD VSS VSS gf180mcu_as_sc_mcu7t3v3__fillcap_16
XFILLER_184_1187 VDD VDD VSS VSS gf180mcu_as_sc_mcu7t3v3__fill_2
XTAP_TAPCELL_ROW_176_2121 VDD VSS gf180mcu_as_sc_mcu7t3v3__tap_2
X_4977_ VDD VDD VSS VSS _5074_/CLK _4977_/D _4977_/Q gf180mcu_as_sc_mcu7t3v3__dfxtp_2
XTAP_TAPCELL_ROW_176_2132 VDD VSS gf180mcu_as_sc_mcu7t3v3__tap_2
XFILLER_165_702 VDD VDD VSS VSS gf180mcu_as_sc_mcu7t3v3__fillcap_8
XFILLER_177_562 VDD VDD VSS VSS gf180mcu_as_sc_mcu7t3v3__fillcap_8
Xclkload5 VDD VDD VSS VSS clkload5/A clkload5/Y gf180mcu_as_sc_mcu7t3v3__clkbuff_12
X_3928_ VDD VDD VSS VSS _3928_/Y _3932_/D _3928_/A gf180mcu_as_sc_mcu7t3v3__nor2_2
XFILLER_138_938 VDD VDD VSS VSS gf180mcu_as_sc_mcu7t3v3__fillcap_4
X_3859_ VDD VDD VSS VSS _3862_/A _3873_/A gf180mcu_as_sc_mcu7t3v3__inv_2
XFILLER_109_139 VDD VDD VSS VSS gf180mcu_as_sc_mcu7t3v3__fill_1
XFILLER_117_161 VDD VDD VSS VSS gf180mcu_as_sc_mcu7t3v3__fill_1
XFILLER_152_418 VDD VDD VSS VSS gf180mcu_as_sc_mcu7t3v3__fillcap_8
XFILLER_145_492 VDD VDD VSS VSS gf180mcu_as_sc_mcu7t3v3__fillcap_16
XFILLER_156_1223 VDD VDD VSS VSS gf180mcu_as_sc_mcu7t3v3__fill_2
XFILLER_173_790 VDD VDD VSS VSS gf180mcu_as_sc_mcu7t3v3__fill_1
XFILLER_160_473 VDD VDD VSS VSS gf180mcu_as_sc_mcu7t3v3__fill_2
XFILLER_59_36 VDD VDD VSS VSS gf180mcu_as_sc_mcu7t3v3__fill_2
XTAP_TAPCELL_ROW_118_3_2527 VDD VSS gf180mcu_as_sc_mcu7t3v3__tap_2
XFILLER_134_1532 VDD VDD VSS VSS gf180mcu_as_sc_mcu7t3v3__fillcap_4
XFILLER_182_37 VDD VDD VSS VSS gf180mcu_as_sc_mcu7t3v3__fillcap_16
XFILLER_82_1486 VDD VDD VSS VSS gf180mcu_as_sc_mcu7t3v3__fillcap_16
XFILLER_86_240 VDD VDD VSS VSS gf180mcu_as_sc_mcu7t3v3__fillcap_4
XTAP_TAPCELL_ROW_148_1522 VDD VSS gf180mcu_as_sc_mcu7t3v3__tap_2
XTAP_TAPCELL_ROW_148_1511 VDD VSS gf180mcu_as_sc_mcu7t3v3__tap_2
XFILLER_75_35 VDD VDD VSS VSS gf180mcu_as_sc_mcu7t3v3__fill_2
XTAP_TAPCELL_ROW_165_1880 VDD VSS gf180mcu_as_sc_mcu7t3v3__tap_2
XTAP_TAPCELL_ROW_144_1419 VDD VSS gf180mcu_as_sc_mcu7t3v3__tap_2
XTAP_TAPCELL_ROW_165_1891 VDD VSS gf180mcu_as_sc_mcu7t3v3__tap_2
XTAP_TAPCELL_ROW_161_1788 VDD VSS gf180mcu_as_sc_mcu7t3v3__tap_2
XFILLER_167_1396 VDD VDD VSS VSS gf180mcu_as_sc_mcu7t3v3__fillcap_4
XTAP_TAPCELL_ROW_161_1799 VDD VSS gf180mcu_as_sc_mcu7t3v3__tap_2
XFILLER_180_1563 VDD VDD VSS VSS gf180mcu_as_sc_mcu7t3v3__fill_2
XFILLER_155_212 VDD VDD VSS VSS gf180mcu_as_sc_mcu7t3v3__fillcap_16
XFILLER_10_295 VDD VDD VSS VSS gf180mcu_as_sc_mcu7t3v3__fillcap_4
XFILLER_137_982 VDD VDD VSS VSS gf180mcu_as_sc_mcu7t3v3__fillcap_16
XFILLER_143_418 VDD VDD VSS VSS gf180mcu_as_sc_mcu7t3v3__fill_2
XFILLER_143_429 VDD VDD VSS VSS gf180mcu_as_sc_mcu7t3v3__fillcap_16
XFILLER_155_267 VDD VDD VSS VSS gf180mcu_as_sc_mcu7t3v3__fillcap_8
XFILLER_6_255 VDD VDD VSS VSS gf180mcu_as_sc_mcu7t3v3__fill_1
XFILLER_108_172 VDD VDD VSS VSS gf180mcu_as_sc_mcu7t3v3__fill_2
XFILLER_152_930 VDD VDD VSS VSS gf180mcu_as_sc_mcu7t3v3__fillcap_8
XFILLER_174_1323 VDD VDD VSS VSS gf180mcu_as_sc_mcu7t3v3__fill_1
XFILLER_178_1470 VDD VDD VSS VSS gf180mcu_as_sc_mcu7t3v3__fillcap_8
XFILLER_6_299 VDD VDD VSS VSS gf180mcu_as_sc_mcu7t3v3__fill_2
XFILLER_123_142 VDD VDD VSS VSS gf180mcu_as_sc_mcu7t3v3__fill_2
XFILLER_135_1318 VDD VDD VSS VSS gf180mcu_as_sc_mcu7t3v3__fillcap_8
XFILLER_152_996 VDD VDD VSS VSS gf180mcu_as_sc_mcu7t3v3__fillcap_4
XFILLER_174_1367 VDD VDD VSS VSS gf180mcu_as_sc_mcu7t3v3__fillcap_8
XFILLER_41_8 VDD VDD VSS VSS gf180mcu_as_sc_mcu7t3v3__fill_2
XFILLER_61_1515 VDD VDD VSS VSS gf180mcu_as_sc_mcu7t3v3__fillcap_4
XFILLER_61_1537 VDD VDD VSS VSS gf180mcu_as_sc_mcu7t3v3__fillcap_16
XFILLER_172_81 VDD VDD VSS VSS gf180mcu_as_sc_mcu7t3v3__fillcap_16
XFILLER_37_104 VDD VDD VSS VSS gf180mcu_as_sc_mcu7t3v3__fillcap_16
XFILLER_77_262 VDD VDD VSS VSS gf180mcu_as_sc_mcu7t3v3__fillcap_4
XFILLER_92_210 VDD VDD VSS VSS gf180mcu_as_sc_mcu7t3v3__fill_2
XFILLER_4_1486 VDD VDD VSS VSS gf180mcu_as_sc_mcu7t3v3__fillcap_16
XFILLER_146_1403 VDD VDD VSS VSS gf180mcu_as_sc_mcu7t3v3__fill_2
XFILLER_52_118 VDD VDD VSS VSS gf180mcu_as_sc_mcu7t3v3__fillcap_16
X_4900_ VDD VDD VSS VSS _4938_/CLK _4900_/D _4900_/Q gf180mcu_as_sc_mcu7t3v3__dfxtp_2
XFILLER_179_838 VDD VDD VSS VSS gf180mcu_as_sc_mcu7t3v3__fill_2
XFILLER_59_1499 VDD VDD VSS VSS gf180mcu_as_sc_mcu7t3v3__fillcap_16
X_4831_ VDD VDD VSS VSS _5046_/CLK _4831_/D _4831_/Q gf180mcu_as_sc_mcu7t3v3__dfxtp_2
XFILLER_181_1338 VDD VDD VSS VSS gf180mcu_as_sc_mcu7t3v3__fill_1
XPHY_EDGE_ROW_36_1_Right_35 VDD VSS gf180mcu_as_sc_mcu7t3v3__tap_2
XFILLER_147_702 VDD VDD VSS VSS gf180mcu_as_sc_mcu7t3v3__fill_2
XFILLER_159_562 VDD VDD VSS VSS gf180mcu_as_sc_mcu7t3v3__fillcap_16
X_4762_ VDD VDD VSS VSS _5199_/CLK _4762_/D _4762_/Q gf180mcu_as_sc_mcu7t3v3__dfxtp_2
XFILLER_140_1013 VDD VDD VSS VSS gf180mcu_as_sc_mcu7t3v3__fill_2
X_4693_ VDD VDD VSS VSS _4707_/S _5251_/Q _4693_/A _5251_/D gf180mcu_as_sc_mcu7t3v3__mux2_2
X_3713_ VDD VDD VSS VSS _3714_/C _3713_/C _3729_/B _4089_/A gf180mcu_as_sc_mcu7t3v3__aoi21_2
XFILLER_174_554 VDD VDD VSS VSS gf180mcu_as_sc_mcu7t3v3__fillcap_16
X_3644_ VDD VDD VSS VSS _3644_/D _4016_/D _3736_/B _3728_/C _3645_/C gf180mcu_as_sc_mcu7t3v3__ao31_2
XFILLER_134_407 VDD VDD VSS VSS gf180mcu_as_sc_mcu7t3v3__fill_1
X_3575_ VDD VDD VSS VSS _3942_/A _3779_/B _3778_/B _3941_/A _3576_/D gf180mcu_as_sc_mcu7t3v3__ao22_2
XFILLER_114_142 VDD VDD VSS VSS gf180mcu_as_sc_mcu7t3v3__fill_2
X_2526_ VDD VDD VSS VSS _4657_/B _5230_/Q _2632_/B gf180mcu_as_sc_mcu7t3v3__nor2b_2
XFILLER_153_1429 VDD VDD VSS VSS gf180mcu_as_sc_mcu7t3v3__fillcap_8
X_5245_ VDD VDD VSS VSS clkload6/A _5245_/D _5245_/Q gf180mcu_as_sc_mcu7t3v3__dfxtp_2
X_2457_ VDD VDD VSS VSS _3846_/B _4911_/Q _4912_/Q gf180mcu_as_sc_mcu7t3v3__nor2_2
XTAP_TAPCELL_ROW_4_3_2356 VDD VSS gf180mcu_as_sc_mcu7t3v3__tap_2
XPHY_EDGE_ROW_69_1_Left_521 VDD VSS gf180mcu_as_sc_mcu7t3v3__tap_2
XFILLER_152_18 VDD VDD VSS VSS gf180mcu_as_sc_mcu7t3v3__fillcap_16
XPHY_EDGE_ROW_121_1_Left_573 VDD VSS gf180mcu_as_sc_mcu7t3v3__tap_2
X_5176_ VDD VDD VSS VSS _5188_/CLK _5176_/D _5176_/Q gf180mcu_as_sc_mcu7t3v3__dfxtp_2
X_4127_ VDD VDD VSS VSS _4127_/A _4127_/B _4141_/B _4132_/C _4127_/D gf180mcu_as_sc_mcu7t3v3__aoi211_2
X_4058_ VDD VDD VSS VSS _4106_/S _4058_/B _4058_/A _4059_/B gf180mcu_as_sc_mcu7t3v3__mux2_2
XFILLER_83_298 VDD VDD VSS VSS gf180mcu_as_sc_mcu7t3v3__fill_2
X_3009_ VDD VDD VSS VSS _3990_/A _3233_/B _3236_/C _3989_/D _3010_/C gf180mcu_as_sc_mcu7t3v3__ao22_2
XTAP_TAPCELL_ROW_33_1_766 VDD VSS gf180mcu_as_sc_mcu7t3v3__tap_2
XFILLER_137_212 VDD VDD VSS VSS gf180mcu_as_sc_mcu7t3v3__fill_2
XFILLER_162_1293 VDD VDD VSS VSS gf180mcu_as_sc_mcu7t3v3__fill_2
XFILLER_138_768 VDD VDD VSS VSS gf180mcu_as_sc_mcu7t3v3__fillcap_16
XFILLER_14_1550 VDD VDD VSS VSS gf180mcu_as_sc_mcu7t3v3__fillcap_4
XFILLER_137_267 VDD VDD VSS VSS gf180mcu_as_sc_mcu7t3v3__fill_1
XFILLER_158_1329 VDD VDD VSS VSS gf180mcu_as_sc_mcu7t3v3__fillcap_16
XFILLER_180_524 VDD VDD VSS VSS gf180mcu_as_sc_mcu7t3v3__fill_1
XTAP_TAPCELL_ROW_137_1278 VDD VSS gf180mcu_as_sc_mcu7t3v3__tap_2
XTAP_TAPCELL_ROW_137_1267 VDD VSS gf180mcu_as_sc_mcu7t3v3__tap_2
XFILLER_101_1553 VDD VDD VSS VSS gf180mcu_as_sc_mcu7t3v3__fillcap_16
XFILLER_3_214 VDD VDD VSS VSS gf180mcu_as_sc_mcu7t3v3__fill_1
XFILLER_3_225 VDD VDD VSS VSS gf180mcu_as_sc_mcu7t3v3__fillcap_8
XFILLER_105_142 VDD VDD VSS VSS gf180mcu_as_sc_mcu7t3v3__fill_2
XTAP_TAPCELL_ROW_121_1_1118 VDD VSS gf180mcu_as_sc_mcu7t3v3__tap_2
XPHY_EDGE_ROW_82_1_Right_81 VDD VSS gf180mcu_as_sc_mcu7t3v3__tap_2
XFILLER_10_85 VDD VDD VSS VSS gf180mcu_as_sc_mcu7t3v3__fillcap_16
XFILLER_126_52 VDD VDD VSS VSS gf180mcu_as_sc_mcu7t3v3__fill_1
XFILLER_134_996 VDD VDD VSS VSS gf180mcu_as_sc_mcu7t3v3__fillcap_4
XFILLER_120_134 VDD VDD VSS VSS gf180mcu_as_sc_mcu7t3v3__fillcap_16
XFILLER_126_96 VDD VDD VSS VSS gf180mcu_as_sc_mcu7t3v3__fill_2
XFILLER_86_34 VDD VDD VSS VSS gf180mcu_as_sc_mcu7t3v3__fill_1
Xoutput390 VDD VDD VSS VSS _4778_/Q se_out[7] gf180mcu_as_sc_mcu7t3v3__buff_2
XTAP_TAPCELL_ROW_167_1931 VDD VSS gf180mcu_as_sc_mcu7t3v3__tap_2
XTAP_TAPCELL_ROW_167_1920 VDD VSS gf180mcu_as_sc_mcu7t3v3__tap_2
XFILLER_134_1362 VDD VDD VSS VSS gf180mcu_as_sc_mcu7t3v3__fillcap_16
XFILLER_19_104 VDD VDD VSS VSS gf180mcu_as_sc_mcu7t3v3__fillcap_16
XFILLER_59_251 VDD VDD VSS VSS gf180mcu_as_sc_mcu7t3v3__fill_1
XFILLER_59_273 VDD VDD VSS VSS gf180mcu_as_sc_mcu7t3v3__fillcap_4
XFILLER_86_67 VDD VDD VSS VSS gf180mcu_as_sc_mcu7t3v3__fill_1
XFILLER_86_78 VDD VDD VSS VSS gf180mcu_as_sc_mcu7t3v3__fillcap_16
XFILLER_169_1425 VDD VDD VSS VSS gf180mcu_as_sc_mcu7t3v3__fillcap_4
XFILLER_19_50 VDD VDD VSS VSS gf180mcu_as_sc_mcu7t3v3__fillcap_16
XFILLER_19_72 VDD VDD VSS VSS gf180mcu_as_sc_mcu7t3v3__fillcap_16
XFILLER_21_1521 VDD VDD VSS VSS gf180mcu_as_sc_mcu7t3v3__fillcap_16
XTAP_TAPCELL_ROW_163_1839 VDD VSS gf180mcu_as_sc_mcu7t3v3__tap_2
XTAP_TAPCELL_ROW_101_1_1038 VDD VSS gf180mcu_as_sc_mcu7t3v3__tap_2
XFILLER_169_1458 VDD VDD VSS VSS gf180mcu_as_sc_mcu7t3v3__fill_1
XFILLER_74_243 VDD VDD VSS VSS gf180mcu_as_sc_mcu7t3v3__fill_2
XFILLER_34_107 VDD VDD VSS VSS gf180mcu_as_sc_mcu7t3v3__fillcap_16
XFILLER_163_1002 VDD VDD VSS VSS gf180mcu_as_sc_mcu7t3v3__fill_2
XFILLER_167_1160 VDD VDD VSS VSS gf180mcu_as_sc_mcu7t3v3__fill_2
XFILLER_163_1068 VDD VDD VSS VSS gf180mcu_as_sc_mcu7t3v3__fillcap_8
XFILLER_128_212 VDD VDD VSS VSS gf180mcu_as_sc_mcu7t3v3__fill_1
XFILLER_168_381 VDD VDD VSS VSS gf180mcu_as_sc_mcu7t3v3__fillcap_4
XFILLER_184_830 VDD VDD VSS VSS gf180mcu_as_sc_mcu7t3v3__fillcap_8
XFILLER_19_1483 VDD VDD VSS VSS gf180mcu_as_sc_mcu7t3v3__fillcap_16
XFILLER_106_1486 VDD VDD VSS VSS gf180mcu_as_sc_mcu7t3v3__fillcap_16
XFILLER_141_1366 VDD VDD VSS VSS gf180mcu_as_sc_mcu7t3v3__fillcap_8
XFILLER_156_554 VDD VDD VSS VSS gf180mcu_as_sc_mcu7t3v3__fill_1
XFILLER_184_852 VDD VDD VSS VSS gf180mcu_as_sc_mcu7t3v3__fillcap_4
XFILLER_128_267 VDD VDD VSS VSS gf180mcu_as_sc_mcu7t3v3__fill_1
XFILLER_141_1399 VDD VDD VSS VSS gf180mcu_as_sc_mcu7t3v3__fill_1
XFILLER_176_1407 VDD VDD VSS VSS gf180mcu_as_sc_mcu7t3v3__fill_2
Xwire462 VDD VDD VSS VSS _2641_/Y wire462/Y gf180mcu_as_sc_mcu7t3v3__buff_8
XFILLER_143_248 VDD VDD VSS VSS gf180mcu_as_sc_mcu7t3v3__fillcap_8
XFILLER_183_384 VDD VDD VSS VSS gf180mcu_as_sc_mcu7t3v3__fillcap_16
XTAP_TAPCELL_ROW_50_1_836 VDD VSS gf180mcu_as_sc_mcu7t3v3__tap_2
XFILLER_139_1262 VDD VDD VSS VSS gf180mcu_as_sc_mcu7t3v3__fillcap_8
X_3360_ VDD VDD VSS VSS _3639_/A _3424_/B _3360_/C _4814_/D _3691_/D gf180mcu_as_sc_mcu7t3v3__aoi211_2
XFILLER_140_922 VDD VDD VSS VSS gf180mcu_as_sc_mcu7t3v3__fill_2
XFILLER_140_944 VDD VDD VSS VSS gf180mcu_as_sc_mcu7t3v3__fill_1
XFILLER_111_134 VDD VDD VSS VSS gf180mcu_as_sc_mcu7t3v3__fillcap_4
XFILLER_170_1017 VDD VDD VSS VSS gf180mcu_as_sc_mcu7t3v3__fillcap_16
XFILLER_183_80 VDD VDD VSS VSS gf180mcu_as_sc_mcu7t3v3__fillcap_8
X_5030_ VDD VDD VSS VSS _5088_/CLK _5030_/D _5030_/Q gf180mcu_as_sc_mcu7t3v3__dfxtp_2
X_3291_ VDD VDD VSS VSS _4916_/Q _3493_/B _3501_/B _3940_/A _3292_/D gf180mcu_as_sc_mcu7t3v3__ao22_2
XFILLER_152_1484 VDD VDD VSS VSS gf180mcu_as_sc_mcu7t3v3__fill_1
XFILLER_18_2 VDD VDD VSS VSS gf180mcu_as_sc_mcu7t3v3__fillcap_16
XFILLER_148_1509 VDD VDD VSS VSS gf180mcu_as_sc_mcu7t3v3__fill_1
XFILLER_65_298 VDD VDD VSS VSS gf180mcu_as_sc_mcu7t3v3__fill_2
XFILLER_179_602 VDD VDD VSS VSS gf180mcu_as_sc_mcu7t3v3__fillcap_8
XFILLER_179_624 VDD VDD VSS VSS gf180mcu_as_sc_mcu7t3v3__fillcap_4
XFILLER_178_101 VDD VDD VSS VSS gf180mcu_as_sc_mcu7t3v3__fillcap_4
XFILLER_178_123 VDD VDD VSS VSS gf180mcu_as_sc_mcu7t3v3__fillcap_16
XFILLER_142_1119 VDD VDD VSS VSS gf180mcu_as_sc_mcu7t3v3__fillcap_16
XFILLER_181_1157 VDD VDD VSS VSS gf180mcu_as_sc_mcu7t3v3__fillcap_4
X_4814_ VDD VDD VSS VSS _4863_/CLK _4814_/D _4814_/Q gf180mcu_as_sc_mcu7t3v3__dfxtp_2
XFILLER_119_212 VDD VDD VSS VSS gf180mcu_as_sc_mcu7t3v3__fill_2
XFILLER_175_830 VDD VDD VSS VSS gf180mcu_as_sc_mcu7t3v3__fillcap_8
X_4745_ VDD VDD VSS VSS _4745_/B _5274_/Q _5275_/D gf180mcu_as_sc_mcu7t3v3__and2_2
XFILLER_31_18 VDD VDD VSS VSS gf180mcu_as_sc_mcu7t3v3__fillcap_16
XFILLER_135_738 VDD VDD VSS VSS gf180mcu_as_sc_mcu7t3v3__fillcap_8
XFILLER_179_1042 VDD VDD VSS VSS gf180mcu_as_sc_mcu7t3v3__fillcap_8
X_4676_ VDD VDD VSS VSS _5245_/D _4676_/A _4688_/B _4676_/C gf180mcu_as_sc_mcu7t3v3__ao21_2
XFILLER_134_237 VDD VDD VSS VSS gf180mcu_as_sc_mcu7t3v3__fill_1
XFILLER_179_1086 VDD VDD VSS VSS gf180mcu_as_sc_mcu7t3v3__fill_1
X_3627_ VDD VDD VSS VSS _3997_/D _3717_/B _3627_/C _3627_/D _3628_/C gf180mcu_as_sc_mcu7t3v3__ao211_2
XFILLER_134_248 VDD VDD VSS VSS gf180mcu_as_sc_mcu7t3v3__fillcap_4
XFILLER_143_760 VDD VDD VSS VSS gf180mcu_as_sc_mcu7t3v3__fill_2
XFILLER_150_708 VDD VDD VSS VSS gf180mcu_as_sc_mcu7t3v3__fillcap_4
X_3558_ VDD VDD VSS VSS _3805_/B _3558_/B _3817_/C gf180mcu_as_sc_mcu7t3v3__nand2_2
XFILLER_0_206 VDD VDD VSS VSS gf180mcu_as_sc_mcu7t3v3__fillcap_4
X_2509_ VDD VDD VSS VSS _5275_/Q _5269_/Q _5270_/Q _4739_/A _4749_/A gf180mcu_as_sc_mcu7t3v3__nand4_2
XFILLER_102_134 VDD VDD VSS VSS gf180mcu_as_sc_mcu7t3v3__fillcap_16
Xinput107 VDD VDD VSS VSS ne_in[5] _3976_/D gf180mcu_as_sc_mcu7t3v3__buff_2
Xinput118 VDD VDD VSS VSS north_in[15] _4054_/A gf180mcu_as_sc_mcu7t3v3__buff_2
X_3489_ VDD VDD VSS VSS _4146_/D _3502_/B _3514_/B _4147_/A _3490_/D gf180mcu_as_sc_mcu7t3v3__ao22_2
XFILLER_102_156 VDD VDD VSS VSS gf180mcu_as_sc_mcu7t3v3__fill_1
X_5228_ VDD VDD VSS VSS clkload7/A _5228_/D _5228_/Q gf180mcu_as_sc_mcu7t3v3__dfxtp_2
Xinput129 VDD VDD VSS VSS north_in[25] _4137_/A gf180mcu_as_sc_mcu7t3v3__buff_2
XFILLER_56_37 VDD VDD VSS VSS gf180mcu_as_sc_mcu7t3v3__fillcap_8
X_5159_ VDD VDD VSS VSS _5159_/CLK _5159_/D _5159_/Q gf180mcu_as_sc_mcu7t3v3__dfxtp_2
XTAP_TAPCELL_ROW_184_2297 VDD VSS gf180mcu_as_sc_mcu7t3v3__tap_2
XFILLER_131_1568 VDD VDD VSS VSS gf180mcu_as_sc_mcu7t3v3__fill_1
XFILLER_56_232 VDD VDD VSS VSS gf180mcu_as_sc_mcu7t3v3__fillcap_8
XFILLER_16_107 VDD VDD VSS VSS gf180mcu_as_sc_mcu7t3v3__fillcap_16
XFILLER_56_298 VDD VDD VSS VSS gf180mcu_as_sc_mcu7t3v3__fill_2
XFILLER_71_202 VDD VDD VSS VSS gf180mcu_as_sc_mcu7t3v3__fillcap_8
XPHY_EDGE_ROW_114_3_Left_248 VDD VSS gf180mcu_as_sc_mcu7t3v3__tap_2
XFILLER_72_14 VDD VDD VSS VSS gf180mcu_as_sc_mcu7t3v3__fill_2
XTAP_TAPCELL_ROW_18_3_2377 VDD VSS gf180mcu_as_sc_mcu7t3v3__tap_2
XTAP_TAPCELL_ROW_15_1_695 VDD VSS gf180mcu_as_sc_mcu7t3v3__tap_2
XTAP_TAPCELL_ROW_139_1307 VDD VSS gf180mcu_as_sc_mcu7t3v3__tap_2
XFILLER_184_104 VDD VDD VSS VSS gf180mcu_as_sc_mcu7t3v3__fillcap_4
XFILLER_184_115 VDD VDD VSS VSS gf180mcu_as_sc_mcu7t3v3__fillcap_16
XTAP_TAPCELL_ROW_139_1318 VDD VSS gf180mcu_as_sc_mcu7t3v3__tap_2
XFILLER_122_2 VDD VDD VSS VSS gf180mcu_as_sc_mcu7t3v3__fillcap_16
XFILLER_138_543 VDD VDD VSS VSS gf180mcu_as_sc_mcu7t3v3__fillcap_16
XFILLER_166_830 VDD VDD VSS VSS gf180mcu_as_sc_mcu7t3v3__fillcap_16
XTAP_TAPCELL_ROW_90_1_996 VDD VSS gf180mcu_as_sc_mcu7t3v3__tap_2
XTAP_TAPCELL_ROW_106_3_2509 VDD VSS gf180mcu_as_sc_mcu7t3v3__tap_2
XTAP_TAPCELL_ROW_156_1687 VDD VSS gf180mcu_as_sc_mcu7t3v3__tap_2
XFILLER_165_384 VDD VDD VSS VSS gf180mcu_as_sc_mcu7t3v3__fillcap_16
XTAP_TAPCELL_ROW_156_1698 VDD VSS gf180mcu_as_sc_mcu7t3v3__tap_2
XFILLER_180_365 VDD VDD VSS VSS gf180mcu_as_sc_mcu7t3v3__fillcap_16
XFILLER_171_1315 VDD VDD VSS VSS gf180mcu_as_sc_mcu7t3v3__fillcap_8
XFILLER_180_387 VDD VDD VSS VSS gf180mcu_as_sc_mcu7t3v3__fillcap_16
XFILLER_171_1348 VDD VDD VSS VSS gf180mcu_as_sc_mcu7t3v3__fillcap_16
XFILLER_175_1495 VDD VDD VSS VSS gf180mcu_as_sc_mcu7t3v3__fillcap_16
XFILLER_97_88 VDD VDD VSS VSS gf180mcu_as_sc_mcu7t3v3__fillcap_4
XFILLER_153_50 VDD VDD VSS VSS gf180mcu_as_sc_mcu7t3v3__fillcap_16
XFILLER_134_1192 VDD VDD VSS VSS gf180mcu_as_sc_mcu7t3v3__fill_2
XFILLER_153_72 VDD VDD VSS VSS gf180mcu_as_sc_mcu7t3v3__fillcap_16
XFILLER_169_1244 VDD VDD VSS VSS gf180mcu_as_sc_mcu7t3v3__fillcap_4
XFILLER_47_276 VDD VDD VSS VSS gf180mcu_as_sc_mcu7t3v3__fillcap_4
XFILLER_47_298 VDD VDD VSS VSS gf180mcu_as_sc_mcu7t3v3__fill_2
XFILLER_62_213 VDD VDD VSS VSS gf180mcu_as_sc_mcu7t3v3__fill_1
XFILLER_165_1108 VDD VDD VSS VSS gf180mcu_as_sc_mcu7t3v3__fill_1
XFILLER_1_1467 VDD VDD VSS VSS gf180mcu_as_sc_mcu7t3v3__fillcap_16
XFILLER_147_1542 VDD VDD VSS VSS gf180mcu_as_sc_mcu7t3v3__fill_1
XFILLER_143_1428 VDD VDD VSS VSS gf180mcu_as_sc_mcu7t3v3__fill_2
XFILLER_176_605 VDD VDD VSS VSS gf180mcu_as_sc_mcu7t3v3__fill_1
X_2860_ VDD VDD VSS VSS _2861_/B _4733_/B _2873_/C gf180mcu_as_sc_mcu7t3v3__and2_2
XTAP_TAPCELL_ROW_98_1_1027 VDD VSS gf180mcu_as_sc_mcu7t3v3__tap_2
XFILLER_148_307 VDD VDD VSS VSS gf180mcu_as_sc_mcu7t3v3__fillcap_8
XFILLER_175_104 VDD VDD VSS VSS gf180mcu_as_sc_mcu7t3v3__fillcap_16
XFILLER_176_616 VDD VDD VSS VSS gf180mcu_as_sc_mcu7t3v3__fillcap_8
XFILLER_141_1152 VDD VDD VSS VSS gf180mcu_as_sc_mcu7t3v3__fillcap_8
X_2791_ VDD VDD VSS VSS _4732_/C _4732_/B _2791_/A gf180mcu_as_sc_mcu7t3v3__nor2b_2
X_4530_ VDD VDD VSS VSS _4531_/D _4530_/B _4562_/A gf180mcu_as_sc_mcu7t3v3__nor2_2
X_4461_ VDD VDD VSS VSS _4465_/B _5074_/Q _4579_/S gf180mcu_as_sc_mcu7t3v3__nand2_2
XFILLER_172_877 VDD VDD VSS VSS gf180mcu_as_sc_mcu7t3v3__fillcap_16
XFILLER_176_1259 VDD VDD VSS VSS gf180mcu_as_sc_mcu7t3v3__fillcap_8
XFILLER_183_192 VDD VDD VSS VSS gf180mcu_as_sc_mcu7t3v3__fillcap_16
XFILLER_67_1521 VDD VDD VSS VSS gf180mcu_as_sc_mcu7t3v3__fillcap_16
X_3412_ VDD VDD VSS VSS _4065_/A _3451_/B _3412_/C _3412_/D _3413_/A gf180mcu_as_sc_mcu7t3v3__ao22_2
XFILLER_139_1070 VDD VDD VSS VSS gf180mcu_as_sc_mcu7t3v3__fill_1
XFILLER_154_1502 VDD VDD VSS VSS gf180mcu_as_sc_mcu7t3v3__fill_2
X_4392_ VDD VDD VSS VSS _4403_/S _5008_/Q _5037_/Q _4393_/B gf180mcu_as_sc_mcu7t3v3__mux2_2
XTAP_TAPCELL_ROW_32_1_765 VDD VSS gf180mcu_as_sc_mcu7t3v3__tap_2
XFILLER_154_1535 VDD VDD VSS VSS gf180mcu_as_sc_mcu7t3v3__fill_2
Xfanout808 VDD VDD VSS VSS _3909_/A fanout808/Y gf180mcu_as_sc_mcu7t3v3__buff_2
X_3343_ VDD VDD VSS VSS _3505_/S _3343_/B _3994_/A _3344_/B gf180mcu_as_sc_mcu7t3v3__mux2_2
XFILLER_140_774 VDD VDD VSS VSS gf180mcu_as_sc_mcu7t3v3__fillcap_16
Xhold1006 VDD VDD VSS VSS _2584_/Y _2585_/B gf180mcu_as_sc_mcu7t3v3__buff_2
X_3274_ VDD VDD VSS VSS _3925_/D _3500_/B _3274_/C _3274_/D _3279_/A gf180mcu_as_sc_mcu7t3v3__ao211_2
X_5013_ VDD VDD VSS VSS _5080_/CLK _5013_/D _5013_/Q gf180mcu_as_sc_mcu7t3v3__dfxtp_2
Xhold1017 VDD VDD VSS VSS hold1050/Y _4960_/D gf180mcu_as_sc_mcu7t3v3__buff_2
Xhold1028 VDD VDD VSS VSS _5239_/Q _4659_/A gf180mcu_as_sc_mcu7t3v3__buff_2
Xhold1039 VDD VDD VSS VSS _3906_/B hold1039/Y gf180mcu_as_sc_mcu7t3v3__buff_2
XFILLER_26_18 VDD VDD VSS VSS gf180mcu_as_sc_mcu7t3v3__fillcap_16
XFILLER_53_224 VDD VDD VSS VSS gf180mcu_as_sc_mcu7t3v3__fill_2
XFILLER_146_1063 VDD VDD VSS VSS gf180mcu_as_sc_mcu7t3v3__fillcap_8
XFILLER_179_454 VDD VDD VSS VSS gf180mcu_as_sc_mcu7t3v3__fillcap_16
XFILLER_167_627 VDD VDD VSS VSS gf180mcu_as_sc_mcu7t3v3__fill_2
Xclkbuf_leaf_13_clk_regs VDD VDD VSS VSS clkbuf_3_3_0_clk_regs/Y _5186_/CLK gf180mcu_as_sc_mcu7t3v3__clkbuff_12
X_2989_ VDD VDD VSS VSS _3601_/D _3194_/S _2989_/B _2989_/C _2990_/C gf180mcu_as_sc_mcu7t3v3__ao31_2
XFILLER_148_874 VDD VDD VSS VSS gf180mcu_as_sc_mcu7t3v3__fill_1
XFILLER_159_1402 VDD VDD VSS VSS gf180mcu_as_sc_mcu7t3v3__fillcap_16
X_4728_ VDD VDD VSS VSS _5110_/Q _4731_/B _4730_/B _5266_/Q _4729_/C gf180mcu_as_sc_mcu7t3v3__ao22_2
XTAP_TAPCELL_ROW_134_1204 VDD VSS gf180mcu_as_sc_mcu7t3v3__tap_2
XFILLER_107_204 VDD VDD VSS VSS gf180mcu_as_sc_mcu7t3v3__fillcap_4
XPHY_EDGE_ROW_184_Right_318 VDD VSS gf180mcu_as_sc_mcu7t3v3__tap_2
X_4659_ VDD VDD VSS VSS _4660_/C _4659_/B _4659_/A gf180mcu_as_sc_mcu7t3v3__nor2_2
XTAP_TAPCELL_ROW_134_1215 VDD VSS gf180mcu_as_sc_mcu7t3v3__tap_2
XFILLER_11_1553 VDD VDD VSS VSS gf180mcu_as_sc_mcu7t3v3__fillcap_16
XPHY_EDGE_ROW_101_3_Right_420 VDD VSS gf180mcu_as_sc_mcu7t3v3__tap_2
XFILLER_150_527 VDD VDD VSS VSS gf180mcu_as_sc_mcu7t3v3__fillcap_4
XTAP_TAPCELL_ROW_151_1584 VDD VSS gf180mcu_as_sc_mcu7t3v3__tap_2
XTAP_TAPCELL_ROW_151_1573 VDD VSS gf180mcu_as_sc_mcu7t3v3__tap_2
XFILLER_157_1192 VDD VDD VSS VSS gf180mcu_as_sc_mcu7t3v3__fillcap_16
XFILLER_88_143 VDD VDD VSS VSS gf180mcu_as_sc_mcu7t3v3__fill_2
XTAP_TAPCELL_ROW_8_1_667 VDD VSS gf180mcu_as_sc_mcu7t3v3__tap_2
XFILLER_29_276 VDD VDD VSS VSS gf180mcu_as_sc_mcu7t3v3__fillcap_4
XFILLER_83_35 VDD VDD VSS VSS gf180mcu_as_sc_mcu7t3v3__fill_2
XFILLER_29_298 VDD VDD VSS VSS gf180mcu_as_sc_mcu7t3v3__fill_2
XFILLER_44_279 VDD VDD VSS VSS gf180mcu_as_sc_mcu7t3v3__fillcap_16
XFILLER_83_79 VDD VDD VSS VSS gf180mcu_as_sc_mcu7t3v3__fillcap_16
XFILLER_164_1152 VDD VDD VSS VSS gf180mcu_as_sc_mcu7t3v3__fill_2
XPHY_EDGE_ROW_130_1_Right_129 VDD VSS gf180mcu_as_sc_mcu7t3v3__tap_2
Xsram2048.u_bank1_820 VDD VDD VSS VSS sram2048.u_bank1/WEN[2] gf180mcu_as_sc_mcu7t3v3__tiel_4
XFILLER_158_616 VDD VDD VSS VSS gf180mcu_as_sc_mcu7t3v3__fillcap_16
XTAP_TAPCELL_ROW_158_1738 VDD VSS gf180mcu_as_sc_mcu7t3v3__tap_2
XTAP_TAPCELL_ROW_158_1727 VDD VSS gf180mcu_as_sc_mcu7t3v3__tap_2
XFILLER_157_137 VDD VDD VSS VSS gf180mcu_as_sc_mcu7t3v3__fill_2
XFILLER_158_649 VDD VDD VSS VSS gf180mcu_as_sc_mcu7t3v3__fillcap_4
XFILLER_142_1472 VDD VDD VSS VSS gf180mcu_as_sc_mcu7t3v3__fillcap_8
XFILLER_142_1494 VDD VDD VSS VSS gf180mcu_as_sc_mcu7t3v3__fillcap_8
XFILLER_16_1486 VDD VDD VSS VSS gf180mcu_as_sc_mcu7t3v3__fillcap_16
XFILLER_172_107 VDD VDD VSS VSS gf180mcu_as_sc_mcu7t3v3__fillcap_16
XFILLER_103_1467 VDD VDD VSS VSS gf180mcu_as_sc_mcu7t3v3__fillcap_16
XFILLER_138_384 VDD VDD VSS VSS gf180mcu_as_sc_mcu7t3v3__fill_1
XFILLER_177_1535 VDD VDD VSS VSS gf180mcu_as_sc_mcu7t3v3__fillcap_4
XFILLER_154_877 VDD VDD VSS VSS gf180mcu_as_sc_mcu7t3v3__fillcap_16
XFILLER_177_1546 VDD VDD VSS VSS gf180mcu_as_sc_mcu7t3v3__fill_2
XFILLER_180_173 VDD VDD VSS VSS gf180mcu_as_sc_mcu7t3v3__fill_2
XFILLER_136_1221 VDD VDD VSS VSS gf180mcu_as_sc_mcu7t3v3__fillcap_4
XFILLER_175_1270 VDD VDD VSS VSS gf180mcu_as_sc_mcu7t3v3__fill_2
XTAP_TAPCELL_ROW_20_1_714 VDD VSS gf180mcu_as_sc_mcu7t3v3__tap_2
XFILLER_136_1254 VDD VDD VSS VSS gf180mcu_as_sc_mcu7t3v3__fillcap_16
XFILLER_79_154 VDD VDD VSS VSS gf180mcu_as_sc_mcu7t3v3__fill_2
XFILLER_171_1189 VDD VDD VSS VSS gf180mcu_as_sc_mcu7t3v3__fill_1
XFILLER_62_1451 VDD VDD VSS VSS gf180mcu_as_sc_mcu7t3v3__fillcap_16
XFILLER_79_198 VDD VDD VSS VSS gf180mcu_as_sc_mcu7t3v3__fill_1
XPHY_EDGE_ROW_45_1_Right_44 VDD VSS gf180mcu_as_sc_mcu7t3v3__tap_2
XFILLER_94_146 VDD VDD VSS VSS gf180mcu_as_sc_mcu7t3v3__fill_2
XPHY_EDGE_ROW_16_1_Left_468 VDD VSS gf180mcu_as_sc_mcu7t3v3__tap_2
XFILLER_169_1052 VDD VDD VSS VSS gf180mcu_as_sc_mcu7t3v3__fillcap_4
XFILLER_184_1528 VDD VDD VSS VSS gf180mcu_as_sc_mcu7t3v3__fill_2
X_3961_ VDD VDD VSS VSS _3962_/D _3961_/C _4163_/B _3961_/A gf180mcu_as_sc_mcu7t3v3__aoi21_2
XFILLER_143_1203 VDD VDD VSS VSS gf180mcu_as_sc_mcu7t3v3__fillcap_16
X_2912_ VDD VDD VSS VSS _3255_/C _3788_/D _3796_/D gf180mcu_as_sc_mcu7t3v3__nor2_2
XFILLER_149_616 VDD VDD VSS VSS gf180mcu_as_sc_mcu7t3v3__fillcap_8
X_3892_ VDD VDD VSS VSS _3905_/B _5182_/Q _4932_/D gf180mcu_as_sc_mcu7t3v3__and2_2
XFILLER_176_435 VDD VDD VSS VSS gf180mcu_as_sc_mcu7t3v3__fillcap_16
XFILLER_176_457 VDD VDD VSS VSS gf180mcu_as_sc_mcu7t3v3__fillcap_16
XFILLER_85_2 VDD VDD VSS VSS gf180mcu_as_sc_mcu7t3v3__fillcap_8
X_2843_ VDD VDD VSS VSS _4290_/B _5226_/Q _4746_/B gf180mcu_as_sc_mcu7t3v3__xnor2_2
XPHY_EDGE_ROW_78_1_Left_530 VDD VSS gf180mcu_as_sc_mcu7t3v3__tap_2
XFILLER_34_1564 VDD VDD VSS VSS gf180mcu_as_sc_mcu7t3v3__fillcap_4
X_2774_ VDD VDD VSS VSS _4259_/B _4719_/A _4649_/B gf180mcu_as_sc_mcu7t3v3__and2_2
XFILLER_145_833 VDD VDD VSS VSS gf180mcu_as_sc_mcu7t3v3__fillcap_4
XFILLER_157_693 VDD VDD VSS VSS gf180mcu_as_sc_mcu7t3v3__fillcap_4
XPHY_EDGE_ROW_130_1_Left_582 VDD VSS gf180mcu_as_sc_mcu7t3v3__tap_2
X_4513_ VDD VDD VSS VSS _5179_/Q _4592_/B _4513_/C _4513_/D _5179_/D gf180mcu_as_sc_mcu7t3v3__ao211_2
XFILLER_145_866 VDD VDD VSS VSS gf180mcu_as_sc_mcu7t3v3__fill_2
XFILLER_137_1029 VDD VDD VSS VSS gf180mcu_as_sc_mcu7t3v3__fillcap_16
XFILLER_144_387 VDD VDD VSS VSS gf180mcu_as_sc_mcu7t3v3__fillcap_4
X_4444_ VDD VDD VSS VSS _4444_/B _4576_/A _4451_/C gf180mcu_as_sc_mcu7t3v3__and2_2
XTAP_TAPCELL_ROW_122_1_1123 VDD VSS gf180mcu_as_sc_mcu7t3v3__tap_2
XFILLER_154_1321 VDD VDD VSS VSS gf180mcu_as_sc_mcu7t3v3__fill_2
Xfanout605 VDD VDD VSS VSS _3749_/B _3741_/B gf180mcu_as_sc_mcu7t3v3__buff_2
X_4375_ VDD VDD VSS VSS _5164_/Q _4590_/B _4590_/C _5484_/A _4376_/B gf180mcu_as_sc_mcu7t3v3__ao22_2
Xfanout616 VDD VDD VSS VSS fanout617/Y _3467_/B gf180mcu_as_sc_mcu7t3v3__buff_2
Xfanout627 VDD VDD VSS VSS fanout631/Y _3239_/A gf180mcu_as_sc_mcu7t3v3__buff_2
Xfanout638 VDD VDD VSS VSS _4629_/C _4623_/C gf180mcu_as_sc_mcu7t3v3__buff_2
Xfanout649 VDD VDD VSS VSS fanout651/Y _4103_/B gf180mcu_as_sc_mcu7t3v3__buff_2
X_3326_ VDD VDD VSS VSS _3470_/B _3326_/B _3326_/C _3327_/C gf180mcu_as_sc_mcu7t3v3__nor3_2
XFILLER_112_295 VDD VDD VSS VSS gf180mcu_as_sc_mcu7t3v3__fillcap_4
XFILLER_140_593 VDD VDD VSS VSS gf180mcu_as_sc_mcu7t3v3__fill_2
X_3257_ VDD VDD VSS VSS _3271_/B _3812_/A _3257_/A gf180mcu_as_sc_mcu7t3v3__nand2_2
XTAP_TAPCELL_ROW_181_2245 VDD VSS gf180mcu_as_sc_mcu7t3v3__tap_2
XTAP_TAPCELL_ROW_181_2234 VDD VSS gf180mcu_as_sc_mcu7t3v3__tap_2
XTAP_TAPCELL_ROW_102_1_1043 VDD VSS gf180mcu_as_sc_mcu7t3v3__tap_2
XFILLER_160_18 VDD VDD VSS VSS gf180mcu_as_sc_mcu7t3v3__fillcap_16
X_3188_ VDD VDD VSS VSS _3235_/B _3188_/B _4159_/A _3191_/D gf180mcu_as_sc_mcu7t3v3__mux2_2
XTAP_TAPCELL_ROW_4_1_651 VDD VSS gf180mcu_as_sc_mcu7t3v3__tap_2
XFILLER_148_1114 VDD VDD VSS VSS gf180mcu_as_sc_mcu7t3v3__fillcap_4
XFILLER_165_1450 VDD VDD VSS VSS gf180mcu_as_sc_mcu7t3v3__fillcap_16
XFILLER_183_1049 VDD VDD VSS VSS gf180mcu_as_sc_mcu7t3v3__fill_1
XPHY_EDGE_ROW_91_1_Right_90 VDD VSS gf180mcu_as_sc_mcu7t3v3__tap_2
XFILLER_165_1472 VDD VDD VSS VSS gf180mcu_as_sc_mcu7t3v3__fillcap_16
XFILLER_168_947 VDD VDD VSS VSS gf180mcu_as_sc_mcu7t3v3__fillcap_16
XTAP_TAPCELL_ROW_179_2196 VDD VSS gf180mcu_as_sc_mcu7t3v3__tap_2
XTAP_TAPCELL_ROW_179_2185 VDD VSS gf180mcu_as_sc_mcu7t3v3__tap_2
XFILLER_126_1467 VDD VDD VSS VSS gf180mcu_as_sc_mcu7t3v3__fillcap_16
XFILLER_139_137 VDD VDD VSS VSS gf180mcu_as_sc_mcu7t3v3__fill_2
XFILLER_161_1358 VDD VDD VSS VSS gf180mcu_as_sc_mcu7t3v3__fillcap_16
XFILLER_148_660 VDD VDD VSS VSS gf180mcu_as_sc_mcu7t3v3__fillcap_4
XFILLER_154_107 VDD VDD VSS VSS gf180mcu_as_sc_mcu7t3v3__fillcap_16
XTAP_TAPCELL_ROW_153_1624 VDD VSS gf180mcu_as_sc_mcu7t3v3__tap_2
XTAP_TAPCELL_ROW_153_1613 VDD VSS gf180mcu_as_sc_mcu7t3v3__tap_2
XTAP_TAPCELL_ROW_60_1_874 VDD VSS gf180mcu_as_sc_mcu7t3v3__tap_2
XFILLER_85_1451 VDD VDD VSS VSS gf180mcu_as_sc_mcu7t3v3__fillcap_16
XPHY_EDGE_ROW_102_3_Right_421 VDD VSS gf180mcu_as_sc_mcu7t3v3__tap_2
XTAP_TAPCELL_ROW_170_1993 VDD VSS gf180mcu_as_sc_mcu7t3v3__tap_2
XFILLER_103_251 VDD VDD VSS VSS gf180mcu_as_sc_mcu7t3v3__fill_1
XFILLER_76_157 VDD VDD VSS VSS gf180mcu_as_sc_mcu7t3v3__fillcap_8
XFILLER_94_78 VDD VDD VSS VSS gf180mcu_as_sc_mcu7t3v3__fillcap_8
XFILLER_27_50 VDD VDD VSS VSS gf180mcu_as_sc_mcu7t3v3__fillcap_16
XFILLER_27_72 VDD VDD VSS VSS gf180mcu_as_sc_mcu7t3v3__fillcap_16
XTAP_TAPCELL_ROW_23_1_729 VDD VSS gf180mcu_as_sc_mcu7t3v3__tap_2
XFILLER_166_1269 VDD VDD VSS VSS gf180mcu_as_sc_mcu7t3v3__fill_1
XFILLER_183_1550 VDD VDD VSS VSS gf180mcu_as_sc_mcu7t3v3__fill_2
XFILLER_57_1553 VDD VDD VSS VSS gf180mcu_as_sc_mcu7t3v3__fillcap_16
XFILLER_158_402 VDD VDD VSS VSS gf180mcu_as_sc_mcu7t3v3__fillcap_8
XFILLER_92_1477 VDD VDD VSS VSS gf180mcu_as_sc_mcu7t3v3__fillcap_4
XPHY_EDGE_ROW_146_Right_280 VDD VSS gf180mcu_as_sc_mcu7t3v3__tap_2
XFILLER_158_457 VDD VDD VSS VSS gf180mcu_as_sc_mcu7t3v3__fillcap_16
XFILLER_173_416 VDD VDD VSS VSS gf180mcu_as_sc_mcu7t3v3__fillcap_4
XFILLER_173_438 VDD VDD VSS VSS gf180mcu_as_sc_mcu7t3v3__fillcap_16
XFILLER_142_803 VDD VDD VSS VSS gf180mcu_as_sc_mcu7t3v3__fill_2
XFILLER_154_641 VDD VDD VSS VSS gf180mcu_as_sc_mcu7t3v3__fillcap_16
XFILLER_177_1321 VDD VDD VSS VSS gf180mcu_as_sc_mcu7t3v3__fill_2
XFILLER_153_162 VDD VDD VSS VSS gf180mcu_as_sc_mcu7t3v3__fill_1
XFILLER_177_1365 VDD VDD VSS VSS gf180mcu_as_sc_mcu7t3v3__fillcap_8
X_2490_ VDD VDD VSS VSS _4371_/A _4739_/A _5270_/Q gf180mcu_as_sc_mcu7t3v3__nor2_2
XFILLER_64_1502 VDD VDD VSS VSS gf180mcu_as_sc_mcu7t3v3__fillcap_16
X_4160_ VDD VDD VSS VSS _4160_/A _4160_/B _4160_/C _4160_/D _4161_/D gf180mcu_as_sc_mcu7t3v3__ao22_2
XFILLER_151_1527 VDD VDD VSS VSS gf180mcu_as_sc_mcu7t3v3__fillcap_8
XFILLER_64_1568 VDD VDD VSS VSS gf180mcu_as_sc_mcu7t3v3__fill_1
X_3111_ VDD VDD VSS VSS _4087_/A _3127_/B _3127_/C _4088_/D _3112_/C gf180mcu_as_sc_mcu7t3v3__ao22_2
XFILLER_67_146 VDD VDD VSS VSS gf180mcu_as_sc_mcu7t3v3__fill_2
XFILLER_7_1451 VDD VDD VSS VSS gf180mcu_as_sc_mcu7t3v3__fillcap_16
X_4091_ VDD VDD VSS VSS _4091_/A _4099_/B _4091_/C _4248_/B _4091_/D gf180mcu_as_sc_mcu7t3v3__aoi211_2
Xinput290 VDD VDD VSS VSS west_in[16] _4065_/A gf180mcu_as_sc_mcu7t3v3__buff_2
X_3042_ VDD VDD VSS VSS _4022_/A _3142_/B _3142_/C _4021_/A _3048_/B gf180mcu_as_sc_mcu7t3v3__ao22_2
XFILLER_149_1467 VDD VDD VSS VSS gf180mcu_as_sc_mcu7t3v3__fill_2
XFILLER_184_1358 VDD VDD VSS VSS gf180mcu_as_sc_mcu7t3v3__fill_2
X_4993_ VDD VDD VSS VSS _5080_/CLK _4993_/D _4993_/Q gf180mcu_as_sc_mcu7t3v3__dfxtp_2
XFILLER_149_402 VDD VDD VSS VSS gf180mcu_as_sc_mcu7t3v3__fillcap_16
XFILLER_90_193 VDD VDD VSS VSS gf180mcu_as_sc_mcu7t3v3__fillcap_16
X_3944_ VDD VDD VSS VSS _3944_/A _4110_/C _3944_/C _3944_/D _3945_/B gf180mcu_as_sc_mcu7t3v3__ao22_2
XFILLER_182_1093 VDD VDD VSS VSS gf180mcu_as_sc_mcu7t3v3__fillcap_16
XFILLER_31_260 VDD VDD VSS VSS gf180mcu_as_sc_mcu7t3v3__fillcap_16
X_3875_ VDD VDD VSS VSS _4946_/D _5165_/Q _4915_/D gf180mcu_as_sc_mcu7t3v3__and2_2
XFILLER_177_766 VDD VDD VSS VSS gf180mcu_as_sc_mcu7t3v3__fillcap_4
XFILLER_177_788 VDD VDD VSS VSS gf180mcu_as_sc_mcu7t3v3__fill_2
XFILLER_31_282 VDD VDD VSS VSS gf180mcu_as_sc_mcu7t3v3__fillcap_16
X_2826_ VDD VDD VSS VSS _4975_/D _2826_/B _5281_/Q _5280_/D gf180mcu_as_sc_mcu7t3v3__mux2_2
XFILLER_136_107 VDD VDD VSS VSS gf180mcu_as_sc_mcu7t3v3__fill_1
XFILLER_158_991 VDD VDD VSS VSS gf180mcu_as_sc_mcu7t3v3__fillcap_8
XFILLER_160_1391 VDD VDD VSS VSS gf180mcu_as_sc_mcu7t3v3__fill_2
XTAP_TAPCELL_ROW_174_2093 VDD VSS gf180mcu_as_sc_mcu7t3v3__tap_2
XTAP_TAPCELL_ROW_174_2082 VDD VSS gf180mcu_as_sc_mcu7t3v3__tap_2
X_2757_ VDD VDD VSS VSS _4377_/A _2765_/C _2765_/B _4691_/A gf180mcu_as_sc_mcu7t3v3__aoi21_2
XFILLER_145_696 VDD VDD VSS VSS gf180mcu_as_sc_mcu7t3v3__fillcap_4
XPHY_EDGE_ROW_123_3_Left_257 VDD VSS gf180mcu_as_sc_mcu7t3v3__tap_2
X_2688_ VDD VDD VSS VSS _2711_/S _4958_/Q _4967_/Q _2691_/B gf180mcu_as_sc_mcu7t3v3__mux2_2
XFILLER_144_173 VDD VDD VSS VSS gf180mcu_as_sc_mcu7t3v3__fill_2
XFILLER_160_633 VDD VDD VSS VSS gf180mcu_as_sc_mcu7t3v3__fillcap_16
X_4427_ VDD VDD VSS VSS _4431_/B _5070_/Q _4552_/A gf180mcu_as_sc_mcu7t3v3__nand2_2
XFILLER_48_16 VDD VDD VSS VSS gf180mcu_as_sc_mcu7t3v3__fill_1
XFILLER_154_1151 VDD VDD VSS VSS gf180mcu_as_sc_mcu7t3v3__fillcap_4
XFILLER_154_1173 VDD VDD VSS VSS gf180mcu_as_sc_mcu7t3v3__fillcap_4
XFILLER_160_699 VDD VDD VSS VSS gf180mcu_as_sc_mcu7t3v3__fillcap_8
XFILLER_48_27 VDD VDD VSS VSS gf180mcu_as_sc_mcu7t3v3__fillcap_8
XFILLER_58_113 VDD VDD VSS VSS gf180mcu_as_sc_mcu7t3v3__fill_1
XFILLER_98_282 VDD VDD VSS VSS gf180mcu_as_sc_mcu7t3v3__fillcap_16
X_4358_ VDD VDD VSS VSS _4379_/B _4358_/B _5159_/Q _5159_/D gf180mcu_as_sc_mcu7t3v3__mux2_2
Xfanout468 VDD VDD VSS VSS _4223_/C _4221_/C gf180mcu_as_sc_mcu7t3v3__buff_2
X_4289_ VDD VDD VSS VSS _4289_/S _5485_/A _5123_/Q _5123_/D gf180mcu_as_sc_mcu7t3v3__mux2_2
X_3309_ VDD VDD VSS VSS _3957_/A _3504_/B _3523_/B _3961_/A _3310_/C gf180mcu_as_sc_mcu7t3v3__ao22_2
Xmesh_tile_872 VDD VDD VSS VSS north_out[13] gf180mcu_as_sc_mcu7t3v3__tiel_4
Xmesh_tile_861 VDD VDD VSS VSS north_out[2] gf180mcu_as_sc_mcu7t3v3__tiel_4
Xmesh_tile_850 VDD VDD VSS VSS ne_out[25] gf180mcu_as_sc_mcu7t3v3__tiel_4
XFILLER_100_298 VDD VDD VSS VSS gf180mcu_as_sc_mcu7t3v3__fill_2
XFILLER_73_127 VDD VDD VSS VSS gf180mcu_as_sc_mcu7t3v3__fillcap_8
Xmesh_tile_894 VDD VDD VSS VSS nw_out[1] gf180mcu_as_sc_mcu7t3v3__tiel_4
Xmesh_tile_883 VDD VDD VSS VSS north_out[24] gf180mcu_as_sc_mcu7t3v3__tiel_4
XTAP_TAPCELL_ROW_63_1_889 VDD VSS gf180mcu_as_sc_mcu7t3v3__tap_2
XTAP_TAPCELL_ROW_146_1472 VDD VSS gf180mcu_as_sc_mcu7t3v3__tap_2
XTAP_TAPCELL_ROW_146_1461 VDD VSS gf180mcu_as_sc_mcu7t3v3__tap_2
XFILLER_64_37 VDD VDD VSS VSS gf180mcu_as_sc_mcu7t3v3__fill_1
XFILLER_120_10 VDD VDD VSS VSS gf180mcu_as_sc_mcu7t3v3__fill_2
XFILLER_128_1518 VDD VDD VSS VSS gf180mcu_as_sc_mcu7t3v3__fillcap_16
XFILLER_120_65 VDD VDD VSS VSS gf180mcu_as_sc_mcu7t3v3__fillcap_8
XFILLER_168_700 VDD VDD VSS VSS gf180mcu_as_sc_mcu7t3v3__fillcap_4
XFILLER_80_14 VDD VDD VSS VSS gf180mcu_as_sc_mcu7t3v3__fill_2
XTAP_TAPCELL_ROW_99_1_1032 VDD VSS gf180mcu_as_sc_mcu7t3v3__tap_2
XFILLER_161_1122 VDD VDD VSS VSS gf180mcu_as_sc_mcu7t3v3__fillcap_16
XFILLER_165_1291 VDD VDD VSS VSS gf180mcu_as_sc_mcu7t3v3__fillcap_8
XFILLER_168_777 VDD VDD VSS VSS gf180mcu_as_sc_mcu7t3v3__fillcap_16
XFILLER_149_991 VDD VDD VSS VSS gf180mcu_as_sc_mcu7t3v3__fillcap_8
XFILLER_167_298 VDD VDD VSS VSS gf180mcu_as_sc_mcu7t3v3__fillcap_16
XFILLER_52_1483 VDD VDD VSS VSS gf180mcu_as_sc_mcu7t3v3__fill_1
XFILLER_13_1467 VDD VDD VSS VSS gf180mcu_as_sc_mcu7t3v3__fillcap_16
XFILLER_164_961 VDD VDD VSS VSS gf180mcu_as_sc_mcu7t3v3__fill_2
XFILLER_171_909 VDD VDD VSS VSS gf180mcu_as_sc_mcu7t3v3__fill_1
XFILLER_89_34 VDD VDD VSS VSS gf180mcu_as_sc_mcu7t3v3__fillcap_4
XPHY_EDGE_ROW_55_3_Left_189 VDD VSS gf180mcu_as_sc_mcu7t3v3__tap_2
XFILLER_159_1062 VDD VDD VSS VSS gf180mcu_as_sc_mcu7t3v3__fill_1
XFILLER_170_419 VDD VDD VSS VSS gf180mcu_as_sc_mcu7t3v3__fillcap_16
XFILLER_182_279 VDD VDD VSS VSS gf180mcu_as_sc_mcu7t3v3__fillcap_16
XFILLER_151_688 VDD VDD VSS VSS gf180mcu_as_sc_mcu7t3v3__fill_1
XFILLER_1_120 VDD VDD VSS VSS gf180mcu_as_sc_mcu7t3v3__fillcap_8
XFILLER_1_142 VDD VDD VSS VSS gf180mcu_as_sc_mcu7t3v3__fillcap_16
XPHY_EDGE_ROW_103_3_Right_422 VDD VSS gf180mcu_as_sc_mcu7t3v3__tap_2
XFILLER_89_260 VDD VDD VSS VSS gf180mcu_as_sc_mcu7t3v3__fillcap_16
XFILLER_89_282 VDD VDD VSS VSS gf180mcu_as_sc_mcu7t3v3__fillcap_16
XFILLER_161_72 VDD VDD VSS VSS gf180mcu_as_sc_mcu7t3v3__fillcap_16
XFILLER_72_193 VDD VDD VSS VSS gf180mcu_as_sc_mcu7t3v3__fillcap_8
XFILLER_109_1451 VDD VDD VSS VSS gf180mcu_as_sc_mcu7t3v3__fillcap_16
XFILLER_13_260 VDD VDD VSS VSS gf180mcu_as_sc_mcu7t3v3__fillcap_16
XFILLER_159_722 VDD VDD VSS VSS gf180mcu_as_sc_mcu7t3v3__fillcap_8
XFILLER_13_282 VDD VDD VSS VSS gf180mcu_as_sc_mcu7t3v3__fillcap_16
XFILLER_140_1217 VDD VDD VSS VSS gf180mcu_as_sc_mcu7t3v3__fillcap_8
XFILLER_144_1375 VDD VDD VSS VSS gf180mcu_as_sc_mcu7t3v3__fill_2
XFILLER_159_788 VDD VDD VSS VSS gf180mcu_as_sc_mcu7t3v3__fillcap_8
XFILLER_70_1550 VDD VDD VSS VSS gf180mcu_as_sc_mcu7t3v3__fillcap_4
XFILLER_118_107 VDD VDD VSS VSS gf180mcu_as_sc_mcu7t3v3__fill_2
X_3660_ VDD VDD VSS VSS _3661_/C _3660_/C _3745_/B _4033_/A gf180mcu_as_sc_mcu7t3v3__aoi21_2
XFILLER_70_91 VDD VDD VSS VSS gf180mcu_as_sc_mcu7t3v3__fill_1
Xclkload12 VDD VDD VSS VSS clkload12/Y _5186_/CLK gf180mcu_as_sc_mcu7t3v3__inv_4
Xclkload23 VDD VDD VSS VSS clkload23/Y _5074_/CLK gf180mcu_as_sc_mcu7t3v3__inv_4
X_3591_ VDD VDD VSS VSS _3957_/A _3750_/B _3750_/C _3956_/A _3592_/D gf180mcu_as_sc_mcu7t3v3__ao22_2
X_2611_ VDD VDD VSS VSS _2776_/A _2771_/A _4708_/A gf180mcu_as_sc_mcu7t3v3__nor2_2
XFILLER_177_1151 VDD VDD VSS VSS gf180mcu_as_sc_mcu7t3v3__fillcap_8
X_2542_ VDD VDD VSS VSS _4327_/C _4328_/A gf180mcu_as_sc_mcu7t3v3__inv_2
XFILLER_126_173 VDD VDD VSS VSS gf180mcu_as_sc_mcu7t3v3__fill_2
XFILLER_126_184 VDD VDD VSS VSS gf180mcu_as_sc_mcu7t3v3__fillcap_16
XFILLER_141_121 VDD VDD VSS VSS gf180mcu_as_sc_mcu7t3v3__fillcap_16
XFILLER_170_942 VDD VDD VSS VSS gf180mcu_as_sc_mcu7t3v3__fill_2
X_5261_ VDD VDD VSS VSS _5266_/CLK _5261_/D _5261_/Q gf180mcu_as_sc_mcu7t3v3__dfxtp_2
XFILLER_138_1157 VDD VDD VSS VSS gf180mcu_as_sc_mcu7t3v3__fillcap_4
X_4212_ VDD VDD VSS VSS _4241_/B _4219_/B _4219_/C _5048_/Q _5048_/D gf180mcu_as_sc_mcu7t3v3__ao22_2
X_2473_ VDD VDD VSS VSS _2474_/C _4362_/B _4369_/B gf180mcu_as_sc_mcu7t3v3__nand2_2
XFILLER_141_187 VDD VDD VSS VSS gf180mcu_as_sc_mcu7t3v3__fillcap_16
X_5192_ VDD VDD VSS VSS clkload2/A _5192_/D _5192_/Q gf180mcu_as_sc_mcu7t3v3__dfxtp_2
X_4143_ VDD VDD VSS VSS _4143_/A _4161_/B _4159_/C _4143_/D _4145_/C gf180mcu_as_sc_mcu7t3v3__ao22_2
XFILLER_95_263 VDD VDD VSS VSS gf180mcu_as_sc_mcu7t3v3__fillcap_4
X_4074_ VDD VDD VSS VSS _4075_/C _4074_/B _4074_/A gf180mcu_as_sc_mcu7t3v3__nor2_2
X_3025_ VDD VDD VSS VSS _3143_/S _4006_/A _4006_/D _3027_/B gf180mcu_as_sc_mcu7t3v3__mux2_2
XTAP_TAPCELL_ROW_51_1_838 VDD VSS gf180mcu_as_sc_mcu7t3v3__tap_2
XFILLER_149_1231 VDD VDD VSS VSS gf180mcu_as_sc_mcu7t3v3__fill_2
XFILLER_51_300 VDD VDD VSS VSS gf180mcu_as_sc_mcu7t3v3__fill_1
XTAP_TAPCELL_ROW_176_2122 VDD VSS gf180mcu_as_sc_mcu7t3v3__tap_2
XFILLER_75_1483 VDD VDD VSS VSS gf180mcu_as_sc_mcu7t3v3__fillcap_16
X_4976_ VDD VDD VSS VSS clkload2/A _4976_/D _4976_/Q gf180mcu_as_sc_mcu7t3v3__dfxtp_2
XTAP_TAPCELL_ROW_176_2133 VDD VSS gf180mcu_as_sc_mcu7t3v3__tap_2
XFILLER_36_1467 VDD VDD VSS VSS gf180mcu_as_sc_mcu7t3v3__fillcap_16
X_3927_ VDD VDD VSS VSS _3927_/Y _3927_/B _3927_/A gf180mcu_as_sc_mcu7t3v3__nor2_2
XFILLER_149_298 VDD VDD VSS VSS gf180mcu_as_sc_mcu7t3v3__fillcap_8
XFILLER_177_574 VDD VDD VSS VSS gf180mcu_as_sc_mcu7t3v3__fill_2
Xclkload6 VDD VDD VSS VSS clkload6/Y clkload6/A gf180mcu_as_sc_mcu7t3v3__inv_6
X_3858_ VDD VDD VSS VSS _3858_/A _3858_/B _3858_/C _3858_/D _3873_/A gf180mcu_as_sc_mcu7t3v3__nand4_2
XFILLER_137_449 VDD VDD VSS VSS gf180mcu_as_sc_mcu7t3v3__fillcap_16
X_3789_ VDD VDD VSS VSS _3789_/D _3789_/A _3812_/B _3797_/C _3790_/D gf180mcu_as_sc_mcu7t3v3__ao31_2
X_2809_ VDD VDD VSS VSS _2809_/B _4708_/C _2811_/C gf180mcu_as_sc_mcu7t3v3__and2_2
XFILLER_160_452 VDD VDD VSS VSS gf180mcu_as_sc_mcu7t3v3__fill_2
XFILLER_115_10 VDD VDD VSS VSS gf180mcu_as_sc_mcu7t3v3__fillcap_4
XFILLER_132_187 VDD VDD VSS VSS gf180mcu_as_sc_mcu7t3v3__fillcap_8
XFILLER_134_1566 VDD VDD VSS VSS gf180mcu_as_sc_mcu7t3v3__fill_2
XTAP_TAPCELL_ROW_148_1523 VDD VSS gf180mcu_as_sc_mcu7t3v3__tap_2
XTAP_TAPCELL_ROW_148_1512 VDD VSS gf180mcu_as_sc_mcu7t3v3__tap_2
XFILLER_115_65 VDD VDD VSS VSS gf180mcu_as_sc_mcu7t3v3__fillcap_4
XFILLER_75_58 VDD VDD VSS VSS gf180mcu_as_sc_mcu7t3v3__fillcap_8
XTAP_TAPCELL_ROW_165_1892 VDD VSS gf180mcu_as_sc_mcu7t3v3__tap_2
XTAP_TAPCELL_ROW_165_1881 VDD VSS gf180mcu_as_sc_mcu7t3v3__tap_2
XFILLER_61_119 VDD VDD VSS VSS gf180mcu_as_sc_mcu7t3v3__fillcap_4
XFILLER_152_2 VDD VDD VSS VSS gf180mcu_as_sc_mcu7t3v3__fillcap_16
XFILLER_167_1375 VDD VDD VSS VSS gf180mcu_as_sc_mcu7t3v3__fill_2
XFILLER_91_35 VDD VDD VSS VSS gf180mcu_as_sc_mcu7t3v3__fill_2
XTAP_TAPCELL_ROW_161_1789 VDD VSS gf180mcu_as_sc_mcu7t3v3__tap_2
XFILLER_54_1534 VDD VDD VSS VSS gf180mcu_as_sc_mcu7t3v3__fillcap_16
XFILLER_91_68 VDD VDD VSS VSS gf180mcu_as_sc_mcu7t3v3__fill_2
XFILLER_141_1526 VDD VDD VSS VSS gf180mcu_as_sc_mcu7t3v3__fillcap_8
XFILLER_168_552 VDD VDD VSS VSS gf180mcu_as_sc_mcu7t3v3__fillcap_4
XFILLER_168_563 VDD VDD VSS VSS gf180mcu_as_sc_mcu7t3v3__fillcap_16
XFILLER_54_1556 VDD VDD VSS VSS gf180mcu_as_sc_mcu7t3v3__fillcap_8
XFILLER_10_241 VDD VDD VSS VSS gf180mcu_as_sc_mcu7t3v3__fillcap_4
XPHY_EDGE_ROW_54_1_Right_53 VDD VSS gf180mcu_as_sc_mcu7t3v3__tap_2
XFILLER_10_263 VDD VDD VSS VSS gf180mcu_as_sc_mcu7t3v3__fillcap_8
XFILLER_155_279 VDD VDD VSS VSS gf180mcu_as_sc_mcu7t3v3__fill_1
XFILLER_152_942 VDD VDD VSS VSS gf180mcu_as_sc_mcu7t3v3__fill_2
XFILLER_178_1482 VDD VDD VSS VSS gf180mcu_as_sc_mcu7t3v3__fill_2
XPHY_EDGE_ROW_25_1_Left_477 VDD VSS gf180mcu_as_sc_mcu7t3v3__tap_2
XFILLER_123_121 VDD VDD VSS VSS gf180mcu_as_sc_mcu7t3v3__fill_1
XFILLER_139_1466 VDD VDD VSS VSS gf180mcu_as_sc_mcu7t3v3__fillcap_4
XFILLER_174_1346 VDD VDD VSS VSS gf180mcu_as_sc_mcu7t3v3__fillcap_4
XFILLER_151_496 VDD VDD VSS VSS gf180mcu_as_sc_mcu7t3v3__fill_2
XFILLER_34_8 VDD VDD VSS VSS gf180mcu_as_sc_mcu7t3v3__fillcap_16
XFILLER_123_198 VDD VDD VSS VSS gf180mcu_as_sc_mcu7t3v3__fill_1
XFILLER_77_230 VDD VDD VSS VSS gf180mcu_as_sc_mcu7t3v3__fillcap_16
XPHY_EDGE_ROW_104_3_Right_423 VDD VSS gf180mcu_as_sc_mcu7t3v3__tap_2
XTAP_TAPCELL_ROW_91_1_998 VDD VSS gf180mcu_as_sc_mcu7t3v3__tap_2
XFILLER_1_66 VDD VDD VSS VSS gf180mcu_as_sc_mcu7t3v3__fillcap_4
XFILLER_1_88 VDD VDD VSS VSS gf180mcu_as_sc_mcu7t3v3__fillcap_16
XFILLER_92_244 VDD VDD VSS VSS gf180mcu_as_sc_mcu7t3v3__fill_1
XFILLER_92_255 VDD VDD VSS VSS gf180mcu_as_sc_mcu7t3v3__fill_2
XFILLER_33_300 VDD VDD VSS VSS gf180mcu_as_sc_mcu7t3v3__fill_1
XFILLER_92_299 VDD VDD VSS VSS gf180mcu_as_sc_mcu7t3v3__fill_2
XFILLER_98_1483 VDD VDD VSS VSS gf180mcu_as_sc_mcu7t3v3__fill_1
XFILLER_146_1437 VDD VDD VSS VSS gf180mcu_as_sc_mcu7t3v3__fill_2
XFILLER_59_1467 VDD VDD VSS VSS gf180mcu_as_sc_mcu7t3v3__fillcap_16
X_4830_ VDD VDD VSS VSS _5046_/CLK _4830_/D _4830_/Q gf180mcu_as_sc_mcu7t3v3__dfxtp_2
XFILLER_146_1459 VDD VDD VSS VSS gf180mcu_as_sc_mcu7t3v3__fill_2
XFILLER_178_349 VDD VDD VSS VSS gf180mcu_as_sc_mcu7t3v3__fillcap_16
XFILLER_144_1150 VDD VDD VSS VSS gf180mcu_as_sc_mcu7t3v3__fillcap_4
XFILLER_144_1161 VDD VDD VSS VSS gf180mcu_as_sc_mcu7t3v3__fill_2
X_4761_ VDD VDD VSS VSS clkload2/A _4761_/D _4761_/Q gf180mcu_as_sc_mcu7t3v3__dfxtp_2
XFILLER_179_1202 VDD VDD VSS VSS gf180mcu_as_sc_mcu7t3v3__fillcap_8
X_4692_ VDD VDD VSS VSS _4733_/C _5479_/A _5252_/Q _4693_/A gf180mcu_as_sc_mcu7t3v3__mux2_2
X_3712_ VDD VDD VSS VSS _3712_/D _4085_/A _3728_/B _3728_/C _3713_/C gf180mcu_as_sc_mcu7t3v3__ao31_2
X_3643_ VDD VDD VSS VSS _4925_/Q _3740_/B _3741_/C _4013_/D _3644_/D gf180mcu_as_sc_mcu7t3v3__ao22_2
XFILLER_146_279 VDD VDD VSS VSS gf180mcu_as_sc_mcu7t3v3__fillcap_16
XFILLER_161_216 VDD VDD VSS VSS gf180mcu_as_sc_mcu7t3v3__fill_1
X_3574_ VDD VDD VSS VSS _4916_/Q _3799_/B _3770_/C _3940_/A _3576_/C gf180mcu_as_sc_mcu7t3v3__ao22_2
X_2525_ VDD VDD VSS VSS _2771_/A _2525_/A _2632_/B gf180mcu_as_sc_mcu7t3v3__and2_2
X_5244_ VDD VDD VSS VSS clkload7/A _5244_/D _5244_/Q gf180mcu_as_sc_mcu7t3v3__dfxtp_2
X_2456_ VDD VDD VSS VSS _4353_/A _2456_/C _2456_/B _4448_/A gf180mcu_as_sc_mcu7t3v3__aoi21_2
XFILLER_29_18 VDD VDD VSS VSS gf180mcu_as_sc_mcu7t3v3__fillcap_16
X_5175_ VDD VDD VSS VSS _5188_/CLK _5175_/D _5175_/Q gf180mcu_as_sc_mcu7t3v3__dfxtp_2
Xclkbuf_leaf_38_clk_regs VDD VDD VSS VSS clkbuf_3_5_0_clk_regs/Y _5081_/CLK gf180mcu_as_sc_mcu7t3v3__clkbuff_12
XFILLER_68_241 VDD VDD VSS VSS gf180mcu_as_sc_mcu7t3v3__fillcap_4
X_4126_ VDD VDD VSS VSS _4126_/A _4126_/B _4126_/C _4126_/D _4127_/D gf180mcu_as_sc_mcu7t3v3__ao22_2
X_4057_ VDD VDD VSS VSS _4057_/A _4122_/B _4057_/C _4057_/D _4058_/B gf180mcu_as_sc_mcu7t3v3__ao211_2
XFILLER_36_171 VDD VDD VSS VSS gf180mcu_as_sc_mcu7t3v3__fillcap_4
X_3008_ VDD VDD VSS VSS _3176_/S _3989_/A _3991_/A _3010_/B gf180mcu_as_sc_mcu7t3v3__mux2_2
XFILLER_36_193 VDD VDD VSS VSS gf180mcu_as_sc_mcu7t3v3__fillcap_16
XFILLER_38_1518 VDD VDD VSS VSS gf180mcu_as_sc_mcu7t3v3__fillcap_16
XTAP_TAPCELL_ROW_33_1_767 VDD VSS gf180mcu_as_sc_mcu7t3v3__tap_2
XFILLER_101_45 VDD VDD VSS VSS gf180mcu_as_sc_mcu7t3v3__fillcap_8
XFILLER_184_308 VDD VDD VSS VSS gf180mcu_as_sc_mcu7t3v3__fillcap_16
XFILLER_51_196 VDD VDD VSS VSS gf180mcu_as_sc_mcu7t3v3__fill_2
X_4959_ VDD VDD VSS VSS _5146_/CLK _4959_/D _4959_/Q gf180mcu_as_sc_mcu7t3v3__dfxtp_2
XFILLER_178_894 VDD VDD VSS VSS gf180mcu_as_sc_mcu7t3v3__fill_1
XFILLER_101_1521 VDD VDD VSS VSS gf180mcu_as_sc_mcu7t3v3__fillcap_16
XTAP_TAPCELL_ROW_137_1279 VDD VSS gf180mcu_as_sc_mcu7t3v3__tap_2
XTAP_TAPCELL_ROW_137_1268 VDD VSS gf180mcu_as_sc_mcu7t3v3__tap_2
XFILLER_134_920 VDD VDD VSS VSS gf180mcu_as_sc_mcu7t3v3__fillcap_16
XFILLER_10_53 VDD VDD VSS VSS gf180mcu_as_sc_mcu7t3v3__fillcap_16
XTAP_TAPCELL_ROW_121_1_1119 VDD VSS gf180mcu_as_sc_mcu7t3v3__tap_2
XFILLER_156_1076 VDD VDD VSS VSS gf180mcu_as_sc_mcu7t3v3__fillcap_8
XFILLER_161_772 VDD VDD VSS VSS gf180mcu_as_sc_mcu7t3v3__fillcap_16
Xoutput380 VDD VDD VSS VSS _4800_/Q se_out[29] gf180mcu_as_sc_mcu7t3v3__buff_2
XFILLER_105_198 VDD VDD VSS VSS gf180mcu_as_sc_mcu7t3v3__fillcap_4
XFILLER_156_1087 VDD VDD VSS VSS gf180mcu_as_sc_mcu7t3v3__fillcap_16
Xoutput391 VDD VDD VSS VSS _4779_/Q se_out[8] gf180mcu_as_sc_mcu7t3v3__buff_2
XTAP_TAPCELL_ROW_167_1932 VDD VSS gf180mcu_as_sc_mcu7t3v3__tap_2
XTAP_TAPCELL_ROW_167_1921 VDD VSS gf180mcu_as_sc_mcu7t3v3__tap_2
XFILLER_59_241 VDD VDD VSS VSS gf180mcu_as_sc_mcu7t3v3__fillcap_8
XFILLER_134_1396 VDD VDD VSS VSS gf180mcu_as_sc_mcu7t3v3__fillcap_16
XTAP_TAPCELL_ROW_101_1_1039 VDD VSS gf180mcu_as_sc_mcu7t3v3__tap_2
XFILLER_74_255 VDD VDD VSS VSS gf180mcu_as_sc_mcu7t3v3__fillcap_4
XFILLER_15_300 VDD VDD VSS VSS gf180mcu_as_sc_mcu7t3v3__fill_1
XFILLER_74_288 VDD VDD VSS VSS gf180mcu_as_sc_mcu7t3v3__fillcap_8
XFILLER_163_1047 VDD VDD VSS VSS gf180mcu_as_sc_mcu7t3v3__fill_2
XFILLER_35_72 VDD VDD VSS VSS gf180mcu_as_sc_mcu7t3v3__fillcap_16
XFILLER_169_850 VDD VDD VSS VSS gf180mcu_as_sc_mcu7t3v3__fillcap_4
XFILLER_19_1451 VDD VDD VSS VSS gf180mcu_as_sc_mcu7t3v3__fillcap_16
XFILLER_42_174 VDD VDD VSS VSS gf180mcu_as_sc_mcu7t3v3__fill_1
XFILLER_42_196 VDD VDD VSS VSS gf180mcu_as_sc_mcu7t3v3__fill_2
XFILLER_141_1323 VDD VDD VSS VSS gf180mcu_as_sc_mcu7t3v3__fillcap_4
XFILLER_141_1378 VDD VDD VSS VSS gf180mcu_as_sc_mcu7t3v3__fill_1
XFILLER_183_330 VDD VDD VSS VSS gf180mcu_as_sc_mcu7t3v3__fillcap_16
XFILLER_183_352 VDD VDD VSS VSS gf180mcu_as_sc_mcu7t3v3__fillcap_16
XFILLER_184_886 VDD VDD VSS VSS gf180mcu_as_sc_mcu7t3v3__fillcap_8
Xwire463 VDD VDD VSS VSS _2610_/Y wire463/Y gf180mcu_as_sc_mcu7t3v3__buff_8
XTAP_TAPCELL_ROW_50_1_837 VDD VSS gf180mcu_as_sc_mcu7t3v3__tap_2
XFILLER_174_1121 VDD VDD VSS VSS gf180mcu_as_sc_mcu7t3v3__fillcap_4
XFILLER_139_1274 VDD VDD VSS VSS gf180mcu_as_sc_mcu7t3v3__fill_2
XFILLER_151_260 VDD VDD VSS VSS gf180mcu_as_sc_mcu7t3v3__fillcap_16
XFILLER_174_1154 VDD VDD VSS VSS gf180mcu_as_sc_mcu7t3v3__fill_1
X_3290_ VDD VDD VSS VSS _3501_/C _3942_/A _3292_/C gf180mcu_as_sc_mcu7t3v3__and2_2
XFILLER_111_124 VDD VDD VSS VSS gf180mcu_as_sc_mcu7t3v3__fill_2
XFILLER_151_282 VDD VDD VSS VSS gf180mcu_as_sc_mcu7t3v3__fillcap_16
XFILLER_111_146 VDD VDD VSS VSS gf180mcu_as_sc_mcu7t3v3__fill_2
XFILLER_152_1441 VDD VDD VSS VSS gf180mcu_as_sc_mcu7t3v3__fill_2
XPHY_EDGE_ROW_105_3_Right_424 VDD VSS gf180mcu_as_sc_mcu7t3v3__tap_2
XFILLER_65_266 VDD VDD VSS VSS gf180mcu_as_sc_mcu7t3v3__fill_1
XFILLER_18_171 VDD VDD VSS VSS gf180mcu_as_sc_mcu7t3v3__fillcap_4
XFILLER_18_193 VDD VDD VSS VSS gf180mcu_as_sc_mcu7t3v3__fillcap_16
XFILLER_80_247 VDD VDD VSS VSS gf180mcu_as_sc_mcu7t3v3__fillcap_4
XFILLER_179_636 VDD VDD VSS VSS gf180mcu_as_sc_mcu7t3v3__fill_2
XPHY_EDGE_ROW_132_3_Left_266 VDD VSS gf180mcu_as_sc_mcu7t3v3__tap_2
XFILLER_33_174 VDD VDD VSS VSS gf180mcu_as_sc_mcu7t3v3__fillcap_16
X_4813_ VDD VDD VSS VSS _4938_/CLK _4813_/D _4813_/Q gf180mcu_as_sc_mcu7t3v3__dfxtp_2
XFILLER_72_1486 VDD VDD VSS VSS gf180mcu_as_sc_mcu7t3v3__fillcap_16
X_4744_ VDD VDD VSS VSS _4745_/B _4744_/A _5274_/D gf180mcu_as_sc_mcu7t3v3__and2_2
XFILLER_175_853 VDD VDD VSS VSS gf180mcu_as_sc_mcu7t3v3__fillcap_16
XFILLER_119_279 VDD VDD VSS VSS gf180mcu_as_sc_mcu7t3v3__fill_1
X_4675_ VDD VDD VSS VSS _5245_/Q _4685_/C _4681_/C _5246_/Q _4676_/C gf180mcu_as_sc_mcu7t3v3__ao22_2
X_3626_ VDD VDD VSS VSS _4000_/A _3716_/B _3719_/C _4000_/D _3627_/D gf180mcu_as_sc_mcu7t3v3__ao22_2
X_3557_ VDD VDD VSS VSS _3805_/A _3557_/B _3559_/C gf180mcu_as_sc_mcu7t3v3__nand2b_2
XFILLER_102_102 VDD VDD VSS VSS gf180mcu_as_sc_mcu7t3v3__fill_2
XFILLER_143_772 VDD VDD VSS VSS gf180mcu_as_sc_mcu7t3v3__fillcap_16
XFILLER_163_18 VDD VDD VSS VSS gf180mcu_as_sc_mcu7t3v3__fillcap_16
X_2508_ VDD VDD VSS VSS _4739_/B _4739_/A _4643_/A gf180mcu_as_sc_mcu7t3v3__and2_2
X_5227_ VDD VDD VSS VSS clkload9/A _5227_/D _5227_/Q gf180mcu_as_sc_mcu7t3v3__dfxtp_2
Xinput108 VDD VDD VSS VSS ne_in[6] _3984_/D gf180mcu_as_sc_mcu7t3v3__buff_2
X_3488_ VDD VDD VSS VSS _3490_/C _4143_/A _3500_/B _3488_/C gf180mcu_as_sc_mcu7t3v3__ao21_2
Xinput119 VDD VDD VSS VSS north_in[16] _4061_/A gf180mcu_as_sc_mcu7t3v3__buff_2
X_2439_ VDD VDD VSS VSS _4075_/A _2439_/A gf180mcu_as_sc_mcu7t3v3__inv_2
X_5158_ VDD VDD VSS VSS _5159_/CLK _5158_/D _5158_/Q gf180mcu_as_sc_mcu7t3v3__dfxtp_2
XTAP_TAPCELL_ROW_184_2298 VDD VSS gf180mcu_as_sc_mcu7t3v3__tap_2
XFILLER_56_244 VDD VDD VSS VSS gf180mcu_as_sc_mcu7t3v3__fill_1
X_5089_ VDD VDD VSS VSS _5094_/CLK _5089_/D _5089_/Q gf180mcu_as_sc_mcu7t3v3__dfxtp_2
X_4109_ VDD VDD VSS VSS _4109_/A _4126_/B _4126_/C _4109_/D _4110_/D gf180mcu_as_sc_mcu7t3v3__ao22_2
XPHY_EDGE_ROW_64_3_Left_198 VDD VSS gf180mcu_as_sc_mcu7t3v3__tap_2
XFILLER_112_88 VDD VDD VSS VSS gf180mcu_as_sc_mcu7t3v3__fillcap_4
XFILLER_112_99 VDD VDD VSS VSS gf180mcu_as_sc_mcu7t3v3__fillcap_4
XFILLER_164_1323 VDD VDD VSS VSS gf180mcu_as_sc_mcu7t3v3__fill_1
XFILLER_72_37 VDD VDD VSS VSS gf180mcu_as_sc_mcu7t3v3__fill_1
XFILLER_164_1367 VDD VDD VSS VSS gf180mcu_as_sc_mcu7t3v3__fillcap_16
XTAP_TAPCELL_ROW_15_1_696 VDD VSS gf180mcu_as_sc_mcu7t3v3__tap_2
XFILLER_51_1515 VDD VDD VSS VSS gf180mcu_as_sc_mcu7t3v3__fillcap_4
XFILLER_90_1564 VDD VDD VSS VSS gf180mcu_as_sc_mcu7t3v3__fillcap_4
XTAP_TAPCELL_ROW_139_1319 VDD VSS gf180mcu_as_sc_mcu7t3v3__tap_2
XTAP_TAPCELL_ROW_139_1308 VDD VSS gf180mcu_as_sc_mcu7t3v3__tap_2
XFILLER_177_190 VDD VDD VSS VSS gf180mcu_as_sc_mcu7t3v3__fillcap_16
XFILLER_184_138 VDD VDD VSS VSS gf180mcu_as_sc_mcu7t3v3__fillcap_4
XFILLER_51_1537 VDD VDD VSS VSS gf180mcu_as_sc_mcu7t3v3__fillcap_16
XTAP_TAPCELL_ROW_90_1_997 VDD VSS gf180mcu_as_sc_mcu7t3v3__tap_2
XFILLER_165_352 VDD VDD VSS VSS gf180mcu_as_sc_mcu7t3v3__fillcap_16
XFILLER_115_2 VDD VDD VSS VSS gf180mcu_as_sc_mcu7t3v3__fillcap_8
XFILLER_180_311 VDD VDD VSS VSS gf180mcu_as_sc_mcu7t3v3__fillcap_4
XFILLER_181_856 VDD VDD VSS VSS gf180mcu_as_sc_mcu7t3v3__fill_1
XTAP_TAPCELL_ROW_156_1699 VDD VSS gf180mcu_as_sc_mcu7t3v3__tap_2
XTAP_TAPCELL_ROW_156_1688 VDD VSS gf180mcu_as_sc_mcu7t3v3__tap_2
XFILLER_125_249 VDD VDD VSS VSS gf180mcu_as_sc_mcu7t3v3__fill_2
XFILLER_180_333 VDD VDD VSS VSS gf180mcu_as_sc_mcu7t3v3__fillcap_16
XFILLER_133_282 VDD VDD VSS VSS gf180mcu_as_sc_mcu7t3v3__fillcap_4
XFILLER_171_1327 VDD VDD VSS VSS gf180mcu_as_sc_mcu7t3v3__fill_2
XFILLER_49_1499 VDD VDD VSS VSS gf180mcu_as_sc_mcu7t3v3__fillcap_16
XFILLER_136_1469 VDD VDD VSS VSS gf180mcu_as_sc_mcu7t3v3__fillcap_16
XFILLER_47_244 VDD VDD VSS VSS gf180mcu_as_sc_mcu7t3v3__fillcap_16
XFILLER_62_247 VDD VDD VSS VSS gf180mcu_as_sc_mcu7t3v3__fillcap_8
XFILLER_15_174 VDD VDD VSS VSS gf180mcu_as_sc_mcu7t3v3__fillcap_16
XFILLER_182_1478 VDD VDD VSS VSS gf180mcu_as_sc_mcu7t3v3__fillcap_4
XTAP_TAPCELL_ROW_98_1_1028 VDD VSS gf180mcu_as_sc_mcu7t3v3__tap_2
XFILLER_176_639 VDD VDD VSS VSS gf180mcu_as_sc_mcu7t3v3__fillcap_16
XFILLER_62_70 VDD VDD VSS VSS gf180mcu_as_sc_mcu7t3v3__fillcap_16
XFILLER_157_842 VDD VDD VSS VSS gf180mcu_as_sc_mcu7t3v3__fillcap_8
XFILLER_30_166 VDD VDD VSS VSS gf180mcu_as_sc_mcu7t3v3__fill_2
XFILLER_30_177 VDD VDD VSS VSS gf180mcu_as_sc_mcu7t3v3__fillcap_16
XFILLER_62_92 VDD VDD VSS VSS gf180mcu_as_sc_mcu7t3v3__fill_1
X_2790_ VDD VDD VSS VSS _4739_/A _2802_/A _2790_/C _5270_/Q _4732_/B gf180mcu_as_sc_mcu7t3v3__ao22_2
XFILLER_184_650 VDD VDD VSS VSS gf180mcu_as_sc_mcu7t3v3__fill_1
XFILLER_156_374 VDD VDD VSS VSS gf180mcu_as_sc_mcu7t3v3__fill_1
XFILLER_172_823 VDD VDD VSS VSS gf180mcu_as_sc_mcu7t3v3__fillcap_16
XFILLER_176_1216 VDD VDD VSS VSS gf180mcu_as_sc_mcu7t3v3__fill_1
X_4460_ VDD VDD VSS VSS _5173_/Q _4548_/B _4460_/C _4460_/D _5173_/D gf180mcu_as_sc_mcu7t3v3__ao211_2
XFILLER_116_238 VDD VDD VSS VSS gf180mcu_as_sc_mcu7t3v3__fillcap_4
XFILLER_176_1238 VDD VDD VSS VSS gf180mcu_as_sc_mcu7t3v3__fillcap_4
XPHY_EDGE_ROW_17_1_Right_16 VDD VSS gf180mcu_as_sc_mcu7t3v3__tap_2
X_4391_ VDD VDD VSS VSS _4394_/C _4979_/Q _4403_/S gf180mcu_as_sc_mcu7t3v3__nand2b_2
X_3411_ VDD VDD VSS VSS _3442_/B _4063_/A _3412_/D gf180mcu_as_sc_mcu7t3v3__or2_2
XFILLER_131_208 VDD VDD VSS VSS gf180mcu_as_sc_mcu7t3v3__fill_2
X_3342_ VDD VDD VSS VSS _3342_/B _3342_/A _3343_/B gf180mcu_as_sc_mcu7t3v3__or2_2
XFILLER_124_293 VDD VDD VSS VSS gf180mcu_as_sc_mcu7t3v3__fillcap_8
XFILLER_140_731 VDD VDD VSS VSS gf180mcu_as_sc_mcu7t3v3__fillcap_4
XFILLER_97_122 VDD VDD VSS VSS gf180mcu_as_sc_mcu7t3v3__fillcap_4
Xfanout809 VDD VDD VSS VSS input180/Y _3909_/A gf180mcu_as_sc_mcu7t3v3__buff_2
XFILLER_97_166 VDD VDD VSS VSS gf180mcu_as_sc_mcu7t3v3__fillcap_4
X_3273_ VDD VDD VSS VSS _3933_/A _3501_/C _3503_/B _3933_/D _3274_/D gf180mcu_as_sc_mcu7t3v3__ao22_2
X_5012_ VDD VDD VSS VSS _5080_/CLK _5012_/D _5012_/Q gf180mcu_as_sc_mcu7t3v3__dfxtp_2
Xhold1007 VDD VDD VSS VSS _2585_/Y _2586_/A gf180mcu_as_sc_mcu7t3v3__buff_2
Xhold1018 VDD VDD VSS VSS hold1051/Y _4963_/D gf180mcu_as_sc_mcu7t3v3__buff_2
Xhold1029 VDD VDD VSS VSS _4951_/Q _2477_/B gf180mcu_as_sc_mcu7t3v3__buff_2
XPHY_EDGE_ROW_106_3_Right_425 VDD VSS gf180mcu_as_sc_mcu7t3v3__tap_2
XFILLER_38_299 VDD VDD VSS VSS gf180mcu_as_sc_mcu7t3v3__fill_2
XFILLER_179_400 VDD VDD VSS VSS gf180mcu_as_sc_mcu7t3v3__fillcap_16
XFILLER_179_422 VDD VDD VSS VSS gf180mcu_as_sc_mcu7t3v3__fillcap_16
XFILLER_146_1053 VDD VDD VSS VSS gf180mcu_as_sc_mcu7t3v3__fill_2
XFILLER_167_606 VDD VDD VSS VSS gf180mcu_as_sc_mcu7t3v3__fill_2
XPHY_EDGE_ROW_102_1_Left_554 VDD VSS gf180mcu_as_sc_mcu7t3v3__tap_2
X_2988_ VDD VDD VSS VSS _2989_/C _2988_/C _3150_/C _3965_/A gf180mcu_as_sc_mcu7t3v3__aoi21_2
XTAP_TAPCELL_ROW_11_1_680 VDD VSS gf180mcu_as_sc_mcu7t3v3__tap_2
XFILLER_147_352 VDD VDD VSS VSS gf180mcu_as_sc_mcu7t3v3__fillcap_16
XFILLER_159_190 VDD VDD VSS VSS gf180mcu_as_sc_mcu7t3v3__fillcap_16
X_4727_ VDD VDD VSS VSS _5264_/D _5109_/Q _4731_/B _4727_/C gf180mcu_as_sc_mcu7t3v3__ao21_2
XFILLER_11_1521 VDD VDD VSS VSS gf180mcu_as_sc_mcu7t3v3__fillcap_16
XFILLER_147_374 VDD VDD VSS VSS gf180mcu_as_sc_mcu7t3v3__fill_1
XFILLER_159_1436 VDD VDD VSS VSS gf180mcu_as_sc_mcu7t3v3__fill_1
XFILLER_174_171 VDD VDD VSS VSS gf180mcu_as_sc_mcu7t3v3__fillcap_4
XFILLER_175_683 VDD VDD VSS VSS gf180mcu_as_sc_mcu7t3v3__fillcap_4
X_4658_ VDD VDD VSS VSS _4658_/B _4659_/B _4660_/B gf180mcu_as_sc_mcu7t3v3__and2_2
XTAP_TAPCELL_ROW_134_1205 VDD VSS gf180mcu_as_sc_mcu7t3v3__tap_2
XFILLER_174_193 VDD VDD VSS VSS gf180mcu_as_sc_mcu7t3v3__fillcap_16
Xinput90 VDD VDD VSS VSS ne_in[20] _4093_/A gf180mcu_as_sc_mcu7t3v3__buff_2
X_3609_ VDD VDD VSS VSS _3983_/A _3716_/B _3716_/C _3982_/A _3610_/C gf180mcu_as_sc_mcu7t3v3__ao22_2
XFILLER_107_22 VDD VDD VSS VSS gf180mcu_as_sc_mcu7t3v3__fill_1
XFILLER_157_1160 VDD VDD VSS VSS gf180mcu_as_sc_mcu7t3v3__fill_2
X_4589_ VDD VDD VSS VSS _4592_/C _4589_/B _4589_/A gf180mcu_as_sc_mcu7t3v3__nor2_2
XTAP_TAPCELL_ROW_151_1574 VDD VSS gf180mcu_as_sc_mcu7t3v3__tap_2
XFILLER_107_66 VDD VDD VSS VSS gf180mcu_as_sc_mcu7t3v3__fillcap_4
XFILLER_115_282 VDD VDD VSS VSS gf180mcu_as_sc_mcu7t3v3__fillcap_16
XFILLER_162_399 VDD VDD VSS VSS gf180mcu_as_sc_mcu7t3v3__fillcap_16
XTAP_TAPCELL_ROW_151_1585 VDD VSS gf180mcu_as_sc_mcu7t3v3__tap_2
XFILLER_107_88 VDD VDD VSS VSS gf180mcu_as_sc_mcu7t3v3__fillcap_4
XFILLER_130_241 VDD VDD VSS VSS gf180mcu_as_sc_mcu7t3v3__fillcap_4
XFILLER_130_263 VDD VDD VSS VSS gf180mcu_as_sc_mcu7t3v3__fill_2
XFILLER_88_177 VDD VDD VSS VSS gf180mcu_as_sc_mcu7t3v3__fill_1
XFILLER_88_188 VDD VDD VSS VSS gf180mcu_as_sc_mcu7t3v3__fillcap_8
XTAP_TAPCELL_ROW_8_1_668 VDD VSS gf180mcu_as_sc_mcu7t3v3__tap_2
XFILLER_29_244 VDD VDD VSS VSS gf180mcu_as_sc_mcu7t3v3__fillcap_16
XFILLER_123_65 VDD VDD VSS VSS gf180mcu_as_sc_mcu7t3v3__fillcap_4
XPHY_EDGE_ROW_63_1_Right_62 VDD VSS gf180mcu_as_sc_mcu7t3v3__tap_2
XFILLER_166_1407 VDD VDD VSS VSS gf180mcu_as_sc_mcu7t3v3__fillcap_16
XFILLER_44_247 VDD VDD VSS VSS gf180mcu_as_sc_mcu7t3v3__fillcap_16
XPHY_EDGE_ROW_34_1_Left_486 VDD VSS gf180mcu_as_sc_mcu7t3v3__tap_2
XFILLER_16_85 VDD VDD VSS VSS gf180mcu_as_sc_mcu7t3v3__fillcap_16
Xsram2048.u_bank1_821 VDD VDD VSS VSS sram2048.u_bank1/WEN[3] gf180mcu_as_sc_mcu7t3v3__tiel_4
XFILLER_160_1017 VDD VDD VSS VSS gf180mcu_as_sc_mcu7t3v3__fill_2
XTAP_TAPCELL_ROW_158_1728 VDD VSS gf180mcu_as_sc_mcu7t3v3__tap_2
XFILLER_12_155 VDD VDD VSS VSS gf180mcu_as_sc_mcu7t3v3__fillcap_16
XFILLER_139_842 VDD VDD VSS VSS gf180mcu_as_sc_mcu7t3v3__fill_2
XTAP_TAPCELL_ROW_158_1739 VDD VSS gf180mcu_as_sc_mcu7t3v3__tap_2
XFILLER_12_199 VDD VDD VSS VSS gf180mcu_as_sc_mcu7t3v3__fillcap_16
XFILLER_153_344 VDD VDD VSS VSS gf180mcu_as_sc_mcu7t3v3__fillcap_4
XFILLER_113_208 VDD VDD VSS VSS gf180mcu_as_sc_mcu7t3v3__fill_2
XFILLER_106_293 VDD VDD VSS VSS gf180mcu_as_sc_mcu7t3v3__fillcap_8
XFILLER_79_133 VDD VDD VSS VSS gf180mcu_as_sc_mcu7t3v3__fillcap_4
XTAP_TAPCELL_ROW_20_1_715 VDD VSS gf180mcu_as_sc_mcu7t3v3__tap_2
XFILLER_171_1157 VDD VDD VSS VSS gf180mcu_as_sc_mcu7t3v3__fillcap_4
XFILLER_136_1288 VDD VDD VSS VSS gf180mcu_as_sc_mcu7t3v3__fillcap_4
XFILLER_79_188 VDD VDD VSS VSS gf180mcu_as_sc_mcu7t3v3__fillcap_8
XFILLER_94_103 VDD VDD VSS VSS gf180mcu_as_sc_mcu7t3v3__fill_2
XFILLER_97_1515 VDD VDD VSS VSS gf180mcu_as_sc_mcu7t3v3__fillcap_4
XFILLER_97_1537 VDD VDD VSS VSS gf180mcu_as_sc_mcu7t3v3__fillcap_16
XFILLER_169_1086 VDD VDD VSS VSS gf180mcu_as_sc_mcu7t3v3__fill_1
X_3960_ VDD VDD VSS VSS _3960_/A _4103_/B _3960_/C _3960_/D _3961_/C gf180mcu_as_sc_mcu7t3v3__ao211_2
XFILLER_147_1351 VDD VDD VSS VSS gf180mcu_as_sc_mcu7t3v3__fillcap_4
X_2911_ VDD VDD VSS VSS _3253_/A _3254_/A _3255_/B gf180mcu_as_sc_mcu7t3v3__or2_2
XFILLER_149_628 VDD VDD VSS VSS gf180mcu_as_sc_mcu7t3v3__fill_2
XFILLER_176_403 VDD VDD VSS VSS gf180mcu_as_sc_mcu7t3v3__fillcap_16
X_3891_ VDD VDD VSS VSS _3905_/B _5181_/Q _4931_/D gf180mcu_as_sc_mcu7t3v3__and2_2
XFILLER_177_948 VDD VDD VSS VSS gf180mcu_as_sc_mcu7t3v3__fill_1
X_2842_ VDD VDD VSS VSS _2842_/A _2842_/B _2842_/C _2842_/D _4290_/B gf180mcu_as_sc_mcu7t3v3__ao22_2
XFILLER_78_2 VDD VDD VSS VSS gf180mcu_as_sc_mcu7t3v3__fillcap_16
X_2773_ VDD VDD VSS VSS _4259_/B _2773_/B _5229_/Q gf180mcu_as_sc_mcu7t3v3__nor2_2
XFILLER_156_171 VDD VDD VSS VSS gf180mcu_as_sc_mcu7t3v3__fillcap_4
X_4512_ VDD VDD VSS VSS _4513_/D _4512_/B _4547_/A gf180mcu_as_sc_mcu7t3v3__nor2_2
XFILLER_156_193 VDD VDD VSS VSS gf180mcu_as_sc_mcu7t3v3__fillcap_16
XFILLER_176_1013 VDD VDD VSS VSS gf180mcu_as_sc_mcu7t3v3__fill_2
XFILLER_160_837 VDD VDD VSS VSS gf180mcu_as_sc_mcu7t3v3__fillcap_4
XFILLER_171_174 VDD VDD VSS VSS gf180mcu_as_sc_mcu7t3v3__fillcap_16
X_4443_ VDD VDD VSS VSS _5173_/Q _4590_/B _4590_/C _5123_/Q _4444_/B gf180mcu_as_sc_mcu7t3v3__ao22_2
XTAP_TAPCELL_ROW_122_1_1124 VDD VSS gf180mcu_as_sc_mcu7t3v3__tap_2
Xfanout606 VDD VDD VSS VSS _3563_/Y _3749_/B gf180mcu_as_sc_mcu7t3v3__buff_2
X_4374_ VDD VDD VSS VSS _4379_/B _4374_/B _5162_/Q _5162_/D gf180mcu_as_sc_mcu7t3v3__mux2_2
Xfanout617 VDD VDD VSS VSS _3267_/Y fanout617/Y gf180mcu_as_sc_mcu7t3v3__buff_2
Xfanout628 VDD VDD VSS VSS fanout631/Y _3150_/C gf180mcu_as_sc_mcu7t3v3__buff_2
Xfanout639 VDD VDD VSS VSS _4607_/C _4629_/C gf180mcu_as_sc_mcu7t3v3__buff_2
X_3325_ VDD VDD VSS VSS _3976_/A _3453_/B _3453_/C _3977_/A _3326_/C gf180mcu_as_sc_mcu7t3v3__ao22_2
XFILLER_112_263 VDD VDD VSS VSS gf180mcu_as_sc_mcu7t3v3__fillcap_4
XFILLER_154_1399 VDD VDD VSS VSS gf180mcu_as_sc_mcu7t3v3__fillcap_16
X_3256_ VDD VDD VSS VSS _3268_/A _3519_/C _3510_/C _3517_/D _3271_/A gf180mcu_as_sc_mcu7t3v3__nand4_2
XFILLER_85_158 VDD VDD VSS VSS gf180mcu_as_sc_mcu7t3v3__fill_2
XTAP_TAPCELL_ROW_181_2246 VDD VSS gf180mcu_as_sc_mcu7t3v3__tap_2
XTAP_TAPCELL_ROW_181_2235 VDD VSS gf180mcu_as_sc_mcu7t3v3__tap_2
XTAP_TAPCELL_ROW_102_1_1044 VDD VSS gf180mcu_as_sc_mcu7t3v3__tap_2
XPHY_EDGE_ROW_107_3_Right_426 VDD VSS gf180mcu_as_sc_mcu7t3v3__tap_2
X_3187_ VDD VDD VSS VSS _3223_/B _3236_/B _3201_/C _3235_/B gf180mcu_as_sc_mcu7t3v3__nand3_2
XTAP_TAPCELL_ROW_4_1_652 VDD VSS gf180mcu_as_sc_mcu7t3v3__tap_2
XFILLER_26_225 VDD VDD VSS VSS gf180mcu_as_sc_mcu7t3v3__fillcap_16
XFILLER_26_247 VDD VDD VSS VSS gf180mcu_as_sc_mcu7t3v3__fillcap_16
XFILLER_41_228 VDD VDD VSS VSS gf180mcu_as_sc_mcu7t3v3__fillcap_16
XTAP_TAPCELL_ROW_179_2197 VDD VSS gf180mcu_as_sc_mcu7t3v3__tap_2
XTAP_TAPCELL_ROW_179_2186 VDD VSS gf180mcu_as_sc_mcu7t3v3__tap_2
XFILLER_183_907 VDD VDD VSS VSS gf180mcu_as_sc_mcu7t3v3__fill_2
XFILLER_148_683 VDD VDD VSS VSS gf180mcu_as_sc_mcu7t3v3__fillcap_4
XTAP_TAPCELL_ROW_153_1625 VDD VSS gf180mcu_as_sc_mcu7t3v3__tap_2
XTAP_TAPCELL_ROW_153_1614 VDD VSS gf180mcu_as_sc_mcu7t3v3__tap_2
XFILLER_135_366 VDD VDD VSS VSS gf180mcu_as_sc_mcu7t3v3__fill_1
XFILLER_136_889 VDD VDD VSS VSS gf180mcu_as_sc_mcu7t3v3__fillcap_4
XFILLER_150_303 VDD VDD VSS VSS gf180mcu_as_sc_mcu7t3v3__fill_2
XFILLER_150_314 VDD VDD VSS VSS gf180mcu_as_sc_mcu7t3v3__fill_1
XFILLER_155_1119 VDD VDD VSS VSS gf180mcu_as_sc_mcu7t3v3__fill_1
XTAP_TAPCELL_ROW_60_1_875 VDD VSS gf180mcu_as_sc_mcu7t3v3__tap_2
XFILLER_137_1520 VDD VDD VSS VSS gf180mcu_as_sc_mcu7t3v3__fill_2
XFILLER_137_1542 VDD VDD VSS VSS gf180mcu_as_sc_mcu7t3v3__fill_2
XTAP_TAPCELL_ROW_170_1994 VDD VSS gf180mcu_as_sc_mcu7t3v3__tap_2
XFILLER_103_241 VDD VDD VSS VSS gf180mcu_as_sc_mcu7t3v3__fillcap_8
XFILLER_150_358 VDD VDD VSS VSS gf180mcu_as_sc_mcu7t3v3__fill_1
XFILLER_172_1433 VDD VDD VSS VSS gf180mcu_as_sc_mcu7t3v3__fill_2
XFILLER_76_103 VDD VDD VSS VSS gf180mcu_as_sc_mcu7t3v3__fill_2
XFILLER_182_2 VDD VDD VSS VSS gf180mcu_as_sc_mcu7t3v3__fillcap_16
XFILLER_91_139 VDD VDD VSS VSS gf180mcu_as_sc_mcu7t3v3__fill_1
XFILLER_57_1521 VDD VDD VSS VSS gf180mcu_as_sc_mcu7t3v3__fillcap_16
XFILLER_144_1524 VDD VDD VSS VSS gf180mcu_as_sc_mcu7t3v3__fillcap_16
XFILLER_159_50 VDD VDD VSS VSS gf180mcu_as_sc_mcu7t3v3__fillcap_16
XFILLER_43_72 VDD VDD VSS VSS gf180mcu_as_sc_mcu7t3v3__fillcap_16
XFILLER_139_650 VDD VDD VSS VSS gf180mcu_as_sc_mcu7t3v3__fill_2
XFILLER_159_72 VDD VDD VSS VSS gf180mcu_as_sc_mcu7t3v3__fillcap_16
XFILLER_43_94 VDD VDD VSS VSS gf180mcu_as_sc_mcu7t3v3__fill_1
XFILLER_139_694 VDD VDD VSS VSS gf180mcu_as_sc_mcu7t3v3__fillcap_4
XFILLER_166_480 VDD VDD VSS VSS gf180mcu_as_sc_mcu7t3v3__fillcap_16
XFILLER_154_675 VDD VDD VSS VSS gf180mcu_as_sc_mcu7t3v3__fillcap_4
XFILLER_177_1377 VDD VDD VSS VSS gf180mcu_as_sc_mcu7t3v3__fill_2
XPHY_EDGE_ROW_89_3_Left_223 VDD VSS gf180mcu_as_sc_mcu7t3v3__tap_2
XFILLER_181_494 VDD VDD VSS VSS gf180mcu_as_sc_mcu7t3v3__fill_1
XFILLER_150_870 VDD VDD VSS VSS gf180mcu_as_sc_mcu7t3v3__fillcap_4
XFILLER_151_1539 VDD VDD VSS VSS gf180mcu_as_sc_mcu7t3v3__fill_1
X_3110_ VDD VDD VSS VSS _3121_/B _4934_/Q _3113_/C gf180mcu_as_sc_mcu7t3v3__or2_2
XFILLER_68_91 VDD VDD VSS VSS gf180mcu_as_sc_mcu7t3v3__fill_1
X_4090_ VDD VDD VSS VSS _4091_/C _4090_/B _4090_/A gf180mcu_as_sc_mcu7t3v3__nor2_2
Xinput280 VDD VDD VSS VSS sw_in[7] _3994_/A gf180mcu_as_sc_mcu7t3v3__buff_2
X_3041_ VDD VDD VSS VSS _4781_/D _3041_/C _3132_/B _3647_/A gf180mcu_as_sc_mcu7t3v3__aoi21_2
XFILLER_149_1402 VDD VDD VSS VSS gf180mcu_as_sc_mcu7t3v3__fillcap_4
Xinput291 VDD VDD VSS VSS west_in[17] _4069_/D gf180mcu_as_sc_mcu7t3v3__buff_2
XFILLER_149_1435 VDD VDD VSS VSS gf180mcu_as_sc_mcu7t3v3__fillcap_4
XFILLER_23_206 VDD VDD VSS VSS gf180mcu_as_sc_mcu7t3v3__fillcap_4
XFILLER_23_228 VDD VDD VSS VSS gf180mcu_as_sc_mcu7t3v3__fillcap_16
XPHY_EDGE_ROW_31_3_Right_350 VDD VSS gf180mcu_as_sc_mcu7t3v3__tap_2
X_4992_ VDD VDD VSS VSS _5172_/CLK _4992_/D _4992_/Q gf180mcu_as_sc_mcu7t3v3__dfxtp_2
X_3943_ VDD VDD VSS VSS _3944_/D _3943_/C _4163_/B _3943_/A gf180mcu_as_sc_mcu7t3v3__aoi21_2
XFILLER_143_1045 VDD VDD VSS VSS gf180mcu_as_sc_mcu7t3v3__fillcap_4
XFILLER_177_723 VDD VDD VSS VSS gf180mcu_as_sc_mcu7t3v3__fillcap_8
XFILLER_182_1083 VDD VDD VSS VSS gf180mcu_as_sc_mcu7t3v3__fill_2
X_3874_ VDD VDD VSS VSS _3874_/B _3874_/A _3874_/Y gf180mcu_as_sc_mcu7t3v3__and2_2
XFILLER_143_1067 VDD VDD VSS VSS gf180mcu_as_sc_mcu7t3v3__fillcap_4
XFILLER_165_929 VDD VDD VSS VSS gf180mcu_as_sc_mcu7t3v3__fillcap_16
X_2825_ VDD VDD VSS VSS _4751_/A _2825_/B _5280_/Q _5279_/D gf180mcu_as_sc_mcu7t3v3__mux2_2
XFILLER_117_300 VDD VDD VSS VSS gf180mcu_as_sc_mcu7t3v3__fill_1
XFILLER_178_1108 VDD VDD VSS VSS gf180mcu_as_sc_mcu7t3v3__fill_1
XFILLER_178_1119 VDD VDD VSS VSS gf180mcu_as_sc_mcu7t3v3__fill_1
XTAP_TAPCELL_ROW_174_2094 VDD VSS gf180mcu_as_sc_mcu7t3v3__tap_2
XTAP_TAPCELL_ROW_174_2083 VDD VSS gf180mcu_as_sc_mcu7t3v3__tap_2
X_2756_ VDD VDD VSS VSS _4627_/A _4652_/B _2766_/C gf180mcu_as_sc_mcu7t3v3__and2_2
XFILLER_173_984 VDD VDD VSS VSS gf180mcu_as_sc_mcu7t3v3__fill_1
X_2687_ VDD VDD VSS VSS _2717_/S _5174_/Q _5166_/Q _2690_/B gf180mcu_as_sc_mcu7t3v3__mux2_2
X_4426_ VDD VDD VSS VSS _4426_/B _4506_/A _4433_/C gf180mcu_as_sc_mcu7t3v3__and2_2
XTAP_TAPCELL_ROW_74_3_2460 VDD VSS gf180mcu_as_sc_mcu7t3v3__tap_2
XFILLER_160_667 VDD VDD VSS VSS gf180mcu_as_sc_mcu7t3v3__fillcap_16
XFILLER_141_892 VDD VDD VSS VSS gf180mcu_as_sc_mcu7t3v3__fill_2
XFILLER_171_18 VDD VDD VSS VSS gf180mcu_as_sc_mcu7t3v3__fillcap_16
X_4357_ VDD VDD VSS VSS _5480_/A _4566_/C _4357_/C _4357_/D _4358_/B gf180mcu_as_sc_mcu7t3v3__ao211_2
Xfanout469 VDD VDD VSS VSS _4223_/C _4219_/C gf180mcu_as_sc_mcu7t3v3__buff_2
X_4288_ VDD VDD VSS VSS _4289_/S _5484_/A _5122_/Q _5122_/D gf180mcu_as_sc_mcu7t3v3__mux2_2
X_3308_ VDD VDD VSS VSS _3502_/B _3956_/A _3308_/A _3310_/B gf180mcu_as_sc_mcu7t3v3__mux2_2
XFILLER_104_34 VDD VDD VSS VSS gf180mcu_as_sc_mcu7t3v3__fill_1
Xmesh_tile_862 VDD VDD VSS VSS north_out[3] gf180mcu_as_sc_mcu7t3v3__tiel_4
Xmesh_tile_851 VDD VDD VSS VSS ne_out[26] gf180mcu_as_sc_mcu7t3v3__tiel_4
Xmesh_tile_840 VDD VDD VSS VSS ne_out[15] gf180mcu_as_sc_mcu7t3v3__tiel_4
X_3239_ VDD VDD VSS VSS _3240_/D _3521_/A _3239_/A gf180mcu_as_sc_mcu7t3v3__nor2b_2
XFILLER_132_1483 VDD VDD VSS VSS gf180mcu_as_sc_mcu7t3v3__fill_1
XFILLER_132_1494 VDD VDD VSS VSS gf180mcu_as_sc_mcu7t3v3__fillcap_4
XFILLER_73_139 VDD VDD VSS VSS gf180mcu_as_sc_mcu7t3v3__fill_1
Xmesh_tile_895 VDD VDD VSS VSS nw_out[2] gf180mcu_as_sc_mcu7t3v3__tiel_4
Xmesh_tile_884 VDD VDD VSS VSS north_out[25] gf180mcu_as_sc_mcu7t3v3__tiel_4
Xmesh_tile_873 VDD VDD VSS VSS north_out[14] gf180mcu_as_sc_mcu7t3v3__tiel_4
XTAP_TAPCELL_ROW_146_1473 VDD VSS gf180mcu_as_sc_mcu7t3v3__tap_2
XTAP_TAPCELL_ROW_146_1462 VDD VSS gf180mcu_as_sc_mcu7t3v3__tap_2
XFILLER_64_49 VDD VDD VSS VSS gf180mcu_as_sc_mcu7t3v3__fillcap_4
XPHY_EDGE_ROW_108_3_Right_427 VDD VSS gf180mcu_as_sc_mcu7t3v3__tap_2
XFILLER_167_1568 VDD VDD VSS VSS gf180mcu_as_sc_mcu7t3v3__fill_1
XFILLER_81_172 VDD VDD VSS VSS gf180mcu_as_sc_mcu7t3v3__fill_1
XFILLER_120_33 VDD VDD VSS VSS gf180mcu_as_sc_mcu7t3v3__fill_2
XTAP_TAPCELL_ROW_99_1_1033 VDD VSS gf180mcu_as_sc_mcu7t3v3__tap_2
XFILLER_120_88 VDD VDD VSS VSS gf180mcu_as_sc_mcu7t3v3__fillcap_4
XFILLER_168_723 VDD VDD VSS VSS gf180mcu_as_sc_mcu7t3v3__fillcap_8
XFILLER_80_37 VDD VDD VSS VSS gf180mcu_as_sc_mcu7t3v3__fill_1
XFILLER_167_244 VDD VDD VSS VSS gf180mcu_as_sc_mcu7t3v3__fillcap_8
XFILLER_52_1451 VDD VDD VSS VSS gf180mcu_as_sc_mcu7t3v3__fillcap_16
XFILLER_108_300 VDD VDD VSS VSS gf180mcu_as_sc_mcu7t3v3__fill_1
XFILLER_182_225 VDD VDD VSS VSS gf180mcu_as_sc_mcu7t3v3__fillcap_16
XFILLER_164_940 VDD VDD VSS VSS gf180mcu_as_sc_mcu7t3v3__fillcap_4
XFILLER_182_247 VDD VDD VSS VSS gf180mcu_as_sc_mcu7t3v3__fillcap_4
XFILLER_151_601 VDD VDD VSS VSS gf180mcu_as_sc_mcu7t3v3__fillcap_4
XFILLER_159_1052 VDD VDD VSS VSS gf180mcu_as_sc_mcu7t3v3__fillcap_8
XFILLER_174_1539 VDD VDD VSS VSS gf180mcu_as_sc_mcu7t3v3__fillcap_16
XFILLER_8_2 VDD VDD VSS VSS gf180mcu_as_sc_mcu7t3v3__fillcap_16
XFILLER_150_177 VDD VDD VSS VSS gf180mcu_as_sc_mcu7t3v3__fillcap_16
XFILLER_1_198 VDD VDD VSS VSS gf180mcu_as_sc_mcu7t3v3__fillcap_4
XPHY_EDGE_ROW_70_3_Right_389 VDD VSS gf180mcu_as_sc_mcu7t3v3__tap_2
XFILLER_24_1564 VDD VDD VSS VSS gf180mcu_as_sc_mcu7t3v3__fillcap_4
XFILLER_49_158 VDD VDD VSS VSS gf180mcu_as_sc_mcu7t3v3__fill_2
XFILLER_94_1518 VDD VDD VSS VSS gf180mcu_as_sc_mcu7t3v3__fillcap_16
XFILLER_72_172 VDD VDD VSS VSS gf180mcu_as_sc_mcu7t3v3__fill_2
XPHY_EDGE_ROW_26_1_Right_25 VDD VSS gf180mcu_as_sc_mcu7t3v3__tap_2
XFILLER_20_209 VDD VDD VSS VSS gf180mcu_as_sc_mcu7t3v3__fillcap_16
XFILLER_144_1387 VDD VDD VSS VSS gf180mcu_as_sc_mcu7t3v3__fillcap_8
XFILLER_147_907 VDD VDD VSS VSS gf180mcu_as_sc_mcu7t3v3__fill_2
XFILLER_158_233 VDD VDD VSS VSS gf180mcu_as_sc_mcu7t3v3__fillcap_8
XTAP_TAPCELL_ROW_80_3_2470 VDD VSS gf180mcu_as_sc_mcu7t3v3__tap_2
XFILLER_140_1229 VDD VDD VSS VSS gf180mcu_as_sc_mcu7t3v3__fill_1
XFILLER_174_726 VDD VDD VSS VSS gf180mcu_as_sc_mcu7t3v3__fillcap_8
XFILLER_174_748 VDD VDD VSS VSS gf180mcu_as_sc_mcu7t3v3__fill_1
XFILLER_179_1428 VDD VDD VSS VSS gf180mcu_as_sc_mcu7t3v3__fillcap_4
XFILLER_9_276 VDD VDD VSS VSS gf180mcu_as_sc_mcu7t3v3__fillcap_4
XFILLER_174_759 VDD VDD VSS VSS gf180mcu_as_sc_mcu7t3v3__fillcap_4
XFILLER_9_298 VDD VDD VSS VSS gf180mcu_as_sc_mcu7t3v3__fill_2
Xclkload13 VDD VDD VSS VSS _5185_/CLK clkload13/Y gf180mcu_as_sc_mcu7t3v3__clkbuff_4
Xclkload24 VDD VDD VSS VSS clkload24/Y _5173_/CLK gf180mcu_as_sc_mcu7t3v3__inv_2
X_3590_ VDD VDD VSS VSS _3960_/A _3741_/B _3590_/C _3590_/D _3592_/C gf180mcu_as_sc_mcu7t3v3__ao211_2
X_2610_ VDD VDD VSS VSS _2730_/A _2610_/B _2610_/A _2610_/Y gf180mcu_as_sc_mcu7t3v3__mux2_2
XFILLER_138_1103 VDD VDD VSS VSS gf180mcu_as_sc_mcu7t3v3__fillcap_4
XFILLER_155_962 VDD VDD VSS VSS gf180mcu_as_sc_mcu7t3v3__fill_1
XFILLER_155_973 VDD VDD VSS VSS gf180mcu_as_sc_mcu7t3v3__fillcap_4
X_2541_ VDD VDD VSS VSS _4719_/A _2541_/B _2541_/C _5277_/Q _2541_/Y gf180mcu_as_sc_mcu7t3v3__ao22_2
XFILLER_138_1136 VDD VDD VSS VSS gf180mcu_as_sc_mcu7t3v3__fillcap_4
X_5260_ VDD VDD VSS VSS _5266_/CLK _5260_/D _5260_/Q gf180mcu_as_sc_mcu7t3v3__dfxtp_2
X_2472_ VDD VDD VSS VSS _4362_/B _2472_/C _2472_/B _4448_/A gf180mcu_as_sc_mcu7t3v3__aoi21_2
XFILLER_141_144 VDD VDD VSS VSS gf180mcu_as_sc_mcu7t3v3__fill_1
XFILLER_142_667 VDD VDD VSS VSS gf180mcu_as_sc_mcu7t3v3__fillcap_8
XFILLER_87_209 VDD VDD VSS VSS gf180mcu_as_sc_mcu7t3v3__fill_1
XPHY_EDGE_ROW_59_1_Left_511 VDD VSS gf180mcu_as_sc_mcu7t3v3__tap_2
X_4211_ VDD VDD VSS VSS _4240_/B _4218_/B _4221_/C _5047_/Q _5047_/D gf180mcu_as_sc_mcu7t3v3__ao22_2
XFILLER_142_689 VDD VDD VSS VSS gf180mcu_as_sc_mcu7t3v3__fillcap_4
XFILLER_151_1303 VDD VDD VSS VSS gf180mcu_as_sc_mcu7t3v3__fillcap_16
XFILLER_155_1450 VDD VDD VSS VSS gf180mcu_as_sc_mcu7t3v3__fillcap_16
XFILLER_155_1472 VDD VDD VSS VSS gf180mcu_as_sc_mcu7t3v3__fillcap_16
X_5191_ VDD VDD VSS VSS clkload4/A _5191_/D _5191_/Q gf180mcu_as_sc_mcu7t3v3__dfxtp_2
XFILLER_116_1467 VDD VDD VSS VSS gf180mcu_as_sc_mcu7t3v3__fillcap_16
XPHY_EDGE_ROW_111_1_Left_563 VDD VSS gf180mcu_as_sc_mcu7t3v3__tap_2
X_4142_ VDD VDD VSS VSS _5003_/Q _4166_/B _4254_/B _4166_/D _5003_/D gf180mcu_as_sc_mcu7t3v3__ao22_2
X_4073_ VDD VDD VSS VSS _4073_/A _4105_/B _4073_/C _4073_/D _4074_/B gf180mcu_as_sc_mcu7t3v3__ao211_2
XFILLER_55_139 VDD VDD VSS VSS gf180mcu_as_sc_mcu7t3v3__fill_1
Xclkbuf_3_4_0_clk_regs VDD VDD VSS VSS clkbuf_0_clk_regs/Y clkbuf_3_4_0_clk_regs/Y
+ gf180mcu_as_sc_mcu7t3v3__clkbuff_12
X_3024_ VDD VDD VSS VSS _3031_/B _3130_/B _4009_/A gf180mcu_as_sc_mcu7t3v3__nand2_2
XTAP_TAPCELL_ROW_51_1_839 VDD VSS gf180mcu_as_sc_mcu7t3v3__tap_2
XFILLER_149_1243 VDD VDD VSS VSS gf180mcu_as_sc_mcu7t3v3__fill_2
XFILLER_63_150 VDD VDD VSS VSS gf180mcu_as_sc_mcu7t3v3__fillcap_4
XFILLER_149_1298 VDD VDD VSS VSS gf180mcu_as_sc_mcu7t3v3__fillcap_16
XFILLER_169_509 VDD VDD VSS VSS gf180mcu_as_sc_mcu7t3v3__fillcap_8
XFILLER_184_1189 VDD VDD VSS VSS gf180mcu_as_sc_mcu7t3v3__fill_1
XFILLER_75_1451 VDD VDD VSS VSS gf180mcu_as_sc_mcu7t3v3__fillcap_16
XPHY_EDGE_ROW_32_3_Right_351 VDD VSS gf180mcu_as_sc_mcu7t3v3__tap_2
X_4975_ VDD VDD VSS VSS clkload4/A _4975_/D _4975_/Q gf180mcu_as_sc_mcu7t3v3__dfxtp_2
XFILLER_149_200 VDD VDD VSS VSS gf180mcu_as_sc_mcu7t3v3__fillcap_8
X_3926_ VDD VDD VSS VSS _3926_/A _4162_/B _4141_/B _3926_/D _3935_/A gf180mcu_as_sc_mcu7t3v3__ao211_2
XTAP_TAPCELL_ROW_176_2134 VDD VSS gf180mcu_as_sc_mcu7t3v3__tap_2
XTAP_TAPCELL_ROW_176_2123 VDD VSS gf180mcu_as_sc_mcu7t3v3__tap_2
XFILLER_149_244 VDD VDD VSS VSS gf180mcu_as_sc_mcu7t3v3__fillcap_8
XFILLER_162_1476 VDD VDD VSS VSS gf180mcu_as_sc_mcu7t3v3__fillcap_16
XFILLER_109_119 VDD VDD VSS VSS gf180mcu_as_sc_mcu7t3v3__fillcap_16
XFILLER_137_417 VDD VDD VSS VSS gf180mcu_as_sc_mcu7t3v3__fill_2
XFILLER_165_737 VDD VDD VSS VSS gf180mcu_as_sc_mcu7t3v3__fillcap_16
XFILLER_177_586 VDD VDD VSS VSS gf180mcu_as_sc_mcu7t3v3__fill_1
XPHY_EDGE_ROW_1_3_Left_135 VDD VSS gf180mcu_as_sc_mcu7t3v3__tap_2
Xclkload7 VDD VDD VSS VSS clkload7/Y clkload7/A gf180mcu_as_sc_mcu7t3v3__inv_2
X_3857_ VDD VDD VSS VSS _5145_/Q _5146_/Q _3857_/C _3858_/D gf180mcu_as_sc_mcu7t3v3__nor3_2
XFILLER_164_247 VDD VDD VSS VSS gf180mcu_as_sc_mcu7t3v3__fillcap_16
XFILLER_166_18 VDD VDD VSS VSS gf180mcu_as_sc_mcu7t3v3__fillcap_16
X_3788_ VDD VDD VSS VSS _3788_/A _3796_/B _3796_/C _3788_/D _3789_/D gf180mcu_as_sc_mcu7t3v3__ao22_2
X_2808_ VDD VDD VSS VSS _4965_/D _5189_/Q _4643_/B _4660_/A gf180mcu_as_sc_mcu7t3v3__ao21_2
XFILLER_145_461 VDD VDD VSS VSS gf180mcu_as_sc_mcu7t3v3__fillcap_4
XFILLER_146_962 VDD VDD VSS VSS gf180mcu_as_sc_mcu7t3v3__fillcap_4
X_2739_ VDD VDD VSS VSS _4947_/Q _2739_/B _2739_/A _5480_/A gf180mcu_as_sc_mcu7t3v3__mux2_2
XPHY_EDGE_ROW_72_1_Right_71 VDD VSS gf180mcu_as_sc_mcu7t3v3__tap_2
XFILLER_156_1203 VDD VDD VSS VSS gf180mcu_as_sc_mcu7t3v3__fillcap_16
XFILLER_132_133 VDD VDD VSS VSS gf180mcu_as_sc_mcu7t3v3__fillcap_8
XFILLER_59_38 VDD VDD VSS VSS gf180mcu_as_sc_mcu7t3v3__fill_1
XFILLER_78_209 VDD VDD VSS VSS gf180mcu_as_sc_mcu7t3v3__fillcap_4
XPHY_EDGE_ROW_43_1_Left_495 VDD VSS gf180mcu_as_sc_mcu7t3v3__tap_2
XFILLER_132_177 VDD VDD VSS VSS gf180mcu_as_sc_mcu7t3v3__fillcap_4
XFILLER_160_475 VDD VDD VSS VSS gf180mcu_as_sc_mcu7t3v3__fill_1
XFILLER_161_998 VDD VDD VSS VSS gf180mcu_as_sc_mcu7t3v3__fillcap_4
XFILLER_47_1553 VDD VDD VSS VSS gf180mcu_as_sc_mcu7t3v3__fillcap_16
X_4409_ VDD VDD VSS VSS _4409_/B _4591_/A _4416_/C gf180mcu_as_sc_mcu7t3v3__and2_2
XTAP_TAPCELL_ROW_148_1513 VDD VSS gf180mcu_as_sc_mcu7t3v3__tap_2
XTAP_TAPCELL_ROW_148_1502 VDD VSS gf180mcu_as_sc_mcu7t3v3__tap_2
XFILLER_115_88 VDD VDD VSS VSS gf180mcu_as_sc_mcu7t3v3__fillcap_4
XFILLER_75_37 VDD VDD VSS VSS gf180mcu_as_sc_mcu7t3v3__fill_1
XFILLER_86_297 VDD VDD VSS VSS gf180mcu_as_sc_mcu7t3v3__fillcap_4
XFILLER_131_32 VDD VDD VSS VSS gf180mcu_as_sc_mcu7t3v3__fillcap_4
XTAP_TAPCELL_ROW_165_1893 VDD VSS gf180mcu_as_sc_mcu7t3v3__tap_2
XTAP_TAPCELL_ROW_165_1882 VDD VSS gf180mcu_as_sc_mcu7t3v3__tap_2
XFILLER_131_65 VDD VDD VSS VSS gf180mcu_as_sc_mcu7t3v3__fillcap_4
XFILLER_54_172 VDD VDD VSS VSS gf180mcu_as_sc_mcu7t3v3__fill_2
XFILLER_91_14 VDD VDD VSS VSS gf180mcu_as_sc_mcu7t3v3__fill_2
XPHY_EDGE_ROW_109_3_Right_428 VDD VSS gf180mcu_as_sc_mcu7t3v3__tap_2
XFILLER_54_1502 VDD VDD VSS VSS gf180mcu_as_sc_mcu7t3v3__fillcap_16
XFILLER_24_85 VDD VDD VSS VSS gf180mcu_as_sc_mcu7t3v3__fillcap_16
XFILLER_54_1568 VDD VDD VSS VSS gf180mcu_as_sc_mcu7t3v3__fill_1
XFILLER_141_1538 VDD VDD VSS VSS gf180mcu_as_sc_mcu7t3v3__fill_2
XFILLER_156_737 VDD VDD VSS VSS gf180mcu_as_sc_mcu7t3v3__fillcap_8
XFILLER_168_597 VDD VDD VSS VSS gf180mcu_as_sc_mcu7t3v3__fillcap_8
Xclkbuf_leaf_8_clk_regs VDD VDD VSS VSS clkbuf_3_1_0_clk_regs/Y clkload7/A gf180mcu_as_sc_mcu7t3v3__clkbuff_12
XFILLER_10_275 VDD VDD VSS VSS gf180mcu_as_sc_mcu7t3v3__fill_2
XFILLER_183_578 VDD VDD VSS VSS gf180mcu_as_sc_mcu7t3v3__fillcap_4
XFILLER_6_268 VDD VDD VSS VSS gf180mcu_as_sc_mcu7t3v3__fill_2
XFILLER_108_174 VDD VDD VSS VSS gf180mcu_as_sc_mcu7t3v3__fill_1
XFILLER_136_483 VDD VDD VSS VSS gf180mcu_as_sc_mcu7t3v3__fillcap_16
XFILLER_139_1434 VDD VDD VSS VSS gf180mcu_as_sc_mcu7t3v3__fillcap_16
XFILLER_123_144 VDD VDD VSS VSS gf180mcu_as_sc_mcu7t3v3__fill_1
XFILLER_123_188 VDD VDD VSS VSS gf180mcu_as_sc_mcu7t3v3__fillcap_8
XTAP_TAPCELL_ROW_16_1_698 VDD VSS gf180mcu_as_sc_mcu7t3v3__tap_2
XFILLER_172_1093 VDD VDD VSS VSS gf180mcu_as_sc_mcu7t3v3__fillcap_16
XTAP_TAPCELL_ROW_91_1_999 VDD VSS gf180mcu_as_sc_mcu7t3v3__tap_2
XFILLER_1_34 VDD VDD VSS VSS gf180mcu_as_sc_mcu7t3v3__fillcap_16
XFILLER_92_212 VDD VDD VSS VSS gf180mcu_as_sc_mcu7t3v3__fill_1
XFILLER_150_1391 VDD VDD VSS VSS gf180mcu_as_sc_mcu7t3v3__fillcap_4
XFILLER_98_1451 VDD VDD VSS VSS gf180mcu_as_sc_mcu7t3v3__fillcap_16
XFILLER_45_150 VDD VDD VSS VSS gf180mcu_as_sc_mcu7t3v3__fill_2
XFILLER_146_1416 VDD VDD VSS VSS gf180mcu_as_sc_mcu7t3v3__fillcap_16
XFILLER_178_317 VDD VDD VSS VSS gf180mcu_as_sc_mcu7t3v3__fillcap_16
XFILLER_60_142 VDD VDD VSS VSS gf180mcu_as_sc_mcu7t3v3__fillcap_4
XFILLER_144_1140 VDD VDD VSS VSS gf180mcu_as_sc_mcu7t3v3__fill_2
XFILLER_147_704 VDD VDD VSS VSS gf180mcu_as_sc_mcu7t3v3__fill_1
XFILLER_81_80 VDD VDD VSS VSS gf180mcu_as_sc_mcu7t3v3__fillcap_8
X_4760_ VDD VDD VSS VSS clkload2/A _4760_/D _4760_/Q gf180mcu_as_sc_mcu7t3v3__dfxtp_2
XFILLER_147_715 VDD VDD VSS VSS gf180mcu_as_sc_mcu7t3v3__fillcap_16
X_4691_ VDD VDD VSS VSS _4691_/D _4691_/A _4721_/A _4691_/C _4707_/S gf180mcu_as_sc_mcu7t3v3__ao31_2
X_3711_ VDD VDD VSS VSS _4934_/Q _3719_/B _3719_/C _4088_/D _3712_/D gf180mcu_as_sc_mcu7t3v3__ao22_2
XFILLER_146_247 VDD VDD VSS VSS gf180mcu_as_sc_mcu7t3v3__fillcap_16
XFILLER_179_1214 VDD VDD VSS VSS gf180mcu_as_sc_mcu7t3v3__fill_2
X_3642_ VDD VDD VSS VSS _3646_/B _3642_/C _3726_/B _4016_/A gf180mcu_as_sc_mcu7t3v3__aoi21_2
XTAP_TAPCELL_ROW_171_2020 VDD VSS gf180mcu_as_sc_mcu7t3v3__tap_2
XFILLER_161_206 VDD VDD VSS VSS gf180mcu_as_sc_mcu7t3v3__fillcap_4
X_3573_ VDD VDD VSS VSS _3936_/A _3802_/C _3573_/C _4839_/D _3573_/D gf180mcu_as_sc_mcu7t3v3__aoi211_2
XFILLER_114_144 VDD VDD VSS VSS gf180mcu_as_sc_mcu7t3v3__fill_1
XFILLER_118_1518 VDD VDD VSS VSS gf180mcu_as_sc_mcu7t3v3__fillcap_16
X_2524_ VDD VDD VSS VSS _2771_/A _2806_/D _2847_/A gf180mcu_as_sc_mcu7t3v3__nor2_2
XFILLER_114_155 VDD VDD VSS VSS gf180mcu_as_sc_mcu7t3v3__fillcap_16
XFILLER_114_177 VDD VDD VSS VSS gf180mcu_as_sc_mcu7t3v3__fillcap_16
XFILLER_143_998 VDD VDD VSS VSS gf180mcu_as_sc_mcu7t3v3__fillcap_4
XFILLER_170_795 VDD VDD VSS VSS gf180mcu_as_sc_mcu7t3v3__fill_2
X_5243_ VDD VDD VSS VSS clkload7/A _5243_/D _5243_/Q gf180mcu_as_sc_mcu7t3v3__dfxtp_2
X_2455_ VDD VDD VSS VSS _2456_/B _2455_/A gf180mcu_as_sc_mcu7t3v3__inv_2
XFILLER_142_497 VDD VDD VSS VSS gf180mcu_as_sc_mcu7t3v3__fillcap_4
XFILLER_151_1122 VDD VDD VSS VSS gf180mcu_as_sc_mcu7t3v3__fillcap_16
X_5174_ VDD VDD VSS VSS _5183_/CLK _5174_/D _5174_/Q gf180mcu_as_sc_mcu7t3v3__dfxtp_2
X_4125_ VDD VDD VSS VSS _5001_/Q _4125_/B _4252_/B _4125_/D _5001_/D gf180mcu_as_sc_mcu7t3v3__ao22_2
XFILLER_28_139 VDD VDD VSS VSS gf180mcu_as_sc_mcu7t3v3__fillcap_16
XFILLER_83_201 VDD VDD VSS VSS gf180mcu_as_sc_mcu7t3v3__fillcap_8
XPHY_EDGE_ROW_104_3_Left_238 VDD VSS gf180mcu_as_sc_mcu7t3v3__tap_2
XFILLER_42_1483 VDD VDD VSS VSS gf180mcu_as_sc_mcu7t3v3__fill_1
X_4056_ VDD VDD VSS VSS _4056_/A _4119_/B _4118_/B _4056_/D _4057_/D gf180mcu_as_sc_mcu7t3v3__ao22_2
XTAP_TAPCELL_ROW_143_1410 VDD VSS gf180mcu_as_sc_mcu7t3v3__tap_2
X_3007_ VDD VDD VSS VSS _3230_/S _3993_/A _3013_/C gf180mcu_as_sc_mcu7t3v3__and2_2
XTAP_TAPCELL_ROW_33_1_768 VDD VSS gf180mcu_as_sc_mcu7t3v3__tap_2
XFILLER_101_35 VDD VDD VSS VSS gf180mcu_as_sc_mcu7t3v3__fill_2
XFILLER_101_57 VDD VDD VSS VSS gf180mcu_as_sc_mcu7t3v3__fill_2
XFILLER_51_142 VDD VDD VSS VSS gf180mcu_as_sc_mcu7t3v3__fill_2
XFILLER_61_39 VDD VDD VSS VSS gf180mcu_as_sc_mcu7t3v3__fillcap_4
XPHY_EDGE_ROW_33_3_Right_352 VDD VSS gf180mcu_as_sc_mcu7t3v3__tap_2
X_4958_ VDD VDD VSS VSS _5146_/CLK _4958_/D _4958_/Q gf180mcu_as_sc_mcu7t3v3__dfxtp_2
XFILLER_131_8 VDD VDD VSS VSS gf180mcu_as_sc_mcu7t3v3__fillcap_16
XFILLER_138_737 VDD VDD VSS VSS gf180mcu_as_sc_mcu7t3v3__fillcap_8
XFILLER_178_884 VDD VDD VSS VSS gf180mcu_as_sc_mcu7t3v3__fillcap_8
X_4889_ VDD VDD VSS VSS _4928_/CLK _4889_/D _4889_/Q gf180mcu_as_sc_mcu7t3v3__dfxtp_2
X_3909_ VDD VDD VSS VSS _4168_/A _3909_/A _4124_/D gf180mcu_as_sc_mcu7t3v3__or2_2
XTAP_TAPCELL_ROW_62_3_2442 VDD VSS gf180mcu_as_sc_mcu7t3v3__tap_2
XTAP_TAPCELL_ROW_137_1269 VDD VSS gf180mcu_as_sc_mcu7t3v3__tap_2
XFILLER_105_144 VDD VDD VSS VSS gf180mcu_as_sc_mcu7t3v3__fill_1
XFILLER_126_10 VDD VDD VSS VSS gf180mcu_as_sc_mcu7t3v3__fillcap_4
XFILLER_134_954 VDD VDD VSS VSS gf180mcu_as_sc_mcu7t3v3__fillcap_4
XFILLER_156_1044 VDD VDD VSS VSS gf180mcu_as_sc_mcu7t3v3__fillcap_16
XFILLER_161_762 VDD VDD VSS VSS gf180mcu_as_sc_mcu7t3v3__fillcap_8
XFILLER_3_249 VDD VDD VSS VSS gf180mcu_as_sc_mcu7t3v3__fillcap_4
Xoutput370 VDD VDD VSS VSS _4772_/Q se_out[1] gf180mcu_as_sc_mcu7t3v3__buff_2
XFILLER_126_98 VDD VDD VSS VSS gf180mcu_as_sc_mcu7t3v3__fill_1
Xoutput392 VDD VDD VSS VSS _4780_/Q se_out[9] gf180mcu_as_sc_mcu7t3v3__buff_2
Xoutput381 VDD VDD VSS VSS _4773_/Q se_out[2] gf180mcu_as_sc_mcu7t3v3__buff_2
XTAP_TAPCELL_ROW_167_1922 VDD VSS gf180mcu_as_sc_mcu7t3v3__tap_2
XFILLER_120_158 VDD VDD VSS VSS gf180mcu_as_sc_mcu7t3v3__fill_1
XTAP_TAPCELL_ROW_167_1933 VDD VSS gf180mcu_as_sc_mcu7t3v3__tap_2
XTAP_TAPCELL_ROW_12_1_682 VDD VSS gf180mcu_as_sc_mcu7t3v3__tap_2
XFILLER_60_1550 VDD VDD VSS VSS gf180mcu_as_sc_mcu7t3v3__fillcap_4
XFILLER_142_97 VDD VDD VSS VSS gf180mcu_as_sc_mcu7t3v3__fillcap_8
XFILLER_163_1004 VDD VDD VSS VSS gf180mcu_as_sc_mcu7t3v3__fill_1
XFILLER_167_1162 VDD VDD VSS VSS gf180mcu_as_sc_mcu7t3v3__fill_1
XFILLER_167_1173 VDD VDD VSS VSS gf180mcu_as_sc_mcu7t3v3__fillcap_16
XFILLER_163_1015 VDD VDD VSS VSS gf180mcu_as_sc_mcu7t3v3__fill_2
XFILLER_35_62 VDD VDD VSS VSS gf180mcu_as_sc_mcu7t3v3__fillcap_8
XFILLER_42_142 VDD VDD VSS VSS gf180mcu_as_sc_mcu7t3v3__fill_2
XPHY_EDGE_ROW_98_3_Left_232 VDD VSS gf180mcu_as_sc_mcu7t3v3__tap_2
XFILLER_169_884 VDD VDD VSS VSS gf180mcu_as_sc_mcu7t3v3__fillcap_8
XFILLER_180_1362 VDD VDD VSS VSS gf180mcu_as_sc_mcu7t3v3__fill_2
XFILLER_128_247 VDD VDD VSS VSS gf180mcu_as_sc_mcu7t3v3__fillcap_4
XFILLER_167_50 VDD VDD VSS VSS gf180mcu_as_sc_mcu7t3v3__fillcap_16
XFILLER_167_72 VDD VDD VSS VSS gf180mcu_as_sc_mcu7t3v3__fillcap_16
XFILLER_51_94 VDD VDD VSS VSS gf180mcu_as_sc_mcu7t3v3__fillcap_8
Xwire464 VDD VDD VSS VSS _2657_/Y wire464/Y gf180mcu_as_sc_mcu7t3v3__buff_8
XFILLER_140_924 VDD VDD VSS VSS gf180mcu_as_sc_mcu7t3v3__fill_1
XFILLER_152_1431 VDD VDD VSS VSS gf180mcu_as_sc_mcu7t3v3__fillcap_4
XFILLER_65_1483 VDD VDD VSS VSS gf180mcu_as_sc_mcu7t3v3__fillcap_16
XFILLER_26_1467 VDD VDD VSS VSS gf180mcu_as_sc_mcu7t3v3__fillcap_16
XFILLER_65_212 VDD VDD VSS VSS gf180mcu_as_sc_mcu7t3v3__fill_2
XFILLER_76_80 VDD VDD VSS VSS gf180mcu_as_sc_mcu7t3v3__fillcap_8
XFILLER_33_120 VDD VDD VSS VSS gf180mcu_as_sc_mcu7t3v3__fillcap_16
XFILLER_33_142 VDD VDD VSS VSS gf180mcu_as_sc_mcu7t3v3__fillcap_16
X_4812_ VDD VDD VSS VSS _5046_/CLK _4812_/D _4812_/Q gf180mcu_as_sc_mcu7t3v3__dfxtp_2
XFILLER_159_372 VDD VDD VSS VSS gf180mcu_as_sc_mcu7t3v3__fill_2
X_4743_ VDD VDD VSS VSS _4745_/B _5272_/Q _5273_/D gf180mcu_as_sc_mcu7t3v3__and2_2
XFILLER_147_523 VDD VDD VSS VSS gf180mcu_as_sc_mcu7t3v3__fillcap_4
XFILLER_179_1000 VDD VDD VSS VSS gf180mcu_as_sc_mcu7t3v3__fill_2
XFILLER_147_556 VDD VDD VSS VSS gf180mcu_as_sc_mcu7t3v3__fillcap_4
XFILLER_147_578 VDD VDD VSS VSS gf180mcu_as_sc_mcu7t3v3__fillcap_4
X_4674_ VDD VDD VSS VSS _5244_/D _5244_/Q _4685_/C _4674_/C gf180mcu_as_sc_mcu7t3v3__ao21_2
XFILLER_134_206 VDD VDD VSS VSS gf180mcu_as_sc_mcu7t3v3__fill_2
X_3625_ VDD VDD VSS VSS _4923_/Q _3719_/B _3716_/C _3999_/A _3627_/C gf180mcu_as_sc_mcu7t3v3__ao22_2
X_3556_ VDD VDD VSS VSS _3556_/Y _3559_/C _3557_/B gf180mcu_as_sc_mcu7t3v3__nor2_2
XFILLER_143_762 VDD VDD VSS VSS gf180mcu_as_sc_mcu7t3v3__fill_1
XFILLER_170_570 VDD VDD VSS VSS gf180mcu_as_sc_mcu7t3v3__fillcap_4
X_2507_ VDD VDD VSS VSS _5269_/Q _5270_/Q _4739_/A _4741_/B gf180mcu_as_sc_mcu7t3v3__nand3_2
XFILLER_142_283 VDD VDD VSS VSS gf180mcu_as_sc_mcu7t3v3__fillcap_4
XFILLER_170_581 VDD VDD VSS VSS gf180mcu_as_sc_mcu7t3v3__fill_1
X_5226_ VDD VDD VSS VSS clkload7/A _5226_/D _5226_/Q gf180mcu_as_sc_mcu7t3v3__dfxtp_2
Xinput109 VDD VDD VSS VSS ne_in[7] _3992_/D gf180mcu_as_sc_mcu7t3v3__buff_2
X_3487_ VDD VDD VSS VSS _4143_/D _3503_/B _3487_/C _3487_/D _3488_/C gf180mcu_as_sc_mcu7t3v3__ao211_2
XFILLER_44_1534 VDD VDD VSS VSS gf180mcu_as_sc_mcu7t3v3__fillcap_8
XFILLER_44_1556 VDD VDD VSS VSS gf180mcu_as_sc_mcu7t3v3__fillcap_4
X_2438_ VDD VDD VSS VSS _4067_/A _2438_/A gf180mcu_as_sc_mcu7t3v3__inv_2
XFILLER_131_1515 VDD VDD VSS VSS gf180mcu_as_sc_mcu7t3v3__fillcap_4
XFILLER_131_1537 VDD VDD VSS VSS gf180mcu_as_sc_mcu7t3v3__fillcap_4
XFILLER_56_201 VDD VDD VSS VSS gf180mcu_as_sc_mcu7t3v3__fillcap_4
X_5157_ VDD VDD VSS VSS _5159_/CLK _5157_/D _5157_/Q gf180mcu_as_sc_mcu7t3v3__dfxtp_2
XTAP_TAPCELL_ROW_184_2299 VDD VSS gf180mcu_as_sc_mcu7t3v3__tap_2
X_5088_ VDD VDD VSS VSS _5088_/CLK _5088_/D _5088_/Q gf180mcu_as_sc_mcu7t3v3__dfxtp_2
X_4108_ VDD VDD VSS VSS _4999_/Q _4117_/B _4250_/B _4108_/D _4999_/D gf180mcu_as_sc_mcu7t3v3__ao22_2
XFILLER_112_34 VDD VDD VSS VSS gf180mcu_as_sc_mcu7t3v3__fill_1
X_4039_ VDD VDD VSS VSS _4039_/A _4120_/B _4120_/C _4928_/Q _4041_/C gf180mcu_as_sc_mcu7t3v3__ao22_2
XTAP_TAPCELL_ROW_162_1830 VDD VSS gf180mcu_as_sc_mcu7t3v3__tap_2
XFILLER_72_16 VDD VDD VSS VSS gf180mcu_as_sc_mcu7t3v3__fill_1
XFILLER_164_1313 VDD VDD VSS VSS gf180mcu_as_sc_mcu7t3v3__fillcap_8
XFILLER_164_1346 VDD VDD VSS VSS gf180mcu_as_sc_mcu7t3v3__fillcap_16
XFILLER_129_1499 VDD VDD VSS VSS gf180mcu_as_sc_mcu7t3v3__fillcap_16
XFILLER_169_136 VDD VDD VSS VSS gf180mcu_as_sc_mcu7t3v3__fillcap_4
XFILLER_169_158 VDD VDD VSS VSS gf180mcu_as_sc_mcu7t3v3__fillcap_16
XTAP_TAPCELL_ROW_15_1_697 VDD VSS gf180mcu_as_sc_mcu7t3v3__tap_2
XPHY_EDGE_ROW_34_3_Right_353 VDD VSS gf180mcu_as_sc_mcu7t3v3__tap_2
XTAP_TAPCELL_ROW_139_1309 VDD VSS gf180mcu_as_sc_mcu7t3v3__tap_2
XTAP_TAPCELL_ROW_5_1_654 VDD VSS gf180mcu_as_sc_mcu7t3v3__tap_2
XTAP_TAPCELL_ROW_156_1678 VDD VSS gf180mcu_as_sc_mcu7t3v3__tap_2
XFILLER_158_1106 VDD VDD VSS VSS gf180mcu_as_sc_mcu7t3v3__fill_2
XTAP_TAPCELL_ROW_156_1689 VDD VSS gf180mcu_as_sc_mcu7t3v3__tap_2
XFILLER_108_2 VDD VDD VSS VSS gf180mcu_as_sc_mcu7t3v3__fillcap_16
XFILLER_153_559 VDD VDD VSS VSS gf180mcu_as_sc_mcu7t3v3__fill_1
XFILLER_88_1483 VDD VDD VSS VSS gf180mcu_as_sc_mcu7t3v3__fill_1
XFILLER_134_784 VDD VDD VSS VSS gf180mcu_as_sc_mcu7t3v3__fillcap_4
XFILLER_161_570 VDD VDD VSS VSS gf180mcu_as_sc_mcu7t3v3__fillcap_4
XFILLER_175_1453 VDD VDD VSS VSS gf180mcu_as_sc_mcu7t3v3__fill_2
XFILLER_49_1467 VDD VDD VSS VSS gf180mcu_as_sc_mcu7t3v3__fillcap_16
XFILLER_97_35 VDD VDD VSS VSS gf180mcu_as_sc_mcu7t3v3__fill_2
XFILLER_133_294 VDD VDD VSS VSS gf180mcu_as_sc_mcu7t3v3__fillcap_4
XFILLER_136_1437 VDD VDD VSS VSS gf180mcu_as_sc_mcu7t3v3__fillcap_16
XPHY_EDGE_ROW_35_1_Right_34 VDD VSS gf180mcu_as_sc_mcu7t3v3__tap_2
XFILLER_47_212 VDD VDD VSS VSS gf180mcu_as_sc_mcu7t3v3__fillcap_16
XFILLER_134_1194 VDD VDD VSS VSS gf180mcu_as_sc_mcu7t3v3__fill_1
XFILLER_169_1213 VDD VDD VSS VSS gf180mcu_as_sc_mcu7t3v3__fillcap_4
XFILLER_46_50 VDD VDD VSS VSS gf180mcu_as_sc_mcu7t3v3__fill_2
XFILLER_15_120 VDD VDD VSS VSS gf180mcu_as_sc_mcu7t3v3__fillcap_16
XFILLER_15_142 VDD VDD VSS VSS gf180mcu_as_sc_mcu7t3v3__fillcap_16
XFILLER_62_259 VDD VDD VSS VSS gf180mcu_as_sc_mcu7t3v3__fill_2
XFILLER_30_101 VDD VDD VSS VSS gf180mcu_as_sc_mcu7t3v3__fillcap_4
XTAP_TAPCELL_ROW_98_1_1029 VDD VSS gf180mcu_as_sc_mcu7t3v3__tap_2
XPHY_EDGE_ROW_68_1_Left_520 VDD VSS gf180mcu_as_sc_mcu7t3v3__tap_2
XFILLER_169_670 VDD VDD VSS VSS gf180mcu_as_sc_mcu7t3v3__fillcap_8
XFILLER_30_134 VDD VDD VSS VSS gf180mcu_as_sc_mcu7t3v3__fillcap_16
XPHY_EDGE_ROW_120_1_Left_572 VDD VSS gf180mcu_as_sc_mcu7t3v3__tap_2
XFILLER_7_66 VDD VDD VSS VSS gf180mcu_as_sc_mcu7t3v3__fillcap_4
XFILLER_7_88 VDD VDD VSS VSS gf180mcu_as_sc_mcu7t3v3__fillcap_16
XFILLER_172_868 VDD VDD VSS VSS gf180mcu_as_sc_mcu7t3v3__fillcap_4
XPHY_EDGE_ROW_152_Right_286 VDD VSS gf180mcu_as_sc_mcu7t3v3__tap_2
X_4390_ VDD VDD VSS VSS _4394_/B _5066_/Q _4403_/S gf180mcu_as_sc_mcu7t3v3__nand2_2
X_3410_ VDD VDD VSS VSS _4062_/A _3449_/B _3410_/C _3450_/B _3412_/C gf180mcu_as_sc_mcu7t3v3__ao211_2
XFILLER_154_1504 VDD VDD VSS VSS gf180mcu_as_sc_mcu7t3v3__fill_1
XFILLER_28_1518 VDD VDD VSS VSS gf180mcu_as_sc_mcu7t3v3__fillcap_16
X_3341_ VDD VDD VSS VSS _3992_/A _3504_/B _3514_/B _3993_/A _3342_/B gf180mcu_as_sc_mcu7t3v3__ao22_2
XFILLER_154_1537 VDD VDD VSS VSS gf180mcu_as_sc_mcu7t3v3__fill_1
XFILLER_97_134 VDD VDD VSS VSS gf180mcu_as_sc_mcu7t3v3__fillcap_4
X_3272_ VDD VDD VSS VSS _3272_/Y _3517_/D _3518_/C gf180mcu_as_sc_mcu7t3v3__nor2_2
XFILLER_23_2 VDD VDD VSS VSS gf180mcu_as_sc_mcu7t3v3__fillcap_16
X_5011_ VDD VDD VSS VSS _5173_/CLK _5011_/D _5011_/Q gf180mcu_as_sc_mcu7t3v3__dfxtp_2
Xhold1008 VDD VDD VSS VSS _3906_/S _2588_/B gf180mcu_as_sc_mcu7t3v3__buff_2
Xhold1019 VDD VDD VSS VSS hold1049/Y _4959_/D gf180mcu_as_sc_mcu7t3v3__buff_2
XFILLER_152_1294 VDD VDD VSS VSS gf180mcu_as_sc_mcu7t3v3__fill_1
XFILLER_53_204 VDD VDD VSS VSS gf180mcu_as_sc_mcu7t3v3__fillcap_4
XPHY_EDGE_ROW_81_1_Right_80 VDD VSS gf180mcu_as_sc_mcu7t3v3__tap_2
XFILLER_146_1098 VDD VDD VSS VSS gf180mcu_as_sc_mcu7t3v3__fillcap_16
XFILLER_167_629 VDD VDD VSS VSS gf180mcu_as_sc_mcu7t3v3__fill_1
XFILLER_166_139 VDD VDD VSS VSS gf180mcu_as_sc_mcu7t3v3__fillcap_16
X_2987_ VDD VDD VSS VSS _3966_/A _3150_/B _2987_/C _2987_/D _2988_/C gf180mcu_as_sc_mcu7t3v3__ao22_2
XTAP_TAPCELL_ROW_11_1_681 VDD VSS gf180mcu_as_sc_mcu7t3v3__tap_2
XFILLER_175_651 VDD VDD VSS VSS gf180mcu_as_sc_mcu7t3v3__fillcap_8
X_4726_ VDD VDD VSS VSS _5265_/Q _4730_/B _4730_/C _5264_/Q _4727_/C gf180mcu_as_sc_mcu7t3v3__ao22_2
XFILLER_107_228 VDD VDD VSS VSS gf180mcu_as_sc_mcu7t3v3__fill_2
X_4657_ VDD VDD VSS VSS _4658_/B _4657_/B _5229_/Q gf180mcu_as_sc_mcu7t3v3__nand2b_2
XTAP_TAPCELL_ROW_134_1206 VDD VSS gf180mcu_as_sc_mcu7t3v3__tap_2
XFILLER_135_548 VDD VDD VSS VSS gf180mcu_as_sc_mcu7t3v3__fillcap_8
XFILLER_162_356 VDD VDD VSS VSS gf180mcu_as_sc_mcu7t3v3__fillcap_4
XFILLER_174_18 VDD VDD VSS VSS gf180mcu_as_sc_mcu7t3v3__fillcap_16
Xinput91 VDD VDD VSS VSS ne_in[21] _4104_/D gf180mcu_as_sc_mcu7t3v3__buff_2
Xinput80 VDD VDD VSS VSS ne_in[11] _4021_/A gf180mcu_as_sc_mcu7t3v3__buff_2
X_3608_ VDD VDD VSS VSS _3608_/A _3746_/B _3608_/C _4844_/D _3661_/D gf180mcu_as_sc_mcu7t3v3__aoi211_2
Xmax_cap572 VDD VDD VSS VSS fanout571/Y _4091_/D gf180mcu_as_sc_mcu7t3v3__buff_8
X_4588_ VDD VDD VSS VSS _4588_/D _4588_/A _4588_/B _4588_/C _4589_/B gf180mcu_as_sc_mcu7t3v3__ao31_2
XTAP_TAPCELL_ROW_151_1575 VDD VSS gf180mcu_as_sc_mcu7t3v3__tap_2
XFILLER_143_570 VDD VDD VSS VSS gf180mcu_as_sc_mcu7t3v3__fillcap_4
XFILLER_171_890 VDD VDD VSS VSS gf180mcu_as_sc_mcu7t3v3__fillcap_8
XFILLER_88_123 VDD VDD VSS VSS gf180mcu_as_sc_mcu7t3v3__fillcap_16
X_3539_ VDD VDD VSS VSS _3539_/B _4946_/Q _3914_/B gf180mcu_as_sc_mcu7t3v3__and2_2
XTAP_TAPCELL_ROW_151_1586 VDD VSS gf180mcu_as_sc_mcu7t3v3__tap_2
XFILLER_153_1036 VDD VDD VSS VSS gf180mcu_as_sc_mcu7t3v3__fillcap_8
XFILLER_67_38 VDD VDD VSS VSS gf180mcu_as_sc_mcu7t3v3__fillcap_4
Xclkbuf_leaf_22_clk_regs VDD VDD VSS VSS clkbuf_3_6_0_clk_regs/Y _5173_/CLK gf180mcu_as_sc_mcu7t3v3__clkbuff_12
XFILLER_29_212 VDD VDD VSS VSS gf180mcu_as_sc_mcu7t3v3__fillcap_16
X_5209_ VDD VDD VSS VSS clkload0/A _5209_/D _5209_/Q gf180mcu_as_sc_mcu7t3v3__dfxtp_2
XTAP_TAPCELL_ROW_8_1_669 VDD VSS gf180mcu_as_sc_mcu7t3v3__tap_2
XFILLER_123_88 VDD VDD VSS VSS gf180mcu_as_sc_mcu7t3v3__fillcap_4
XFILLER_44_226 VDD VDD VSS VSS gf180mcu_as_sc_mcu7t3v3__fillcap_16
XFILLER_83_37 VDD VDD VSS VSS gf180mcu_as_sc_mcu7t3v3__fill_1
XTAP_TAPCELL_ROW_50_3_2424 VDD VSS gf180mcu_as_sc_mcu7t3v3__tap_2
XFILLER_16_53 VDD VDD VSS VSS gf180mcu_as_sc_mcu7t3v3__fillcap_16
XFILLER_12_101 VDD VDD VSS VSS gf180mcu_as_sc_mcu7t3v3__fillcap_4
XFILLER_164_1154 VDD VDD VSS VSS gf180mcu_as_sc_mcu7t3v3__fill_1
XFILLER_12_123 VDD VDD VSS VSS gf180mcu_as_sc_mcu7t3v3__fillcap_16
XFILLER_164_1165 VDD VDD VSS VSS gf180mcu_as_sc_mcu7t3v3__fillcap_4
Xsram2048.u_bank1_822 VDD VDD VSS VSS sram2048.u_bank1/WEN[4] gf180mcu_as_sc_mcu7t3v3__tiel_4
XTAP_TAPCELL_ROW_158_1729 VDD VSS gf180mcu_as_sc_mcu7t3v3__tap_2
XFILLER_157_117 VDD VDD VSS VSS gf180mcu_as_sc_mcu7t3v3__fillcap_16
XFILLER_157_139 VDD VDD VSS VSS gf180mcu_as_sc_mcu7t3v3__fill_1
XPHY_EDGE_ROW_35_3_Right_354 VDD VSS gf180mcu_as_sc_mcu7t3v3__tap_2
XFILLER_166_695 VDD VDD VSS VSS gf180mcu_as_sc_mcu7t3v3__fill_2
XFILLER_32_85 VDD VDD VSS VSS gf180mcu_as_sc_mcu7t3v3__fillcap_16
XFILLER_148_85 VDD VDD VSS VSS gf180mcu_as_sc_mcu7t3v3__fillcap_16
XFILLER_154_857 VDD VDD VSS VSS gf180mcu_as_sc_mcu7t3v3__fillcap_4
XFILLER_141_507 VDD VDD VSS VSS gf180mcu_as_sc_mcu7t3v3__fillcap_8
XFILLER_171_1103 VDD VDD VSS VSS gf180mcu_as_sc_mcu7t3v3__fillcap_4
XFILLER_175_1272 VDD VDD VSS VSS gf180mcu_as_sc_mcu7t3v3__fill_1
XTAP_TAPCELL_ROW_20_1_716 VDD VSS gf180mcu_as_sc_mcu7t3v3__tap_2
XFILLER_171_1136 VDD VDD VSS VSS gf180mcu_as_sc_mcu7t3v3__fill_2
XFILLER_62_1486 VDD VDD VSS VSS gf180mcu_as_sc_mcu7t3v3__fillcap_16
XPHY_EDGE_ROW_1_1_Right_0 VDD VSS gf180mcu_as_sc_mcu7t3v3__tap_2
X_2910_ VDD VDD VSS VSS _3818_/D _3253_/A _3254_/A gf180mcu_as_sc_mcu7t3v3__nor2_2
XFILLER_143_1227 VDD VDD VSS VSS gf180mcu_as_sc_mcu7t3v3__fillcap_4
XFILLER_177_938 VDD VDD VSS VSS gf180mcu_as_sc_mcu7t3v3__fillcap_8
XFILLER_182_1254 VDD VDD VSS VSS gf180mcu_as_sc_mcu7t3v3__fill_1
XFILLER_182_1276 VDD VDD VSS VSS gf180mcu_as_sc_mcu7t3v3__fillcap_4
X_3890_ VDD VDD VSS VSS _3905_/B _5180_/Q _4930_/D gf180mcu_as_sc_mcu7t3v3__and2_2
XFILLER_148_139 VDD VDD VSS VSS gf180mcu_as_sc_mcu7t3v3__fillcap_16
X_2841_ VDD VDD VSS VSS _2841_/B _2841_/A _2842_/C gf180mcu_as_sc_mcu7t3v3__xnor2_2
XFILLER_157_662 VDD VDD VSS VSS gf180mcu_as_sc_mcu7t3v3__fillcap_16
X_2772_ VDD VDD VSS VSS _2773_/B _2776_/A _5230_/Q gf180mcu_as_sc_mcu7t3v3__nand2_2
X_4511_ VDD VDD VSS VSS _4511_/D _4511_/A _4511_/B _4511_/C _4512_/B gf180mcu_as_sc_mcu7t3v3__ao31_2
XFILLER_171_120 VDD VDD VSS VSS gf180mcu_as_sc_mcu7t3v3__fillcap_16
XPHY_EDGE_ROW_113_3_Left_247 VDD VSS gf180mcu_as_sc_mcu7t3v3__tap_2
X_4442_ VDD VDD VSS VSS _5171_/Q _4565_/B _4442_/C _4442_/D _5171_/D gf180mcu_as_sc_mcu7t3v3__ao211_2
XFILLER_171_142 VDD VDD VSS VSS gf180mcu_as_sc_mcu7t3v3__fillcap_16
XTAP_TAPCELL_ROW_122_1_1125 VDD VSS gf180mcu_as_sc_mcu7t3v3__tap_2
XFILLER_154_1323 VDD VDD VSS VSS gf180mcu_as_sc_mcu7t3v3__fill_1
XFILLER_158_1481 VDD VDD VSS VSS gf180mcu_as_sc_mcu7t3v3__fill_2
X_4373_ VDD VDD VSS VSS _5483_/A _4590_/C _4373_/C _4373_/D _4374_/B gf180mcu_as_sc_mcu7t3v3__ao22_2
Xfanout607 VDD VDD VSS VSS _3751_/B _3781_/S gf180mcu_as_sc_mcu7t3v3__buff_2
Xfanout618 VDD VDD VSS VSS fanout622/Y _3500_/B gf180mcu_as_sc_mcu7t3v3__buff_2
Xfanout629 VDD VDD VSS VSS fanout631/Y _3125_/C gf180mcu_as_sc_mcu7t3v3__buff_2
X_3324_ VDD VDD VSS VSS _3452_/S _3976_/D _3324_/A _3326_/B gf180mcu_as_sc_mcu7t3v3__mux2_2
XFILLER_140_562 VDD VDD VSS VSS gf180mcu_as_sc_mcu7t3v3__fillcap_8
XFILLER_154_1367 VDD VDD VSS VSS gf180mcu_as_sc_mcu7t3v3__fillcap_16
X_3255_ VDD VDD VSS VSS _3787_/A _3255_/B _3255_/C _3517_/D gf180mcu_as_sc_mcu7t3v3__nand3_2
XFILLER_41_1515 VDD VDD VSS VSS gf180mcu_as_sc_mcu7t3v3__fillcap_4
XFILLER_41_1537 VDD VDD VSS VSS gf180mcu_as_sc_mcu7t3v3__fillcap_16
XFILLER_80_1564 VDD VDD VSS VSS gf180mcu_as_sc_mcu7t3v3__fillcap_4
XTAP_TAPCELL_ROW_181_2247 VDD VSS gf180mcu_as_sc_mcu7t3v3__tap_2
XTAP_TAPCELL_ROW_181_2236 VDD VSS gf180mcu_as_sc_mcu7t3v3__tap_2
XTAP_TAPCELL_ROW_102_1_1045 VDD VSS gf180mcu_as_sc_mcu7t3v3__tap_2
X_3186_ VDD VDD VSS VSS _3186_/D _4159_/D _3236_/B _3236_/C _3188_/B gf180mcu_as_sc_mcu7t3v3__ao31_2
XTAP_TAPCELL_ROW_4_1_653 VDD VSS gf180mcu_as_sc_mcu7t3v3__tap_2
XFILLER_169_18 VDD VDD VSS VSS gf180mcu_as_sc_mcu7t3v3__fillcap_16
XFILLER_39_1499 VDD VDD VSS VSS gf180mcu_as_sc_mcu7t3v3__fillcap_16
XTAP_TAPCELL_ROW_179_2198 VDD VSS gf180mcu_as_sc_mcu7t3v3__tap_2
XTAP_TAPCELL_ROW_179_2187 VDD VSS gf180mcu_as_sc_mcu7t3v3__tap_2
XFILLER_139_139 VDD VDD VSS VSS gf180mcu_as_sc_mcu7t3v3__fill_1
XFILLER_175_470 VDD VDD VSS VSS gf180mcu_as_sc_mcu7t3v3__fillcap_16
XPHY_EDGE_ROW_45_3_Left_179 VDD VSS gf180mcu_as_sc_mcu7t3v3__tap_2
X_4709_ VDD VDD VSS VSS _4717_/S _5257_/Q _5258_/Q _4710_/B gf180mcu_as_sc_mcu7t3v3__mux2_2
XTAP_TAPCELL_ROW_153_1626 VDD VSS gf180mcu_as_sc_mcu7t3v3__tap_2
XTAP_TAPCELL_ROW_153_1615 VDD VSS gf180mcu_as_sc_mcu7t3v3__tap_2
XFILLER_147_194 VDD VDD VSS VSS gf180mcu_as_sc_mcu7t3v3__fillcap_16
XFILLER_163_632 VDD VDD VSS VSS gf180mcu_as_sc_mcu7t3v3__fill_2
XFILLER_151_827 VDD VDD VSS VSS gf180mcu_as_sc_mcu7t3v3__fillcap_8
XTAP_TAPCELL_ROW_60_1_876 VDD VSS gf180mcu_as_sc_mcu7t3v3__tap_2
XFILLER_118_88 VDD VDD VSS VSS gf180mcu_as_sc_mcu7t3v3__fillcap_4
XFILLER_162_197 VDD VDD VSS VSS gf180mcu_as_sc_mcu7t3v3__fill_2
XFILLER_78_37 VDD VDD VSS VSS gf180mcu_as_sc_mcu7t3v3__fillcap_4
XTAP_TAPCELL_ROW_170_1995 VDD VSS gf180mcu_as_sc_mcu7t3v3__tap_2
XFILLER_150_348 VDD VDD VSS VSS gf180mcu_as_sc_mcu7t3v3__fillcap_8
XFILLER_172_1489 VDD VDD VSS VSS gf180mcu_as_sc_mcu7t3v3__fillcap_16
XPHY_EDGE_ROW_147_Left_599 VDD VSS gf180mcu_as_sc_mcu7t3v3__tap_2
XFILLER_175_2 VDD VDD VSS VSS gf180mcu_as_sc_mcu7t3v3__fillcap_16
XTAP_TAPCELL_ROW_68_3_2451 VDD VSS gf180mcu_as_sc_mcu7t3v3__tap_2
XFILLER_166_1227 VDD VDD VSS VSS gf180mcu_as_sc_mcu7t3v3__fillcap_4
XFILLER_2_1564 VDD VDD VSS VSS gf180mcu_as_sc_mcu7t3v3__fillcap_4
XFILLER_144_1503 VDD VDD VSS VSS gf180mcu_as_sc_mcu7t3v3__fill_2
XFILLER_150_97 VDD VDD VSS VSS gf180mcu_as_sc_mcu7t3v3__fillcap_8
XFILLER_183_1552 VDD VDD VSS VSS gf180mcu_as_sc_mcu7t3v3__fill_1
XFILLER_40_295 VDD VDD VSS VSS gf180mcu_as_sc_mcu7t3v3__fillcap_4
XFILLER_138_150 VDD VDD VSS VSS gf180mcu_as_sc_mcu7t3v3__fillcap_16
XFILLER_167_982 VDD VDD VSS VSS gf180mcu_as_sc_mcu7t3v3__fillcap_16
XPHY_EDGE_ROW_36_3_Right_355 VDD VSS gf180mcu_as_sc_mcu7t3v3__tap_2
XFILLER_153_120 VDD VDD VSS VSS gf180mcu_as_sc_mcu7t3v3__fillcap_16
XFILLER_177_1323 VDD VDD VSS VSS gf180mcu_as_sc_mcu7t3v3__fill_1
XFILLER_153_142 VDD VDD VSS VSS gf180mcu_as_sc_mcu7t3v3__fillcap_16
XFILLER_175_50 VDD VDD VSS VSS gf180mcu_as_sc_mcu7t3v3__fillcap_16
XFILLER_57_8 VDD VDD VSS VSS gf180mcu_as_sc_mcu7t3v3__fillcap_4
XFILLER_138_1329 VDD VDD VSS VSS gf180mcu_as_sc_mcu7t3v3__fillcap_16
XFILLER_142_849 VDD VDD VSS VSS gf180mcu_as_sc_mcu7t3v3__fillcap_16
XFILLER_153_186 VDD VDD VSS VSS gf180mcu_as_sc_mcu7t3v3__fillcap_16
XFILLER_175_72 VDD VDD VSS VSS gf180mcu_as_sc_mcu7t3v3__fillcap_16
XFILLER_4_34 VDD VDD VSS VSS gf180mcu_as_sc_mcu7t3v3__fill_1
XFILLER_136_1031 VDD VDD VSS VSS gf180mcu_as_sc_mcu7t3v3__fill_2
XFILLER_141_348 VDD VDD VSS VSS gf180mcu_as_sc_mcu7t3v3__fill_2
XFILLER_136_1053 VDD VDD VSS VSS gf180mcu_as_sc_mcu7t3v3__fill_2
XFILLER_150_893 VDD VDD VSS VSS gf180mcu_as_sc_mcu7t3v3__fill_2
XFILLER_82_107 VDD VDD VSS VSS gf180mcu_as_sc_mcu7t3v3__fillcap_16
Xinput270 VDD VDD VSS VSS sw_in[29] _3794_/A gf180mcu_as_sc_mcu7t3v3__buff_2
Xinput281 VDD VDD VSS VSS sw_in[8] _2430_/A gf180mcu_as_sc_mcu7t3v3__buff_2
X_3040_ VDD VDD VSS VSS _3691_/D _3194_/S _3040_/B _3040_/C _3041_/C gf180mcu_as_sc_mcu7t3v3__ao31_2
Xinput292 VDD VDD VSS VSS west_in[18] _4077_/D gf180mcu_as_sc_mcu7t3v3__buff_2
XFILLER_84_80 VDD VDD VSS VSS gf180mcu_as_sc_mcu7t3v3__fillcap_8
XFILLER_149_1469 VDD VDD VSS VSS gf180mcu_as_sc_mcu7t3v3__fill_1
X_4991_ VDD VDD VSS VSS _5085_/CLK _4991_/D _4991_/Q gf180mcu_as_sc_mcu7t3v3__dfxtp_2
XFILLER_177_702 VDD VDD VSS VSS gf180mcu_as_sc_mcu7t3v3__fill_2
X_3942_ VDD VDD VSS VSS _3942_/A _4159_/B _3942_/C _3942_/D _3943_/C gf180mcu_as_sc_mcu7t3v3__ao211_2
XFILLER_149_426 VDD VDD VSS VSS gf180mcu_as_sc_mcu7t3v3__fill_2
XFILLER_177_735 VDD VDD VSS VSS gf180mcu_as_sc_mcu7t3v3__fill_2
XFILLER_90_2 VDD VDD VSS VSS gf180mcu_as_sc_mcu7t3v3__fillcap_8
X_3873_ VDD VDD VSS VSS _3873_/A _3873_/B _3873_/C _3874_/B gf180mcu_as_sc_mcu7t3v3__nor3_2
XFILLER_165_908 VDD VDD VSS VSS gf180mcu_as_sc_mcu7t3v3__fill_2
X_2824_ VDD VDD VSS VSS _4974_/D _2830_/B _4761_/Q _4760_/D gf180mcu_as_sc_mcu7t3v3__mux2_2
XFILLER_160_1360 VDD VDD VSS VSS gf180mcu_as_sc_mcu7t3v3__fillcap_4
XFILLER_164_418 VDD VDD VSS VSS gf180mcu_as_sc_mcu7t3v3__fillcap_16
XTAP_TAPCELL_ROW_174_2095 VDD VSS gf180mcu_as_sc_mcu7t3v3__tap_2
XTAP_TAPCELL_ROW_174_2084 VDD VSS gf180mcu_as_sc_mcu7t3v3__tap_2
XFILLER_145_632 VDD VDD VSS VSS gf180mcu_as_sc_mcu7t3v3__fillcap_4
X_2755_ VDD VDD VSS VSS _2780_/B _4652_/B _2765_/C gf180mcu_as_sc_mcu7t3v3__and2_2
XFILLER_144_142 VDD VDD VSS VSS gf180mcu_as_sc_mcu7t3v3__fillcap_4
XFILLER_172_451 VDD VDD VSS VSS gf180mcu_as_sc_mcu7t3v3__fillcap_4
X_2686_ VDD VDD VSS VSS _2716_/A _2686_/B _2686_/C _2686_/D _2686_/Y gf180mcu_as_sc_mcu7t3v3__ao22_2
XFILLER_160_624 VDD VDD VSS VSS gf180mcu_as_sc_mcu7t3v3__fill_2
XFILLER_172_473 VDD VDD VSS VSS gf180mcu_as_sc_mcu7t3v3__fillcap_16
X_4425_ VDD VDD VSS VSS _5171_/Q _4470_/B _4493_/C _5121_/Q _4426_/B gf180mcu_as_sc_mcu7t3v3__ao22_2
XTAP_TAPCELL_ROW_74_3_2461 VDD VSS gf180mcu_as_sc_mcu7t3v3__tap_2
XFILLER_98_240 VDD VDD VSS VSS gf180mcu_as_sc_mcu7t3v3__fillcap_4
X_4356_ VDD VDD VSS VSS _4356_/B _4590_/B _4357_/D gf180mcu_as_sc_mcu7t3v3__and2_2
X_3307_ VDD VDD VSS VSS _3308_/A _3956_/D _3500_/B _3307_/C gf180mcu_as_sc_mcu7t3v3__ao21_2
XFILLER_150_1017 VDD VDD VSS VSS gf180mcu_as_sc_mcu7t3v3__fillcap_8
XFILLER_58_137 VDD VDD VSS VSS gf180mcu_as_sc_mcu7t3v3__fillcap_16
X_4287_ VDD VDD VSS VSS _4289_/S _5483_/A _5121_/Q _5121_/D gf180mcu_as_sc_mcu7t3v3__mux2_2
XFILLER_132_1451 VDD VDD VSS VSS gf180mcu_as_sc_mcu7t3v3__fillcap_16
Xmesh_tile_863 VDD VDD VSS VSS north_out[4] gf180mcu_as_sc_mcu7t3v3__tiel_4
Xmesh_tile_852 VDD VDD VSS VSS ne_out[27] gf180mcu_as_sc_mcu7t3v3__tiel_4
Xmesh_tile_841 VDD VDD VSS VSS ne_out[16] gf180mcu_as_sc_mcu7t3v3__tiel_4
Xmesh_tile_830 VDD VDD VSS VSS ne_out[5] gf180mcu_as_sc_mcu7t3v3__tiel_4
X_3238_ VDD VDD VSS VSS _3240_/C _3238_/C _3238_/B _3238_/A gf180mcu_as_sc_mcu7t3v3__aoi21_2
Xmesh_tile_896 VDD VDD VSS VSS nw_out[3] gf180mcu_as_sc_mcu7t3v3__tiel_4
Xmesh_tile_885 VDD VDD VSS VSS north_out[26] gf180mcu_as_sc_mcu7t3v3__tiel_4
Xmesh_tile_874 VDD VDD VSS VSS north_out[15] gf180mcu_as_sc_mcu7t3v3__tiel_4
X_3169_ VDD VDD VSS VSS _4144_/A _3177_/B _3169_/C _4143_/D _3170_/C gf180mcu_as_sc_mcu7t3v3__ao22_2
XTAP_TAPCELL_ROW_146_1474 VDD VSS gf180mcu_as_sc_mcu7t3v3__tap_2
XTAP_TAPCELL_ROW_146_1463 VDD VSS gf180mcu_as_sc_mcu7t3v3__tap_2
XFILLER_167_1536 VDD VDD VSS VSS gf180mcu_as_sc_mcu7t3v3__fillcap_4
XFILLER_120_12 VDD VDD VSS VSS gf180mcu_as_sc_mcu7t3v3__fill_1
XFILLER_167_1558 VDD VDD VSS VSS gf180mcu_as_sc_mcu7t3v3__fillcap_8
XPHY_EDGE_ROW_0_1_Left_637 VDD VSS gf180mcu_as_sc_mcu7t3v3__tap_2
XFILLER_167_212 VDD VDD VSS VSS gf180mcu_as_sc_mcu7t3v3__fillcap_16
XFILLER_80_27 VDD VDD VSS VSS gf180mcu_as_sc_mcu7t3v3__fillcap_8
XFILLER_149_960 VDD VDD VSS VSS gf180mcu_as_sc_mcu7t3v3__fillcap_8
XFILLER_22_295 VDD VDD VSS VSS gf180mcu_as_sc_mcu7t3v3__fillcap_4
XPHY_EDGE_ROW_44_1_Right_43 VDD VSS gf180mcu_as_sc_mcu7t3v3__tap_2
XFILLER_149_982 VDD VDD VSS VSS gf180mcu_as_sc_mcu7t3v3__fill_2
XFILLER_155_418 VDD VDD VSS VSS gf180mcu_as_sc_mcu7t3v3__fill_2
XFILLER_104_1564 VDD VDD VSS VSS gf180mcu_as_sc_mcu7t3v3__fill_1
XFILLER_129_65 VDD VDD VSS VSS gf180mcu_as_sc_mcu7t3v3__fillcap_4
XFILLER_87_1515 VDD VDD VSS VSS gf180mcu_as_sc_mcu7t3v3__fillcap_4
XPHY_EDGE_ROW_15_1_Left_467 VDD VSS gf180mcu_as_sc_mcu7t3v3__tap_2
XFILLER_135_142 VDD VDD VSS VSS gf180mcu_as_sc_mcu7t3v3__fill_2
XFILLER_163_462 VDD VDD VSS VSS gf180mcu_as_sc_mcu7t3v3__fillcap_4
XFILLER_174_1507 VDD VDD VSS VSS gf180mcu_as_sc_mcu7t3v3__fillcap_16
XFILLER_87_1537 VDD VDD VSS VSS gf180mcu_as_sc_mcu7t3v3__fillcap_16
XFILLER_151_624 VDD VDD VSS VSS gf180mcu_as_sc_mcu7t3v3__fillcap_4
XFILLER_89_69 VDD VDD VSS VSS gf180mcu_as_sc_mcu7t3v3__fill_1
XFILLER_150_123 VDD VDD VSS VSS gf180mcu_as_sc_mcu7t3v3__fillcap_16
XPHY_EDGE_ROW_155_Left_607 VDD VSS gf180mcu_as_sc_mcu7t3v3__tap_2
XFILLER_172_1297 VDD VDD VSS VSS gf180mcu_as_sc_mcu7t3v3__fillcap_16
XFILLER_166_1002 VDD VDD VSS VSS gf180mcu_as_sc_mcu7t3v3__fillcap_8
XFILLER_159_702 VDD VDD VSS VSS gf180mcu_as_sc_mcu7t3v3__fillcap_8
XFILLER_166_1057 VDD VDD VSS VSS gf180mcu_as_sc_mcu7t3v3__fill_1
XPHY_EDGE_ROW_164_Left_616 VDD VSS gf180mcu_as_sc_mcu7t3v3__tap_2
XFILLER_158_201 VDD VDD VSS VSS gf180mcu_as_sc_mcu7t3v3__fillcap_4
XFILLER_144_1399 VDD VDD VSS VSS gf180mcu_as_sc_mcu7t3v3__fill_2
XFILLER_146_418 VDD VDD VSS VSS gf180mcu_as_sc_mcu7t3v3__fillcap_16
XFILLER_9_244 VDD VDD VSS VSS gf180mcu_as_sc_mcu7t3v3__fillcap_16
XFILLER_139_492 VDD VDD VSS VSS gf180mcu_as_sc_mcu7t3v3__fill_2
Xclkload14 VDD VDD VSS VSS clkload14/Y _5159_/CLK gf180mcu_as_sc_mcu7t3v3__inv_2
Xclkload25 VDD VDD VSS VSS _5183_/CLK clkload25/Y gf180mcu_as_sc_mcu7t3v3__clkbuff_4
XPHY_EDGE_ROW_37_3_Right_356 VDD VSS gf180mcu_as_sc_mcu7t3v3__tap_2
X_2540_ VDD VDD VSS VSS _2541_/C _4371_/B _4372_/D _2792_/A gf180mcu_as_sc_mcu7t3v3__aoi21_2
XFILLER_141_112 VDD VDD VSS VSS gf180mcu_as_sc_mcu7t3v3__fill_2
XFILLER_142_613 VDD VDD VSS VSS gf180mcu_as_sc_mcu7t3v3__fillcap_8
XFILLER_154_473 VDD VDD VSS VSS gf180mcu_as_sc_mcu7t3v3__fillcap_4
XFILLER_170_922 VDD VDD VSS VSS gf180mcu_as_sc_mcu7t3v3__fillcap_4
XFILLER_170_944 VDD VDD VSS VSS gf180mcu_as_sc_mcu7t3v3__fill_1
XPHY_EDGE_ROW_173_Left_625 VDD VSS gf180mcu_as_sc_mcu7t3v3__tap_2
X_2471_ VDD VDD VSS VSS _2472_/B _2471_/A gf180mcu_as_sc_mcu7t3v3__inv_2
XFILLER_142_679 VDD VDD VSS VSS gf180mcu_as_sc_mcu7t3v3__fill_2
XFILLER_79_80 VDD VDD VSS VSS gf180mcu_as_sc_mcu7t3v3__fillcap_8
XFILLER_9_1515 VDD VDD VSS VSS gf180mcu_as_sc_mcu7t3v3__fillcap_4
X_4210_ VDD VDD VSS VSS _4239_/B _4218_/B _4221_/C _5046_/Q _5046_/D gf180mcu_as_sc_mcu7t3v3__ao22_2
XFILLER_170_999 VDD VDD VSS VSS gf180mcu_as_sc_mcu7t3v3__fill_2
XFILLER_9_1537 VDD VDD VSS VSS gf180mcu_as_sc_mcu7t3v3__fillcap_16
X_5190_ VDD VDD VSS VSS _5199_/CLK _5190_/D _5190_/Q gf180mcu_as_sc_mcu7t3v3__dfxtp_2
X_4141_ VDD VDD VSS VSS _4141_/A _4141_/B _4141_/C _4254_/B _4141_/D gf180mcu_as_sc_mcu7t3v3__aoi211_2
X_4072_ VDD VDD VSS VSS _4072_/A _4103_/B _4101_/C _4072_/D _4073_/D gf180mcu_as_sc_mcu7t3v3__ao22_2
XFILLER_95_298 VDD VDD VSS VSS gf180mcu_as_sc_mcu7t3v3__fill_2
X_3023_ VDD VDD VSS VSS _4003_/A _3149_/B _3023_/C _4779_/D _3746_/D gf180mcu_as_sc_mcu7t3v3__aoi211_2
XFILLER_149_1255 VDD VDD VSS VSS gf180mcu_as_sc_mcu7t3v3__fillcap_4
XPHY_EDGE_ROW_182_Left_634 VDD VSS gf180mcu_as_sc_mcu7t3v3__tap_2
X_4974_ VDD VDD VSS VSS clkload2/A _4974_/D _4974_/Q gf180mcu_as_sc_mcu7t3v3__dfxtp_2
XTAP_TAPCELL_ROW_141_1360 VDD VSS gf180mcu_as_sc_mcu7t3v3__tap_2
XFILLER_149_212 VDD VDD VSS VSS gf180mcu_as_sc_mcu7t3v3__fillcap_16
XFILLER_162_1411 VDD VDD VSS VSS gf180mcu_as_sc_mcu7t3v3__fillcap_16
X_3925_ VDD VDD VSS VSS _3925_/A _4160_/B _4161_/B _3925_/D _3926_/D gf180mcu_as_sc_mcu7t3v3__ao22_2
XTAP_TAPCELL_ROW_176_2135 VDD VSS gf180mcu_as_sc_mcu7t3v3__tap_2
XTAP_TAPCELL_ROW_176_2124 VDD VSS gf180mcu_as_sc_mcu7t3v3__tap_2
XFILLER_162_1444 VDD VDD VSS VSS gf180mcu_as_sc_mcu7t3v3__fillcap_16
Xclkload8 VDD VDD VSS VSS clkload8/Y clkload8/A gf180mcu_as_sc_mcu7t3v3__inv_4
X_3856_ VDD VDD VSS VSS _5144_/Q _5143_/Q _3857_/C gf180mcu_as_sc_mcu7t3v3__or2_2
XFILLER_146_930 VDD VDD VSS VSS gf180mcu_as_sc_mcu7t3v3__fill_1
X_3787_ VDD VDD VSS VSS _3818_/D _3787_/A _3796_/C gf180mcu_as_sc_mcu7t3v3__and2_2
X_2807_ VDD VDD VSS VSS _4660_/A _4259_/C _4643_/B gf180mcu_as_sc_mcu7t3v3__nor2_2
XFILLER_117_142 VDD VDD VSS VSS gf180mcu_as_sc_mcu7t3v3__fill_2
XFILLER_161_900 VDD VDD VSS VSS gf180mcu_as_sc_mcu7t3v3__fillcap_8
X_2738_ VDD VDD VSS VSS _4947_/Q _2738_/B _2738_/A _5479_/A gf180mcu_as_sc_mcu7t3v3__mux2_2
XFILLER_117_175 VDD VDD VSS VSS gf180mcu_as_sc_mcu7t3v3__fill_1
XFILLER_161_922 VDD VDD VSS VSS gf180mcu_as_sc_mcu7t3v3__fillcap_4
XFILLER_132_145 VDD VDD VSS VSS gf180mcu_as_sc_mcu7t3v3__fill_2
XFILLER_156_1259 VDD VDD VSS VSS gf180mcu_as_sc_mcu7t3v3__fillcap_16
XFILLER_160_454 VDD VDD VSS VSS gf180mcu_as_sc_mcu7t3v3__fill_1
XFILLER_182_18 VDD VDD VSS VSS gf180mcu_as_sc_mcu7t3v3__fillcap_16
XFILLER_47_1521 VDD VDD VSS VSS gf180mcu_as_sc_mcu7t3v3__fillcap_16
X_4408_ VDD VDD VSS VSS _5169_/Q _4470_/B _4493_/C _5119_/Q _4409_/B gf180mcu_as_sc_mcu7t3v3__ao22_2
X_2669_ VDD VDD VSS VSS _2673_/B _5133_/Q _2670_/D gf180mcu_as_sc_mcu7t3v3__and2_2
XFILLER_173_1562 VDD VDD VSS VSS gf180mcu_as_sc_mcu7t3v3__fill_2
XTAP_TAPCELL_ROW_30_1_754 VDD VSS gf180mcu_as_sc_mcu7t3v3__tap_2
XFILLER_82_1467 VDD VDD VSS VSS gf180mcu_as_sc_mcu7t3v3__fillcap_16
XFILLER_86_232 VDD VDD VSS VSS gf180mcu_as_sc_mcu7t3v3__fillcap_8
X_4339_ VDD VDD VSS VSS _4350_/C _4339_/B _4350_/A gf180mcu_as_sc_mcu7t3v3__nor2_2
XTAP_TAPCELL_ROW_148_1514 VDD VSS gf180mcu_as_sc_mcu7t3v3__tap_2
XTAP_TAPCELL_ROW_148_1503 VDD VSS gf180mcu_as_sc_mcu7t3v3__tap_2
XFILLER_134_1568 VDD VDD VSS VSS gf180mcu_as_sc_mcu7t3v3__fill_1
XFILLER_75_27 VDD VDD VSS VSS gf180mcu_as_sc_mcu7t3v3__fillcap_8
XFILLER_46_107 VDD VDD VSS VSS gf180mcu_as_sc_mcu7t3v3__fillcap_16
XTAP_TAPCELL_ROW_165_1894 VDD VSS gf180mcu_as_sc_mcu7t3v3__tap_2
XTAP_TAPCELL_ROW_165_1883 VDD VSS gf180mcu_as_sc_mcu7t3v3__tap_2
XFILLER_167_1355 VDD VDD VSS VSS gf180mcu_as_sc_mcu7t3v3__fillcap_16
XFILLER_131_88 VDD VDD VSS VSS gf180mcu_as_sc_mcu7t3v3__fillcap_4
XFILLER_167_1388 VDD VDD VSS VSS gf180mcu_as_sc_mcu7t3v3__fillcap_8
XFILLER_91_37 VDD VDD VSS VSS gf180mcu_as_sc_mcu7t3v3__fill_1
XFILLER_91_48 VDD VDD VSS VSS gf180mcu_as_sc_mcu7t3v3__fillcap_16
XFILLER_165_1090 VDD VDD VSS VSS gf180mcu_as_sc_mcu7t3v3__fillcap_16
XFILLER_180_1555 VDD VDD VSS VSS gf180mcu_as_sc_mcu7t3v3__fillcap_8
XFILLER_24_53 VDD VDD VSS VSS gf180mcu_as_sc_mcu7t3v3__fillcap_16
XFILLER_138_2 VDD VDD VSS VSS gf180mcu_as_sc_mcu7t3v3__fillcap_16
XFILLER_155_204 VDD VDD VSS VSS gf180mcu_as_sc_mcu7t3v3__fillcap_4
XFILLER_168_587 VDD VDD VSS VSS gf180mcu_as_sc_mcu7t3v3__fill_1
XFILLER_156_749 VDD VDD VSS VSS gf180mcu_as_sc_mcu7t3v3__fill_1
XFILLER_6_225 VDD VDD VSS VSS gf180mcu_as_sc_mcu7t3v3__fillcap_16
XFILLER_136_440 VDD VDD VSS VSS gf180mcu_as_sc_mcu7t3v3__fillcap_4
XFILLER_137_974 VDD VDD VSS VSS gf180mcu_as_sc_mcu7t3v3__fillcap_4
XFILLER_139_1402 VDD VDD VSS VSS gf180mcu_as_sc_mcu7t3v3__fillcap_16
XFILLER_6_247 VDD VDD VSS VSS gf180mcu_as_sc_mcu7t3v3__fillcap_8
XFILLER_151_410 VDD VDD VSS VSS gf180mcu_as_sc_mcu7t3v3__fill_2
XFILLER_152_944 VDD VDD VSS VSS gf180mcu_as_sc_mcu7t3v3__fill_1
XFILLER_164_793 VDD VDD VSS VSS gf180mcu_as_sc_mcu7t3v3__fillcap_8
XFILLER_40_96 VDD VDD VSS VSS gf180mcu_as_sc_mcu7t3v3__fillcap_8
XFILLER_108_197 VDD VDD VSS VSS gf180mcu_as_sc_mcu7t3v3__fill_2
XFILLER_123_134 VDD VDD VSS VSS gf180mcu_as_sc_mcu7t3v3__fillcap_4
XFILLER_156_85 VDD VDD VSS VSS gf180mcu_as_sc_mcu7t3v3__fillcap_4
XPHY_EDGE_ROW_168_Right_302 VDD VSS gf180mcu_as_sc_mcu7t3v3__tap_2
XFILLER_152_988 VDD VDD VSS VSS gf180mcu_as_sc_mcu7t3v3__fillcap_8
XTAP_TAPCELL_ROW_56_3_2433 VDD VSS gf180mcu_as_sc_mcu7t3v3__tap_2
XTAP_TAPCELL_ROW_16_1_699 VDD VSS gf180mcu_as_sc_mcu7t3v3__tap_2
XFILLER_137_1170 VDD VDD VSS VSS gf180mcu_as_sc_mcu7t3v3__fillcap_8
XFILLER_151_498 VDD VDD VSS VSS gf180mcu_as_sc_mcu7t3v3__fill_1
XFILLER_49_72 VDD VDD VSS VSS gf180mcu_as_sc_mcu7t3v3__fillcap_16
XFILLER_77_298 VDD VDD VSS VSS gf180mcu_as_sc_mcu7t3v3__fill_2
Xfanout790 VDD VDD VSS VSS _2709_/A _2737_/A gf180mcu_as_sc_mcu7t3v3__buff_2
XFILLER_4_1467 VDD VDD VSS VSS gf180mcu_as_sc_mcu7t3v3__fillcap_16
XPHY_EDGE_ROW_122_3_Left_256 VDD VSS gf180mcu_as_sc_mcu7t3v3__tap_2
XFILLER_146_1439 VDD VDD VSS VSS gf180mcu_as_sc_mcu7t3v3__fill_1
X_3710_ VDD VDD VSS VSS _3714_/B _3710_/C _3726_/B _4086_/A gf180mcu_as_sc_mcu7t3v3__aoi21_2
XFILLER_81_92 VDD VDD VSS VSS gf180mcu_as_sc_mcu7t3v3__fill_2
X_4690_ VDD VDD VSS VSS _5250_/D _5250_/Q _4691_/D _4690_/C gf180mcu_as_sc_mcu7t3v3__ao21_2
XTAP_TAPCELL_ROW_171_2010 VDD VSS gf180mcu_as_sc_mcu7t3v3__tap_2
XFILLER_140_1049 VDD VDD VSS VSS gf180mcu_as_sc_mcu7t3v3__fillcap_4
XFILLER_174_535 VDD VDD VSS VSS gf180mcu_as_sc_mcu7t3v3__fillcap_4
X_3641_ VDD VDD VSS VSS _3642_/C _4013_/A _3742_/B _3641_/C gf180mcu_as_sc_mcu7t3v3__ao21_2
XTAP_TAPCELL_ROW_171_2021 VDD VSS gf180mcu_as_sc_mcu7t3v3__tap_2
XFILLER_122_1483 VDD VDD VSS VSS gf180mcu_as_sc_mcu7t3v3__fill_1
XFILLER_179_1259 VDD VDD VSS VSS gf180mcu_as_sc_mcu7t3v3__fill_1
X_3572_ VDD VDD VSS VSS _3934_/A _3802_/B _3802_/C _3573_/C _3572_/D gf180mcu_as_sc_mcu7t3v3__aoi211_2
XFILLER_142_410 VDD VDD VSS VSS gf180mcu_as_sc_mcu7t3v3__fill_2
XFILLER_143_944 VDD VDD VSS VSS gf180mcu_as_sc_mcu7t3v3__fillcap_4
XFILLER_161_229 VDD VDD VSS VSS gf180mcu_as_sc_mcu7t3v3__fillcap_4
XPHY_EDGE_ROW_38_3_Right_357 VDD VSS gf180mcu_as_sc_mcu7t3v3__tap_2
X_2523_ VDD VDD VSS VSS _2847_/A _5227_/Q _2842_/D gf180mcu_as_sc_mcu7t3v3__or2_2
XFILLER_114_134 VDD VDD VSS VSS gf180mcu_as_sc_mcu7t3v3__fillcap_8
XFILLER_142_432 VDD VDD VSS VSS gf180mcu_as_sc_mcu7t3v3__fill_1
XFILLER_143_977 VDD VDD VSS VSS gf180mcu_as_sc_mcu7t3v3__fill_2
XFILLER_154_292 VDD VDD VSS VSS gf180mcu_as_sc_mcu7t3v3__fillcap_16
XFILLER_157_1535 VDD VDD VSS VSS gf180mcu_as_sc_mcu7t3v3__fillcap_4
XFILLER_170_763 VDD VDD VSS VSS gf180mcu_as_sc_mcu7t3v3__fillcap_4
XFILLER_142_465 VDD VDD VSS VSS gf180mcu_as_sc_mcu7t3v3__fillcap_4
XFILLER_170_785 VDD VDD VSS VSS gf180mcu_as_sc_mcu7t3v3__fill_2
X_5242_ VDD VDD VSS VSS clkload7/A _5242_/D _5242_/Q gf180mcu_as_sc_mcu7t3v3__dfxtp_2
X_2454_ VDD VDD VSS VSS _4341_/S _5091_/Q _5004_/Q _2455_/A gf180mcu_as_sc_mcu7t3v3__mux2_2
XFILLER_155_1270 VDD VDD VSS VSS gf180mcu_as_sc_mcu7t3v3__fill_2
X_5173_ VDD VDD VSS VSS _5173_/CLK _5173_/D _5173_/Q gf180mcu_as_sc_mcu7t3v3__dfxtp_2
X_4124_ VDD VDD VSS VSS _4124_/A _4124_/B _4124_/C _4252_/B _4124_/D gf180mcu_as_sc_mcu7t3v3__aoi211_2
XFILLER_28_107 VDD VDD VSS VSS gf180mcu_as_sc_mcu7t3v3__fillcap_16
XFILLER_42_1451 VDD VDD VSS VSS gf180mcu_as_sc_mcu7t3v3__fillcap_16
XFILLER_68_298 VDD VDD VSS VSS gf180mcu_as_sc_mcu7t3v3__fill_2
XFILLER_83_224 VDD VDD VSS VSS gf180mcu_as_sc_mcu7t3v3__fillcap_16
Xinput1 VDD VDD VSS VSS boot_addr[0] input1/Y gf180mcu_as_sc_mcu7t3v3__buff_2
XPHY_EDGE_ROW_54_3_Left_188 VDD VSS gf180mcu_as_sc_mcu7t3v3__tap_2
X_4055_ VDD VDD VSS VSS _4055_/A _4121_/B _4055_/C _4055_/D _4057_/C gf180mcu_as_sc_mcu7t3v3__ao211_2
XTAP_TAPCELL_ROW_143_1411 VDD VSS gf180mcu_as_sc_mcu7t3v3__tap_2
XTAP_TAPCELL_ROW_143_1400 VDD VSS gf180mcu_as_sc_mcu7t3v3__tap_2
XFILLER_36_151 VDD VDD VSS VSS gf180mcu_as_sc_mcu7t3v3__fill_2
X_3006_ VDD VDD VSS VSS _3616_/A _3124_/B _3006_/C _4777_/D _3661_/D gf180mcu_as_sc_mcu7t3v3__aoi211_2
XFILLER_101_14 VDD VDD VSS VSS gf180mcu_as_sc_mcu7t3v3__fill_2
XFILLER_149_1052 VDD VDD VSS VSS gf180mcu_as_sc_mcu7t3v3__fillcap_16
XTAP_TAPCELL_ROW_33_1_769 VDD VSS gf180mcu_as_sc_mcu7t3v3__tap_2
XFILLER_164_1539 VDD VDD VSS VSS gf180mcu_as_sc_mcu7t3v3__fillcap_16
XTAP_TAPCELL_ROW_160_1780 VDD VSS gf180mcu_as_sc_mcu7t3v3__tap_2
XFILLER_178_830 VDD VDD VSS VSS gf180mcu_as_sc_mcu7t3v3__fillcap_8
XFILLER_51_198 VDD VDD VSS VSS gf180mcu_as_sc_mcu7t3v3__fill_1
X_4957_ VDD VDD VSS VSS clkload9/A _4957_/D _4957_/Q gf180mcu_as_sc_mcu7t3v3__dfxtp_2
XFILLER_162_1285 VDD VDD VSS VSS gf180mcu_as_sc_mcu7t3v3__fillcap_8
XFILLER_177_18 VDD VDD VSS VSS gf180mcu_as_sc_mcu7t3v3__fillcap_16
XFILLER_178_874 VDD VDD VSS VSS gf180mcu_as_sc_mcu7t3v3__fill_1
X_4888_ VDD VDD VSS VSS _5146_/CLK _4888_/D _4888_/Q gf180mcu_as_sc_mcu7t3v3__dfxtp_2
X_3908_ VDD VDD VSS VSS _3908_/B _5161_/Q _4977_/D gf180mcu_as_sc_mcu7t3v3__and2_2
XTAP_TAPCELL_ROW_62_3_2443 VDD VSS gf180mcu_as_sc_mcu7t3v3__tap_2
XFILLER_138_749 VDD VDD VSS VSS gf180mcu_as_sc_mcu7t3v3__fill_2
XFILLER_177_384 VDD VDD VSS VSS gf180mcu_as_sc_mcu7t3v3__fillcap_16
X_3839_ VDD VDD VSS VSS _3839_/B _3839_/A _4911_/D gf180mcu_as_sc_mcu7t3v3__and2_2
XFILLER_14_1564 VDD VDD VSS VSS gf180mcu_as_sc_mcu7t3v3__fillcap_4
XFILLER_3_206 VDD VDD VSS VSS gf180mcu_as_sc_mcu7t3v3__fillcap_4
XFILLER_180_549 VDD VDD VSS VSS gf180mcu_as_sc_mcu7t3v3__fillcap_4
XFILLER_84_1518 VDD VDD VSS VSS gf180mcu_as_sc_mcu7t3v3__fillcap_16
XFILLER_134_988 VDD VDD VSS VSS gf180mcu_as_sc_mcu7t3v3__fillcap_8
Xoutput371 VDD VDD VSS VSS _4791_/Q se_out[20] gf180mcu_as_sc_mcu7t3v3__buff_2
Xoutput360 VDD VDD VSS VSS _4781_/Q se_out[10] gf180mcu_as_sc_mcu7t3v3__buff_2
XFILLER_120_104 VDD VDD VSS VSS gf180mcu_as_sc_mcu7t3v3__fill_1
XFILLER_134_1310 VDD VDD VSS VSS gf180mcu_as_sc_mcu7t3v3__fillcap_16
XFILLER_173_1370 VDD VDD VSS VSS gf180mcu_as_sc_mcu7t3v3__fillcap_4
XFILLER_86_37 VDD VDD VSS VSS gf180mcu_as_sc_mcu7t3v3__fill_1
Xoutput393 VDD VDD VSS VSS _4805_/Q south_out[0] gf180mcu_as_sc_mcu7t3v3__buff_2
Xoutput382 VDD VDD VSS VSS _4801_/Q se_out[30] gf180mcu_as_sc_mcu7t3v3__buff_2
XTAP_TAPCELL_ROW_167_1923 VDD VSS gf180mcu_as_sc_mcu7t3v3__tap_2
XTAP_TAPCELL_ROW_167_1934 VDD VSS gf180mcu_as_sc_mcu7t3v3__tap_2
XTAP_TAPCELL_ROW_12_1_683 VDD VSS gf180mcu_as_sc_mcu7t3v3__tap_2
XFILLER_142_10 VDD VDD VSS VSS gf180mcu_as_sc_mcu7t3v3__fill_2
XFILLER_142_32 VDD VDD VSS VSS gf180mcu_as_sc_mcu7t3v3__fill_2
XFILLER_59_298 VDD VDD VSS VSS gf180mcu_as_sc_mcu7t3v3__fill_2
XFILLER_142_65 VDD VDD VSS VSS gf180mcu_as_sc_mcu7t3v3__fillcap_16
XFILLER_167_1152 VDD VDD VSS VSS gf180mcu_as_sc_mcu7t3v3__fillcap_8
XFILLER_35_30 VDD VDD VSS VSS gf180mcu_as_sc_mcu7t3v3__fillcap_16
XFILLER_163_1049 VDD VDD VSS VSS gf180mcu_as_sc_mcu7t3v3__fill_1
XFILLER_169_830 VDD VDD VSS VSS gf180mcu_as_sc_mcu7t3v3__fillcap_8
XFILLER_145_1472 VDD VDD VSS VSS gf180mcu_as_sc_mcu7t3v3__fillcap_16
XFILLER_42_198 VDD VDD VSS VSS gf180mcu_as_sc_mcu7t3v3__fill_1
XFILLER_106_1467 VDD VDD VSS VSS gf180mcu_as_sc_mcu7t3v3__fillcap_16
XFILLER_128_204 VDD VDD VSS VSS gf180mcu_as_sc_mcu7t3v3__fillcap_8
XFILLER_141_1336 VDD VDD VSS VSS gf180mcu_as_sc_mcu7t3v3__fill_2
XFILLER_156_524 VDD VDD VSS VSS gf180mcu_as_sc_mcu7t3v3__fill_1
XFILLER_144_708 VDD VDD VSS VSS gf180mcu_as_sc_mcu7t3v3__fillcap_4
Xwire465 VDD VDD VSS VSS _2650_/Y wire465/Y gf180mcu_as_sc_mcu7t3v3__buff_8
XFILLER_135_1118 VDD VDD VSS VSS gf180mcu_as_sc_mcu7t3v3__fill_2
XFILLER_152_763 VDD VDD VSS VSS gf180mcu_as_sc_mcu7t3v3__fill_2
XFILLER_152_785 VDD VDD VSS VSS gf180mcu_as_sc_mcu7t3v3__fill_2
XFILLER_111_126 VDD VDD VSS VSS gf180mcu_as_sc_mcu7t3v3__fill_1
XFILLER_139_1298 VDD VDD VSS VSS gf180mcu_as_sc_mcu7t3v3__fillcap_16
XFILLER_140_947 VDD VDD VSS VSS gf180mcu_as_sc_mcu7t3v3__fill_2
XFILLER_183_72 VDD VDD VSS VSS gf180mcu_as_sc_mcu7t3v3__fillcap_4
XFILLER_65_1451 VDD VDD VSS VSS gf180mcu_as_sc_mcu7t3v3__fillcap_16
XFILLER_152_1454 VDD VDD VSS VSS gf180mcu_as_sc_mcu7t3v3__fillcap_16
XFILLER_6_1518 VDD VDD VSS VSS gf180mcu_as_sc_mcu7t3v3__fillcap_16
XFILLER_65_279 VDD VDD VSS VSS gf180mcu_as_sc_mcu7t3v3__fill_1
XFILLER_179_616 VDD VDD VSS VSS gf180mcu_as_sc_mcu7t3v3__fillcap_8
XFILLER_179_638 VDD VDD VSS VSS gf180mcu_as_sc_mcu7t3v3__fill_1
XFILLER_92_80 VDD VDD VSS VSS gf180mcu_as_sc_mcu7t3v3__fillcap_8
X_4905__962 VDD VDD VSS VSS _4905_/D gf180mcu_as_sc_mcu7t3v3__tiel_4
X_4811_ VDD VDD VSS VSS _4904_/CLK _4811_/D _4811_/Q gf180mcu_as_sc_mcu7t3v3__dfxtp_2
XTAP_TAPCELL_ROW_21_1_718 VDD VSS gf180mcu_as_sc_mcu7t3v3__tap_2
XFILLER_181_1149 VDD VDD VSS VSS gf180mcu_as_sc_mcu7t3v3__fillcap_8
XFILLER_37_1553 VDD VDD VSS VSS gf180mcu_as_sc_mcu7t3v3__fillcap_16
XFILLER_124_1534 VDD VDD VSS VSS gf180mcu_as_sc_mcu7t3v3__fillcap_16
XFILLER_175_800 VDD VDD VSS VSS gf180mcu_as_sc_mcu7t3v3__fillcap_8
X_4742_ VDD VDD VSS VSS _5272_/D _4742_/C _4742_/B _4742_/A gf180mcu_as_sc_mcu7t3v3__aoi21b_2
XFILLER_119_204 VDD VDD VSS VSS gf180mcu_as_sc_mcu7t3v3__fillcap_4
XFILLER_124_1556 VDD VDD VSS VSS gf180mcu_as_sc_mcu7t3v3__fill_1
X_4673_ VDD VDD VSS VSS _5114_/Q _4688_/B _4681_/C _5245_/Q _4674_/C gf180mcu_as_sc_mcu7t3v3__ao22_2
XFILLER_175_877 VDD VDD VSS VSS gf180mcu_as_sc_mcu7t3v3__fillcap_16
X_3624_ VDD VDD VSS VSS _3624_/B _3624_/A _4846_/D gf180mcu_as_sc_mcu7t3v3__and2_2
XFILLER_174_365 VDD VDD VSS VSS gf180mcu_as_sc_mcu7t3v3__fillcap_16
XFILLER_174_387 VDD VDD VSS VSS gf180mcu_as_sc_mcu7t3v3__fillcap_16
XFILLER_179_1067 VDD VDD VSS VSS gf180mcu_as_sc_mcu7t3v3__fillcap_4
XFILLER_143_752 VDD VDD VSS VSS gf180mcu_as_sc_mcu7t3v3__fillcap_8
XFILLER_157_1332 VDD VDD VSS VSS gf180mcu_as_sc_mcu7t3v3__fillcap_4
X_3555_ VDD VDD VSS VSS _3559_/C _3561_/B _3561_/A gf180mcu_as_sc_mcu7t3v3__nand2b_2
XPHY_EDGE_ROW_39_3_Right_358 VDD VSS gf180mcu_as_sc_mcu7t3v3__tap_2
X_3486_ VDD VDD VSS VSS _4941_/Q _3486_/B _3501_/B _4144_/A _3487_/D gf180mcu_as_sc_mcu7t3v3__ao22_2
X_2506_ VDD VDD VSS VSS _4736_/B _5270_/Q _4739_/B gf180mcu_as_sc_mcu7t3v3__and2_2
XFILLER_102_104 VDD VDD VSS VSS gf180mcu_as_sc_mcu7t3v3__fill_1
XFILLER_142_295 VDD VDD VSS VSS gf180mcu_as_sc_mcu7t3v3__fillcap_8
XFILLER_143_796 VDD VDD VSS VSS gf180mcu_as_sc_mcu7t3v3__fillcap_4
XFILLER_157_1398 VDD VDD VSS VSS gf180mcu_as_sc_mcu7t3v3__fill_2
XFILLER_170_593 VDD VDD VSS VSS gf180mcu_as_sc_mcu7t3v3__fill_2
XFILLER_44_1502 VDD VDD VSS VSS gf180mcu_as_sc_mcu7t3v3__fillcap_16
X_5225_ VDD VDD VSS VSS clkload6/A _5225_/D _5225_/Q gf180mcu_as_sc_mcu7t3v3__dfxtp_2
X_2437_ VDD VDD VSS VSS _3684_/A _4058_/A gf180mcu_as_sc_mcu7t3v3__inv_2
XFILLER_44_1546 VDD VDD VSS VSS gf180mcu_as_sc_mcu7t3v3__fill_2
XPHY_EDGE_ROW_53_1_Right_52 VDD VSS gf180mcu_as_sc_mcu7t3v3__tap_2
X_5156_ VDD VDD VSS VSS clkload8/A _5156_/D _5156_/Q gf180mcu_as_sc_mcu7t3v3__dfxtp_2
X_5087_ VDD VDD VSS VSS _5188_/CLK _5087_/D _5087_/Q gf180mcu_as_sc_mcu7t3v3__dfxtp_2
X_4107_ VDD VDD VSS VSS _4107_/B _4165_/A _4250_/B gf180mcu_as_sc_mcu7t3v3__and2_2
XTAP_TAPCELL_ROW_114_3_2520 VDD VSS gf180mcu_as_sc_mcu7t3v3__tap_2
X_4038_ VDD VDD VSS VSS _4038_/A _4119_/B _4124_/B _4038_/D _4042_/A gf180mcu_as_sc_mcu7t3v3__ao211_2
XTAP_TAPCELL_ROW_162_1831 VDD VSS gf180mcu_as_sc_mcu7t3v3__tap_2
XTAP_TAPCELL_ROW_162_1820 VDD VSS gf180mcu_as_sc_mcu7t3v3__tap_2
XPHY_EDGE_ROW_24_1_Left_476 VDD VSS gf180mcu_as_sc_mcu7t3v3__tap_2
XFILLER_169_104 VDD VDD VSS VSS gf180mcu_as_sc_mcu7t3v3__fillcap_16
XFILLER_129_1467 VDD VDD VSS VSS gf180mcu_as_sc_mcu7t3v3__fillcap_16
XFILLER_166_800 VDD VDD VSS VSS gf180mcu_as_sc_mcu7t3v3__fillcap_4
XFILLER_138_524 VDD VDD VSS VSS gf180mcu_as_sc_mcu7t3v3__fill_1
XFILLER_165_343 VDD VDD VSS VSS gf180mcu_as_sc_mcu7t3v3__fillcap_4
XFILLER_166_877 VDD VDD VSS VSS gf180mcu_as_sc_mcu7t3v3__fillcap_16
XTAP_TAPCELL_ROW_5_1_655 VDD VSS gf180mcu_as_sc_mcu7t3v3__tap_2
XFILLER_153_516 VDD VDD VSS VSS gf180mcu_as_sc_mcu7t3v3__fillcap_4
XFILLER_88_1451 VDD VDD VSS VSS gf180mcu_as_sc_mcu7t3v3__fillcap_16
XTAP_TAPCELL_ROW_156_1679 VDD VSS gf180mcu_as_sc_mcu7t3v3__tap_2
XFILLER_158_1129 VDD VDD VSS VSS gf180mcu_as_sc_mcu7t3v3__fillcap_4
XFILLER_97_14 VDD VDD VSS VSS gf180mcu_as_sc_mcu7t3v3__fill_2
XFILLER_133_251 VDD VDD VSS VSS gf180mcu_as_sc_mcu7t3v3__fill_1
XFILLER_161_593 VDD VDD VSS VSS gf180mcu_as_sc_mcu7t3v3__fillcap_16
XFILLER_171_1329 VDD VDD VSS VSS gf180mcu_as_sc_mcu7t3v3__fill_1
XFILLER_134_1162 VDD VDD VSS VSS gf180mcu_as_sc_mcu7t3v3__fill_2
XTAP_TAPCELL_ROW_61_1_878 VDD VSS gf180mcu_as_sc_mcu7t3v3__tap_2
XFILLER_147_1534 VDD VDD VSS VSS gf180mcu_as_sc_mcu7t3v3__fillcap_4
XFILLER_108_1518 VDD VDD VSS VSS gf180mcu_as_sc_mcu7t3v3__fillcap_16
XFILLER_95_1499 VDD VDD VSS VSS gf180mcu_as_sc_mcu7t3v3__fillcap_16
XFILLER_70_293 VDD VDD VSS VSS gf180mcu_as_sc_mcu7t3v3__fillcap_8
XFILLER_141_1122 VDD VDD VSS VSS gf180mcu_as_sc_mcu7t3v3__fill_2
XFILLER_30_168 VDD VDD VSS VSS gf180mcu_as_sc_mcu7t3v3__fill_1
XFILLER_7_34 VDD VDD VSS VSS gf180mcu_as_sc_mcu7t3v3__fillcap_16
XTAP_TAPCELL_ROW_44_3_2415 VDD VSS gf180mcu_as_sc_mcu7t3v3__tap_2
XFILLER_144_527 VDD VDD VSS VSS gf180mcu_as_sc_mcu7t3v3__fill_1
XFILLER_156_387 VDD VDD VSS VSS gf180mcu_as_sc_mcu7t3v3__fill_2
XFILLER_157_888 VDD VDD VSS VSS gf180mcu_as_sc_mcu7t3v3__fillcap_4
XFILLER_32_1483 VDD VDD VSS VSS gf180mcu_as_sc_mcu7t3v3__fill_1
XFILLER_171_346 VDD VDD VSS VSS gf180mcu_as_sc_mcu7t3v3__fillcap_4
XFILLER_124_251 VDD VDD VSS VSS gf180mcu_as_sc_mcu7t3v3__fill_2
XFILLER_171_368 VDD VDD VSS VSS gf180mcu_as_sc_mcu7t3v3__fillcap_16
X_3340_ VDD VDD VSS VSS _3502_/B _3992_/D _3340_/A _3342_/A gf180mcu_as_sc_mcu7t3v3__mux2_2
XTAP_TAPCELL_ROW_120_3_2530 VDD VSS gf180mcu_as_sc_mcu7t3v3__tap_2
X_5010_ VDD VDD VSS VSS _5173_/CLK _5010_/D _5010_/Q gf180mcu_as_sc_mcu7t3v3__dfxtp_2
X_3271_ VDD VDD VSS VSS _3271_/B _3271_/A _3442_/B gf180mcu_as_sc_mcu7t3v3__or2_2
Xhold1009 VDD VDD VSS VSS _2588_/Y hold1009/Y gf180mcu_as_sc_mcu7t3v3__buff_2
XFILLER_16_2 VDD VDD VSS VSS gf180mcu_as_sc_mcu7t3v3__fillcap_16
XFILLER_38_279 VDD VDD VSS VSS gf180mcu_as_sc_mcu7t3v3__fillcap_16
XFILLER_53_249 VDD VDD VSS VSS gf180mcu_as_sc_mcu7t3v3__fillcap_4
XFILLER_146_1055 VDD VDD VSS VSS gf180mcu_as_sc_mcu7t3v3__fill_1
XFILLER_166_107 VDD VDD VSS VSS gf180mcu_as_sc_mcu7t3v3__fillcap_16
XFILLER_61_282 VDD VDD VSS VSS gf180mcu_as_sc_mcu7t3v3__fillcap_16
X_2986_ VDD VDD VSS VSS _3178_/A _2986_/B _2986_/C _3178_/D _2987_/D gf180mcu_as_sc_mcu7t3v3__ao211_2
XFILLER_148_855 VDD VDD VSS VSS gf180mcu_as_sc_mcu7t3v3__fillcap_4
XFILLER_148_877 VDD VDD VSS VSS gf180mcu_as_sc_mcu7t3v3__fillcap_16
X_4725_ VDD VDD VSS VSS _5263_/D _5108_/Q _4731_/B _4725_/C gf180mcu_as_sc_mcu7t3v3__ao21_2
XFILLER_50_1550 VDD VDD VSS VSS gf180mcu_as_sc_mcu7t3v3__fillcap_4
X_4656_ VDD VDD VSS VSS _4659_/B _4656_/B _5238_/Q _5238_/D gf180mcu_as_sc_mcu7t3v3__mux2_2
XTAP_TAPCELL_ROW_134_1207 VDD VSS gf180mcu_as_sc_mcu7t3v3__tap_2
Xinput81 VDD VDD VSS VSS ne_in[12] _4032_/D gf180mcu_as_sc_mcu7t3v3__buff_2
Xinput70 VDD VDD VSS VSS east_in[33] _3533_/A gf180mcu_as_sc_mcu7t3v3__buff_2
X_4587_ VDD VDD VSS VSS _4588_/D _4587_/B _4587_/A gf180mcu_as_sc_mcu7t3v3__nor2_2
X_3607_ VDD VDD VSS VSS _3977_/A _3729_/B _3746_/B _3608_/C _3607_/D gf180mcu_as_sc_mcu7t3v3__aoi211_2
XFILLER_115_251 VDD VDD VSS VSS gf180mcu_as_sc_mcu7t3v3__fill_1
XFILLER_150_519 VDD VDD VSS VSS gf180mcu_as_sc_mcu7t3v3__fillcap_4
XFILLER_157_1140 VDD VDD VSS VSS gf180mcu_as_sc_mcu7t3v3__fill_1
Xinput92 VDD VDD VSS VSS ne_in[22] _4109_/A gf180mcu_as_sc_mcu7t3v3__buff_2
X_3538_ VDD VDD VSS VSS _3539_/B _4944_/Q _4945_/Q gf180mcu_as_sc_mcu7t3v3__nor2_2
XFILLER_107_35 VDD VDD VSS VSS gf180mcu_as_sc_mcu7t3v3__fill_2
XFILLER_157_1162 VDD VDD VSS VSS gf180mcu_as_sc_mcu7t3v3__fill_1
XTAP_TAPCELL_ROW_151_1587 VDD VSS gf180mcu_as_sc_mcu7t3v3__tap_2
XTAP_TAPCELL_ROW_151_1576 VDD VSS gf180mcu_as_sc_mcu7t3v3__tap_2
XFILLER_153_1048 VDD VDD VSS VSS gf180mcu_as_sc_mcu7t3v3__fill_2
X_3469_ VDD VDD VSS VSS _4122_/A _3469_/B _3469_/C _3470_/C _3470_/B gf180mcu_as_sc_mcu7t3v3__aoi211_2
XFILLER_130_265 VDD VDD VSS VSS gf180mcu_as_sc_mcu7t3v3__fill_1
XFILLER_170_1362 VDD VDD VSS VSS gf180mcu_as_sc_mcu7t3v3__fill_2
XFILLER_29_202 VDD VDD VSS VSS gf180mcu_as_sc_mcu7t3v3__fillcap_8
X_5208_ VDD VDD VSS VSS clkload0/A _5208_/D _5208_/Q gf180mcu_as_sc_mcu7t3v3__dfxtp_2
XFILLER_123_34 VDD VDD VSS VSS gf180mcu_as_sc_mcu7t3v3__fillcap_4
X_5139_ VDD VDD VSS VSS clkload9/A _5139_/D _5139_/Q gf180mcu_as_sc_mcu7t3v3__dfxtp_2
XFILLER_83_27 VDD VDD VSS VSS gf180mcu_as_sc_mcu7t3v3__fillcap_8
XTAP_TAPCELL_ROW_50_3_2425 VDD VSS gf180mcu_as_sc_mcu7t3v3__tap_2
XFILLER_164_1133 VDD VDD VSS VSS gf180mcu_as_sc_mcu7t3v3__fillcap_8
XFILLER_160_1019 VDD VDD VSS VSS gf180mcu_as_sc_mcu7t3v3__fill_1
Xsram2048.u_bank1_823 VDD VDD VSS VSS sram2048.u_bank1/WEN[5] gf180mcu_as_sc_mcu7t3v3__tiel_4
XFILLER_138_310 VDD VDD VSS VSS gf180mcu_as_sc_mcu7t3v3__fillcap_4
XFILLER_142_1420 VDD VDD VSS VSS gf180mcu_as_sc_mcu7t3v3__fillcap_8
XFILLER_181_1480 VDD VDD VSS VSS gf180mcu_as_sc_mcu7t3v3__fillcap_4
XFILLER_55_1483 VDD VDD VSS VSS gf180mcu_as_sc_mcu7t3v3__fillcap_16
XFILLER_154_803 VDD VDD VSS VSS gf180mcu_as_sc_mcu7t3v3__fill_2
XFILLER_16_1467 VDD VDD VSS VSS gf180mcu_as_sc_mcu7t3v3__fillcap_16
XFILLER_32_53 VDD VDD VSS VSS gf180mcu_as_sc_mcu7t3v3__fillcap_16
XFILLER_8_139 VDD VDD VSS VSS gf180mcu_as_sc_mcu7t3v3__fillcap_16
XFILLER_120_2 VDD VDD VSS VSS gf180mcu_as_sc_mcu7t3v3__fillcap_8
XFILLER_138_365 VDD VDD VSS VSS gf180mcu_as_sc_mcu7t3v3__fillcap_4
XFILLER_148_53 VDD VDD VSS VSS gf180mcu_as_sc_mcu7t3v3__fillcap_16
XFILLER_138_398 VDD VDD VSS VSS gf180mcu_as_sc_mcu7t3v3__fillcap_8
XFILLER_177_1527 VDD VDD VSS VSS gf180mcu_as_sc_mcu7t3v3__fillcap_8
XPHY_EDGE_ROW_79_3_Left_213 VDD VSS gf180mcu_as_sc_mcu7t3v3__tap_2
XFILLER_141_519 VDD VDD VSS VSS gf180mcu_as_sc_mcu7t3v3__fill_1
XFILLER_153_368 VDD VDD VSS VSS gf180mcu_as_sc_mcu7t3v3__fillcap_4
XFILLER_171_1115 VDD VDD VSS VSS gf180mcu_as_sc_mcu7t3v3__fillcap_4
XFILLER_175_1262 VDD VDD VSS VSS gf180mcu_as_sc_mcu7t3v3__fillcap_8
XPHY_EDGE_ROW_131_3_Left_265 VDD VSS gf180mcu_as_sc_mcu7t3v3__tap_2
XTAP_TAPCELL_ROW_20_1_717 VDD VSS gf180mcu_as_sc_mcu7t3v3__tap_2
XFILLER_164_85 VDD VDD VSS VSS gf180mcu_as_sc_mcu7t3v3__fillcap_16
XPHY_EDGE_ROW_9_1_Left_461 VDD VSS gf180mcu_as_sc_mcu7t3v3__tap_2
XFILLER_121_298 VDD VDD VSS VSS gf180mcu_as_sc_mcu7t3v3__fill_2
XFILLER_57_72 VDD VDD VSS VSS gf180mcu_as_sc_mcu7t3v3__fillcap_16
XFILLER_169_1033 VDD VDD VSS VSS gf180mcu_as_sc_mcu7t3v3__fillcap_4
XFILLER_43_260 VDD VDD VSS VSS gf180mcu_as_sc_mcu7t3v3__fillcap_16
XFILLER_147_1386 VDD VDD VSS VSS gf180mcu_as_sc_mcu7t3v3__fill_2
XFILLER_43_282 VDD VDD VSS VSS gf180mcu_as_sc_mcu7t3v3__fillcap_16
X_4902__965 VDD VDD VSS VSS _4902_/D gf180mcu_as_sc_mcu7t3v3__tiel_4
X_2840_ VDD VDD VSS VSS _2840_/A _2840_/B _2840_/C _2840_/D _2841_/B gf180mcu_as_sc_mcu7t3v3__nand4_2
XTAP_TAPCELL_ROW_129_1_1150 VDD VSS gf180mcu_as_sc_mcu7t3v3__tap_2
XFILLER_148_107 VDD VDD VSS VSS gf180mcu_as_sc_mcu7t3v3__fillcap_16
XFILLER_160_1531 VDD VDD VSS VSS gf180mcu_as_sc_mcu7t3v3__fillcap_4
XFILLER_34_1534 VDD VDD VSS VSS gf180mcu_as_sc_mcu7t3v3__fillcap_16
XFILLER_121_1515 VDD VDD VSS VSS gf180mcu_as_sc_mcu7t3v3__fillcap_4
XFILLER_34_1556 VDD VDD VSS VSS gf180mcu_as_sc_mcu7t3v3__fillcap_8
X_2771_ VDD VDD VSS VSS _2771_/A _2771_/B _2771_/C _2771_/D _2796_/B gf180mcu_as_sc_mcu7t3v3__ao211_2
XFILLER_11_190 VDD VDD VSS VSS gf180mcu_as_sc_mcu7t3v3__fillcap_16
XFILLER_121_1537 VDD VDD VSS VSS gf180mcu_as_sc_mcu7t3v3__fillcap_16
XFILLER_145_825 VDD VDD VSS VSS gf180mcu_as_sc_mcu7t3v3__fillcap_8
XFILLER_184_460 VDD VDD VSS VSS gf180mcu_as_sc_mcu7t3v3__fillcap_16
X_4510_ VDD VDD VSS VSS _4511_/D _4510_/B _4510_/A gf180mcu_as_sc_mcu7t3v3__nor2_2
XFILLER_145_858 VDD VDD VSS VSS gf180mcu_as_sc_mcu7t3v3__fillcap_8
X_4441_ VDD VDD VSS VSS _4442_/D _4441_/B _4562_/A gf180mcu_as_sc_mcu7t3v3__nor2_2
XTAP_TAPCELL_ROW_109_1_1070 VDD VSS gf180mcu_as_sc_mcu7t3v3__tap_2
XPHY_EDGE_ROW_63_3_Left_197 VDD VSS gf180mcu_as_sc_mcu7t3v3__tap_2
XFILLER_144_379 VDD VDD VSS VSS gf180mcu_as_sc_mcu7t3v3__fillcap_4
XFILLER_154_1313 VDD VDD VSS VSS gf180mcu_as_sc_mcu7t3v3__fillcap_8
X_4372_ VDD VDD VSS VSS _4736_/B _4372_/B _4372_/C _4373_/C _4372_/D gf180mcu_as_sc_mcu7t3v3__aoi31_2
XFILLER_112_243 VDD VDD VSS VSS gf180mcu_as_sc_mcu7t3v3__fill_2
XFILLER_154_1346 VDD VDD VSS VSS gf180mcu_as_sc_mcu7t3v3__fillcap_16
Xfanout608 VDD VDD VSS VSS _3742_/B _3717_/B gf180mcu_as_sc_mcu7t3v3__buff_2
Xfanout619 VDD VDD VSS VSS fanout622/Y _3475_/B gf180mcu_as_sc_mcu7t3v3__buff_2
X_3323_ VDD VDD VSS VSS _3973_/A _3451_/B _3323_/C _3323_/D _3324_/A gf180mcu_as_sc_mcu7t3v3__ao22_2
XFILLER_119_1499 VDD VDD VSS VSS gf180mcu_as_sc_mcu7t3v3__fillcap_16
XFILLER_140_585 VDD VDD VSS VSS gf180mcu_as_sc_mcu7t3v3__fillcap_8
X_3254_ VDD VDD VSS VSS _3518_/A _3818_/C _3254_/A gf180mcu_as_sc_mcu7t3v3__nand2_2
XFILLER_85_138 VDD VDD VSS VSS gf180mcu_as_sc_mcu7t3v3__fill_2
XTAP_TAPCELL_ROW_181_2248 VDD VSS gf180mcu_as_sc_mcu7t3v3__tap_2
XTAP_TAPCELL_ROW_181_2237 VDD VSS gf180mcu_as_sc_mcu7t3v3__tap_2
X_3185_ VDD VDD VSS VSS _3185_/D _4160_/D _3236_/B _3233_/B _3186_/D gf180mcu_as_sc_mcu7t3v3__ao31_2
XFILLER_81_300 VDD VDD VSS VSS gf180mcu_as_sc_mcu7t3v3__fill_1
XFILLER_93_193 VDD VDD VSS VSS gf180mcu_as_sc_mcu7t3v3__fillcap_4
XFILLER_41_208 VDD VDD VSS VSS gf180mcu_as_sc_mcu7t3v3__fill_2
XFILLER_78_1483 VDD VDD VSS VSS gf180mcu_as_sc_mcu7t3v3__fill_1
XFILLER_39_1467 VDD VDD VSS VSS gf180mcu_as_sc_mcu7t3v3__fillcap_16
XTAP_TAPCELL_ROW_179_2199 VDD VSS gf180mcu_as_sc_mcu7t3v3__tap_2
XTAP_TAPCELL_ROW_179_2188 VDD VSS gf180mcu_as_sc_mcu7t3v3__tap_2
XFILLER_139_129 VDD VDD VSS VSS gf180mcu_as_sc_mcu7t3v3__fillcap_8
XFILLER_167_416 VDD VDD VSS VSS gf180mcu_as_sc_mcu7t3v3__fillcap_4
XFILLER_167_438 VDD VDD VSS VSS gf180mcu_as_sc_mcu7t3v3__fillcap_16
XFILLER_179_276 VDD VDD VSS VSS gf180mcu_as_sc_mcu7t3v3__fillcap_4
XFILLER_179_298 VDD VDD VSS VSS gf180mcu_as_sc_mcu7t3v3__fillcap_16
XFILLER_183_909 VDD VDD VSS VSS gf180mcu_as_sc_mcu7t3v3__fill_1
X_2969_ VDD VDD VSS VSS _3178_/A _2969_/B _2969_/C _3178_/D _2971_/C gf180mcu_as_sc_mcu7t3v3__ao211_2
XFILLER_136_825 VDD VDD VSS VSS gf180mcu_as_sc_mcu7t3v3__fillcap_16
XFILLER_176_972 VDD VDD VSS VSS gf180mcu_as_sc_mcu7t3v3__fill_2
XFILLER_182_419 VDD VDD VSS VSS gf180mcu_as_sc_mcu7t3v3__fillcap_16
X_4708_ VDD VDD VSS VSS _4717_/S _4708_/A _4708_/B _4708_/C gf180mcu_as_sc_mcu7t3v3__ao21_2
XTAP_TAPCELL_ROW_153_1616 VDD VSS gf180mcu_as_sc_mcu7t3v3__tap_2
XTAP_TAPCELL_ROW_14_3_2370 VDD VSS gf180mcu_as_sc_mcu7t3v3__tap_2
XFILLER_159_1213 VDD VDD VSS VSS gf180mcu_as_sc_mcu7t3v3__fillcap_4
XTAP_TAPCELL_ROW_153_1627 VDD VSS gf180mcu_as_sc_mcu7t3v3__tap_2
XFILLER_118_34 VDD VDD VSS VSS gf180mcu_as_sc_mcu7t3v3__fill_1
XFILLER_150_305 VDD VDD VSS VSS gf180mcu_as_sc_mcu7t3v3__fill_1
X_4639_ VDD VDD VSS VSS _4733_/C _5105_/Q _5230_/Q _5230_/D gf180mcu_as_sc_mcu7t3v3__mux2_2
XTAP_TAPCELL_ROW_60_1_877 VDD VSS gf180mcu_as_sc_mcu7t3v3__tap_2
XFILLER_137_1522 VDD VDD VSS VSS gf180mcu_as_sc_mcu7t3v3__fill_1
XFILLER_151_839 VDD VDD VSS VSS gf180mcu_as_sc_mcu7t3v3__fill_1
XFILLER_172_1413 VDD VDD VSS VSS gf180mcu_as_sc_mcu7t3v3__fillcap_16
XTAP_TAPCELL_ROW_170_1996 VDD VSS gf180mcu_as_sc_mcu7t3v3__tap_2
XTAP_TAPCELL_ROW_102_3_2502 VDD VSS gf180mcu_as_sc_mcu7t3v3__tap_2
XFILLER_137_1544 VDD VDD VSS VSS gf180mcu_as_sc_mcu7t3v3__fill_1
XFILLER_170_1192 VDD VDD VSS VSS gf180mcu_as_sc_mcu7t3v3__fill_2
XFILLER_91_108 VDD VDD VSS VSS gf180mcu_as_sc_mcu7t3v3__fill_1
XFILLER_94_37 VDD VDD VSS VSS gf180mcu_as_sc_mcu7t3v3__fillcap_4
XTAP_TAPCELL_ROW_68_3_2452 VDD VSS gf180mcu_as_sc_mcu7t3v3__tap_2
XFILLER_150_65 VDD VDD VSS VSS gf180mcu_as_sc_mcu7t3v3__fillcap_16
XFILLER_168_2 VDD VDD VSS VSS gf180mcu_as_sc_mcu7t3v3__fillcap_16
XFILLER_84_193 VDD VDD VSS VSS gf180mcu_as_sc_mcu7t3v3__fillcap_4
XFILLER_96_1550 VDD VDD VSS VSS gf180mcu_as_sc_mcu7t3v3__fillcap_4
XPHY_EDGE_ROW_16_1_Right_15 VDD VSS gf180mcu_as_sc_mcu7t3v3__tap_2
XFILLER_183_1542 VDD VDD VSS VSS gf180mcu_as_sc_mcu7t3v3__fillcap_8
XFILLER_25_260 VDD VDD VSS VSS gf180mcu_as_sc_mcu7t3v3__fillcap_16
XFILLER_159_928 VDD VDD VSS VSS gf180mcu_as_sc_mcu7t3v3__fillcap_16
XFILLER_18_1518 VDD VDD VSS VSS gf180mcu_as_sc_mcu7t3v3__fillcap_16
XFILLER_25_282 VDD VDD VSS VSS gf180mcu_as_sc_mcu7t3v3__fillcap_16
XFILLER_158_427 VDD VDD VSS VSS gf180mcu_as_sc_mcu7t3v3__fill_1
XFILLER_40_241 VDD VDD VSS VSS gf180mcu_as_sc_mcu7t3v3__fillcap_4
XFILLER_43_52 VDD VDD VSS VSS gf180mcu_as_sc_mcu7t3v3__fillcap_4
XFILLER_40_263 VDD VDD VSS VSS gf180mcu_as_sc_mcu7t3v3__fillcap_16
XFILLER_182_942 VDD VDD VSS VSS gf180mcu_as_sc_mcu7t3v3__fill_2
XPHY_EDGE_ROW_49_1_Left_501 VDD VSS gf180mcu_as_sc_mcu7t3v3__tap_2
XFILLER_177_1379 VDD VDD VSS VSS gf180mcu_as_sc_mcu7t3v3__fill_1
XFILLER_99_219 VDD VDD VSS VSS gf180mcu_as_sc_mcu7t3v3__fill_2
XPHY_EDGE_ROW_101_1_Left_553 VDD VSS gf180mcu_as_sc_mcu7t3v3__tap_2
XFILLER_136_1098 VDD VDD VSS VSS gf180mcu_as_sc_mcu7t3v3__fillcap_8
XFILLER_67_138 VDD VDD VSS VSS gf180mcu_as_sc_mcu7t3v3__fill_2
Xinput260 VDD VDD VSS VSS sw_in[1] _2424_/A gf180mcu_as_sc_mcu7t3v3__buff_2
Xinput271 VDD VDD VSS VSS sw_in[2] _3302_/A gf180mcu_as_sc_mcu7t3v3__buff_2
XFILLER_63_300 VDD VDD VSS VSS gf180mcu_as_sc_mcu7t3v3__fill_1
XFILLER_75_160 VDD VDD VSS VSS gf180mcu_as_sc_mcu7t3v3__fill_2
Xinput282 VDD VDD VSS VSS sw_in[9] _4010_/A gf180mcu_as_sc_mcu7t3v3__buff_2
Xinput293 VDD VDD VSS VSS west_in[19] _4085_/D gf180mcu_as_sc_mcu7t3v3__buff_2
XTAP_TAPCELL_ROW_20_3_2380 VDD VSS gf180mcu_as_sc_mcu7t3v3__tap_2
X_4990_ VDD VDD VSS VSS _5080_/CLK _4990_/D _4990_/Q gf180mcu_as_sc_mcu7t3v3__dfxtp_2
XFILLER_16_271 VDD VDD VSS VSS gf180mcu_as_sc_mcu7t3v3__fillcap_4
X_3941_ VDD VDD VSS VSS _4159_/C _3941_/A _3942_/D gf180mcu_as_sc_mcu7t3v3__and2_2
X_3872_ VDD VDD VSS VSS _4952_/D _4948_/Q _5127_/Q _3872_/D _3873_/C gf180mcu_as_sc_mcu7t3v3__ao211_2
XFILLER_83_2 VDD VDD VSS VSS gf180mcu_as_sc_mcu7t3v3__fillcap_16
X_2823_ VDD VDD VSS VSS _5484_/A _2833_/A _2830_/B gf180mcu_as_sc_mcu7t3v3__and2_2
XFILLER_160_1383 VDD VDD VSS VSS gf180mcu_as_sc_mcu7t3v3__fillcap_8
XFILLER_176_279 VDD VDD VSS VSS gf180mcu_as_sc_mcu7t3v3__fillcap_16
X_2754_ VDD VDD VSS VSS _2754_/D _2833_/A _4751_/A _5478_/A _4627_/A gf180mcu_as_sc_mcu7t3v3__ao31_2
XTAP_TAPCELL_ROW_174_2085 VDD VSS gf180mcu_as_sc_mcu7t3v3__tap_2
XTAP_TAPCELL_ROW_174_2074 VDD VSS gf180mcu_as_sc_mcu7t3v3__tap_2
XFILLER_129_162 VDD VDD VSS VSS gf180mcu_as_sc_mcu7t3v3__fill_1
XFILLER_157_471 VDD VDD VSS VSS gf180mcu_as_sc_mcu7t3v3__fillcap_8
XPHY_EDGE_ROW_62_1_Right_61 VDD VSS gf180mcu_as_sc_mcu7t3v3__tap_2
XFILLER_145_666 VDD VDD VSS VSS gf180mcu_as_sc_mcu7t3v3__fillcap_16
XFILLER_160_603 VDD VDD VSS VSS gf180mcu_as_sc_mcu7t3v3__fillcap_4
XFILLER_184_290 VDD VDD VSS VSS gf180mcu_as_sc_mcu7t3v3__fillcap_16
X_2685_ VDD VDD VSS VSS _2686_/D _2730_/A _2729_/B _2685_/A gf180mcu_as_sc_mcu7t3v3__aoi21b_2
XPHY_EDGE_ROW_33_1_Left_485 VDD VSS gf180mcu_as_sc_mcu7t3v3__tap_2
X_4424_ VDD VDD VSS VSS _5169_/Q _4548_/B _4424_/C _4424_/D _5169_/D gf180mcu_as_sc_mcu7t3v3__ao211_2
XFILLER_154_1110 VDD VDD VSS VSS gf180mcu_as_sc_mcu7t3v3__fillcap_16
X_4355_ VDD VDD VSS VSS _4366_/S _5160_/Q _4355_/A _4356_/B gf180mcu_as_sc_mcu7t3v3__mux2_2
X_3306_ VDD VDD VSS VSS _3958_/A _3503_/B _3306_/C _3306_/D _3307_/C gf180mcu_as_sc_mcu7t3v3__ao211_2
XFILLER_140_371 VDD VDD VSS VSS gf180mcu_as_sc_mcu7t3v3__fillcap_8
XFILLER_141_894 VDD VDD VSS VSS gf180mcu_as_sc_mcu7t3v3__fill_1
X_4286_ VDD VDD VSS VSS _4289_/S _5482_/A _5120_/Q _5120_/D gf180mcu_as_sc_mcu7t3v3__mux2_2
XFILLER_104_14 VDD VDD VSS VSS gf180mcu_as_sc_mcu7t3v3__fill_1
Xmesh_tile_853 VDD VDD VSS VSS ne_out[28] gf180mcu_as_sc_mcu7t3v3__tiel_4
Xmesh_tile_842 VDD VDD VSS VSS ne_out[17] gf180mcu_as_sc_mcu7t3v3__tiel_4
Xmesh_tile_831 VDD VDD VSS VSS ne_out[6] gf180mcu_as_sc_mcu7t3v3__tiel_4
X_3237_ VDD VDD VSS VSS _3238_/B _3237_/C _3237_/B _3520_/A gf180mcu_as_sc_mcu7t3v3__aoi21b_2
XFILLER_167_1504 VDD VDD VSS VSS gf180mcu_as_sc_mcu7t3v3__fillcap_16
XFILLER_54_300 VDD VDD VSS VSS gf180mcu_as_sc_mcu7t3v3__fill_1
XFILLER_73_119 VDD VDD VSS VSS gf180mcu_as_sc_mcu7t3v3__fill_1
Xmesh_tile_886 VDD VDD VSS VSS north_out[27] gf180mcu_as_sc_mcu7t3v3__tiel_4
Xmesh_tile_875 VDD VDD VSS VSS north_out[16] gf180mcu_as_sc_mcu7t3v3__tiel_4
Xmesh_tile_864 VDD VDD VSS VSS north_out[5] gf180mcu_as_sc_mcu7t3v3__tiel_4
X_3168_ VDD VDD VSS VSS _3168_/B _4941_/Q _3171_/C gf180mcu_as_sc_mcu7t3v3__or2_2
XTAP_TAPCELL_ROW_146_1464 VDD VSS gf180mcu_as_sc_mcu7t3v3__tap_2
XFILLER_66_193 VDD VDD VSS VSS gf180mcu_as_sc_mcu7t3v3__fillcap_4
Xmesh_tile_897 VDD VDD VSS VSS nw_out[4] gf180mcu_as_sc_mcu7t3v3__tiel_4
XTAP_TAPCELL_ROW_146_1475 VDD VSS gf180mcu_as_sc_mcu7t3v3__tap_2
XFILLER_81_152 VDD VDD VSS VSS gf180mcu_as_sc_mcu7t3v3__fillcap_16
X_3099_ VDD VDD VSS VSS _3106_/B _3241_/B _4081_/A gf180mcu_as_sc_mcu7t3v3__nand2_2
XFILLER_81_196 VDD VDD VSS VSS gf180mcu_as_sc_mcu7t3v3__fillcap_4
XFILLER_22_241 VDD VDD VSS VSS gf180mcu_as_sc_mcu7t3v3__fillcap_4
XFILLER_22_263 VDD VDD VSS VSS gf180mcu_as_sc_mcu7t3v3__fillcap_16
XFILLER_13_66 VDD VDD VSS VSS gf180mcu_as_sc_mcu7t3v3__fillcap_4
XFILLER_167_279 VDD VDD VSS VSS gf180mcu_as_sc_mcu7t3v3__fill_1
XFILLER_13_88 VDD VDD VSS VSS gf180mcu_as_sc_mcu7t3v3__fillcap_16
XFILLER_52_1486 VDD VDD VSS VSS gf180mcu_as_sc_mcu7t3v3__fillcap_16
XFILLER_129_88 VDD VDD VSS VSS gf180mcu_as_sc_mcu7t3v3__fillcap_4
XFILLER_135_176 VDD VDD VSS VSS gf180mcu_as_sc_mcu7t3v3__fill_1
XFILLER_163_474 VDD VDD VSS VSS gf180mcu_as_sc_mcu7t3v3__fillcap_16
XFILLER_159_1098 VDD VDD VSS VSS gf180mcu_as_sc_mcu7t3v3__fillcap_8
XFILLER_1_134 VDD VDD VSS VSS gf180mcu_as_sc_mcu7t3v3__fillcap_4
XFILLER_145_65 VDD VDD VSS VSS gf180mcu_as_sc_mcu7t3v3__fillcap_4
XFILLER_150_168 VDD VDD VSS VSS gf180mcu_as_sc_mcu7t3v3__fillcap_4
XFILLER_172_1243 VDD VDD VSS VSS gf180mcu_as_sc_mcu7t3v3__fillcap_4
XFILLER_137_1396 VDD VDD VSS VSS gf180mcu_as_sc_mcu7t3v3__fillcap_4
XFILLER_49_138 VDD VDD VSS VSS gf180mcu_as_sc_mcu7t3v3__fill_2
XFILLER_38_85 VDD VDD VSS VSS gf180mcu_as_sc_mcu7t3v3__fillcap_16
XFILLER_45_300 VDD VDD VSS VSS gf180mcu_as_sc_mcu7t3v3__fill_1
XFILLER_166_1014 VDD VDD VSS VSS gf180mcu_as_sc_mcu7t3v3__fill_1
XFILLER_72_174 VDD VDD VSS VSS gf180mcu_as_sc_mcu7t3v3__fill_1
XFILLER_144_1345 VDD VDD VSS VSS gf180mcu_as_sc_mcu7t3v3__fillcap_16
XFILLER_144_1367 VDD VDD VSS VSS gf180mcu_as_sc_mcu7t3v3__fillcap_8
XFILLER_147_909 VDD VDD VSS VSS gf180mcu_as_sc_mcu7t3v3__fill_1
XFILLER_9_212 VDD VDD VSS VSS gf180mcu_as_sc_mcu7t3v3__fillcap_16
XFILLER_31_1515 VDD VDD VSS VSS gf180mcu_as_sc_mcu7t3v3__fillcap_4
XFILLER_70_1564 VDD VDD VSS VSS gf180mcu_as_sc_mcu7t3v3__fillcap_4
XFILLER_31_1537 VDD VDD VSS VSS gf180mcu_as_sc_mcu7t3v3__fillcap_16
Xclkload15 VDD VDD VSS VSS clkload15/Y _4943_/CLK gf180mcu_as_sc_mcu7t3v3__inv_6
Xclkload26 VDD VDD VSS VSS clkload26/Y _5188_/CLK gf180mcu_as_sc_mcu7t3v3__inv_6
XFILLER_142_625 VDD VDD VSS VSS gf180mcu_as_sc_mcu7t3v3__fill_2
XFILLER_181_260 VDD VDD VSS VSS gf180mcu_as_sc_mcu7t3v3__fillcap_16
X_2470_ VDD VDD VSS VSS _4341_/S _5092_/Q _5005_/Q _2471_/A gf180mcu_as_sc_mcu7t3v3__mux2_2
XFILLER_177_1187 VDD VDD VSS VSS gf180mcu_as_sc_mcu7t3v3__fill_2
XFILLER_181_282 VDD VDD VSS VSS gf180mcu_as_sc_mcu7t3v3__fillcap_16
X_4140_ VDD VDD VSS VSS _4141_/C _4140_/B _4140_/A gf180mcu_as_sc_mcu7t3v3__nor2_2
XFILLER_151_1327 VDD VDD VSS VSS gf180mcu_as_sc_mcu7t3v3__fill_2
XFILLER_29_1499 VDD VDD VSS VSS gf180mcu_as_sc_mcu7t3v3__fillcap_16
XFILLER_95_255 VDD VDD VSS VSS gf180mcu_as_sc_mcu7t3v3__fillcap_8
X_4071_ VDD VDD VSS VSS _4071_/A _4102_/B _4102_/C _4932_/Q _4073_/C gf180mcu_as_sc_mcu7t3v3__ao22_2
XFILLER_55_119 VDD VDD VSS VSS gf180mcu_as_sc_mcu7t3v3__fillcap_16
X_3022_ VDD VDD VSS VSS _3149_/B _3022_/B _3022_/C _3023_/C gf180mcu_as_sc_mcu7t3v3__nor3_2
XFILLER_48_193 VDD VDD VSS VSS gf180mcu_as_sc_mcu7t3v3__fillcap_8
XFILLER_184_1158 VDD VDD VSS VSS gf180mcu_as_sc_mcu7t3v3__fillcap_4
XFILLER_63_196 VDD VDD VSS VSS gf180mcu_as_sc_mcu7t3v3__fill_2
X_4973_ VDD VDD VSS VSS _5146_/CLK _4973_/D _4973_/Q gf180mcu_as_sc_mcu7t3v3__dfxtp_2
XTAP_TAPCELL_ROW_141_1361 VDD VSS gf180mcu_as_sc_mcu7t3v3__tap_2
XTAP_TAPCELL_ROW_141_1350 VDD VSS gf180mcu_as_sc_mcu7t3v3__tap_2
XFILLER_127_1521 VDD VDD VSS VSS gf180mcu_as_sc_mcu7t3v3__fillcap_16
X_3924_ VDD VDD VSS VSS _3924_/A _3931_/A _3924_/C _3924_/Y gf180mcu_as_sc_mcu7t3v3__nor3_2
XTAP_TAPCELL_ROW_176_2136 VDD VSS gf180mcu_as_sc_mcu7t3v3__tap_2
XTAP_TAPCELL_ROW_176_2125 VDD VSS gf180mcu_as_sc_mcu7t3v3__tap_2
XFILLER_177_544 VDD VDD VSS VSS gf180mcu_as_sc_mcu7t3v3__fillcap_16
XFILLER_137_419 VDD VDD VSS VSS gf180mcu_as_sc_mcu7t3v3__fill_1
Xclkload9 VDD VDD VSS VSS clkload9/Y clkload9/A gf180mcu_as_sc_mcu7t3v3__inv_2
X_3855_ VDD VDD VSS VSS _5149_/Q _5150_/Q _3855_/C _3858_/C gf180mcu_as_sc_mcu7t3v3__nor3_2
XFILLER_146_942 VDD VDD VSS VSS gf180mcu_as_sc_mcu7t3v3__fill_2
X_3786_ VDD VDD VSS VSS _3811_/B _3786_/A _3796_/B gf180mcu_as_sc_mcu7t3v3__and2_2
X_2806_ VDD VDD VSS VSS _4259_/C _2806_/A _2806_/B _2806_/C _2806_/D gf180mcu_as_sc_mcu7t3v3__aoi22_2
X_2737_ VDD VDD VSS VSS _2737_/A _2737_/B _2737_/C _2737_/D _2737_/Y gf180mcu_as_sc_mcu7t3v3__ao22_2
XFILLER_173_772 VDD VDD VSS VSS gf180mcu_as_sc_mcu7t3v3__fillcap_16
X_2668_ VDD VDD VSS VSS _2668_/Y _2668_/C _2709_/A _2668_/A gf180mcu_as_sc_mcu7t3v3__aoi21b_2
XFILLER_156_1227 VDD VDD VSS VSS gf180mcu_as_sc_mcu7t3v3__fillcap_16
XFILLER_161_978 VDD VDD VSS VSS gf180mcu_as_sc_mcu7t3v3__fill_2
X_4407_ VDD VDD VSS VSS _5167_/Q _4592_/B _4407_/C _4407_/D _5167_/D gf180mcu_as_sc_mcu7t3v3__ao211_2
XFILLER_134_1514 VDD VDD VSS VSS gf180mcu_as_sc_mcu7t3v3__fillcap_16
X_2599_ VDD VDD VSS VSS _2831_/A _2601_/D _2599_/B _2599_/A gf180mcu_as_sc_mcu7t3v3__aoi21b_2
XTAP_TAPCELL_ROW_30_1_755 VDD VSS gf180mcu_as_sc_mcu7t3v3__tap_2
XFILLER_115_35 VDD VDD VSS VSS gf180mcu_as_sc_mcu7t3v3__fill_2
XFILLER_134_1536 VDD VDD VSS VSS gf180mcu_as_sc_mcu7t3v3__fill_2
XFILLER_141_680 VDD VDD VSS VSS gf180mcu_as_sc_mcu7t3v3__fill_1
X_4338_ VDD VDD VSS VSS _4338_/Y _4373_/D _4338_/A gf180mcu_as_sc_mcu7t3v3__nor2_2
XTAP_TAPCELL_ROW_148_1515 VDD VSS gf180mcu_as_sc_mcu7t3v3__tap_2
XTAP_TAPCELL_ROW_148_1504 VDD VSS gf180mcu_as_sc_mcu7t3v3__tap_2
XFILLER_86_244 VDD VDD VSS VSS gf180mcu_as_sc_mcu7t3v3__fill_1
XFILLER_86_255 VDD VDD VSS VSS gf180mcu_as_sc_mcu7t3v3__fillcap_4
X_4269_ VDD VDD VSS VSS _4269_/S _5481_/A _5103_/Q _5103_/D gf180mcu_as_sc_mcu7t3v3__mux2_2
XFILLER_27_300 VDD VDD VSS VSS gf180mcu_as_sc_mcu7t3v3__fill_1
XTAP_TAPCELL_ROW_165_1895 VDD VSS gf180mcu_as_sc_mcu7t3v3__tap_2
XTAP_TAPCELL_ROW_165_1884 VDD VSS gf180mcu_as_sc_mcu7t3v3__tap_2
XPHY_EDGE_ROW_88_3_Left_222 VDD VSS gf180mcu_as_sc_mcu7t3v3__tap_2
XFILLER_54_174 VDD VDD VSS VSS gf180mcu_as_sc_mcu7t3v3__fill_1
XFILLER_54_196 VDD VDD VSS VSS gf180mcu_as_sc_mcu7t3v3__fillcap_4
XFILLER_91_27 VDD VDD VSS VSS gf180mcu_as_sc_mcu7t3v3__fillcap_8
XFILLER_180_1523 VDD VDD VSS VSS gf180mcu_as_sc_mcu7t3v3__fillcap_16
XFILLER_93_1553 VDD VDD VSS VSS gf180mcu_as_sc_mcu7t3v3__fillcap_16
XPHY_EDGE_ROW_0_1_Right_133 VDD VSS gf180mcu_as_sc_mcu7t3v3__tap_2
XFILLER_168_544 VDD VDD VSS VSS gf180mcu_as_sc_mcu7t3v3__fillcap_8
XFILLER_183_525 VDD VDD VSS VSS gf180mcu_as_sc_mcu7t3v3__fillcap_8
XFILLER_108_143 VDD VDD VSS VSS gf180mcu_as_sc_mcu7t3v3__fill_2
XFILLER_10_299 VDD VDD VSS VSS gf180mcu_as_sc_mcu7t3v3__fill_2
XFILLER_152_901 VDD VDD VSS VSS gf180mcu_as_sc_mcu7t3v3__fill_1
XFILLER_178_1430 VDD VDD VSS VSS gf180mcu_as_sc_mcu7t3v3__fill_1
XFILLER_183_558 VDD VDD VSS VSS gf180mcu_as_sc_mcu7t3v3__fill_2
XFILLER_156_53 VDD VDD VSS VSS gf180mcu_as_sc_mcu7t3v3__fillcap_16
XFILLER_151_422 VDD VDD VSS VSS gf180mcu_as_sc_mcu7t3v3__fillcap_8
XFILLER_152_956 VDD VDD VSS VSS gf180mcu_as_sc_mcu7t3v3__fillcap_16
XFILLER_163_282 VDD VDD VSS VSS gf180mcu_as_sc_mcu7t3v3__fillcap_16
XFILLER_151_466 VDD VDD VSS VSS gf180mcu_as_sc_mcu7t3v3__fill_2
XTAP_TAPCELL_ROW_56_3_2434 VDD VSS gf180mcu_as_sc_mcu7t3v3__tap_2
XFILLER_137_1160 VDD VDD VSS VSS gf180mcu_as_sc_mcu7t3v3__fill_2
XFILLER_172_1084 VDD VDD VSS VSS gf180mcu_as_sc_mcu7t3v3__fill_1
XFILLER_77_266 VDD VDD VSS VSS gf180mcu_as_sc_mcu7t3v3__fill_1
Xfanout780 VDD VDD VSS VSS _4975_/D _4751_/A gf180mcu_as_sc_mcu7t3v3__buff_2
Xfanout791 VDD VDD VSS VSS _2832_/S _2709_/A gf180mcu_as_sc_mcu7t3v3__buff_2
XFILLER_92_247 VDD VDD VSS VSS gf180mcu_as_sc_mcu7t3v3__fillcap_8
XFILLER_65_94 VDD VDD VSS VSS gf180mcu_as_sc_mcu7t3v3__fillcap_16
XFILLER_98_1486 VDD VDD VSS VSS gf180mcu_as_sc_mcu7t3v3__fillcap_16
XFILLER_45_196 VDD VDD VSS VSS gf180mcu_as_sc_mcu7t3v3__fill_2
XFILLER_159_500 VDD VDD VSS VSS gf180mcu_as_sc_mcu7t3v3__fill_2
XFILLER_144_1142 VDD VDD VSS VSS gf180mcu_as_sc_mcu7t3v3__fill_1
XFILLER_60_177 VDD VDD VSS VSS gf180mcu_as_sc_mcu7t3v3__fillcap_16
XFILLER_140_1017 VDD VDD VSS VSS gf180mcu_as_sc_mcu7t3v3__fillcap_16
XFILLER_147_739 VDD VDD VSS VSS gf180mcu_as_sc_mcu7t3v3__fillcap_4
XFILLER_179_1216 VDD VDD VSS VSS gf180mcu_as_sc_mcu7t3v3__fill_1
X_3640_ VDD VDD VSS VSS _4015_/A _3741_/B _3740_/C _4014_/A _3641_/C gf180mcu_as_sc_mcu7t3v3__ao22_2
XTAP_TAPCELL_ROW_171_2022 VDD VSS gf180mcu_as_sc_mcu7t3v3__tap_2
XTAP_TAPCELL_ROW_171_2011 VDD VSS gf180mcu_as_sc_mcu7t3v3__tap_2
XFILLER_122_1451 VDD VDD VSS VSS gf180mcu_as_sc_mcu7t3v3__fillcap_16
XFILLER_155_750 VDD VDD VSS VSS gf180mcu_as_sc_mcu7t3v3__fillcap_8
XFILLER_162_709 VDD VDD VSS VSS gf180mcu_as_sc_mcu7t3v3__fill_1
XFILLER_179_1249 VDD VDD VSS VSS gf180mcu_as_sc_mcu7t3v3__fill_2
X_3571_ VDD VDD VSS VSS _3925_/D _3781_/S _3571_/C _3571_/D _3572_/D gf180mcu_as_sc_mcu7t3v3__ao211_2
XFILLER_143_912 VDD VDD VSS VSS gf180mcu_as_sc_mcu7t3v3__fillcap_16
XFILLER_155_772 VDD VDD VSS VSS gf180mcu_as_sc_mcu7t3v3__fillcap_16
X_2522_ VDD VDD VSS VSS _2765_/B _2545_/B _2522_/C _2545_/D gf180mcu_as_sc_mcu7t3v3__nor3_2
XFILLER_170_731 VDD VDD VSS VSS gf180mcu_as_sc_mcu7t3v3__fillcap_4
XTAP_TAPCELL_ROW_91_3_2486 VDD VSS gf180mcu_as_sc_mcu7t3v3__tap_2
X_5241_ VDD VDD VSS VSS clkload7/A _5241_/D _5241_/Q gf180mcu_as_sc_mcu7t3v3__dfxtp_2
X_2453_ VDD VDD VSS VSS _2456_/C _2453_/C _5062_/Q _4341_/S gf180mcu_as_sc_mcu7t3v3__aoi21b_2
XFILLER_151_1102 VDD VDD VSS VSS gf180mcu_as_sc_mcu7t3v3__fillcap_4
XFILLER_170_797 VDD VDD VSS VSS gf180mcu_as_sc_mcu7t3v3__fill_1
X_5172_ VDD VDD VSS VSS _5172_/CLK _5172_/D _5172_/Q gf180mcu_as_sc_mcu7t3v3__dfxtp_2
XFILLER_68_233 VDD VDD VSS VSS gf180mcu_as_sc_mcu7t3v3__fillcap_8
XFILLER_68_255 VDD VDD VSS VSS gf180mcu_as_sc_mcu7t3v3__fill_2
X_4123_ VDD VDD VSS VSS _4124_/C _4123_/B _4123_/A gf180mcu_as_sc_mcu7t3v3__nor2_2
XFILLER_151_1157 VDD VDD VSS VSS gf180mcu_as_sc_mcu7t3v3__fillcap_4
Xinput2 VDD VDD VSS VSS boot_addr[10] input2/Y gf180mcu_as_sc_mcu7t3v3__buff_2
X_4054_ VDD VDD VSS VSS _4054_/A _4120_/B _4120_/C _4930_/Q _4055_/D gf180mcu_as_sc_mcu7t3v3__ao22_2
X_3005_ VDD VDD VSS VSS _3149_/B _3005_/B _3005_/C _3006_/C gf180mcu_as_sc_mcu7t3v3__nor3_2
XTAP_TAPCELL_ROW_143_1412 VDD VSS gf180mcu_as_sc_mcu7t3v3__tap_2
XTAP_TAPCELL_ROW_143_1401 VDD VSS gf180mcu_as_sc_mcu7t3v3__tap_2
XFILLER_77_1515 VDD VDD VSS VSS gf180mcu_as_sc_mcu7t3v3__fillcap_4
XFILLER_77_1537 VDD VDD VSS VSS gf180mcu_as_sc_mcu7t3v3__fillcap_16
XFILLER_164_1507 VDD VDD VSS VSS gf180mcu_as_sc_mcu7t3v3__fillcap_16
XFILLER_101_37 VDD VDD VSS VSS gf180mcu_as_sc_mcu7t3v3__fill_1
XFILLER_51_144 VDD VDD VSS VSS gf180mcu_as_sc_mcu7t3v3__fill_1
XTAP_TAPCELL_ROW_160_1781 VDD VSS gf180mcu_as_sc_mcu7t3v3__tap_2
XTAP_TAPCELL_ROW_160_1770 VDD VSS gf180mcu_as_sc_mcu7t3v3__tap_2
XFILLER_101_59 VDD VDD VSS VSS gf180mcu_as_sc_mcu7t3v3__fill_1
XFILLER_177_330 VDD VDD VSS VSS gf180mcu_as_sc_mcu7t3v3__fillcap_16
XFILLER_178_842 VDD VDD VSS VSS gf180mcu_as_sc_mcu7t3v3__fill_2
XFILLER_51_188 VDD VDD VSS VSS gf180mcu_as_sc_mcu7t3v3__fillcap_8
X_4956_ VDD VDD VSS VSS clkload8/A _4956_/D _4956_/Q gf180mcu_as_sc_mcu7t3v3__dfxtp_2
XTAP_TAPCELL_ROW_128_1_1146 VDD VSS gf180mcu_as_sc_mcu7t3v3__tap_2
XFILLER_162_1253 VDD VDD VSS VSS gf180mcu_as_sc_mcu7t3v3__fillcap_16
XFILLER_177_352 VDD VDD VSS VSS gf180mcu_as_sc_mcu7t3v3__fillcap_16
X_4887_ VDD VDD VSS VSS _4914_/CLK _4887_/D _4887_/Q gf180mcu_as_sc_mcu7t3v3__dfxtp_2
X_3907_ VDD VDD VSS VSS _3907_/B _3907_/A _4948_/D gf180mcu_as_sc_mcu7t3v3__and2_2
XFILLER_162_1297 VDD VDD VSS VSS gf180mcu_as_sc_mcu7t3v3__fillcap_4
XFILLER_165_525 VDD VDD VSS VSS gf180mcu_as_sc_mcu7t3v3__fillcap_16
X_3838_ VDD VDD VSS VSS _3839_/B _4753_/A _3838_/B _4911_/Q gf180mcu_as_sc_mcu7t3v3__aoi21_2
XFILLER_137_249 VDD VDD VSS VSS gf180mcu_as_sc_mcu7t3v3__fill_2
Xclkbuf_leaf_16_clk_regs VDD VDD VSS VSS clkbuf_3_2_0_clk_regs/Y _4914_/CLK gf180mcu_as_sc_mcu7t3v3__clkbuff_12
X_3769_ VDD VDD VSS VSS _3778_/B _4151_/D _3771_/C gf180mcu_as_sc_mcu7t3v3__and2_2
XTAP_TAPCELL_ROW_108_1_1066 VDD VSS gf180mcu_as_sc_mcu7t3v3__tap_2
XFILLER_105_135 VDD VDD VSS VSS gf180mcu_as_sc_mcu7t3v3__fillcap_4
XFILLER_10_34 VDD VDD VSS VSS gf180mcu_as_sc_mcu7t3v3__fill_1
XFILLER_145_282 VDD VDD VSS VSS gf180mcu_as_sc_mcu7t3v3__fill_2
XFILLER_161_731 VDD VDD VSS VSS gf180mcu_as_sc_mcu7t3v3__fill_2
XFILLER_160_263 VDD VDD VSS VSS gf180mcu_as_sc_mcu7t3v3__fillcap_4
XPHY_EDGE_ROW_25_1_Right_24 VDD VSS gf180mcu_as_sc_mcu7t3v3__tap_2
Xoutput361 VDD VDD VSS VSS _4782_/Q se_out[11] gf180mcu_as_sc_mcu7t3v3__buff_2
Xoutput350 VDD VDD VSS VSS _4871_/Q east_out[32] gf180mcu_as_sc_mcu7t3v3__buff_2
XFILLER_138_1480 VDD VDD VSS VSS gf180mcu_as_sc_mcu7t3v3__fillcap_16
XFILLER_160_274 VDD VDD VSS VSS gf180mcu_as_sc_mcu7t3v3__fillcap_16
Xoutput394 VDD VDD VSS VSS _4815_/Q south_out[10] gf180mcu_as_sc_mcu7t3v3__buff_2
Xoutput383 VDD VDD VSS VSS _4802_/Q se_out[31] gf180mcu_as_sc_mcu7t3v3__buff_2
Xoutput372 VDD VDD VSS VSS _4792_/Q se_out[21] gf180mcu_as_sc_mcu7t3v3__buff_2
XFILLER_134_1344 VDD VDD VSS VSS gf180mcu_as_sc_mcu7t3v3__fillcap_16
XTAP_TAPCELL_ROW_167_1935 VDD VSS gf180mcu_as_sc_mcu7t3v3__tap_2
XTAP_TAPCELL_ROW_167_1924 VDD VSS gf180mcu_as_sc_mcu7t3v3__tap_2
XTAP_TAPCELL_ROW_12_1_684 VDD VSS gf180mcu_as_sc_mcu7t3v3__tap_2
XFILLER_59_277 VDD VDD VSS VSS gf180mcu_as_sc_mcu7t3v3__fill_2
XFILLER_74_203 VDD VDD VSS VSS gf180mcu_as_sc_mcu7t3v3__fill_1
XFILLER_169_1429 VDD VDD VSS VSS gf180mcu_as_sc_mcu7t3v3__fill_2
XFILLER_74_247 VDD VDD VSS VSS gf180mcu_as_sc_mcu7t3v3__fillcap_8
XFILLER_27_174 VDD VDD VSS VSS gf180mcu_as_sc_mcu7t3v3__fillcap_16
XFILLER_150_2 VDD VDD VSS VSS gf180mcu_as_sc_mcu7t3v3__fillcap_16
XFILLER_42_144 VDD VDD VSS VSS gf180mcu_as_sc_mcu7t3v3__fill_1
XPHY_EDGE_ROW_58_1_Left_510 VDD VSS gf180mcu_as_sc_mcu7t3v3__tap_2
XFILLER_163_1039 VDD VDD VSS VSS gf180mcu_as_sc_mcu7t3v3__fillcap_8
XFILLER_169_842 VDD VDD VSS VSS gf180mcu_as_sc_mcu7t3v3__fillcap_8
XFILLER_42_188 VDD VDD VSS VSS gf180mcu_as_sc_mcu7t3v3__fillcap_8
XFILLER_141_1315 VDD VDD VSS VSS gf180mcu_as_sc_mcu7t3v3__fillcap_8
XFILLER_180_1364 VDD VDD VSS VSS gf180mcu_as_sc_mcu7t3v3__fill_1
XFILLER_180_1375 VDD VDD VSS VSS gf180mcu_as_sc_mcu7t3v3__fill_2
XPHY_EDGE_ROW_110_1_Left_562 VDD VSS gf180mcu_as_sc_mcu7t3v3__tap_2
XTAP_TAPCELL_ROW_108_3_2511 VDD VSS gf180mcu_as_sc_mcu7t3v3__tap_2
XFILLER_184_856 VDD VDD VSS VSS gf180mcu_as_sc_mcu7t3v3__fill_1
Xwire466 VDD VDD VSS VSS _2604_/Y wire466/Y gf180mcu_as_sc_mcu7t3v3__buff_8
XFILLER_137_772 VDD VDD VSS VSS gf180mcu_as_sc_mcu7t3v3__fillcap_16
XFILLER_171_517 VDD VDD VSS VSS gf180mcu_as_sc_mcu7t3v3__fill_2
XFILLER_171_539 VDD VDD VSS VSS gf180mcu_as_sc_mcu7t3v3__fillcap_4
Xwire477 VDD VDD VSS VSS _2737_/Y wire477/Y gf180mcu_as_sc_mcu7t3v3__buff_8
XFILLER_152_731 VDD VDD VSS VSS gf180mcu_as_sc_mcu7t3v3__fillcap_4
XFILLER_174_1157 VDD VDD VSS VSS gf180mcu_as_sc_mcu7t3v3__fillcap_4
XFILLER_2_251 VDD VDD VSS VSS gf180mcu_as_sc_mcu7t3v3__fill_1
XFILLER_111_138 VDD VDD VSS VSS gf180mcu_as_sc_mcu7t3v3__fill_2
XFILLER_117_1553 VDD VDD VSS VSS gf180mcu_as_sc_mcu7t3v3__fillcap_4
XFILLER_2_295 VDD VDD VSS VSS gf180mcu_as_sc_mcu7t3v3__fillcap_4
XFILLER_65_214 VDD VDD VSS VSS gf180mcu_as_sc_mcu7t3v3__fill_1
XPHY_EDGE_ROW_0_3_Left_134 VDD VSS gf180mcu_as_sc_mcu7t3v3__tap_2
XFILLER_65_236 VDD VDD VSS VSS gf180mcu_as_sc_mcu7t3v3__fillcap_16
XFILLER_150_1190 VDD VDD VSS VSS gf180mcu_as_sc_mcu7t3v3__fill_1
XPHY_EDGE_ROW_71_1_Right_70 VDD VSS gf180mcu_as_sc_mcu7t3v3__tap_2
XFILLER_179_628 VDD VDD VSS VSS gf180mcu_as_sc_mcu7t3v3__fill_2
XFILLER_181_1106 VDD VDD VSS VSS gf180mcu_as_sc_mcu7t3v3__fillcap_4
XPHY_EDGE_ROW_42_1_Left_494 VDD VSS gf180mcu_as_sc_mcu7t3v3__tap_2
X_4810_ VDD VDD VSS VSS _4928_/CLK _4810_/D _4810_/Q gf180mcu_as_sc_mcu7t3v3__dfxtp_2
XTAP_TAPCELL_ROW_21_1_719 VDD VSS gf180mcu_as_sc_mcu7t3v3__tap_2
XFILLER_124_1502 VDD VDD VSS VSS gf180mcu_as_sc_mcu7t3v3__fillcap_16
XFILLER_37_1521 VDD VDD VSS VSS gf180mcu_as_sc_mcu7t3v3__fillcap_16
XFILLER_159_352 VDD VDD VSS VSS gf180mcu_as_sc_mcu7t3v3__fillcap_16
XFILLER_72_1467 VDD VDD VSS VSS gf180mcu_as_sc_mcu7t3v3__fillcap_16
X_4741_ VDD VDD VSS VSS _4742_/B _4741_/C _4741_/B _5275_/Q gf180mcu_as_sc_mcu7t3v3__aoi21_2
XFILLER_159_374 VDD VDD VSS VSS gf180mcu_as_sc_mcu7t3v3__fill_1
XFILLER_174_311 VDD VDD VSS VSS gf180mcu_as_sc_mcu7t3v3__fillcap_4
XFILLER_179_1002 VDD VDD VSS VSS gf180mcu_as_sc_mcu7t3v3__fill_1
X_4672_ VDD VDD VSS VSS _5243_/D _5243_/Q _4685_/C _4672_/C gf180mcu_as_sc_mcu7t3v3__ao21_2
XFILLER_119_249 VDD VDD VSS VSS gf180mcu_as_sc_mcu7t3v3__fill_2
XFILLER_174_333 VDD VDD VSS VSS gf180mcu_as_sc_mcu7t3v3__fillcap_16
X_3623_ VDD VDD VSS VSS _3794_/S _3623_/B _3994_/A _3624_/B gf180mcu_as_sc_mcu7t3v3__mux2_2
XFILLER_143_720 VDD VDD VSS VSS gf180mcu_as_sc_mcu7t3v3__fillcap_16
X_3554_ VDD VDD VSS VSS _3561_/B _3801_/C _3554_/A gf180mcu_as_sc_mcu7t3v3__nand2_2
XFILLER_157_1366 VDD VDD VSS VSS gf180mcu_as_sc_mcu7t3v3__fillcap_16
X_3485_ VDD VDD VSS VSS _3501_/C _4145_/A _3487_/C gf180mcu_as_sc_mcu7t3v3__and2_2
X_2505_ VDD VDD VSS VSS _5269_/Q _5275_/Q _4736_/B gf180mcu_as_sc_mcu7t3v3__and2_2
X_5224_ VDD VDD VSS VSS clkload9/A _5224_/D _5224_/Q gf180mcu_as_sc_mcu7t3v3__dfxtp_2
X_2436_ VDD VDD VSS VSS _3676_/A _4050_/A gf180mcu_as_sc_mcu7t3v3__inv_2
XTAP_TAPCELL_ROW_38_3_2406 VDD VSS gf180mcu_as_sc_mcu7t3v3__tap_2
XFILLER_170_1555 VDD VDD VSS VSS gf180mcu_as_sc_mcu7t3v3__fillcap_4
X_5155_ VDD VDD VSS VSS clkload8/A _5155_/D _5155_/Q gf180mcu_as_sc_mcu7t3v3__dfxtp_2
XFILLER_110_193 VDD VDD VSS VSS gf180mcu_as_sc_mcu7t3v3__fillcap_4
XFILLER_56_247 VDD VDD VSS VSS gf180mcu_as_sc_mcu7t3v3__fillcap_8
X_5086_ VDD VDD VSS VSS _5188_/CLK _5086_/D _5086_/Q gf180mcu_as_sc_mcu7t3v3__dfxtp_2
X_4106_ VDD VDD VSS VSS _4106_/S _4106_/B _4106_/A _4107_/B gf180mcu_as_sc_mcu7t3v3__mux2_2
XTAP_TAPCELL_ROW_162_1810 VDD VSS gf180mcu_as_sc_mcu7t3v3__tap_2
XTAP_TAPCELL_ROW_114_3_2521 VDD VSS gf180mcu_as_sc_mcu7t3v3__tap_2
X_4037_ VDD VDD VSS VSS _4037_/A _4118_/B _4118_/C _4037_/D _4038_/D gf180mcu_as_sc_mcu7t3v3__ao22_2
XTAP_TAPCELL_ROW_162_1821 VDD VSS gf180mcu_as_sc_mcu7t3v3__tap_2
XFILLER_71_228 VDD VDD VSS VSS gf180mcu_as_sc_mcu7t3v3__fillcap_16
XFILLER_168_1495 VDD VDD VSS VSS gf180mcu_as_sc_mcu7t3v3__fillcap_8
XFILLER_24_155 VDD VDD VSS VSS gf180mcu_as_sc_mcu7t3v3__fillcap_16
XFILLER_24_177 VDD VDD VSS VSS gf180mcu_as_sc_mcu7t3v3__fillcap_16
XFILLER_184_108 VDD VDD VSS VSS gf180mcu_as_sc_mcu7t3v3__fill_1
XFILLER_90_1534 VDD VDD VSS VSS gf180mcu_as_sc_mcu7t3v3__fillcap_16
XFILLER_90_1556 VDD VDD VSS VSS gf180mcu_as_sc_mcu7t3v3__fillcap_8
X_4939_ VDD VDD VSS VSS _5053_/CLK _4939_/D _4939_/Q gf180mcu_as_sc_mcu7t3v3__dfxtp_2
XFILLER_162_1083 VDD VDD VSS VSS gf180mcu_as_sc_mcu7t3v3__fill_2
XTAP_TAPCELL_ROW_5_1_656 VDD VSS gf180mcu_as_sc_mcu7t3v3__tap_2
XFILLER_158_1108 VDD VDD VSS VSS gf180mcu_as_sc_mcu7t3v3__fill_1
XFILLER_21_66 VDD VDD VSS VSS gf180mcu_as_sc_mcu7t3v3__fillcap_4
XFILLER_21_88 VDD VDD VSS VSS gf180mcu_as_sc_mcu7t3v3__fillcap_16
XFILLER_133_230 VDD VDD VSS VSS gf180mcu_as_sc_mcu7t3v3__fillcap_4
XFILLER_133_241 VDD VDD VSS VSS gf180mcu_as_sc_mcu7t3v3__fillcap_8
XFILLER_137_66 VDD VDD VSS VSS gf180mcu_as_sc_mcu7t3v3__fillcap_4
XFILLER_137_88 VDD VDD VSS VSS gf180mcu_as_sc_mcu7t3v3__fillcap_16
XFILLER_175_1433 VDD VDD VSS VSS gf180mcu_as_sc_mcu7t3v3__fill_2
XFILLER_175_1455 VDD VDD VSS VSS gf180mcu_as_sc_mcu7t3v3__fill_1
XFILLER_175_1466 VDD VDD VSS VSS gf180mcu_as_sc_mcu7t3v3__fillcap_4
XFILLER_97_37 VDD VDD VSS VSS gf180mcu_as_sc_mcu7t3v3__fill_1
XFILLER_133_263 VDD VDD VSS VSS gf180mcu_as_sc_mcu7t3v3__fillcap_16
XFILLER_136_1428 VDD VDD VSS VSS gf180mcu_as_sc_mcu7t3v3__fillcap_4
XFILLER_134_1152 VDD VDD VSS VSS gf180mcu_as_sc_mcu7t3v3__fillcap_4
XFILLER_46_52 VDD VDD VSS VSS gf180mcu_as_sc_mcu7t3v3__fill_1
XFILLER_112_1483 VDD VDD VSS VSS gf180mcu_as_sc_mcu7t3v3__fill_1
XFILLER_169_1259 VDD VDD VSS VSS gf180mcu_as_sc_mcu7t3v3__fill_1
XTAP_TAPCELL_ROW_61_1_879 VDD VSS gf180mcu_as_sc_mcu7t3v3__tap_2
XFILLER_95_1467 VDD VDD VSS VSS gf180mcu_as_sc_mcu7t3v3__fillcap_16
XFILLER_102_80 VDD VDD VSS VSS gf180mcu_as_sc_mcu7t3v3__fillcap_8
XFILLER_168_171 VDD VDD VSS VSS gf180mcu_as_sc_mcu7t3v3__fillcap_4
XFILLER_180_1161 VDD VDD VSS VSS gf180mcu_as_sc_mcu7t3v3__fill_2
XFILLER_168_193 VDD VDD VSS VSS gf180mcu_as_sc_mcu7t3v3__fillcap_16
XPHY_EDGE_ROW_103_3_Left_237 VDD VSS gf180mcu_as_sc_mcu7t3v3__tap_2
XTAP_TAPCELL_ROW_44_3_2416 VDD VSS gf180mcu_as_sc_mcu7t3v3__tap_2
XFILLER_171_314 VDD VDD VSS VSS gf180mcu_as_sc_mcu7t3v3__fillcap_16
XFILLER_32_1451 VDD VDD VSS VSS gf180mcu_as_sc_mcu7t3v3__fillcap_16
XFILLER_109_282 VDD VDD VSS VSS gf180mcu_as_sc_mcu7t3v3__fillcap_16
XFILLER_139_1052 VDD VDD VSS VSS gf180mcu_as_sc_mcu7t3v3__fillcap_4
XFILLER_152_561 VDD VDD VSS VSS gf180mcu_as_sc_mcu7t3v3__fillcap_16
XFILLER_140_723 VDD VDD VSS VSS gf180mcu_as_sc_mcu7t3v3__fillcap_8
XFILLER_152_594 VDD VDD VSS VSS gf180mcu_as_sc_mcu7t3v3__fill_1
XFILLER_180_892 VDD VDD VSS VSS gf180mcu_as_sc_mcu7t3v3__fill_2
X_3270_ VDD VDD VSS VSS _3270_/Y _3271_/B _3271_/A gf180mcu_as_sc_mcu7t3v3__nor2_2
XFILLER_140_745 VDD VDD VSS VSS gf180mcu_as_sc_mcu7t3v3__fill_2
XFILLER_97_158 VDD VDD VSS VSS gf180mcu_as_sc_mcu7t3v3__fillcap_8
XFILLER_87_92 VDD VDD VSS VSS gf180mcu_as_sc_mcu7t3v3__fill_1
XFILLER_38_225 VDD VDD VSS VSS gf180mcu_as_sc_mcu7t3v3__fillcap_16
XFILLER_38_247 VDD VDD VSS VSS gf180mcu_as_sc_mcu7t3v3__fillcap_16
XTAP_TAPCELL_ROW_183_2290 VDD VSS gf180mcu_as_sc_mcu7t3v3__tap_2
XTAP_TAPCELL_ROW_0_3_2350 VDD VSS gf180mcu_as_sc_mcu7t3v3__tap_2
XFILLER_74_1518 VDD VDD VSS VSS gf180mcu_as_sc_mcu7t3v3__fillcap_16
XFILLER_146_1045 VDD VDD VSS VSS gf180mcu_as_sc_mcu7t3v3__fillcap_8
XFILLER_21_136 VDD VDD VSS VSS gf180mcu_as_sc_mcu7t3v3__fillcap_4
XFILLER_148_823 VDD VDD VSS VSS gf180mcu_as_sc_mcu7t3v3__fillcap_16
XFILLER_21_158 VDD VDD VSS VSS gf180mcu_as_sc_mcu7t3v3__fillcap_16
XPHY_EDGE_ROW_35_3_Left_169 VDD VSS gf180mcu_as_sc_mcu7t3v3__tap_2
X_4724_ VDD VDD VSS VSS _5264_/Q _4730_/B _4730_/C _5263_/Q _4725_/C gf180mcu_as_sc_mcu7t3v3__ao22_2
X_2985_ VDD VDD VSS VSS _3967_/A _3152_/B _3152_/C _3968_/D _2986_/C gf180mcu_as_sc_mcu7t3v3__ao22_2
XTAP_TAPCELL_ROW_138_1300 VDD VSS gf180mcu_as_sc_mcu7t3v3__tap_2
XFILLER_147_333 VDD VDD VSS VSS gf180mcu_as_sc_mcu7t3v3__fillcap_16
XFILLER_107_208 VDD VDD VSS VSS gf180mcu_as_sc_mcu7t3v3__fill_2
XFILLER_135_517 VDD VDD VSS VSS gf180mcu_as_sc_mcu7t3v3__fillcap_4
XFILLER_162_303 VDD VDD VSS VSS gf180mcu_as_sc_mcu7t3v3__fillcap_4
XFILLER_163_815 VDD VDD VSS VSS gf180mcu_as_sc_mcu7t3v3__fillcap_4
X_4655_ VDD VDD VSS VSS _4656_/B _5239_/Q _4655_/B _4746_/D gf180mcu_as_sc_mcu7t3v3__ao21_2
XTAP_TAPCELL_ROW_134_1208 VDD VSS gf180mcu_as_sc_mcu7t3v3__tap_2
Xinput82 VDD VDD VSS VSS ne_in[13] _4037_/A gf180mcu_as_sc_mcu7t3v3__buff_2
Xinput71 VDD VDD VSS VSS east_in[3] _3960_/A gf180mcu_as_sc_mcu7t3v3__buff_2
Xinput60 VDD VDD VSS VSS east_in[24] _4130_/A gf180mcu_as_sc_mcu7t3v3__buff_2
X_4586_ VDD VDD VSS VSS _4586_/S _5030_/Q _5059_/Q _4587_/B gf180mcu_as_sc_mcu7t3v3__mux2_2
X_3606_ VDD VDD VSS VSS _3973_/A _3717_/B _3606_/C _3606_/D _3607_/D gf180mcu_as_sc_mcu7t3v3__ao211_2
XTAP_TAPCELL_ROW_1_1_640 VDD VSS gf180mcu_as_sc_mcu7t3v3__tap_2
XFILLER_115_241 VDD VDD VSS VSS gf180mcu_as_sc_mcu7t3v3__fillcap_8
XFILLER_162_369 VDD VDD VSS VSS gf180mcu_as_sc_mcu7t3v3__fillcap_16
Xinput93 VDD VDD VSS VSS ne_in[23] _4118_/A gf180mcu_as_sc_mcu7t3v3__buff_2
X_3537_ VDD VDD VSS VSS _3932_/B _3537_/A _3777_/B gf180mcu_as_sc_mcu7t3v3__and2_2
XFILLER_157_1152 VDD VDD VSS VSS gf180mcu_as_sc_mcu7t3v3__fillcap_8
XFILLER_157_1174 VDD VDD VSS VSS gf180mcu_as_sc_mcu7t3v3__fillcap_4
XFILLER_157_1185 VDD VDD VSS VSS gf180mcu_as_sc_mcu7t3v3__fillcap_4
XTAP_TAPCELL_ROW_151_1588 VDD VSS gf180mcu_as_sc_mcu7t3v3__tap_2
XTAP_TAPCELL_ROW_151_1577 VDD VSS gf180mcu_as_sc_mcu7t3v3__tap_2
XPHY_EDGE_ROW_97_3_Left_231 VDD VSS gf180mcu_as_sc_mcu7t3v3__tap_2
X_3468_ VDD VDD VSS VSS _4118_/D _3468_/B _3468_/C _3468_/D _3469_/C gf180mcu_as_sc_mcu7t3v3__ao211_2
XFILLER_135_1450 VDD VDD VSS VSS gf180mcu_as_sc_mcu7t3v3__fillcap_16
XFILLER_135_1472 VDD VDD VSS VSS gf180mcu_as_sc_mcu7t3v3__fillcap_16
X_5207_ VDD VDD VSS VSS clkload0/A _5207_/D _5207_/Q gf180mcu_as_sc_mcu7t3v3__dfxtp_2
X_3399_ VDD VDD VSS VSS _3505_/S _3399_/B _4050_/A _3400_/B gf180mcu_as_sc_mcu7t3v3__mux2_2
X_2419_ VDD VDD VSS VSS _3240_/A _3522_/A gf180mcu_as_sc_mcu7t3v3__inv_2
X_5138_ VDD VDD VSS VSS clkload9/A _5138_/D _5138_/Q gf180mcu_as_sc_mcu7t3v3__dfxtp_2
XFILLER_184_8 VDD VDD VSS VSS gf180mcu_as_sc_mcu7t3v3__fillcap_16
X_5069_ VDD VDD VSS VSS _5173_/CLK _5069_/D _5069_/Q gf180mcu_as_sc_mcu7t3v3__dfxtp_2
XFILLER_168_1281 VDD VDD VSS VSS gf180mcu_as_sc_mcu7t3v3__fillcap_8
XFILLER_55_1451 VDD VDD VSS VSS gf180mcu_as_sc_mcu7t3v3__fillcap_16
Xclkbuf_leaf_31_clk_regs VDD VDD VSS VSS clkbuf_3_4_0_clk_regs/Y _5052_/CLK gf180mcu_as_sc_mcu7t3v3__clkbuff_12
Xsram2048.u_bank1_824 VDD VDD VSS VSS sram2048.u_bank1/WEN[6] gf180mcu_as_sc_mcu7t3v3__tiel_4
XFILLER_142_1432 VDD VDD VSS VSS gf180mcu_as_sc_mcu7t3v3__fill_2
XFILLER_8_107 VDD VDD VSS VSS gf180mcu_as_sc_mcu7t3v3__fillcap_16
XFILLER_138_333 VDD VDD VSS VSS gf180mcu_as_sc_mcu7t3v3__fillcap_16
XFILLER_148_10 VDD VDD VSS VSS gf180mcu_as_sc_mcu7t3v3__fill_2
XFILLER_139_889 VDD VDD VSS VSS gf180mcu_as_sc_mcu7t3v3__fillcap_4
XFILLER_154_815 VDD VDD VSS VSS gf180mcu_as_sc_mcu7t3v3__fill_2
XFILLER_166_675 VDD VDD VSS VSS gf180mcu_as_sc_mcu7t3v3__fillcap_4
XFILLER_113_2 VDD VDD VSS VSS gf180mcu_as_sc_mcu7t3v3__fillcap_8
XFILLER_165_174 VDD VDD VSS VSS gf180mcu_as_sc_mcu7t3v3__fillcap_16
XFILLER_166_697 VDD VDD VSS VSS gf180mcu_as_sc_mcu7t3v3__fill_1
XFILLER_177_1539 VDD VDD VSS VSS gf180mcu_as_sc_mcu7t3v3__fill_1
XFILLER_106_241 VDD VDD VSS VSS gf180mcu_as_sc_mcu7t3v3__fillcap_4
XFILLER_181_678 VDD VDD VSS VSS gf180mcu_as_sc_mcu7t3v3__fill_2
XFILLER_106_263 VDD VDD VSS VSS gf180mcu_as_sc_mcu7t3v3__fill_2
XFILLER_162_892 VDD VDD VSS VSS gf180mcu_as_sc_mcu7t3v3__fillcap_4
XFILLER_180_177 VDD VDD VSS VSS gf180mcu_as_sc_mcu7t3v3__fillcap_16
XFILLER_121_244 VDD VDD VSS VSS gf180mcu_as_sc_mcu7t3v3__fillcap_16
XFILLER_164_53 VDD VDD VSS VSS gf180mcu_as_sc_mcu7t3v3__fillcap_16
XFILLER_171_1149 VDD VDD VSS VSS gf180mcu_as_sc_mcu7t3v3__fillcap_8
XFILLER_27_1553 VDD VDD VSS VSS gf180mcu_as_sc_mcu7t3v3__fillcap_16
XFILLER_114_1534 VDD VDD VSS VSS gf180mcu_as_sc_mcu7t3v3__fillcap_16
XFILLER_114_1556 VDD VDD VSS VSS gf180mcu_as_sc_mcu7t3v3__fillcap_4
XFILLER_169_1001 VDD VDD VSS VSS gf180mcu_as_sc_mcu7t3v3__fill_1
XFILLER_169_1045 VDD VDD VSS VSS gf180mcu_as_sc_mcu7t3v3__fillcap_4
XFILLER_180_85 VDD VDD VSS VSS gf180mcu_as_sc_mcu7t3v3__fillcap_16
XFILLER_35_206 VDD VDD VSS VSS gf180mcu_as_sc_mcu7t3v3__fillcap_4
XFILLER_35_228 VDD VDD VSS VSS gf180mcu_as_sc_mcu7t3v3__fillcap_16
XFILLER_169_1067 VDD VDD VSS VSS gf180mcu_as_sc_mcu7t3v3__fillcap_4
XFILLER_147_1332 VDD VDD VSS VSS gf180mcu_as_sc_mcu7t3v3__fillcap_4
XFILLER_147_1343 VDD VDD VSS VSS gf180mcu_as_sc_mcu7t3v3__fillcap_8
XFILLER_182_1223 VDD VDD VSS VSS gf180mcu_as_sc_mcu7t3v3__fill_2
XFILLER_73_72 VDD VDD VSS VSS gf180mcu_as_sc_mcu7t3v3__fillcap_16
XFILLER_177_907 VDD VDD VSS VSS gf180mcu_as_sc_mcu7t3v3__fill_2
XFILLER_177_918 VDD VDD VSS VSS gf180mcu_as_sc_mcu7t3v3__fill_2
XFILLER_182_1267 VDD VDD VSS VSS gf180mcu_as_sc_mcu7t3v3__fill_2
XTAP_TAPCELL_ROW_129_1_1151 VDD VSS gf180mcu_as_sc_mcu7t3v3__tap_2
XFILLER_34_1502 VDD VDD VSS VSS gf180mcu_as_sc_mcu7t3v3__fillcap_16
XFILLER_34_1568 VDD VDD VSS VSS gf180mcu_as_sc_mcu7t3v3__fill_1
X_2770_ VDD VDD VSS VSS _2840_/A _2840_/B _2770_/C _2771_/C _2770_/D gf180mcu_as_sc_mcu7t3v3__oai211_2
XFILLER_144_303 VDD VDD VSS VSS gf180mcu_as_sc_mcu7t3v3__fill_2
XFILLER_145_837 VDD VDD VSS VSS gf180mcu_as_sc_mcu7t3v3__fill_2
XFILLER_157_697 VDD VDD VSS VSS gf180mcu_as_sc_mcu7t3v3__fill_2
XFILLER_184_494 VDD VDD VSS VSS gf180mcu_as_sc_mcu7t3v3__fillcap_16
X_4440_ VDD VDD VSS VSS _4440_/D _4520_/A _4440_/B _4440_/C _4441_/B gf180mcu_as_sc_mcu7t3v3__ao31_2
XTAP_TAPCELL_ROW_109_1_1071 VDD VSS gf180mcu_as_sc_mcu7t3v3__tap_2
XFILLER_144_358 VDD VDD VSS VSS gf180mcu_as_sc_mcu7t3v3__fill_1
XFILLER_158_1450 VDD VDD VSS VSS gf180mcu_as_sc_mcu7t3v3__fillcap_4
XFILLER_160_807 VDD VDD VSS VSS gf180mcu_as_sc_mcu7t3v3__fill_2
XFILLER_160_829 VDD VDD VSS VSS gf180mcu_as_sc_mcu7t3v3__fillcap_8
XFILLER_172_667 VDD VDD VSS VSS gf180mcu_as_sc_mcu7t3v3__fillcap_16
XFILLER_176_1049 VDD VDD VSS VSS gf180mcu_as_sc_mcu7t3v3__fillcap_4
XFILLER_153_892 VDD VDD VSS VSS gf180mcu_as_sc_mcu7t3v3__fill_2
XFILLER_158_1483 VDD VDD VSS VSS gf180mcu_as_sc_mcu7t3v3__fill_1
XFILLER_98_80 VDD VDD VSS VSS gf180mcu_as_sc_mcu7t3v3__fillcap_8
X_4371_ VDD VDD VSS VSS _4372_/C _4371_/B _4371_/A gf180mcu_as_sc_mcu7t3v3__nor2b_2
XFILLER_119_1467 VDD VDD VSS VSS gf180mcu_as_sc_mcu7t3v3__fillcap_16
XFILLER_152_380 VDD VDD VSS VSS gf180mcu_as_sc_mcu7t3v3__fillcap_4
Xfanout609 VDD VDD VSS VSS _3751_/B _3742_/B gf180mcu_as_sc_mcu7t3v3__buff_2
X_3322_ VDD VDD VSS VSS _3442_/B _3975_/A _3323_/D gf180mcu_as_sc_mcu7t3v3__or2_2
X_3253_ VDD VDD VSS VSS _3509_/A _3818_/C _3253_/A gf180mcu_as_sc_mcu7t3v3__nand2_2
XFILLER_112_299 VDD VDD VSS VSS gf180mcu_as_sc_mcu7t3v3__fill_2
XFILLER_140_597 VDD VDD VSS VSS gf180mcu_as_sc_mcu7t3v3__fillcap_8
X_3184_ VDD VDD VSS VSS _3185_/D _3213_/A gf180mcu_as_sc_mcu7t3v3__inv_2
XTAP_TAPCELL_ROW_181_2238 VDD VSS gf180mcu_as_sc_mcu7t3v3__tap_2
XTAP_TAPCELL_ROW_181_2249 VDD VSS gf180mcu_as_sc_mcu7t3v3__tap_2
XFILLER_148_1118 VDD VDD VSS VSS gf180mcu_as_sc_mcu7t3v3__fill_2
XFILLER_78_1451 VDD VDD VSS VSS gf180mcu_as_sc_mcu7t3v3__fillcap_16
XFILLER_168_907 VDD VDD VSS VSS gf180mcu_as_sc_mcu7t3v3__fillcap_4
XFILLER_179_244 VDD VDD VSS VSS gf180mcu_as_sc_mcu7t3v3__fillcap_16
XPHY_EDGE_ROW_34_1_Right_33 VDD VSS gf180mcu_as_sc_mcu7t3v3__tap_2
XTAP_TAPCELL_ROW_179_2189 VDD VSS gf180mcu_as_sc_mcu7t3v3__tap_2
XTAP_TAPCELL_ROW_97_3_2495 VDD VSS gf180mcu_as_sc_mcu7t3v3__tap_2
X_2968_ VDD VDD VSS VSS _3950_/A _3233_/B _3236_/C _3949_/A _2969_/C gf180mcu_as_sc_mcu7t3v3__ao22_2
XTAP_TAPCELL_ROW_157_1720 VDD VSS gf180mcu_as_sc_mcu7t3v3__tap_2
XFILLER_135_303 VDD VDD VSS VSS gf180mcu_as_sc_mcu7t3v3__fillcap_4
XFILLER_148_664 VDD VDD VSS VSS gf180mcu_as_sc_mcu7t3v3__fill_1
X_4707_ VDD VDD VSS VSS _4707_/S _5256_/Q _4707_/A _5256_/D gf180mcu_as_sc_mcu7t3v3__mux2_2
XTAP_TAPCELL_ROW_153_1617 VDD VSS gf180mcu_as_sc_mcu7t3v3__tap_2
XTAP_TAPCELL_ROW_14_3_2371 VDD VSS gf180mcu_as_sc_mcu7t3v3__tap_2
XFILLER_135_314 VDD VDD VSS VSS gf180mcu_as_sc_mcu7t3v3__fillcap_4
XFILLER_136_848 VDD VDD VSS VSS gf180mcu_as_sc_mcu7t3v3__fill_2
XFILLER_163_634 VDD VDD VSS VSS gf180mcu_as_sc_mcu7t3v3__fill_1
X_4638_ VDD VDD VSS VSS _4733_/C _5104_/Q _5229_/Q _5229_/D gf180mcu_as_sc_mcu7t3v3__mux2_2
X_2899_ VDD VDD VSS VSS _4946_/Q _4945_/Q _3249_/B gf180mcu_as_sc_mcu7t3v3__and2_2
XTAP_TAPCELL_ROW_153_1628 VDD VSS gf180mcu_as_sc_mcu7t3v3__tap_2
XFILLER_162_155 VDD VDD VSS VSS gf180mcu_as_sc_mcu7t3v3__fillcap_16
XFILLER_163_678 VDD VDD VSS VSS gf180mcu_as_sc_mcu7t3v3__fillcap_4
XFILLER_150_317 VDD VDD VSS VSS gf180mcu_as_sc_mcu7t3v3__fillcap_4
XFILLER_162_177 VDD VDD VSS VSS gf180mcu_as_sc_mcu7t3v3__fillcap_16
X_4569_ VDD VDD VSS VSS _4572_/C _4999_/Q _4570_/S gf180mcu_as_sc_mcu7t3v3__nand2b_2
XTAP_TAPCELL_ROW_170_1997 VDD VSS gf180mcu_as_sc_mcu7t3v3__tap_2
XTAP_TAPCELL_ROW_170_1986 VDD VSS gf180mcu_as_sc_mcu7t3v3__tap_2
XTAP_TAPCELL_ROW_102_3_2503 VDD VSS gf180mcu_as_sc_mcu7t3v3__tap_2
XFILLER_85_1499 VDD VDD VSS VSS gf180mcu_as_sc_mcu7t3v3__fillcap_16
XFILLER_103_277 VDD VDD VSS VSS gf180mcu_as_sc_mcu7t3v3__fill_2
XFILLER_76_117 VDD VDD VSS VSS gf180mcu_as_sc_mcu7t3v3__fill_2
XFILLER_94_27 VDD VDD VSS VSS gf180mcu_as_sc_mcu7t3v3__fillcap_8
XFILLER_17_206 VDD VDD VSS VSS gf180mcu_as_sc_mcu7t3v3__fillcap_4
XFILLER_17_228 VDD VDD VSS VSS gf180mcu_as_sc_mcu7t3v3__fillcap_16
XFILLER_84_150 VDD VDD VSS VSS gf180mcu_as_sc_mcu7t3v3__fillcap_16
XFILLER_22_1483 VDD VDD VSS VSS gf180mcu_as_sc_mcu7t3v3__fill_1
XFILLER_32_209 VDD VDD VSS VSS gf180mcu_as_sc_mcu7t3v3__fillcap_16
XFILLER_138_174 VDD VDD VSS VSS gf180mcu_as_sc_mcu7t3v3__fill_1
XFILLER_139_686 VDD VDD VSS VSS gf180mcu_as_sc_mcu7t3v3__fillcap_8
XTAP_TAPCELL_ROW_94_1_1010 VDD VSS gf180mcu_as_sc_mcu7t3v3__tap_2
XFILLER_154_667 VDD VDD VSS VSS gf180mcu_as_sc_mcu7t3v3__fillcap_8
XFILLER_177_1336 VDD VDD VSS VSS gf180mcu_as_sc_mcu7t3v3__fill_1
XFILLER_181_486 VDD VDD VSS VSS gf180mcu_as_sc_mcu7t3v3__fillcap_4
XFILLER_182_998 VDD VDD VSS VSS gf180mcu_as_sc_mcu7t3v3__fillcap_4
XFILLER_134_380 VDD VDD VSS VSS gf180mcu_as_sc_mcu7t3v3__fill_2
XFILLER_136_1033 VDD VDD VSS VSS gf180mcu_as_sc_mcu7t3v3__fill_1
XFILLER_136_1055 VDD VDD VSS VSS gf180mcu_as_sc_mcu7t3v3__fill_1
XFILLER_4_69 VDD VDD VSS VSS gf180mcu_as_sc_mcu7t3v3__fillcap_16
XFILLER_67_106 VDD VDD VSS VSS gf180mcu_as_sc_mcu7t3v3__fillcap_4
XFILLER_153_1391 VDD VDD VSS VSS gf180mcu_as_sc_mcu7t3v3__fillcap_8
Xinput250 VDD VDD VSS VSS sw_in[10] _4018_/A gf180mcu_as_sc_mcu7t3v3__buff_2
Xinput261 VDD VDD VSS VSS sw_in[20] _2442_/A gf180mcu_as_sc_mcu7t3v3__buff_2
Xinput272 VDD VDD VSS VSS sw_in[30] _3803_/A gf180mcu_as_sc_mcu7t3v3__buff_2
XFILLER_40_1550 VDD VDD VSS VSS gf180mcu_as_sc_mcu7t3v3__fillcap_4
XFILLER_7_1499 VDD VDD VSS VSS gf180mcu_as_sc_mcu7t3v3__fillcap_16
XPHY_EDGE_ROW_174_Right_308 VDD VSS gf180mcu_as_sc_mcu7t3v3__tap_2
Xinput283 VDD VDD VSS VSS west_in[0] _3925_/D gf180mcu_as_sc_mcu7t3v3__buff_2
Xinput294 VDD VDD VSS VSS west_in[1] _3938_/D gf180mcu_as_sc_mcu7t3v3__buff_2
XFILLER_90_142 VDD VDD VSS VSS gf180mcu_as_sc_mcu7t3v3__fill_2
XFILLER_90_164 VDD VDD VSS VSS gf180mcu_as_sc_mcu7t3v3__fillcap_4
X_3940_ VDD VDD VSS VSS _3940_/A _4160_/C _4152_/C _4916_/Q _3942_/C gf180mcu_as_sc_mcu7t3v3__ao22_2
XFILLER_147_1173 VDD VDD VSS VSS gf180mcu_as_sc_mcu7t3v3__fillcap_4
XFILLER_177_737 VDD VDD VSS VSS gf180mcu_as_sc_mcu7t3v3__fill_1
XFILLER_182_1053 VDD VDD VSS VSS gf180mcu_as_sc_mcu7t3v3__fill_2
X_3871_ VDD VDD VSS VSS _3872_/D _3871_/B _5224_/Q gf180mcu_as_sc_mcu7t3v3__nand2_2
XFILLER_176_225 VDD VDD VSS VSS gf180mcu_as_sc_mcu7t3v3__fillcap_16
XFILLER_176_247 VDD VDD VSS VSS gf180mcu_as_sc_mcu7t3v3__fillcap_16
XFILLER_177_748 VDD VDD VSS VSS gf180mcu_as_sc_mcu7t3v3__fill_1
X_2822_ VDD VDD VSS VSS _4974_/D _2829_/B _4760_/Q _4759_/D gf180mcu_as_sc_mcu7t3v3__mux2_2
XFILLER_76_2 VDD VDD VSS VSS gf180mcu_as_sc_mcu7t3v3__fillcap_16
X_2753_ VDD VDD VSS VSS _2833_/A _4751_/A _5478_/A _2780_/B _2754_/D gf180mcu_as_sc_mcu7t3v3__aoi31_2
XTAP_TAPCELL_ROW_174_2086 VDD VSS gf180mcu_as_sc_mcu7t3v3__tap_2
XTAP_TAPCELL_ROW_174_2075 VDD VSS gf180mcu_as_sc_mcu7t3v3__tap_2
X_2684_ VDD VDD VSS VSS _2735_/A _2684_/B _2684_/C _2735_/D _2686_/C gf180mcu_as_sc_mcu7t3v3__ao211_2
XFILLER_144_177 VDD VDD VSS VSS gf180mcu_as_sc_mcu7t3v3__fillcap_16
XFILLER_160_626 VDD VDD VSS VSS gf180mcu_as_sc_mcu7t3v3__fill_1
X_4423_ VDD VDD VSS VSS _4423_/B _4591_/A _4424_/D gf180mcu_as_sc_mcu7t3v3__and2_2
X_4354_ VDD VDD VSS VSS _4354_/B _5159_/Q _4355_/A gf180mcu_as_sc_mcu7t3v3__xnor2_2
XFILLER_141_884 VDD VDD VSS VSS gf180mcu_as_sc_mcu7t3v3__fillcap_8
X_3305_ VDD VDD VSS VSS _3501_/C _3960_/A _3306_/D gf180mcu_as_sc_mcu7t3v3__and2_2
XFILLER_140_383 VDD VDD VSS VSS gf180mcu_as_sc_mcu7t3v3__fill_2
XFILLER_154_1177 VDD VDD VSS VSS gf180mcu_as_sc_mcu7t3v3__fill_1
X_4285_ VDD VDD VSS VSS _4289_/S _5481_/A _5119_/Q _5119_/D gf180mcu_as_sc_mcu7t3v3__mux2_2
XFILLER_100_247 VDD VDD VSS VSS gf180mcu_as_sc_mcu7t3v3__fillcap_4
XFILLER_104_26 VDD VDD VSS VSS gf180mcu_as_sc_mcu7t3v3__fillcap_8
XFILLER_45_1483 VDD VDD VSS VSS gf180mcu_as_sc_mcu7t3v3__fillcap_16
Xmesh_tile_854 VDD VDD VSS VSS ne_out[29] gf180mcu_as_sc_mcu7t3v3__tiel_4
Xmesh_tile_843 VDD VDD VSS VSS ne_out[18] gf180mcu_as_sc_mcu7t3v3__tiel_4
Xmesh_tile_832 VDD VDD VSS VSS ne_out[7] gf180mcu_as_sc_mcu7t3v3__tiel_4
X_3236_ VDD VDD VSS VSS _3236_/D _3236_/A _3236_/B _3236_/C _3237_/C gf180mcu_as_sc_mcu7t3v3__ao31_2
XFILLER_104_37 VDD VDD VSS VSS gf180mcu_as_sc_mcu7t3v3__fill_1
XFILLER_132_1486 VDD VDD VSS VSS gf180mcu_as_sc_mcu7t3v3__fillcap_8
Xmesh_tile_887 VDD VDD VSS VSS north_out[28] gf180mcu_as_sc_mcu7t3v3__tiel_4
Xmesh_tile_876 VDD VDD VSS VSS north_out[17] gf180mcu_as_sc_mcu7t3v3__tiel_4
Xmesh_tile_865 VDD VDD VSS VSS north_out[6] gf180mcu_as_sc_mcu7t3v3__tiel_4
X_3167_ VDD VDD VSS VSS _3176_/S _4143_/A _4145_/A _3170_/B gf180mcu_as_sc_mcu7t3v3__mux2_2
XTAP_TAPCELL_ROW_146_1465 VDD VSS gf180mcu_as_sc_mcu7t3v3__tap_2
Xmesh_tile_898 VDD VDD VSS VSS nw_out[5] gf180mcu_as_sc_mcu7t3v3__tiel_4
X_3098_ VDD VDD VSS VSS _4788_/D _3098_/C _3132_/B _4075_/A gf180mcu_as_sc_mcu7t3v3__aoi21_2
XTAP_TAPCELL_ROW_146_1476 VDD VSS gf180mcu_as_sc_mcu7t3v3__tap_2
XFILLER_14_209 VDD VDD VSS VSS gf180mcu_as_sc_mcu7t3v3__fillcap_16
XFILLER_81_142 VDD VDD VSS VSS gf180mcu_as_sc_mcu7t3v3__fill_2
XFILLER_120_25 VDD VDD VSS VSS gf180mcu_as_sc_mcu7t3v3__fillcap_8
XFILLER_168_704 VDD VDD VSS VSS gf180mcu_as_sc_mcu7t3v3__fill_1
XFILLER_147_8 VDD VDD VSS VSS gf180mcu_as_sc_mcu7t3v3__fillcap_16
XFILLER_165_1262 VDD VDD VSS VSS gf180mcu_as_sc_mcu7t3v3__fillcap_8
XFILLER_168_759 VDD VDD VSS VSS gf180mcu_as_sc_mcu7t3v3__fillcap_4
XFILLER_13_34 VDD VDD VSS VSS gf180mcu_as_sc_mcu7t3v3__fillcap_16
XFILLER_129_34 VDD VDD VSS VSS gf180mcu_as_sc_mcu7t3v3__fillcap_4
XFILLER_164_932 VDD VDD VSS VSS gf180mcu_as_sc_mcu7t3v3__fillcap_8
XFILLER_135_133 VDD VDD VSS VSS gf180mcu_as_sc_mcu7t3v3__fillcap_4
XFILLER_135_144 VDD VDD VSS VSS gf180mcu_as_sc_mcu7t3v3__fill_1
XFILLER_136_667 VDD VDD VSS VSS gf180mcu_as_sc_mcu7t3v3__fillcap_16
XFILLER_159_1044 VDD VDD VSS VSS gf180mcu_as_sc_mcu7t3v3__fillcap_4
XFILLER_164_998 VDD VDD VSS VSS gf180mcu_as_sc_mcu7t3v3__fillcap_4
XFILLER_135_188 VDD VDD VSS VSS gf180mcu_as_sc_mcu7t3v3__fillcap_16
XFILLER_150_147 VDD VDD VSS VSS gf180mcu_as_sc_mcu7t3v3__fill_1
XFILLER_172_1211 VDD VDD VSS VSS gf180mcu_as_sc_mcu7t3v3__fillcap_4
XFILLER_137_1364 VDD VDD VSS VSS gf180mcu_as_sc_mcu7t3v3__fillcap_16
XFILLER_145_88 VDD VDD VSS VSS gf180mcu_as_sc_mcu7t3v3__fillcap_16
XFILLER_24_1534 VDD VDD VSS VSS gf180mcu_as_sc_mcu7t3v3__fillcap_16
XFILLER_24_1556 VDD VDD VSS VSS gf180mcu_as_sc_mcu7t3v3__fillcap_8
XFILLER_38_53 VDD VDD VSS VSS gf180mcu_as_sc_mcu7t3v3__fillcap_16
XFILLER_111_1515 VDD VDD VSS VSS gf180mcu_as_sc_mcu7t3v3__fillcap_4
XFILLER_111_1537 VDD VDD VSS VSS gf180mcu_as_sc_mcu7t3v3__fillcap_16
XFILLER_161_65 VDD VDD VSS VSS gf180mcu_as_sc_mcu7t3v3__fillcap_4
XFILLER_180_2 VDD VDD VSS VSS gf180mcu_as_sc_mcu7t3v3__fillcap_16
XPHY_EDGE_ROW_112_3_Left_246 VDD VSS gf180mcu_as_sc_mcu7t3v3__tap_2
XFILLER_166_1037 VDD VDD VSS VSS gf180mcu_as_sc_mcu7t3v3__fillcap_16
XFILLER_72_142 VDD VDD VSS VSS gf180mcu_as_sc_mcu7t3v3__fill_2
XFILLER_144_1313 VDD VDD VSS VSS gf180mcu_as_sc_mcu7t3v3__fillcap_16
XFILLER_148_1493 VDD VDD VSS VSS gf180mcu_as_sc_mcu7t3v3__fill_1
XFILLER_54_96 VDD VDD VSS VSS gf180mcu_as_sc_mcu7t3v3__fillcap_8
XFILLER_110_80 VDD VDD VSS VSS gf180mcu_as_sc_mcu7t3v3__fillcap_8
XFILLER_158_247 VDD VDD VSS VSS gf180mcu_as_sc_mcu7t3v3__fillcap_4
XTAP_TAPCELL_ROW_13_1_686 VDD VSS gf180mcu_as_sc_mcu7t3v3__tap_2
XFILLER_109_1499 VDD VDD VSS VSS gf180mcu_as_sc_mcu7t3v3__fillcap_16
XFILLER_173_206 VDD VDD VSS VSS gf180mcu_as_sc_mcu7t3v3__fillcap_4
XFILLER_173_228 VDD VDD VSS VSS gf180mcu_as_sc_mcu7t3v3__fillcap_16
XFILLER_70_73 VDD VDD VSS VSS gf180mcu_as_sc_mcu7t3v3__fillcap_16
Xclkload16 VDD VDD VSS VSS _5052_/CLK clkload16/Y gf180mcu_as_sc_mcu7t3v3__clkbuff_12
XFILLER_62_8 VDD VDD VSS VSS gf180mcu_as_sc_mcu7t3v3__fill_2
Xclkload27 VDD VDD VSS VSS clkload27/Y _4867_/CLK gf180mcu_as_sc_mcu7t3v3__inv_2
XPHY_EDGE_ROW_90_3_Right_409 VDD VSS gf180mcu_as_sc_mcu7t3v3__tap_2
XFILLER_155_998 VDD VDD VSS VSS gf180mcu_as_sc_mcu7t3v3__fillcap_8
XFILLER_141_114 VDD VDD VSS VSS gf180mcu_as_sc_mcu7t3v3__fill_1
XFILLER_170_968 VDD VDD VSS VSS gf180mcu_as_sc_mcu7t3v3__fill_1
XFILLER_68_1483 VDD VDD VSS VSS gf180mcu_as_sc_mcu7t3v3__fill_1
XFILLER_29_1467 VDD VDD VSS VSS gf180mcu_as_sc_mcu7t3v3__fillcap_16
XFILLER_150_692 VDD VDD VSS VSS gf180mcu_as_sc_mcu7t3v3__fillcap_16
X_4070_ VDD VDD VSS VSS _4070_/A _4104_/B _4099_/B _4070_/D _4074_/A gf180mcu_as_sc_mcu7t3v3__ao211_2
XFILLER_48_161 VDD VDD VSS VSS gf180mcu_as_sc_mcu7t3v3__fill_2
XFILLER_95_267 VDD VDD VSS VSS gf180mcu_as_sc_mcu7t3v3__fill_2
XPHY_EDGE_ROW_44_3_Left_178 VDD VSS gf180mcu_as_sc_mcu7t3v3__tap_2
X_3021_ VDD VDD VSS VSS _4001_/A _3147_/B _3021_/C _3021_/D _3022_/C gf180mcu_as_sc_mcu7t3v3__ao22_2
XFILLER_184_1104 VDD VDD VSS VSS gf180mcu_as_sc_mcu7t3v3__fillcap_4
XFILLER_63_142 VDD VDD VSS VSS gf180mcu_as_sc_mcu7t3v3__fillcap_8
X_4972_ VDD VDD VSS VSS _5146_/CLK _4972_/D _4972_/Q gf180mcu_as_sc_mcu7t3v3__dfxtp_2
XTAP_TAPCELL_ROW_141_1351 VDD VSS gf180mcu_as_sc_mcu7t3v3__tap_2
X_3923_ VDD VDD VSS VSS _3923_/B _3923_/A _3923_/Y gf180mcu_as_sc_mcu7t3v3__and2_2
XTAP_TAPCELL_ROW_176_2137 VDD VSS gf180mcu_as_sc_mcu7t3v3__tap_2
XTAP_TAPCELL_ROW_176_2126 VDD VSS gf180mcu_as_sc_mcu7t3v3__tap_2
XTAP_TAPCELL_ROW_141_1362 VDD VSS gf180mcu_as_sc_mcu7t3v3__tap_2
X_3854_ VDD VDD VSS VSS _5148_/Q _5147_/Q _3855_/C gf180mcu_as_sc_mcu7t3v3__or2_2
X_2805_ VDD VDD VSS VSS _2840_/D _2805_/A _2806_/C gf180mcu_as_sc_mcu7t3v3__and2_2
XFILLER_160_1170 VDD VDD VSS VSS gf180mcu_as_sc_mcu7t3v3__fillcap_8
XFILLER_164_217 VDD VDD VSS VSS gf180mcu_as_sc_mcu7t3v3__fill_2
X_3785_ VDD VDD VSS VSS _3785_/B _3795_/A _4867_/D gf180mcu_as_sc_mcu7t3v3__and2_2
XFILLER_117_144 VDD VDD VSS VSS gf180mcu_as_sc_mcu7t3v3__fill_1
XFILLER_145_453 VDD VDD VSS VSS gf180mcu_as_sc_mcu7t3v3__fillcap_8
XFILLER_173_740 VDD VDD VSS VSS gf180mcu_as_sc_mcu7t3v3__fillcap_16
X_2736_ VDD VDD VSS VSS _2737_/D _2737_/A _2736_/B _2736_/A gf180mcu_as_sc_mcu7t3v3__aoi21b_2
XFILLER_145_486 VDD VDD VSS VSS gf180mcu_as_sc_mcu7t3v3__fillcap_4
X_2667_ VDD VDD VSS VSS input9/Y _2736_/B _2667_/C _2668_/C _2832_/S gf180mcu_as_sc_mcu7t3v3__aoi211_2
XFILLER_117_188 VDD VDD VSS VSS gf180mcu_as_sc_mcu7t3v3__fillcap_16
XFILLER_161_946 VDD VDD VSS VSS gf180mcu_as_sc_mcu7t3v3__fill_2
XFILLER_173_1520 VDD VDD VSS VSS gf180mcu_as_sc_mcu7t3v3__fillcap_16
XFILLER_86_1550 VDD VDD VSS VSS gf180mcu_as_sc_mcu7t3v3__fillcap_4
X_4406_ VDD VDD VSS VSS _4407_/D _4406_/B _4562_/A gf180mcu_as_sc_mcu7t3v3__nor2_2
XFILLER_173_1542 VDD VDD VSS VSS gf180mcu_as_sc_mcu7t3v3__fillcap_16
XPHY_EDGE_ROW_136_Right_270 VDD VSS gf180mcu_as_sc_mcu7t3v3__tap_2
X_2598_ VDD VDD VSS VSS _2598_/B _2598_/A _2599_/B gf180mcu_as_sc_mcu7t3v3__and2_2
XTAP_TAPCELL_ROW_30_1_756 VDD VSS gf180mcu_as_sc_mcu7t3v3__tap_2
XFILLER_115_14 VDD VDD VSS VSS gf180mcu_as_sc_mcu7t3v3__fill_1
XFILLER_141_670 VDD VDD VSS VSS gf180mcu_as_sc_mcu7t3v3__fillcap_8
XFILLER_173_1564 VDD VDD VSS VSS gf180mcu_as_sc_mcu7t3v3__fill_1
X_4337_ VDD VDD VSS VSS _4366_/S _4337_/B _5157_/Q _4345_/B gf180mcu_as_sc_mcu7t3v3__mux2_2
XTAP_TAPCELL_ROW_148_1516 VDD VSS gf180mcu_as_sc_mcu7t3v3__tap_2
XTAP_TAPCELL_ROW_148_1505 VDD VSS gf180mcu_as_sc_mcu7t3v3__tap_2
XFILLER_115_69 VDD VDD VSS VSS gf180mcu_as_sc_mcu7t3v3__fill_1
X_4268_ VDD VDD VSS VSS _4273_/S _5480_/A _5102_/Q _5102_/D gf180mcu_as_sc_mcu7t3v3__mux2_2
XFILLER_86_289 VDD VDD VSS VSS gf180mcu_as_sc_mcu7t3v3__fillcap_8
X_3219_ VDD VDD VSS VSS _4801_/D _3219_/B _3706_/D gf180mcu_as_sc_mcu7t3v3__nor2_2
XFILLER_131_24 VDD VDD VSS VSS gf180mcu_as_sc_mcu7t3v3__fillcap_8
XFILLER_167_1313 VDD VDD VSS VSS gf180mcu_as_sc_mcu7t3v3__fillcap_16
X_4199_ VDD VDD VSS VSS _4199_/Y _4228_/B _4199_/A gf180mcu_as_sc_mcu7t3v3__nor2_2
XTAP_TAPCELL_ROW_85_3_2477 VDD VSS gf180mcu_as_sc_mcu7t3v3__tap_2
XTAP_TAPCELL_ROW_165_1896 VDD VSS gf180mcu_as_sc_mcu7t3v3__tap_2
XTAP_TAPCELL_ROW_165_1885 VDD VSS gf180mcu_as_sc_mcu7t3v3__tap_2
XFILLER_93_1521 VDD VDD VSS VSS gf180mcu_as_sc_mcu7t3v3__fillcap_16
XFILLER_180_1502 VDD VDD VSS VSS gf180mcu_as_sc_mcu7t3v3__fill_2
XFILLER_156_707 VDD VDD VSS VSS gf180mcu_as_sc_mcu7t3v3__fill_2
XFILLER_155_228 VDD VDD VSS VSS gf180mcu_as_sc_mcu7t3v3__fillcap_16
XFILLER_40_10 VDD VDD VSS VSS gf180mcu_as_sc_mcu7t3v3__fill_1
XFILLER_148_291 VDD VDD VSS VSS gf180mcu_as_sc_mcu7t3v3__fillcap_16
XFILLER_178_1420 VDD VDD VSS VSS gf180mcu_as_sc_mcu7t3v3__fillcap_8
XFILLER_40_32 VDD VDD VSS VSS gf180mcu_as_sc_mcu7t3v3__fill_2
XFILLER_108_177 VDD VDD VSS VSS gf180mcu_as_sc_mcu7t3v3__fillcap_16
XFILLER_137_998 VDD VDD VSS VSS gf180mcu_as_sc_mcu7t3v3__fillcap_4
XFILLER_170_209 VDD VDD VSS VSS gf180mcu_as_sc_mcu7t3v3__fillcap_16
XFILLER_151_412 VDD VDD VSS VSS gf180mcu_as_sc_mcu7t3v3__fill_1
XFILLER_174_1317 VDD VDD VSS VSS gf180mcu_as_sc_mcu7t3v3__fillcap_4
XFILLER_6_2 VDD VDD VSS VSS gf180mcu_as_sc_mcu7t3v3__fillcap_16
XFILLER_49_41 VDD VDD VSS VSS gf180mcu_as_sc_mcu7t3v3__fill_1
XFILLER_77_212 VDD VDD VSS VSS gf180mcu_as_sc_mcu7t3v3__fillcap_4
XFILLER_8_1550 VDD VDD VSS VSS gf180mcu_as_sc_mcu7t3v3__fillcap_4
XFILLER_172_97 VDD VDD VSS VSS gf180mcu_as_sc_mcu7t3v3__fillcap_8
Xfanout770 VDD VDD VSS VSS _4570_/S _4544_/S gf180mcu_as_sc_mcu7t3v3__buff_2
Xfanout781 VDD VDD VSS VSS _4974_/Q _4975_/D gf180mcu_as_sc_mcu7t3v3__buff_2
Xfanout792 VDD VDD VSS VSS _2730_/A _2832_/S gf180mcu_as_sc_mcu7t3v3__buff_2
XTAP_TAPCELL_ROW_6_1_658 VDD VSS gf180mcu_as_sc_mcu7t3v3__tap_2
XFILLER_105_80 VDD VDD VSS VSS gf180mcu_as_sc_mcu7t3v3__fillcap_8
XFILLER_150_1383 VDD VDD VSS VSS gf180mcu_as_sc_mcu7t3v3__fillcap_8
XFILLER_45_142 VDD VDD VSS VSS gf180mcu_as_sc_mcu7t3v3__fillcap_8
XFILLER_60_134 VDD VDD VSS VSS gf180mcu_as_sc_mcu7t3v3__fillcap_8
XFILLER_159_545 VDD VDD VSS VSS gf180mcu_as_sc_mcu7t3v3__fill_2
XFILLER_81_72 VDD VDD VSS VSS gf180mcu_as_sc_mcu7t3v3__fill_1
XFILLER_144_1154 VDD VDD VSS VSS gf180mcu_as_sc_mcu7t3v3__fill_1
XFILLER_159_578 VDD VDD VSS VSS gf180mcu_as_sc_mcu7t3v3__fill_1
XFILLER_81_94 VDD VDD VSS VSS gf180mcu_as_sc_mcu7t3v3__fill_1
XTAP_TAPCELL_ROW_171_2023 VDD VSS gf180mcu_as_sc_mcu7t3v3__tap_2
XTAP_TAPCELL_ROW_171_2012 VDD VSS gf180mcu_as_sc_mcu7t3v3__tap_2
X_3570_ VDD VDD VSS VSS _3926_/A _3792_/B _3791_/B _3925_/A _3571_/D gf180mcu_as_sc_mcu7t3v3__ao22_2
X_2521_ VDD VDD VSS VSS _2522_/C _4739_/A _5270_/Q _5269_/Q gf180mcu_as_sc_mcu7t3v3__aoi21_2
XFILLER_142_412 VDD VDD VSS VSS gf180mcu_as_sc_mcu7t3v3__fill_1
XFILLER_154_283 VDD VDD VSS VSS gf180mcu_as_sc_mcu7t3v3__fill_2
XFILLER_170_754 VDD VDD VSS VSS gf180mcu_as_sc_mcu7t3v3__fillcap_4
XFILLER_5_282 VDD VDD VSS VSS gf180mcu_as_sc_mcu7t3v3__fill_1
X_5240_ VDD VDD VSS VSS clkload7/A _5240_/D _5240_/Q gf180mcu_as_sc_mcu7t3v3__dfxtp_2
XFILLER_143_979 VDD VDD VSS VSS gf180mcu_as_sc_mcu7t3v3__fill_1
XFILLER_170_787 VDD VDD VSS VSS gf180mcu_as_sc_mcu7t3v3__fill_1
X_2452_ VDD VDD VSS VSS _2453_/C _4341_/S _5033_/Q _4448_/A gf180mcu_as_sc_mcu7t3v3__ao21_2
XFILLER_155_1272 VDD VDD VSS VSS gf180mcu_as_sc_mcu7t3v3__fill_1
XFILLER_39_2 VDD VDD VSS VSS gf180mcu_as_sc_mcu7t3v3__fill_1
X_5171_ VDD VDD VSS VSS _5172_/CLK _5171_/D _5171_/Q gf180mcu_as_sc_mcu7t3v3__dfxtp_2
XPHY_EDGE_ROW_43_1_Right_42 VDD VSS gf180mcu_as_sc_mcu7t3v3__tap_2
X_4122_ VDD VDD VSS VSS _4122_/A _4122_/B _4122_/C _4122_/D _4123_/B gf180mcu_as_sc_mcu7t3v3__ao211_2
X_4053_ VDD VDD VSS VSS _4053_/A _4118_/C _4121_/C _4053_/D _4055_/C gf180mcu_as_sc_mcu7t3v3__ao22_2
XFILLER_42_1486 VDD VDD VSS VSS gf180mcu_as_sc_mcu7t3v3__fillcap_16
XPHY_EDGE_ROW_14_1_Left_466 VDD VSS gf180mcu_as_sc_mcu7t3v3__tap_2
Xinput3 VDD VDD VSS VSS boot_addr[1] input3/Y gf180mcu_as_sc_mcu7t3v3__buff_2
X_3004_ VDD VDD VSS VSS _3985_/A _3130_/B _3004_/C _3004_/D _3005_/C gf180mcu_as_sc_mcu7t3v3__ao22_2
XTAP_TAPCELL_ROW_143_1413 VDD VSS gf180mcu_as_sc_mcu7t3v3__tap_2
XTAP_TAPCELL_ROW_143_1402 VDD VSS gf180mcu_as_sc_mcu7t3v3__tap_2
XFILLER_101_16 VDD VDD VSS VSS gf180mcu_as_sc_mcu7t3v3__fill_1
XFILLER_101_27 VDD VDD VSS VSS gf180mcu_as_sc_mcu7t3v3__fillcap_8
XFILLER_149_1076 VDD VDD VSS VSS gf180mcu_as_sc_mcu7t3v3__fill_2
XFILLER_51_134 VDD VDD VSS VSS gf180mcu_as_sc_mcu7t3v3__fillcap_4
XFILLER_91_292 VDD VDD VSS VSS gf180mcu_as_sc_mcu7t3v3__fillcap_8
X_4955_ VDD VDD VSS VSS clkload5/A _4955_/D _4955_/Q gf180mcu_as_sc_mcu7t3v3__dfxtp_2
XTAP_TAPCELL_ROW_160_1782 VDD VSS gf180mcu_as_sc_mcu7t3v3__tap_2
XTAP_TAPCELL_ROW_160_1771 VDD VSS gf180mcu_as_sc_mcu7t3v3__tap_2
XFILLER_51_156 VDD VDD VSS VSS gf180mcu_as_sc_mcu7t3v3__fillcap_4
X_3906_ VDD VDD VSS VSS _3906_/S _3906_/B _4947_/Q _4947_/D gf180mcu_as_sc_mcu7t3v3__mux2_2
XTAP_TAPCELL_ROW_128_1_1147 VDD VSS gf180mcu_as_sc_mcu7t3v3__tap_2
X_4886_ VDD VDD VSS VSS _4943_/CLK _4886_/D _4886_/Q gf180mcu_as_sc_mcu7t3v3__dfxtp_2
X_3837_ VDD VDD VSS VSS _3838_/B _4911_/Q _3839_/A gf180mcu_as_sc_mcu7t3v3__or2_2
X_3768_ VDD VDD VSS VSS _3768_/B _3768_/A _4865_/D gf180mcu_as_sc_mcu7t3v3__and2_2
XFILLER_152_209 VDD VDD VSS VSS gf180mcu_as_sc_mcu7t3v3__fillcap_16
XFILLER_161_710 VDD VDD VSS VSS gf180mcu_as_sc_mcu7t3v3__fill_2
X_2719_ VDD VDD VSS VSS _5162_/Q _4269_/S _4278_/S _5186_/Q _2720_/B gf180mcu_as_sc_mcu7t3v3__ao22_2
X_3699_ VDD VDD VSS VSS _4075_/A _3731_/B _3699_/C _4856_/D _3699_/D gf180mcu_as_sc_mcu7t3v3__aoi211_2
XTAP_TAPCELL_ROW_108_1_1067 VDD VSS gf180mcu_as_sc_mcu7t3v3__tap_2
XFILLER_160_242 VDD VDD VSS VSS gf180mcu_as_sc_mcu7t3v3__fill_2
Xoutput362 VDD VDD VSS VSS _4783_/Q se_out[12] gf180mcu_as_sc_mcu7t3v3__buff_2
Xoutput351 VDD VDD VSS VSS _4872_/Q east_out[33] gf180mcu_as_sc_mcu7t3v3__buff_2
Xoutput340 VDD VDD VSS VSS _4862_/Q east_out[23] gf180mcu_as_sc_mcu7t3v3__buff_2
XFILLER_59_212 VDD VDD VSS VSS gf180mcu_as_sc_mcu7t3v3__fill_1
Xoutput395 VDD VDD VSS VSS _4816_/Q south_out[11] gf180mcu_as_sc_mcu7t3v3__buff_2
Xoutput384 VDD VDD VSS VSS _4803_/Q se_out[32] gf180mcu_as_sc_mcu7t3v3__buff_2
Xoutput373 VDD VDD VSS VSS _4793_/Q se_out[22] gf180mcu_as_sc_mcu7t3v3__buff_2
XTAP_TAPCELL_ROW_167_1936 VDD VSS gf180mcu_as_sc_mcu7t3v3__tap_2
XTAP_TAPCELL_ROW_167_1925 VDD VSS gf180mcu_as_sc_mcu7t3v3__tap_2
XTAP_TAPCELL_ROW_12_1_685 VDD VSS gf180mcu_as_sc_mcu7t3v3__tap_2
XFILLER_134_1378 VDD VDD VSS VSS gf180mcu_as_sc_mcu7t3v3__fillcap_16
XFILLER_142_34 VDD VDD VSS VSS gf180mcu_as_sc_mcu7t3v3__fill_1
XFILLER_19_66 VDD VDD VSS VSS gf180mcu_as_sc_mcu7t3v3__fillcap_4
XFILLER_19_88 VDD VDD VSS VSS gf180mcu_as_sc_mcu7t3v3__fillcap_16
XFILLER_21_1515 VDD VDD VSS VSS gf180mcu_as_sc_mcu7t3v3__fillcap_4
XFILLER_21_1537 VDD VDD VSS VSS gf180mcu_as_sc_mcu7t3v3__fillcap_16
XFILLER_60_1564 VDD VDD VSS VSS gf180mcu_as_sc_mcu7t3v3__fillcap_4
XFILLER_27_120 VDD VDD VSS VSS gf180mcu_as_sc_mcu7t3v3__fillcap_16
XFILLER_27_142 VDD VDD VSS VSS gf180mcu_as_sc_mcu7t3v3__fillcap_16
XFILLER_74_259 VDD VDD VSS VSS gf180mcu_as_sc_mcu7t3v3__fill_2
XTAP_TAPCELL_ROW_2_1_642 VDD VSS gf180mcu_as_sc_mcu7t3v3__tap_2
XFILLER_42_134 VDD VDD VSS VSS gf180mcu_as_sc_mcu7t3v3__fillcap_8
XFILLER_145_1430 VDD VDD VSS VSS gf180mcu_as_sc_mcu7t3v3__fill_1
XFILLER_180_1321 VDD VDD VSS VSS gf180mcu_as_sc_mcu7t3v3__fillcap_4
XFILLER_169_854 VDD VDD VSS VSS gf180mcu_as_sc_mcu7t3v3__fill_2
XTAP_TAPCELL_ROW_108_3_2512 VDD VSS gf180mcu_as_sc_mcu7t3v3__tap_2
XFILLER_141_1327 VDD VDD VSS VSS gf180mcu_as_sc_mcu7t3v3__fill_2
XFILLER_141_1338 VDD VDD VSS VSS gf180mcu_as_sc_mcu7t3v3__fill_1
XFILLER_156_504 VDD VDD VSS VSS gf180mcu_as_sc_mcu7t3v3__fillcap_16
XFILLER_19_1499 VDD VDD VSS VSS gf180mcu_as_sc_mcu7t3v3__fillcap_16
Xclkbuf_3_3_0_clk_regs VDD VDD VSS VSS clkbuf_0_clk_regs/Y clkbuf_3_3_0_clk_regs/Y
+ gf180mcu_as_sc_mcu7t3v3__clkbuff_12
XFILLER_143_209 VDD VDD VSS VSS gf180mcu_as_sc_mcu7t3v3__fill_1
Xwire478 VDD VDD VSS VSS _2730_/Y wire478/Y gf180mcu_as_sc_mcu7t3v3__buff_8
XFILLER_152_765 VDD VDD VSS VSS gf180mcu_as_sc_mcu7t3v3__fill_1
XFILLER_174_1125 VDD VDD VSS VSS gf180mcu_as_sc_mcu7t3v3__fill_1
XFILLER_2_241 VDD VDD VSS VSS gf180mcu_as_sc_mcu7t3v3__fillcap_4
XFILLER_117_1521 VDD VDD VSS VSS gf180mcu_as_sc_mcu7t3v3__fillcap_16
XFILLER_140_938 VDD VDD VSS VSS gf180mcu_as_sc_mcu7t3v3__fillcap_4
XFILLER_152_787 VDD VDD VSS VSS gf180mcu_as_sc_mcu7t3v3__fill_1
XFILLER_116_90 VDD VDD VSS VSS gf180mcu_as_sc_mcu7t3v3__fill_2
XFILLER_152_1478 VDD VDD VSS VSS gf180mcu_as_sc_mcu7t3v3__fillcap_4
XFILLER_146_1205 VDD VDD VSS VSS gf180mcu_as_sc_mcu7t3v3__fillcap_16
XFILLER_178_139 VDD VDD VSS VSS gf180mcu_as_sc_mcu7t3v3__fillcap_16
X_4740_ VDD VDD VSS VSS _4740_/B _4750_/B _5271_/D gf180mcu_as_sc_mcu7t3v3__and2_2
X_4671_ VDD VDD VSS VSS _5113_/Q _4680_/B _4681_/C _5244_/Q _4672_/C gf180mcu_as_sc_mcu7t3v3__ao22_2
X_3622_ VDD VDD VSS VSS _3623_/B _3993_/A _3802_/B _3622_/C gf180mcu_as_sc_mcu7t3v3__ao21_2
XFILLER_127_250 VDD VDD VSS VSS gf180mcu_as_sc_mcu7t3v3__fillcap_4
XTAP_TAPCELL_ROW_93_1_1006 VDD VSS gf180mcu_as_sc_mcu7t3v3__tap_2
XTAP_TAPCELL_ROW_136_1250 VDD VSS gf180mcu_as_sc_mcu7t3v3__tap_2
XFILLER_127_294 VDD VDD VSS VSS gf180mcu_as_sc_mcu7t3v3__fillcap_4
X_3553_ VDD VDD VSS VSS _3801_/C _3814_/A _3553_/A gf180mcu_as_sc_mcu7t3v3__nor2b_2
XFILLER_170_562 VDD VDD VSS VSS gf180mcu_as_sc_mcu7t3v3__fillcap_8
X_3484_ VDD VDD VSS VSS _3484_/B _3624_/A _4830_/D gf180mcu_as_sc_mcu7t3v3__and2_2
X_2504_ VDD VDD VSS VSS _2546_/B _2546_/A _2745_/A gf180mcu_as_sc_mcu7t3v3__xnor2_2
XFILLER_142_275 VDD VDD VSS VSS gf180mcu_as_sc_mcu7t3v3__fillcap_8
XFILLER_83_1553 VDD VDD VSS VSS gf180mcu_as_sc_mcu7t3v3__fillcap_16
X_5223_ VDD VDD VSS VSS clkload8/A _5223_/D _5223_/Q gf180mcu_as_sc_mcu7t3v3__dfxtp_2
X_2435_ VDD VDD VSS VSS _4043_/A _2435_/A gf180mcu_as_sc_mcu7t3v3__inv_2
XFILLER_102_128 VDD VDD VSS VSS gf180mcu_as_sc_mcu7t3v3__fill_2
XFILLER_170_1523 VDD VDD VSS VSS gf180mcu_as_sc_mcu7t3v3__fillcap_16
XPHY_EDGE_ROW_179_Left_631 VDD VSS gf180mcu_as_sc_mcu7t3v3__tap_2
X_5154_ VDD VDD VSS VSS clkload8/A _5154_/D _5154_/Q gf180mcu_as_sc_mcu7t3v3__dfxtp_2
XTAP_TAPCELL_ROW_38_3_2407 VDD VSS gf180mcu_as_sc_mcu7t3v3__tap_2
X_4105_ VDD VDD VSS VSS _4105_/A _4105_/B _4105_/C _4105_/D _4106_/B gf180mcu_as_sc_mcu7t3v3__ao211_2
X_5085_ VDD VDD VSS VSS _5085_/CLK _5085_/D _5085_/Q gf180mcu_as_sc_mcu7t3v3__dfxtp_2
X_4036_ VDD VDD VSS VSS _4990_/Q _4092_/B _4241_/B _4092_/D _4990_/D gf180mcu_as_sc_mcu7t3v3__ao22_2
XTAP_TAPCELL_ROW_162_1822 VDD VSS gf180mcu_as_sc_mcu7t3v3__tap_2
XTAP_TAPCELL_ROW_162_1811 VDD VSS gf180mcu_as_sc_mcu7t3v3__tap_2
XFILLER_112_37 VDD VDD VSS VSS gf180mcu_as_sc_mcu7t3v3__fill_1
XFILLER_168_1463 VDD VDD VSS VSS gf180mcu_as_sc_mcu7t3v3__fillcap_16
XFILLER_24_101 VDD VDD VSS VSS gf180mcu_as_sc_mcu7t3v3__fillcap_4
XFILLER_24_123 VDD VDD VSS VSS gf180mcu_as_sc_mcu7t3v3__fillcap_16
XFILLER_90_1502 VDD VDD VSS VSS gf180mcu_as_sc_mcu7t3v3__fillcap_16
XFILLER_178_651 VDD VDD VSS VSS gf180mcu_as_sc_mcu7t3v3__fill_1
X_4938_ VDD VDD VSS VSS _4938_/CLK _4938_/D _4938_/Q gf180mcu_as_sc_mcu7t3v3__dfxtp_2
XFILLER_90_1568 VDD VDD VSS VSS gf180mcu_as_sc_mcu7t3v3__fill_1
X_4869_ VDD VDD VSS VSS _4869_/CLK _4869_/D _4869_/Q gf180mcu_as_sc_mcu7t3v3__dfxtp_2
XFILLER_138_559 VDD VDD VSS VSS gf180mcu_as_sc_mcu7t3v3__fillcap_16
XFILLER_166_846 VDD VDD VSS VSS gf180mcu_as_sc_mcu7t3v3__fillcap_4
XTAP_TAPCELL_ROW_5_1_657 VDD VSS gf180mcu_as_sc_mcu7t3v3__tap_2
XFILLER_181_838 VDD VDD VSS VSS gf180mcu_as_sc_mcu7t3v3__fill_2
XFILLER_21_34 VDD VDD VSS VSS gf180mcu_as_sc_mcu7t3v3__fillcap_16
XPHY_EDGE_ROW_69_3_Left_203 VDD VSS gf180mcu_as_sc_mcu7t3v3__tap_2
XFILLER_134_732 VDD VDD VSS VSS gf180mcu_as_sc_mcu7t3v3__fillcap_16
XFILLER_137_34 VDD VDD VSS VSS gf180mcu_as_sc_mcu7t3v3__fillcap_16
XPHY_EDGE_ROW_121_3_Left_255 VDD VSS gf180mcu_as_sc_mcu7t3v3__tap_2
XFILLER_133_220 VDD VDD VSS VSS gf180mcu_as_sc_mcu7t3v3__fillcap_4
XFILLER_175_1445 VDD VDD VSS VSS gf180mcu_as_sc_mcu7t3v3__fillcap_8
XFILLER_88_1486 VDD VDD VSS VSS gf180mcu_as_sc_mcu7t3v3__fillcap_16
XFILLER_97_27 VDD VDD VSS VSS gf180mcu_as_sc_mcu7t3v3__fillcap_8
XFILLER_133_286 VDD VDD VSS VSS gf180mcu_as_sc_mcu7t3v3__fill_1
XFILLER_161_562 VDD VDD VSS VSS gf180mcu_as_sc_mcu7t3v3__fillcap_8
XTAP_TAPCELL_ROW_73_3_2459 VDD VSS gf180mcu_as_sc_mcu7t3v3__tap_2
XFILLER_134_1164 VDD VDD VSS VSS gf180mcu_as_sc_mcu7t3v3__fill_1
XFILLER_153_66 VDD VDD VSS VSS gf180mcu_as_sc_mcu7t3v3__fillcap_4
XFILLER_47_204 VDD VDD VSS VSS gf180mcu_as_sc_mcu7t3v3__fillcap_4
XFILLER_153_88 VDD VDD VSS VSS gf180mcu_as_sc_mcu7t3v3__fillcap_16
XFILLER_169_1205 VDD VDD VSS VSS gf180mcu_as_sc_mcu7t3v3__fillcap_8
XFILLER_101_194 VDD VDD VSS VSS gf180mcu_as_sc_mcu7t3v3__fillcap_8
XFILLER_112_1451 VDD VDD VSS VSS gf180mcu_as_sc_mcu7t3v3__fillcap_16
XFILLER_5_1553 VDD VDD VSS VSS gf180mcu_as_sc_mcu7t3v3__fillcap_16
XFILLER_70_251 VDD VDD VSS VSS gf180mcu_as_sc_mcu7t3v3__fill_1
XFILLER_62_41 VDD VDD VSS VSS gf180mcu_as_sc_mcu7t3v3__fill_2
XFILLER_141_1124 VDD VDD VSS VSS gf180mcu_as_sc_mcu7t3v3__fill_1
XFILLER_157_824 VDD VDD VSS VSS gf180mcu_as_sc_mcu7t3v3__fillcap_16
XFILLER_178_85 VDD VDD VSS VSS gf180mcu_as_sc_mcu7t3v3__fillcap_16
XFILLER_156_356 VDD VDD VSS VSS gf180mcu_as_sc_mcu7t3v3__fill_2
XFILLER_183_142 VDD VDD VSS VSS gf180mcu_as_sc_mcu7t3v3__fill_2
XPHY_EDGE_ROW_53_3_Left_187 VDD VSS gf180mcu_as_sc_mcu7t3v3__tap_2
XFILLER_109_261 VDD VDD VSS VSS gf180mcu_as_sc_mcu7t3v3__fill_2
XFILLER_137_570 VDD VDD VSS VSS gf180mcu_as_sc_mcu7t3v3__fillcap_4
XFILLER_67_1515 VDD VDD VSS VSS gf180mcu_as_sc_mcu7t3v3__fillcap_4
XFILLER_124_231 VDD VDD VSS VSS gf180mcu_as_sc_mcu7t3v3__fillcap_8
XFILLER_67_1537 VDD VDD VSS VSS gf180mcu_as_sc_mcu7t3v3__fillcap_16
XFILLER_124_253 VDD VDD VSS VSS gf180mcu_as_sc_mcu7t3v3__fill_1
XFILLER_154_1507 VDD VDD VSS VSS gf180mcu_as_sc_mcu7t3v3__fillcap_16
XFILLER_97_126 VDD VDD VSS VSS gf180mcu_as_sc_mcu7t3v3__fill_1
XTAP_TAPCELL_ROW_40_1_794 VDD VSS gf180mcu_as_sc_mcu7t3v3__tap_2
Xclkbuf_leaf_1_clk_regs VDD VDD VSS VSS clkbuf_3_0_0_clk_regs/Y clkload1/A gf180mcu_as_sc_mcu7t3v3__clkbuff_12
XFILLER_152_1297 VDD VDD VSS VSS gf180mcu_as_sc_mcu7t3v3__fillcap_16
XTAP_TAPCELL_ROW_183_2280 VDD VSS gf180mcu_as_sc_mcu7t3v3__tap_2
XTAP_TAPCELL_ROW_183_2291 VDD VSS gf180mcu_as_sc_mcu7t3v3__tap_2
XFILLER_146_1013 VDD VDD VSS VSS gf180mcu_as_sc_mcu7t3v3__fill_2
XFILLER_21_104 VDD VDD VSS VSS gf180mcu_as_sc_mcu7t3v3__fillcap_16
X_2984_ VDD VDD VSS VSS _3137_/B _4919_/Q _2987_/C gf180mcu_as_sc_mcu7t3v3__or2_2
X_4723_ VDD VDD VSS VSS _4723_/B _4723_/A _5262_/D gf180mcu_as_sc_mcu7t3v3__or2_2
XTAP_TAPCELL_ROW_138_1301 VDD VSS gf180mcu_as_sc_mcu7t3v3__tap_2
XFILLER_159_1418 VDD VDD VSS VSS gf180mcu_as_sc_mcu7t3v3__fillcap_16
XFILLER_175_687 VDD VDD VSS VSS gf180mcu_as_sc_mcu7t3v3__fill_2
X_4654_ VDD VDD VSS VSS _4659_/B _4654_/B _5237_/Q _5237_/D gf180mcu_as_sc_mcu7t3v3__mux2_2
XTAP_TAPCELL_ROW_134_1209 VDD VSS gf180mcu_as_sc_mcu7t3v3__tap_2
XFILLER_163_838 VDD VDD VSS VSS gf180mcu_as_sc_mcu7t3v3__fill_2
Xinput72 VDD VDD VSS VSS east_in[4] _3968_/A gf180mcu_as_sc_mcu7t3v3__buff_2
Xinput61 VDD VDD VSS VSS east_in[25] _4138_/A gf180mcu_as_sc_mcu7t3v3__buff_2
Xinput50 VDD VDD VSS VSS east_in[15] _4055_/A gf180mcu_as_sc_mcu7t3v3__buff_2
X_4585_ VDD VDD VSS VSS _4588_/C _5001_/Q _4586_/S gf180mcu_as_sc_mcu7t3v3__nand2b_2
X_3605_ VDD VDD VSS VSS _3976_/A _3726_/B _3750_/C _3976_/D _3606_/D gf180mcu_as_sc_mcu7t3v3__ao22_2
XTAP_TAPCELL_ROW_1_1_641 VDD VSS gf180mcu_as_sc_mcu7t3v3__tap_2
XTAP_TAPCELL_ROW_155_1670 VDD VSS gf180mcu_as_sc_mcu7t3v3__tap_2
XFILLER_162_348 VDD VDD VSS VSS gf180mcu_as_sc_mcu7t3v3__fillcap_8
Xinput94 VDD VDD VSS VSS ne_in[24] _4126_/A gf180mcu_as_sc_mcu7t3v3__buff_2
Xinput83 VDD VDD VSS VSS ne_in[14] _4048_/D gf180mcu_as_sc_mcu7t3v3__buff_2
X_3536_ VDD VDD VSS VSS _3790_/C _3932_/B _3537_/A gf180mcu_as_sc_mcu7t3v3__nand2_2
XFILLER_107_37 VDD VDD VSS VSS gf180mcu_as_sc_mcu7t3v3__fill_1
XFILLER_130_201 VDD VDD VSS VSS gf180mcu_as_sc_mcu7t3v3__fill_1
XFILLER_143_562 VDD VDD VSS VSS gf180mcu_as_sc_mcu7t3v3__fillcap_8
XFILLER_88_104 VDD VDD VSS VSS gf180mcu_as_sc_mcu7t3v3__fill_1
XTAP_TAPCELL_ROW_151_1589 VDD VSS gf180mcu_as_sc_mcu7t3v3__tap_2
XTAP_TAPCELL_ROW_151_1578 VDD VSS gf180mcu_as_sc_mcu7t3v3__tap_2
XFILLER_170_381 VDD VDD VSS VSS gf180mcu_as_sc_mcu7t3v3__fillcap_4
X_5206_ VDD VDD VSS VSS clkload0/A _5206_/D _5206_/Q gf180mcu_as_sc_mcu7t3v3__dfxtp_2
X_3467_ VDD VDD VSS VSS _4118_/A _3467_/B _3467_/C _4119_/A _3468_/D gf180mcu_as_sc_mcu7t3v3__ao22_2
X_3398_ VDD VDD VSS VSS _4048_/A _3474_/C _3398_/C _3398_/D _3399_/B gf180mcu_as_sc_mcu7t3v3__ao211_2
X_2418_ VDD VDD VSS VSS _3236_/A _3254_/A gf180mcu_as_sc_mcu7t3v3__inv_2
XFILLER_170_1364 VDD VDD VSS VSS gf180mcu_as_sc_mcu7t3v3__fill_1
XFILLER_170_1375 VDD VDD VSS VSS gf180mcu_as_sc_mcu7t3v3__fillcap_4
X_5137_ VDD VDD VSS VSS clkload8/A _5137_/D _5137_/Q gf180mcu_as_sc_mcu7t3v3__dfxtp_2
XFILLER_170_1397 VDD VDD VSS VSS gf180mcu_as_sc_mcu7t3v3__fill_2
X_5068_ VDD VDD VSS VSS _5183_/CLK _5068_/D _5068_/Q gf180mcu_as_sc_mcu7t3v3__dfxtp_2
XFILLER_123_69 VDD VDD VSS VSS gf180mcu_as_sc_mcu7t3v3__fill_1
XFILLER_83_18 VDD VDD VSS VSS gf180mcu_as_sc_mcu7t3v3__fill_2
X_4019_ VDD VDD VSS VSS _4019_/B _4165_/A _4239_/B gf180mcu_as_sc_mcu7t3v3__and2_2
XFILLER_168_1271 VDD VDD VSS VSS gf180mcu_as_sc_mcu7t3v3__fill_2
XFILLER_16_34 VDD VDD VSS VSS gf180mcu_as_sc_mcu7t3v3__fill_1
XFILLER_168_1293 VDD VDD VSS VSS gf180mcu_as_sc_mcu7t3v3__fill_2
XFILLER_164_1157 VDD VDD VSS VSS gf180mcu_as_sc_mcu7t3v3__fillcap_8
XFILLER_52_295 VDD VDD VSS VSS gf180mcu_as_sc_mcu7t3v3__fillcap_4
Xsram2048.u_bank1_825 VDD VDD VSS VSS sram2048.u_bank1/WEN[7] gf180mcu_as_sc_mcu7t3v3__tiel_4
XFILLER_107_1553 VDD VDD VSS VSS gf180mcu_as_sc_mcu7t3v3__fillcap_16
XFILLER_166_610 VDD VDD VSS VSS gf180mcu_as_sc_mcu7t3v3__fillcap_16
XFILLER_139_835 VDD VDD VSS VSS gf180mcu_as_sc_mcu7t3v3__fillcap_4
XFILLER_165_120 VDD VDD VSS VSS gf180mcu_as_sc_mcu7t3v3__fillcap_16
XFILLER_138_378 VDD VDD VSS VSS gf180mcu_as_sc_mcu7t3v3__fillcap_4
XFILLER_148_33 VDD VDD VSS VSS gf180mcu_as_sc_mcu7t3v3__fill_2
XFILLER_165_142 VDD VDD VSS VSS gf180mcu_as_sc_mcu7t3v3__fillcap_16
XFILLER_166_687 VDD VDD VSS VSS gf180mcu_as_sc_mcu7t3v3__fillcap_8
XFILLER_140_1190 VDD VDD VSS VSS gf180mcu_as_sc_mcu7t3v3__fillcap_4
XFILLER_154_838 VDD VDD VSS VSS gf180mcu_as_sc_mcu7t3v3__fillcap_4
XFILLER_154_849 VDD VDD VSS VSS gf180mcu_as_sc_mcu7t3v3__fillcap_8
XFILLER_180_101 VDD VDD VSS VSS gf180mcu_as_sc_mcu7t3v3__fillcap_4
XFILLER_180_123 VDD VDD VSS VSS gf180mcu_as_sc_mcu7t3v3__fillcap_16
XFILLER_181_624 VDD VDD VSS VSS gf180mcu_as_sc_mcu7t3v3__fillcap_4
XFILLER_181_646 VDD VDD VSS VSS gf180mcu_as_sc_mcu7t3v3__fillcap_4
XFILLER_106_2 VDD VDD VSS VSS gf180mcu_as_sc_mcu7t3v3__fillcap_16
XFILLER_153_348 VDD VDD VSS VSS gf180mcu_as_sc_mcu7t3v3__fill_2
XFILLER_134_562 VDD VDD VSS VSS gf180mcu_as_sc_mcu7t3v3__fillcap_16
XFILLER_121_212 VDD VDD VSS VSS gf180mcu_as_sc_mcu7t3v3__fillcap_16
XFILLER_27_1521 VDD VDD VSS VSS gf180mcu_as_sc_mcu7t3v3__fillcap_16
XFILLER_79_137 VDD VDD VSS VSS gf180mcu_as_sc_mcu7t3v3__fill_2
XFILLER_114_1502 VDD VDD VSS VSS gf180mcu_as_sc_mcu7t3v3__fillcap_16
XFILLER_94_107 VDD VDD VSS VSS gf180mcu_as_sc_mcu7t3v3__fillcap_8
XFILLER_62_1467 VDD VDD VSS VSS gf180mcu_as_sc_mcu7t3v3__fillcap_16
XFILLER_180_53 VDD VDD VSS VSS gf180mcu_as_sc_mcu7t3v3__fillcap_16
XFILLER_113_80 VDD VDD VSS VSS gf180mcu_as_sc_mcu7t3v3__fillcap_8
XFILLER_182_1213 VDD VDD VSS VSS gf180mcu_as_sc_mcu7t3v3__fillcap_4
XFILLER_143_1219 VDD VDD VSS VSS gf180mcu_as_sc_mcu7t3v3__fillcap_8
XFILLER_147_1366 VDD VDD VSS VSS gf180mcu_as_sc_mcu7t3v3__fillcap_16
XFILLER_147_1388 VDD VDD VSS VSS gf180mcu_as_sc_mcu7t3v3__fill_1
XTAP_TAPCELL_ROW_129_1_1152 VDD VSS gf180mcu_as_sc_mcu7t3v3__tap_2
XFILLER_169_470 VDD VDD VSS VSS gf180mcu_as_sc_mcu7t3v3__fillcap_4
XFILLER_157_632 VDD VDD VSS VSS gf180mcu_as_sc_mcu7t3v3__fillcap_4
XFILLER_169_492 VDD VDD VSS VSS gf180mcu_as_sc_mcu7t3v3__fill_1
XPHY_EDGE_ROW_52_1_Right_51 VDD VSS gf180mcu_as_sc_mcu7t3v3__tap_2
XFILLER_172_624 VDD VDD VSS VSS gf180mcu_as_sc_mcu7t3v3__fill_2
XFILLER_7_174 VDD VDD VSS VSS gf180mcu_as_sc_mcu7t3v3__fillcap_16
XTAP_TAPCELL_ROW_109_1_1072 VDD VSS gf180mcu_as_sc_mcu7t3v3__tap_2
XPHY_EDGE_ROW_23_1_Left_475 VDD VSS gf180mcu_as_sc_mcu7t3v3__tap_2
X_4370_ VDD VDD VSS VSS _5161_/D _4370_/C _4378_/D _4370_/A gf180mcu_as_sc_mcu7t3v3__aoi21_2
XFILLER_158_1473 VDD VDD VSS VSS gf180mcu_as_sc_mcu7t3v3__fillcap_8
X_3321_ VDD VDD VSS VSS _3973_/D _3449_/B _3321_/C _3450_/B _3323_/C gf180mcu_as_sc_mcu7t3v3__ao211_2
XFILLER_140_521 VDD VDD VSS VSS gf180mcu_as_sc_mcu7t3v3__fillcap_4
XFILLER_158_1495 VDD VDD VSS VSS gf180mcu_as_sc_mcu7t3v3__fillcap_8
XFILLER_112_267 VDD VDD VSS VSS gf180mcu_as_sc_mcu7t3v3__fill_1
XFILLER_80_1534 VDD VDD VSS VSS gf180mcu_as_sc_mcu7t3v3__fillcap_16
X_3252_ VDD VDD VSS VSS _3255_/C _3787_/A _3818_/C gf180mcu_as_sc_mcu7t3v3__and2_2
XFILLER_21_2 VDD VDD VSS VSS gf180mcu_as_sc_mcu7t3v3__fillcap_16
XFILLER_80_1556 VDD VDD VSS VSS gf180mcu_as_sc_mcu7t3v3__fillcap_8
X_3183_ VDD VDD VSS VSS _3213_/A _3199_/B _4977_/Q gf180mcu_as_sc_mcu7t3v3__nand2_2
XTAP_TAPCELL_ROW_181_2239 VDD VSS gf180mcu_as_sc_mcu7t3v3__tap_2
XTAP_TAPCELL_ROW_181_2228 VDD VSS gf180mcu_as_sc_mcu7t3v3__tap_2
XFILLER_152_1083 VDD VDD VSS VSS gf180mcu_as_sc_mcu7t3v3__fill_2
XTAP_TAPCELL_ROW_131_3_2546 VDD VSS gf180mcu_as_sc_mcu7t3v3__tap_2
XFILLER_179_212 VDD VDD VSS VSS gf180mcu_as_sc_mcu7t3v3__fillcap_16
XFILLER_165_1466 VDD VDD VSS VSS gf180mcu_as_sc_mcu7t3v3__fillcap_4
XFILLER_165_1488 VDD VDD VSS VSS gf180mcu_as_sc_mcu7t3v3__fillcap_16
XFILLER_34_295 VDD VDD VSS VSS gf180mcu_as_sc_mcu7t3v3__fillcap_4
XFILLER_147_120 VDD VDD VSS VSS gf180mcu_as_sc_mcu7t3v3__fillcap_16
XFILLER_148_632 VDD VDD VSS VSS gf180mcu_as_sc_mcu7t3v3__fillcap_16
X_2967_ VDD VDD VSS VSS _3176_/S _3947_/D _3951_/A _2969_/B gf180mcu_as_sc_mcu7t3v3__mux2_2
XTAP_TAPCELL_ROW_157_1721 VDD VSS gf180mcu_as_sc_mcu7t3v3__tap_2
XTAP_TAPCELL_ROW_157_1710 VDD VSS gf180mcu_as_sc_mcu7t3v3__tap_2
XFILLER_147_142 VDD VDD VSS VSS gf180mcu_as_sc_mcu7t3v3__fillcap_4
XFILLER_176_974 VDD VDD VSS VSS gf180mcu_as_sc_mcu7t3v3__fill_1
X_4706_ VDD VDD VSS VSS _4721_/A _4706_/B _5484_/A _4707_/A gf180mcu_as_sc_mcu7t3v3__mux2_2
X_2898_ VDD VDD VSS VSS _4977_/Q _4943_/Q _3542_/A gf180mcu_as_sc_mcu7t3v3__or2_2
XFILLER_148_687 VDD VDD VSS VSS gf180mcu_as_sc_mcu7t3v3__fill_1
XFILLER_162_101 VDD VDD VSS VSS gf180mcu_as_sc_mcu7t3v3__fillcap_4
XFILLER_163_613 VDD VDD VSS VSS gf180mcu_as_sc_mcu7t3v3__fillcap_16
X_4637_ VDD VDD VSS VSS _4688_/B _5114_/Q _5228_/Q _5228_/D gf180mcu_as_sc_mcu7t3v3__mux2_2
XTAP_TAPCELL_ROW_153_1629 VDD VSS gf180mcu_as_sc_mcu7t3v3__tap_2
XTAP_TAPCELL_ROW_153_1618 VDD VSS gf180mcu_as_sc_mcu7t3v3__tap_2
XFILLER_102_1483 VDD VDD VSS VSS gf180mcu_as_sc_mcu7t3v3__fill_1
XFILLER_135_348 VDD VDD VSS VSS gf180mcu_as_sc_mcu7t3v3__fill_2
XFILLER_159_1259 VDD VDD VSS VSS gf180mcu_as_sc_mcu7t3v3__fill_1
XFILLER_162_123 VDD VDD VSS VSS gf180mcu_as_sc_mcu7t3v3__fillcap_16
XFILLER_163_646 VDD VDD VSS VSS gf180mcu_as_sc_mcu7t3v3__fill_2
XFILLER_118_69 VDD VDD VSS VSS gf180mcu_as_sc_mcu7t3v3__fillcap_4
XFILLER_78_18 VDD VDD VSS VSS gf180mcu_as_sc_mcu7t3v3__fillcap_16
X_4568_ VDD VDD VSS VSS _4572_/B _5086_/Q _4568_/A gf180mcu_as_sc_mcu7t3v3__nand2_2
XTAP_TAPCELL_ROW_170_1987 VDD VSS gf180mcu_as_sc_mcu7t3v3__tap_2
XFILLER_103_212 VDD VDD VSS VSS gf180mcu_as_sc_mcu7t3v3__fill_2
XFILLER_137_1535 VDD VDD VSS VSS gf180mcu_as_sc_mcu7t3v3__fillcap_4
XFILLER_144_893 VDD VDD VSS VSS gf180mcu_as_sc_mcu7t3v3__fillcap_4
XFILLER_85_1467 VDD VDD VSS VSS gf180mcu_as_sc_mcu7t3v3__fillcap_16
X_4499_ VDD VDD VSS VSS _4502_/C _4991_/Q _4586_/S gf180mcu_as_sc_mcu7t3v3__nand2b_2
X_3519_ VDD VDD VSS VSS _3519_/D _3519_/A _3818_/B _3519_/C _3520_/D gf180mcu_as_sc_mcu7t3v3__ao31_2
XTAP_TAPCELL_ROW_170_1998 VDD VSS gf180mcu_as_sc_mcu7t3v3__tap_2
XFILLER_135_1270 VDD VDD VSS VSS gf180mcu_as_sc_mcu7t3v3__fillcap_4
XFILLER_170_1161 VDD VDD VSS VSS gf180mcu_as_sc_mcu7t3v3__fill_2
XFILLER_22_1451 VDD VDD VSS VSS gf180mcu_as_sc_mcu7t3v3__fillcap_16
XFILLER_150_34 VDD VDD VSS VSS gf180mcu_as_sc_mcu7t3v3__fill_1
XFILLER_27_66 VDD VDD VSS VSS gf180mcu_as_sc_mcu7t3v3__fillcap_4
XFILLER_2_1534 VDD VDD VSS VSS gf180mcu_as_sc_mcu7t3v3__fillcap_16
XFILLER_2_1556 VDD VDD VSS VSS gf180mcu_as_sc_mcu7t3v3__fillcap_8
XFILLER_183_1511 VDD VDD VSS VSS gf180mcu_as_sc_mcu7t3v3__fillcap_16
XFILLER_27_88 VDD VDD VSS VSS gf180mcu_as_sc_mcu7t3v3__fillcap_16
XTAP_TAPCELL_ROW_31_1_758 VDD VSS gf180mcu_as_sc_mcu7t3v3__tap_2
XFILLER_166_451 VDD VDD VSS VSS gf180mcu_as_sc_mcu7t3v3__fillcap_4
XFILLER_167_974 VDD VDD VSS VSS gf180mcu_as_sc_mcu7t3v3__fillcap_4
XFILLER_139_698 VDD VDD VSS VSS gf180mcu_as_sc_mcu7t3v3__fill_2
XFILLER_182_944 VDD VDD VSS VSS gf180mcu_as_sc_mcu7t3v3__fill_1
XTAP_TAPCELL_ROW_94_1_1011 VDD VSS gf180mcu_as_sc_mcu7t3v3__tap_2
XFILLER_120_1550 VDD VDD VSS VSS gf180mcu_as_sc_mcu7t3v3__fillcap_4
XFILLER_154_657 VDD VDD VSS VSS gf180mcu_as_sc_mcu7t3v3__fillcap_8
XFILLER_181_454 VDD VDD VSS VSS gf180mcu_as_sc_mcu7t3v3__fillcap_16
XFILLER_154_679 VDD VDD VSS VSS gf180mcu_as_sc_mcu7t3v3__fill_2
XFILLER_4_155 VDD VDD VSS VSS gf180mcu_as_sc_mcu7t3v3__fillcap_16
XFILLER_108_80 VDD VDD VSS VSS gf180mcu_as_sc_mcu7t3v3__fillcap_8
XFILLER_136_1001 VDD VDD VSS VSS gf180mcu_as_sc_mcu7t3v3__fill_1
XFILLER_4_177 VDD VDD VSS VSS gf180mcu_as_sc_mcu7t3v3__fillcap_16
XFILLER_4_37 VDD VDD VSS VSS gf180mcu_as_sc_mcu7t3v3__fillcap_16
XFILLER_64_1518 VDD VDD VSS VSS gf180mcu_as_sc_mcu7t3v3__fillcap_16
XFILLER_136_1045 VDD VDD VSS VSS gf180mcu_as_sc_mcu7t3v3__fillcap_8
XFILLER_150_874 VDD VDD VSS VSS gf180mcu_as_sc_mcu7t3v3__fill_1
XFILLER_7_1467 VDD VDD VSS VSS gf180mcu_as_sc_mcu7t3v3__fillcap_16
Xinput240 VDD VDD VSS VSS south_in[32] _3254_/A gf180mcu_as_sc_mcu7t3v3__buff_2
Xinput251 VDD VDD VSS VSS sw_in[11] _2433_/A gf180mcu_as_sc_mcu7t3v3__buff_2
Xinput262 VDD VDD VSS VSS sw_in[21] _4106_/A gf180mcu_as_sc_mcu7t3v3__buff_2
XFILLER_149_1406 VDD VDD VSS VSS gf180mcu_as_sc_mcu7t3v3__fill_2
XPHY_EDGE_ROW_134_Left_586 VDD VSS gf180mcu_as_sc_mcu7t3v3__tap_2
Xinput273 VDD VDD VSS VSS sw_in[31] _3515_/A gf180mcu_as_sc_mcu7t3v3__buff_2
Xinput284 VDD VDD VSS VSS west_in[10] _4013_/A gf180mcu_as_sc_mcu7t3v3__buff_2
Xinput295 VDD VDD VSS VSS west_in[20] _4093_/D gf180mcu_as_sc_mcu7t3v3__buff_2
XFILLER_149_1439 VDD VDD VSS VSS gf180mcu_as_sc_mcu7t3v3__fill_1
XFILLER_149_418 VDD VDD VSS VSS gf180mcu_as_sc_mcu7t3v3__fill_2
XFILLER_16_295 VDD VDD VSS VSS gf180mcu_as_sc_mcu7t3v3__fillcap_4
X_3870_ VDD VDD VSS VSS _4914_/D _4339_/B _4753_/A gf180mcu_as_sc_mcu7t3v3__nor2_2
XFILLER_143_1049 VDD VDD VSS VSS gf180mcu_as_sc_mcu7t3v3__fill_1
XFILLER_31_276 VDD VDD VSS VSS gf180mcu_as_sc_mcu7t3v3__fillcap_4
X_2821_ VDD VDD VSS VSS _5483_/A _2833_/A _2829_/B gf180mcu_as_sc_mcu7t3v3__and2_2
XFILLER_125_1483 VDD VDD VSS VSS gf180mcu_as_sc_mcu7t3v3__fillcap_16
XFILLER_129_142 VDD VDD VSS VSS gf180mcu_as_sc_mcu7t3v3__fillcap_16
XFILLER_31_298 VDD VDD VSS VSS gf180mcu_as_sc_mcu7t3v3__fill_2
XPHY_EDGE_ROW_143_Left_595 VDD VSS gf180mcu_as_sc_mcu7t3v3__tap_2
X_2752_ VDD VDD VSS VSS _2754_/D _4751_/A _5279_/Q gf180mcu_as_sc_mcu7t3v3__nor2b_2
XTAP_TAPCELL_ROW_174_2087 VDD VSS gf180mcu_as_sc_mcu7t3v3__tap_2
XTAP_TAPCELL_ROW_174_2076 VDD VSS gf180mcu_as_sc_mcu7t3v3__tap_2
XFILLER_145_624 VDD VDD VSS VSS gf180mcu_as_sc_mcu7t3v3__fillcap_4
XFILLER_144_134 VDD VDD VSS VSS gf180mcu_as_sc_mcu7t3v3__fillcap_8
X_4422_ VDD VDD VSS VSS _5170_/Q _4470_/B _4493_/C _5120_/Q _4423_/B gf180mcu_as_sc_mcu7t3v3__ao22_2
X_2683_ VDD VDD VSS VSS _2727_/S _2683_/B _2683_/A _2684_/C gf180mcu_as_sc_mcu7t3v3__mux2_2
XFILLER_160_616 VDD VDD VSS VSS gf180mcu_as_sc_mcu7t3v3__fillcap_8
XFILLER_173_999 VDD VDD VSS VSS gf180mcu_as_sc_mcu7t3v3__fill_2
XFILLER_141_830 VDD VDD VSS VSS gf180mcu_as_sc_mcu7t3v3__fillcap_8
XFILLER_158_1281 VDD VDD VSS VSS gf180mcu_as_sc_mcu7t3v3__fillcap_8
XFILLER_160_649 VDD VDD VSS VSS gf180mcu_as_sc_mcu7t3v3__fillcap_4
X_4353_ VDD VDD VSS VSS _4357_/C _4562_/A _4353_/A gf180mcu_as_sc_mcu7t3v3__nor2b_2
XFILLER_154_1134 VDD VDD VSS VSS gf180mcu_as_sc_mcu7t3v3__fillcap_4
X_4284_ VDD VDD VSS VSS _4289_/S _5480_/A _5118_/Q _5118_/D gf180mcu_as_sc_mcu7t3v3__mux2_2
X_3304_ VDD VDD VSS VSS _4918_/Q _3465_/B _3501_/B _3959_/A _3306_/C gf180mcu_as_sc_mcu7t3v3__ao22_2
XFILLER_45_1451 VDD VDD VSS VSS gf180mcu_as_sc_mcu7t3v3__fillcap_16
XFILLER_58_107 VDD VDD VSS VSS gf180mcu_as_sc_mcu7t3v3__fillcap_4
XFILLER_98_298 VDD VDD VSS VSS gf180mcu_as_sc_mcu7t3v3__fill_2
X_3235_ VDD VDD VSS VSS _3236_/D _3235_/B _3517_/A gf180mcu_as_sc_mcu7t3v3__nor2_2
Xmesh_tile_844 VDD VDD VSS VSS ne_out[19] gf180mcu_as_sc_mcu7t3v3__tiel_4
Xmesh_tile_833 VDD VDD VSS VSS ne_out[8] gf180mcu_as_sc_mcu7t3v3__tiel_4
XFILLER_66_151 VDD VDD VSS VSS gf180mcu_as_sc_mcu7t3v3__fill_1
Xmesh_tile_877 VDD VDD VSS VSS north_out[18] gf180mcu_as_sc_mcu7t3v3__tiel_4
Xmesh_tile_866 VDD VDD VSS VSS north_out[7] gf180mcu_as_sc_mcu7t3v3__tiel_4
Xmesh_tile_855 VDD VDD VSS VSS ne_out[30] gf180mcu_as_sc_mcu7t3v3__tiel_4
X_3166_ VDD VDD VSS VSS _3230_/S _4147_/A _3172_/C gf180mcu_as_sc_mcu7t3v3__and2_2
XFILLER_132_1498 VDD VDD VSS VSS gf180mcu_as_sc_mcu7t3v3__fill_2
Xmesh_tile_899 VDD VDD VSS VSS nw_out[6] gf180mcu_as_sc_mcu7t3v3__tiel_4
Xmesh_tile_888 VDD VDD VSS VSS north_out[29] gf180mcu_as_sc_mcu7t3v3__tiel_4
X_3097_ VDD VDD VSS VSS _3699_/D _3140_/A _3097_/B _3097_/C _3098_/C gf180mcu_as_sc_mcu7t3v3__ao31_2
XTAP_TAPCELL_ROW_146_1477 VDD VSS gf180mcu_as_sc_mcu7t3v3__tap_2
XTAP_TAPCELL_ROW_146_1466 VDD VSS gf180mcu_as_sc_mcu7t3v3__tap_2
XPHY_EDGE_ROW_78_3_Left_212 VDD VSS gf180mcu_as_sc_mcu7t3v3__tap_2
XFILLER_120_37 VDD VDD VSS VSS gf180mcu_as_sc_mcu7t3v3__fill_1
XPHY_EDGE_ROW_130_3_Left_264 VDD VSS gf180mcu_as_sc_mcu7t3v3__tap_2
XFILLER_161_1138 VDD VDD VSS VSS gf180mcu_as_sc_mcu7t3v3__fill_2
XFILLER_17_1553 VDD VDD VSS VSS gf180mcu_as_sc_mcu7t3v3__fillcap_16
X_3999_ VDD VDD VSS VSS _3999_/A _4120_/B _4120_/C _4923_/Q _4001_/C gf180mcu_as_sc_mcu7t3v3__ao22_2
XPHY_EDGE_ROW_8_1_Left_460 VDD VSS gf180mcu_as_sc_mcu7t3v3__tap_2
XFILLER_104_1534 VDD VDD VSS VSS gf180mcu_as_sc_mcu7t3v3__fillcap_16
XFILLER_104_1556 VDD VDD VSS VSS gf180mcu_as_sc_mcu7t3v3__fillcap_8
XFILLER_136_624 VDD VDD VSS VSS gf180mcu_as_sc_mcu7t3v3__fillcap_4
XFILLER_148_473 VDD VDD VSS VSS gf180mcu_as_sc_mcu7t3v3__fill_1
XFILLER_164_944 VDD VDD VSS VSS gf180mcu_as_sc_mcu7t3v3__fill_1
XFILLER_163_454 VDD VDD VSS VSS gf180mcu_as_sc_mcu7t3v3__fillcap_8
XFILLER_151_616 VDD VDD VSS VSS gf180mcu_as_sc_mcu7t3v3__fillcap_8
XFILLER_137_1332 VDD VDD VSS VSS gf180mcu_as_sc_mcu7t3v3__fillcap_16
XFILLER_1_158 VDD VDD VSS VSS gf180mcu_as_sc_mcu7t3v3__fillcap_16
XFILLER_172_1267 VDD VDD VSS VSS gf180mcu_as_sc_mcu7t3v3__fill_2
XFILLER_24_1502 VDD VDD VSS VSS gf180mcu_as_sc_mcu7t3v3__fillcap_16
XFILLER_38_10 VDD VDD VSS VSS gf180mcu_as_sc_mcu7t3v3__fill_1
XFILLER_89_276 VDD VDD VSS VSS gf180mcu_as_sc_mcu7t3v3__fillcap_4
XFILLER_89_298 VDD VDD VSS VSS gf180mcu_as_sc_mcu7t3v3__fill_2
XFILLER_38_32 VDD VDD VSS VSS gf180mcu_as_sc_mcu7t3v3__fill_2
XFILLER_24_1568 VDD VDD VSS VSS gf180mcu_as_sc_mcu7t3v3__fill_1
XFILLER_161_88 VDD VDD VSS VSS gf180mcu_as_sc_mcu7t3v3__fillcap_16
XFILLER_57_195 VDD VDD VSS VSS gf180mcu_as_sc_mcu7t3v3__fillcap_4
XPHY_EDGE_ROW_62_3_Left_196 VDD VSS gf180mcu_as_sc_mcu7t3v3__tap_2
XFILLER_54_31 VDD VDD VSS VSS gf180mcu_as_sc_mcu7t3v3__fillcap_4
XFILLER_54_53 VDD VDD VSS VSS gf180mcu_as_sc_mcu7t3v3__fill_2
XFILLER_183_1374 VDD VDD VSS VSS gf180mcu_as_sc_mcu7t3v3__fill_2
XFILLER_109_1467 VDD VDD VSS VSS gf180mcu_as_sc_mcu7t3v3__fillcap_16
XFILLER_13_276 VDD VDD VSS VSS gf180mcu_as_sc_mcu7t3v3__fillcap_4
XPHY_EDGE_ROW_161_Right_295 VDD VSS gf180mcu_as_sc_mcu7t3v3__tap_2
XTAP_TAPCELL_ROW_13_1_687 VDD VSS gf180mcu_as_sc_mcu7t3v3__tap_2
XFILLER_13_298 VDD VDD VSS VSS gf180mcu_as_sc_mcu7t3v3__fill_2
XFILLER_167_760 VDD VDD VSS VSS gf180mcu_as_sc_mcu7t3v3__fillcap_8
XTAP_TAPCELL_ROW_79_3_2468 VDD VSS gf180mcu_as_sc_mcu7t3v3__tap_2
Xclkload17 VDD VDD VSS VSS _5085_/CLK clkload17/Y gf180mcu_as_sc_mcu7t3v3__clkbuff_4
XFILLER_126_134 VDD VDD VSS VSS gf180mcu_as_sc_mcu7t3v3__fillcap_16
XFILLER_155_944 VDD VDD VSS VSS gf180mcu_as_sc_mcu7t3v3__fillcap_16
XFILLER_155_977 VDD VDD VSS VSS gf180mcu_as_sc_mcu7t3v3__fill_2
Xclkload28 VDD VDD VSS VSS _5084_/CLK clkload28/Y gf180mcu_as_sc_mcu7t3v3__clkbuff_4
XFILLER_138_1107 VDD VDD VSS VSS gf180mcu_as_sc_mcu7t3v3__fill_2
XFILLER_55_8 VDD VDD VSS VSS gf180mcu_as_sc_mcu7t3v3__fill_2
XFILLER_141_104 VDD VDD VSS VSS gf180mcu_as_sc_mcu7t3v3__fillcap_8
XFILLER_141_137 VDD VDD VSS VSS gf180mcu_as_sc_mcu7t3v3__fill_2
XFILLER_170_947 VDD VDD VSS VSS gf180mcu_as_sc_mcu7t3v3__fill_2
XFILLER_177_1189 VDD VDD VSS VSS gf180mcu_as_sc_mcu7t3v3__fill_1
XFILLER_68_1451 VDD VDD VSS VSS gf180mcu_as_sc_mcu7t3v3__fillcap_16
XFILLER_79_72 VDD VDD VSS VSS gf180mcu_as_sc_mcu7t3v3__fill_1
XFILLER_151_1329 VDD VDD VSS VSS gf180mcu_as_sc_mcu7t3v3__fill_1
XFILLER_95_279 VDD VDD VSS VSS gf180mcu_as_sc_mcu7t3v3__fill_1
X_3020_ VDD VDD VSS VSS _3121_/B _4923_/Q _3021_/D gf180mcu_as_sc_mcu7t3v3__or2_2
XFILLER_149_1203 VDD VDD VSS VSS gf180mcu_as_sc_mcu7t3v3__fillcap_16
XFILLER_63_154 VDD VDD VSS VSS gf180mcu_as_sc_mcu7t3v3__fill_2
X_4971_ VDD VDD VSS VSS _5164_/CLK _4971_/D _4971_/Q gf180mcu_as_sc_mcu7t3v3__dfxtp_2
XTAP_TAPCELL_ROW_141_1352 VDD VSS gf180mcu_as_sc_mcu7t3v3__tap_2
XFILLER_63_198 VDD VDD VSS VSS gf180mcu_as_sc_mcu7t3v3__fill_1
X_3922_ VDD VDD VSS VSS _3922_/A _3922_/B _3922_/C _3927_/B _4106_/S gf180mcu_as_sc_mcu7t3v3__ao211_2
XTAP_TAPCELL_ROW_176_2138 VDD VSS gf180mcu_as_sc_mcu7t3v3__tap_2
XTAP_TAPCELL_ROW_176_2127 VDD VSS gf180mcu_as_sc_mcu7t3v3__tap_2
XTAP_TAPCELL_ROW_141_1363 VDD VSS gf180mcu_as_sc_mcu7t3v3__tap_2
XFILLER_177_524 VDD VDD VSS VSS gf180mcu_as_sc_mcu7t3v3__fillcap_4
XFILLER_75_1499 VDD VDD VSS VSS gf180mcu_as_sc_mcu7t3v3__fillcap_16
XPHY_EDGE_ROW_151_Left_603 VDD VSS gf180mcu_as_sc_mcu7t3v3__tap_2
X_3853_ VDD VDD VSS VSS _5153_/Q _5154_/Q _3853_/C _3858_/B gf180mcu_as_sc_mcu7t3v3__nor3_2
X_2804_ VDD VDD VSS VSS _2840_/D _5227_/Q _5226_/Q gf180mcu_as_sc_mcu7t3v3__nand2_2
XFILLER_146_922 VDD VDD VSS VSS gf180mcu_as_sc_mcu7t3v3__fillcap_8
XFILLER_158_793 VDD VDD VSS VSS gf180mcu_as_sc_mcu7t3v3__fillcap_8
XFILLER_160_1182 VDD VDD VSS VSS gf180mcu_as_sc_mcu7t3v3__fill_1
X_3784_ VDD VDD VSS VSS _3794_/S _3784_/B _4164_/A _3785_/B gf180mcu_as_sc_mcu7t3v3__mux2_2
XTAP_TAPCELL_ROW_31_3_2396 VDD VSS gf180mcu_as_sc_mcu7t3v3__tap_2
XFILLER_117_134 VDD VDD VSS VSS gf180mcu_as_sc_mcu7t3v3__fillcap_4
XFILLER_146_944 VDD VDD VSS VSS gf180mcu_as_sc_mcu7t3v3__fill_1
XFILLER_146_966 VDD VDD VSS VSS gf180mcu_as_sc_mcu7t3v3__fill_1
X_2735_ VDD VDD VSS VSS _2735_/A _2735_/B _2735_/C _2735_/D _2737_/C gf180mcu_as_sc_mcu7t3v3__ao211_2
XFILLER_12_1483 VDD VDD VSS VSS gf180mcu_as_sc_mcu7t3v3__fill_1
XFILLER_145_465 VDD VDD VSS VSS gf180mcu_as_sc_mcu7t3v3__fill_2
XFILLER_160_402 VDD VDD VSS VSS gf180mcu_as_sc_mcu7t3v3__fillcap_16
XPHY_EDGE_ROW_15_1_Right_14 VDD VSS gf180mcu_as_sc_mcu7t3v3__tap_2
X_2666_ VDD VDD VSS VSS _2692_/S _2666_/B _2666_/C _2666_/D _2667_/C gf180mcu_as_sc_mcu7t3v3__ao22_2
XFILLER_132_104 VDD VDD VSS VSS gf180mcu_as_sc_mcu7t3v3__fill_1
XFILLER_172_295 VDD VDD VSS VSS gf180mcu_as_sc_mcu7t3v3__fillcap_16
X_4405_ VDD VDD VSS VSS _4405_/D _4510_/A _4405_/B _4405_/C _4406_/B gf180mcu_as_sc_mcu7t3v3__ao31_2
XFILLER_160_457 VDD VDD VSS VSS gf180mcu_as_sc_mcu7t3v3__fillcap_16
XPHY_EDGE_ROW_160_Left_612 VDD VSS gf180mcu_as_sc_mcu7t3v3__tap_2
X_4336_ VDD VDD VSS VSS _4379_/B _4565_/B _4366_/S gf180mcu_as_sc_mcu7t3v3__nand2_2
X_2597_ VDD VDD VSS VSS _5227_/Q _2597_/B _2597_/C _2597_/D _2598_/B gf180mcu_as_sc_mcu7t3v3__ao22_2
XTAP_TAPCELL_ROW_30_1_757 VDD VSS gf180mcu_as_sc_mcu7t3v3__tap_2
XFILLER_115_37 VDD VDD VSS VSS gf180mcu_as_sc_mcu7t3v3__fill_1
XFILLER_141_693 VDD VDD VSS VSS gf180mcu_as_sc_mcu7t3v3__fillcap_4
XFILLER_86_202 VDD VDD VSS VSS gf180mcu_as_sc_mcu7t3v3__fill_2
XTAP_TAPCELL_ROW_148_1506 VDD VSS gf180mcu_as_sc_mcu7t3v3__tap_2
X_4267_ VDD VDD VSS VSS _4273_/S _5479_/A _5101_/Q _5101_/D gf180mcu_as_sc_mcu7t3v3__mux2_2
XTAP_TAPCELL_ROW_148_1517 VDD VSS gf180mcu_as_sc_mcu7t3v3__tap_2
X_4198_ VDD VDD VSS VSS _4198_/Y _4908_/Q _4198_/A gf180mcu_as_sc_mcu7t3v3__nor2b_2
X_3218_ VDD VDD VSS VSS _3219_/B _3218_/C _3218_/B _3803_/A gf180mcu_as_sc_mcu7t3v3__aoi21_2
X_3149_ VDD VDD VSS VSS _4124_/A _3149_/B _3149_/C _4794_/D _3746_/D gf180mcu_as_sc_mcu7t3v3__aoi211_2
XTAP_TAPCELL_ROW_165_1886 VDD VSS gf180mcu_as_sc_mcu7t3v3__tap_2
XFILLER_131_36 VDD VDD VSS VSS gf180mcu_as_sc_mcu7t3v3__fill_2
XFILLER_54_143 VDD VDD VSS VSS gf180mcu_as_sc_mcu7t3v3__fill_2
XFILLER_94_290 VDD VDD VSS VSS gf180mcu_as_sc_mcu7t3v3__fillcap_8
XTAP_TAPCELL_ROW_165_1897 VDD VSS gf180mcu_as_sc_mcu7t3v3__tap_2
XFILLER_131_69 VDD VDD VSS VSS gf180mcu_as_sc_mcu7t3v3__fill_1
XPHY_EDGE_ROW_48_1_Left_500 VDD VSS gf180mcu_as_sc_mcu7t3v3__tap_2
XPHY_EDGE_ROW_100_1_Left_552 VDD VSS gf180mcu_as_sc_mcu7t3v3__tap_2
XFILLER_24_34 VDD VDD VSS VSS gf180mcu_as_sc_mcu7t3v3__fill_1
XFILLER_156_719 VDD VDD VSS VSS gf180mcu_as_sc_mcu7t3v3__fillcap_16
XFILLER_168_579 VDD VDD VSS VSS gf180mcu_as_sc_mcu7t3v3__fillcap_8
XFILLER_136_410 VDD VDD VSS VSS gf180mcu_as_sc_mcu7t3v3__fillcap_4
XFILLER_108_123 VDD VDD VSS VSS gf180mcu_as_sc_mcu7t3v3__fillcap_16
XFILLER_136_465 VDD VDD VSS VSS gf180mcu_as_sc_mcu7t3v3__fillcap_4
XFILLER_151_402 VDD VDD VSS VSS gf180mcu_as_sc_mcu7t3v3__fillcap_8
XFILLER_152_914 VDD VDD VSS VSS gf180mcu_as_sc_mcu7t3v3__fillcap_16
XFILLER_163_251 VDD VDD VSS VSS gf180mcu_as_sc_mcu7t3v3__fill_2
XFILLER_178_1443 VDD VDD VSS VSS gf180mcu_as_sc_mcu7t3v3__fill_2
XFILLER_30_1550 VDD VDD VSS VSS gf180mcu_as_sc_mcu7t3v3__fillcap_4
XFILLER_152_947 VDD VDD VSS VSS gf180mcu_as_sc_mcu7t3v3__fill_2
XFILLER_178_1498 VDD VDD VSS VSS gf180mcu_as_sc_mcu7t3v3__fillcap_4
XFILLER_137_1162 VDD VDD VSS VSS gf180mcu_as_sc_mcu7t3v3__fill_1
XFILLER_172_1053 VDD VDD VSS VSS gf180mcu_as_sc_mcu7t3v3__fill_2
XFILLER_172_65 VDD VDD VSS VSS gf180mcu_as_sc_mcu7t3v3__fillcap_16
XFILLER_77_246 VDD VDD VSS VSS gf180mcu_as_sc_mcu7t3v3__fillcap_16
Xfanout760 VDD VDD VSS VSS _4511_/A _4581_/A gf180mcu_as_sc_mcu7t3v3__buff_2
XFILLER_77_279 VDD VDD VSS VSS gf180mcu_as_sc_mcu7t3v3__fill_1
Xfanout771 VDD VDD VSS VSS _4568_/A _4579_/S gf180mcu_as_sc_mcu7t3v3__buff_2
Xfanout782 VDD VDD VSS VSS _2701_/A _2692_/S gf180mcu_as_sc_mcu7t3v3__buff_2
Xfanout793 VDD VDD VSS VSS _2716_/A _2730_/A gf180mcu_as_sc_mcu7t3v3__buff_2
XTAP_TAPCELL_ROW_6_1_659 VDD VSS gf180mcu_as_sc_mcu7t3v3__tap_2
XFILLER_105_92 VDD VDD VSS VSS gf180mcu_as_sc_mcu7t3v3__fill_2
XPHY_EDGE_ROW_61_1_Right_60 VDD VSS gf180mcu_as_sc_mcu7t3v3__tap_2
XPHY_EDGE_ROW_32_1_Left_484 VDD VSS gf180mcu_as_sc_mcu7t3v3__tap_2
XFILLER_45_198 VDD VDD VSS VSS gf180mcu_as_sc_mcu7t3v3__fill_1
XFILLER_60_146 VDD VDD VSS VSS gf180mcu_as_sc_mcu7t3v3__fill_2
XFILLER_183_1160 VDD VDD VSS VSS gf180mcu_as_sc_mcu7t3v3__fill_2
XFILLER_159_557 VDD VDD VSS VSS gf180mcu_as_sc_mcu7t3v3__fill_2
XFILLER_174_527 VDD VDD VSS VSS gf180mcu_as_sc_mcu7t3v3__fillcap_8
XFILLER_35_1483 VDD VDD VSS VSS gf180mcu_as_sc_mcu7t3v3__fillcap_16
XTAP_TAPCELL_ROW_171_2024 VDD VSS gf180mcu_as_sc_mcu7t3v3__tap_2
XTAP_TAPCELL_ROW_171_2013 VDD VSS gf180mcu_as_sc_mcu7t3v3__tap_2
XFILLER_122_1486 VDD VDD VSS VSS gf180mcu_as_sc_mcu7t3v3__fillcap_16
XFILLER_154_251 VDD VDD VSS VSS gf180mcu_as_sc_mcu7t3v3__fill_1
X_2520_ VDD VDD VSS VSS _2797_/A _2545_/B gf180mcu_as_sc_mcu7t3v3__inv_2
XFILLER_114_104 VDD VDD VSS VSS gf180mcu_as_sc_mcu7t3v3__fill_1
XFILLER_114_115 VDD VDD VSS VSS gf180mcu_as_sc_mcu7t3v3__fill_1
XFILLER_142_424 VDD VDD VSS VSS gf180mcu_as_sc_mcu7t3v3__fillcap_8
XFILLER_157_1527 VDD VDD VSS VSS gf180mcu_as_sc_mcu7t3v3__fillcap_8
X_2451_ VDD VDD VSS VSS _2832_/B _2451_/A gf180mcu_as_sc_mcu7t3v3__inv_2
XFILLER_142_457 VDD VDD VSS VSS gf180mcu_as_sc_mcu7t3v3__fillcap_8
XFILLER_155_1240 VDD VDD VSS VSS gf180mcu_as_sc_mcu7t3v3__fill_2
XFILLER_170_777 VDD VDD VSS VSS gf180mcu_as_sc_mcu7t3v3__fillcap_8
XFILLER_155_1262 VDD VDD VSS VSS gf180mcu_as_sc_mcu7t3v3__fillcap_8
X_5170_ VDD VDD VSS VSS _5183_/CLK _5170_/D _5170_/Q gf180mcu_as_sc_mcu7t3v3__dfxtp_2
X_4121_ VDD VDD VSS VSS _4121_/A _4121_/B _4121_/C _4121_/D _4122_/D gf180mcu_as_sc_mcu7t3v3__ao22_2
XFILLER_68_257 VDD VDD VSS VSS gf180mcu_as_sc_mcu7t3v3__fill_1
X_4052_ VDD VDD VSS VSS _4992_/Q _4117_/B _4243_/B _4108_/D _4992_/D gf180mcu_as_sc_mcu7t3v3__ao22_2
Xinput4 VDD VDD VSS VSS boot_addr[2] input4/Y gf180mcu_as_sc_mcu7t3v3__buff_2
X_3003_ VDD VDD VSS VSS _3121_/B _4921_/Q _3004_/D gf180mcu_as_sc_mcu7t3v3__or2_2
XTAP_TAPCELL_ROW_143_1403 VDD VSS gf180mcu_as_sc_mcu7t3v3__tap_2
XFILLER_149_1033 VDD VDD VSS VSS gf180mcu_as_sc_mcu7t3v3__fill_1
XFILLER_51_102 VDD VDD VSS VSS gf180mcu_as_sc_mcu7t3v3__fillcap_4
XFILLER_149_1088 VDD VDD VSS VSS gf180mcu_as_sc_mcu7t3v3__fillcap_16
XFILLER_178_800 VDD VDD VSS VSS gf180mcu_as_sc_mcu7t3v3__fillcap_4
X_4954_ VDD VDD VSS VSS _5199_/CLK _4954_/D _4954_/Q gf180mcu_as_sc_mcu7t3v3__dfxtp_2
XTAP_TAPCELL_ROW_160_1783 VDD VSS gf180mcu_as_sc_mcu7t3v3__tap_2
XTAP_TAPCELL_ROW_160_1772 VDD VSS gf180mcu_as_sc_mcu7t3v3__tap_2
XFILLER_166_1391 VDD VDD VSS VSS gf180mcu_as_sc_mcu7t3v3__fillcap_16
X_3905_ VDD VDD VSS VSS _3905_/B _5164_/Q _4945_/D gf180mcu_as_sc_mcu7t3v3__and2_2
X_4885_ VDD VDD VSS VSS _4914_/CLK _4885_/D _4885_/Q gf180mcu_as_sc_mcu7t3v3__dfxtp_2
XTAP_TAPCELL_ROW_128_1_1148 VDD VSS gf180mcu_as_sc_mcu7t3v3__tap_2
XFILLER_14_1534 VDD VDD VSS VSS gf180mcu_as_sc_mcu7t3v3__fillcap_16
X_3836_ VDD VDD VSS VSS _3838_/B _3843_/B _3845_/A gf180mcu_as_sc_mcu7t3v3__nand2_2
XFILLER_101_1515 VDD VDD VSS VSS gf180mcu_as_sc_mcu7t3v3__fillcap_4
XFILLER_14_1556 VDD VDD VSS VSS gf180mcu_as_sc_mcu7t3v3__fillcap_8
XFILLER_165_549 VDD VDD VSS VSS gf180mcu_as_sc_mcu7t3v3__fillcap_4
X_3767_ VDD VDD VSS VSS _3794_/S _3767_/B _4148_/A _3768_/B gf180mcu_as_sc_mcu7t3v3__mux2_2
XFILLER_101_1537 VDD VDD VSS VSS gf180mcu_as_sc_mcu7t3v3__fillcap_16
XFILLER_146_785 VDD VDD VSS VSS gf180mcu_as_sc_mcu7t3v3__fill_2
XFILLER_180_508 VDD VDD VSS VSS gf180mcu_as_sc_mcu7t3v3__fillcap_16
X_2718_ VDD VDD VSS VSS _4975_/Q _4962_/Q _4971_/Q _2720_/A gf180mcu_as_sc_mcu7t3v3__mux2_2
XFILLER_134_936 VDD VDD VSS VSS gf180mcu_as_sc_mcu7t3v3__fillcap_16
XFILLER_134_958 VDD VDD VSS VSS gf180mcu_as_sc_mcu7t3v3__fill_1
XFILLER_145_295 VDD VDD VSS VSS gf180mcu_as_sc_mcu7t3v3__fillcap_8
XFILLER_161_733 VDD VDD VSS VSS gf180mcu_as_sc_mcu7t3v3__fill_1
X_3698_ VDD VDD VSS VSS _3699_/C _3698_/C _3729_/B _4073_/A gf180mcu_as_sc_mcu7t3v3__aoi21_2
XTAP_TAPCELL_ROW_108_1_1068 VDD VSS gf180mcu_as_sc_mcu7t3v3__tap_2
XFILLER_10_69 VDD VDD VSS VSS gf180mcu_as_sc_mcu7t3v3__fillcap_16
XFILLER_126_14 VDD VDD VSS VSS gf180mcu_as_sc_mcu7t3v3__fill_1
Xoutput352 VDD VDD VSS VSS _4842_/Q east_out[3] gf180mcu_as_sc_mcu7t3v3__buff_2
Xoutput341 VDD VDD VSS VSS _4863_/Q east_out[24] gf180mcu_as_sc_mcu7t3v3__buff_2
Xoutput330 VDD VDD VSS VSS _4853_/Q east_out[14] gf180mcu_as_sc_mcu7t3v3__buff_2
X_2649_ VDD VDD VSS VSS _2666_/B _2649_/B _2649_/C _2729_/B _2650_/D gf180mcu_as_sc_mcu7t3v3__ao211_2
XFILLER_120_118 VDD VDD VSS VSS gf180mcu_as_sc_mcu7t3v3__fillcap_4
XFILLER_161_788 VDD VDD VSS VSS gf180mcu_as_sc_mcu7t3v3__fillcap_16
XFILLER_86_18 VDD VDD VSS VSS gf180mcu_as_sc_mcu7t3v3__fillcap_16
Xoutput396 VDD VDD VSS VSS _4817_/Q south_out[12] gf180mcu_as_sc_mcu7t3v3__buff_2
Xoutput385 VDD VDD VSS VSS _4804_/Q se_out[33] gf180mcu_as_sc_mcu7t3v3__buff_2
Xoutput374 VDD VDD VSS VSS _4794_/Q se_out[23] gf180mcu_as_sc_mcu7t3v3__buff_2
Xoutput363 VDD VDD VSS VSS _4784_/Q se_out[13] gf180mcu_as_sc_mcu7t3v3__buff_2
X_4319_ VDD VDD VSS VSS _4321_/S _5149_/Q _5148_/Q _5148_/D gf180mcu_as_sc_mcu7t3v3__mux2_2
XTAP_TAPCELL_ROW_167_1937 VDD VSS gf180mcu_as_sc_mcu7t3v3__tap_2
XTAP_TAPCELL_ROW_167_1926 VDD VSS gf180mcu_as_sc_mcu7t3v3__tap_2
XFILLER_19_34 VDD VDD VSS VSS gf180mcu_as_sc_mcu7t3v3__fillcap_16
XFILLER_59_279 VDD VDD VSS VSS gf180mcu_as_sc_mcu7t3v3__fill_1
Xclkbuf_leaf_25_clk_regs VDD VDD VSS VSS clkbuf_3_7_0_clk_regs/Y _5084_/CLK gf180mcu_as_sc_mcu7t3v3__clkbuff_12
XFILLER_169_1409 VDD VDD VSS VSS gf180mcu_as_sc_mcu7t3v3__fillcap_16
XFILLER_167_1100 VDD VDD VSS VSS gf180mcu_as_sc_mcu7t3v3__fillcap_8
XTAP_TAPCELL_ROW_2_1_643 VDD VSS gf180mcu_as_sc_mcu7t3v3__tap_2
XFILLER_167_1122 VDD VDD VSS VSS gf180mcu_as_sc_mcu7t3v3__fillcap_4
XFILLER_35_88 VDD VDD VSS VSS gf180mcu_as_sc_mcu7t3v3__fillcap_16
XFILLER_58_1483 VDD VDD VSS VSS gf180mcu_as_sc_mcu7t3v3__fill_1
XFILLER_145_1453 VDD VDD VSS VSS gf180mcu_as_sc_mcu7t3v3__fillcap_4
XFILLER_19_1467 VDD VDD VSS VSS gf180mcu_as_sc_mcu7t3v3__fillcap_16
XFILLER_136_2 VDD VDD VSS VSS gf180mcu_as_sc_mcu7t3v3__fillcap_8
XFILLER_168_365 VDD VDD VSS VSS gf180mcu_as_sc_mcu7t3v3__fillcap_16
XFILLER_168_387 VDD VDD VSS VSS gf180mcu_as_sc_mcu7t3v3__fillcap_16
XFILLER_51_32 VDD VDD VSS VSS gf180mcu_as_sc_mcu7t3v3__fillcap_4
XFILLER_183_346 VDD VDD VSS VSS gf180mcu_as_sc_mcu7t3v3__fillcap_4
XFILLER_171_519 VDD VDD VSS VSS gf180mcu_as_sc_mcu7t3v3__fill_1
XFILLER_183_368 VDD VDD VSS VSS gf180mcu_as_sc_mcu7t3v3__fillcap_16
Xwire479 VDD VDD VSS VSS _2723_/Y wire479/Y gf180mcu_as_sc_mcu7t3v3__buff_8
XFILLER_139_1202 VDD VDD VSS VSS gf180mcu_as_sc_mcu7t3v3__fillcap_16
XPHY_EDGE_ROW_20_3_Right_339 VDD VSS gf180mcu_as_sc_mcu7t3v3__tap_2
XFILLER_136_295 VDD VDD VSS VSS gf180mcu_as_sc_mcu7t3v3__fillcap_8
XFILLER_139_1257 VDD VDD VSS VSS gf180mcu_as_sc_mcu7t3v3__fill_2
XFILLER_152_755 VDD VDD VSS VSS gf180mcu_as_sc_mcu7t3v3__fillcap_8
XFILLER_152_777 VDD VDD VSS VSS gf180mcu_as_sc_mcu7t3v3__fillcap_8
XFILLER_174_1137 VDD VDD VSS VSS gf180mcu_as_sc_mcu7t3v3__fillcap_4
XFILLER_151_276 VDD VDD VSS VSS gf180mcu_as_sc_mcu7t3v3__fillcap_4
XFILLER_152_799 VDD VDD VSS VSS gf180mcu_as_sc_mcu7t3v3__fillcap_4
XFILLER_183_64 VDD VDD VSS VSS gf180mcu_as_sc_mcu7t3v3__fillcap_4
XFILLER_151_298 VDD VDD VSS VSS gf180mcu_as_sc_mcu7t3v3__fillcap_8
Xfanout590 VDD VDD VSS VSS _2831_/A _2653_/S gf180mcu_as_sc_mcu7t3v3__buff_2
XFILLER_73_282 VDD VDD VSS VSS gf180mcu_as_sc_mcu7t3v3__fillcap_16
XFILLER_76_1550 VDD VDD VSS VSS gf180mcu_as_sc_mcu7t3v3__fillcap_4
XFILLER_163_1520 VDD VDD VSS VSS gf180mcu_as_sc_mcu7t3v3__fillcap_16
XFILLER_163_1542 VDD VDD VSS VSS gf180mcu_as_sc_mcu7t3v3__fillcap_16
XFILLER_178_107 VDD VDD VSS VSS gf180mcu_as_sc_mcu7t3v3__fillcap_16
XPHY_EDGE_ROW_25_3_Left_159 VDD VSS gf180mcu_as_sc_mcu7t3v3__tap_2
XFILLER_147_527 VDD VDD VSS VSS gf180mcu_as_sc_mcu7t3v3__fill_2
X_4670_ VDD VDD VSS VSS _5242_/D _5242_/Q _4685_/C _4670_/C gf180mcu_as_sc_mcu7t3v3__ao21_2
XFILLER_175_869 VDD VDD VSS VSS gf180mcu_as_sc_mcu7t3v3__fill_1
X_3621_ VDD VDD VSS VSS _3992_/A _3792_/B _3621_/C _3621_/D _3622_/C gf180mcu_as_sc_mcu7t3v3__ao211_2
X_3552_ VDD VDD VSS VSS _3801_/B _3561_/A gf180mcu_as_sc_mcu7t3v3__inv_2
XTAP_TAPCELL_ROW_93_1_1007 VDD VSS gf180mcu_as_sc_mcu7t3v3__tap_2
XTAP_TAPCELL_ROW_136_1251 VDD VSS gf180mcu_as_sc_mcu7t3v3__tap_2
XTAP_TAPCELL_ROW_136_1240 VDD VSS gf180mcu_as_sc_mcu7t3v3__tap_2
XFILLER_157_1313 VDD VDD VSS VSS gf180mcu_as_sc_mcu7t3v3__fillcap_16
XFILLER_51_2 VDD VDD VSS VSS gf180mcu_as_sc_mcu7t3v3__fill_2
X_2503_ VDD VDD VSS VSS _2546_/B _2503_/B _5189_/Q gf180mcu_as_sc_mcu7t3v3__nand2_2
XPHY_EDGE_ROW_87_3_Left_221 VDD VSS gf180mcu_as_sc_mcu7t3v3__tap_2
XFILLER_83_1521 VDD VDD VSS VSS gf180mcu_as_sc_mcu7t3v3__fillcap_16
X_3483_ VDD VDD VSS VSS _3505_/S _3483_/B _3483_/A _3484_/B gf180mcu_as_sc_mcu7t3v3__mux2_2
XFILLER_102_107 VDD VDD VSS VSS gf180mcu_as_sc_mcu7t3v3__fillcap_4
XFILLER_142_287 VDD VDD VSS VSS gf180mcu_as_sc_mcu7t3v3__fill_1
XFILLER_143_788 VDD VDD VSS VSS gf180mcu_as_sc_mcu7t3v3__fillcap_8
X_5222_ VDD VDD VSS VSS clkload6/A _5222_/D _5222_/Q gf180mcu_as_sc_mcu7t3v3__dfxtp_2
X_2434_ VDD VDD VSS VSS _3661_/A _4034_/A gf180mcu_as_sc_mcu7t3v3__inv_2
X_5153_ VDD VDD VSS VSS clkload8/A _5153_/D _5153_/Q gf180mcu_as_sc_mcu7t3v3__dfxtp_2
X_4104_ VDD VDD VSS VSS _4104_/A _4104_/B _4104_/C _4104_/D _4105_/D gf180mcu_as_sc_mcu7t3v3__ao22_2
X_5084_ VDD VDD VSS VSS _5084_/CLK _5084_/D _5084_/Q gf180mcu_as_sc_mcu7t3v3__dfxtp_2
X_4035_ VDD VDD VSS VSS _4035_/B _4059_/A _4241_/B gf180mcu_as_sc_mcu7t3v3__and2_2
XTAP_TAPCELL_ROW_162_1823 VDD VSS gf180mcu_as_sc_mcu7t3v3__tap_2
XTAP_TAPCELL_ROW_162_1812 VDD VSS gf180mcu_as_sc_mcu7t3v3__tap_2
XFILLER_168_1431 VDD VDD VSS VSS gf180mcu_as_sc_mcu7t3v3__fillcap_4
X_4937_ VDD VDD VSS VSS _5084_/CLK _4937_/D _4937_/Q gf180mcu_as_sc_mcu7t3v3__dfxtp_2
XFILLER_138_527 VDD VDD VSS VSS gf180mcu_as_sc_mcu7t3v3__fillcap_16
X_4868_ VDD VDD VSS VSS _4869_/CLK _4868_/D _4868_/Q gf180mcu_as_sc_mcu7t3v3__dfxtp_2
XFILLER_165_335 VDD VDD VSS VSS gf180mcu_as_sc_mcu7t3v3__fillcap_8
X_3819_ VDD VDD VSS VSS _3927_/A _3920_/B _3929_/B _3922_/C _3820_/B gf180mcu_as_sc_mcu7t3v3__nand4_2
XFILLER_140_1361 VDD VDD VSS VSS gf180mcu_as_sc_mcu7t3v3__fillcap_4
XFILLER_153_508 VDD VDD VSS VSS gf180mcu_as_sc_mcu7t3v3__fillcap_8
XFILLER_165_368 VDD VDD VSS VSS gf180mcu_as_sc_mcu7t3v3__fillcap_16
X_4799_ VDD VDD VSS VSS _4867_/CLK _4799_/D _4799_/Q gf180mcu_as_sc_mcu7t3v3__dfxtp_2
XFILLER_140_1394 VDD VDD VSS VSS gf180mcu_as_sc_mcu7t3v3__fillcap_16
XFILLER_146_571 VDD VDD VSS VSS gf180mcu_as_sc_mcu7t3v3__fill_2
XFILLER_175_1402 VDD VDD VSS VSS gf180mcu_as_sc_mcu7t3v3__fill_2
XFILLER_118_295 VDD VDD VSS VSS gf180mcu_as_sc_mcu7t3v3__fillcap_4
XFILLER_180_349 VDD VDD VSS VSS gf180mcu_as_sc_mcu7t3v3__fillcap_16
XFILLER_134_777 VDD VDD VSS VSS gf180mcu_as_sc_mcu7t3v3__fillcap_4
XFILLER_134_788 VDD VDD VSS VSS gf180mcu_as_sc_mcu7t3v3__fill_2
XFILLER_161_574 VDD VDD VSS VSS gf180mcu_as_sc_mcu7t3v3__fill_2
XFILLER_133_298 VDD VDD VSS VSS gf180mcu_as_sc_mcu7t3v3__fill_2
XFILLER_153_34 VDD VDD VSS VSS gf180mcu_as_sc_mcu7t3v3__fillcap_16
XFILLER_173_1192 VDD VDD VSS VSS gf180mcu_as_sc_mcu7t3v3__fill_2
XFILLER_46_10 VDD VDD VSS VSS gf180mcu_as_sc_mcu7t3v3__fill_1
XFILLER_5_1521 VDD VDD VSS VSS gf180mcu_as_sc_mcu7t3v3__fillcap_16
XFILLER_169_1228 VDD VDD VSS VSS gf180mcu_as_sc_mcu7t3v3__fillcap_16
XFILLER_46_32 VDD VDD VSS VSS gf180mcu_as_sc_mcu7t3v3__fill_2
XFILLER_99_1561 VDD VDD VSS VSS gf180mcu_as_sc_mcu7t3v3__fillcap_4
XFILLER_147_1526 VDD VDD VSS VSS gf180mcu_as_sc_mcu7t3v3__fillcap_8
XFILLER_55_282 VDD VDD VSS VSS gf180mcu_as_sc_mcu7t3v3__fillcap_16
XFILLER_182_1428 VDD VDD VSS VSS gf180mcu_as_sc_mcu7t3v3__fill_2
XFILLER_145_1250 VDD VDD VSS VSS gf180mcu_as_sc_mcu7t3v3__fill_2
XFILLER_178_53 VDD VDD VSS VSS gf180mcu_as_sc_mcu7t3v3__fillcap_16
XFILLER_180_1152 VDD VDD VSS VSS gf180mcu_as_sc_mcu7t3v3__fill_2
XFILLER_23_190 VDD VDD VSS VSS gf180mcu_as_sc_mcu7t3v3__fillcap_16
XFILLER_62_86 VDD VDD VSS VSS gf180mcu_as_sc_mcu7t3v3__fillcap_4
XFILLER_184_622 VDD VDD VSS VSS gf180mcu_as_sc_mcu7t3v3__fillcap_4
XFILLER_172_839 VDD VDD VSS VSS gf180mcu_as_sc_mcu7t3v3__fill_2
XFILLER_183_176 VDD VDD VSS VSS gf180mcu_as_sc_mcu7t3v3__fillcap_16
XFILLER_32_1486 VDD VDD VSS VSS gf180mcu_as_sc_mcu7t3v3__fillcap_16
XFILLER_124_243 VDD VDD VSS VSS gf180mcu_as_sc_mcu7t3v3__fill_2
XFILLER_180_894 VDD VDD VSS VSS gf180mcu_as_sc_mcu7t3v3__fill_1
XFILLER_139_1098 VDD VDD VSS VSS gf180mcu_as_sc_mcu7t3v3__fillcap_16
XFILLER_97_138 VDD VDD VSS VSS gf180mcu_as_sc_mcu7t3v3__fill_2
XTAP_TAPCELL_ROW_40_1_795 VDD VSS gf180mcu_as_sc_mcu7t3v3__tap_2
XFILLER_87_72 VDD VDD VSS VSS gf180mcu_as_sc_mcu7t3v3__fillcap_16
XFILLER_152_1265 VDD VDD VSS VSS gf180mcu_as_sc_mcu7t3v3__fillcap_4
XFILLER_93_300 VDD VDD VSS VSS gf180mcu_as_sc_mcu7t3v3__fill_1
XTAP_TAPCELL_ROW_183_2292 VDD VSS gf180mcu_as_sc_mcu7t3v3__tap_2
XTAP_TAPCELL_ROW_183_2281 VDD VSS gf180mcu_as_sc_mcu7t3v3__tap_2
XFILLER_53_208 VDD VDD VSS VSS gf180mcu_as_sc_mcu7t3v3__fill_2
XFILLER_146_1025 VDD VDD VSS VSS gf180mcu_as_sc_mcu7t3v3__fillcap_4
XFILLER_179_416 VDD VDD VSS VSS gf180mcu_as_sc_mcu7t3v3__fillcap_4
XFILLER_179_438 VDD VDD VSS VSS gf180mcu_as_sc_mcu7t3v3__fillcap_16
XPHY_EDGE_ROW_24_1_Right_23 VDD VSS gf180mcu_as_sc_mcu7t3v3__tap_2
XFILLER_99_2 VDD VDD VSS VSS gf180mcu_as_sc_mcu7t3v3__fillcap_8
X_2983_ VDD VDD VSS VSS _3143_/S _3965_/D _3968_/A _2986_/B gf180mcu_as_sc_mcu7t3v3__mux2_2
XFILLER_148_803 VDD VDD VSS VSS gf180mcu_as_sc_mcu7t3v3__fill_2
X_4722_ VDD VDD VSS VSS _5263_/Q _4730_/B _4730_/C _5262_/Q _4723_/B gf180mcu_as_sc_mcu7t3v3__ao22_2
XTAP_TAPCELL_ROW_138_1302 VDD VSS gf180mcu_as_sc_mcu7t3v3__tap_2
XFILLER_11_1515 VDD VDD VSS VSS gf180mcu_as_sc_mcu7t3v3__fillcap_4
XFILLER_147_368 VDD VDD VSS VSS gf180mcu_as_sc_mcu7t3v3__fillcap_4
XFILLER_50_1564 VDD VDD VSS VSS gf180mcu_as_sc_mcu7t3v3__fillcap_4
Xinput40 VDD VDD VSS VSS dft_wdata[5] _2723_/B gf180mcu_as_sc_mcu7t3v3__buff_2
X_4653_ VDD VDD VSS VSS _4653_/B _4657_/B _4654_/B gf180mcu_as_sc_mcu7t3v3__or2_2
XFILLER_11_1537 VDD VDD VSS VSS gf180mcu_as_sc_mcu7t3v3__fillcap_16
Xinput73 VDD VDD VSS VSS east_in[5] _3975_/A gf180mcu_as_sc_mcu7t3v3__buff_2
Xinput62 VDD VDD VSS VSS east_in[26] _4145_/A gf180mcu_as_sc_mcu7t3v3__buff_2
Xinput51 VDD VDD VSS VSS east_in[16] _4063_/A gf180mcu_as_sc_mcu7t3v3__buff_2
X_4584_ VDD VDD VSS VSS _4588_/B _5088_/Q _4586_/S gf180mcu_as_sc_mcu7t3v3__nand2_2
X_3604_ VDD VDD VSS VSS _3975_/A _3716_/B _3604_/C _3604_/D _3606_/C gf180mcu_as_sc_mcu7t3v3__ao211_2
XTAP_TAPCELL_ROW_155_1671 VDD VSS gf180mcu_as_sc_mcu7t3v3__tap_2
XTAP_TAPCELL_ROW_155_1660 VDD VSS gf180mcu_as_sc_mcu7t3v3__tap_2
Xinput95 VDD VDD VSS VSS ne_in[25] _4135_/A gf180mcu_as_sc_mcu7t3v3__buff_2
Xinput84 VDD VDD VSS VSS ne_in[15] _4056_/D gf180mcu_as_sc_mcu7t3v3__buff_2
X_3535_ VDD VDD VSS VSS _3799_/A _3932_/B _3535_/A gf180mcu_as_sc_mcu7t3v3__nand2_2
XFILLER_107_27 VDD VDD VSS VSS gf180mcu_as_sc_mcu7t3v3__fillcap_8
X_3466_ VDD VDD VSS VSS _4121_/D _3466_/B _3466_/C _3466_/D _3468_/C gf180mcu_as_sc_mcu7t3v3__ao211_2
XTAP_TAPCELL_ROW_151_1579 VDD VSS gf180mcu_as_sc_mcu7t3v3__tap_2
XTAP_TAPCELL_ROW_151_1568 VDD VSS gf180mcu_as_sc_mcu7t3v3__tap_2
XFILLER_115_298 VDD VDD VSS VSS gf180mcu_as_sc_mcu7t3v3__fill_2
X_5205_ VDD VDD VSS VSS clkload3/A _5205_/D _5205_/Q gf180mcu_as_sc_mcu7t3v3__dfxtp_2
X_2417_ VDD VDD VSS VSS _3224_/D _3510_/A gf180mcu_as_sc_mcu7t3v3__inv_2
XFILLER_170_1321 VDD VDD VSS VSS gf180mcu_as_sc_mcu7t3v3__fill_2
X_3397_ VDD VDD VSS VSS _4048_/D _3474_/B _3523_/B _4049_/A _3398_/D gf180mcu_as_sc_mcu7t3v3__ao22_2
XFILLER_84_300 VDD VDD VSS VSS gf180mcu_as_sc_mcu7t3v3__fill_1
XFILLER_96_160 VDD VDD VSS VSS gf180mcu_as_sc_mcu7t3v3__fillcap_8
X_5136_ VDD VDD VSS VSS clkload8/A _5136_/D _5136_/Q gf180mcu_as_sc_mcu7t3v3__dfxtp_2
X_5067_ VDD VDD VSS VSS _5172_/CLK _5067_/D _5067_/Q gf180mcu_as_sc_mcu7t3v3__dfxtp_2
XFILLER_37_260 VDD VDD VSS VSS gf180mcu_as_sc_mcu7t3v3__fillcap_16
X_4018_ VDD VDD VSS VSS _4050_/S _4018_/B _4018_/A _4019_/B gf180mcu_as_sc_mcu7t3v3__mux2_2
XFILLER_37_282 VDD VDD VSS VSS gf180mcu_as_sc_mcu7t3v3__fillcap_16
XFILLER_164_1103 VDD VDD VSS VSS gf180mcu_as_sc_mcu7t3v3__fillcap_4
XFILLER_164_1169 VDD VDD VSS VSS gf180mcu_as_sc_mcu7t3v3__fill_1
XFILLER_107_1521 VDD VDD VSS VSS gf180mcu_as_sc_mcu7t3v3__fillcap_16
XFILLER_138_302 VDD VDD VSS VSS gf180mcu_as_sc_mcu7t3v3__fillcap_8
XFILLER_181_1472 VDD VDD VSS VSS gf180mcu_as_sc_mcu7t3v3__fillcap_8
XTAP_TAPCELL_ROW_125_3_2537 VDD VSS gf180mcu_as_sc_mcu7t3v3__tap_2
XFILLER_142_1434 VDD VDD VSS VSS gf180mcu_as_sc_mcu7t3v3__fill_1
XFILLER_142_1456 VDD VDD VSS VSS gf180mcu_as_sc_mcu7t3v3__fillcap_4
XFILLER_148_12 VDD VDD VSS VSS gf180mcu_as_sc_mcu7t3v3__fill_1
XFILLER_32_34 VDD VDD VSS VSS gf180mcu_as_sc_mcu7t3v3__fill_1
XFILLER_154_817 VDD VDD VSS VSS gf180mcu_as_sc_mcu7t3v3__fill_1
XFILLER_20_171 VDD VDD VSS VSS gf180mcu_as_sc_mcu7t3v3__fillcap_4
XFILLER_20_193 VDD VDD VSS VSS gf180mcu_as_sc_mcu7t3v3__fillcap_16
XPHY_EDGE_ROW_177_Right_311 VDD VSS gf180mcu_as_sc_mcu7t3v3__tap_2
XFILLER_147_891 VDD VDD VSS VSS gf180mcu_as_sc_mcu7t3v3__fillcap_4
XFILLER_162_850 VDD VDD VSS VSS gf180mcu_as_sc_mcu7t3v3__fill_1
XFILLER_106_265 VDD VDD VSS VSS gf180mcu_as_sc_mcu7t3v3__fill_1
XFILLER_136_1205 VDD VDD VSS VSS gf180mcu_as_sc_mcu7t3v3__fillcap_16
XPHY_EDGE_ROW_41_1_Left_493 VDD VSS gf180mcu_as_sc_mcu7t3v3__tap_2
XFILLER_171_1107 VDD VDD VSS VSS gf180mcu_as_sc_mcu7t3v3__fill_2
XFILLER_75_300 VDD VDD VSS VSS gf180mcu_as_sc_mcu7t3v3__fill_1
XFILLER_94_119 VDD VDD VSS VSS gf180mcu_as_sc_mcu7t3v3__fillcap_4
XFILLER_87_182 VDD VDD VSS VSS gf180mcu_as_sc_mcu7t3v3__fillcap_16
XFILLER_169_1025 VDD VDD VSS VSS gf180mcu_as_sc_mcu7t3v3__fillcap_8
XFILLER_177_909 VDD VDD VSS VSS gf180mcu_as_sc_mcu7t3v3__fill_1
XTAP_TAPCELL_ROW_129_1_1153 VDD VSS gf180mcu_as_sc_mcu7t3v3__tap_2
XFILLER_160_1501 VDD VDD VSS VSS gf180mcu_as_sc_mcu7t3v3__fillcap_4
XFILLER_160_1523 VDD VDD VSS VSS gf180mcu_as_sc_mcu7t3v3__fillcap_8
XFILLER_176_419 VDD VDD VSS VSS gf180mcu_as_sc_mcu7t3v3__fillcap_16
XFILLER_182_1269 VDD VDD VSS VSS gf180mcu_as_sc_mcu7t3v3__fill_1
XFILLER_73_1553 VDD VDD VSS VSS gf180mcu_as_sc_mcu7t3v3__fillcap_16
XFILLER_172_603 VDD VDD VSS VSS gf180mcu_as_sc_mcu7t3v3__fill_1
XFILLER_7_120 VDD VDD VSS VSS gf180mcu_as_sc_mcu7t3v3__fillcap_16
XFILLER_144_305 VDD VDD VSS VSS gf180mcu_as_sc_mcu7t3v3__fill_1
XFILLER_145_839 VDD VDD VSS VSS gf180mcu_as_sc_mcu7t3v3__fill_1
XFILLER_157_699 VDD VDD VSS VSS gf180mcu_as_sc_mcu7t3v3__fill_1
XFILLER_7_142 VDD VDD VSS VSS gf180mcu_as_sc_mcu7t3v3__fillcap_16
XFILLER_160_809 VDD VDD VSS VSS gf180mcu_as_sc_mcu7t3v3__fill_1
XTAP_TAPCELL_ROW_109_1_1073 VDD VSS gf180mcu_as_sc_mcu7t3v3__tap_2
XFILLER_153_872 VDD VDD VSS VSS gf180mcu_as_sc_mcu7t3v3__fill_2
X_3320_ VDD VDD VSS VSS _4920_/Q _3440_/B _3440_/C _3974_/A _3321_/C gf180mcu_as_sc_mcu7t3v3__ao22_2
XFILLER_153_894 VDD VDD VSS VSS gf180mcu_as_sc_mcu7t3v3__fill_1
XFILLER_180_691 VDD VDD VSS VSS gf180mcu_as_sc_mcu7t3v3__fill_1
XFILLER_80_1502 VDD VDD VSS VSS gf180mcu_as_sc_mcu7t3v3__fillcap_16
XFILLER_112_235 VDD VDD VSS VSS gf180mcu_as_sc_mcu7t3v3__fillcap_8
X_3251_ VDD VDD VSS VSS _3518_/C _3268_/A _3493_/B gf180mcu_as_sc_mcu7t3v3__nand2b_2
XFILLER_80_1568 VDD VDD VSS VSS gf180mcu_as_sc_mcu7t3v3__fill_1
X_3182_ VDD VDD VSS VSS _3775_/A _3182_/B _3182_/C _4798_/D _3825_/C gf180mcu_as_sc_mcu7t3v3__aoi211_2
XTAP_TAPCELL_ROW_181_2229 VDD VSS gf180mcu_as_sc_mcu7t3v3__tap_2
XFILLER_120_290 VDD VDD VSS VSS gf180mcu_as_sc_mcu7t3v3__fillcap_8
XFILLER_14_2 VDD VDD VSS VSS gf180mcu_as_sc_mcu7t3v3__fillcap_16
XFILLER_78_193 VDD VDD VSS VSS gf180mcu_as_sc_mcu7t3v3__fillcap_16
XFILLER_19_260 VDD VDD VSS VSS gf180mcu_as_sc_mcu7t3v3__fillcap_16
XFILLER_19_282 VDD VDD VSS VSS gf180mcu_as_sc_mcu7t3v3__fillcap_16
XFILLER_93_185 VDD VDD VSS VSS gf180mcu_as_sc_mcu7t3v3__fillcap_8
XFILLER_165_1434 VDD VDD VSS VSS gf180mcu_as_sc_mcu7t3v3__fillcap_16
XFILLER_34_241 VDD VDD VSS VSS gf180mcu_as_sc_mcu7t3v3__fillcap_4
XFILLER_78_1486 VDD VDD VSS VSS gf180mcu_as_sc_mcu7t3v3__fillcap_16
XFILLER_34_263 VDD VDD VSS VSS gf180mcu_as_sc_mcu7t3v3__fillcap_16
XTAP_TAPCELL_ROW_157_1700 VDD VSS gf180mcu_as_sc_mcu7t3v3__tap_2
XFILLER_163_1180 VDD VDD VSS VSS gf180mcu_as_sc_mcu7t3v3__fillcap_8
X_2966_ VDD VDD VSS VSS _3948_/A _3240_/B _3239_/A _3947_/A _2972_/B gf180mcu_as_sc_mcu7t3v3__ao22_2
XTAP_TAPCELL_ROW_157_1711 VDD VSS gf180mcu_as_sc_mcu7t3v3__tap_2
XFILLER_176_986 VDD VDD VSS VSS gf180mcu_as_sc_mcu7t3v3__fillcap_16
X_4705_ VDD VDD VSS VSS _4705_/D _4705_/A _4705_/B _4705_/C _4706_/B gf180mcu_as_sc_mcu7t3v3__ao31_2
X_2897_ VDD VDD VSS VSS _3914_/A _4977_/Q _4943_/Q gf180mcu_as_sc_mcu7t3v3__nor2_2
XFILLER_159_1205 VDD VDD VSS VSS gf180mcu_as_sc_mcu7t3v3__fillcap_8
X_4636_ VDD VDD VSS VSS _4688_/B _5113_/Q _5227_/Q _5227_/D gf180mcu_as_sc_mcu7t3v3__mux2_2
XTAP_TAPCELL_ROW_153_1619 VDD VSS gf180mcu_as_sc_mcu7t3v3__tap_2
XFILLER_102_1451 VDD VDD VSS VSS gf180mcu_as_sc_mcu7t3v3__fillcap_16
XFILLER_118_37 VDD VDD VSS VSS gf180mcu_as_sc_mcu7t3v3__fill_1
X_4567_ VDD VDD VSS VSS _4567_/B _4576_/A _4574_/C gf180mcu_as_sc_mcu7t3v3__and2_2
XTAP_TAPCELL_ROW_170_1988 VDD VSS gf180mcu_as_sc_mcu7t3v3__tap_2
X_4498_ VDD VDD VSS VSS _4502_/B _5078_/Q _4586_/S gf180mcu_as_sc_mcu7t3v3__nand2_2
X_3518_ VDD VDD VSS VSS _3520_/C _3518_/C _3518_/B _3518_/A gf180mcu_as_sc_mcu7t3v3__aoi21_2
XTAP_TAPCELL_ROW_170_1999 VDD VSS gf180mcu_as_sc_mcu7t3v3__tap_2
X_3449_ VDD VDD VSS VSS _3451_/C _4101_/D _3449_/B _3449_/C gf180mcu_as_sc_mcu7t3v3__ao21_2
XFILLER_103_279 VDD VDD VSS VSS gf180mcu_as_sc_mcu7t3v3__fill_1
XFILLER_134_36 VDD VDD VSS VSS gf180mcu_as_sc_mcu7t3v3__fillcap_4
XFILLER_57_300 VDD VDD VSS VSS gf180mcu_as_sc_mcu7t3v3__fill_1
XFILLER_69_160 VDD VDD VSS VSS gf180mcu_as_sc_mcu7t3v3__fill_2
XFILLER_76_119 VDD VDD VSS VSS gf180mcu_as_sc_mcu7t3v3__fill_1
XFILLER_94_18 VDD VDD VSS VSS gf180mcu_as_sc_mcu7t3v3__fill_2
XPHY_EDGE_ROW_102_3_Left_236 VDD VSS gf180mcu_as_sc_mcu7t3v3__tap_2
X_5119_ VDD VDD VSS VSS _5186_/CLK _5119_/D _5119_/Q gf180mcu_as_sc_mcu7t3v3__dfxtp_2
XFILLER_27_34 VDD VDD VSS VSS gf180mcu_as_sc_mcu7t3v3__fillcap_16
XFILLER_2_1502 VDD VDD VSS VSS gf180mcu_as_sc_mcu7t3v3__fillcap_16
XFILLER_166_1209 VDD VDD VSS VSS gf180mcu_as_sc_mcu7t3v3__fillcap_16
XFILLER_84_185 VDD VDD VSS VSS gf180mcu_as_sc_mcu7t3v3__fillcap_8
XPHY_EDGE_ROW_142_Right_276 VDD VSS gf180mcu_as_sc_mcu7t3v3__tap_2
XFILLER_2_1568 VDD VDD VSS VSS gf180mcu_as_sc_mcu7t3v3__fill_1
XFILLER_57_1515 VDD VDD VSS VSS gf180mcu_as_sc_mcu7t3v3__fillcap_4
XFILLER_57_1537 VDD VDD VSS VSS gf180mcu_as_sc_mcu7t3v3__fillcap_16
XFILLER_96_1564 VDD VDD VSS VSS gf180mcu_as_sc_mcu7t3v3__fillcap_4
XFILLER_144_1507 VDD VDD VSS VSS gf180mcu_as_sc_mcu7t3v3__fillcap_4
XTAP_TAPCELL_ROW_31_1_759 VDD VSS gf180mcu_as_sc_mcu7t3v3__tap_2
XTAP_TAPCELL_ROW_115_1_1094 VDD VSS gf180mcu_as_sc_mcu7t3v3__tap_2
XFILLER_43_44 VDD VDD VSS VSS gf180mcu_as_sc_mcu7t3v3__fillcap_8
XFILLER_159_66 VDD VDD VSS VSS gf180mcu_as_sc_mcu7t3v3__fillcap_4
XFILLER_43_88 VDD VDD VSS VSS gf180mcu_as_sc_mcu7t3v3__fillcap_4
XFILLER_159_88 VDD VDD VSS VSS gf180mcu_as_sc_mcu7t3v3__fillcap_16
XFILLER_40_299 VDD VDD VSS VSS gf180mcu_as_sc_mcu7t3v3__fill_2
XFILLER_154_625 VDD VDD VSS VSS gf180mcu_as_sc_mcu7t3v3__fillcap_16
XFILLER_181_400 VDD VDD VSS VSS gf180mcu_as_sc_mcu7t3v3__fillcap_16
XTAP_TAPCELL_ROW_94_1_1012 VDD VSS gf180mcu_as_sc_mcu7t3v3__tap_2
XFILLER_166_496 VDD VDD VSS VSS gf180mcu_as_sc_mcu7t3v3__fillcap_4
XFILLER_181_422 VDD VDD VSS VSS gf180mcu_as_sc_mcu7t3v3__fillcap_16
XFILLER_4_101 VDD VDD VSS VSS gf180mcu_as_sc_mcu7t3v3__fillcap_4
XFILLER_4_123 VDD VDD VSS VSS gf180mcu_as_sc_mcu7t3v3__fillcap_16
XFILLER_135_850 VDD VDD VSS VSS gf180mcu_as_sc_mcu7t3v3__fill_1
XFILLER_141_319 VDD VDD VSS VSS gf180mcu_as_sc_mcu7t3v3__fill_2
XFILLER_134_393 VDD VDD VSS VSS gf180mcu_as_sc_mcu7t3v3__fillcap_8
XFILLER_135_894 VDD VDD VSS VSS gf180mcu_as_sc_mcu7t3v3__fill_1
XFILLER_175_1073 VDD VDD VSS VSS gf180mcu_as_sc_mcu7t3v3__fill_1
XFILLER_161_190 VDD VDD VSS VSS gf180mcu_as_sc_mcu7t3v3__fillcap_16
XPHY_EDGE_ROW_34_3_Left_168 VDD VSS gf180mcu_as_sc_mcu7t3v3__tap_2
Xinput230 VDD VDD VSS VSS south_in[23] _4121_/D gf180mcu_as_sc_mcu7t3v3__buff_2
Xinput241 VDD VDD VSS VSS south_in[33] _3787_/A gf180mcu_as_sc_mcu7t3v3__buff_2
Xinput252 VDD VDD VSS VSS sw_in[12] _4034_/A gf180mcu_as_sc_mcu7t3v3__buff_2
Xinput263 VDD VDD VSS VSS sw_in[22] _2444_/A gf180mcu_as_sc_mcu7t3v3__buff_2
XFILLER_124_80 VDD VDD VSS VSS gf180mcu_as_sc_mcu7t3v3__fillcap_8
XFILLER_75_152 VDD VDD VSS VSS gf180mcu_as_sc_mcu7t3v3__fillcap_8
XPHY_EDGE_ROW_101_1_Right_100 VDD VSS gf180mcu_as_sc_mcu7t3v3__tap_2
Xinput274 VDD VDD VSS VSS sw_in[32] _3524_/A gf180mcu_as_sc_mcu7t3v3__buff_2
Xinput285 VDD VDD VSS VSS west_in[11] _4021_/D gf180mcu_as_sc_mcu7t3v3__buff_2
Xinput296 VDD VDD VSS VSS west_in[21] _4101_/A gf180mcu_as_sc_mcu7t3v3__buff_2
XFILLER_75_185 VDD VDD VSS VSS gf180mcu_as_sc_mcu7t3v3__fillcap_16
XFILLER_16_241 VDD VDD VSS VSS gf180mcu_as_sc_mcu7t3v3__fillcap_4
XFILLER_90_144 VDD VDD VSS VSS gf180mcu_as_sc_mcu7t3v3__fill_1
XFILLER_16_263 VDD VDD VSS VSS gf180mcu_as_sc_mcu7t3v3__fillcap_8
XFILLER_90_177 VDD VDD VSS VSS gf180mcu_as_sc_mcu7t3v3__fillcap_16
XPHY_EDGE_ROW_96_3_Left_230 VDD VSS gf180mcu_as_sc_mcu7t3v3__tap_2
XFILLER_182_1055 VDD VDD VSS VSS gf180mcu_as_sc_mcu7t3v3__fill_1
XFILLER_31_244 VDD VDD VSS VSS gf180mcu_as_sc_mcu7t3v3__fillcap_16
XFILLER_125_1451 VDD VDD VSS VSS gf180mcu_as_sc_mcu7t3v3__fillcap_16
XFILLER_158_942 VDD VDD VSS VSS gf180mcu_as_sc_mcu7t3v3__fill_2
X_2820_ VDD VDD VSS VSS _4974_/D _2828_/B _4759_/Q _4758_/D gf180mcu_as_sc_mcu7t3v3__mux2_2
XTAP_TAPCELL_ROW_178_2180 VDD VSS gf180mcu_as_sc_mcu7t3v3__tap_2
XFILLER_157_430 VDD VDD VSS VSS gf180mcu_as_sc_mcu7t3v3__fillcap_4
XFILLER_160_1364 VDD VDD VSS VSS gf180mcu_as_sc_mcu7t3v3__fill_1
X_2751_ VDD VDD VSS VSS _5478_/A _2833_/A _2812_/B gf180mcu_as_sc_mcu7t3v3__and2_2
XTAP_TAPCELL_ROW_174_2077 VDD VSS gf180mcu_as_sc_mcu7t3v3__tap_2
XFILLER_173_912 VDD VDD VSS VSS gf180mcu_as_sc_mcu7t3v3__fill_2
XFILLER_184_260 VDD VDD VSS VSS gf180mcu_as_sc_mcu7t3v3__fill_1
XFILLER_184_271 VDD VDD VSS VSS gf180mcu_as_sc_mcu7t3v3__fill_1
X_2682_ VDD VDD VSS VSS _5157_/Q _4273_/S _4281_/S _5181_/Q _2683_/B gf180mcu_as_sc_mcu7t3v3__ao22_2
XTAP_TAPCELL_ROW_174_2088 VDD VSS gf180mcu_as_sc_mcu7t3v3__tap_2
XFILLER_145_636 VDD VDD VSS VSS gf180mcu_as_sc_mcu7t3v3__fill_2
X_4421_ VDD VDD VSS VSS _4581_/A _4421_/B _4421_/C _4424_/C _4589_/A gf180mcu_as_sc_mcu7t3v3__aoi211_2
XFILLER_144_146 VDD VDD VSS VSS gf180mcu_as_sc_mcu7t3v3__fill_1
XFILLER_141_842 VDD VDD VSS VSS gf180mcu_as_sc_mcu7t3v3__fillcap_4
XFILLER_153_680 VDD VDD VSS VSS gf180mcu_as_sc_mcu7t3v3__fill_1
X_4352_ VDD VDD VSS VSS _4379_/B _4352_/B _5158_/Q _5158_/D gf180mcu_as_sc_mcu7t3v3__mux2_2
XFILLER_154_1157 VDD VDD VSS VSS gf180mcu_as_sc_mcu7t3v3__fillcap_16
XFILLER_158_1293 VDD VDD VSS VSS gf180mcu_as_sc_mcu7t3v3__fill_2
XFILLER_98_244 VDD VDD VSS VSS gf180mcu_as_sc_mcu7t3v3__fill_1
XFILLER_98_255 VDD VDD VSS VSS gf180mcu_as_sc_mcu7t3v3__fill_1
X_4283_ VDD VDD VSS VSS _4289_/S _5479_/A _5117_/Q _5117_/D gf180mcu_as_sc_mcu7t3v3__mux2_2
X_3303_ VDD VDD VSS VSS _3303_/B _3795_/A _4807_/D gf180mcu_as_sc_mcu7t3v3__and2_2
XFILLER_39_300 VDD VDD VSS VSS gf180mcu_as_sc_mcu7t3v3__fill_1
XFILLER_98_266 VDD VDD VSS VSS gf180mcu_as_sc_mcu7t3v3__fillcap_16
X_3234_ VDD VDD VSS VSS _3542_/A _3249_/B _3236_/B _3234_/D _3238_/A gf180mcu_as_sc_mcu7t3v3__ao22_2
Xmesh_tile_845 VDD VDD VSS VSS ne_out[20] gf180mcu_as_sc_mcu7t3v3__tiel_4
Xmesh_tile_834 VDD VDD VSS VSS ne_out[9] gf180mcu_as_sc_mcu7t3v3__tiel_4
Xmesh_tile_878 VDD VDD VSS VSS north_out[19] gf180mcu_as_sc_mcu7t3v3__tiel_4
Xmesh_tile_867 VDD VDD VSS VSS north_out[8] gf180mcu_as_sc_mcu7t3v3__tiel_4
Xmesh_tile_856 VDD VDD VSS VSS ne_out[31] gf180mcu_as_sc_mcu7t3v3__tiel_4
X_3165_ VDD VDD VSS VSS _4141_/A _3182_/B _3165_/C _4796_/D _3825_/C gf180mcu_as_sc_mcu7t3v3__aoi211_2
XFILLER_66_174 VDD VDD VSS VSS gf180mcu_as_sc_mcu7t3v3__fill_1
XPHY_EDGE_ROW_111_3_Right_430 VDD VSS gf180mcu_as_sc_mcu7t3v3__tap_2
Xmesh_tile_889 VDD VDD VSS VSS north_out[30] gf180mcu_as_sc_mcu7t3v3__tiel_4
X_3096_ VDD VDD VSS VSS _3097_/C _3096_/C _3125_/C _4069_/A gf180mcu_as_sc_mcu7t3v3__aoi21_2
XTAP_TAPCELL_ROW_146_1478 VDD VSS gf180mcu_as_sc_mcu7t3v3__tap_2
XTAP_TAPCELL_ROW_146_1467 VDD VSS gf180mcu_as_sc_mcu7t3v3__tap_2
XFILLER_81_144 VDD VDD VSS VSS gf180mcu_as_sc_mcu7t3v3__fill_1
XFILLER_81_188 VDD VDD VSS VSS gf180mcu_as_sc_mcu7t3v3__fillcap_8
XFILLER_161_1106 VDD VDD VSS VSS gf180mcu_as_sc_mcu7t3v3__fill_2
XFILLER_149_920 VDD VDD VSS VSS gf180mcu_as_sc_mcu7t3v3__fillcap_4
XFILLER_17_1521 VDD VDD VSS VSS gf180mcu_as_sc_mcu7t3v3__fillcap_16
X_3998_ VDD VDD VSS VSS _3998_/A _4104_/B _4124_/B _3998_/D _4002_/A gf180mcu_as_sc_mcu7t3v3__ao211_2
XFILLER_104_1502 VDD VDD VSS VSS gf180mcu_as_sc_mcu7t3v3__fillcap_16
XFILLER_22_299 VDD VDD VSS VSS gf180mcu_as_sc_mcu7t3v3__fill_2
XFILLER_52_1467 VDD VDD VSS VSS gf180mcu_as_sc_mcu7t3v3__fillcap_16
XFILLER_91_1483 VDD VDD VSS VSS gf180mcu_as_sc_mcu7t3v3__fillcap_16
X_2949_ VDD VDD VSS VSS _3176_/S _3925_/D _3933_/A _2951_/B gf180mcu_as_sc_mcu7t3v3__mux2_2
XFILLER_159_1002 VDD VDD VSS VSS gf180mcu_as_sc_mcu7t3v3__fill_1
XFILLER_175_260 VDD VDD VSS VSS gf180mcu_as_sc_mcu7t3v3__fillcap_16
XFILLER_129_69 VDD VDD VSS VSS gf180mcu_as_sc_mcu7t3v3__fill_1
XFILLER_163_422 VDD VDD VSS VSS gf180mcu_as_sc_mcu7t3v3__fillcap_16
XFILLER_175_282 VDD VDD VSS VSS gf180mcu_as_sc_mcu7t3v3__fillcap_16
XFILLER_89_18 VDD VDD VSS VSS gf180mcu_as_sc_mcu7t3v3__fillcap_16
XFILLER_135_168 VDD VDD VSS VSS gf180mcu_as_sc_mcu7t3v3__fillcap_8
XFILLER_151_628 VDD VDD VSS VSS gf180mcu_as_sc_mcu7t3v3__fill_2
XFILLER_163_466 VDD VDD VSS VSS gf180mcu_as_sc_mcu7t3v3__fill_1
X_4619_ VDD VDD VSS VSS _5213_/Q _4623_/B _4623_/C _5214_/Q _5213_/D gf180mcu_as_sc_mcu7t3v3__ao22_2
XFILLER_145_35 VDD VDD VSS VSS gf180mcu_as_sc_mcu7t3v3__fill_2
XFILLER_1_104 VDD VDD VSS VSS gf180mcu_as_sc_mcu7t3v3__fillcap_16
XFILLER_172_1224 VDD VDD VSS VSS gf180mcu_as_sc_mcu7t3v3__fill_1
XFILLER_89_244 VDD VDD VSS VSS gf180mcu_as_sc_mcu7t3v3__fillcap_16
XFILLER_49_119 VDD VDD VSS VSS gf180mcu_as_sc_mcu7t3v3__fillcap_4
XTAP_TAPCELL_ROW_25_3_2387 VDD VSS gf180mcu_as_sc_mcu7t3v3__tap_2
XFILLER_161_34 VDD VDD VSS VSS gf180mcu_as_sc_mcu7t3v3__fillcap_4
XTAP_TAPCELL_ROW_113_3_2519 VDD VSS gf180mcu_as_sc_mcu7t3v3__tap_2
XFILLER_166_2 VDD VDD VSS VSS gf180mcu_as_sc_mcu7t3v3__fillcap_16
XFILLER_72_144 VDD VDD VSS VSS gf180mcu_as_sc_mcu7t3v3__fill_1
XFILLER_72_177 VDD VDD VSS VSS gf180mcu_as_sc_mcu7t3v3__fillcap_16
XFILLER_13_244 VDD VDD VSS VSS gf180mcu_as_sc_mcu7t3v3__fillcap_16
XFILLER_158_205 VDD VDD VSS VSS gf180mcu_as_sc_mcu7t3v3__fill_1
XTAP_TAPCELL_ROW_13_1_688 VDD VSS gf180mcu_as_sc_mcu7t3v3__tap_2
XFILLER_70_1534 VDD VDD VSS VSS gf180mcu_as_sc_mcu7t3v3__fillcap_16
XFILLER_70_1556 VDD VDD VSS VSS gf180mcu_as_sc_mcu7t3v3__fillcap_8
XFILLER_139_463 VDD VDD VSS VSS gf180mcu_as_sc_mcu7t3v3__fillcap_4
XFILLER_139_474 VDD VDD VSS VSS gf180mcu_as_sc_mcu7t3v3__fillcap_4
XFILLER_142_1083 VDD VDD VSS VSS gf180mcu_as_sc_mcu7t3v3__fill_2
XFILLER_154_411 VDD VDD VSS VSS gf180mcu_as_sc_mcu7t3v3__fill_2
XFILLER_155_912 VDD VDD VSS VSS gf180mcu_as_sc_mcu7t3v3__fillcap_16
XFILLER_167_772 VDD VDD VSS VSS gf180mcu_as_sc_mcu7t3v3__fillcap_16
XFILLER_182_731 VDD VDD VSS VSS gf180mcu_as_sc_mcu7t3v3__fillcap_4
Xclkload18 VDD VDD VSS VSS clkload18/Y _4858_/CLK gf180mcu_as_sc_mcu7t3v3__inv_4
Xclkload29 VDD VDD VSS VSS clkload29/Y _5046_/CLK gf180mcu_as_sc_mcu7t3v3__inv_2
XFILLER_135_680 VDD VDD VSS VSS gf180mcu_as_sc_mcu7t3v3__fill_1
XPHY_EDGE_ROW_33_1_Right_32 VDD VSS gf180mcu_as_sc_mcu7t3v3__tap_2
XFILLER_151_1319 VDD VDD VSS VSS gf180mcu_as_sc_mcu7t3v3__fillcap_8
XFILLER_155_1466 VDD VDD VSS VSS gf180mcu_as_sc_mcu7t3v3__fillcap_4
XFILLER_155_1488 VDD VDD VSS VSS gf180mcu_as_sc_mcu7t3v3__fillcap_16
XFILLER_95_203 VDD VDD VSS VSS gf180mcu_as_sc_mcu7t3v3__fillcap_4
XTAP_TAPCELL_ROW_117_1_1102 VDD VSS gf180mcu_as_sc_mcu7t3v3__tap_2
XFILLER_95_72 VDD VDD VSS VSS gf180mcu_as_sc_mcu7t3v3__fillcap_16
XFILLER_48_163 VDD VDD VSS VSS gf180mcu_as_sc_mcu7t3v3__fill_1
XFILLER_63_122 VDD VDD VSS VSS gf180mcu_as_sc_mcu7t3v3__fill_1
XPHY_EDGE_ROW_102_1_Right_101 VDD VSS gf180mcu_as_sc_mcu7t3v3__tap_2
XPHY_EDGE_ROW_129_1_Left_581 VDD VSS gf180mcu_as_sc_mcu7t3v3__tap_2
XFILLER_149_1259 VDD VDD VSS VSS gf180mcu_as_sc_mcu7t3v3__fill_1
XFILLER_63_188 VDD VDD VSS VSS gf180mcu_as_sc_mcu7t3v3__fillcap_8
X_4970_ VDD VDD VSS VSS _5164_/CLK _4970_/D _4970_/Q gf180mcu_as_sc_mcu7t3v3__dfxtp_2
XFILLER_75_1467 VDD VDD VSS VSS gf180mcu_as_sc_mcu7t3v3__fillcap_16
X_3921_ VDD VDD VSS VSS _3922_/A _3922_/B _3922_/C _4115_/B _3927_/B gf180mcu_as_sc_mcu7t3v3__aoi211_2
XTAP_TAPCELL_ROW_176_2128 VDD VSS gf180mcu_as_sc_mcu7t3v3__tap_2
XTAP_TAPCELL_ROW_141_1364 VDD VSS gf180mcu_as_sc_mcu7t3v3__tap_2
XTAP_TAPCELL_ROW_141_1353 VDD VSS gf180mcu_as_sc_mcu7t3v3__tap_2
X_3852_ VDD VDD VSS VSS _5152_/Q _5151_/Q _3853_/C gf180mcu_as_sc_mcu7t3v3__or2_2
XTAP_TAPCELL_ROW_176_2139 VDD VSS gf180mcu_as_sc_mcu7t3v3__tap_2
XFILLER_81_2 VDD VDD VSS VSS gf180mcu_as_sc_mcu7t3v3__fillcap_4
X_2803_ VDD VDD VSS VSS _2806_/B _2803_/B _2806_/D gf180mcu_as_sc_mcu7t3v3__nand2_2
XFILLER_160_1161 VDD VDD VSS VSS gf180mcu_as_sc_mcu7t3v3__fill_2
X_3783_ VDD VDD VSS VSS _4163_/A _3802_/B _3783_/C _3783_/D _3784_/B gf180mcu_as_sc_mcu7t3v3__ao211_2
XFILLER_145_411 VDD VDD VSS VSS gf180mcu_as_sc_mcu7t3v3__fill_2
XFILLER_145_422 VDD VDD VSS VSS gf180mcu_as_sc_mcu7t3v3__fillcap_4
XFILLER_157_282 VDD VDD VSS VSS gf180mcu_as_sc_mcu7t3v3__fill_1
XFILLER_160_1194 VDD VDD VSS VSS gf180mcu_as_sc_mcu7t3v3__fillcap_16
XFILLER_173_731 VDD VDD VSS VSS gf180mcu_as_sc_mcu7t3v3__fill_2
X_2734_ VDD VDD VSS VSS _4264_/B _2734_/B _2734_/A _2735_/C gf180mcu_as_sc_mcu7t3v3__mux2_2
XFILLER_12_1451 VDD VDD VSS VSS gf180mcu_as_sc_mcu7t3v3__fillcap_16
XFILLER_146_989 VDD VDD VSS VSS gf180mcu_as_sc_mcu7t3v3__fillcap_16
XFILLER_161_926 VDD VDD VSS VSS gf180mcu_as_sc_mcu7t3v3__fill_2
XFILLER_172_241 VDD VDD VSS VSS gf180mcu_as_sc_mcu7t3v3__fillcap_4
XFILLER_172_263 VDD VDD VSS VSS gf180mcu_as_sc_mcu7t3v3__fillcap_16
XFILLER_173_764 VDD VDD VSS VSS gf180mcu_as_sc_mcu7t3v3__fillcap_4
X_2665_ VDD VDD VSS VSS _2673_/B _5132_/Q _5196_/Q _2666_/C gf180mcu_as_sc_mcu7t3v3__mux2_2
XFILLER_156_1219 VDD VDD VSS VSS gf180mcu_as_sc_mcu7t3v3__fillcap_4
XFILLER_161_948 VDD VDD VSS VSS gf180mcu_as_sc_mcu7t3v3__fill_1
X_4404_ VDD VDD VSS VSS _4405_/D _4404_/B _4510_/A gf180mcu_as_sc_mcu7t3v3__nor2_2
X_2596_ VDD VDD VSS VSS _5126_/Q _5099_/Q _2597_/D gf180mcu_as_sc_mcu7t3v3__xnor2_2
X_4335_ VDD VDD VSS VSS _4565_/B _4366_/S _4378_/D gf180mcu_as_sc_mcu7t3v3__and2_2
XFILLER_115_27 VDD VDD VSS VSS gf180mcu_as_sc_mcu7t3v3__fillcap_8
XTAP_TAPCELL_ROW_148_1507 VDD VSS gf180mcu_as_sc_mcu7t3v3__tap_2
XFILLER_140_193 VDD VDD VSS VSS gf180mcu_as_sc_mcu7t3v3__fillcap_8
XFILLER_86_247 VDD VDD VSS VSS gf180mcu_as_sc_mcu7t3v3__fillcap_8
X_4266_ VDD VDD VSS VSS _4273_/S _5478_/A _5100_/Q _5100_/D gf180mcu_as_sc_mcu7t3v3__mux2_2
XTAP_TAPCELL_ROW_148_1518 VDD VSS gf180mcu_as_sc_mcu7t3v3__tap_2
XFILLER_39_130 VDD VDD VSS VSS gf180mcu_as_sc_mcu7t3v3__fillcap_8
X_4197_ VDD VDD VSS VSS _4257_/B _4197_/B _4197_/C _5035_/Q _5035_/D gf180mcu_as_sc_mcu7t3v3__ao22_2
X_3217_ VDD VDD VSS VSS _3230_/S _3802_/A _3217_/A _3218_/C gf180mcu_as_sc_mcu7t3v3__mux2_2
X_3148_ VDD VDD VSS VSS _3149_/B _3148_/B _3148_/C _3149_/C gf180mcu_as_sc_mcu7t3v3__nor3_2
XTAP_TAPCELL_ROW_165_1887 VDD VSS gf180mcu_as_sc_mcu7t3v3__tap_2
XTAP_TAPCELL_ROW_165_1876 VDD VSS gf180mcu_as_sc_mcu7t3v3__tap_2
XFILLER_110_1550 VDD VDD VSS VSS gf180mcu_as_sc_mcu7t3v3__fillcap_4
XFILLER_54_177 VDD VDD VSS VSS gf180mcu_as_sc_mcu7t3v3__fillcap_4
XFILLER_54_188 VDD VDD VSS VSS gf180mcu_as_sc_mcu7t3v3__fillcap_8
XPHY_EDGE_ROW_112_3_Right_431 VDD VSS gf180mcu_as_sc_mcu7t3v3__tap_2
X_3079_ VDD VDD VSS VSS _4057_/A _3147_/B _3079_/C _3079_/D _3080_/C gf180mcu_as_sc_mcu7t3v3__ao22_2
XFILLER_180_1504 VDD VDD VSS VSS gf180mcu_as_sc_mcu7t3v3__fill_1
XFILLER_54_1518 VDD VDD VSS VSS gf180mcu_as_sc_mcu7t3v3__fillcap_16
XFILLER_10_225 VDD VDD VSS VSS gf180mcu_as_sc_mcu7t3v3__fillcap_16
XFILLER_10_247 VDD VDD VSS VSS gf180mcu_as_sc_mcu7t3v3__fillcap_16
XFILLER_149_772 VDD VDD VSS VSS gf180mcu_as_sc_mcu7t3v3__fillcap_16
XFILLER_155_208 VDD VDD VSS VSS gf180mcu_as_sc_mcu7t3v3__fill_2
XFILLER_108_102 VDD VDD VSS VSS gf180mcu_as_sc_mcu7t3v3__fill_2
XFILLER_164_731 VDD VDD VSS VSS gf180mcu_as_sc_mcu7t3v3__fillcap_4
XFILLER_40_34 VDD VDD VSS VSS gf180mcu_as_sc_mcu7t3v3__fill_1
XFILLER_137_978 VDD VDD VSS VSS gf180mcu_as_sc_mcu7t3v3__fill_2
XFILLER_156_34 VDD VDD VSS VSS gf180mcu_as_sc_mcu7t3v3__fill_1
XFILLER_136_499 VDD VDD VSS VSS gf180mcu_as_sc_mcu7t3v3__fillcap_4
XFILLER_123_138 VDD VDD VSS VSS gf180mcu_as_sc_mcu7t3v3__fill_2
XFILLER_156_89 VDD VDD VSS VSS gf180mcu_as_sc_mcu7t3v3__fill_2
XFILLER_172_1021 VDD VDD VSS VSS gf180mcu_as_sc_mcu7t3v3__fill_2
XFILLER_49_10 VDD VDD VSS VSS gf180mcu_as_sc_mcu7t3v3__fill_1
XFILLER_131_160 VDD VDD VSS VSS gf180mcu_as_sc_mcu7t3v3__fill_1
XFILLER_137_1152 VDD VDD VSS VSS gf180mcu_as_sc_mcu7t3v3__fillcap_8
XFILLER_160_992 VDD VDD VSS VSS gf180mcu_as_sc_mcu7t3v3__fillcap_8
XFILLER_49_54 VDD VDD VSS VSS gf180mcu_as_sc_mcu7t3v3__fill_1
Xfanout750 VDD VDD VSS VSS _4634_/A _4684_/A gf180mcu_as_sc_mcu7t3v3__buff_2
XFILLER_92_206 VDD VDD VSS VSS gf180mcu_as_sc_mcu7t3v3__fillcap_4
Xfanout761 VDD VDD VSS VSS _4511_/A _4572_/A gf180mcu_as_sc_mcu7t3v3__buff_2
Xfanout772 VDD VDD VSS VSS _4570_/S _4568_/A gf180mcu_as_sc_mcu7t3v3__buff_2
Xfanout783 VDD VDD VSS VSS _2729_/B _2736_/B gf180mcu_as_sc_mcu7t3v3__buff_2
Xfanout794 VDD VDD VSS VSS _4199_/A _4753_/A gf180mcu_as_sc_mcu7t3v3__buff_2
XFILLER_115_1483 VDD VDD VSS VSS gf180mcu_as_sc_mcu7t3v3__fillcap_16
XFILLER_98_1467 VDD VDD VSS VSS gf180mcu_as_sc_mcu7t3v3__fillcap_16
XFILLER_45_188 VDD VDD VSS VSS gf180mcu_as_sc_mcu7t3v3__fillcap_8
XFILLER_148_1281 VDD VDD VSS VSS gf180mcu_as_sc_mcu7t3v3__fillcap_8
XFILLER_81_52 VDD VDD VSS VSS gf180mcu_as_sc_mcu7t3v3__fill_2
XFILLER_35_1451 VDD VDD VSS VSS gf180mcu_as_sc_mcu7t3v3__fillcap_16
XTAP_TAPCELL_ROW_171_2025 VDD VSS gf180mcu_as_sc_mcu7t3v3__tap_2
XTAP_TAPCELL_ROW_171_2014 VDD VSS gf180mcu_as_sc_mcu7t3v3__tap_2
XFILLER_139_282 VDD VDD VSS VSS gf180mcu_as_sc_mcu7t3v3__fill_2
XFILLER_174_539 VDD VDD VSS VSS gf180mcu_as_sc_mcu7t3v3__fill_1
XFILLER_154_241 VDD VDD VSS VSS gf180mcu_as_sc_mcu7t3v3__fillcap_4
XFILLER_143_948 VDD VDD VSS VSS gf180mcu_as_sc_mcu7t3v3__fill_2
XFILLER_155_797 VDD VDD VSS VSS gf180mcu_as_sc_mcu7t3v3__fillcap_4
XFILLER_157_1539 VDD VDD VSS VSS gf180mcu_as_sc_mcu7t3v3__fill_1
XFILLER_170_723 VDD VDD VSS VSS gf180mcu_as_sc_mcu7t3v3__fillcap_8
X_2450_ VDD VDD VSS VSS _3192_/A _4162_/A gf180mcu_as_sc_mcu7t3v3__inv_2
XFILLER_142_469 VDD VDD VSS VSS gf180mcu_as_sc_mcu7t3v3__fill_1
XFILLER_170_767 VDD VDD VSS VSS gf180mcu_as_sc_mcu7t3v3__fill_2
XFILLER_5_295 VDD VDD VSS VSS gf180mcu_as_sc_mcu7t3v3__fillcap_4
XTAP_TAPCELL_ROW_134_1190 VDD VSS gf180mcu_as_sc_mcu7t3v3__tap_2
X_4834__998 VDD VDD VSS VSS _4834_/D gf180mcu_as_sc_mcu7t3v3__tiel_4
XFILLER_110_300 VDD VDD VSS VSS gf180mcu_as_sc_mcu7t3v3__fill_1
XFILLER_122_193 VDD VDD VSS VSS gf180mcu_as_sc_mcu7t3v3__fillcap_4
XFILLER_68_247 VDD VDD VSS VSS gf180mcu_as_sc_mcu7t3v3__fillcap_8
X_4120_ VDD VDD VSS VSS _4120_/A _4120_/B _4120_/C _4938_/Q _4122_/C gf180mcu_as_sc_mcu7t3v3__ao22_2
XFILLER_151_1149 VDD VDD VSS VSS gf180mcu_as_sc_mcu7t3v3__fillcap_8
X_4051_ VDD VDD VSS VSS _4051_/B _4165_/A _4243_/B gf180mcu_as_sc_mcu7t3v3__and2_2
Xinput5 VDD VDD VSS VSS boot_addr[3] input5/Y gf180mcu_as_sc_mcu7t3v3__buff_2
X_3002_ VDD VDD VSS VSS _3120_/A _3002_/B _3002_/C _3120_/D _3004_/C gf180mcu_as_sc_mcu7t3v3__ao211_2
XFILLER_149_1001 VDD VDD VSS VSS gf180mcu_as_sc_mcu7t3v3__fill_1
XTAP_TAPCELL_ROW_143_1404 VDD VSS gf180mcu_as_sc_mcu7t3v3__tap_2
XFILLER_149_1045 VDD VDD VSS VSS gf180mcu_as_sc_mcu7t3v3__fillcap_4
XFILLER_36_177 VDD VDD VSS VSS gf180mcu_as_sc_mcu7t3v3__fillcap_16
XPHY_EDGE_ROW_103_1_Right_102 VDD VSS gf180mcu_as_sc_mcu7t3v3__tap_2
X_4953_ VDD VDD VSS VSS clkload8/A _4953_/D _4953_/Q gf180mcu_as_sc_mcu7t3v3__dfxtp_2
XTAP_TAPCELL_ROW_160_1773 VDD VSS gf180mcu_as_sc_mcu7t3v3__tap_2
X_3904_ VDD VDD VSS VSS _3908_/B _5163_/Q _4944_/D gf180mcu_as_sc_mcu7t3v3__and2_2
XTAP_TAPCELL_ROW_160_1784 VDD VSS gf180mcu_as_sc_mcu7t3v3__tap_2
X_4884_ VDD VDD VSS VSS _5081_/CLK _4884_/D _4884_/Q gf180mcu_as_sc_mcu7t3v3__dfxtp_2
XTAP_TAPCELL_ROW_128_1_1149 VDD VSS gf180mcu_as_sc_mcu7t3v3__tap_2
XFILLER_14_1502 VDD VDD VSS VSS gf180mcu_as_sc_mcu7t3v3__fillcap_16
X_3835_ VDD VDD VSS VSS _3843_/B _3835_/B _4168_/A gf180mcu_as_sc_mcu7t3v3__nand2_2
XFILLER_146_731 VDD VDD VSS VSS gf180mcu_as_sc_mcu7t3v3__fillcap_4
XFILLER_14_1568 VDD VDD VSS VSS gf180mcu_as_sc_mcu7t3v3__fill_1
X_3766_ VDD VDD VSS VSS _3767_/B _4147_/A _3802_/B _3766_/C gf180mcu_as_sc_mcu7t3v3__ao21_2
XFILLER_134_915 VDD VDD VSS VSS gf180mcu_as_sc_mcu7t3v3__fill_2
XFILLER_145_241 VDD VDD VSS VSS gf180mcu_as_sc_mcu7t3v3__fillcap_16
XFILLER_146_764 VDD VDD VSS VSS gf180mcu_as_sc_mcu7t3v3__fill_2
XPHY_EDGE_ROW_111_3_Left_245 VDD VSS gf180mcu_as_sc_mcu7t3v3__tap_2
X_2717_ VDD VDD VSS VSS _2717_/S _5178_/Q _5170_/Q _2721_/B gf180mcu_as_sc_mcu7t3v3__mux2_2
XFILLER_10_37 VDD VDD VSS VSS gf180mcu_as_sc_mcu7t3v3__fillcap_16
XFILLER_161_723 VDD VDD VSS VSS gf180mcu_as_sc_mcu7t3v3__fillcap_8
X_3697_ VDD VDD VSS VSS _4070_/A _3726_/B _3697_/C _3731_/B _3698_/C gf180mcu_as_sc_mcu7t3v3__ao211_2
XTAP_TAPCELL_ROW_108_1_1069 VDD VSS gf180mcu_as_sc_mcu7t3v3__tap_2
XFILLER_105_127 VDD VDD VSS VSS gf180mcu_as_sc_mcu7t3v3__fillcap_8
XFILLER_126_37 VDD VDD VSS VSS gf180mcu_as_sc_mcu7t3v3__fill_1
XFILLER_160_244 VDD VDD VSS VSS gf180mcu_as_sc_mcu7t3v3__fill_1
Xoutput353 VDD VDD VSS VSS _4843_/Q east_out[4] gf180mcu_as_sc_mcu7t3v3__buff_2
Xoutput342 VDD VDD VSS VSS _4864_/Q east_out[25] gf180mcu_as_sc_mcu7t3v3__buff_2
Xoutput331 VDD VDD VSS VSS _4854_/Q east_out[15] gf180mcu_as_sc_mcu7t3v3__buff_2
Xoutput320 VDD VDD VSS VSS _5481_/Y dft_rdata[3] gf180mcu_as_sc_mcu7t3v3__buff_2
X_2648_ VDD VDD VSS VSS _2649_/C _2648_/B _4262_/B gf180mcu_as_sc_mcu7t3v3__nor2_2
Xoutput386 VDD VDD VSS VSS _4774_/Q se_out[3] gf180mcu_as_sc_mcu7t3v3__buff_2
Xoutput375 VDD VDD VSS VSS _4795_/Q se_out[24] gf180mcu_as_sc_mcu7t3v3__buff_2
Xoutput364 VDD VDD VSS VSS _4785_/Q se_out[14] gf180mcu_as_sc_mcu7t3v3__buff_2
X_2579_ VDD VDD VSS VSS _2666_/D _2674_/C gf180mcu_as_sc_mcu7t3v3__inv_2
XFILLER_101_300 VDD VDD VSS VSS gf180mcu_as_sc_mcu7t3v3__fill_1
XFILLER_113_160 VDD VDD VSS VSS gf180mcu_as_sc_mcu7t3v3__fill_1
XFILLER_142_992 VDD VDD VSS VSS gf180mcu_as_sc_mcu7t3v3__fillcap_8
XFILLER_173_1374 VDD VDD VSS VSS gf180mcu_as_sc_mcu7t3v3__fill_2
XFILLER_173_1396 VDD VDD VSS VSS gf180mcu_as_sc_mcu7t3v3__fillcap_4
Xoutput397 VDD VDD VSS VSS _4818_/Q south_out[13] gf180mcu_as_sc_mcu7t3v3__buff_2
X_4318_ VDD VDD VSS VSS _4321_/S _5148_/Q _5147_/Q _5147_/D gf180mcu_as_sc_mcu7t3v3__mux2_2
XTAP_TAPCELL_ROW_167_1938 VDD VSS gf180mcu_as_sc_mcu7t3v3__tap_2
XTAP_TAPCELL_ROW_167_1927 VDD VSS gf180mcu_as_sc_mcu7t3v3__tap_2
X_4249_ VDD VDD VSS VSS _4252_/S _4249_/B _5085_/Q _5085_/D gf180mcu_as_sc_mcu7t3v3__mux2_2
XFILLER_74_239 VDD VDD VSS VSS gf180mcu_as_sc_mcu7t3v3__fillcap_4
XTAP_TAPCELL_ROW_2_1_644 VDD VSS gf180mcu_as_sc_mcu7t3v3__tap_2
XFILLER_58_1451 VDD VDD VSS VSS gf180mcu_as_sc_mcu7t3v3__fillcap_16
XFILLER_82_294 VDD VDD VSS VSS gf180mcu_as_sc_mcu7t3v3__fillcap_4
XPHY_EDGE_ROW_113_3_Right_432 VDD VSS gf180mcu_as_sc_mcu7t3v3__tap_2
XFILLER_167_1189 VDD VDD VSS VSS gf180mcu_as_sc_mcu7t3v3__fill_1
XFILLER_168_311 VDD VDD VSS VSS gf180mcu_as_sc_mcu7t3v3__fillcap_4
XFILLER_184_1470 VDD VDD VSS VSS gf180mcu_as_sc_mcu7t3v3__fillcap_8
XFILLER_168_333 VDD VDD VSS VSS gf180mcu_as_sc_mcu7t3v3__fillcap_16
XFILLER_169_856 VDD VDD VSS VSS gf180mcu_as_sc_mcu7t3v3__fill_1
XFILLER_141_1329 VDD VDD VSS VSS gf180mcu_as_sc_mcu7t3v3__fill_1
XFILLER_180_1367 VDD VDD VSS VSS gf180mcu_as_sc_mcu7t3v3__fillcap_8
XFILLER_184_815 VDD VDD VSS VSS gf180mcu_as_sc_mcu7t3v3__fill_1
XFILLER_129_2 VDD VDD VSS VSS gf180mcu_as_sc_mcu7t3v3__fillcap_16
XFILLER_183_314 VDD VDD VSS VSS gf180mcu_as_sc_mcu7t3v3__fillcap_16
XFILLER_184_848 VDD VDD VSS VSS gf180mcu_as_sc_mcu7t3v3__fill_2
XPHY_EDGE_ROW_43_3_Left_177 VDD VSS gf180mcu_as_sc_mcu7t3v3__tap_2
XFILLER_136_241 VDD VDD VSS VSS gf180mcu_as_sc_mcu7t3v3__fillcap_4
XFILLER_167_66 VDD VDD VSS VSS gf180mcu_as_sc_mcu7t3v3__fillcap_4
XFILLER_167_88 VDD VDD VSS VSS gf180mcu_as_sc_mcu7t3v3__fillcap_16
XFILLER_171_509 VDD VDD VSS VSS gf180mcu_as_sc_mcu7t3v3__fillcap_8
XTAP_TAPCELL_ROW_13_3_2369 VDD VSS gf180mcu_as_sc_mcu7t3v3__tap_2
XFILLER_136_263 VDD VDD VSS VSS gf180mcu_as_sc_mcu7t3v3__fillcap_4
XFILLER_152_723 VDD VDD VSS VSS gf180mcu_as_sc_mcu7t3v3__fillcap_8
XFILLER_164_594 VDD VDD VSS VSS gf180mcu_as_sc_mcu7t3v3__fill_1
XFILLER_151_244 VDD VDD VSS VSS gf180mcu_as_sc_mcu7t3v3__fillcap_16
XFILLER_183_10 VDD VDD VSS VSS gf180mcu_as_sc_mcu7t3v3__fill_2
XFILLER_183_32 VDD VDD VSS VSS gf180mcu_as_sc_mcu7t3v3__fillcap_16
XFILLER_104_193 VDD VDD VSS VSS gf180mcu_as_sc_mcu7t3v3__fillcap_4
XFILLER_65_1499 VDD VDD VSS VSS gf180mcu_as_sc_mcu7t3v3__fillcap_16
XFILLER_65_206 VDD VDD VSS VSS gf180mcu_as_sc_mcu7t3v3__fillcap_4
Xfanout580 VDD VDD VSS VSS fanout583/Y _3150_/B gf180mcu_as_sc_mcu7t3v3__buff_2
Xfanout591 VDD VDD VSS VSS _4264_/B _2727_/S gf180mcu_as_sc_mcu7t3v3__buff_2
XFILLER_132_80 VDD VDD VSS VSS gf180mcu_as_sc_mcu7t3v3__fillcap_8
XFILLER_18_155 VDD VDD VSS VSS gf180mcu_as_sc_mcu7t3v3__fillcap_16
XFILLER_18_177 VDD VDD VSS VSS gf180mcu_as_sc_mcu7t3v3__fillcap_16
XFILLER_33_136 VDD VDD VSS VSS gf180mcu_as_sc_mcu7t3v3__fillcap_4
XFILLER_33_158 VDD VDD VSS VSS gf180mcu_as_sc_mcu7t3v3__fillcap_16
XFILLER_159_333 VDD VDD VSS VSS gf180mcu_as_sc_mcu7t3v3__fill_2
XFILLER_119_208 VDD VDD VSS VSS gf180mcu_as_sc_mcu7t3v3__fill_2
X_3620_ VDD VDD VSS VSS _3989_/A _3781_/S _3620_/C _3620_/D _3621_/D gf180mcu_as_sc_mcu7t3v3__ao211_2
XFILLER_162_509 VDD VDD VSS VSS gf180mcu_as_sc_mcu7t3v3__fillcap_16
X_3551_ VDD VDD VSS VSS _3561_/A _3800_/C _3551_/A gf180mcu_as_sc_mcu7t3v3__nand2_2
XTAP_TAPCELL_ROW_93_1_1008 VDD VSS gf180mcu_as_sc_mcu7t3v3__tap_2
XTAP_TAPCELL_ROW_136_1241 VDD VSS gf180mcu_as_sc_mcu7t3v3__tap_2
XFILLER_183_892 VDD VDD VSS VSS gf180mcu_as_sc_mcu7t3v3__fill_2
X_2502_ VDD VDD VSS VSS _4746_/D _4691_/A _2502_/C _2502_/D _2503_/B gf180mcu_as_sc_mcu7t3v3__ao211_2
XTAP_TAPCELL_ROW_136_1252 VDD VSS gf180mcu_as_sc_mcu7t3v3__tap_2
XFILLER_142_244 VDD VDD VSS VSS gf180mcu_as_sc_mcu7t3v3__fill_1
XFILLER_157_1336 VDD VDD VSS VSS gf180mcu_as_sc_mcu7t3v3__fill_1
X_3482_ VDD VDD VSS VSS _4139_/A _3514_/B _3482_/C _3482_/D _3483_/B gf180mcu_as_sc_mcu7t3v3__ao211_2
XFILLER_142_255 VDD VDD VSS VSS gf180mcu_as_sc_mcu7t3v3__fillcap_4
XFILLER_142_266 VDD VDD VSS VSS gf180mcu_as_sc_mcu7t3v3__fill_2
X_5221_ VDD VDD VSS VSS clkload9/A _5221_/D _5221_/Q gf180mcu_as_sc_mcu7t3v3__dfxtp_2
X_2433_ VDD VDD VSS VSS _4027_/A _2433_/A gf180mcu_as_sc_mcu7t3v3__inv_2
XFILLER_170_597 VDD VDD VSS VSS gf180mcu_as_sc_mcu7t3v3__fill_2
X_5152_ VDD VDD VSS VSS clkload8/A _5152_/D _5152_/Q gf180mcu_as_sc_mcu7t3v3__dfxtp_2
X_4103_ VDD VDD VSS VSS _4103_/A _4103_/B _4103_/C _4103_/D _4105_/C gf180mcu_as_sc_mcu7t3v3__ao211_2
X_5083_ VDD VDD VSS VSS _5183_/CLK _5083_/D _5083_/Q gf180mcu_as_sc_mcu7t3v3__dfxtp_2
X_4034_ VDD VDD VSS VSS _4106_/S _4034_/B _4034_/A _4035_/B gf180mcu_as_sc_mcu7t3v3__mux2_2
XTAP_TAPCELL_ROW_162_1824 VDD VSS gf180mcu_as_sc_mcu7t3v3__tap_2
XTAP_TAPCELL_ROW_162_1813 VDD VSS gf180mcu_as_sc_mcu7t3v3__tap_2
XFILLER_20_1550 VDD VDD VSS VSS gf180mcu_as_sc_mcu7t3v3__fillcap_4
XPHY_EDGE_ROW_104_1_Right_103 VDD VSS gf180mcu_as_sc_mcu7t3v3__tap_2
X_4936_ VDD VDD VSS VSS _5052_/CLK _4936_/D _4936_/Q gf180mcu_as_sc_mcu7t3v3__dfxtp_2
XFILLER_162_1075 VDD VDD VSS VSS gf180mcu_as_sc_mcu7t3v3__fillcap_8
XFILLER_166_804 VDD VDD VSS VSS gf180mcu_as_sc_mcu7t3v3__fill_1
XFILLER_166_815 VDD VDD VSS VSS gf180mcu_as_sc_mcu7t3v3__fill_2
XFILLER_178_675 VDD VDD VSS VSS gf180mcu_as_sc_mcu7t3v3__fillcap_4
X_4867_ VDD VDD VSS VSS _4867_/CLK _4867_/D _4867_/Q gf180mcu_as_sc_mcu7t3v3__dfxtp_2
XFILLER_177_174 VDD VDD VSS VSS gf180mcu_as_sc_mcu7t3v3__fillcap_16
X_3818_ VDD VDD VSS VSS _3818_/A _3818_/B _3818_/C _3818_/D _3915_/A gf180mcu_as_sc_mcu7t3v3__ao22_2
XFILLER_118_241 VDD VDD VSS VSS gf180mcu_as_sc_mcu7t3v3__fillcap_4
XFILLER_165_347 VDD VDD VSS VSS gf180mcu_as_sc_mcu7t3v3__fill_2
X_4798_ VDD VDD VSS VSS _4867_/CLK _4798_/D _4798_/Q gf180mcu_as_sc_mcu7t3v3__dfxtp_2
XFILLER_146_583 VDD VDD VSS VSS gf180mcu_as_sc_mcu7t3v3__fill_2
XFILLER_180_317 VDD VDD VSS VSS gf180mcu_as_sc_mcu7t3v3__fillcap_16
X_3749_ VDD VDD VSS VSS _4130_/A _3749_/B _3749_/C _3749_/D _3751_/C gf180mcu_as_sc_mcu7t3v3__ao211_2
XFILLER_47_228 VDD VDD VSS VSS gf180mcu_as_sc_mcu7t3v3__fillcap_16
XFILLER_151_1480 VDD VDD VSS VSS gf180mcu_as_sc_mcu7t3v3__fillcap_4
XFILLER_25_1483 VDD VDD VSS VSS gf180mcu_as_sc_mcu7t3v3__fillcap_16
XFILLER_112_1486 VDD VDD VSS VSS gf180mcu_as_sc_mcu7t3v3__fillcap_16
XFILLER_46_88 VDD VDD VSS VSS gf180mcu_as_sc_mcu7t3v3__fillcap_4
XFILLER_102_61 VDD VDD VSS VSS gf180mcu_as_sc_mcu7t3v3__fill_1
XFILLER_147_1538 VDD VDD VSS VSS gf180mcu_as_sc_mcu7t3v3__fill_2
XFILLER_15_136 VDD VDD VSS VSS gf180mcu_as_sc_mcu7t3v3__fillcap_4
XFILLER_15_158 VDD VDD VSS VSS gf180mcu_as_sc_mcu7t3v3__fillcap_16
XFILLER_70_264 VDD VDD VSS VSS gf180mcu_as_sc_mcu7t3v3__fill_2
XPHY_EDGE_ROW_114_3_Right_433 VDD VSS gf180mcu_as_sc_mcu7t3v3__tap_2
XFILLER_145_1262 VDD VDD VSS VSS gf180mcu_as_sc_mcu7t3v3__fillcap_8
XFILLER_156_303 VDD VDD VSS VSS gf180mcu_as_sc_mcu7t3v3__fillcap_4
XPHY_EDGE_ROW_42_1_Right_41 VDD VSS gf180mcu_as_sc_mcu7t3v3__tap_2
XFILLER_109_241 VDD VDD VSS VSS gf180mcu_as_sc_mcu7t3v3__fillcap_16
XFILLER_137_550 VDD VDD VSS VSS gf180mcu_as_sc_mcu7t3v3__fillcap_8
XFILLER_144_509 VDD VDD VSS VSS gf180mcu_as_sc_mcu7t3v3__fillcap_16
XFILLER_156_358 VDD VDD VSS VSS gf180mcu_as_sc_mcu7t3v3__fill_1
XFILLER_172_807 VDD VDD VSS VSS gf180mcu_as_sc_mcu7t3v3__fillcap_16
XFILLER_183_144 VDD VDD VSS VSS gf180mcu_as_sc_mcu7t3v3__fill_1
XFILLER_184_678 VDD VDD VSS VSS gf180mcu_as_sc_mcu7t3v3__fill_2
XPHY_EDGE_ROW_13_1_Left_465 VDD VSS gf180mcu_as_sc_mcu7t3v3__tap_2
XFILLER_109_263 VDD VDD VSS VSS gf180mcu_as_sc_mcu7t3v3__fill_1
XFILLER_184_689 VDD VDD VSS VSS gf180mcu_as_sc_mcu7t3v3__fill_1
XFILLER_164_380 VDD VDD VSS VSS gf180mcu_as_sc_mcu7t3v3__fillcap_4
XFILLER_139_1066 VDD VDD VSS VSS gf180mcu_as_sc_mcu7t3v3__fillcap_4
XFILLER_180_884 VDD VDD VSS VSS gf180mcu_as_sc_mcu7t3v3__fillcap_8
XFILLER_97_106 VDD VDD VSS VSS gf180mcu_as_sc_mcu7t3v3__fillcap_16
XTAP_TAPCELL_ROW_119_3_2528 VDD VSS gf180mcu_as_sc_mcu7t3v3__tap_2
XFILLER_140_737 VDD VDD VSS VSS gf180mcu_as_sc_mcu7t3v3__fillcap_8
XFILLER_152_597 VDD VDD VSS VSS gf180mcu_as_sc_mcu7t3v3__fillcap_16
XFILLER_30_8 VDD VDD VSS VSS gf180mcu_as_sc_mcu7t3v3__fillcap_16
XTAP_TAPCELL_ROW_40_1_796 VDD VSS gf180mcu_as_sc_mcu7t3v3__tap_2
XFILLER_152_1277 VDD VDD VSS VSS gf180mcu_as_sc_mcu7t3v3__fill_1
XTAP_TAPCELL_ROW_183_2293 VDD VSS gf180mcu_as_sc_mcu7t3v3__tap_2
XTAP_TAPCELL_ROW_183_2282 VDD VSS gf180mcu_as_sc_mcu7t3v3__tap_2
XFILLER_61_253 VDD VDD VSS VSS gf180mcu_as_sc_mcu7t3v3__fillcap_4
XFILLER_163_1340 VDD VDD VSS VSS gf180mcu_as_sc_mcu7t3v3__fillcap_4
X_2982_ VDD VDD VSS VSS _2989_/B _3130_/B _3969_/A gf180mcu_as_sc_mcu7t3v3__nand2_2
X_4721_ VDD VDD VSS VSS _4721_/B _4721_/A _4730_/C gf180mcu_as_sc_mcu7t3v3__and2_2
XTAP_TAPCELL_ROW_138_1303 VDD VSS gf180mcu_as_sc_mcu7t3v3__tap_2
XFILLER_159_174 VDD VDD VSS VSS gf180mcu_as_sc_mcu7t3v3__fillcap_16
XFILLER_175_623 VDD VDD VSS VSS gf180mcu_as_sc_mcu7t3v3__fillcap_4
X_4652_ VDD VDD VSS VSS _4746_/D _4652_/B _5238_/Q _4733_/A _4653_/B gf180mcu_as_sc_mcu7t3v3__ao22_2
XFILLER_135_509 VDD VDD VSS VSS gf180mcu_as_sc_mcu7t3v3__fillcap_8
XFILLER_174_155 VDD VDD VSS VSS gf180mcu_as_sc_mcu7t3v3__fillcap_16
XFILLER_175_667 VDD VDD VSS VSS gf180mcu_as_sc_mcu7t3v3__fillcap_16
Xinput30 VDD VDD VSS VSS dft_addr[7] _2668_/A gf180mcu_as_sc_mcu7t3v3__buff_2
X_3603_ VDD VDD VSS VSS _4920_/Q _3719_/B _3716_/C _3974_/A _3604_/D gf180mcu_as_sc_mcu7t3v3__ao22_2
XFILLER_156_870 VDD VDD VSS VSS gf180mcu_as_sc_mcu7t3v3__fillcap_4
XFILLER_162_317 VDD VDD VSS VSS gf180mcu_as_sc_mcu7t3v3__fillcap_4
XFILLER_174_177 VDD VDD VSS VSS gf180mcu_as_sc_mcu7t3v3__fillcap_16
Xinput63 VDD VDD VSS VSS east_in[27] _4153_/A gf180mcu_as_sc_mcu7t3v3__buff_2
Xinput52 VDD VDD VSS VSS east_in[17] _4072_/A gf180mcu_as_sc_mcu7t3v3__buff_2
Xinput41 VDD VDD VSS VSS dft_wdata[6] _2730_/B gf180mcu_as_sc_mcu7t3v3__buff_2
X_4583_ VDD VDD VSS VSS _5187_/Q _4592_/B _4583_/C _4583_/D _5187_/D gf180mcu_as_sc_mcu7t3v3__ao211_2
XTAP_TAPCELL_ROW_155_1672 VDD VSS gf180mcu_as_sc_mcu7t3v3__tap_2
XTAP_TAPCELL_ROW_155_1661 VDD VSS gf180mcu_as_sc_mcu7t3v3__tap_2
XFILLER_143_531 VDD VDD VSS VSS gf180mcu_as_sc_mcu7t3v3__fill_2
XFILLER_157_1122 VDD VDD VSS VSS gf180mcu_as_sc_mcu7t3v3__fillcap_16
Xinput96 VDD VDD VSS VSS ne_in[26] _4146_/D gf180mcu_as_sc_mcu7t3v3__buff_2
Xinput85 VDD VDD VSS VSS ne_in[16] _4064_/D gf180mcu_as_sc_mcu7t3v3__buff_2
Xinput74 VDD VDD VSS VSS east_in[6] _3983_/A gf180mcu_as_sc_mcu7t3v3__buff_2
X_3534_ VDD VDD VSS VSS _3818_/A _3534_/A _3932_/B gf180mcu_as_sc_mcu7t3v3__and2_2
X_3465_ VDD VDD VSS VSS _4938_/Q _3465_/B _3465_/C _4120_/A _3466_/D gf180mcu_as_sc_mcu7t3v3__ao22_2
XTAP_TAPCELL_ROW_151_1569 VDD VSS gf180mcu_as_sc_mcu7t3v3__tap_2
XFILLER_88_139 VDD VDD VSS VSS gf180mcu_as_sc_mcu7t3v3__fillcap_4
X_5204_ VDD VDD VSS VSS clkload3/A _5204_/D _5204_/Q gf180mcu_as_sc_mcu7t3v3__dfxtp_2
X_2416_ VDD VDD VSS VSS _2695_/A _2711_/S gf180mcu_as_sc_mcu7t3v3__inv_2
XFILLER_130_247 VDD VDD VSS VSS gf180mcu_as_sc_mcu7t3v3__fillcap_16
XFILLER_174_1480 VDD VDD VSS VSS gf180mcu_as_sc_mcu7t3v3__fillcap_4
XFILLER_48_1483 VDD VDD VSS VSS gf180mcu_as_sc_mcu7t3v3__fill_1
X_3396_ VDD VDD VSS VSS _3475_/B _4046_/A _3396_/A _3398_/C gf180mcu_as_sc_mcu7t3v3__mux2_2
XFILLER_96_172 VDD VDD VSS VSS gf180mcu_as_sc_mcu7t3v3__fill_2
X_5135_ VDD VDD VSS VSS clkload8/A _5135_/D _5135_/Q gf180mcu_as_sc_mcu7t3v3__dfxtp_2
XFILLER_29_228 VDD VDD VSS VSS gf180mcu_as_sc_mcu7t3v3__fillcap_16
X_5066_ VDD VDD VSS VSS _5074_/CLK _5066_/D _5066_/Q gf180mcu_as_sc_mcu7t3v3__dfxtp_2
X_4017_ VDD VDD VSS VSS _4017_/A _4105_/B _4017_/C _4017_/D _4018_/B gf180mcu_as_sc_mcu7t3v3__ao211_2
XFILLER_168_1251 VDD VDD VSS VSS gf180mcu_as_sc_mcu7t3v3__fill_2
XFILLER_168_1273 VDD VDD VSS VSS gf180mcu_as_sc_mcu7t3v3__fill_1
XFILLER_16_69 VDD VDD VSS VSS gf180mcu_as_sc_mcu7t3v3__fillcap_16
XPHY_EDGE_ROW_105_1_Right_104 VDD VSS gf180mcu_as_sc_mcu7t3v3__tap_2
XFILLER_12_139 VDD VDD VSS VSS gf180mcu_as_sc_mcu7t3v3__fillcap_16
X_4919_ VDD VDD VSS VSS _5053_/CLK _4919_/D _4919_/Q gf180mcu_as_sc_mcu7t3v3__dfxtp_2
XFILLER_138_314 VDD VDD VSS VSS gf180mcu_as_sc_mcu7t3v3__fill_1
XFILLER_138_369 VDD VDD VSS VSS gf180mcu_as_sc_mcu7t3v3__fill_2
XFILLER_154_807 VDD VDD VSS VSS gf180mcu_as_sc_mcu7t3v3__fillcap_8
XFILLER_166_667 VDD VDD VSS VSS gf180mcu_as_sc_mcu7t3v3__fillcap_8
XFILLER_181_604 VDD VDD VSS VSS gf180mcu_as_sc_mcu7t3v3__fill_2
XFILLER_153_328 VDD VDD VSS VSS gf180mcu_as_sc_mcu7t3v3__fillcap_16
XFILLER_134_531 VDD VDD VSS VSS gf180mcu_as_sc_mcu7t3v3__fillcap_8
XFILLER_146_391 VDD VDD VSS VSS gf180mcu_as_sc_mcu7t3v3__fill_1
XFILLER_180_147 VDD VDD VSS VSS gf180mcu_as_sc_mcu7t3v3__fill_1
XFILLER_162_884 VDD VDD VSS VSS gf180mcu_as_sc_mcu7t3v3__fillcap_8
XFILLER_164_34 VDD VDD VSS VSS gf180mcu_as_sc_mcu7t3v3__fill_1
XTAP_TAPCELL_ROW_69_1_910 VDD VSS gf180mcu_as_sc_mcu7t3v3__tap_2
XTAP_TAPCELL_ROW_5_3_2357 VDD VSS gf180mcu_as_sc_mcu7t3v3__tap_2
XFILLER_161_372 VDD VDD VSS VSS gf180mcu_as_sc_mcu7t3v3__fill_2
XFILLER_171_1119 VDD VDD VSS VSS gf180mcu_as_sc_mcu7t3v3__fill_1
XFILLER_175_1299 VDD VDD VSS VSS gf180mcu_as_sc_mcu7t3v3__fill_2
XFILLER_66_1550 VDD VDD VSS VSS gf180mcu_as_sc_mcu7t3v3__fillcap_4
XFILLER_79_139 VDD VDD VSS VSS gf180mcu_as_sc_mcu7t3v3__fill_1
XFILLER_57_32 VDD VDD VSS VSS gf180mcu_as_sc_mcu7t3v3__fillcap_4
XFILLER_57_65 VDD VDD VSS VSS gf180mcu_as_sc_mcu7t3v3__fillcap_4
XFILLER_169_1037 VDD VDD VSS VSS gf180mcu_as_sc_mcu7t3v3__fill_1
XFILLER_73_31 VDD VDD VSS VSS gf180mcu_as_sc_mcu7t3v3__fillcap_4
XFILLER_147_1313 VDD VDD VSS VSS gf180mcu_as_sc_mcu7t3v3__fillcap_16
XFILLER_182_1259 VDD VDD VSS VSS gf180mcu_as_sc_mcu7t3v3__fillcap_8
XFILLER_73_1521 VDD VDD VSS VSS gf180mcu_as_sc_mcu7t3v3__fillcap_16
XPHY_EDGE_ROW_5_1_Right_4 VDD VSS gf180mcu_as_sc_mcu7t3v3__tap_2
XFILLER_157_601 VDD VDD VSS VSS gf180mcu_as_sc_mcu7t3v3__fillcap_8
XPHY_EDGE_ROW_115_3_Right_434 VDD VSS gf180mcu_as_sc_mcu7t3v3__tap_2
XFILLER_160_1535 VDD VDD VSS VSS gf180mcu_as_sc_mcu7t3v3__fill_2
XFILLER_156_155 VDD VDD VSS VSS gf180mcu_as_sc_mcu7t3v3__fillcap_16
XFILLER_156_177 VDD VDD VSS VSS gf180mcu_as_sc_mcu7t3v3__fillcap_16
XFILLER_157_678 VDD VDD VSS VSS gf180mcu_as_sc_mcu7t3v3__fillcap_4
XFILLER_172_626 VDD VDD VSS VSS gf180mcu_as_sc_mcu7t3v3__fill_1
XFILLER_158_1431 VDD VDD VSS VSS gf180mcu_as_sc_mcu7t3v3__fillcap_4
XFILLER_171_136 VDD VDD VSS VSS gf180mcu_as_sc_mcu7t3v3__fillcap_4
XFILLER_153_884 VDD VDD VSS VSS gf180mcu_as_sc_mcu7t3v3__fillcap_8
XFILLER_171_158 VDD VDD VSS VSS gf180mcu_as_sc_mcu7t3v3__fillcap_16
XFILLER_112_247 VDD VDD VSS VSS gf180mcu_as_sc_mcu7t3v3__fillcap_16
X_3250_ VDD VDD VSS VSS _3250_/Y _3510_/C _3519_/C gf180mcu_as_sc_mcu7t3v3__nand2_2
X_3181_ VDD VDD VSS VSS _3182_/B _3181_/B _3181_/C _3182_/C gf180mcu_as_sc_mcu7t3v3__nor3_2
XFILLER_93_120 VDD VDD VSS VSS gf180mcu_as_sc_mcu7t3v3__fill_1
XFILLER_26_209 VDD VDD VSS VSS gf180mcu_as_sc_mcu7t3v3__fillcap_16
XFILLER_93_142 VDD VDD VSS VSS gf180mcu_as_sc_mcu7t3v3__fillcap_4
XPHY_EDGE_ROW_68_3_Left_202 VDD VSS gf180mcu_as_sc_mcu7t3v3__tap_2
XFILLER_93_197 VDD VDD VSS VSS gf180mcu_as_sc_mcu7t3v3__fill_2
XPHY_EDGE_ROW_120_3_Left_254 VDD VSS gf180mcu_as_sc_mcu7t3v3__tap_2
XFILLER_165_1402 VDD VDD VSS VSS gf180mcu_as_sc_mcu7t3v3__fillcap_16
XFILLER_163_1192 VDD VDD VSS VSS gf180mcu_as_sc_mcu7t3v3__fill_1
X_4704_ VDD VDD VSS VSS _4705_/C _4704_/A _4704_/B _5241_/Q gf180mcu_as_sc_mcu7t3v3__ao21_2
X_2965_ VDD VDD VSS VSS _4772_/D _2965_/C _3182_/B _3944_/A gf180mcu_as_sc_mcu7t3v3__aoi21_2
XTAP_TAPCELL_ROW_157_1712 VDD VSS gf180mcu_as_sc_mcu7t3v3__tap_2
XTAP_TAPCELL_ROW_157_1701 VDD VSS gf180mcu_as_sc_mcu7t3v3__tap_2
XFILLER_148_667 VDD VDD VSS VSS gf180mcu_as_sc_mcu7t3v3__fillcap_16
X_2896_ VDD VDD VSS VSS _3176_/S _3227_/S _2948_/B gf180mcu_as_sc_mcu7t3v3__and2_2
XFILLER_159_1217 VDD VDD VSS VSS gf180mcu_as_sc_mcu7t3v3__fill_2
XFILLER_175_486 VDD VDD VSS VSS gf180mcu_as_sc_mcu7t3v3__fillcap_4
X_4635_ VDD VDD VSS VSS _4688_/B _5112_/Q _5226_/Q _5226_/D gf180mcu_as_sc_mcu7t3v3__mux2_2
X_4566_ VDD VDD VSS VSS _5187_/Q _4566_/B _4566_/C _5105_/Q _4567_/B gf180mcu_as_sc_mcu7t3v3__ao22_2
XFILLER_137_1504 VDD VDD VSS VSS gf180mcu_as_sc_mcu7t3v3__fillcap_16
XFILLER_144_873 VDD VDD VSS VSS gf180mcu_as_sc_mcu7t3v3__fill_2
X_3517_ VDD VDD VSS VSS _3517_/A _3533_/A _3812_/A _3517_/D _3518_/B gf180mcu_as_sc_mcu7t3v3__nand4_2
XFILLER_103_203 VDD VDD VSS VSS gf180mcu_as_sc_mcu7t3v3__fillcap_4
XFILLER_143_372 VDD VDD VSS VSS gf180mcu_as_sc_mcu7t3v3__fill_2
X_4497_ VDD VDD VSS VSS _4497_/B _4506_/A _4504_/C gf180mcu_as_sc_mcu7t3v3__and2_2
XTAP_TAPCELL_ROW_170_1989 VDD VSS gf180mcu_as_sc_mcu7t3v3__tap_2
X_3448_ VDD VDD VSS VSS _4936_/Q _3465_/B _3465_/C _4102_/A _3449_/C gf180mcu_as_sc_mcu7t3v3__ao22_2
X_3379_ VDD VDD VSS VSS _3466_/B _4031_/A _3379_/A _3380_/D gf180mcu_as_sc_mcu7t3v3__mux2_2
XFILLER_84_120 VDD VDD VSS VSS gf180mcu_as_sc_mcu7t3v3__fill_2
X_5118_ VDD VDD VSS VSS _5186_/CLK _5118_/D _5118_/Q gf180mcu_as_sc_mcu7t3v3__dfxtp_2
XPHY_EDGE_ROW_52_3_Left_186 VDD VSS gf180mcu_as_sc_mcu7t3v3__tap_2
XFILLER_22_1486 VDD VDD VSS VSS gf180mcu_as_sc_mcu7t3v3__fillcap_16
XFILLER_84_197 VDD VDD VSS VSS gf180mcu_as_sc_mcu7t3v3__fill_2
X_5049_ VDD VDD VSS VSS _5085_/CLK _5049_/D _5049_/Q gf180mcu_as_sc_mcu7t3v3__dfxtp_2
XFILLER_183_1535 VDD VDD VSS VSS gf180mcu_as_sc_mcu7t3v3__fillcap_4
XTAP_TAPCELL_ROW_115_1_1095 VDD VSS gf180mcu_as_sc_mcu7t3v3__tap_2
XFILLER_43_34 VDD VDD VSS VSS gf180mcu_as_sc_mcu7t3v3__fillcap_4
XFILLER_43_56 VDD VDD VSS VSS gf180mcu_as_sc_mcu7t3v3__fill_2
XFILLER_139_601 VDD VDD VSS VSS gf180mcu_as_sc_mcu7t3v3__fillcap_16
XFILLER_159_34 VDD VDD VSS VSS gf180mcu_as_sc_mcu7t3v3__fillcap_16
XFILLER_167_932 VDD VDD VSS VSS gf180mcu_as_sc_mcu7t3v3__fill_2
XPHY_EDGE_ROW_106_1_Right_105 VDD VSS gf180mcu_as_sc_mcu7t3v3__tap_2
XFILLER_142_1254 VDD VDD VSS VSS gf180mcu_as_sc_mcu7t3v3__fillcap_16
XFILLER_167_954 VDD VDD VSS VSS gf180mcu_as_sc_mcu7t3v3__fillcap_4
XFILLER_138_166 VDD VDD VSS VSS gf180mcu_as_sc_mcu7t3v3__fillcap_8
XFILLER_167_998 VDD VDD VSS VSS gf180mcu_as_sc_mcu7t3v3__fillcap_16
XTAP_TAPCELL_ROW_94_1_1013 VDD VSS gf180mcu_as_sc_mcu7t3v3__tap_2
XFILLER_111_2 VDD VDD VSS VSS gf180mcu_as_sc_mcu7t3v3__fillcap_16
XFILLER_138_188 VDD VDD VSS VSS gf180mcu_as_sc_mcu7t3v3__fillcap_16
XFILLER_153_136 VDD VDD VSS VSS gf180mcu_as_sc_mcu7t3v3__fillcap_4
XFILLER_177_1317 VDD VDD VSS VSS gf180mcu_as_sc_mcu7t3v3__fillcap_4
XFILLER_153_158 VDD VDD VSS VSS gf180mcu_as_sc_mcu7t3v3__fillcap_4
XFILLER_175_1030 VDD VDD VSS VSS gf180mcu_as_sc_mcu7t3v3__fill_1
XFILLER_175_66 VDD VDD VSS VSS gf180mcu_as_sc_mcu7t3v3__fillcap_4
XFILLER_136_1014 VDD VDD VSS VSS gf180mcu_as_sc_mcu7t3v3__fill_1
XFILLER_162_681 VDD VDD VSS VSS gf180mcu_as_sc_mcu7t3v3__fill_1
XFILLER_175_1052 VDD VDD VSS VSS gf180mcu_as_sc_mcu7t3v3__fillcap_4
XFILLER_175_88 VDD VDD VSS VSS gf180mcu_as_sc_mcu7t3v3__fillcap_16
Xinput220 VDD VDD VSS VSS south_in[14] _4047_/A gf180mcu_as_sc_mcu7t3v3__buff_2
Xinput231 VDD VDD VSS VSS south_in[24] _4128_/A gf180mcu_as_sc_mcu7t3v3__buff_2
Xinput242 VDD VDD VSS VSS south_in[3] _3958_/A gf180mcu_as_sc_mcu7t3v3__buff_2
Xinput253 VDD VDD VSS VSS sw_in[13] _2435_/A gf180mcu_as_sc_mcu7t3v3__buff_2
XTAP_TAPCELL_ROW_10_1_674 VDD VSS gf180mcu_as_sc_mcu7t3v3__tap_2
XFILLER_75_142 VDD VDD VSS VSS gf180mcu_as_sc_mcu7t3v3__fill_2
Xinput264 VDD VDD VSS VSS sw_in[23] _2445_/A gf180mcu_as_sc_mcu7t3v3__buff_2
Xinput275 VDD VDD VSS VSS sw_in[33] _3817_/A gf180mcu_as_sc_mcu7t3v3__buff_2
Xinput286 VDD VDD VSS VSS west_in[12] _4030_/A gf180mcu_as_sc_mcu7t3v3__buff_2
Xinput297 VDD VDD VSS VSS west_in[22] _4109_/D gf180mcu_as_sc_mcu7t3v3__buff_2
XFILLER_149_1419 VDD VDD VSS VSS gf180mcu_as_sc_mcu7t3v3__fillcap_16
XFILLER_40_1564 VDD VDD VSS VSS gf180mcu_as_sc_mcu7t3v3__fillcap_4
XFILLER_90_134 VDD VDD VSS VSS gf180mcu_as_sc_mcu7t3v3__fillcap_8
XFILLER_90_156 VDD VDD VSS VSS gf180mcu_as_sc_mcu7t3v3__fillcap_8
XTAP_TAPCELL_ROW_19_3_2378 VDD VSS gf180mcu_as_sc_mcu7t3v3__tap_2
XFILLER_16_275 VDD VDD VSS VSS gf180mcu_as_sc_mcu7t3v3__fill_2
XFILLER_147_1165 VDD VDD VSS VSS gf180mcu_as_sc_mcu7t3v3__fillcap_8
XFILLER_182_1045 VDD VDD VSS VSS gf180mcu_as_sc_mcu7t3v3__fillcap_8
XFILLER_31_212 VDD VDD VSS VSS gf180mcu_as_sc_mcu7t3v3__fillcap_16
XTAP_TAPCELL_ROW_178_2170 VDD VSS gf180mcu_as_sc_mcu7t3v3__tap_2
XFILLER_143_1029 VDD VDD VSS VSS gf180mcu_as_sc_mcu7t3v3__fillcap_16
XFILLER_160_1321 VDD VDD VSS VSS gf180mcu_as_sc_mcu7t3v3__fill_2
XTAP_TAPCELL_ROW_178_2181 VDD VSS gf180mcu_as_sc_mcu7t3v3__tap_2
XFILLER_173_902 VDD VDD VSS VSS gf180mcu_as_sc_mcu7t3v3__fill_1
XPHY_EDGE_ROW_116_3_Right_435 VDD VSS gf180mcu_as_sc_mcu7t3v3__tap_2
X_2750_ VDD VDD VSS VSS _2764_/A _2810_/A gf180mcu_as_sc_mcu7t3v3__inv_2
XTAP_TAPCELL_ROW_174_2078 VDD VSS gf180mcu_as_sc_mcu7t3v3__tap_2
X_2681_ VDD VDD VSS VSS _2681_/Y _2717_/S _2699_/A gf180mcu_as_sc_mcu7t3v3__nor2_2
XTAP_TAPCELL_ROW_174_2089 VDD VSS gf180mcu_as_sc_mcu7t3v3__tap_2
XFILLER_129_188 VDD VDD VSS VSS gf180mcu_as_sc_mcu7t3v3__fillcap_16
XFILLER_173_946 VDD VDD VSS VSS gf180mcu_as_sc_mcu7t3v3__fill_2
X_4420_ VDD VDD VSS VSS _4421_/B _4420_/A gf180mcu_as_sc_mcu7t3v3__inv_2
XFILLER_144_169 VDD VDD VSS VSS gf180mcu_as_sc_mcu7t3v3__fillcap_4
XFILLER_160_607 VDD VDD VSS VSS gf180mcu_as_sc_mcu7t3v3__fill_2
XFILLER_173_979 VDD VDD VSS VSS gf180mcu_as_sc_mcu7t3v3__fill_1
XFILLER_153_670 VDD VDD VSS VSS gf180mcu_as_sc_mcu7t3v3__fillcap_8
XFILLER_172_489 VDD VDD VSS VSS gf180mcu_as_sc_mcu7t3v3__fill_2
XFILLER_98_212 VDD VDD VSS VSS gf180mcu_as_sc_mcu7t3v3__fillcap_4
X_4351_ VDD VDD VSS VSS _4575_/B _4351_/B _4351_/A _4352_/B gf180mcu_as_sc_mcu7t3v3__mux2_2
XFILLER_3_190 VDD VDD VSS VSS gf180mcu_as_sc_mcu7t3v3__fillcap_16
X_4282_ VDD VDD VSS VSS _4289_/S _5478_/A _5116_/Q _5116_/D gf180mcu_as_sc_mcu7t3v3__mux2_2
X_3302_ VDD VDD VSS VSS _3505_/S _3302_/B _3302_/A _3303_/B gf180mcu_as_sc_mcu7t3v3__mux2_2
X_3233_ VDD VDD VSS VSS _3234_/D _3233_/C _3233_/B _3519_/A gf180mcu_as_sc_mcu7t3v3__aoi21b_2
XFILLER_171_1472 VDD VDD VSS VSS gf180mcu_as_sc_mcu7t3v3__fillcap_16
Xmesh_tile_835 VDD VDD VSS VSS ne_out[10] gf180mcu_as_sc_mcu7t3v3__tiel_4
XFILLER_132_1467 VDD VDD VSS VSS gf180mcu_as_sc_mcu7t3v3__fillcap_16
XFILLER_66_142 VDD VDD VSS VSS gf180mcu_as_sc_mcu7t3v3__fill_2
Xmesh_tile_868 VDD VDD VSS VSS north_out[9] gf180mcu_as_sc_mcu7t3v3__tiel_4
Xmesh_tile_857 VDD VDD VSS VSS ne_out[32] gf180mcu_as_sc_mcu7t3v3__tiel_4
Xmesh_tile_846 VDD VDD VSS VSS ne_out[21] gf180mcu_as_sc_mcu7t3v3__tiel_4
X_3164_ VDD VDD VSS VSS _3182_/B _3164_/B _3164_/C _3165_/C gf180mcu_as_sc_mcu7t3v3__nor3_2
Xmesh_tile_879 VDD VDD VSS VSS north_out[20] gf180mcu_as_sc_mcu7t3v3__tiel_4
X_3095_ VDD VDD VSS VSS _4070_/A _3125_/B _3095_/C _3095_/D _3096_/C gf180mcu_as_sc_mcu7t3v3__ao22_2
XTAP_TAPCELL_ROW_146_1479 VDD VSS gf180mcu_as_sc_mcu7t3v3__tap_2
XTAP_TAPCELL_ROW_146_1468 VDD VSS gf180mcu_as_sc_mcu7t3v3__tap_2
XFILLER_66_197 VDD VDD VSS VSS gf180mcu_as_sc_mcu7t3v3__fill_2
XFILLER_81_134 VDD VDD VSS VSS gf180mcu_as_sc_mcu7t3v3__fillcap_4
XFILLER_167_206 VDD VDD VSS VSS gf180mcu_as_sc_mcu7t3v3__fillcap_4
XFILLER_167_228 VDD VDD VSS VSS gf180mcu_as_sc_mcu7t3v3__fillcap_16
XFILLER_91_1451 VDD VDD VSS VSS gf180mcu_as_sc_mcu7t3v3__fillcap_16
X_3997_ VDD VDD VSS VSS _3997_/A _4118_/B _4118_/C _3997_/D _3998_/D gf180mcu_as_sc_mcu7t3v3__ao22_2
XFILLER_148_420 VDD VDD VSS VSS gf180mcu_as_sc_mcu7t3v3__fillcap_8
X_2948_ VDD VDD VSS VSS _2948_/Y _2948_/B _3201_/C gf180mcu_as_sc_mcu7t3v3__nor2b_2
XFILLER_182_209 VDD VDD VSS VSS gf180mcu_as_sc_mcu7t3v3__fillcap_16
X_4618_ VDD VDD VSS VSS _5212_/Q _4623_/B _4623_/C _5213_/Q _5212_/D gf180mcu_as_sc_mcu7t3v3__ao22_2
X_2879_ VDD VDD VSS VSS _2880_/B _4719_/B _2879_/B _2879_/A gf180mcu_as_sc_mcu7t3v3__aoi21_2
Xclkbuf_leaf_19_clk_regs VDD VDD VSS VSS clkbuf_3_6_0_clk_regs/Y _5172_/CLK gf180mcu_as_sc_mcu7t3v3__clkbuff_12
XFILLER_137_1323 VDD VDD VSS VSS gf180mcu_as_sc_mcu7t3v3__fillcap_4
XFILLER_145_14 VDD VDD VSS VSS gf180mcu_as_sc_mcu7t3v3__fill_1
XFILLER_172_1203 VDD VDD VSS VSS gf180mcu_as_sc_mcu7t3v3__fillcap_8
XFILLER_89_212 VDD VDD VSS VSS gf180mcu_as_sc_mcu7t3v3__fillcap_16
X_4549_ VDD VDD VSS VSS _4552_/A _5084_/Q _4997_/Q _4550_/A gf180mcu_as_sc_mcu7t3v3__mux2_2
XFILLER_145_69 VDD VDD VSS VSS gf180mcu_as_sc_mcu7t3v3__fill_1
XFILLER_150_139 VDD VDD VSS VSS gf180mcu_as_sc_mcu7t3v3__fillcap_8
XFILLER_1_138 VDD VDD VSS VSS gf180mcu_as_sc_mcu7t3v3__fill_2
XFILLER_172_1269 VDD VDD VSS VSS gf180mcu_as_sc_mcu7t3v3__fill_1
XFILLER_63_1553 VDD VDD VSS VSS gf180mcu_as_sc_mcu7t3v3__fillcap_16
XFILLER_38_34 VDD VDD VSS VSS gf180mcu_as_sc_mcu7t3v3__fill_1
XPHY_EDGE_ROW_51_1_Right_50 VDD VSS gf180mcu_as_sc_mcu7t3v3__tap_2
XFILLER_57_142 VDD VDD VSS VSS gf180mcu_as_sc_mcu7t3v3__fill_2
XFILLER_72_134 VDD VDD VSS VSS gf180mcu_as_sc_mcu7t3v3__fillcap_8
XPHY_EDGE_ROW_22_1_Left_474 VDD VSS gf180mcu_as_sc_mcu7t3v3__tap_2
XFILLER_183_1310 VDD VDD VSS VSS gf180mcu_as_sc_mcu7t3v3__fillcap_8
XFILLER_54_66 VDD VDD VSS VSS gf180mcu_as_sc_mcu7t3v3__fill_2
XFILLER_13_212 VDD VDD VSS VSS gf180mcu_as_sc_mcu7t3v3__fillcap_16
XFILLER_148_1485 VDD VDD VSS VSS gf180mcu_as_sc_mcu7t3v3__fillcap_8
XFILLER_159_2 VDD VDD VSS VSS gf180mcu_as_sc_mcu7t3v3__fillcap_16
XFILLER_183_1376 VDD VDD VSS VSS gf180mcu_as_sc_mcu7t3v3__fill_1
XFILLER_70_1502 VDD VDD VSS VSS gf180mcu_as_sc_mcu7t3v3__fillcap_16
XFILLER_139_442 VDD VDD VSS VSS gf180mcu_as_sc_mcu7t3v3__fill_1
XPHY_EDGE_ROW_107_1_Right_106 VDD VSS gf180mcu_as_sc_mcu7t3v3__tap_2
XTAP_TAPCELL_ROW_13_1_689 VDD VSS gf180mcu_as_sc_mcu7t3v3__tap_2
XFILLER_70_1568 VDD VDD VSS VSS gf180mcu_as_sc_mcu7t3v3__fill_1
Xclkload19 VDD VDD VSS VSS clkload19/Y _4904_/CLK gf180mcu_as_sc_mcu7t3v3__inv_2
XTAP_TAPCELL_ROW_3_1_646 VDD VSS gf180mcu_as_sc_mcu7t3v3__tap_2
XFILLER_155_979 VDD VDD VSS VSS gf180mcu_as_sc_mcu7t3v3__fill_1
XFILLER_135_670 VDD VDD VSS VSS gf180mcu_as_sc_mcu7t3v3__fillcap_8
XFILLER_170_938 VDD VDD VSS VSS gf180mcu_as_sc_mcu7t3v3__fillcap_4
XFILLER_141_139 VDD VDD VSS VSS gf180mcu_as_sc_mcu7t3v3__fill_1
XFILLER_155_1434 VDD VDD VSS VSS gf180mcu_as_sc_mcu7t3v3__fillcap_4
XFILLER_68_1486 VDD VDD VSS VSS gf180mcu_as_sc_mcu7t3v3__fillcap_16
XFILLER_135_80 VDD VDD VSS VSS gf180mcu_as_sc_mcu7t3v3__fillcap_8
XFILLER_48_142 VDD VDD VSS VSS gf180mcu_as_sc_mcu7t3v3__fill_2
XTAP_TAPCELL_ROW_117_1_1103 VDD VSS gf180mcu_as_sc_mcu7t3v3__tap_2
XFILLER_149_1227 VDD VDD VSS VSS gf180mcu_as_sc_mcu7t3v3__fillcap_4
XFILLER_63_134 VDD VDD VSS VSS gf180mcu_as_sc_mcu7t3v3__fillcap_4
XFILLER_63_156 VDD VDD VSS VSS gf180mcu_as_sc_mcu7t3v3__fill_1
X_3920_ VDD VDD VSS VSS _3927_/B _3920_/B _3920_/A gf180mcu_as_sc_mcu7t3v3__nand2b_2
XFILLER_166_1563 VDD VDD VSS VSS gf180mcu_as_sc_mcu7t3v3__fillcap_4
XTAP_TAPCELL_ROW_176_2129 VDD VSS gf180mcu_as_sc_mcu7t3v3__tap_2
XTAP_TAPCELL_ROW_176_2118 VDD VSS gf180mcu_as_sc_mcu7t3v3__tap_2
XTAP_TAPCELL_ROW_141_1365 VDD VSS gf180mcu_as_sc_mcu7t3v3__tap_2
XTAP_TAPCELL_ROW_141_1354 VDD VSS gf180mcu_as_sc_mcu7t3v3__tap_2
XFILLER_149_228 VDD VDD VSS VSS gf180mcu_as_sc_mcu7t3v3__fillcap_16
XFILLER_162_1427 VDD VDD VSS VSS gf180mcu_as_sc_mcu7t3v3__fillcap_8
X_3851_ VDD VDD VSS VSS _5132_/Q _5133_/Q _3851_/C _3858_/A gf180mcu_as_sc_mcu7t3v3__nor3_2
X_3782_ VDD VDD VSS VSS _4162_/A _3792_/B _3791_/B _4160_/A _3783_/D gf180mcu_as_sc_mcu7t3v3__ao22_2
X_2802_ VDD VDD VSS VSS _2805_/A _2802_/A _2803_/B gf180mcu_as_sc_mcu7t3v3__or2_2
XFILLER_164_209 VDD VDD VSS VSS gf180mcu_as_sc_mcu7t3v3__fillcap_8
XPHY_EDGE_ROW_117_3_Right_436 VDD VSS gf180mcu_as_sc_mcu7t3v3__tap_2
X_2733_ VDD VDD VSS VSS _5164_/Q _4269_/S _4278_/S _5188_/Q _2734_/B gf180mcu_as_sc_mcu7t3v3__ao22_2
X_2664_ VDD VDD VSS VSS _2664_/Y _2832_/S _2664_/B _2664_/C gf180mcu_as_sc_mcu7t3v3__ao21_2
XFILLER_145_478 VDD VDD VSS VSS gf180mcu_as_sc_mcu7t3v3__fill_1
XFILLER_160_426 VDD VDD VSS VSS gf180mcu_as_sc_mcu7t3v3__fill_2
XFILLER_161_938 VDD VDD VSS VSS gf180mcu_as_sc_mcu7t3v3__fillcap_8
XFILLER_47_1515 VDD VDD VSS VSS gf180mcu_as_sc_mcu7t3v3__fillcap_4
XFILLER_86_1564 VDD VDD VSS VSS gf180mcu_as_sc_mcu7t3v3__fillcap_4
X_4403_ VDD VDD VSS VSS _4403_/S _5009_/Q _5038_/Q _4404_/B gf180mcu_as_sc_mcu7t3v3__mux2_2
X_2595_ VDD VDD VSS VSS _5125_/Q _4264_/A _2595_/A _2597_/C gf180mcu_as_sc_mcu7t3v3__mux2_2
XFILLER_47_1537 VDD VDD VSS VSS gf180mcu_as_sc_mcu7t3v3__fillcap_16
X_4334_ VDD VDD VSS VSS _4334_/Y _4334_/B _4590_/B gf180mcu_as_sc_mcu7t3v3__nand2_2
XFILLER_86_204 VDD VDD VSS VSS gf180mcu_as_sc_mcu7t3v3__fill_1
XFILLER_140_172 VDD VDD VSS VSS gf180mcu_as_sc_mcu7t3v3__fill_2
X_4265_ VDD VDD VSS VSS _4742_/C _4265_/B _4265_/C _5099_/D gf180mcu_as_sc_mcu7t3v3__nor3_2
XTAP_TAPCELL_ROW_148_1519 VDD VSS gf180mcu_as_sc_mcu7t3v3__tap_2
XTAP_TAPCELL_ROW_148_1508 VDD VSS gf180mcu_as_sc_mcu7t3v3__tap_2
XFILLER_39_142 VDD VDD VSS VSS gf180mcu_as_sc_mcu7t3v3__fillcap_16
XFILLER_86_259 VDD VDD VSS VSS gf180mcu_as_sc_mcu7t3v3__fill_2
X_4196_ VDD VDD VSS VSS _4256_/B _4197_/B _4197_/C _5034_/Q _5034_/D gf180mcu_as_sc_mcu7t3v3__ao22_2
X_3216_ VDD VDD VSS VSS _3216_/D _3801_/A _3216_/B _3216_/C _3217_/A gf180mcu_as_sc_mcu7t3v3__ao31_2
XTAP_TAPCELL_ROW_169_1980 VDD VSS gf180mcu_as_sc_mcu7t3v3__tap_2
X_3147_ VDD VDD VSS VSS _4122_/A _3147_/B _3147_/C _3147_/D _3148_/C gf180mcu_as_sc_mcu7t3v3__ao22_2
XTAP_TAPCELL_ROW_165_1877 VDD VSS gf180mcu_as_sc_mcu7t3v3__tap_2
XFILLER_54_123 VDD VDD VSS VSS gf180mcu_as_sc_mcu7t3v3__fillcap_16
XTAP_TAPCELL_ROW_165_1888 VDD VSS gf180mcu_as_sc_mcu7t3v3__tap_2
X_3078_ VDD VDD VSS VSS _3121_/B _4930_/Q _3079_/D gf180mcu_as_sc_mcu7t3v3__or2_2
XFILLER_24_69 VDD VDD VSS VSS gf180mcu_as_sc_mcu7t3v3__fillcap_16
XFILLER_137_946 VDD VDD VSS VSS gf180mcu_as_sc_mcu7t3v3__fill_2
XFILLER_40_24 VDD VDD VSS VSS gf180mcu_as_sc_mcu7t3v3__fillcap_8
XFILLER_178_1445 VDD VDD VSS VSS gf180mcu_as_sc_mcu7t3v3__fill_1
XFILLER_139_1418 VDD VDD VSS VSS gf180mcu_as_sc_mcu7t3v3__fillcap_16
XFILLER_152_938 VDD VDD VSS VSS gf180mcu_as_sc_mcu7t3v3__fillcap_4
XFILLER_174_1309 VDD VDD VSS VSS gf180mcu_as_sc_mcu7t3v3__fillcap_8
XFILLER_178_1478 VDD VDD VSS VSS gf180mcu_as_sc_mcu7t3v3__fillcap_4
XFILLER_151_437 VDD VDD VSS VSS gf180mcu_as_sc_mcu7t3v3__fill_1
XFILLER_160_960 VDD VDD VSS VSS gf180mcu_as_sc_mcu7t3v3__fillcap_16
XFILLER_172_1055 VDD VDD VSS VSS gf180mcu_as_sc_mcu7t3v3__fill_1
XFILLER_77_204 VDD VDD VSS VSS gf180mcu_as_sc_mcu7t3v3__fillcap_4
XFILLER_172_1066 VDD VDD VSS VSS gf180mcu_as_sc_mcu7t3v3__fill_1
XFILLER_172_34 VDD VDD VSS VSS gf180mcu_as_sc_mcu7t3v3__fill_1
XFILLER_49_66 VDD VDD VSS VSS gf180mcu_as_sc_mcu7t3v3__fillcap_4
XFILLER_49_88 VDD VDD VSS VSS gf180mcu_as_sc_mcu7t3v3__fillcap_4
Xfanout751 VDD VDD VSS VSS _5225_/Q _4634_/A gf180mcu_as_sc_mcu7t3v3__buff_2
XFILLER_115_1451 VDD VDD VSS VSS gf180mcu_as_sc_mcu7t3v3__fillcap_16
XFILLER_1_18 VDD VDD VSS VSS gf180mcu_as_sc_mcu7t3v3__fillcap_16
XFILLER_8_1564 VDD VDD VSS VSS gf180mcu_as_sc_mcu7t3v3__fillcap_4
Xfanout762 VDD VDD VSS VSS _5095_/Q _4511_/A gf180mcu_as_sc_mcu7t3v3__buff_2
Xfanout773 VDD VDD VSS VSS _5094_/Q _4570_/S gf180mcu_as_sc_mcu7t3v3__buff_2
Xfanout784 VDD VDD VSS VSS _2735_/D _2729_/B gf180mcu_as_sc_mcu7t3v3__buff_2
XFILLER_105_72 VDD VDD VSS VSS gf180mcu_as_sc_mcu7t3v3__fill_1
XFILLER_150_1364 VDD VDD VSS VSS gf180mcu_as_sc_mcu7t3v3__fill_1
Xfanout795 VDD VDD VSS VSS _3909_/A _4199_/A gf180mcu_as_sc_mcu7t3v3__buff_2
XFILLER_105_94 VDD VDD VSS VSS gf180mcu_as_sc_mcu7t3v3__fill_1
XFILLER_65_43 VDD VDD VSS VSS gf180mcu_as_sc_mcu7t3v3__fillcap_16
XPHY_EDGE_ROW_15_3_Left_149 VDD VSS gf180mcu_as_sc_mcu7t3v3__tap_2
XFILLER_148_1293 VDD VDD VSS VSS gf180mcu_as_sc_mcu7t3v3__fill_2
XFILLER_183_1162 VDD VDD VSS VSS gf180mcu_as_sc_mcu7t3v3__fill_1
XFILLER_144_1157 VDD VDD VSS VSS gf180mcu_as_sc_mcu7t3v3__fillcap_4
XFILLER_159_559 VDD VDD VSS VSS gf180mcu_as_sc_mcu7t3v3__fill_1
XFILLER_146_209 VDD VDD VSS VSS gf180mcu_as_sc_mcu7t3v3__fill_2
XTAP_TAPCELL_ROW_171_2015 VDD VSS gf180mcu_as_sc_mcu7t3v3__tap_2
XPHY_EDGE_ROW_108_1_Right_107 VDD VSS gf180mcu_as_sc_mcu7t3v3__tap_2
XTAP_TAPCELL_ROW_171_2026 VDD VSS gf180mcu_as_sc_mcu7t3v3__tap_2
XFILLER_60_8 VDD VDD VSS VSS gf180mcu_as_sc_mcu7t3v3__fill_2
XPHY_EDGE_ROW_77_3_Left_211 VDD VSS gf180mcu_as_sc_mcu7t3v3__tap_2
XFILLER_5_252 VDD VDD VSS VSS gf180mcu_as_sc_mcu7t3v3__fill_2
XPHY_EDGE_ROW_41_3_Right_360 VDD VSS gf180mcu_as_sc_mcu7t3v3__tap_2
XTAP_TAPCELL_ROW_134_1191 VDD VSS gf180mcu_as_sc_mcu7t3v3__tap_2
XTAP_TAPCELL_ROW_134_1180 VDD VSS gf180mcu_as_sc_mcu7t3v3__tap_2
XFILLER_151_982 VDD VDD VSS VSS gf180mcu_as_sc_mcu7t3v3__fillcap_16
XFILLER_155_1242 VDD VDD VSS VSS gf180mcu_as_sc_mcu7t3v3__fill_1
XFILLER_122_172 VDD VDD VSS VSS gf180mcu_as_sc_mcu7t3v3__fill_2
XFILLER_151_1106 VDD VDD VSS VSS gf180mcu_as_sc_mcu7t3v3__fill_2
XFILLER_81_1483 VDD VDD VSS VSS gf180mcu_as_sc_mcu7t3v3__fillcap_16
X_4050_ VDD VDD VSS VSS _4050_/S _4050_/B _4050_/A _4051_/B gf180mcu_as_sc_mcu7t3v3__mux2_2
XFILLER_36_101 VDD VDD VSS VSS gf180mcu_as_sc_mcu7t3v3__fillcap_4
XFILLER_42_1467 VDD VDD VSS VSS gf180mcu_as_sc_mcu7t3v3__fillcap_16
Xinput6 VDD VDD VSS VSS boot_addr[4] input6/Y gf180mcu_as_sc_mcu7t3v3__buff_2
X_3001_ VDD VDD VSS VSS _3982_/A _3127_/B _3127_/C _3981_/D _3002_/C gf180mcu_as_sc_mcu7t3v3__ao22_2
XFILLER_36_123 VDD VDD VSS VSS gf180mcu_as_sc_mcu7t3v3__fillcap_16
XTAP_TAPCELL_ROW_143_1405 VDD VSS gf180mcu_as_sc_mcu7t3v3__tap_2
XFILLER_149_1068 VDD VDD VSS VSS gf180mcu_as_sc_mcu7t3v3__fillcap_8
X_4952_ VDD VDD VSS VSS _5159_/CLK _4952_/Q _4952_/RN _3907_/A _4952_/D gf180mcu_as_sc_mcu7t3v3__dfsrtp_2
XTAP_TAPCELL_ROW_160_1774 VDD VSS gf180mcu_as_sc_mcu7t3v3__tap_2
XFILLER_162_1224 VDD VDD VSS VSS gf180mcu_as_sc_mcu7t3v3__fill_1
XFILLER_178_813 VDD VDD VSS VSS gf180mcu_as_sc_mcu7t3v3__fillcap_4
X_4883_ VDD VDD VSS VSS _4914_/CLK _4883_/D _4883_/Q gf180mcu_as_sc_mcu7t3v3__dfxtp_2
X_3903_ VDD VDD VSS VSS _3908_/B _5162_/Q _4943_/D gf180mcu_as_sc_mcu7t3v3__and2_2
XTAP_TAPCELL_ROW_41_1_798 VDD VSS gf180mcu_as_sc_mcu7t3v3__tap_2
XTAP_TAPCELL_ROW_160_1785 VDD VSS gf180mcu_as_sc_mcu7t3v3__tap_2
X_3834_ VDD VDD VSS VSS _3835_/B _4168_/A _3845_/A gf180mcu_as_sc_mcu7t3v3__or2_2
X_3765_ VDD VDD VSS VSS _4146_/A _3792_/B _3765_/C _3765_/D _3766_/C gf180mcu_as_sc_mcu7t3v3__ao211_2
XPHY_EDGE_ROW_118_3_Right_437 VDD VSS gf180mcu_as_sc_mcu7t3v3__tap_2
X_3696_ VDD VDD VSS VSS _3697_/C _4069_/A _3743_/B _3696_/C gf180mcu_as_sc_mcu7t3v3__ao21_2
X_2716_ VDD VDD VSS VSS _2716_/A _2716_/B _2716_/C _2716_/D _2716_/Y gf180mcu_as_sc_mcu7t3v3__ao22_2
XPHY_EDGE_ROW_61_3_Left_195 VDD VSS gf180mcu_as_sc_mcu7t3v3__tap_2
XFILLER_146_787 VDD VDD VSS VSS gf180mcu_as_sc_mcu7t3v3__fill_1
XFILLER_161_702 VDD VDD VSS VSS gf180mcu_as_sc_mcu7t3v3__fillcap_8
XFILLER_173_562 VDD VDD VSS VSS gf180mcu_as_sc_mcu7t3v3__fillcap_16
XFILLER_173_595 VDD VDD VSS VSS gf180mcu_as_sc_mcu7t3v3__fillcap_16
X_2647_ VDD VDD VSS VSS _2673_/B _5129_/Q _5193_/Q _2648_/B gf180mcu_as_sc_mcu7t3v3__mux2_2
XFILLER_105_139 VDD VDD VSS VSS gf180mcu_as_sc_mcu7t3v3__fill_1
XFILLER_126_27 VDD VDD VSS VSS gf180mcu_as_sc_mcu7t3v3__fillcap_8
XFILLER_156_1028 VDD VDD VSS VSS gf180mcu_as_sc_mcu7t3v3__fillcap_16
XFILLER_161_746 VDD VDD VSS VSS gf180mcu_as_sc_mcu7t3v3__fillcap_16
Xoutput343 VDD VDD VSS VSS _4865_/Q east_out[26] gf180mcu_as_sc_mcu7t3v3__buff_2
Xoutput332 VDD VDD VSS VSS _4855_/Q east_out[16] gf180mcu_as_sc_mcu7t3v3__buff_2
Xoutput321 VDD VDD VSS VSS _5482_/Y dft_rdata[4] gf180mcu_as_sc_mcu7t3v3__buff_2
XFILLER_142_960 VDD VDD VSS VSS gf180mcu_as_sc_mcu7t3v3__fillcap_16
Xoutput387 VDD VDD VSS VSS _4775_/Q se_out[4] gf180mcu_as_sc_mcu7t3v3__buff_2
Xoutput376 VDD VDD VSS VSS _4796_/Q se_out[25] gf180mcu_as_sc_mcu7t3v3__buff_2
Xoutput365 VDD VDD VSS VSS _4786_/Q se_out[15] gf180mcu_as_sc_mcu7t3v3__buff_2
Xoutput354 VDD VDD VSS VSS _4844_/Q east_out[5] gf180mcu_as_sc_mcu7t3v3__buff_2
X_2578_ VDD VDD VSS VSS _2674_/C _4264_/B _2692_/S gf180mcu_as_sc_mcu7t3v3__nand2_2
XFILLER_141_492 VDD VDD VSS VSS gf180mcu_as_sc_mcu7t3v3__fillcap_8
Xoutput398 VDD VDD VSS VSS _4819_/Q south_out[14] gf180mcu_as_sc_mcu7t3v3__buff_2
X_4317_ VDD VDD VSS VSS _4321_/S _5147_/Q _5146_/Q _5146_/D gf180mcu_as_sc_mcu7t3v3__mux2_2
XTAP_TAPCELL_ROW_167_1928 VDD VSS gf180mcu_as_sc_mcu7t3v3__tap_2
XFILLER_59_259 VDD VDD VSS VSS gf180mcu_as_sc_mcu7t3v3__fill_2
XFILLER_60_1534 VDD VDD VSS VSS gf180mcu_as_sc_mcu7t3v3__fillcap_16
X_4248_ VDD VDD VSS VSS _4248_/S _4248_/B _5084_/Q _5084_/D gf180mcu_as_sc_mcu7t3v3__mux2_2
XTAP_TAPCELL_ROW_167_1939 VDD VSS gf180mcu_as_sc_mcu7t3v3__tap_2
XFILLER_142_37 VDD VDD VSS VSS gf180mcu_as_sc_mcu7t3v3__fill_1
XFILLER_60_1556 VDD VDD VSS VSS gf180mcu_as_sc_mcu7t3v3__fillcap_8
X_4179_ VDD VDD VSS VSS _4239_/B _4187_/B _4190_/C _5017_/Q _5017_/D gf180mcu_as_sc_mcu7t3v3__ao22_2
XTAP_TAPCELL_ROW_2_1_645 VDD VSS gf180mcu_as_sc_mcu7t3v3__tap_2
XFILLER_3_1483 VDD VDD VSS VSS gf180mcu_as_sc_mcu7t3v3__fillcap_16
XFILLER_169_802 VDD VDD VSS VSS gf180mcu_as_sc_mcu7t3v3__fill_2
XFILLER_35_46 VDD VDD VSS VSS gf180mcu_as_sc_mcu7t3v3__fillcap_16
XFILLER_180_1313 VDD VDD VSS VSS gf180mcu_as_sc_mcu7t3v3__fillcap_8
XFILLER_184_1482 VDD VDD VSS VSS gf180mcu_as_sc_mcu7t3v3__fill_2
XPHY_EDGE_ROW_80_3_Right_399 VDD VSS gf180mcu_as_sc_mcu7t3v3__tap_2
XFILLER_145_1488 VDD VDD VSS VSS gf180mcu_as_sc_mcu7t3v3__fillcap_16
X_4896__971 VDD VDD VSS VSS _4896_/D gf180mcu_as_sc_mcu7t3v3__tiel_4
Xclkbuf_leaf_34_clk_regs VDD VDD VSS VSS clkbuf_3_4_0_clk_regs/Y _4904_/CLK gf180mcu_as_sc_mcu7t3v3__clkbuff_12
XFILLER_149_570 VDD VDD VSS VSS gf180mcu_as_sc_mcu7t3v3__fillcap_4
XFILLER_167_34 VDD VDD VSS VSS gf180mcu_as_sc_mcu7t3v3__fillcap_16
XFILLER_184_838 VDD VDD VSS VSS gf180mcu_as_sc_mcu7t3v3__fillcap_4
XFILLER_51_56 VDD VDD VSS VSS gf180mcu_as_sc_mcu7t3v3__fill_2
XFILLER_51_78 VDD VDD VSS VSS gf180mcu_as_sc_mcu7t3v3__fillcap_16
XFILLER_178_1264 VDD VDD VSS VSS gf180mcu_as_sc_mcu7t3v3__fillcap_4
XFILLER_139_1259 VDD VDD VSS VSS gf180mcu_as_sc_mcu7t3v3__fill_1
XFILLER_151_212 VDD VDD VSS VSS gf180mcu_as_sc_mcu7t3v3__fillcap_16
XFILLER_4_2 VDD VDD VSS VSS gf180mcu_as_sc_mcu7t3v3__fillcap_16
XFILLER_104_150 VDD VDD VSS VSS gf180mcu_as_sc_mcu7t3v3__fill_1
XFILLER_152_1415 VDD VDD VSS VSS gf180mcu_as_sc_mcu7t3v3__fillcap_16
XFILLER_152_1437 VDD VDD VSS VSS gf180mcu_as_sc_mcu7t3v3__fillcap_4
XFILLER_183_88 VDD VDD VSS VSS gf180mcu_as_sc_mcu7t3v3__fillcap_4
XFILLER_2_299 VDD VDD VSS VSS gf180mcu_as_sc_mcu7t3v3__fill_2
XFILLER_65_1467 VDD VDD VSS VSS gf180mcu_as_sc_mcu7t3v3__fillcap_16
XPHY_EDGE_ROW_183_Right_317 VDD VSS gf180mcu_as_sc_mcu7t3v3__tap_2
Xfanout570 VDD VDD VSS VSS fanout571/Y _4141_/D gf180mcu_as_sc_mcu7t3v3__buff_2
Xfanout581 VDD VDD VSS VSS fanout583/Y _3125_/B gf180mcu_as_sc_mcu7t3v3__buff_2
Xfanout592 VDD VDD VSS VSS _2576_/Y _4264_/B gf180mcu_as_sc_mcu7t3v3__buff_2
XFILLER_18_101 VDD VDD VSS VSS gf180mcu_as_sc_mcu7t3v3__fillcap_4
XFILLER_18_123 VDD VDD VSS VSS gf180mcu_as_sc_mcu7t3v3__fillcap_16
XFILLER_73_251 VDD VDD VSS VSS gf180mcu_as_sc_mcu7t3v3__fill_1
XPHY_EDGE_ROW_14_1_Right_13 VDD VSS gf180mcu_as_sc_mcu7t3v3__tap_2
XFILLER_33_104 VDD VDD VSS VSS gf180mcu_as_sc_mcu7t3v3__fillcap_16
XFILLER_163_1566 VDD VDD VSS VSS gf180mcu_as_sc_mcu7t3v3__fill_2
XFILLER_147_507 VDD VDD VSS VSS gf180mcu_as_sc_mcu7t3v3__fillcap_16
XFILLER_175_838 VDD VDD VSS VSS gf180mcu_as_sc_mcu7t3v3__fill_2
XPHY_EDGE_ROW_109_1_Right_108 VDD VSS gf180mcu_as_sc_mcu7t3v3__tap_2
X_3550_ VDD VDD VSS VSS _3562_/B _3562_/A _3550_/Y gf180mcu_as_sc_mcu7t3v3__and2_2
XTAP_TAPCELL_ROW_136_1242 VDD VSS gf180mcu_as_sc_mcu7t3v3__tap_2
XFILLER_142_201 VDD VDD VSS VSS gf180mcu_as_sc_mcu7t3v3__fillcap_4
XFILLER_143_702 VDD VDD VSS VSS gf180mcu_as_sc_mcu7t3v3__fillcap_4
XFILLER_155_562 VDD VDD VSS VSS gf180mcu_as_sc_mcu7t3v3__fillcap_16
X_2501_ VDD VDD VSS VSS _4746_/A _4662_/C _5222_/Q _2502_/D gf180mcu_as_sc_mcu7t3v3__mux2_2
XTAP_TAPCELL_ROW_93_1_1009 VDD VSS gf180mcu_as_sc_mcu7t3v3__tap_2
XTAP_TAPCELL_ROW_136_1253 VDD VSS gf180mcu_as_sc_mcu7t3v3__tap_2
XFILLER_100_1550 VDD VDD VSS VSS gf180mcu_as_sc_mcu7t3v3__fillcap_4
XFILLER_182_381 VDD VDD VSS VSS gf180mcu_as_sc_mcu7t3v3__fillcap_4
XFILLER_51_4 VDD VDD VSS VSS gf180mcu_as_sc_mcu7t3v3__fill_1
XPHY_EDGE_ROW_42_3_Right_361 VDD VSS gf180mcu_as_sc_mcu7t3v3__tap_2
X_5220_ VDD VDD VSS VSS clkload2/A _5220_/D _5220_/Q gf180mcu_as_sc_mcu7t3v3__dfxtp_2
X_3481_ VDD VDD VSS VSS _4135_/A _3502_/B _3504_/B _4136_/A _3482_/D gf180mcu_as_sc_mcu7t3v3__ao22_2
X_2432_ VDD VDD VSS VSS _3647_/A _4018_/A gf180mcu_as_sc_mcu7t3v3__inv_2
XFILLER_44_1518 VDD VDD VSS VSS gf180mcu_as_sc_mcu7t3v3__fillcap_16
X_5151_ VDD VDD VSS VSS clkload9/A _5151_/D _5151_/Q gf180mcu_as_sc_mcu7t3v3__dfxtp_2
XFILLER_155_1083 VDD VDD VSS VSS gf180mcu_as_sc_mcu7t3v3__fillcap_16
XFILLER_170_1559 VDD VDD VSS VSS gf180mcu_as_sc_mcu7t3v3__fill_2
X_5082_ VDD VDD VSS VSS _5084_/CLK _5082_/D _5082_/Q gf180mcu_as_sc_mcu7t3v3__dfxtp_2
X_4102_ VDD VDD VSS VSS _4102_/A _4102_/B _4102_/C _4936_/Q _4103_/D gf180mcu_as_sc_mcu7t3v3__ao22_2
X_4033_ VDD VDD VSS VSS _4033_/A _4122_/B _4033_/C _4033_/D _4034_/B gf180mcu_as_sc_mcu7t3v3__ao211_2
XFILLER_110_197 VDD VDD VSS VSS gf180mcu_as_sc_mcu7t3v3__fill_2
XTAP_TAPCELL_ROW_162_1825 VDD VSS gf180mcu_as_sc_mcu7t3v3__tap_2
XTAP_TAPCELL_ROW_162_1814 VDD VSS gf180mcu_as_sc_mcu7t3v3__tap_2
XFILLER_112_18 VDD VDD VSS VSS gf180mcu_as_sc_mcu7t3v3__fillcap_16
XPHY_EDGE_ROW_148_Left_600 VDD VSS gf180mcu_as_sc_mcu7t3v3__tap_2
XFILLER_64_295 VDD VDD VSS VSS gf180mcu_as_sc_mcu7t3v3__fillcap_4
XFILLER_177_120 VDD VDD VSS VSS gf180mcu_as_sc_mcu7t3v3__fillcap_16
XFILLER_178_621 VDD VDD VSS VSS gf180mcu_as_sc_mcu7t3v3__fillcap_4
X_4935_ VDD VDD VSS VSS _5085_/CLK _4935_/D _4935_/Q gf180mcu_as_sc_mcu7t3v3__dfxtp_2
XFILLER_177_142 VDD VDD VSS VSS gf180mcu_as_sc_mcu7t3v3__fillcap_16
X_4866_ VDD VDD VSS VSS _4867_/CLK _4866_/D _4866_/Q gf180mcu_as_sc_mcu7t3v3__dfxtp_2
XFILLER_162_1087 VDD VDD VSS VSS gf180mcu_as_sc_mcu7t3v3__fillcap_16
X_4797_ VDD VDD VSS VSS _5046_/CLK _4797_/D _4797_/Q gf180mcu_as_sc_mcu7t3v3__dfxtp_2
X_3817_ VDD VDD VSS VSS _3817_/A _3817_/B _3817_/C _3922_/C gf180mcu_as_sc_mcu7t3v3__nand3_2
XFILLER_105_1483 VDD VDD VSS VSS gf180mcu_as_sc_mcu7t3v3__fillcap_16
X_3748_ VDD VDD VSS VSS _4939_/Q _3762_/B _3748_/C _4129_/A _3749_/D gf180mcu_as_sc_mcu7t3v3__ao22_2
XFILLER_146_573 VDD VDD VSS VSS gf180mcu_as_sc_mcu7t3v3__fill_1
XFILLER_174_893 VDD VDD VSS VSS gf180mcu_as_sc_mcu7t3v3__fill_2
XFILLER_175_1404 VDD VDD VSS VSS gf180mcu_as_sc_mcu7t3v3__fill_1
XFILLER_179_1562 VDD VDD VSS VSS gf180mcu_as_sc_mcu7t3v3__fill_2
XPHY_EDGE_ROW_119_3_Right_438 VDD VSS gf180mcu_as_sc_mcu7t3v3__tap_2
XFILLER_133_212 VDD VDD VSS VSS gf180mcu_as_sc_mcu7t3v3__fillcap_8
XFILLER_88_1467 VDD VDD VSS VSS gf180mcu_as_sc_mcu7t3v3__fillcap_16
XPHY_EDGE_ROW_31_1_Left_483 VDD VSS gf180mcu_as_sc_mcu7t3v3__tap_2
X_3679_ VDD VDD VSS VSS _3683_/B _3679_/C _3726_/B _4056_/A gf180mcu_as_sc_mcu7t3v3__aoi21_2
XFILLER_138_1292 VDD VDD VSS VSS gf180mcu_as_sc_mcu7t3v3__fill_2
XFILLER_101_142 VDD VDD VSS VSS gf180mcu_as_sc_mcu7t3v3__fillcap_16
XFILLER_25_1451 VDD VDD VSS VSS gf180mcu_as_sc_mcu7t3v3__fillcap_16
XFILLER_46_34 VDD VDD VSS VSS gf180mcu_as_sc_mcu7t3v3__fill_1
XFILLER_55_251 VDD VDD VSS VSS gf180mcu_as_sc_mcu7t3v3__fill_1
XFILLER_15_104 VDD VDD VSS VSS gf180mcu_as_sc_mcu7t3v3__fillcap_16
XFILLER_70_221 VDD VDD VSS VSS gf180mcu_as_sc_mcu7t3v3__fillcap_16
XFILLER_169_632 VDD VDD VSS VSS gf180mcu_as_sc_mcu7t3v3__fill_1
XFILLER_30_107 VDD VDD VSS VSS gf180mcu_as_sc_mcu7t3v3__fill_2
XFILLER_141_2 VDD VDD VSS VSS gf180mcu_as_sc_mcu7t3v3__fillcap_16
XFILLER_180_1154 VDD VDD VSS VSS gf180mcu_as_sc_mcu7t3v3__fill_1
XFILLER_156_348 VDD VDD VSS VSS gf180mcu_as_sc_mcu7t3v3__fillcap_8
XFILLER_183_134 VDD VDD VSS VSS gf180mcu_as_sc_mcu7t3v3__fillcap_4
XFILLER_109_275 VDD VDD VSS VSS gf180mcu_as_sc_mcu7t3v3__fillcap_4
XFILLER_137_562 VDD VDD VSS VSS gf180mcu_as_sc_mcu7t3v3__fillcap_8
XFILLER_180_841 VDD VDD VSS VSS gf180mcu_as_sc_mcu7t3v3__fill_1
XFILLER_139_1045 VDD VDD VSS VSS gf180mcu_as_sc_mcu7t3v3__fillcap_4
XFILLER_180_874 VDD VDD VSS VSS gf180mcu_as_sc_mcu7t3v3__fill_1
XFILLER_152_1201 VDD VDD VSS VSS gf180mcu_as_sc_mcu7t3v3__fillcap_16
X_4870__996 VDD VDD VSS VSS _4870_/D gf180mcu_as_sc_mcu7t3v3__tiel_4
XTAP_TAPCELL_ROW_40_1_797 VDD VSS gf180mcu_as_sc_mcu7t3v3__tap_2
XFILLER_130_1543 VDD VDD VSS VSS gf180mcu_as_sc_mcu7t3v3__fill_2
XTAP_TAPCELL_ROW_183_2283 VDD VSS gf180mcu_as_sc_mcu7t3v3__tap_2
XTAP_TAPCELL_ROW_183_2272 VDD VSS gf180mcu_as_sc_mcu7t3v3__tap_2
XTAP_TAPCELL_ROW_100_3_2499 VDD VSS gf180mcu_as_sc_mcu7t3v3__tap_2
XFILLER_146_1005 VDD VDD VSS VSS gf180mcu_as_sc_mcu7t3v3__fillcap_8
XFILLER_46_295 VDD VDD VSS VSS gf180mcu_as_sc_mcu7t3v3__fillcap_4
X_2981_ VDD VDD VSS VSS _3962_/A _3156_/A _2981_/C _4774_/D _3753_/D gf180mcu_as_sc_mcu7t3v3__aoi211_2
XFILLER_128_1483 VDD VDD VSS VSS gf180mcu_as_sc_mcu7t3v3__fill_1
XFILLER_159_120 VDD VDD VSS VSS gf180mcu_as_sc_mcu7t3v3__fillcap_16
XFILLER_159_142 VDD VDD VSS VSS gf180mcu_as_sc_mcu7t3v3__fillcap_16
XFILLER_163_1374 VDD VDD VSS VSS gf180mcu_as_sc_mcu7t3v3__fill_2
XFILLER_61_298 VDD VDD VSS VSS gf180mcu_as_sc_mcu7t3v3__fill_2
X_4720_ VDD VDD VSS VSS _4730_/B _4721_/B _4720_/A gf180mcu_as_sc_mcu7t3v3__nor2_2
XFILLER_174_101 VDD VDD VSS VSS gf180mcu_as_sc_mcu7t3v3__fillcap_4
X_4651_ VDD VDD VSS VSS _4659_/B _4651_/B _5236_/Q _5236_/D gf180mcu_as_sc_mcu7t3v3__mux2_2
XFILLER_174_123 VDD VDD VSS VSS gf180mcu_as_sc_mcu7t3v3__fillcap_16
Xinput20 VDD VDD VSS VSS boot_mode _4952_/D gf180mcu_as_sc_mcu7t3v3__buff_2
Xinput31 VDD VDD VSS VSS dft_addr[8] _2672_/B gf180mcu_as_sc_mcu7t3v3__buff_2
X_3602_ VDD VDD VSS VSS _3719_/C _3973_/D _3604_/C gf180mcu_as_sc_mcu7t3v3__and2_2
XFILLER_162_307 VDD VDD VSS VSS gf180mcu_as_sc_mcu7t3v3__fill_2
Xinput64 VDD VDD VSS VSS east_in[28] _4159_/A gf180mcu_as_sc_mcu7t3v3__buff_2
Xinput53 VDD VDD VSS VSS east_in[18] _4080_/A gf180mcu_as_sc_mcu7t3v3__buff_2
Xinput42 VDD VDD VSS VSS dft_wdata[7] _2737_/B gf180mcu_as_sc_mcu7t3v3__buff_2
X_4582_ VDD VDD VSS VSS _4583_/D _4582_/B _4589_/A gf180mcu_as_sc_mcu7t3v3__nor2_2
XTAP_TAPCELL_ROW_155_1673 VDD VSS gf180mcu_as_sc_mcu7t3v3__tap_2
XTAP_TAPCELL_ROW_155_1662 VDD VSS gf180mcu_as_sc_mcu7t3v3__tap_2
XFILLER_115_212 VDD VDD VSS VSS gf180mcu_as_sc_mcu7t3v3__fill_2
XFILLER_156_893 VDD VDD VSS VSS gf180mcu_as_sc_mcu7t3v3__fill_2
XFILLER_171_830 VDD VDD VSS VSS gf180mcu_as_sc_mcu7t3v3__fillcap_8
Xinput97 VDD VDD VSS VSS ne_in[27] _4154_/D gf180mcu_as_sc_mcu7t3v3__buff_2
Xinput86 VDD VDD VSS VSS ne_in[17] _4069_/A gf180mcu_as_sc_mcu7t3v3__buff_2
Xinput75 VDD VDD VSS VSS east_in[7] _3991_/A gf180mcu_as_sc_mcu7t3v3__buff_2
X_3533_ VDD VDD VSS VSS _3533_/A _3533_/B _3533_/C _3563_/A gf180mcu_as_sc_mcu7t3v3__nand3_2
XFILLER_107_18 VDD VDD VSS VSS gf180mcu_as_sc_mcu7t3v3__fillcap_4
XFILLER_171_874 VDD VDD VSS VSS gf180mcu_as_sc_mcu7t3v3__fillcap_16
X_3464_ VDD VDD VSS VSS _3464_/B _4121_/A _3466_/C gf180mcu_as_sc_mcu7t3v3__and2_2
XFILLER_157_1189 VDD VDD VSS VSS gf180mcu_as_sc_mcu7t3v3__fill_1
XFILLER_48_1451 VDD VDD VSS VSS gf180mcu_as_sc_mcu7t3v3__fillcap_16
XFILLER_88_107 VDD VDD VSS VSS gf180mcu_as_sc_mcu7t3v3__fillcap_16
XPHY_EDGE_ROW_43_3_Right_362 VDD VSS gf180mcu_as_sc_mcu7t3v3__tap_2
X_5203_ VDD VDD VSS VSS clkload3/A _5203_/D _5203_/Q gf180mcu_as_sc_mcu7t3v3__dfxtp_2
X_2415_ VDD VDD VSS VSS _4750_/A _5278_/Q gf180mcu_as_sc_mcu7t3v3__inv_2
XFILLER_170_1323 VDD VDD VSS VSS gf180mcu_as_sc_mcu7t3v3__fill_1
X_5134_ VDD VDD VSS VSS _5199_/CLK _5134_/D _5134_/Q gf180mcu_as_sc_mcu7t3v3__dfxtp_2
X_3395_ VDD VDD VSS VSS _4047_/A _3473_/B _3395_/C _3395_/D _3396_/A gf180mcu_as_sc_mcu7t3v3__ao211_2
XFILLER_170_1367 VDD VDD VSS VSS gf180mcu_as_sc_mcu7t3v3__fillcap_8
XFILLER_96_151 VDD VDD VSS VSS gf180mcu_as_sc_mcu7t3v3__fill_2
X_4886__981 VDD VDD VSS VSS _4886_/D gf180mcu_as_sc_mcu7t3v3__tiel_4
X_5065_ VDD VDD VSS VSS _5172_/CLK _5065_/D _5065_/Q gf180mcu_as_sc_mcu7t3v3__dfxtp_2
Xclkbuf_3_2_0_clk_regs VDD VDD VSS VSS clkbuf_0_clk_regs/Y clkbuf_3_2_0_clk_regs/Y
+ gf180mcu_as_sc_mcu7t3v3__clkbuff_12
X_4016_ VDD VDD VSS VSS _4016_/A _4104_/B _4104_/C _4016_/D _4017_/D gf180mcu_as_sc_mcu7t3v3__ao22_2
XFILLER_16_37 VDD VDD VSS VSS gf180mcu_as_sc_mcu7t3v3__fillcap_16
XFILLER_52_243 VDD VDD VSS VSS gf180mcu_as_sc_mcu7t3v3__fill_2
XFILLER_0_1475 VDD VDD VSS VSS gf180mcu_as_sc_mcu7t3v3__fillcap_8
XFILLER_12_107 VDD VDD VSS VSS gf180mcu_as_sc_mcu7t3v3__fillcap_16
XFILLER_181_1430 VDD VDD VSS VSS gf180mcu_as_sc_mcu7t3v3__fill_1
XFILLER_142_1403 VDD VDD VSS VSS gf180mcu_as_sc_mcu7t3v3__fill_2
XFILLER_178_451 VDD VDD VSS VSS gf180mcu_as_sc_mcu7t3v3__fillcap_4
XFILLER_52_287 VDD VDD VSS VSS gf180mcu_as_sc_mcu7t3v3__fillcap_8
X_4918_ VDD VDD VSS VSS _5053_/CLK _4918_/D _4918_/Q gf180mcu_as_sc_mcu7t3v3__dfxtp_2
XFILLER_139_827 VDD VDD VSS VSS gf180mcu_as_sc_mcu7t3v3__fillcap_8
XFILLER_178_473 VDD VDD VSS VSS gf180mcu_as_sc_mcu7t3v3__fillcap_16
XFILLER_179_996 VDD VDD VSS VSS gf180mcu_as_sc_mcu7t3v3__fillcap_4
XFILLER_55_1499 VDD VDD VSS VSS gf180mcu_as_sc_mcu7t3v3__fillcap_16
XFILLER_32_69 VDD VDD VSS VSS gf180mcu_as_sc_mcu7t3v3__fillcap_16
X_4849_ VDD VDD VSS VSS _4863_/CLK _4849_/D _4849_/Q gf180mcu_as_sc_mcu7t3v3__dfxtp_2
XFILLER_148_69 VDD VDD VSS VSS gf180mcu_as_sc_mcu7t3v3__fillcap_16
XFILLER_166_679 VDD VDD VSS VSS gf180mcu_as_sc_mcu7t3v3__fill_2
XFILLER_181_616 VDD VDD VSS VSS gf180mcu_as_sc_mcu7t3v3__fillcap_8
X_4893__974 VDD VDD VSS VSS _4893_/D gf180mcu_as_sc_mcu7t3v3__tiel_4
XFILLER_146_370 VDD VDD VSS VSS gf180mcu_as_sc_mcu7t3v3__fillcap_8
XFILLER_162_830 VDD VDD VSS VSS gf180mcu_as_sc_mcu7t3v3__fillcap_16
XFILLER_134_543 VDD VDD VSS VSS gf180mcu_as_sc_mcu7t3v3__fill_1
XFILLER_162_874 VDD VDD VSS VSS gf180mcu_as_sc_mcu7t3v3__fill_1
XTAP_TAPCELL_ROW_69_1_911 VDD VSS gf180mcu_as_sc_mcu7t3v3__tap_2
XFILLER_162_896 VDD VDD VSS VSS gf180mcu_as_sc_mcu7t3v3__fill_2
XPHY_EDGE_ROW_24_3_Left_158 VDD VSS gf180mcu_as_sc_mcu7t3v3__tap_2
XFILLER_180_34 VDD VDD VSS VSS gf180mcu_as_sc_mcu7t3v3__fill_1
XFILLER_57_88 VDD VDD VSS VSS gf180mcu_as_sc_mcu7t3v3__fillcap_16
XFILLER_113_72 VDD VDD VSS VSS gf180mcu_as_sc_mcu7t3v3__fill_1
XFILLER_169_1049 VDD VDD VSS VSS gf180mcu_as_sc_mcu7t3v3__fill_1
XPHY_EDGE_ROW_86_3_Left_220 VDD VSS gf180mcu_as_sc_mcu7t3v3__tap_2
XFILLER_182_1205 VDD VDD VSS VSS gf180mcu_as_sc_mcu7t3v3__fillcap_8
XFILLER_28_295 VDD VDD VSS VSS gf180mcu_as_sc_mcu7t3v3__fillcap_4
XFILLER_43_276 VDD VDD VSS VSS gf180mcu_as_sc_mcu7t3v3__fillcap_4
X_4952__1000 VDD VDD VSS VSS _4952_/RN gf180mcu_as_sc_mcu7t3v3__tieh_4
XFILLER_43_298 VDD VDD VSS VSS gf180mcu_as_sc_mcu7t3v3__fill_2
XFILLER_157_624 VDD VDD VSS VSS gf180mcu_as_sc_mcu7t3v3__fillcap_4
XFILLER_184_410 VDD VDD VSS VSS gf180mcu_as_sc_mcu7t3v3__fillcap_16
XFILLER_156_123 VDD VDD VSS VSS gf180mcu_as_sc_mcu7t3v3__fillcap_16
XFILLER_171_104 VDD VDD VSS VSS gf180mcu_as_sc_mcu7t3v3__fillcap_16
XFILLER_172_616 VDD VDD VSS VSS gf180mcu_as_sc_mcu7t3v3__fillcap_8
XFILLER_137_392 VDD VDD VSS VSS gf180mcu_as_sc_mcu7t3v3__fill_2
XFILLER_138_893 VDD VDD VSS VSS gf180mcu_as_sc_mcu7t3v3__fill_2
XFILLER_10_1550 VDD VDD VSS VSS gf180mcu_as_sc_mcu7t3v3__fillcap_4
XFILLER_158_1454 VDD VDD VSS VSS gf180mcu_as_sc_mcu7t3v3__fill_1
XFILLER_152_384 VDD VDD VSS VSS gf180mcu_as_sc_mcu7t3v3__fill_1
XFILLER_152_1053 VDD VDD VSS VSS gf180mcu_as_sc_mcu7t3v3__fill_2
XFILLER_78_162 VDD VDD VSS VSS gf180mcu_as_sc_mcu7t3v3__fillcap_4
X_3180_ VDD VDD VSS VSS _4155_/A _3230_/S _3180_/C _3180_/D _3181_/C gf180mcu_as_sc_mcu7t3v3__ao22_2
XFILLER_93_110 VDD VDD VSS VSS gf180mcu_as_sc_mcu7t3v3__fillcap_8
XFILLER_93_132 VDD VDD VSS VSS gf180mcu_as_sc_mcu7t3v3__fillcap_8
XFILLER_93_165 VDD VDD VSS VSS gf180mcu_as_sc_mcu7t3v3__fill_2
XTAP_TAPCELL_ROW_34_3_2400 VDD VSS gf180mcu_as_sc_mcu7t3v3__tap_2
X_2964_ VDD VDD VSS VSS _3706_/D _3194_/S _2964_/B _2964_/C _2965_/C gf180mcu_as_sc_mcu7t3v3__ao31_2
X_4703_ VDD VDD VSS VSS _4703_/A _4703_/B _5222_/Q _4703_/D _4705_/B gf180mcu_as_sc_mcu7t3v3__ao211_2
XTAP_TAPCELL_ROW_157_1713 VDD VSS gf180mcu_as_sc_mcu7t3v3__tap_2
XTAP_TAPCELL_ROW_157_1702 VDD VSS gf180mcu_as_sc_mcu7t3v3__tap_2
X_2895_ VDD VDD VSS VSS _3533_/C _3257_/A _3223_/B gf180mcu_as_sc_mcu7t3v3__and2_2
XFILLER_135_318 VDD VDD VSS VSS gf180mcu_as_sc_mcu7t3v3__fill_2
XFILLER_147_178 VDD VDD VSS VSS gf180mcu_as_sc_mcu7t3v3__fillcap_16
XFILLER_15_1483 VDD VDD VSS VSS gf180mcu_as_sc_mcu7t3v3__fillcap_16
XFILLER_175_454 VDD VDD VSS VSS gf180mcu_as_sc_mcu7t3v3__fillcap_16
X_4634_ VDD VDD VSS VSS _4680_/B _5122_/Q _4634_/A _5225_/D gf180mcu_as_sc_mcu7t3v3__mux2_2
XFILLER_144_841 VDD VDD VSS VSS gf180mcu_as_sc_mcu7t3v3__fill_1
X_4565_ VDD VDD VSS VSS _5185_/Q _4565_/B _4565_/C _4565_/D _5185_/D gf180mcu_as_sc_mcu7t3v3__ao211_2
XFILLER_102_1486 VDD VDD VSS VSS gf180mcu_as_sc_mcu7t3v3__fillcap_16
X_3516_ VDD VDD VSS VSS _3516_/B _3768_/A _4836_/D gf180mcu_as_sc_mcu7t3v3__and2_2
XFILLER_137_1527 VDD VDD VSS VSS gf180mcu_as_sc_mcu7t3v3__fillcap_8
XFILLER_172_1429 VDD VDD VSS VSS gf180mcu_as_sc_mcu7t3v3__fillcap_4
X_4496_ VDD VDD VSS VSS _5179_/Q _4496_/B _4505_/C _5113_/Q _4497_/B gf180mcu_as_sc_mcu7t3v3__ao22_2
XPHY_EDGE_ROW_44_3_Right_363 VDD VSS gf180mcu_as_sc_mcu7t3v3__tap_2
X_3447_ VDD VDD VSS VSS _4099_/A _3447_/B _3447_/C _4825_/D _3722_/D gf180mcu_as_sc_mcu7t3v3__aoi211_2
XFILLER_135_1262 VDD VDD VSS VSS gf180mcu_as_sc_mcu7t3v3__fillcap_8
XFILLER_69_162 VDD VDD VSS VSS gf180mcu_as_sc_mcu7t3v3__fill_1
X_3378_ VDD VDD VSS VSS _4927_/Q _3440_/B _3440_/C _4029_/A _3379_/A gf180mcu_as_sc_mcu7t3v3__ao22_2
XFILLER_170_1175 VDD VDD VSS VSS gf180mcu_as_sc_mcu7t3v3__fill_2
XFILLER_69_173 VDD VDD VSS VSS gf180mcu_as_sc_mcu7t3v3__fillcap_4
X_5117_ VDD VDD VSS VSS _5185_/CLK _5117_/D _5117_/Q gf180mcu_as_sc_mcu7t3v3__dfxtp_2
X_5048_ VDD VDD VSS VSS _5085_/CLK _5048_/D _5048_/Q gf180mcu_as_sc_mcu7t3v3__dfxtp_2
XFILLER_150_37 VDD VDD VSS VSS gf180mcu_as_sc_mcu7t3v3__fill_1
XFILLER_25_276 VDD VDD VSS VSS gf180mcu_as_sc_mcu7t3v3__fillcap_4
XFILLER_25_298 VDD VDD VSS VSS gf180mcu_as_sc_mcu7t3v3__fill_2
XTAP_TAPCELL_ROW_115_1_1096 VDD VSS gf180mcu_as_sc_mcu7t3v3__tap_2
XFILLER_138_101 VDD VDD VSS VSS gf180mcu_as_sc_mcu7t3v3__fillcap_4
XFILLER_138_134 VDD VDD VSS VSS gf180mcu_as_sc_mcu7t3v3__fillcap_16
XFILLER_139_646 VDD VDD VSS VSS gf180mcu_as_sc_mcu7t3v3__fillcap_4
XFILLER_167_966 VDD VDD VSS VSS gf180mcu_as_sc_mcu7t3v3__fillcap_8
XFILLER_40_279 VDD VDD VSS VSS gf180mcu_as_sc_mcu7t3v3__fillcap_16
XFILLER_153_104 VDD VDD VSS VSS gf180mcu_as_sc_mcu7t3v3__fillcap_16
XFILLER_175_34 VDD VDD VSS VSS gf180mcu_as_sc_mcu7t3v3__fillcap_16
XFILLER_182_947 VDD VDD VSS VSS gf180mcu_as_sc_mcu7t3v3__fill_2
XFILLER_104_2 VDD VDD VSS VSS gf180mcu_as_sc_mcu7t3v3__fillcap_8
XFILLER_134_362 VDD VDD VSS VSS gf180mcu_as_sc_mcu7t3v3__fill_1
XFILLER_162_693 VDD VDD VSS VSS gf180mcu_as_sc_mcu7t3v3__fillcap_16
XFILLER_4_18 VDD VDD VSS VSS gf180mcu_as_sc_mcu7t3v3__fillcap_16
XPHY_EDGE_ROW_23_1_Right_22 VDD VSS gf180mcu_as_sc_mcu7t3v3__tap_2
XTAP_TAPCELL_ROW_40_3_2410 VDD VSS gf180mcu_as_sc_mcu7t3v3__tap_2
XFILLER_175_1097 VDD VDD VSS VSS gf180mcu_as_sc_mcu7t3v3__fillcap_8
XFILLER_150_877 VDD VDD VSS VSS gf180mcu_as_sc_mcu7t3v3__fillcap_16
XFILLER_68_87 VDD VDD VSS VSS gf180mcu_as_sc_mcu7t3v3__fillcap_4
Xinput210 VDD VDD VSS VSS se_in[5] _3977_/A gf180mcu_as_sc_mcu7t3v3__buff_2
Xinput221 VDD VDD VSS VSS south_in[15] _4053_/D gf180mcu_as_sc_mcu7t3v3__buff_2
Xinput232 VDD VDD VSS VSS south_in[25] _4138_/D gf180mcu_as_sc_mcu7t3v3__buff_2
Xinput243 VDD VDD VSS VSS south_in[4] _3968_/D gf180mcu_as_sc_mcu7t3v3__buff_2
Xinput254 VDD VDD VSS VSS sw_in[14] _4050_/A gf180mcu_as_sc_mcu7t3v3__buff_2
XTAP_TAPCELL_ROW_10_1_675 VDD VSS gf180mcu_as_sc_mcu7t3v3__tap_2
XPHY_EDGE_ROW_119_1_Left_571 VDD VSS gf180mcu_as_sc_mcu7t3v3__tap_2
Xinput265 VDD VDD VSS VSS sw_in[24] _2446_/A gf180mcu_as_sc_mcu7t3v3__buff_2
Xinput276 VDD VDD VSS VSS sw_in[3] _2426_/A gf180mcu_as_sc_mcu7t3v3__buff_2
Xinput287 VDD VDD VSS VSS west_in[13] _4037_/D gf180mcu_as_sc_mcu7t3v3__buff_2
XTAP_TAPCELL_ROW_180_2220 VDD VSS gf180mcu_as_sc_mcu7t3v3__tap_2
Xinput298 VDD VDD VSS VSS west_in[23] _4118_/D gf180mcu_as_sc_mcu7t3v3__buff_2
XFILLER_147_1122 VDD VDD VSS VSS gf180mcu_as_sc_mcu7t3v3__fillcap_4
XFILLER_140_81 VDD VDD VSS VSS gf180mcu_as_sc_mcu7t3v3__fillcap_16
XFILLER_147_1177 VDD VDD VSS VSS gf180mcu_as_sc_mcu7t3v3__fill_1
XFILLER_38_1483 VDD VDD VSS VSS gf180mcu_as_sc_mcu7t3v3__fill_1
XTAP_TAPCELL_ROW_178_2182 VDD VSS gf180mcu_as_sc_mcu7t3v3__tap_2
XTAP_TAPCELL_ROW_178_2171 VDD VSS gf180mcu_as_sc_mcu7t3v3__tap_2
XFILLER_129_134 VDD VDD VSS VSS gf180mcu_as_sc_mcu7t3v3__fillcap_4
XFILLER_158_944 VDD VDD VSS VSS gf180mcu_as_sc_mcu7t3v3__fill_1
XFILLER_158_955 VDD VDD VSS VSS gf180mcu_as_sc_mcu7t3v3__fillcap_4
XFILLER_145_616 VDD VDD VSS VSS gf180mcu_as_sc_mcu7t3v3__fillcap_8
XFILLER_158_977 VDD VDD VSS VSS gf180mcu_as_sc_mcu7t3v3__fill_2
XFILLER_158_999 VDD VDD VSS VSS gf180mcu_as_sc_mcu7t3v3__fill_2
XFILLER_184_240 VDD VDD VSS VSS gf180mcu_as_sc_mcu7t3v3__fillcap_16
X_2680_ VDD VDD VSS VSS _2711_/S _4957_/Q _4966_/Q _2683_/A gf180mcu_as_sc_mcu7t3v3__mux2_2
XTAP_TAPCELL_ROW_174_2079 VDD VSS gf180mcu_as_sc_mcu7t3v3__tap_2
XFILLER_145_638 VDD VDD VSS VSS gf180mcu_as_sc_mcu7t3v3__fill_1
XFILLER_172_435 VDD VDD VSS VSS gf180mcu_as_sc_mcu7t3v3__fillcap_16
X_4876__991 VDD VDD VSS VSS _4876_/D gf180mcu_as_sc_mcu7t3v3__tiel_4
XTAP_TAPCELL_ROW_152_1610 VDD VSS gf180mcu_as_sc_mcu7t3v3__tap_2
XPHY_EDGE_ROW_9_3_Left_143 VDD VSS gf180mcu_as_sc_mcu7t3v3__tap_2
XFILLER_172_457 VDD VDD VSS VSS gf180mcu_as_sc_mcu7t3v3__fillcap_16
X_4350_ VDD VDD VSS VSS _4350_/A _5479_/A _4350_/C _4350_/D _4351_/A gf180mcu_as_sc_mcu7t3v3__ao22_2
X_3301_ VDD VDD VSS VSS _3952_/A _3514_/B _3301_/C _3301_/D _3302_/B gf180mcu_as_sc_mcu7t3v3__ao211_2
XFILLER_153_693 VDD VDD VSS VSS gf180mcu_as_sc_mcu7t3v3__fillcap_4
XFILLER_154_1126 VDD VDD VSS VSS gf180mcu_as_sc_mcu7t3v3__fillcap_8
X_4281_ VDD VDD VSS VSS _4281_/S _5485_/A _5115_/Q _5115_/D gf180mcu_as_sc_mcu7t3v3__mux2_2
X_3232_ VDD VDD VSS VSS _3232_/B _3768_/A _4802_/D gf180mcu_as_sc_mcu7t3v3__and2_2
XFILLER_100_218 VDD VDD VSS VSS gf180mcu_as_sc_mcu7t3v3__fillcap_4
XFILLER_100_229 VDD VDD VSS VSS gf180mcu_as_sc_mcu7t3v3__fillcap_16
XFILLER_140_387 VDD VDD VSS VSS gf180mcu_as_sc_mcu7t3v3__fillcap_4
Xmesh_tile_836 VDD VDD VSS VSS ne_out[11] gf180mcu_as_sc_mcu7t3v3__tiel_4
X_3163_ VDD VDD VSS VSS _4139_/A _3230_/S _3163_/C _3163_/D _3164_/C gf180mcu_as_sc_mcu7t3v3__ao22_2
Xmesh_tile_869 VDD VDD VSS VSS north_out[10] gf180mcu_as_sc_mcu7t3v3__tiel_4
Xmesh_tile_858 VDD VDD VSS VSS ne_out[33] gf180mcu_as_sc_mcu7t3v3__tiel_4
Xmesh_tile_847 VDD VDD VSS VSS ne_out[22] gf180mcu_as_sc_mcu7t3v3__tiel_4
X_3094_ VDD VDD VSS VSS _3145_/A _3094_/B _3094_/C _3145_/D _3095_/D gf180mcu_as_sc_mcu7t3v3__ao211_2
XTAP_TAPCELL_ROW_146_1469 VDD VSS gf180mcu_as_sc_mcu7t3v3__tap_2
XTAP_TAPCELL_ROW_146_1458 VDD VSS gf180mcu_as_sc_mcu7t3v3__tap_2
X_4883__984 VDD VDD VSS VSS _4883_/D gf180mcu_as_sc_mcu7t3v3__tiel_4
XFILLER_81_168 VDD VDD VSS VSS gf180mcu_as_sc_mcu7t3v3__fillcap_4
XFILLER_161_1108 VDD VDD VSS VSS gf180mcu_as_sc_mcu7t3v3__fill_1
XFILLER_165_1244 VDD VDD VSS VSS gf180mcu_as_sc_mcu7t3v3__fill_1
XFILLER_56_1550 VDD VDD VSS VSS gf180mcu_as_sc_mcu7t3v3__fillcap_4
XPHY_EDGE_ROW_40_1_Left_492 VDD VSS gf180mcu_as_sc_mcu7t3v3__tap_2
XFILLER_161_1119 VDD VDD VSS VSS gf180mcu_as_sc_mcu7t3v3__fill_1
XFILLER_165_1299 VDD VDD VSS VSS gf180mcu_as_sc_mcu7t3v3__fillcap_4
X_3996_ VDD VDD VSS VSS _4985_/Q _4166_/B _4236_/B _4166_/D _4985_/D gf180mcu_as_sc_mcu7t3v3__ao22_2
XFILLER_148_410 VDD VDD VSS VSS gf180mcu_as_sc_mcu7t3v3__fill_2
XFILLER_22_279 VDD VDD VSS VSS gf180mcu_as_sc_mcu7t3v3__fillcap_16
X_2947_ VDD VDD VSS VSS _2947_/Y _2947_/B _2947_/A gf180mcu_as_sc_mcu7t3v3__nor2_2
XFILLER_136_616 VDD VDD VSS VSS gf180mcu_as_sc_mcu7t3v3__fillcap_8
XFILLER_149_999 VDD VDD VSS VSS gf180mcu_as_sc_mcu7t3v3__fill_2
XFILLER_163_402 VDD VDD VSS VSS gf180mcu_as_sc_mcu7t3v3__fillcap_16
XFILLER_164_947 VDD VDD VSS VSS gf180mcu_as_sc_mcu7t3v3__fill_2
X_4617_ VDD VDD VSS VSS _5211_/Q _4623_/B _4623_/C _5212_/Q _5211_/D gf180mcu_as_sc_mcu7t3v3__ao22_2
X_2878_ VDD VDD VSS VSS _5265_/Q _5264_/Q _5266_/Q _2879_/B gf180mcu_as_sc_mcu7t3v3__nor3_2
XFILLER_135_137 VDD VDD VSS VSS gf180mcu_as_sc_mcu7t3v3__fill_2
XFILLER_159_1048 VDD VDD VSS VSS gf180mcu_as_sc_mcu7t3v3__fill_2
XFILLER_150_107 VDD VDD VSS VSS gf180mcu_as_sc_mcu7t3v3__fillcap_16
X_4890__977 VDD VDD VSS VSS _4890_/D gf180mcu_as_sc_mcu7t3v3__tiel_4
X_4548_ VDD VDD VSS VSS _5183_/Q _4548_/B _4548_/C _4548_/D _5183_/D gf180mcu_as_sc_mcu7t3v3__ao211_2
XFILLER_145_37 VDD VDD VSS VSS gf180mcu_as_sc_mcu7t3v3__fill_1
XFILLER_172_1215 VDD VDD VSS VSS gf180mcu_as_sc_mcu7t3v3__fill_2
X_4479_ VDD VDD VSS VSS _5177_/Q _4496_/B _4493_/C _5111_/Q _4480_/B gf180mcu_as_sc_mcu7t3v3__ao22_2
XFILLER_172_1259 VDD VDD VSS VSS gf180mcu_as_sc_mcu7t3v3__fillcap_8
XFILLER_63_1521 VDD VDD VSS VSS gf180mcu_as_sc_mcu7t3v3__fillcap_16
XFILLER_150_1535 VDD VDD VSS VSS gf180mcu_as_sc_mcu7t3v3__fillcap_4
XFILLER_38_24 VDD VDD VSS VSS gf180mcu_as_sc_mcu7t3v3__fillcap_8
XFILLER_57_110 VDD VDD VSS VSS gf180mcu_as_sc_mcu7t3v3__fill_1
XPHY_EDGE_ROW_45_3_Right_364 VDD VSS gf180mcu_as_sc_mcu7t3v3__tap_2
XFILLER_161_69 VDD VDD VSS VSS gf180mcu_as_sc_mcu7t3v3__fill_1
XFILLER_57_187 VDD VDD VSS VSS gf180mcu_as_sc_mcu7t3v3__fillcap_8
XFILLER_54_23 VDD VDD VSS VSS gf180mcu_as_sc_mcu7t3v3__fillcap_8
XFILLER_148_1453 VDD VDD VSS VSS gf180mcu_as_sc_mcu7t3v3__fillcap_16
XFILLER_183_1322 VDD VDD VSS VSS gf180mcu_as_sc_mcu7t3v3__fill_2
XFILLER_183_1366 VDD VDD VSS VSS gf180mcu_as_sc_mcu7t3v3__fillcap_8
XFILLER_183_1399 VDD VDD VSS VSS gf180mcu_as_sc_mcu7t3v3__fill_1
XFILLER_9_206 VDD VDD VSS VSS gf180mcu_as_sc_mcu7t3v3__fillcap_4
XFILLER_9_228 VDD VDD VSS VSS gf180mcu_as_sc_mcu7t3v3__fillcap_16
XFILLER_166_240 VDD VDD VSS VSS gf180mcu_as_sc_mcu7t3v3__fillcap_4
XFILLER_166_295 VDD VDD VSS VSS gf180mcu_as_sc_mcu7t3v3__fillcap_16
XFILLER_177_1115 VDD VDD VSS VSS gf180mcu_as_sc_mcu7t3v3__fillcap_4
XTAP_TAPCELL_ROW_3_1_647 VDD VSS gf180mcu_as_sc_mcu7t3v3__tap_2
XFILLER_154_457 VDD VDD VSS VSS gf180mcu_as_sc_mcu7t3v3__fillcap_16
XFILLER_182_777 VDD VDD VSS VSS gf180mcu_as_sc_mcu7t3v3__fillcap_16
XFILLER_155_1402 VDD VDD VSS VSS gf180mcu_as_sc_mcu7t3v3__fillcap_16
XFILLER_177_1159 VDD VDD VSS VSS gf180mcu_as_sc_mcu7t3v3__fillcap_4
XFILLER_181_276 VDD VDD VSS VSS gf180mcu_as_sc_mcu7t3v3__fillcap_4
XFILLER_181_298 VDD VDD VSS VSS gf180mcu_as_sc_mcu7t3v3__fillcap_16
XFILLER_0_161 VDD VDD VSS VSS gf180mcu_as_sc_mcu7t3v3__fillcap_8
XFILLER_0_172 VDD VDD VSS VSS gf180mcu_as_sc_mcu7t3v3__fillcap_16
XTAP_TAPCELL_ROW_117_1_1104 VDD VSS gf180mcu_as_sc_mcu7t3v3__tap_2
XFILLER_184_1108 VDD VDD VSS VSS gf180mcu_as_sc_mcu7t3v3__fill_1
XFILLER_127_1515 VDD VDD VSS VSS gf180mcu_as_sc_mcu7t3v3__fillcap_4
XTAP_TAPCELL_ROW_176_2119 VDD VSS gf180mcu_as_sc_mcu7t3v3__tap_2
XTAP_TAPCELL_ROW_141_1366 VDD VSS gf180mcu_as_sc_mcu7t3v3__tap_2
XTAP_TAPCELL_ROW_141_1355 VDD VSS gf180mcu_as_sc_mcu7t3v3__tap_2
XFILLER_127_1537 VDD VDD VSS VSS gf180mcu_as_sc_mcu7t3v3__fillcap_16
X_3850_ VDD VDD VSS VSS _3850_/A _5156_/Q _3850_/C _3851_/C gf180mcu_as_sc_mcu7t3v3__nand3_2
X_3781_ VDD VDD VSS VSS _3781_/S _3781_/B _3781_/A _3783_/C gf180mcu_as_sc_mcu7t3v3__mux2_2
X_2801_ VDD VDD VSS VSS _2847_/A _5245_/Q _4754_/Q _2805_/A gf180mcu_as_sc_mcu7t3v3__mux2_2
XFILLER_157_251 VDD VDD VSS VSS gf180mcu_as_sc_mcu7t3v3__fill_1
XFILLER_160_1152 VDD VDD VSS VSS gf180mcu_as_sc_mcu7t3v3__fill_2
XPHY_EDGE_ROW_101_3_Left_235 VDD VSS gf180mcu_as_sc_mcu7t3v3__tap_2
X_2732_ VDD VDD VSS VSS _4975_/Q _4964_/Q _4973_/Q _2734_/A gf180mcu_as_sc_mcu7t3v3__mux2_2
XFILLER_146_947 VDD VDD VSS VSS gf180mcu_as_sc_mcu7t3v3__fillcap_4
XFILLER_173_733 VDD VDD VSS VSS gf180mcu_as_sc_mcu7t3v3__fill_1
XFILLER_117_159 VDD VDD VSS VSS gf180mcu_as_sc_mcu7t3v3__fill_2
XFILLER_157_295 VDD VDD VSS VSS gf180mcu_as_sc_mcu7t3v3__fillcap_8
XFILLER_67_2 VDD VDD VSS VSS gf180mcu_as_sc_mcu7t3v3__fillcap_8
XFILLER_8_283 VDD VDD VSS VSS gf180mcu_as_sc_mcu7t3v3__fill_2
X_2663_ VDD VDD VSS VSS _2663_/A _2729_/B _2663_/C _2664_/C _2832_/S gf180mcu_as_sc_mcu7t3v3__aoi211_2
XFILLER_12_1486 VDD VDD VSS VSS gf180mcu_as_sc_mcu7t3v3__fillcap_16
XFILLER_173_788 VDD VDD VSS VSS gf180mcu_as_sc_mcu7t3v3__fill_2
X_4402_ VDD VDD VSS VSS _4405_/C _4980_/Q _4403_/S gf180mcu_as_sc_mcu7t3v3__nand2b_2
X_2594_ VDD VDD VSS VSS _2595_/A _2767_/A _4264_/A gf180mcu_as_sc_mcu7t3v3__nand2_2
XFILLER_158_1081 VDD VDD VSS VSS gf180mcu_as_sc_mcu7t3v3__fillcap_4
XFILLER_5_50 VDD VDD VSS VSS gf180mcu_as_sc_mcu7t3v3__fillcap_16
XFILLER_5_72 VDD VDD VSS VSS gf180mcu_as_sc_mcu7t3v3__fillcap_16
X_4333_ VDD VDD VSS VSS _4334_/B _4590_/B _4574_/B gf180mcu_as_sc_mcu7t3v3__and2_2
XFILLER_140_140 VDD VDD VSS VSS gf180mcu_as_sc_mcu7t3v3__fillcap_8
X_4264_ VDD VDD VSS VSS _4265_/C _5099_/Q _4264_/B _4264_/A gf180mcu_as_sc_mcu7t3v3__aoi21_2
X_3215_ VDD VDD VSS VSS _3228_/A _3215_/B _3215_/A _3216_/D gf180mcu_as_sc_mcu7t3v3__mux2_2
XTAP_TAPCELL_ROW_169_1970 VDD VSS gf180mcu_as_sc_mcu7t3v3__tap_2
XTAP_TAPCELL_ROW_148_1509 VDD VSS gf180mcu_as_sc_mcu7t3v3__tap_2
X_4195_ VDD VDD VSS VSS _4255_/B _4197_/B _4197_/C _5033_/Q _5033_/D gf180mcu_as_sc_mcu7t3v3__ao22_2
XTAP_TAPCELL_ROW_169_1981 VDD VSS gf180mcu_as_sc_mcu7t3v3__tap_2
X_3146_ VDD VDD VSS VSS _3168_/B _4938_/Q _3147_/D gf180mcu_as_sc_mcu7t3v3__or2_2
XTAP_TAPCELL_ROW_165_1878 VDD VSS gf180mcu_as_sc_mcu7t3v3__tap_2
XFILLER_39_187 VDD VDD VSS VSS gf180mcu_as_sc_mcu7t3v3__fillcap_16
X_3077_ VDD VDD VSS VSS _3120_/A _3077_/B _3077_/C _3120_/D _3079_/C gf180mcu_as_sc_mcu7t3v3__ao211_2
XTAP_TAPCELL_ROW_165_1889 VDD VSS gf180mcu_as_sc_mcu7t3v3__tap_2
XFILLER_167_1339 VDD VDD VSS VSS gf180mcu_as_sc_mcu7t3v3__fillcap_16
XFILLER_165_1052 VDD VDD VSS VSS gf180mcu_as_sc_mcu7t3v3__fillcap_8
XFILLER_165_1074 VDD VDD VSS VSS gf180mcu_as_sc_mcu7t3v3__fillcap_4
XFILLER_168_527 VDD VDD VSS VSS gf180mcu_as_sc_mcu7t3v3__fill_2
XFILLER_180_1539 VDD VDD VSS VSS gf180mcu_as_sc_mcu7t3v3__fillcap_16
XFILLER_24_37 VDD VDD VSS VSS gf180mcu_as_sc_mcu7t3v3__fillcap_16
XFILLER_149_741 VDD VDD VSS VSS gf180mcu_as_sc_mcu7t3v3__fillcap_16
XPHY_EDGE_ROW_33_3_Left_167 VDD VSS gf180mcu_as_sc_mcu7t3v3__tap_2
XFILLER_148_251 VDD VDD VSS VSS gf180mcu_as_sc_mcu7t3v3__fill_1
X_3979_ VDD VDD VSS VSS _3979_/B _4165_/A _4234_/B gf180mcu_as_sc_mcu7t3v3__and2_2
XFILLER_108_104 VDD VDD VSS VSS gf180mcu_as_sc_mcu7t3v3__fill_1
XFILLER_136_402 VDD VDD VSS VSS gf180mcu_as_sc_mcu7t3v3__fillcap_8
XFILLER_149_796 VDD VDD VSS VSS gf180mcu_as_sc_mcu7t3v3__fillcap_4
XFILLER_6_209 VDD VDD VSS VSS gf180mcu_as_sc_mcu7t3v3__fillcap_16
XFILLER_136_457 VDD VDD VSS VSS gf180mcu_as_sc_mcu7t3v3__fillcap_8
XFILLER_164_777 VDD VDD VSS VSS gf180mcu_as_sc_mcu7t3v3__fillcap_16
XFILLER_156_69 VDD VDD VSS VSS gf180mcu_as_sc_mcu7t3v3__fillcap_16
XFILLER_30_1564 VDD VDD VSS VSS gf180mcu_as_sc_mcu7t3v3__fillcap_4
XFILLER_163_298 VDD VDD VSS VSS gf180mcu_as_sc_mcu7t3v3__fillcap_8
XFILLER_172_1001 VDD VDD VSS VSS gf180mcu_as_sc_mcu7t3v3__fill_1
XFILLER_172_1045 VDD VDD VSS VSS gf180mcu_as_sc_mcu7t3v3__fillcap_8
XFILLER_49_23 VDD VDD VSS VSS gf180mcu_as_sc_mcu7t3v3__fillcap_16
XFILLER_77_216 VDD VDD VSS VSS gf180mcu_as_sc_mcu7t3v3__fill_2
Xfanout730 VDD VDD VSS VSS _2894_/Y _3143_/S gf180mcu_as_sc_mcu7t3v3__buff_2
XFILLER_150_1321 VDD VDD VSS VSS gf180mcu_as_sc_mcu7t3v3__fill_2
XPHY_EDGE_ROW_46_3_Right_365 VDD VSS gf180mcu_as_sc_mcu7t3v3__tap_2
Xfanout752 VDD VDD VSS VSS _5224_/Q _4652_/B gf180mcu_as_sc_mcu7t3v3__buff_2
Xfanout763 VDD VDD VSS VSS _4588_/A _4587_/A gf180mcu_as_sc_mcu7t3v3__buff_2
Xfanout774 VDD VDD VSS VSS _4536_/S _4552_/A gf180mcu_as_sc_mcu7t3v3__buff_2
Xfanout785 VDD VDD VSS VSS _2560_/Y _2735_/D gf180mcu_as_sc_mcu7t3v3__buff_2
XFILLER_85_260 VDD VDD VSS VSS gf180mcu_as_sc_mcu7t3v3__fill_2
Xfanout796 VDD VDD VSS VSS _3909_/A _3825_/C gf180mcu_as_sc_mcu7t3v3__buff_2
XFILLER_171_2 VDD VDD VSS VSS gf180mcu_as_sc_mcu7t3v3__fillcap_16
XFILLER_45_135 VDD VDD VSS VSS gf180mcu_as_sc_mcu7t3v3__fillcap_4
XFILLER_85_282 VDD VDD VSS VSS gf180mcu_as_sc_mcu7t3v3__fillcap_16
XFILLER_121_72 VDD VDD VSS VSS gf180mcu_as_sc_mcu7t3v3__fillcap_16
XFILLER_144_1103 VDD VDD VSS VSS gf180mcu_as_sc_mcu7t3v3__fillcap_4
XFILLER_183_1152 VDD VDD VSS VSS gf180mcu_as_sc_mcu7t3v3__fillcap_8
XFILLER_144_1136 VDD VDD VSS VSS gf180mcu_as_sc_mcu7t3v3__fillcap_4
XFILLER_161_1472 VDD VDD VSS VSS gf180mcu_as_sc_mcu7t3v3__fillcap_16
XTAP_TAPCELL_ROW_171_2016 VDD VSS gf180mcu_as_sc_mcu7t3v3__tap_2
XTAP_TAPCELL_ROW_171_2027 VDD VSS gf180mcu_as_sc_mcu7t3v3__tap_2
XFILLER_122_1467 VDD VDD VSS VSS gf180mcu_as_sc_mcu7t3v3__fillcap_16
XFILLER_139_295 VDD VDD VSS VSS gf180mcu_as_sc_mcu7t3v3__fillcap_8
XFILLER_114_107 VDD VDD VSS VSS gf180mcu_as_sc_mcu7t3v3__fillcap_8
XFILLER_143_928 VDD VDD VSS VSS gf180mcu_as_sc_mcu7t3v3__fillcap_16
XFILLER_155_788 VDD VDD VSS VSS gf180mcu_as_sc_mcu7t3v3__fill_2
XFILLER_182_563 VDD VDD VSS VSS gf180mcu_as_sc_mcu7t3v3__fillcap_16
X_4873__994 VDD VDD VSS VSS _4873_/D gf180mcu_as_sc_mcu7t3v3__tiel_4
XFILLER_136_991 VDD VDD VSS VSS gf180mcu_as_sc_mcu7t3v3__fillcap_8
XFILLER_170_758 VDD VDD VSS VSS gf180mcu_as_sc_mcu7t3v3__fill_1
XFILLER_170_769 VDD VDD VSS VSS gf180mcu_as_sc_mcu7t3v3__fill_1
XTAP_TAPCELL_ROW_134_1181 VDD VSS gf180mcu_as_sc_mcu7t3v3__tap_2
XTAP_TAPCELL_ROW_134_1170 VDD VSS gf180mcu_as_sc_mcu7t3v3__tap_2
XFILLER_122_140 VDD VDD VSS VSS gf180mcu_as_sc_mcu7t3v3__fillcap_4
XFILLER_151_961 VDD VDD VSS VSS gf180mcu_as_sc_mcu7t3v3__fillcap_16
XTAP_TAPCELL_ROW_134_1192 VDD VSS gf180mcu_as_sc_mcu7t3v3__tap_2
XFILLER_81_1451 VDD VDD VSS VSS gf180mcu_as_sc_mcu7t3v3__fillcap_16
Xclkbuf_leaf_4_clk_regs VDD VDD VSS VSS clkbuf_3_1_0_clk_regs/Y clkload4/A gf180mcu_as_sc_mcu7t3v3__clkbuff_12
Xinput7 VDD VDD VSS VSS boot_addr[5] input7/Y gf180mcu_as_sc_mcu7t3v3__buff_2
X_3000_ VDD VDD VSS VSS _3118_/S _3981_/A _3983_/A _3002_/B gf180mcu_as_sc_mcu7t3v3__mux2_2
XTAP_TAPCELL_ROW_143_1406 VDD VSS gf180mcu_as_sc_mcu7t3v3__tap_2
X_4951_ VDD VDD VSS VSS _5159_/CLK _4951_/D _4951_/Q gf180mcu_as_sc_mcu7t3v3__dfxtp_2
X_4880__987 VDD VDD VSS VSS _4880_/D gf180mcu_as_sc_mcu7t3v3__tiel_4
XFILLER_166_1361 VDD VDD VSS VSS gf180mcu_as_sc_mcu7t3v3__fillcap_4
XFILLER_51_138 VDD VDD VSS VSS gf180mcu_as_sc_mcu7t3v3__fill_2
X_4882_ VDD VDD VSS VSS _4943_/CLK _4882_/D _4882_/Q gf180mcu_as_sc_mcu7t3v3__dfxtp_2
X_3902_ VDD VDD VSS VSS _3908_/B _5160_/Q _4942_/D gf180mcu_as_sc_mcu7t3v3__and2_2
XTAP_TAPCELL_ROW_41_1_799 VDD VSS gf180mcu_as_sc_mcu7t3v3__tap_2
XTAP_TAPCELL_ROW_160_1786 VDD VSS gf180mcu_as_sc_mcu7t3v3__tap_2
XTAP_TAPCELL_ROW_160_1775 VDD VSS gf180mcu_as_sc_mcu7t3v3__tap_2
XFILLER_177_346 VDD VDD VSS VSS gf180mcu_as_sc_mcu7t3v3__fillcap_4
X_3833_ VDD VDD VSS VSS _4910_/D _4753_/B _4753_/A gf180mcu_as_sc_mcu7t3v3__nor2_2
XFILLER_162_1269 VDD VDD VSS VSS gf180mcu_as_sc_mcu7t3v3__fillcap_16
XFILLER_177_368 VDD VDD VSS VSS gf180mcu_as_sc_mcu7t3v3__fillcap_16
XFILLER_53_1553 VDD VDD VSS VSS gf180mcu_as_sc_mcu7t3v3__fillcap_16
X_3764_ VDD VDD VSS VSS _4143_/A _3781_/S _3764_/C _3764_/D _3765_/D gf180mcu_as_sc_mcu7t3v3__ao211_2
X_3695_ VDD VDD VSS VSS _4069_/D _3742_/B _3695_/C _3695_/D _3696_/C gf180mcu_as_sc_mcu7t3v3__ao211_2
X_2715_ VDD VDD VSS VSS _2716_/D _2716_/A _2729_/B _2715_/A gf180mcu_as_sc_mcu7t3v3__aoi21b_2
XFILLER_134_917 VDD VDD VSS VSS gf180mcu_as_sc_mcu7t3v3__fill_1
XFILLER_145_265 VDD VDD VSS VSS gf180mcu_as_sc_mcu7t3v3__fill_2
XFILLER_146_777 VDD VDD VSS VSS gf180mcu_as_sc_mcu7t3v3__fillcap_8
XFILLER_146_799 VDD VDD VSS VSS gf180mcu_as_sc_mcu7t3v3__fillcap_4
X_2646_ VDD VDD VSS VSS _2653_/S _2646_/B _5264_/Q _2649_/B gf180mcu_as_sc_mcu7t3v3__mux2_2
XFILLER_160_213 VDD VDD VSS VSS gf180mcu_as_sc_mcu7t3v3__fill_2
Xoutput344 VDD VDD VSS VSS _4866_/Q east_out[27] gf180mcu_as_sc_mcu7t3v3__buff_2
Xoutput333 VDD VDD VSS VSS _4856_/Q east_out[17] gf180mcu_as_sc_mcu7t3v3__buff_2
Xoutput322 VDD VDD VSS VSS _5483_/Y dft_rdata[5] gf180mcu_as_sc_mcu7t3v3__buff_2
XFILLER_173_1354 VDD VDD VSS VSS gf180mcu_as_sc_mcu7t3v3__fillcap_16
Xoutput377 VDD VDD VSS VSS _4797_/Q se_out[26] gf180mcu_as_sc_mcu7t3v3__buff_2
Xoutput366 VDD VDD VSS VSS _4787_/Q se_out[16] gf180mcu_as_sc_mcu7t3v3__buff_2
Xoutput355 VDD VDD VSS VSS _4845_/Q east_out[6] gf180mcu_as_sc_mcu7t3v3__buff_2
X_2577_ VDD VDD VSS VSS _2599_/A _2601_/D _4262_/B gf180mcu_as_sc_mcu7t3v3__or2_2
XFILLER_138_1496 VDD VDD VSS VSS gf180mcu_as_sc_mcu7t3v3__fillcap_8
XFILLER_141_471 VDD VDD VSS VSS gf180mcu_as_sc_mcu7t3v3__fillcap_16
XFILLER_173_1376 VDD VDD VSS VSS gf180mcu_as_sc_mcu7t3v3__fill_1
Xoutput399 VDD VDD VSS VSS _4820_/Q south_out[15] gf180mcu_as_sc_mcu7t3v3__buff_2
Xoutput388 VDD VDD VSS VSS _4776_/Q se_out[5] gf180mcu_as_sc_mcu7t3v3__buff_2
X_4316_ VDD VDD VSS VSS _4321_/S _5146_/Q _5145_/Q _5145_/D gf180mcu_as_sc_mcu7t3v3__mux2_2
XTAP_TAPCELL_ROW_167_1929 VDD VSS gf180mcu_as_sc_mcu7t3v3__tap_2
XFILLER_59_249 VDD VDD VSS VSS gf180mcu_as_sc_mcu7t3v3__fill_2
XFILLER_60_1502 VDD VDD VSS VSS gf180mcu_as_sc_mcu7t3v3__fillcap_16
X_4247_ VDD VDD VSS VSS _4250_/S _4247_/B _5083_/Q _5083_/D gf180mcu_as_sc_mcu7t3v3__mux2_2
XFILLER_142_16 VDD VDD VSS VSS gf180mcu_as_sc_mcu7t3v3__fillcap_16
XFILLER_60_1568 VDD VDD VSS VSS gf180mcu_as_sc_mcu7t3v3__fill_1
X_4178_ VDD VDD VSS VSS _4238_/B _4187_/B _4190_/C _5016_/Q _5016_/D gf180mcu_as_sc_mcu7t3v3__ao22_2
XFILLER_67_282 VDD VDD VSS VSS gf180mcu_as_sc_mcu7t3v3__fillcap_16
XFILLER_35_14 VDD VDD VSS VSS gf180mcu_as_sc_mcu7t3v3__fillcap_16
XFILLER_3_1451 VDD VDD VSS VSS gf180mcu_as_sc_mcu7t3v3__fillcap_16
XFILLER_82_241 VDD VDD VSS VSS gf180mcu_as_sc_mcu7t3v3__fillcap_4
X_3129_ VDD VDD VSS VSS _3137_/B _4936_/Q _3130_/D gf180mcu_as_sc_mcu7t3v3__or2_2
XPHY_EDGE_ROW_159_Right_293 VDD VSS gf180mcu_as_sc_mcu7t3v3__tap_2
XFILLER_184_1461 VDD VDD VSS VSS gf180mcu_as_sc_mcu7t3v3__fill_1
XFILLER_35_190 VDD VDD VSS VSS gf180mcu_as_sc_mcu7t3v3__fillcap_16
XFILLER_58_1486 VDD VDD VSS VSS gf180mcu_as_sc_mcu7t3v3__fillcap_16
XPHY_EDGE_ROW_32_1_Right_31 VDD VSS gf180mcu_as_sc_mcu7t3v3__tap_2
XFILLER_180_1325 VDD VDD VSS VSS gf180mcu_as_sc_mcu7t3v3__fill_2
XFILLER_50_160 VDD VDD VSS VSS gf180mcu_as_sc_mcu7t3v3__fill_2
XFILLER_51_24 VDD VDD VSS VSS gf180mcu_as_sc_mcu7t3v3__fillcap_8
XFILLER_137_788 VDD VDD VSS VSS gf180mcu_as_sc_mcu7t3v3__fillcap_8
XFILLER_164_585 VDD VDD VSS VSS gf180mcu_as_sc_mcu7t3v3__fill_2
XPHY_EDGE_ROW_128_1_Left_580 VDD VSS gf180mcu_as_sc_mcu7t3v3__tap_2
XFILLER_139_1249 VDD VDD VSS VSS gf180mcu_as_sc_mcu7t3v3__fillcap_8
XFILLER_2_201 VDD VDD VSS VSS gf180mcu_as_sc_mcu7t3v3__fill_2
XFILLER_116_61 VDD VDD VSS VSS gf180mcu_as_sc_mcu7t3v3__fill_1
Xfanout560 VDD VDD VSS VSS _2945_/Y fanout560/Y gf180mcu_as_sc_mcu7t3v3__buff_2
XFILLER_76_65 VDD VDD VSS VSS gf180mcu_as_sc_mcu7t3v3__fillcap_4
Xfanout571 VDD VDD VSS VSS _4124_/D fanout571/Y gf180mcu_as_sc_mcu7t3v3__buff_2
Xfanout582 VDD VDD VSS VSS fanout583/Y _3142_/B gf180mcu_as_sc_mcu7t3v3__buff_2
Xfanout593 VDD VDD VSS VSS fanout597/Y _4161_/B gf180mcu_as_sc_mcu7t3v3__buff_2
XFILLER_150_1173 VDD VDD VSS VSS gf180mcu_as_sc_mcu7t3v3__fill_1
XPHY_EDGE_ROW_47_3_Right_366 VDD VSS gf180mcu_as_sc_mcu7t3v3__tap_2
XFILLER_37_1515 VDD VDD VSS VSS gf180mcu_as_sc_mcu7t3v3__fillcap_4
XFILLER_76_1564 VDD VDD VSS VSS gf180mcu_as_sc_mcu7t3v3__fillcap_4
XFILLER_159_335 VDD VDD VSS VSS gf180mcu_as_sc_mcu7t3v3__fill_1
XFILLER_37_1537 VDD VDD VSS VSS gf180mcu_as_sc_mcu7t3v3__fillcap_16
XFILLER_124_1518 VDD VDD VSS VSS gf180mcu_as_sc_mcu7t3v3__fillcap_16
XFILLER_159_368 VDD VDD VSS VSS gf180mcu_as_sc_mcu7t3v3__fillcap_4
XFILLER_41_160 VDD VDD VSS VSS gf180mcu_as_sc_mcu7t3v3__fill_1
XFILLER_174_349 VDD VDD VSS VSS gf180mcu_as_sc_mcu7t3v3__fillcap_16
XFILLER_127_254 VDD VDD VSS VSS gf180mcu_as_sc_mcu7t3v3__fill_1
XFILLER_183_894 VDD VDD VSS VSS gf180mcu_as_sc_mcu7t3v3__fill_1
X_3480_ VDD VDD VSS VSS _4135_/D _3500_/B _3480_/C _3480_/D _3482_/C gf180mcu_as_sc_mcu7t3v3__ao211_2
X_2500_ VDD VDD VSS VSS _2525_/A _5229_/Q _2502_/C gf180mcu_as_sc_mcu7t3v3__and2_2
XTAP_TAPCELL_ROW_136_1254 VDD VSS gf180mcu_as_sc_mcu7t3v3__tap_2
XTAP_TAPCELL_ROW_136_1243 VDD VSS gf180mcu_as_sc_mcu7t3v3__tap_2
XFILLER_127_298 VDD VDD VSS VSS gf180mcu_as_sc_mcu7t3v3__fill_2
XFILLER_143_736 VDD VDD VSS VSS gf180mcu_as_sc_mcu7t3v3__fillcap_16
X_2431_ VDD VDD VSS VSS _3639_/A _4010_/A gf180mcu_as_sc_mcu7t3v3__inv_2
X_5150_ VDD VDD VSS VSS clkload9/A _5150_/D _5150_/Q gf180mcu_as_sc_mcu7t3v3__dfxtp_2
XFILLER_110_121 VDD VDD VSS VSS gf180mcu_as_sc_mcu7t3v3__fillcap_16
X_5081_ VDD VDD VSS VSS _5081_/CLK _5081_/D _5081_/Q gf180mcu_as_sc_mcu7t3v3__dfxtp_2
X_4101_ VDD VDD VSS VSS _4101_/A _4101_/B _4101_/C _4101_/D _4103_/C gf180mcu_as_sc_mcu7t3v3__ao22_2
X_4032_ VDD VDD VSS VSS _4032_/A _4119_/B _4118_/B _4032_/D _4033_/D gf180mcu_as_sc_mcu7t3v3__ao22_2
XFILLER_49_282 VDD VDD VSS VSS gf180mcu_as_sc_mcu7t3v3__fillcap_16
XTAP_TAPCELL_ROW_162_1826 VDD VSS gf180mcu_as_sc_mcu7t3v3__tap_2
XTAP_TAPCELL_ROW_162_1815 VDD VSS gf180mcu_as_sc_mcu7t3v3__tap_2
XFILLER_64_241 VDD VDD VSS VSS gf180mcu_as_sc_mcu7t3v3__fillcap_4
XFILLER_64_263 VDD VDD VSS VSS gf180mcu_as_sc_mcu7t3v3__fillcap_16
XFILLER_17_190 VDD VDD VSS VSS gf180mcu_as_sc_mcu7t3v3__fillcap_16
X_4934_ VDD VDD VSS VSS _5085_/CLK VSS _4934_/Q gf180mcu_as_sc_mcu7t3v3__dfxtp_2
XFILLER_162_1033 VDD VDD VSS VSS gf180mcu_as_sc_mcu7t3v3__fillcap_16
XTAP_TAPCELL_ROW_81_3_2471 VDD VSS gf180mcu_as_sc_mcu7t3v3__tap_2
XFILLER_138_508 VDD VDD VSS VSS gf180mcu_as_sc_mcu7t3v3__fillcap_16
XFILLER_166_817 VDD VDD VSS VSS gf180mcu_as_sc_mcu7t3v3__fill_1
XFILLER_32_171 VDD VDD VSS VSS gf180mcu_as_sc_mcu7t3v3__fillcap_4
XFILLER_32_193 VDD VDD VSS VSS gf180mcu_as_sc_mcu7t3v3__fillcap_16
X_4865_ VDD VDD VSS VSS _5046_/CLK _4865_/D _4865_/Q gf180mcu_as_sc_mcu7t3v3__dfxtp_2
XFILLER_178_688 VDD VDD VSS VSS gf180mcu_as_sc_mcu7t3v3__fill_1
X_4796_ VDD VDD VSS VSS _5046_/CLK _4796_/D _4796_/Q gf180mcu_as_sc_mcu7t3v3__dfxtp_2
X_3816_ VDD VDD VSS VSS _3928_/A _3818_/B _3818_/A gf180mcu_as_sc_mcu7t3v3__nand2_2
XFILLER_105_1451 VDD VDD VSS VSS gf180mcu_as_sc_mcu7t3v3__fillcap_16
XFILLER_165_349 VDD VDD VSS VSS gf180mcu_as_sc_mcu7t3v3__fill_1
X_3747_ VDD VDD VSS VSS _3747_/B _4128_/A _3749_/C gf180mcu_as_sc_mcu7t3v3__and2_2
XFILLER_140_1375 VDD VDD VSS VSS gf180mcu_as_sc_mcu7t3v3__fillcap_4
XFILLER_146_563 VDD VDD VSS VSS gf180mcu_as_sc_mcu7t3v3__fillcap_8
X_3678_ VDD VDD VSS VSS _3679_/C _4053_/A _3717_/B _3678_/C gf180mcu_as_sc_mcu7t3v3__ao21_2
X_2629_ VDD VDD VSS VSS _2832_/S _2629_/B _2629_/A _2629_/Y gf180mcu_as_sc_mcu7t3v3__mux2_2
XFILLER_133_279 VDD VDD VSS VSS gf180mcu_as_sc_mcu7t3v3__fill_1
XFILLER_173_1151 VDD VDD VSS VSS gf180mcu_as_sc_mcu7t3v3__fillcap_8
XFILLER_87_300 VDD VDD VSS VSS gf180mcu_as_sc_mcu7t3v3__fill_1
XFILLER_134_1124 VDD VDD VSS VSS gf180mcu_as_sc_mcu7t3v3__fill_1
XFILLER_47_208 VDD VDD VSS VSS gf180mcu_as_sc_mcu7t3v3__fill_2
X_5279_ VDD VDD VSS VSS clkload1/A _5279_/D _5279_/Q gf180mcu_as_sc_mcu7t3v3__dfxtp_2
XFILLER_46_24 VDD VDD VSS VSS gf180mcu_as_sc_mcu7t3v3__fillcap_8
XFILLER_99_1553 VDD VDD VSS VSS gf180mcu_as_sc_mcu7t3v3__fillcap_8
XFILLER_70_200 VDD VDD VSS VSS gf180mcu_as_sc_mcu7t3v3__fill_2
XFILLER_11_300 VDD VDD VSS VSS gf180mcu_as_sc_mcu7t3v3__fill_1
XFILLER_141_1106 VDD VDD VSS VSS gf180mcu_as_sc_mcu7t3v3__fill_2
XFILLER_178_34 VDD VDD VSS VSS gf180mcu_as_sc_mcu7t3v3__fill_1
XFILLER_134_2 VDD VDD VSS VSS gf180mcu_as_sc_mcu7t3v3__fillcap_16
XFILLER_145_1297 VDD VDD VSS VSS gf180mcu_as_sc_mcu7t3v3__fillcap_16
XFILLER_184_614 VDD VDD VSS VSS gf180mcu_as_sc_mcu7t3v3__fillcap_8
XFILLER_7_18 VDD VDD VSS VSS gf180mcu_as_sc_mcu7t3v3__fillcap_16
XFILLER_183_124 VDD VDD VSS VSS gf180mcu_as_sc_mcu7t3v3__fill_2
XFILLER_71_1483 VDD VDD VSS VSS gf180mcu_as_sc_mcu7t3v3__fillcap_16
XFILLER_32_1467 VDD VDD VSS VSS gf180mcu_as_sc_mcu7t3v3__fillcap_16
XFILLER_109_298 VDD VDD VSS VSS gf180mcu_as_sc_mcu7t3v3__fill_2
XFILLER_137_585 VDD VDD VSS VSS gf180mcu_as_sc_mcu7t3v3__fillcap_4
XFILLER_152_577 VDD VDD VSS VSS gf180mcu_as_sc_mcu7t3v3__fill_1
XFILLER_87_64 VDD VDD VSS VSS gf180mcu_as_sc_mcu7t3v3__fillcap_4
XFILLER_152_1257 VDD VDD VSS VSS gf180mcu_as_sc_mcu7t3v3__fillcap_8
XTAP_TAPCELL_ROW_183_2284 VDD VSS gf180mcu_as_sc_mcu7t3v3__tap_2
XTAP_TAPCELL_ROW_183_2273 VDD VSS gf180mcu_as_sc_mcu7t3v3__tap_2
XPHY_EDGE_ROW_110_3_Left_244 VDD VSS gf180mcu_as_sc_mcu7t3v3__tap_2
XPHY_EDGE_ROW_48_3_Right_367 VDD VSS gf180mcu_as_sc_mcu7t3v3__tap_2
XFILLER_46_263 VDD VDD VSS VSS gf180mcu_as_sc_mcu7t3v3__fillcap_16
XFILLER_146_1017 VDD VDD VSS VSS gf180mcu_as_sc_mcu7t3v3__fillcap_8
XFILLER_128_1451 VDD VDD VSS VSS gf180mcu_as_sc_mcu7t3v3__fillcap_16
XFILLER_163_1320 VDD VDD VSS VSS gf180mcu_as_sc_mcu7t3v3__fillcap_4
XFILLER_61_277 VDD VDD VSS VSS gf180mcu_as_sc_mcu7t3v3__fill_2
X_2980_ VDD VDD VSS VSS _3156_/A _2980_/B _2980_/C _2981_/C gf180mcu_as_sc_mcu7t3v3__nor3_2
XFILLER_14_171 VDD VDD VSS VSS gf180mcu_as_sc_mcu7t3v3__fillcap_4
XFILLER_148_839 VDD VDD VSS VSS gf180mcu_as_sc_mcu7t3v3__fillcap_16
XFILLER_14_193 VDD VDD VSS VSS gf180mcu_as_sc_mcu7t3v3__fillcap_16
X_4650_ VDD VDD VSS VSS _4651_/B _4733_/A _5237_/Q _4657_/B gf180mcu_as_sc_mcu7t3v3__ao21_2
XFILLER_147_349 VDD VDD VSS VSS gf180mcu_as_sc_mcu7t3v3__fill_1
XFILLER_50_1534 VDD VDD VSS VSS gf180mcu_as_sc_mcu7t3v3__fillcap_16
Xinput10 VDD VDD VSS VSS boot_addr[8] _2671_/A gf180mcu_as_sc_mcu7t3v3__buff_2
Xinput21 VDD VDD VSS VSS boot_wen _2831_/B gf180mcu_as_sc_mcu7t3v3__buff_2
X_3601_ VDD VDD VSS VSS _3971_/A _3707_/B _3601_/C _4843_/D _3601_/D gf180mcu_as_sc_mcu7t3v3__aoi211_2
XFILLER_50_1556 VDD VDD VSS VSS gf180mcu_as_sc_mcu7t3v3__fillcap_8
Xinput32 VDD VDD VSS VSS dft_addr[9] _2676_/B gf180mcu_as_sc_mcu7t3v3__buff_2
Xinput54 VDD VDD VSS VSS east_in[19] _4088_/A gf180mcu_as_sc_mcu7t3v3__buff_2
Xinput43 VDD VDD VSS VSS dft_we _2451_/A gf180mcu_as_sc_mcu7t3v3__buff_2
X_4581_ VDD VDD VSS VSS _4581_/D _4581_/A _4581_/B _4581_/C _4582_/B gf180mcu_as_sc_mcu7t3v3__ao31_2
XTAP_TAPCELL_ROW_155_1674 VDD VSS gf180mcu_as_sc_mcu7t3v3__tap_2
XTAP_TAPCELL_ROW_155_1663 VDD VSS gf180mcu_as_sc_mcu7t3v3__tap_2
XTAP_TAPCELL_ROW_124_1_1130 VDD VSS gf180mcu_as_sc_mcu7t3v3__tap_2
XFILLER_143_533 VDD VDD VSS VSS gf180mcu_as_sc_mcu7t3v3__fill_1
XFILLER_171_842 VDD VDD VSS VSS gf180mcu_as_sc_mcu7t3v3__fillcap_16
XFILLER_183_680 VDD VDD VSS VSS gf180mcu_as_sc_mcu7t3v3__fill_1
XFILLER_183_691 VDD VDD VSS VSS gf180mcu_as_sc_mcu7t3v3__fill_2
Xinput98 VDD VDD VSS VSS ne_in[28] _4160_/A gf180mcu_as_sc_mcu7t3v3__buff_2
Xinput87 VDD VDD VSS VSS ne_in[18] _4077_/A gf180mcu_as_sc_mcu7t3v3__buff_2
Xinput76 VDD VDD VSS VSS east_in[8] _4000_/A gf180mcu_as_sc_mcu7t3v3__buff_2
Xinput65 VDD VDD VSS VSS east_in[29] _3789_/A gf180mcu_as_sc_mcu7t3v3__buff_2
X_3532_ VDD VDD VSS VSS _3728_/B _3551_/A gf180mcu_as_sc_mcu7t3v3__inv_2
X_3463_ VDD VDD VSS VSS _4115_/A _3477_/B _3463_/C _4827_/D _3753_/D gf180mcu_as_sc_mcu7t3v3__aoi211_2
XFILLER_115_279 VDD VDD VSS VSS gf180mcu_as_sc_mcu7t3v3__fill_1
XFILLER_69_300 VDD VDD VSS VSS gf180mcu_as_sc_mcu7t3v3__fill_1
X_5202_ VDD VDD VSS VSS clkload3/A _5202_/D _5202_/Q gf180mcu_as_sc_mcu7t3v3__dfxtp_2
X_2414_ VDD VDD VSS VSS _3850_/A _5155_/Q gf180mcu_as_sc_mcu7t3v3__inv_2
XFILLER_170_1313 VDD VDD VSS VSS gf180mcu_as_sc_mcu7t3v3__fillcap_8
X_5133_ VDD VDD VSS VSS _5199_/CLK _5133_/D _5133_/Q gf180mcu_as_sc_mcu7t3v3__dfxtp_2
X_3394_ VDD VDD VSS VSS _3471_/B _4046_/D _3395_/D gf180mcu_as_sc_mcu7t3v3__and2_2
XFILLER_135_1466 VDD VDD VSS VSS gf180mcu_as_sc_mcu7t3v3__fillcap_4
XFILLER_135_1488 VDD VDD VSS VSS gf180mcu_as_sc_mcu7t3v3__fill_2
XFILLER_170_1346 VDD VDD VSS VSS gf180mcu_as_sc_mcu7t3v3__fillcap_16
XTAP_TAPCELL_ROW_104_1_1050 VDD VSS gf180mcu_as_sc_mcu7t3v3__tap_2
XFILLER_123_18 VDD VDD VSS VSS gf180mcu_as_sc_mcu7t3v3__fillcap_16
XFILLER_96_174 VDD VDD VSS VSS gf180mcu_as_sc_mcu7t3v3__fill_1
XPHY_EDGE_ROW_42_3_Left_176 VDD VSS gf180mcu_as_sc_mcu7t3v3__tap_2
X_5064_ VDD VDD VSS VSS _5094_/CLK _5064_/D _5064_/Q gf180mcu_as_sc_mcu7t3v3__dfxtp_2
X_4015_ VDD VDD VSS VSS _4015_/A _4103_/B _4015_/C _4015_/D _4017_/C gf180mcu_as_sc_mcu7t3v3__ao211_2
XFILLER_52_200 VDD VDD VSS VSS gf180mcu_as_sc_mcu7t3v3__fill_1
XFILLER_168_1297 VDD VDD VSS VSS gf180mcu_as_sc_mcu7t3v3__fillcap_4
XFILLER_181_1420 VDD VDD VSS VSS gf180mcu_as_sc_mcu7t3v3__fillcap_8
XFILLER_52_255 VDD VDD VSS VSS gf180mcu_as_sc_mcu7t3v3__fill_1
XFILLER_94_1483 VDD VDD VSS VSS gf180mcu_as_sc_mcu7t3v3__fill_1
Xsram2048.u_bank1_818 VDD VDD VSS VSS sram2048.u_bank1/WEN[0] gf180mcu_as_sc_mcu7t3v3__tiel_4
XFILLER_179_975 VDD VDD VSS VSS gf180mcu_as_sc_mcu7t3v3__fillcap_4
XFILLER_52_299 VDD VDD VSS VSS gf180mcu_as_sc_mcu7t3v3__fill_2
XFILLER_55_1467 VDD VDD VSS VSS gf180mcu_as_sc_mcu7t3v3__fillcap_16
X_4917_ VDD VDD VSS VSS _5183_/CLK _4917_/D _4917_/Q gf180mcu_as_sc_mcu7t3v3__dfxtp_2
XFILLER_139_839 VDD VDD VSS VSS gf180mcu_as_sc_mcu7t3v3__fill_1
XFILLER_142_1448 VDD VDD VSS VSS gf180mcu_as_sc_mcu7t3v3__fillcap_8
XFILLER_32_37 VDD VDD VSS VSS gf180mcu_as_sc_mcu7t3v3__fillcap_16
X_4848_ VDD VDD VSS VSS _5052_/CLK _4848_/D _4848_/Q gf180mcu_as_sc_mcu7t3v3__dfxtp_2
XFILLER_138_349 VDD VDD VSS VSS gf180mcu_as_sc_mcu7t3v3__fillcap_16
XFILLER_148_37 VDD VDD VSS VSS gf180mcu_as_sc_mcu7t3v3__fillcap_16
XFILLER_140_1161 VDD VDD VSS VSS gf180mcu_as_sc_mcu7t3v3__fill_2
XFILLER_147_883 VDD VDD VSS VSS gf180mcu_as_sc_mcu7t3v3__fillcap_8
XFILLER_181_628 VDD VDD VSS VSS gf180mcu_as_sc_mcu7t3v3__fill_2
X_4779_ VDD VDD VSS VSS _4938_/CLK _4779_/D _4779_/Q gf180mcu_as_sc_mcu7t3v3__dfxtp_2
XFILLER_106_213 VDD VDD VSS VSS gf180mcu_as_sc_mcu7t3v3__fill_1
XFILLER_146_382 VDD VDD VSS VSS gf180mcu_as_sc_mcu7t3v3__fill_2
XFILLER_175_1213 VDD VDD VSS VSS gf180mcu_as_sc_mcu7t3v3__fillcap_4
XFILLER_161_352 VDD VDD VSS VSS gf180mcu_as_sc_mcu7t3v3__fillcap_4
XFILLER_173_190 VDD VDD VSS VSS gf180mcu_as_sc_mcu7t3v3__fillcap_16
XTAP_TAPCELL_ROW_69_1_912 VDD VSS gf180mcu_as_sc_mcu7t3v3__tap_2
XFILLER_161_374 VDD VDD VSS VSS gf180mcu_as_sc_mcu7t3v3__fill_1
XFILLER_79_119 VDD VDD VSS VSS gf180mcu_as_sc_mcu7t3v3__fillcap_4
XFILLER_164_69 VDD VDD VSS VSS gf180mcu_as_sc_mcu7t3v3__fillcap_16
XFILLER_28_241 VDD VDD VSS VSS gf180mcu_as_sc_mcu7t3v3__fillcap_4
XFILLER_28_263 VDD VDD VSS VSS gf180mcu_as_sc_mcu7t3v3__fillcap_16
XFILLER_43_244 VDD VDD VSS VSS gf180mcu_as_sc_mcu7t3v3__fillcap_16
XFILLER_73_88 VDD VDD VSS VSS gf180mcu_as_sc_mcu7t3v3__fillcap_4
XPHY_EDGE_ROW_167_Left_619 VDD VSS gf180mcu_as_sc_mcu7t3v3__tap_2
XFILLER_156_102 VDD VDD VSS VSS gf180mcu_as_sc_mcu7t3v3__fill_2
XFILLER_160_1537 VDD VDD VSS VSS gf180mcu_as_sc_mcu7t3v3__fill_1
XFILLER_169_474 VDD VDD VSS VSS gf180mcu_as_sc_mcu7t3v3__fill_2
XFILLER_34_1518 VDD VDD VSS VSS gf180mcu_as_sc_mcu7t3v3__fillcap_16
XFILLER_11_174 VDD VDD VSS VSS gf180mcu_as_sc_mcu7t3v3__fillcap_16
XFILLER_145_809 VDD VDD VSS VSS gf180mcu_as_sc_mcu7t3v3__fill_2
XFILLER_157_636 VDD VDD VSS VSS gf180mcu_as_sc_mcu7t3v3__fill_2
XFILLER_184_444 VDD VDD VSS VSS gf180mcu_as_sc_mcu7t3v3__fillcap_16
XFILLER_172_639 VDD VDD VSS VSS gf180mcu_as_sc_mcu7t3v3__fillcap_8
XFILLER_98_52 VDD VDD VSS VSS gf180mcu_as_sc_mcu7t3v3__fillcap_16
XTAP_TAPCELL_ROW_150_1560 VDD VSS gf180mcu_as_sc_mcu7t3v3__tap_2
XFILLER_98_96 VDD VDD VSS VSS gf180mcu_as_sc_mcu7t3v3__fill_2
XPHY_EDGE_ROW_176_Left_628 VDD VSS gf180mcu_as_sc_mcu7t3v3__tap_2
XFILLER_152_1098 VDD VDD VSS VSS gf180mcu_as_sc_mcu7t3v3__fillcap_8
XTAP_TAPCELL_ROW_34_3_2401 VDD VSS gf180mcu_as_sc_mcu7t3v3__tap_2
XFILLER_78_1467 VDD VDD VSS VSS gf180mcu_as_sc_mcu7t3v3__fillcap_16
XPHY_EDGE_ROW_49_3_Right_368 VDD VSS gf180mcu_as_sc_mcu7t3v3__tap_2
XFILLER_34_299 VDD VDD VSS VSS gf180mcu_as_sc_mcu7t3v3__fill_2
XFILLER_97_2 VDD VDD VSS VSS gf180mcu_as_sc_mcu7t3v3__fillcap_8
X_2963_ VDD VDD VSS VSS _2964_/C _2963_/C _3150_/C _3938_/A gf180mcu_as_sc_mcu7t3v3__aoi21_2
XFILLER_175_400 VDD VDD VSS VSS gf180mcu_as_sc_mcu7t3v3__fillcap_16
X_4702_ VDD VDD VSS VSS _4705_/D _4705_/A _5250_/Q gf180mcu_as_sc_mcu7t3v3__nor2b_2
XTAP_TAPCELL_ROW_157_1714 VDD VSS gf180mcu_as_sc_mcu7t3v3__tap_2
XTAP_TAPCELL_ROW_157_1703 VDD VSS gf180mcu_as_sc_mcu7t3v3__tap_2
XFILLER_175_422 VDD VDD VSS VSS gf180mcu_as_sc_mcu7t3v3__fillcap_16
X_2894_ VDD VDD VSS VSS _2894_/Y _3533_/C _3257_/A gf180mcu_as_sc_mcu7t3v3__nand2_2
XFILLER_147_146 VDD VDD VSS VSS gf180mcu_as_sc_mcu7t3v3__fill_2
XFILLER_15_1451 VDD VDD VSS VSS gf180mcu_as_sc_mcu7t3v3__fillcap_16
X_4633_ VDD VDD VSS VSS _4688_/B _5121_/Q _5224_/Q _5224_/D gf180mcu_as_sc_mcu7t3v3__mux2_2
XFILLER_118_18 VDD VDD VSS VSS gf180mcu_as_sc_mcu7t3v3__fillcap_16
X_4564_ VDD VDD VSS VSS _4564_/B _4576_/A _4565_/D gf180mcu_as_sc_mcu7t3v3__and2_2
X_3515_ VDD VDD VSS VSS _3515_/D _3515_/A _3817_/A _3524_/C _3516_/B gf180mcu_as_sc_mcu7t3v3__ao31_2
XFILLER_137_1539 VDD VDD VSS VSS gf180mcu_as_sc_mcu7t3v3__fill_1
XFILLER_143_352 VDD VDD VSS VSS gf180mcu_as_sc_mcu7t3v3__fillcap_16
XFILLER_143_374 VDD VDD VSS VSS gf180mcu_as_sc_mcu7t3v3__fill_1
XFILLER_144_897 VDD VDD VSS VSS gf180mcu_as_sc_mcu7t3v3__fill_2
X_4495_ VDD VDD VSS VSS _5177_/Q _4548_/B _4495_/C _4495_/D _5177_/D gf180mcu_as_sc_mcu7t3v3__ao211_2
XFILLER_103_249 VDD VDD VSS VSS gf180mcu_as_sc_mcu7t3v3__fill_2
XFILLER_135_1230 VDD VDD VSS VSS gf180mcu_as_sc_mcu7t3v3__fill_2
XFILLER_170_171 VDD VDD VSS VSS gf180mcu_as_sc_mcu7t3v3__fillcap_4
XFILLER_170_193 VDD VDD VSS VSS gf180mcu_as_sc_mcu7t3v3__fillcap_16
X_3446_ VDD VDD VSS VSS _3447_/B _3446_/B _3446_/C _3447_/C gf180mcu_as_sc_mcu7t3v3__nor3_2
XFILLER_69_152 VDD VDD VSS VSS gf180mcu_as_sc_mcu7t3v3__fillcap_8
XPHY_EDGE_ROW_41_1_Right_40 VDD VSS gf180mcu_as_sc_mcu7t3v3__tap_2
X_3377_ VDD VDD VSS VSS _3464_/B _4030_/D _3380_/C gf180mcu_as_sc_mcu7t3v3__and2_2
XFILLER_111_282 VDD VDD VSS VSS gf180mcu_as_sc_mcu7t3v3__fillcap_16
XFILLER_135_1274 VDD VDD VSS VSS gf180mcu_as_sc_mcu7t3v3__fill_1
X_5116_ VDD VDD VSS VSS _5185_/CLK _5116_/D _5116_/Q gf180mcu_as_sc_mcu7t3v3__dfxtp_2
XFILLER_113_1561 VDD VDD VSS VSS gf180mcu_as_sc_mcu7t3v3__fillcap_4
XFILLER_69_196 VDD VDD VSS VSS gf180mcu_as_sc_mcu7t3v3__fill_2
XPHY_EDGE_ROW_12_1_Left_464 VDD VSS gf180mcu_as_sc_mcu7t3v3__tap_2
X_5047_ VDD VDD VSS VSS _5173_/CLK _5047_/D _5047_/Q gf180mcu_as_sc_mcu7t3v3__dfxtp_2
XFILLER_84_166 VDD VDD VSS VSS gf180mcu_as_sc_mcu7t3v3__fill_2
XFILLER_84_177 VDD VDD VSS VSS gf180mcu_as_sc_mcu7t3v3__fill_2
XFILLER_96_1534 VDD VDD VSS VSS gf180mcu_as_sc_mcu7t3v3__fillcap_16
XFILLER_96_1556 VDD VDD VSS VSS gf180mcu_as_sc_mcu7t3v3__fillcap_8
XFILLER_168_1083 VDD VDD VSS VSS gf180mcu_as_sc_mcu7t3v3__fill_2
XFILLER_25_244 VDD VDD VSS VSS gf180mcu_as_sc_mcu7t3v3__fillcap_16
XFILLER_40_225 VDD VDD VSS VSS gf180mcu_as_sc_mcu7t3v3__fillcap_16
XTAP_TAPCELL_ROW_115_1_1097 VDD VSS gf180mcu_as_sc_mcu7t3v3__tap_2
XFILLER_139_625 VDD VDD VSS VSS gf180mcu_as_sc_mcu7t3v3__fillcap_4
XFILLER_142_1223 VDD VDD VSS VSS gf180mcu_as_sc_mcu7t3v3__fill_2
XFILLER_167_912 VDD VDD VSS VSS gf180mcu_as_sc_mcu7t3v3__fillcap_16
XFILLER_179_772 VDD VDD VSS VSS gf180mcu_as_sc_mcu7t3v3__fillcap_16
XFILLER_40_247 VDD VDD VSS VSS gf180mcu_as_sc_mcu7t3v3__fillcap_16
XFILLER_43_58 VDD VDD VSS VSS gf180mcu_as_sc_mcu7t3v3__fill_1
XFILLER_167_978 VDD VDD VSS VSS gf180mcu_as_sc_mcu7t3v3__fill_2
XFILLER_135_842 VDD VDD VSS VSS gf180mcu_as_sc_mcu7t3v3__fillcap_8
XFILLER_150_823 VDD VDD VSS VSS gf180mcu_as_sc_mcu7t3v3__fillcap_16
XFILLER_136_1027 VDD VDD VSS VSS gf180mcu_as_sc_mcu7t3v3__fillcap_4
Xinput200 VDD VDD VSS VSS se_in[27] _4155_/A gf180mcu_as_sc_mcu7t3v3__buff_2
Xinput211 VDD VDD VSS VSS se_in[6] _3985_/A gf180mcu_as_sc_mcu7t3v3__buff_2
XFILLER_118_1483 VDD VDD VSS VSS gf180mcu_as_sc_mcu7t3v3__fill_1
Xinput222 VDD VDD VSS VSS south_in[16] _4062_/A gf180mcu_as_sc_mcu7t3v3__buff_2
Xinput233 VDD VDD VSS VSS south_in[26] _4143_/D gf180mcu_as_sc_mcu7t3v3__buff_2
Xinput244 VDD VDD VSS VSS south_in[5] _3973_/D gf180mcu_as_sc_mcu7t3v3__buff_2
XTAP_TAPCELL_ROW_180_2210 VDD VSS gf180mcu_as_sc_mcu7t3v3__tap_2
XFILLER_75_144 VDD VDD VSS VSS gf180mcu_as_sc_mcu7t3v3__fill_1
XFILLER_84_10 VDD VDD VSS VSS gf180mcu_as_sc_mcu7t3v3__fillcap_4
Xinput255 VDD VDD VSS VSS sw_in[15] _4058_/A gf180mcu_as_sc_mcu7t3v3__buff_2
Xinput266 VDD VDD VSS VSS sw_in[25] _3483_/A gf180mcu_as_sc_mcu7t3v3__buff_2
Xinput277 VDD VDD VSS VSS sw_in[4] _2427_/A gf180mcu_as_sc_mcu7t3v3__buff_2
Xinput288 VDD VDD VSS VSS west_in[14] _4046_/A gf180mcu_as_sc_mcu7t3v3__buff_2
XTAP_TAPCELL_ROW_180_2221 VDD VSS gf180mcu_as_sc_mcu7t3v3__tap_2
XTAP_TAPCELL_ROW_10_1_676 VDD VSS gf180mcu_as_sc_mcu7t3v3__tap_2
XFILLER_90_103 VDD VDD VSS VSS gf180mcu_as_sc_mcu7t3v3__fill_2
Xinput299 VDD VDD VSS VSS west_in[24] _4126_/D gf180mcu_as_sc_mcu7t3v3__buff_2
XFILLER_182_1014 VDD VDD VSS VSS gf180mcu_as_sc_mcu7t3v3__fill_1
XFILLER_16_299 VDD VDD VSS VSS gf180mcu_as_sc_mcu7t3v3__fill_2
XFILLER_38_1451 VDD VDD VSS VSS gf180mcu_as_sc_mcu7t3v3__fillcap_16
XFILLER_147_1189 VDD VDD VSS VSS gf180mcu_as_sc_mcu7t3v3__fill_1
XFILLER_160_1301 VDD VDD VSS VSS gf180mcu_as_sc_mcu7t3v3__fill_1
XFILLER_169_260 VDD VDD VSS VSS gf180mcu_as_sc_mcu7t3v3__fillcap_16
XTAP_TAPCELL_ROW_178_2183 VDD VSS gf180mcu_as_sc_mcu7t3v3__tap_2
XTAP_TAPCELL_ROW_178_2172 VDD VSS gf180mcu_as_sc_mcu7t3v3__tap_2
XFILLER_157_422 VDD VDD VSS VSS gf180mcu_as_sc_mcu7t3v3__fillcap_8
XFILLER_160_1323 VDD VDD VSS VSS gf180mcu_as_sc_mcu7t3v3__fill_1
XFILLER_169_282 VDD VDD VSS VSS gf180mcu_as_sc_mcu7t3v3__fillcap_16
XFILLER_157_455 VDD VDD VSS VSS gf180mcu_as_sc_mcu7t3v3__fillcap_16
XFILLER_160_1367 VDD VDD VSS VSS gf180mcu_as_sc_mcu7t3v3__fillcap_16
XFILLER_172_403 VDD VDD VSS VSS gf180mcu_as_sc_mcu7t3v3__fillcap_16
XFILLER_145_628 VDD VDD VSS VSS gf180mcu_as_sc_mcu7t3v3__fill_2
XFILLER_173_948 VDD VDD VSS VSS gf180mcu_as_sc_mcu7t3v3__fill_1
XFILLER_184_274 VDD VDD VSS VSS gf180mcu_as_sc_mcu7t3v3__fillcap_16
XTAP_TAPCELL_ROW_152_1611 VDD VSS gf180mcu_as_sc_mcu7t3v3__tap_2
XTAP_TAPCELL_ROW_152_1600 VDD VSS gf180mcu_as_sc_mcu7t3v3__tap_2
XFILLER_138_691 VDD VDD VSS VSS gf180mcu_as_sc_mcu7t3v3__fillcap_4
X_3300_ VDD VDD VSS VSS _3947_/A _3502_/B _3504_/B _3948_/A _3301_/D gf180mcu_as_sc_mcu7t3v3__ao22_2
XFILLER_152_171 VDD VDD VSS VSS gf180mcu_as_sc_mcu7t3v3__fillcap_4
XFILLER_152_193 VDD VDD VSS VSS gf180mcu_as_sc_mcu7t3v3__fillcap_16
XFILLER_154_1138 VDD VDD VSS VSS gf180mcu_as_sc_mcu7t3v3__fill_2
XFILLER_98_247 VDD VDD VSS VSS gf180mcu_as_sc_mcu7t3v3__fillcap_8
X_4280_ VDD VDD VSS VSS _4281_/S _5484_/A _5114_/Q _5114_/D gf180mcu_as_sc_mcu7t3v3__mux2_2
X_3231_ VDD VDD VSS VSS _3232_/B _3515_/A _3241_/C _3231_/C gf180mcu_as_sc_mcu7t3v3__ao21_2
Xmesh_tile_826 VDD VDD VSS VSS ne_out[1] gf180mcu_as_sc_mcu7t3v3__tiel_4
X_3162_ VDD VDD VSS VSS _3179_/B _4940_/Q _3163_/D gf180mcu_as_sc_mcu7t3v3__or2_2
XFILLER_12_2 VDD VDD VSS VSS gf180mcu_as_sc_mcu7t3v3__fillcap_16
XFILLER_45_1499 VDD VDD VSS VSS gf180mcu_as_sc_mcu7t3v3__fillcap_16
XFILLER_66_144 VDD VDD VSS VSS gf180mcu_as_sc_mcu7t3v3__fill_1
Xmesh_tile_859 VDD VDD VSS VSS north_out[0] gf180mcu_as_sc_mcu7t3v3__tiel_4
Xmesh_tile_848 VDD VDD VSS VSS ne_out[23] gf180mcu_as_sc_mcu7t3v3__tiel_4
Xmesh_tile_837 VDD VDD VSS VSS ne_out[12] gf180mcu_as_sc_mcu7t3v3__tiel_4
XFILLER_66_166 VDD VDD VSS VSS gf180mcu_as_sc_mcu7t3v3__fillcap_8
XFILLER_66_177 VDD VDD VSS VSS gf180mcu_as_sc_mcu7t3v3__fillcap_16
X_3093_ VDD VDD VSS VSS _4071_/A _3152_/B _3152_/C _4072_/D _3094_/C gf180mcu_as_sc_mcu7t3v3__ao22_2
XTAP_TAPCELL_ROW_146_1459 VDD VSS gf180mcu_as_sc_mcu7t3v3__tap_2
XFILLER_169_1370 VDD VDD VSS VSS gf180mcu_as_sc_mcu7t3v3__fillcap_4
XFILLER_22_225 VDD VDD VSS VSS gf180mcu_as_sc_mcu7t3v3__fillcap_16
XFILLER_143_1510 VDD VDD VSS VSS gf180mcu_as_sc_mcu7t3v3__fillcap_8
XFILLER_149_912 VDD VDD VSS VSS gf180mcu_as_sc_mcu7t3v3__fillcap_8
XFILLER_22_247 VDD VDD VSS VSS gf180mcu_as_sc_mcu7t3v3__fillcap_16
X_3995_ VDD VDD VSS VSS _3995_/B _4165_/A _4236_/B gf180mcu_as_sc_mcu7t3v3__and2_2
XFILLER_176_731 VDD VDD VSS VSS gf180mcu_as_sc_mcu7t3v3__fillcap_4
X_2946_ VDD VDD VSS VSS _3140_/A _3218_/B _3283_/A gf180mcu_as_sc_mcu7t3v3__nand2_2
X_2877_ VDD VDD VSS VSS _2879_/A _5262_/Q _5263_/Q gf180mcu_as_sc_mcu7t3v3__nor2_2
X_4616_ VDD VDD VSS VSS _5210_/Q _4623_/B _4623_/C _5211_/Q _5210_/D gf180mcu_as_sc_mcu7t3v3__ao22_2
XFILLER_176_1363 VDD VDD VSS VSS gf180mcu_as_sc_mcu7t3v3__fill_2
XFILLER_89_203 VDD VDD VSS VSS gf180mcu_as_sc_mcu7t3v3__fillcap_4
X_4547_ VDD VDD VSS VSS _4548_/D _4547_/B _4547_/A gf180mcu_as_sc_mcu7t3v3__nor2_2
XFILLER_172_1227 VDD VDD VSS VSS gf180mcu_as_sc_mcu7t3v3__fillcap_16
X_4478_ VDD VDD VSS VSS _5175_/Q _4548_/B _4478_/C _4478_/D _5175_/D gf180mcu_as_sc_mcu7t3v3__ao211_2
X_3429_ VDD VDD VSS VSS _3474_/B _4077_/A _3429_/A _3431_/B gf180mcu_as_sc_mcu7t3v3__mux2_2
XFILLER_150_1503 VDD VDD VSS VSS gf180mcu_as_sc_mcu7t3v3__fill_2
XFILLER_38_69 VDD VDD VSS VSS gf180mcu_as_sc_mcu7t3v3__fillcap_16
XFILLER_57_144 VDD VDD VSS VSS gf180mcu_as_sc_mcu7t3v3__fill_1
XTAP_TAPCELL_ROW_87_3_2480 VDD VSS gf180mcu_as_sc_mcu7t3v3__tap_2
Xclkbuf_leaf_28_clk_regs VDD VDD VSS VSS clkbuf_3_7_0_clk_regs/Y _5046_/CLK gf180mcu_as_sc_mcu7t3v3__clkbuff_12
XFILLER_57_199 VDD VDD VSS VSS gf180mcu_as_sc_mcu7t3v3__fill_1
XFILLER_54_68 VDD VDD VSS VSS gf180mcu_as_sc_mcu7t3v3__fill_1
XFILLER_144_1329 VDD VDD VSS VSS gf180mcu_as_sc_mcu7t3v3__fillcap_16
XFILLER_139_422 VDD VDD VSS VSS gf180mcu_as_sc_mcu7t3v3__fillcap_16
XFILLER_167_731 VDD VDD VSS VSS gf180mcu_as_sc_mcu7t3v3__fill_2
XFILLER_70_34 VDD VDD VSS VSS gf180mcu_as_sc_mcu7t3v3__fill_1
XFILLER_139_455 VDD VDD VSS VSS gf180mcu_as_sc_mcu7t3v3__fillcap_8
XFILLER_142_1053 VDD VDD VSS VSS gf180mcu_as_sc_mcu7t3v3__fill_2
XFILLER_70_45 VDD VDD VSS VSS gf180mcu_as_sc_mcu7t3v3__fill_1
XFILLER_166_263 VDD VDD VSS VSS gf180mcu_as_sc_mcu7t3v3__fillcap_16
XFILLER_181_200 VDD VDD VSS VSS gf180mcu_as_sc_mcu7t3v3__fillcap_8
XFILLER_182_723 VDD VDD VSS VSS gf180mcu_as_sc_mcu7t3v3__fillcap_8
XFILLER_70_89 VDD VDD VSS VSS gf180mcu_as_sc_mcu7t3v3__fill_2
XTAP_TAPCELL_ROW_3_1_648 VDD VSS gf180mcu_as_sc_mcu7t3v3__tap_2
XPHY_EDGE_ROW_67_3_Left_201 VDD VSS gf180mcu_as_sc_mcu7t3v3__tap_2
XFILLER_119_72 VDD VDD VSS VSS gf180mcu_as_sc_mcu7t3v3__fillcap_16
XFILLER_177_1138 VDD VDD VSS VSS gf180mcu_as_sc_mcu7t3v3__fill_1
XFILLER_181_244 VDD VDD VSS VSS gf180mcu_as_sc_mcu7t3v3__fillcap_16
XFILLER_79_10 VDD VDD VSS VSS gf180mcu_as_sc_mcu7t3v3__fillcap_4
XFILLER_79_54 VDD VDD VSS VSS gf180mcu_as_sc_mcu7t3v3__fillcap_4
XFILLER_150_675 VDD VDD VSS VSS gf180mcu_as_sc_mcu7t3v3__fillcap_4
XFILLER_95_239 VDD VDD VSS VSS gf180mcu_as_sc_mcu7t3v3__fillcap_16
XFILLER_48_144 VDD VDD VSS VSS gf180mcu_as_sc_mcu7t3v3__fill_1
XFILLER_88_291 VDD VDD VSS VSS gf180mcu_as_sc_mcu7t3v3__fillcap_8
XTAP_TAPCELL_ROW_117_1_1105 VDD VSS gf180mcu_as_sc_mcu7t3v3__tap_2
XFILLER_48_177 VDD VDD VSS VSS gf180mcu_as_sc_mcu7t3v3__fillcap_16
XTAP_TAPCELL_ROW_141_1367 VDD VSS gf180mcu_as_sc_mcu7t3v3__tap_2
XTAP_TAPCELL_ROW_141_1356 VDD VSS gf180mcu_as_sc_mcu7t3v3__tap_2
XFILLER_149_208 VDD VDD VSS VSS gf180mcu_as_sc_mcu7t3v3__fill_2
XFILLER_177_528 VDD VDD VSS VSS gf180mcu_as_sc_mcu7t3v3__fill_2
XFILLER_158_731 VDD VDD VSS VSS gf180mcu_as_sc_mcu7t3v3__fillcap_4
XFILLER_160_1120 VDD VDD VSS VSS gf180mcu_as_sc_mcu7t3v3__fillcap_16
X_3780_ VDD VDD VSS VSS _3781_/B _3780_/A _3811_/A _3780_/C gf180mcu_as_sc_mcu7t3v3__ao21_2
X_2800_ VDD VDD VSS VSS _2800_/B _2800_/A _4973_/D gf180mcu_as_sc_mcu7t3v3__and2_2
X_2731_ VDD VDD VSS VSS _4264_/A _5180_/Q _5172_/Q _2735_/B gf180mcu_as_sc_mcu7t3v3__mux2_2
XFILLER_173_723 VDD VDD VSS VSS gf180mcu_as_sc_mcu7t3v3__fillcap_8
XPHY_EDGE_ROW_51_3_Left_185 VDD VSS gf180mcu_as_sc_mcu7t3v3__tap_2
XFILLER_117_138 VDD VDD VSS VSS gf180mcu_as_sc_mcu7t3v3__fill_2
XFILLER_173_756 VDD VDD VSS VSS gf180mcu_as_sc_mcu7t3v3__fillcap_8
XFILLER_8_295 VDD VDD VSS VSS gf180mcu_as_sc_mcu7t3v3__fillcap_4
X_4401_ VDD VDD VSS VSS _4405_/B _5067_/Q _4403_/S gf180mcu_as_sc_mcu7t3v3__nand2_2
X_2662_ VDD VDD VSS VSS _2662_/D _2692_/S _2666_/B _2662_/C _2663_/C gf180mcu_as_sc_mcu7t3v3__ao31_2
X_2593_ VDD VDD VSS VSS _4264_/A _5099_/Q _2597_/B gf180mcu_as_sc_mcu7t3v3__or2_2
XFILLER_113_300 VDD VDD VSS VSS gf180mcu_as_sc_mcu7t3v3__fill_1
XFILLER_125_171 VDD VDD VSS VSS gf180mcu_as_sc_mcu7t3v3__fillcap_8
XFILLER_132_119 VDD VDD VSS VSS gf180mcu_as_sc_mcu7t3v3__fill_2
XFILLER_173_1536 VDD VDD VSS VSS gf180mcu_as_sc_mcu7t3v3__fillcap_4
X_4332_ VDD VDD VSS VSS _4332_/D _5270_/Q _5125_/Q _4332_/C _4334_/B gf180mcu_as_sc_mcu7t3v3__ao31_2
XTAP_TAPCELL_ROW_79_1_950 VDD VSS gf180mcu_as_sc_mcu7t3v3__tap_2
XFILLER_173_1558 VDD VDD VSS VSS gf180mcu_as_sc_mcu7t3v3__fillcap_4
X_4263_ VDD VDD VSS VSS _4263_/B _4748_/A _5098_/D gf180mcu_as_sc_mcu7t3v3__and2_2
XFILLER_140_174 VDD VDD VSS VSS gf180mcu_as_sc_mcu7t3v3__fill_1
XFILLER_141_697 VDD VDD VSS VSS gf180mcu_as_sc_mcu7t3v3__fill_2
X_3214_ VDD VDD VSS VSS _3227_/S _3800_/A _3796_/A _3215_/A gf180mcu_as_sc_mcu7t3v3__mux2_2
XFILLER_136_1391 VDD VDD VSS VSS gf180mcu_as_sc_mcu7t3v3__fill_2
X_4194_ VDD VDD VSS VSS _4254_/B _4197_/B _4197_/C _5032_/Q _5032_/D gf180mcu_as_sc_mcu7t3v3__ao22_2
XTAP_TAPCELL_ROW_169_1982 VDD VSS gf180mcu_as_sc_mcu7t3v3__tap_2
XTAP_TAPCELL_ROW_169_1971 VDD VSS gf180mcu_as_sc_mcu7t3v3__tap_2
X_3145_ VDD VDD VSS VSS _3145_/A _3145_/B _3145_/C _3145_/D _3147_/C gf180mcu_as_sc_mcu7t3v3__ao211_2
X_3076_ VDD VDD VSS VSS _4054_/A _3127_/B _3127_/C _4053_/D _3077_/C gf180mcu_as_sc_mcu7t3v3__ao22_2
XTAP_TAPCELL_ROW_165_1879 VDD VSS gf180mcu_as_sc_mcu7t3v3__tap_2
XFILLER_110_1564 VDD VDD VSS VSS gf180mcu_as_sc_mcu7t3v3__fillcap_4
XFILLER_167_1329 VDD VDD VSS VSS gf180mcu_as_sc_mcu7t3v3__fill_1
XFILLER_93_1515 VDD VDD VSS VSS gf180mcu_as_sc_mcu7t3v3__fillcap_4
XFILLER_93_1537 VDD VDD VSS VSS gf180mcu_as_sc_mcu7t3v3__fillcap_16
XFILLER_180_1507 VDD VDD VSS VSS gf180mcu_as_sc_mcu7t3v3__fillcap_16
X_3978_ VDD VDD VSS VSS _4050_/S _3978_/B _3978_/A _3979_/B gf180mcu_as_sc_mcu7t3v3__mux2_2
XFILLER_148_241 VDD VDD VSS VSS gf180mcu_as_sc_mcu7t3v3__fillcap_4
XFILLER_183_509 VDD VDD VSS VSS gf180mcu_as_sc_mcu7t3v3__fillcap_16
X_2929_ VDD VDD VSS VSS _3176_/S _3236_/B _3201_/C _3204_/C gf180mcu_as_sc_mcu7t3v3__nand3_2
XFILLER_136_414 VDD VDD VSS VSS gf180mcu_as_sc_mcu7t3v3__fill_2
XFILLER_137_948 VDD VDD VSS VSS gf180mcu_as_sc_mcu7t3v3__fill_1
XFILLER_164_723 VDD VDD VSS VSS gf180mcu_as_sc_mcu7t3v3__fillcap_8
XFILLER_40_37 VDD VDD VSS VSS gf180mcu_as_sc_mcu7t3v3__fill_1
XFILLER_136_469 VDD VDD VSS VSS gf180mcu_as_sc_mcu7t3v3__fill_2
XFILLER_156_37 VDD VDD VSS VSS gf180mcu_as_sc_mcu7t3v3__fillcap_16
XTAP_TAPCELL_ROW_123_1_1126 VDD VSS gf180mcu_as_sc_mcu7t3v3__tap_2
XFILLER_123_119 VDD VDD VSS VSS gf180mcu_as_sc_mcu7t3v3__fill_2
XFILLER_137_1122 VDD VDD VSS VSS gf180mcu_as_sc_mcu7t3v3__fillcap_4
XFILLER_160_940 VDD VDD VSS VSS gf180mcu_as_sc_mcu7t3v3__fillcap_4
XFILLER_116_193 VDD VDD VSS VSS gf180mcu_as_sc_mcu7t3v3__fillcap_4
XFILLER_172_1013 VDD VDD VSS VSS gf180mcu_as_sc_mcu7t3v3__fill_2
Xfanout720 VDD VDD VSS VSS _4720_/A _4731_/B gf180mcu_as_sc_mcu7t3v3__buff_2
Xfanout731 VDD VDD VSS VSS _4281_/S _4278_/S gf180mcu_as_sc_mcu7t3v3__buff_2
Xfanout742 VDD VDD VSS VSS _2677_/Y _4273_/S gf180mcu_as_sc_mcu7t3v3__buff_2
XFILLER_28_1483 VDD VDD VSS VSS gf180mcu_as_sc_mcu7t3v3__fill_1
Xfanout753 VDD VDD VSS VSS _4703_/A _2747_/A gf180mcu_as_sc_mcu7t3v3__buff_2
Xfanout764 VDD VDD VSS VSS _4520_/A _4588_/A gf180mcu_as_sc_mcu7t3v3__buff_2
Xfanout775 VDD VDD VSS VSS _4586_/S _4559_/S gf180mcu_as_sc_mcu7t3v3__buff_2
XTAP_TAPCELL_ROW_103_1_1046 VDD VSS gf180mcu_as_sc_mcu7t3v3__tap_2
Xfanout786 VDD VDD VSS VSS _3795_/A _3768_/A gf180mcu_as_sc_mcu7t3v3__buff_2
Xfanout797 VDD VDD VSS VSS _3805_/C _3706_/D gf180mcu_as_sc_mcu7t3v3__buff_2
XFILLER_65_78 VDD VDD VSS VSS gf180mcu_as_sc_mcu7t3v3__fillcap_16
XFILLER_164_2 VDD VDD VSS VSS gf180mcu_as_sc_mcu7t3v3__fillcap_16
XFILLER_159_517 VDD VDD VSS VSS gf180mcu_as_sc_mcu7t3v3__fill_2
XFILLER_126_1560 VDD VDD VSS VSS gf180mcu_as_sc_mcu7t3v3__fill_1
XFILLER_174_509 VDD VDD VSS VSS gf180mcu_as_sc_mcu7t3v3__fillcap_16
XFILLER_81_88 VDD VDD VSS VSS gf180mcu_as_sc_mcu7t3v3__fillcap_4
XFILLER_155_734 VDD VDD VSS VSS gf180mcu_as_sc_mcu7t3v3__fillcap_16
XTAP_TAPCELL_ROW_171_2028 VDD VSS gf180mcu_as_sc_mcu7t3v3__tap_2
XTAP_TAPCELL_ROW_171_2017 VDD VSS gf180mcu_as_sc_mcu7t3v3__tap_2
XFILLER_143_907 VDD VDD VSS VSS gf180mcu_as_sc_mcu7t3v3__fill_2
XFILLER_167_594 VDD VDD VSS VSS gf180mcu_as_sc_mcu7t3v3__fillcap_8
XFILLER_142_406 VDD VDD VSS VSS gf180mcu_as_sc_mcu7t3v3__fillcap_4
XFILLER_170_704 VDD VDD VSS VSS gf180mcu_as_sc_mcu7t3v3__fill_2
XFILLER_5_254 VDD VDD VSS VSS gf180mcu_as_sc_mcu7t3v3__fill_1
XFILLER_107_160 VDD VDD VSS VSS gf180mcu_as_sc_mcu7t3v3__fill_1
XFILLER_159_1380 VDD VDD VSS VSS gf180mcu_as_sc_mcu7t3v3__fillcap_16
XFILLER_182_597 VDD VDD VSS VSS gf180mcu_as_sc_mcu7t3v3__fill_2
XTAP_TAPCELL_ROW_134_1182 VDD VSS gf180mcu_as_sc_mcu7t3v3__tap_2
XTAP_TAPCELL_ROW_134_1171 VDD VSS gf180mcu_as_sc_mcu7t3v3__tap_2
XFILLER_46_8 VDD VDD VSS VSS gf180mcu_as_sc_mcu7t3v3__fill_2
XTAP_TAPCELL_ROW_134_1193 VDD VSS gf180mcu_as_sc_mcu7t3v3__tap_2
XFILLER_122_174 VDD VDD VSS VSS gf180mcu_as_sc_mcu7t3v3__fill_1
XFILLER_151_1108 VDD VDD VSS VSS gf180mcu_as_sc_mcu7t3v3__fill_1
XFILLER_46_1550 VDD VDD VSS VSS gf180mcu_as_sc_mcu7t3v3__fillcap_4
XFILLER_76_261 VDD VDD VSS VSS gf180mcu_as_sc_mcu7t3v3__fill_1
XFILLER_83_209 VDD VDD VSS VSS gf180mcu_as_sc_mcu7t3v3__fill_1
Xinput8 VDD VDD VSS VSS boot_addr[6] input8/Y gf180mcu_as_sc_mcu7t3v3__buff_2
XTAP_TAPCELL_ROW_143_1407 VDD VSS gf180mcu_as_sc_mcu7t3v3__tap_2
XFILLER_36_147 VDD VDD VSS VSS gf180mcu_as_sc_mcu7t3v3__fillcap_4
XFILLER_51_106 VDD VDD VSS VSS gf180mcu_as_sc_mcu7t3v3__fill_1
X_4950_ VDD VDD VSS VSS _5159_/CLK _4950_/D _4950_/Q gf180mcu_as_sc_mcu7t3v3__dfxtp_2
XFILLER_178_804 VDD VDD VSS VSS gf180mcu_as_sc_mcu7t3v3__fill_1
X_4881_ VDD VDD VSS VSS _4943_/CLK _4881_/D _4881_/Q gf180mcu_as_sc_mcu7t3v3__dfxtp_2
X_3901_ VDD VDD VSS VSS _3908_/B _5159_/Q _4941_/D gf180mcu_as_sc_mcu7t3v3__and2_2
XTAP_TAPCELL_ROW_160_1787 VDD VSS gf180mcu_as_sc_mcu7t3v3__tap_2
XTAP_TAPCELL_ROW_160_1776 VDD VSS gf180mcu_as_sc_mcu7t3v3__tap_2
XFILLER_162_1237 VDD VDD VSS VSS gf180mcu_as_sc_mcu7t3v3__fillcap_16
XFILLER_177_314 VDD VDD VSS VSS gf180mcu_as_sc_mcu7t3v3__fillcap_16
XFILLER_53_1521 VDD VDD VSS VSS gf180mcu_as_sc_mcu7t3v3__fillcap_16
X_3832_ VDD VDD VSS VSS _4752_/C _4910_/Q _4753_/B gf180mcu_as_sc_mcu7t3v3__xnor2_2
XFILLER_140_1502 VDD VDD VSS VSS gf180mcu_as_sc_mcu7t3v3__fill_2
XFILLER_165_509 VDD VDD VSS VSS gf180mcu_as_sc_mcu7t3v3__fillcap_16
XFILLER_140_1535 VDD VDD VSS VSS gf180mcu_as_sc_mcu7t3v3__fill_2
XFILLER_146_723 VDD VDD VSS VSS gf180mcu_as_sc_mcu7t3v3__fillcap_8
XFILLER_158_561 VDD VDD VSS VSS gf180mcu_as_sc_mcu7t3v3__fillcap_16
X_3763_ VDD VDD VSS VSS _4145_/A _3779_/B _3778_/B _4143_/D _3764_/D gf180mcu_as_sc_mcu7t3v3__ao22_2
XFILLER_134_907 VDD VDD VSS VSS gf180mcu_as_sc_mcu7t3v3__fillcap_8
X_3694_ VDD VDD VSS VSS _4072_/A _3741_/B _3741_/C _4072_/D _3695_/D gf180mcu_as_sc_mcu7t3v3__ao22_2
X_2714_ VDD VDD VSS VSS _2735_/A _2714_/B _2714_/C _2735_/D _2716_/C gf180mcu_as_sc_mcu7t3v3__ao211_2
XFILLER_10_18 VDD VDD VSS VSS gf180mcu_as_sc_mcu7t3v3__fillcap_16
XPHY_EDGE_ROW_21_1_Left_473 VDD VSS gf180mcu_as_sc_mcu7t3v3__tap_2
X_2645_ VDD VDD VSS VSS _2658_/S _5259_/Q _5247_/Q _2646_/B gf180mcu_as_sc_mcu7t3v3__mux2_2
XFILLER_138_1420 VDD VDD VSS VSS gf180mcu_as_sc_mcu7t3v3__fillcap_8
XFILLER_142_940 VDD VDD VSS VSS gf180mcu_as_sc_mcu7t3v3__fillcap_4
XFILLER_160_225 VDD VDD VSS VSS gf180mcu_as_sc_mcu7t3v3__fillcap_4
XFILLER_177_1480 VDD VDD VSS VSS gf180mcu_as_sc_mcu7t3v3__fillcap_4
Xoutput334 VDD VDD VSS VSS _4857_/Q east_out[18] gf180mcu_as_sc_mcu7t3v3__buff_2
Xoutput323 VDD VDD VSS VSS _5484_/Y dft_rdata[6] gf180mcu_as_sc_mcu7t3v3__buff_2
XFILLER_138_1464 VDD VDD VSS VSS gf180mcu_as_sc_mcu7t3v3__fillcap_16
XFILLER_160_247 VDD VDD VSS VSS gf180mcu_as_sc_mcu7t3v3__fillcap_16
Xoutput378 VDD VDD VSS VSS _4798_/Q se_out[27] gf180mcu_as_sc_mcu7t3v3__buff_2
Xoutput367 VDD VDD VSS VSS _4788_/Q se_out[17] gf180mcu_as_sc_mcu7t3v3__buff_2
Xoutput356 VDD VDD VSS VSS _4846_/Q east_out[7] gf180mcu_as_sc_mcu7t3v3__buff_2
Xoutput345 VDD VDD VSS VSS _4867_/Q east_out[28] gf180mcu_as_sc_mcu7t3v3__buff_2
X_4315_ VDD VDD VSS VSS _4321_/S _5145_/Q _5144_/Q _5144_/D gf180mcu_as_sc_mcu7t3v3__mux2_2
X_2576_ VDD VDD VSS VSS _2576_/Y _2599_/A _2601_/D gf180mcu_as_sc_mcu7t3v3__nor2_2
XFILLER_134_1328 VDD VDD VSS VSS gf180mcu_as_sc_mcu7t3v3__fillcap_16
XPHY_EDGE_ROW_151_Right_285 VDD VSS gf180mcu_as_sc_mcu7t3v3__tap_2
Xoutput389 VDD VDD VSS VSS _4777_/Q se_out[6] gf180mcu_as_sc_mcu7t3v3__buff_2
XFILLER_173_1388 VDD VDD VSS VSS gf180mcu_as_sc_mcu7t3v3__fillcap_8
X_4246_ VDD VDD VSS VSS _4248_/S _4246_/B _5082_/Q _5082_/D gf180mcu_as_sc_mcu7t3v3__mux2_2
X_4177_ VDD VDD VSS VSS _4237_/B _4188_/B _4188_/C _5015_/Q _5015_/D gf180mcu_as_sc_mcu7t3v3__ao22_2
XFILLER_82_220 VDD VDD VSS VSS gf180mcu_as_sc_mcu7t3v3__fillcap_8
X_3128_ VDD VDD VSS VSS _3145_/A _3128_/B _3128_/C _3145_/D _3130_/C gf180mcu_as_sc_mcu7t3v3__ao211_2
XFILLER_167_1115 VDD VDD VSS VSS gf180mcu_as_sc_mcu7t3v3__fillcap_4
XFILLER_167_1126 VDD VDD VSS VSS gf180mcu_as_sc_mcu7t3v3__fill_1
XFILLER_27_136 VDD VDD VSS VSS gf180mcu_as_sc_mcu7t3v3__fillcap_4
XFILLER_27_158 VDD VDD VSS VSS gf180mcu_as_sc_mcu7t3v3__fillcap_16
XFILLER_82_286 VDD VDD VSS VSS gf180mcu_as_sc_mcu7t3v3__fillcap_8
X_3059_ VDD VDD VSS VSS _3118_/S _4037_/D _4040_/A _3061_/B gf180mcu_as_sc_mcu7t3v3__mux2_2
XFILLER_145_1402 VDD VDD VSS VSS gf180mcu_as_sc_mcu7t3v3__fillcap_4
XFILLER_169_804 VDD VDD VSS VSS gf180mcu_as_sc_mcu7t3v3__fill_1
XFILLER_169_815 VDD VDD VSS VSS gf180mcu_as_sc_mcu7t3v3__fill_2
XFILLER_145_1457 VDD VDD VSS VSS gf180mcu_as_sc_mcu7t3v3__fill_2
XFILLER_51_36 VDD VDD VSS VSS gf180mcu_as_sc_mcu7t3v3__fill_2
XFILLER_136_200 VDD VDD VSS VSS gf180mcu_as_sc_mcu7t3v3__fill_2
XFILLER_137_723 VDD VDD VSS VSS gf180mcu_as_sc_mcu7t3v3__fillcap_16
XFILLER_177_892 VDD VDD VSS VSS gf180mcu_as_sc_mcu7t3v3__fill_2
XFILLER_51_58 VDD VDD VSS VSS gf180mcu_as_sc_mcu7t3v3__fill_1
XFILLER_136_233 VDD VDD VSS VSS gf180mcu_as_sc_mcu7t3v3__fillcap_8
XFILLER_178_1211 VDD VDD VSS VSS gf180mcu_as_sc_mcu7t3v3__fillcap_4
XFILLER_164_553 VDD VDD VSS VSS gf180mcu_as_sc_mcu7t3v3__fillcap_16
XFILLER_164_597 VDD VDD VSS VSS gf180mcu_as_sc_mcu7t3v3__fill_1
XTAP_TAPCELL_ROW_75_3_2462 VDD VSS gf180mcu_as_sc_mcu7t3v3__tap_2
XFILLER_117_1515 VDD VDD VSS VSS gf180mcu_as_sc_mcu7t3v3__fillcap_4
XFILLER_117_1537 VDD VDD VSS VSS gf180mcu_as_sc_mcu7t3v3__fillcap_16
XFILLER_183_68 VDD VDD VSS VSS gf180mcu_as_sc_mcu7t3v3__fill_2
Xfanout550 VDD VDD VSS VSS fanout553/Y _3474_/C gf180mcu_as_sc_mcu7t3v3__buff_2
XFILLER_150_1152 VDD VDD VSS VSS gf180mcu_as_sc_mcu7t3v3__fill_2
Xfanout561 VDD VDD VSS VSS _4190_/C _4197_/C gf180mcu_as_sc_mcu7t3v3__buff_2
Xfanout583 VDD VDD VSS VSS _2928_/Y fanout583/Y gf180mcu_as_sc_mcu7t3v3__buff_2
XFILLER_76_88 VDD VDD VSS VSS gf180mcu_as_sc_mcu7t3v3__fillcap_4
Xfanout594 VDD VDD VSS VSS fanout597/Y _4126_/C gf180mcu_as_sc_mcu7t3v3__buff_2
XPHY_EDGE_ROW_97_1_Left_549 VDD VSS gf180mcu_as_sc_mcu7t3v3__tap_2
XFILLER_92_65 VDD VDD VSS VSS gf180mcu_as_sc_mcu7t3v3__fillcap_4
XFILLER_148_1081 VDD VDD VSS VSS gf180mcu_as_sc_mcu7t3v3__fillcap_4
XFILLER_159_303 VDD VDD VSS VSS gf180mcu_as_sc_mcu7t3v3__fill_2
XFILLER_163_1568 VDD VDD VSS VSS gf180mcu_as_sc_mcu7t3v3__fill_1
XFILLER_175_818 VDD VDD VSS VSS gf180mcu_as_sc_mcu7t3v3__fill_2
XFILLER_174_317 VDD VDD VSS VSS gf180mcu_as_sc_mcu7t3v3__fillcap_16
XFILLER_127_222 VDD VDD VSS VSS gf180mcu_as_sc_mcu7t3v3__fill_1
XFILLER_170_501 VDD VDD VSS VSS gf180mcu_as_sc_mcu7t3v3__fillcap_4
XFILLER_183_884 VDD VDD VSS VSS gf180mcu_as_sc_mcu7t3v3__fillcap_8
XTAP_TAPCELL_ROW_136_1255 VDD VSS gf180mcu_as_sc_mcu7t3v3__tap_2
XTAP_TAPCELL_ROW_136_1244 VDD VSS gf180mcu_as_sc_mcu7t3v3__tap_2
X_2430_ VDD VDD VSS VSS _4003_/A _2430_/A gf180mcu_as_sc_mcu7t3v3__inv_2
XFILLER_142_236 VDD VDD VSS VSS gf180mcu_as_sc_mcu7t3v3__fillcap_8
XFILLER_142_247 VDD VDD VSS VSS gf180mcu_as_sc_mcu7t3v3__fillcap_8
XFILLER_155_1052 VDD VDD VSS VSS gf180mcu_as_sc_mcu7t3v3__fillcap_4
XFILLER_170_589 VDD VDD VSS VSS gf180mcu_as_sc_mcu7t3v3__fillcap_4
XFILLER_170_1539 VDD VDD VSS VSS gf180mcu_as_sc_mcu7t3v3__fillcap_16
X_5080_ VDD VDD VSS VSS _5080_/CLK _5080_/D _5080_/Q gf180mcu_as_sc_mcu7t3v3__dfxtp_2
X_4100_ VDD VDD VSS VSS _4998_/Q _4125_/B _4249_/B _4125_/D _4998_/D gf180mcu_as_sc_mcu7t3v3__ao22_2
X_4031_ VDD VDD VSS VSS _4031_/A _4121_/C _4031_/C _4031_/D _4033_/C gf180mcu_as_sc_mcu7t3v3__ao211_2
XFILLER_110_177 VDD VDD VSS VSS gf180mcu_as_sc_mcu7t3v3__fillcap_16
XFILLER_2_85 VDD VDD VSS VSS gf180mcu_as_sc_mcu7t3v3__fillcap_16
XTAP_TAPCELL_ROW_162_1816 VDD VSS gf180mcu_as_sc_mcu7t3v3__tap_2
XTAP_TAPCELL_ROW_162_1827 VDD VSS gf180mcu_as_sc_mcu7t3v3__tap_2
XFILLER_20_1564 VDD VDD VSS VSS gf180mcu_as_sc_mcu7t3v3__fillcap_4
XFILLER_168_1479 VDD VDD VSS VSS gf180mcu_as_sc_mcu7t3v3__fillcap_16
XFILLER_24_139 VDD VDD VSS VSS gf180mcu_as_sc_mcu7t3v3__fillcap_16
X_4933_ VDD VDD VSS VSS _5053_/CLK _4933_/D _4933_/Q gf180mcu_as_sc_mcu7t3v3__dfxtp_2
XFILLER_162_1001 VDD VDD VSS VSS gf180mcu_as_sc_mcu7t3v3__fillcap_4
XFILLER_166_1181 VDD VDD VSS VSS gf180mcu_as_sc_mcu7t3v3__fill_1
XFILLER_90_1518 VDD VDD VSS VSS gf180mcu_as_sc_mcu7t3v3__fillcap_16
XFILLER_166_807 VDD VDD VSS VSS gf180mcu_as_sc_mcu7t3v3__fillcap_8
XFILLER_178_667 VDD VDD VSS VSS gf180mcu_as_sc_mcu7t3v3__fillcap_8
X_4864_ VDD VDD VSS VSS _5046_/CLK _4864_/D _4864_/Q gf180mcu_as_sc_mcu7t3v3__dfxtp_2
XFILLER_165_306 VDD VDD VSS VSS gf180mcu_as_sc_mcu7t3v3__fill_1
X_4795_ VDD VDD VSS VSS _4869_/CLK _4795_/D _4795_/Q gf180mcu_as_sc_mcu7t3v3__dfxtp_2
X_3815_ VDD VDD VSS VSS _3929_/B _3914_/B _3914_/A gf180mcu_as_sc_mcu7t3v3__nand2_2
XFILLER_159_892 VDD VDD VSS VSS gf180mcu_as_sc_mcu7t3v3__fillcap_4
X_3746_ VDD VDD VSS VSS _4124_/A _3746_/B _3746_/C _4862_/D _3746_/D gf180mcu_as_sc_mcu7t3v3__aoi211_2
XFILLER_118_255 VDD VDD VSS VSS gf180mcu_as_sc_mcu7t3v3__fill_1
XFILLER_179_1542 VDD VDD VSS VSS gf180mcu_as_sc_mcu7t3v3__fillcap_16
XFILLER_179_1564 VDD VDD VSS VSS gf180mcu_as_sc_mcu7t3v3__fill_1
XFILLER_118_299 VDD VDD VSS VSS gf180mcu_as_sc_mcu7t3v3__fill_2
XFILLER_175_1417 VDD VDD VSS VSS gf180mcu_as_sc_mcu7t3v3__fillcap_16
X_3677_ VDD VDD VSS VSS _4055_/A _3716_/B _3716_/C _4054_/A _3678_/C gf180mcu_as_sc_mcu7t3v3__ao22_2
XPHY_EDGE_ROW_14_3_Left_148 VDD VSS gf180mcu_as_sc_mcu7t3v3__tap_2
X_2628_ VDD VDD VSS VSS _2692_/S _2628_/B input4/Y _2629_/A gf180mcu_as_sc_mcu7t3v3__mux2_2
X_2559_ VDD VDD VSS VSS _2559_/B _4325_/S _4956_/D gf180mcu_as_sc_mcu7t3v3__and2_2
XFILLER_138_1294 VDD VDD VSS VSS gf180mcu_as_sc_mcu7t3v3__fill_1
X_5278_ VDD VDD VSS VSS clkload4/A _5278_/D _5278_/Q gf180mcu_as_sc_mcu7t3v3__dfxtp_2
XFILLER_134_1158 VDD VDD VSS VSS gf180mcu_as_sc_mcu7t3v3__fillcap_4
X_4229_ VDD VDD VSS VSS _4257_/S _4229_/B _5065_/Q _5065_/D gf180mcu_as_sc_mcu7t3v3__mux2_2
XFILLER_101_166 VDD VDD VSS VSS gf180mcu_as_sc_mcu7t3v3__fill_1
XFILLER_151_1472 VDD VDD VSS VSS gf180mcu_as_sc_mcu7t3v3__fillcap_8
XFILLER_99_1521 VDD VDD VSS VSS gf180mcu_as_sc_mcu7t3v3__fillcap_16
XFILLER_112_1467 VDD VDD VSS VSS gf180mcu_as_sc_mcu7t3v3__fillcap_16
XPHY_EDGE_ROW_76_3_Left_210 VDD VSS gf180mcu_as_sc_mcu7t3v3__tap_2
XFILLER_102_53 VDD VDD VSS VSS gf180mcu_as_sc_mcu7t3v3__fillcap_8
XFILLER_156_317 VDD VDD VSS VSS gf180mcu_as_sc_mcu7t3v3__fillcap_4
XFILLER_168_155 VDD VDD VSS VSS gf180mcu_as_sc_mcu7t3v3__fillcap_16
XFILLER_168_177 VDD VDD VSS VSS gf180mcu_as_sc_mcu7t3v3__fillcap_16
XFILLER_169_678 VDD VDD VSS VSS gf180mcu_as_sc_mcu7t3v3__fillcap_4
XFILLER_184_626 VDD VDD VSS VSS gf180mcu_as_sc_mcu7t3v3__fill_2
XFILLER_71_1451 VDD VDD VSS VSS gf180mcu_as_sc_mcu7t3v3__fillcap_16
XFILLER_127_2 VDD VDD VSS VSS gf180mcu_as_sc_mcu7t3v3__fillcap_16
XFILLER_184_648 VDD VDD VSS VSS gf180mcu_as_sc_mcu7t3v3__fill_2
XFILLER_137_542 VDD VDD VSS VSS gf180mcu_as_sc_mcu7t3v3__fill_1
XFILLER_165_884 VDD VDD VSS VSS gf180mcu_as_sc_mcu7t3v3__fillcap_16
XFILLER_11_50 VDD VDD VSS VSS gf180mcu_as_sc_mcu7t3v3__fillcap_16
XFILLER_11_72 VDD VDD VSS VSS gf180mcu_as_sc_mcu7t3v3__fillcap_16
XFILLER_124_247 VDD VDD VSS VSS gf180mcu_as_sc_mcu7t3v3__fillcap_4
XFILLER_152_545 VDD VDD VSS VSS gf180mcu_as_sc_mcu7t3v3__fillcap_16
XFILLER_127_72 VDD VDD VSS VSS gf180mcu_as_sc_mcu7t3v3__fillcap_16
XFILLER_132_280 VDD VDD VSS VSS gf180mcu_as_sc_mcu7t3v3__fillcap_8
XFILLER_156_1383 VDD VDD VSS VSS gf180mcu_as_sc_mcu7t3v3__fillcap_16
XFILLER_152_1269 VDD VDD VSS VSS gf180mcu_as_sc_mcu7t3v3__fill_1
XFILLER_38_209 VDD VDD VSS VSS gf180mcu_as_sc_mcu7t3v3__fillcap_16
XTAP_TAPCELL_ROW_183_2285 VDD VSS gf180mcu_as_sc_mcu7t3v3__tap_2
XTAP_TAPCELL_ROW_183_2274 VDD VSS gf180mcu_as_sc_mcu7t3v3__tap_2
XFILLER_130_1545 VDD VDD VSS VSS gf180mcu_as_sc_mcu7t3v3__fill_1
XFILLER_130_1556 VDD VDD VSS VSS gf180mcu_as_sc_mcu7t3v3__fill_1
XFILLER_46_220 VDD VDD VSS VSS gf180mcu_as_sc_mcu7t3v3__fillcap_16
XPHY_EDGE_ROW_60_3_Left_194 VDD VSS gf180mcu_as_sc_mcu7t3v3__tap_2
XFILLER_61_212 VDD VDD VSS VSS gf180mcu_as_sc_mcu7t3v3__fillcap_4
XFILLER_146_1029 VDD VDD VSS VSS gf180mcu_as_sc_mcu7t3v3__fill_2
XFILLER_163_1332 VDD VDD VSS VSS gf180mcu_as_sc_mcu7t3v3__fillcap_8
XFILLER_61_245 VDD VDD VSS VSS gf180mcu_as_sc_mcu7t3v3__fillcap_8
XFILLER_148_807 VDD VDD VSS VSS gf180mcu_as_sc_mcu7t3v3__fillcap_16
XFILLER_163_1376 VDD VDD VSS VSS gf180mcu_as_sc_mcu7t3v3__fill_1
XFILLER_175_615 VDD VDD VSS VSS gf180mcu_as_sc_mcu7t3v3__fillcap_8
XFILLER_50_1502 VDD VDD VSS VSS gf180mcu_as_sc_mcu7t3v3__fillcap_16
XTAP_TAPCELL_ROW_11_1_678 VDD VSS gf180mcu_as_sc_mcu7t3v3__tap_2
XFILLER_175_659 VDD VDD VSS VSS gf180mcu_as_sc_mcu7t3v3__fill_1
Xinput11 VDD VDD VSS VSS boot_addr[9] _2675_/A gf180mcu_as_sc_mcu7t3v3__buff_2
Xinput22 VDD VDD VSS VSS dft_addr[0] _2604_/B gf180mcu_as_sc_mcu7t3v3__buff_2
X_4580_ VDD VDD VSS VSS _4581_/D _4580_/B _4581_/A gf180mcu_as_sc_mcu7t3v3__nor2_2
X_3600_ VDD VDD VSS VSS _3601_/C _3600_/C _3752_/B _3969_/A gf180mcu_as_sc_mcu7t3v3__aoi21_2
XFILLER_156_862 VDD VDD VSS VSS gf180mcu_as_sc_mcu7t3v3__fillcap_8
XFILLER_50_1568 VDD VDD VSS VSS gf180mcu_as_sc_mcu7t3v3__fill_1
Xinput33 VDD VDD VSS VSS dft_ce _2586_/B gf180mcu_as_sc_mcu7t3v3__buff_2
Xinput55 VDD VDD VSS VSS east_in[1] _3942_/A gf180mcu_as_sc_mcu7t3v3__buff_2
Xinput44 VDD VDD VSS VSS east_in[0] _3933_/A gf180mcu_as_sc_mcu7t3v3__buff_2
X_3531_ VDD VDD VSS VSS _3551_/A _3807_/B _3531_/A gf180mcu_as_sc_mcu7t3v3__nand2_2
XTAP_TAPCELL_ROW_155_1664 VDD VSS gf180mcu_as_sc_mcu7t3v3__tap_2
XFILLER_171_821 VDD VDD VSS VSS gf180mcu_as_sc_mcu7t3v3__fill_2
XFILLER_183_670 VDD VDD VSS VSS gf180mcu_as_sc_mcu7t3v3__fillcap_8
Xinput88 VDD VDD VSS VSS ne_in[19] _4085_/A gf180mcu_as_sc_mcu7t3v3__buff_2
Xinput77 VDD VDD VSS VSS east_in[9] _4006_/D gf180mcu_as_sc_mcu7t3v3__buff_2
Xinput66 VDD VDD VSS VSS east_in[2] _3951_/A gf180mcu_as_sc_mcu7t3v3__buff_2
XTAP_TAPCELL_ROW_155_1675 VDD VSS gf180mcu_as_sc_mcu7t3v3__tap_2
XTAP_TAPCELL_ROW_124_1_1131 VDD VSS gf180mcu_as_sc_mcu7t3v3__tap_2
Xinput99 VDD VDD VSS VSS ne_in[29] _3791_/A gf180mcu_as_sc_mcu7t3v3__buff_2
X_3462_ VDD VDD VSS VSS _3462_/A _3462_/B _3462_/C _3463_/C gf180mcu_as_sc_mcu7t3v3__nor3_2
X_5201_ VDD VDD VSS VSS clkload0/A _5201_/D _5201_/Q gf180mcu_as_sc_mcu7t3v3__dfxtp_2
X_3393_ VDD VDD VSS VSS _4929_/Q _3493_/B _3472_/C _4045_/A _3395_/C gf180mcu_as_sc_mcu7t3v3__ao22_2
X_2413_ VDD VDD VSS VSS _2844_/C _5126_/Q gf180mcu_as_sc_mcu7t3v3__inv_2
XFILLER_135_1434 VDD VDD VSS VSS gf180mcu_as_sc_mcu7t3v3__fillcap_16
XFILLER_48_1486 VDD VDD VSS VSS gf180mcu_as_sc_mcu7t3v3__fillcap_16
X_5132_ VDD VDD VSS VSS _5199_/CLK _5132_/D _5132_/Q gf180mcu_as_sc_mcu7t3v3__dfxtp_2
Xclkbuf_1_0__f_clk VDD VDD VSS VSS clkbuf_0_clk/Y clkbuf_1_0__f_clk/Y gf180mcu_as_sc_mcu7t3v3__clkbuff_12
XFILLER_96_142 VDD VDD VSS VSS gf180mcu_as_sc_mcu7t3v3__fill_2
XTAP_TAPCELL_ROW_104_1_1051 VDD VSS gf180mcu_as_sc_mcu7t3v3__tap_2
X_5063_ VDD VDD VSS VSS _5094_/CLK _5063_/D _5063_/Q gf180mcu_as_sc_mcu7t3v3__dfxtp_2
X_4014_ VDD VDD VSS VSS _4014_/A _4102_/B _4102_/C _4925_/Q _4015_/D gf180mcu_as_sc_mcu7t3v3__ao22_2
XFILLER_168_1221 VDD VDD VSS VSS gf180mcu_as_sc_mcu7t3v3__fillcap_4
XFILLER_168_1243 VDD VDD VSS VSS gf180mcu_as_sc_mcu7t3v3__fillcap_8
XFILLER_164_1107 VDD VDD VSS VSS gf180mcu_as_sc_mcu7t3v3__fill_2
XFILLER_94_1451 VDD VDD VSS VSS gf180mcu_as_sc_mcu7t3v3__fillcap_16
XFILLER_142_1405 VDD VDD VSS VSS gf180mcu_as_sc_mcu7t3v3__fill_1
X_4916_ VDD VDD VSS VSS _5053_/CLK _4916_/D _4916_/Q gf180mcu_as_sc_mcu7t3v3__dfxtp_2
Xsram2048.u_bank1_819 VDD VDD VSS VSS sram2048.u_bank1/WEN[1] gf180mcu_as_sc_mcu7t3v3__tiel_4
XFILLER_138_317 VDD VDD VSS VSS gf180mcu_as_sc_mcu7t3v3__fillcap_16
XFILLER_166_626 VDD VDD VSS VSS gf180mcu_as_sc_mcu7t3v3__fillcap_4
X_4847_ VDD VDD VSS VSS _4938_/CLK _4847_/D _4847_/Q gf180mcu_as_sc_mcu7t3v3__dfxtp_2
XFILLER_165_136 VDD VDD VSS VSS gf180mcu_as_sc_mcu7t3v3__fillcap_4
XFILLER_165_158 VDD VDD VSS VSS gf180mcu_as_sc_mcu7t3v3__fillcap_16
X_4778_ VDD VDD VSS VSS _4867_/CLK _4778_/D _4778_/Q gf180mcu_as_sc_mcu7t3v3__dfxtp_2
XFILLER_134_512 VDD VDD VSS VSS gf180mcu_as_sc_mcu7t3v3__fillcap_8
XFILLER_179_1372 VDD VDD VSS VSS gf180mcu_as_sc_mcu7t3v3__fillcap_4
XPHY_EDGE_ROW_13_1_Right_12 VDD VSS gf180mcu_as_sc_mcu7t3v3__tap_2
X_3729_ VDD VDD VSS VSS _3730_/C _3729_/C _3729_/B _4105_/A gf180mcu_as_sc_mcu7t3v3__aoi21_2
XFILLER_106_247 VDD VDD VSS VSS gf180mcu_as_sc_mcu7t3v3__fillcap_16
XFILLER_175_1247 VDD VDD VSS VSS gf180mcu_as_sc_mcu7t3v3__fill_2
XFILLER_180_139 VDD VDD VSS VSS gf180mcu_as_sc_mcu7t3v3__fillcap_8
XTAP_TAPCELL_ROW_69_1_913 VDD VSS gf180mcu_as_sc_mcu7t3v3__tap_2
XFILLER_164_37 VDD VDD VSS VSS gf180mcu_as_sc_mcu7t3v3__fillcap_16
XFILLER_121_228 VDD VDD VSS VSS gf180mcu_as_sc_mcu7t3v3__fillcap_16
XFILLER_27_1515 VDD VDD VSS VSS gf180mcu_as_sc_mcu7t3v3__fillcap_4
XFILLER_27_1537 VDD VDD VSS VSS gf180mcu_as_sc_mcu7t3v3__fillcap_16
XFILLER_66_1564 VDD VDD VSS VSS gf180mcu_as_sc_mcu7t3v3__fillcap_4
XFILLER_87_120 VDD VDD VSS VSS gf180mcu_as_sc_mcu7t3v3__fillcap_16
XFILLER_114_1518 VDD VDD VSS VSS gf180mcu_as_sc_mcu7t3v3__fillcap_16
XFILLER_57_24 VDD VDD VSS VSS gf180mcu_as_sc_mcu7t3v3__fillcap_8
XFILLER_87_142 VDD VDD VSS VSS gf180mcu_as_sc_mcu7t3v3__fill_2
XPHY_EDGE_ROW_109_1_Left_561 VDD VSS gf180mcu_as_sc_mcu7t3v3__tap_2
XFILLER_180_69 VDD VDD VSS VSS gf180mcu_as_sc_mcu7t3v3__fillcap_16
XFILLER_43_212 VDD VDD VSS VSS gf180mcu_as_sc_mcu7t3v3__fillcap_16
XFILLER_73_23 VDD VDD VSS VSS gf180mcu_as_sc_mcu7t3v3__fillcap_8
XFILLER_73_45 VDD VDD VSS VSS gf180mcu_as_sc_mcu7t3v3__fillcap_4
XFILLER_11_120 VDD VDD VSS VSS gf180mcu_as_sc_mcu7t3v3__fillcap_16
XTAP_TAPCELL_ROW_63_3_2444 VDD VSS gf180mcu_as_sc_mcu7t3v3__tap_2
XFILLER_11_142 VDD VDD VSS VSS gf180mcu_as_sc_mcu7t3v3__fillcap_16
XFILLER_184_478 VDD VDD VSS VSS gf180mcu_as_sc_mcu7t3v3__fillcap_16
XFILLER_153_821 VDD VDD VSS VSS gf180mcu_as_sc_mcu7t3v3__fillcap_16
XFILLER_165_670 VDD VDD VSS VSS gf180mcu_as_sc_mcu7t3v3__fillcap_8
XFILLER_152_364 VDD VDD VSS VSS gf180mcu_as_sc_mcu7t3v3__fillcap_16
XTAP_TAPCELL_ROW_150_1561 VDD VSS gf180mcu_as_sc_mcu7t3v3__tap_2
XTAP_TAPCELL_ROW_150_1550 VDD VSS gf180mcu_as_sc_mcu7t3v3__tap_2
XFILLER_152_1000 VDD VDD VSS VSS gf180mcu_as_sc_mcu7t3v3__fill_2
XFILLER_78_120 VDD VDD VSS VSS gf180mcu_as_sc_mcu7t3v3__fillcap_4
XFILLER_152_1033 VDD VDD VSS VSS gf180mcu_as_sc_mcu7t3v3__fill_1
XFILLER_154_81 VDD VDD VSS VSS gf180mcu_as_sc_mcu7t3v3__fillcap_16
XFILLER_78_142 VDD VDD VSS VSS gf180mcu_as_sc_mcu7t3v3__fillcap_4
XFILLER_152_1055 VDD VDD VSS VSS gf180mcu_as_sc_mcu7t3v3__fill_1
XPHY_EDGE_ROW_30_1_Left_482 VDD VSS gf180mcu_as_sc_mcu7t3v3__tap_2
XFILLER_179_206 VDD VDD VSS VSS gf180mcu_as_sc_mcu7t3v3__fillcap_4
XFILLER_179_228 VDD VDD VSS VSS gf180mcu_as_sc_mcu7t3v3__fillcap_16
XFILLER_163_1140 VDD VDD VSS VSS gf180mcu_as_sc_mcu7t3v3__fill_2
X_2962_ VDD VDD VSS VSS _3939_/A _3150_/B _2962_/C _2962_/D _2963_/C gf180mcu_as_sc_mcu7t3v3__ao22_2
X_4701_ VDD VDD VSS VSS _4707_/S _5255_/Q _4701_/A _5255_/D gf180mcu_as_sc_mcu7t3v3__mux2_2
XTAP_TAPCELL_ROW_157_1715 VDD VSS gf180mcu_as_sc_mcu7t3v3__tap_2
XTAP_TAPCELL_ROW_157_1704 VDD VSS gf180mcu_as_sc_mcu7t3v3__tap_2
XFILLER_148_648 VDD VDD VSS VSS gf180mcu_as_sc_mcu7t3v3__fill_1
X_4632_ VDD VDD VSS VSS _4688_/B _5120_/Q _4703_/A _5223_/D gf180mcu_as_sc_mcu7t3v3__mux2_2
X_2893_ VDD VDD VSS VSS _3789_/A _3797_/A _3533_/C gf180mcu_as_sc_mcu7t3v3__or2_2
XFILLER_147_136 VDD VDD VSS VSS gf180mcu_as_sc_mcu7t3v3__fillcap_4
XFILLER_163_629 VDD VDD VSS VSS gf180mcu_as_sc_mcu7t3v3__fill_1
XFILLER_89_1553 VDD VDD VSS VSS gf180mcu_as_sc_mcu7t3v3__fillcap_16
X_4563_ VDD VDD VSS VSS _5186_/Q _4575_/B _4566_/C _5104_/Q _4564_/B gf180mcu_as_sc_mcu7t3v3__ao22_2
XFILLER_162_139 VDD VDD VSS VSS gf180mcu_as_sc_mcu7t3v3__fillcap_16
XFILLER_176_1523 VDD VDD VSS VSS gf180mcu_as_sc_mcu7t3v3__fillcap_16
X_4494_ VDD VDD VSS VSS _4494_/B _4591_/A _4495_/D gf180mcu_as_sc_mcu7t3v3__and2_2
X_3514_ VDD VDD VSS VSS _3515_/D _3514_/C _3514_/B _3514_/A gf180mcu_as_sc_mcu7t3v3__aoi21b_2
X_3445_ VDD VDD VSS VSS _4094_/A _3467_/C _3469_/B _4097_/A _3446_/C gf180mcu_as_sc_mcu7t3v3__ao22_2
XFILLER_134_18 VDD VDD VSS VSS gf180mcu_as_sc_mcu7t3v3__fillcap_16
XFILLER_69_142 VDD VDD VSS VSS gf180mcu_as_sc_mcu7t3v3__fill_2
X_3376_ VDD VDD VSS VSS _4027_/A _3470_/B _3376_/C _4816_/D _3746_/D gf180mcu_as_sc_mcu7t3v3__aoi211_2
X_5115_ VDD VDD VSS VSS _5186_/CLK _5115_/D _5115_/Q gf180mcu_as_sc_mcu7t3v3__dfxtp_2
XFILLER_170_1188 VDD VDD VSS VSS gf180mcu_as_sc_mcu7t3v3__fillcap_4
XFILLER_61_1483 VDD VDD VSS VSS gf180mcu_as_sc_mcu7t3v3__fillcap_16
XFILLER_84_134 VDD VDD VSS VSS gf180mcu_as_sc_mcu7t3v3__fillcap_16
X_5046_ VDD VDD VSS VSS _5046_/CLK _5046_/D _5046_/Q gf180mcu_as_sc_mcu7t3v3__dfxtp_2
XFILLER_22_1467 VDD VDD VSS VSS gf180mcu_as_sc_mcu7t3v3__fillcap_16
XFILLER_96_1502 VDD VDD VSS VSS gf180mcu_as_sc_mcu7t3v3__fillcap_16
XFILLER_25_212 VDD VDD VSS VSS gf180mcu_as_sc_mcu7t3v3__fillcap_16
XFILLER_96_1568 VDD VDD VSS VSS gf180mcu_as_sc_mcu7t3v3__fill_1
XFILLER_183_1527 VDD VDD VSS VSS gf180mcu_as_sc_mcu7t3v3__fillcap_8
XFILLER_43_26 VDD VDD VSS VSS gf180mcu_as_sc_mcu7t3v3__fillcap_8
XFILLER_142_1213 VDD VDD VSS VSS gf180mcu_as_sc_mcu7t3v3__fillcap_4
XFILLER_181_1262 VDD VDD VSS VSS gf180mcu_as_sc_mcu7t3v3__fillcap_8
XFILLER_177_1309 VDD VDD VSS VSS gf180mcu_as_sc_mcu7t3v3__fillcap_8
XFILLER_182_938 VDD VDD VSS VSS gf180mcu_as_sc_mcu7t3v3__fillcap_4
XFILLER_134_342 VDD VDD VSS VSS gf180mcu_as_sc_mcu7t3v3__fillcap_16
XFILLER_68_12 VDD VDD VSS VSS gf180mcu_as_sc_mcu7t3v3__fill_1
XFILLER_118_1451 VDD VDD VSS VSS gf180mcu_as_sc_mcu7t3v3__fillcap_16
Xinput201 VDD VDD VSS VSS se_in[28] _4163_/A gf180mcu_as_sc_mcu7t3v3__buff_2
XFILLER_153_1375 VDD VDD VSS VSS gf180mcu_as_sc_mcu7t3v3__fillcap_16
Xinput212 VDD VDD VSS VSS se_in[7] _3993_/A gf180mcu_as_sc_mcu7t3v3__buff_2
Xinput223 VDD VDD VSS VSS south_in[17] _4072_/D gf180mcu_as_sc_mcu7t3v3__buff_2
Xinput234 VDD VDD VSS VSS south_in[27] _4151_/D gf180mcu_as_sc_mcu7t3v3__buff_2
Xinput245 VDD VDD VSS VSS south_in[6] _3981_/D gf180mcu_as_sc_mcu7t3v3__buff_2
XFILLER_40_1534 VDD VDD VSS VSS gf180mcu_as_sc_mcu7t3v3__fillcap_16
XFILLER_75_134 VDD VDD VSS VSS gf180mcu_as_sc_mcu7t3v3__fillcap_4
Xinput256 VDD VDD VSS VSS sw_in[16] _2438_/A gf180mcu_as_sc_mcu7t3v3__buff_2
Xinput267 VDD VDD VSS VSS sw_in[26] _4148_/A gf180mcu_as_sc_mcu7t3v3__buff_2
Xinput278 VDD VDD VSS VSS sw_in[5] _3978_/A gf180mcu_as_sc_mcu7t3v3__buff_2
XTAP_TAPCELL_ROW_180_2222 VDD VSS gf180mcu_as_sc_mcu7t3v3__tap_2
XTAP_TAPCELL_ROW_180_2211 VDD VSS gf180mcu_as_sc_mcu7t3v3__tap_2
XTAP_TAPCELL_ROW_10_1_677 VDD VSS gf180mcu_as_sc_mcu7t3v3__tap_2
XFILLER_40_1556 VDD VDD VSS VSS gf180mcu_as_sc_mcu7t3v3__fillcap_8
Xinput289 VDD VDD VSS VSS west_in[15] _4053_/A gf180mcu_as_sc_mcu7t3v3__buff_2
XFILLER_84_88 VDD VDD VSS VSS gf180mcu_as_sc_mcu7t3v3__fillcap_4
XFILLER_160_1313 VDD VDD VSS VSS gf180mcu_as_sc_mcu7t3v3__fillcap_8
XFILLER_176_209 VDD VDD VSS VSS gf180mcu_as_sc_mcu7t3v3__fillcap_16
XTAP_TAPCELL_ROW_178_2173 VDD VSS gf180mcu_as_sc_mcu7t3v3__tap_2
XTAP_TAPCELL_ROW_178_2162 VDD VSS gf180mcu_as_sc_mcu7t3v3__tap_2
XFILLER_157_434 VDD VDD VSS VSS gf180mcu_as_sc_mcu7t3v3__fill_2
XFILLER_160_1335 VDD VDD VSS VSS gf180mcu_as_sc_mcu7t3v3__fillcap_4
XFILLER_125_1499 VDD VDD VSS VSS gf180mcu_as_sc_mcu7t3v3__fillcap_16
XFILLER_129_158 VDD VDD VSS VSS gf180mcu_as_sc_mcu7t3v3__fillcap_4
XFILLER_158_979 VDD VDD VSS VSS gf180mcu_as_sc_mcu7t3v3__fill_1
XFILLER_173_938 VDD VDD VSS VSS gf180mcu_as_sc_mcu7t3v3__fillcap_8
XTAP_TAPCELL_ROW_152_1601 VDD VSS gf180mcu_as_sc_mcu7t3v3__tap_2
XFILLER_98_204 VDD VDD VSS VSS gf180mcu_as_sc_mcu7t3v3__fillcap_8
XFILLER_158_1297 VDD VDD VSS VSS gf180mcu_as_sc_mcu7t3v3__fillcap_16
XFILLER_140_356 VDD VDD VSS VSS gf180mcu_as_sc_mcu7t3v3__fill_2
XFILLER_171_1442 VDD VDD VSS VSS gf180mcu_as_sc_mcu7t3v3__fill_1
XFILLER_84_1483 VDD VDD VSS VSS gf180mcu_as_sc_mcu7t3v3__fill_1
X_3230_ VDD VDD VSS VSS _3230_/S _3514_/A _3230_/A _3231_/C gf180mcu_as_sc_mcu7t3v3__mux2_2
XFILLER_45_1467 VDD VDD VSS VSS gf180mcu_as_sc_mcu7t3v3__fillcap_16
Xmesh_tile_827 VDD VDD VSS VSS ne_out[2] gf180mcu_as_sc_mcu7t3v3__tiel_4
X_3161_ VDD VDD VSS VSS _3178_/A _3161_/B _3161_/C _3178_/D _3163_/C gf180mcu_as_sc_mcu7t3v3__ao211_2
XFILLER_66_134 VDD VDD VSS VSS gf180mcu_as_sc_mcu7t3v3__fillcap_8
XPHY_EDGE_ROW_167_Right_301 VDD VSS gf180mcu_as_sc_mcu7t3v3__tap_2
Xmesh_tile_849 VDD VDD VSS VSS ne_out[24] gf180mcu_as_sc_mcu7t3v3__tiel_4
Xmesh_tile_838 VDD VDD VSS VSS ne_out[13] gf180mcu_as_sc_mcu7t3v3__tiel_4
X_3092_ VDD VDD VSS VSS _3137_/B _4932_/Q _3095_/C gf180mcu_as_sc_mcu7t3v3__or2_2
XFILLER_149_924 VDD VDD VSS VSS gf180mcu_as_sc_mcu7t3v3__fill_2
XPHY_EDGE_ROW_23_3_Left_157 VDD VSS gf180mcu_as_sc_mcu7t3v3__tap_2
X_3994_ VDD VDD VSS VSS _4164_/S _3994_/B _3994_/A _3995_/B gf180mcu_as_sc_mcu7t3v3__mux2_2
XFILLER_13_18 VDD VDD VSS VSS gf180mcu_as_sc_mcu7t3v3__fillcap_16
XFILLER_148_412 VDD VDD VSS VSS gf180mcu_as_sc_mcu7t3v3__fill_1
XFILLER_149_946 VDD VDD VSS VSS gf180mcu_as_sc_mcu7t3v3__fill_2
X_2945_ VDD VDD VSS VSS _3218_/B _3283_/A _2945_/Y gf180mcu_as_sc_mcu7t3v3__and2_2
XFILLER_129_18 VDD VDD VSS VSS gf180mcu_as_sc_mcu7t3v3__fillcap_16
XFILLER_149_968 VDD VDD VSS VSS gf180mcu_as_sc_mcu7t3v3__fill_2
X_2876_ VDD VDD VSS VSS _4719_/B _4652_/B _2876_/B _4691_/C gf180mcu_as_sc_mcu7t3v3__ao21_2
XFILLER_164_949 VDD VDD VSS VSS gf180mcu_as_sc_mcu7t3v3__fill_1
X_4615_ VDD VDD VSS VSS _5209_/Q _4623_/B _4623_/C _5210_/Q _5209_/D gf180mcu_as_sc_mcu7t3v3__ao22_2
XFILLER_135_139 VDD VDD VSS VSS gf180mcu_as_sc_mcu7t3v3__fill_1
XFILLER_159_1028 VDD VDD VSS VSS gf180mcu_as_sc_mcu7t3v3__fillcap_16
X_4546_ VDD VDD VSS VSS _4546_/D _4581_/A _4546_/B _4546_/C _4547_/B gf180mcu_as_sc_mcu7t3v3__ao31_2
XTAP_TAPCELL_ROW_121_3_2531 VDD VSS gf180mcu_as_sc_mcu7t3v3__tap_2
XFILLER_137_1315 VDD VDD VSS VSS gf180mcu_as_sc_mcu7t3v3__fillcap_8
XFILLER_172_960 VDD VDD VSS VSS gf180mcu_as_sc_mcu7t3v3__fillcap_16
XFILLER_137_1348 VDD VDD VSS VSS gf180mcu_as_sc_mcu7t3v3__fillcap_16
XFILLER_171_470 VDD VDD VSS VSS gf180mcu_as_sc_mcu7t3v3__fillcap_8
XFILLER_171_492 VDD VDD VSS VSS gf180mcu_as_sc_mcu7t3v3__fill_2
XFILLER_176_1375 VDD VDD VSS VSS gf180mcu_as_sc_mcu7t3v3__fillcap_4
XFILLER_176_1397 VDD VDD VSS VSS gf180mcu_as_sc_mcu7t3v3__fillcap_4
X_4477_ VDD VDD VSS VSS _4478_/D _4477_/B _4589_/A gf180mcu_as_sc_mcu7t3v3__nor2_2
XFILLER_143_194 VDD VDD VSS VSS gf180mcu_as_sc_mcu7t3v3__fillcap_4
X_3428_ VDD VDD VSS VSS _4077_/D _3475_/B _3428_/C _3428_/D _3429_/A gf180mcu_as_sc_mcu7t3v3__ao211_2
XFILLER_24_1518 VDD VDD VSS VSS gf180mcu_as_sc_mcu7t3v3__fillcap_16
X_3359_ VDD VDD VSS VSS _3424_/B _3359_/B _3359_/C _3360_/C gf180mcu_as_sc_mcu7t3v3__nor3_2
XFILLER_135_1083 VDD VDD VSS VSS gf180mcu_as_sc_mcu7t3v3__fill_2
XFILLER_38_37 VDD VDD VSS VSS gf180mcu_as_sc_mcu7t3v3__fillcap_16
XFILLER_57_123 VDD VDD VSS VSS gf180mcu_as_sc_mcu7t3v3__fillcap_16
XFILLER_6_1483 VDD VDD VSS VSS gf180mcu_as_sc_mcu7t3v3__fill_1
XFILLER_72_104 VDD VDD VSS VSS gf180mcu_as_sc_mcu7t3v3__fill_1
XFILLER_72_115 VDD VDD VSS VSS gf180mcu_as_sc_mcu7t3v3__fillcap_4
XFILLER_72_126 VDD VDD VSS VSS gf180mcu_as_sc_mcu7t3v3__fill_2
X_5029_ VDD VDD VSS VSS _5173_/CLK _5029_/D _5029_/Q gf180mcu_as_sc_mcu7t3v3__dfxtp_2
XFILLER_148_1433 VDD VDD VSS VSS gf180mcu_as_sc_mcu7t3v3__fill_2
XFILLER_139_401 VDD VDD VSS VSS gf180mcu_as_sc_mcu7t3v3__fillcap_16
XFILLER_142_1032 VDD VDD VSS VSS gf180mcu_as_sc_mcu7t3v3__fillcap_4
XFILLER_167_710 VDD VDD VSS VSS gf180mcu_as_sc_mcu7t3v3__fill_2
XFILLER_179_570 VDD VDD VSS VSS gf180mcu_as_sc_mcu7t3v3__fillcap_4
XFILLER_181_1070 VDD VDD VSS VSS gf180mcu_as_sc_mcu7t3v3__fill_1
XFILLER_139_478 VDD VDD VSS VSS gf180mcu_as_sc_mcu7t3v3__fill_1
XFILLER_142_1087 VDD VDD VSS VSS gf180mcu_as_sc_mcu7t3v3__fillcap_16
XFILLER_177_1106 VDD VDD VSS VSS gf180mcu_as_sc_mcu7t3v3__fill_2
XPHY_EDGE_ROW_165_Right_299 VDD VSS gf180mcu_as_sc_mcu7t3v3__tap_2
XTAP_TAPCELL_ROW_3_1_649 VDD VSS gf180mcu_as_sc_mcu7t3v3__tap_2
XTAP_TAPCELL_ROW_173_2070 VDD VSS gf180mcu_as_sc_mcu7t3v3__tap_2
XFILLER_181_212 VDD VDD VSS VSS gf180mcu_as_sc_mcu7t3v3__fillcap_16
XFILLER_163_982 VDD VDD VSS VSS gf180mcu_as_sc_mcu7t3v3__fillcap_16
XFILLER_134_172 VDD VDD VSS VSS gf180mcu_as_sc_mcu7t3v3__fillcap_4
XFILLER_68_1467 VDD VDD VSS VSS gf180mcu_as_sc_mcu7t3v3__fillcap_16
XFILLER_79_88 VDD VDD VSS VSS gf180mcu_as_sc_mcu7t3v3__fillcap_4
XFILLER_135_72 VDD VDD VSS VSS gf180mcu_as_sc_mcu7t3v3__fill_2
XFILLER_153_1150 VDD VDD VSS VSS gf180mcu_as_sc_mcu7t3v3__fillcap_8
XFILLER_95_207 VDD VDD VSS VSS gf180mcu_as_sc_mcu7t3v3__fill_2
XFILLER_48_134 VDD VDD VSS VSS gf180mcu_as_sc_mcu7t3v3__fillcap_8
XFILLER_95_65 VDD VDD VSS VSS gf180mcu_as_sc_mcu7t3v3__fillcap_4
XFILLER_149_1219 VDD VDD VSS VSS gf180mcu_as_sc_mcu7t3v3__fillcap_8
XTAP_TAPCELL_ROW_51_3_2426 VDD VSS gf180mcu_as_sc_mcu7t3v3__tap_2
XFILLER_166_1555 VDD VDD VSS VSS gf180mcu_as_sc_mcu7t3v3__fillcap_8
XTAP_TAPCELL_ROW_141_1368 VDD VSS gf180mcu_as_sc_mcu7t3v3__tap_2
XTAP_TAPCELL_ROW_141_1357 VDD VSS gf180mcu_as_sc_mcu7t3v3__tap_2
XFILLER_44_80 VDD VDD VSS VSS gf180mcu_as_sc_mcu7t3v3__fillcap_16
XFILLER_71_170 VDD VDD VSS VSS gf180mcu_as_sc_mcu7t3v3__fillcap_16
XFILLER_157_231 VDD VDD VSS VSS gf180mcu_as_sc_mcu7t3v3__fillcap_16
XFILLER_160_1154 VDD VDD VSS VSS gf180mcu_as_sc_mcu7t3v3__fill_1
XFILLER_81_6 VDD VDD VSS VSS gf180mcu_as_sc_mcu7t3v3__fill_1
X_2730_ VDD VDD VSS VSS _2730_/A _2730_/B _2730_/C _2730_/D _2730_/Y gf180mcu_as_sc_mcu7t3v3__ao22_2
XFILLER_146_938 VDD VDD VSS VSS gf180mcu_as_sc_mcu7t3v3__fillcap_4
XFILLER_173_713 VDD VDD VSS VSS gf180mcu_as_sc_mcu7t3v3__fillcap_4
XFILLER_8_241 VDD VDD VSS VSS gf180mcu_as_sc_mcu7t3v3__fillcap_4
XFILLER_8_263 VDD VDD VSS VSS gf180mcu_as_sc_mcu7t3v3__fillcap_16
X_2661_ VDD VDD VSS VSS _2662_/D _2661_/B _2674_/C gf180mcu_as_sc_mcu7t3v3__nor2_2
XFILLER_161_908 VDD VDD VSS VSS gf180mcu_as_sc_mcu7t3v3__fill_2
XFILLER_173_768 VDD VDD VSS VSS gf180mcu_as_sc_mcu7t3v3__fill_2
X_4400_ VDD VDD VSS VSS _4400_/B _4506_/A _4407_/C gf180mcu_as_sc_mcu7t3v3__and2_2
XFILLER_160_418 VDD VDD VSS VSS gf180mcu_as_sc_mcu7t3v3__fillcap_8
XFILLER_86_1534 VDD VDD VSS VSS gf180mcu_as_sc_mcu7t3v3__fillcap_16
X_2592_ VDD VDD VSS VSS _2852_/B _4652_/B _2598_/A gf180mcu_as_sc_mcu7t3v3__and2_2
XFILLER_153_481 VDD VDD VSS VSS gf180mcu_as_sc_mcu7t3v3__fillcap_8
XFILLER_153_492 VDD VDD VSS VSS gf180mcu_as_sc_mcu7t3v3__fillcap_16
XFILLER_173_1504 VDD VDD VSS VSS gf180mcu_as_sc_mcu7t3v3__fillcap_16
XFILLER_181_790 VDD VDD VSS VSS gf180mcu_as_sc_mcu7t3v3__fill_1
XFILLER_86_1556 VDD VDD VSS VSS gf180mcu_as_sc_mcu7t3v3__fillcap_8
X_4331_ VDD VDD VSS VSS _5271_/Q _5126_/Q _4708_/C _4331_/D _4332_/D gf180mcu_as_sc_mcu7t3v3__ao211_2
XTAP_TAPCELL_ROW_79_1_951 VDD VSS gf180mcu_as_sc_mcu7t3v3__tap_2
X_4262_ VDD VDD VSS VSS _4262_/B _4264_/A _4263_/B gf180mcu_as_sc_mcu7t3v3__xnor2_2
X_3213_ VDD VDD VSS VSS _3213_/D _3213_/A _3213_/B _3213_/C _3215_/B gf180mcu_as_sc_mcu7t3v3__ao31_2
X_4193_ VDD VDD VSS VSS _4253_/B _4197_/B _4197_/C _5031_/Q _5031_/D gf180mcu_as_sc_mcu7t3v3__ao22_2
XTAP_TAPCELL_ROW_169_1983 VDD VSS gf180mcu_as_sc_mcu7t3v3__tap_2
XTAP_TAPCELL_ROW_169_1972 VDD VSS gf180mcu_as_sc_mcu7t3v3__tap_2
X_3144_ VDD VDD VSS VSS _4120_/A _3144_/B _3169_/C _4121_/D _3145_/C gf180mcu_as_sc_mcu7t3v3__ao22_2
XFILLER_54_104 VDD VDD VSS VSS gf180mcu_as_sc_mcu7t3v3__fill_1
X_3075_ VDD VDD VSS VSS _3118_/S _4053_/A _4055_/A _3077_/B gf180mcu_as_sc_mcu7t3v3__mux2_2
XPHY_EDGE_ROW_22_1_Right_21 VDD VSS gf180mcu_as_sc_mcu7t3v3__tap_2
XFILLER_168_529 VDD VDD VSS VSS gf180mcu_as_sc_mcu7t3v3__fill_1
X_3977_ VDD VDD VSS VSS _3977_/A _4105_/B _3977_/C _3977_/D _3978_/B gf180mcu_as_sc_mcu7t3v3__ao211_2
XFILLER_108_1483 VDD VDD VSS VSS gf180mcu_as_sc_mcu7t3v3__fill_1
XFILLER_143_1374 VDD VDD VSS VSS gf180mcu_as_sc_mcu7t3v3__fill_2
X_2928_ VDD VDD VSS VSS _3216_/C _3216_/B _2928_/Y gf180mcu_as_sc_mcu7t3v3__and2_2
XFILLER_137_927 VDD VDD VSS VSS gf180mcu_as_sc_mcu7t3v3__fill_2
XFILLER_137_938 VDD VDD VSS VSS gf180mcu_as_sc_mcu7t3v3__fillcap_8
XFILLER_143_1396 VDD VDD VSS VSS gf180mcu_as_sc_mcu7t3v3__fillcap_4
XFILLER_148_275 VDD VDD VSS VSS gf180mcu_as_sc_mcu7t3v3__fillcap_16
XFILLER_176_562 VDD VDD VSS VSS gf180mcu_as_sc_mcu7t3v3__fillcap_16
XPHY_EDGE_ROW_118_1_Left_570 VDD VSS gf180mcu_as_sc_mcu7t3v3__tap_2
XFILLER_108_139 VDD VDD VSS VSS gf180mcu_as_sc_mcu7t3v3__fillcap_4
XFILLER_163_212 VDD VDD VSS VSS gf180mcu_as_sc_mcu7t3v3__fillcap_4
X_2859_ VDD VDD VSS VSS _4749_/B _4745_/B _2861_/B gf180mcu_as_sc_mcu7t3v3__and2_2
XTAP_TAPCELL_ROW_123_1_1127 VDD VSS gf180mcu_as_sc_mcu7t3v3__tap_2
XFILLER_144_481 VDD VDD VSS VSS gf180mcu_as_sc_mcu7t3v3__fill_1
XFILLER_145_982 VDD VDD VSS VSS gf180mcu_as_sc_mcu7t3v3__fillcap_16
XFILLER_172_790 VDD VDD VSS VSS gf180mcu_as_sc_mcu7t3v3__fill_1
XFILLER_176_1161 VDD VDD VSS VSS gf180mcu_as_sc_mcu7t3v3__fill_2
X_4529_ VDD VDD VSS VSS _4529_/D _4587_/A _4529_/B _4529_/C _4530_/B gf180mcu_as_sc_mcu7t3v3__ao31_2
XFILLER_131_142 VDD VDD VSS VSS gf180mcu_as_sc_mcu7t3v3__fillcap_16
XFILLER_137_1178 VDD VDD VSS VSS gf180mcu_as_sc_mcu7t3v3__fill_1
XFILLER_172_37 VDD VDD VSS VSS gf180mcu_as_sc_mcu7t3v3__fill_1
XFILLER_28_1451 VDD VDD VSS VSS gf180mcu_as_sc_mcu7t3v3__fillcap_16
XFILLER_8_1534 VDD VDD VSS VSS gf180mcu_as_sc_mcu7t3v3__fillcap_16
Xfanout710 VDD VDD VSS VSS _2903_/Y _3168_/B gf180mcu_as_sc_mcu7t3v3__buff_2
Xfanout721 VDD VDD VSS VSS _2857_/Y _4720_/A gf180mcu_as_sc_mcu7t3v3__buff_2
Xfanout732 VDD VDD VSS VSS _2681_/Y _4281_/S gf180mcu_as_sc_mcu7t3v3__buff_2
XFILLER_150_1323 VDD VDD VSS VSS gf180mcu_as_sc_mcu7t3v3__fill_1
XFILLER_8_1556 VDD VDD VSS VSS gf180mcu_as_sc_mcu7t3v3__fillcap_8
Xfanout743 VDD VDD VSS VSS _2677_/Y _4269_/S gf180mcu_as_sc_mcu7t3v3__buff_2
Xfanout754 VDD VDD VSS VSS _5223_/Q _4703_/A gf180mcu_as_sc_mcu7t3v3__buff_2
Xfanout765 VDD VDD VSS VSS _4553_/A _4520_/A gf180mcu_as_sc_mcu7t3v3__buff_2
Xfanout776 VDD VDD VSS VSS _4536_/S _4586_/S gf180mcu_as_sc_mcu7t3v3__buff_2
XTAP_TAPCELL_ROW_103_1_1047 VDD VSS gf180mcu_as_sc_mcu7t3v3__tap_2
XFILLER_150_1367 VDD VDD VSS VSS gf180mcu_as_sc_mcu7t3v3__fillcap_16
XFILLER_85_240 VDD VDD VSS VSS gf180mcu_as_sc_mcu7t3v3__fillcap_16
XFILLER_85_262 VDD VDD VSS VSS gf180mcu_as_sc_mcu7t3v3__fill_1
Xfanout787 VDD VDD VSS VSS _3624_/A _3795_/A gf180mcu_as_sc_mcu7t3v3__buff_2
Xfanout798 VDD VDD VSS VSS _3601_/D _3753_/D gf180mcu_as_sc_mcu7t3v3__buff_2
XPHY_EDGE_ROW_8_3_Left_142 VDD VSS gf180mcu_as_sc_mcu7t3v3__tap_2
XFILLER_45_159 VDD VDD VSS VSS gf180mcu_as_sc_mcu7t3v3__fill_2
XFILLER_148_1263 VDD VDD VSS VSS gf180mcu_as_sc_mcu7t3v3__fillcap_4
XTAP_TAPCELL_ROW_175_2110 VDD VSS gf180mcu_as_sc_mcu7t3v3__tap_2
XFILLER_126_1550 VDD VDD VSS VSS gf180mcu_as_sc_mcu7t3v3__fillcap_4
XFILLER_155_702 VDD VDD VSS VSS gf180mcu_as_sc_mcu7t3v3__fillcap_16
XFILLER_167_562 VDD VDD VSS VSS gf180mcu_as_sc_mcu7t3v3__fillcap_16
XFILLER_35_1499 VDD VDD VSS VSS gf180mcu_as_sc_mcu7t3v3__fillcap_16
XTAP_TAPCELL_ROW_171_2029 VDD VSS gf180mcu_as_sc_mcu7t3v3__tap_2
XTAP_TAPCELL_ROW_171_2018 VDD VSS gf180mcu_as_sc_mcu7t3v3__tap_2
XFILLER_5_244 VDD VDD VSS VSS gf180mcu_as_sc_mcu7t3v3__fillcap_8
XFILLER_170_749 VDD VDD VSS VSS gf180mcu_as_sc_mcu7t3v3__fill_1
XTAP_TAPCELL_ROW_134_1172 VDD VSS gf180mcu_as_sc_mcu7t3v3__tap_2
XFILLER_135_492 VDD VDD VSS VSS gf180mcu_as_sc_mcu7t3v3__fill_2
XFILLER_5_299 VDD VDD VSS VSS gf180mcu_as_sc_mcu7t3v3__fill_2
XTAP_TAPCELL_ROW_134_1194 VDD VSS gf180mcu_as_sc_mcu7t3v3__tap_2
XTAP_TAPCELL_ROW_134_1183 VDD VSS gf180mcu_as_sc_mcu7t3v3__tap_2
XFILLER_150_473 VDD VDD VSS VSS gf180mcu_as_sc_mcu7t3v3__fill_2
XFILLER_122_197 VDD VDD VSS VSS gf180mcu_as_sc_mcu7t3v3__fill_2
XFILLER_133_1521 VDD VDD VSS VSS gf180mcu_as_sc_mcu7t3v3__fillcap_16
XTAP_TAPCELL_ROW_147_1500 VDD VSS gf180mcu_as_sc_mcu7t3v3__tap_2
Xinput9 VDD VDD VSS VSS boot_addr[7] input9/Y gf180mcu_as_sc_mcu7t3v3__buff_2
XTAP_TAPCELL_ROW_69_3_2453 VDD VSS gf180mcu_as_sc_mcu7t3v3__tap_2
XTAP_TAPCELL_ROW_143_1408 VDD VSS gf180mcu_as_sc_mcu7t3v3__tap_2
XFILLER_149_1049 VDD VDD VSS VSS gf180mcu_as_sc_mcu7t3v3__fill_1
X_4880_ VDD VDD VSS VSS _4914_/CLK _4880_/D _4880_/Q gf180mcu_as_sc_mcu7t3v3__dfxtp_2
X_3900_ VDD VDD VSS VSS _3908_/B _5158_/Q _4940_/D gf180mcu_as_sc_mcu7t3v3__and2_2
XTAP_TAPCELL_ROW_160_1777 VDD VSS gf180mcu_as_sc_mcu7t3v3__tap_2
XTAP_TAPCELL_ROW_160_1766 VDD VSS gf180mcu_as_sc_mcu7t3v3__tap_2
XFILLER_178_838 VDD VDD VSS VSS gf180mcu_as_sc_mcu7t3v3__fillcap_4
X_3831_ VDD VDD VSS VSS _4753_/A _4752_/B _4752_/C _4909_/D gf180mcu_as_sc_mcu7t3v3__nor3_2
X_3762_ VDD VDD VSS VSS _4941_/Q _3762_/B _3770_/C _4144_/A _3764_/C gf180mcu_as_sc_mcu7t3v3__ao22_2
XFILLER_72_2 VDD VDD VSS VSS gf180mcu_as_sc_mcu7t3v3__fillcap_8
XFILLER_145_212 VDD VDD VSS VSS gf180mcu_as_sc_mcu7t3v3__fill_2
X_3693_ VDD VDD VSS VSS _4932_/Q _3740_/B _3740_/C _4071_/A _3695_/C gf180mcu_as_sc_mcu7t3v3__ao22_2
X_2713_ VDD VDD VSS VSS _2727_/S _2713_/B _2713_/A _2714_/C gf180mcu_as_sc_mcu7t3v3__mux2_2
XFILLER_173_554 VDD VDD VSS VSS gf180mcu_as_sc_mcu7t3v3__fillcap_4
X_2644_ VDD VDD VSS VSS _2666_/B _2644_/C _2644_/B _2653_/S gf180mcu_as_sc_mcu7t3v3__aoi21b_2
Xoutput335 VDD VDD VSS VSS _4858_/Q east_out[19] gf180mcu_as_sc_mcu7t3v3__buff_2
Xoutput324 VDD VDD VSS VSS _5485_/Y dft_rdata[7] gf180mcu_as_sc_mcu7t3v3__buff_2
X_2575_ VDD VDD VSS VSS _2599_/A _2852_/B _2575_/B _5097_/Q gf180mcu_as_sc_mcu7t3v3__ao21_2
XFILLER_138_1432 VDD VDD VSS VSS gf180mcu_as_sc_mcu7t3v3__fill_2
XFILLER_173_1323 VDD VDD VSS VSS gf180mcu_as_sc_mcu7t3v3__fillcap_4
Xoutput368 VDD VDD VSS VSS _4789_/Q se_out[18] gf180mcu_as_sc_mcu7t3v3__buff_2
Xoutput357 VDD VDD VSS VSS _4847_/Q east_out[8] gf180mcu_as_sc_mcu7t3v3__buff_2
Xoutput346 VDD VDD VSS VSS _4868_/Q east_out[29] gf180mcu_as_sc_mcu7t3v3__buff_2
X_4314_ VDD VDD VSS VSS _4321_/S _5144_/Q _5143_/Q _5143_/D gf180mcu_as_sc_mcu7t3v3__mux2_2
XFILLER_113_142 VDD VDD VSS VSS gf180mcu_as_sc_mcu7t3v3__fill_2
Xoutput379 VDD VDD VSS VSS _4799_/Q se_out[28] gf180mcu_as_sc_mcu7t3v3__buff_2
X_4245_ VDD VDD VSS VSS _4252_/S _4245_/B _5081_/Q _5081_/D gf180mcu_as_sc_mcu7t3v3__mux2_2
XFILLER_67_251 VDD VDD VSS VSS gf180mcu_as_sc_mcu7t3v3__fill_1
X_4176_ VDD VDD VSS VSS _4236_/B _4197_/B _4197_/C _5014_/Q _5014_/D gf180mcu_as_sc_mcu7t3v3__ao22_2
XFILLER_27_104 VDD VDD VSS VSS gf180mcu_as_sc_mcu7t3v3__fillcap_16
X_3127_ VDD VDD VSS VSS _4102_/A _3127_/B _3127_/C _4101_/D _3128_/C gf180mcu_as_sc_mcu7t3v3__ao22_2
XTAP_TAPCELL_ROW_21_3_2381 VDD VSS gf180mcu_as_sc_mcu7t3v3__tap_2
XFILLER_184_1430 VDD VDD VSS VSS gf180mcu_as_sc_mcu7t3v3__fill_1
X_3058_ VDD VDD VSS VSS _4038_/A _3142_/B _3142_/C _4037_/A _3064_/B gf180mcu_as_sc_mcu7t3v3__ao22_2
XFILLER_82_298 VDD VDD VSS VSS gf180mcu_as_sc_mcu7t3v3__fill_2
XFILLER_143_8 VDD VDD VSS VSS gf180mcu_as_sc_mcu7t3v3__fillcap_16
XFILLER_169_838 VDD VDD VSS VSS gf180mcu_as_sc_mcu7t3v3__fill_2
XFILLER_50_162 VDD VDD VSS VSS gf180mcu_as_sc_mcu7t3v3__fill_1
XFILLER_50_173 VDD VDD VSS VSS gf180mcu_as_sc_mcu7t3v3__fill_2
XFILLER_137_702 VDD VDD VSS VSS gf180mcu_as_sc_mcu7t3v3__fill_2
XFILLER_143_1160 VDD VDD VSS VSS gf180mcu_as_sc_mcu7t3v3__fill_2
XFILLER_149_562 VDD VDD VSS VSS gf180mcu_as_sc_mcu7t3v3__fillcap_8
XFILLER_177_860 VDD VDD VSS VSS gf180mcu_as_sc_mcu7t3v3__fill_2
XFILLER_164_510 VDD VDD VSS VSS gf180mcu_as_sc_mcu7t3v3__fillcap_8
XFILLER_176_381 VDD VDD VSS VSS gf180mcu_as_sc_mcu7t3v3__fillcap_4
XFILLER_178_1223 VDD VDD VSS VSS gf180mcu_as_sc_mcu7t3v3__fill_2
XFILLER_136_267 VDD VDD VSS VSS gf180mcu_as_sc_mcu7t3v3__fill_1
XFILLER_137_768 VDD VDD VSS VSS gf180mcu_as_sc_mcu7t3v3__fill_2
XFILLER_178_1256 VDD VDD VSS VSS gf180mcu_as_sc_mcu7t3v3__fillcap_8
XFILLER_139_1218 VDD VDD VSS VSS gf180mcu_as_sc_mcu7t3v3__fillcap_4
XFILLER_164_587 VDD VDD VSS VSS gf180mcu_as_sc_mcu7t3v3__fill_1
XFILLER_2_203 VDD VDD VSS VSS gf180mcu_as_sc_mcu7t3v3__fill_1
XFILLER_2_247 VDD VDD VSS VSS gf180mcu_as_sc_mcu7t3v3__fillcap_4
XFILLER_104_197 VDD VDD VSS VSS gf180mcu_as_sc_mcu7t3v3__fill_2
XFILLER_116_74 VDD VDD VSS VSS gf180mcu_as_sc_mcu7t3v3__fillcap_16
XFILLER_160_793 VDD VDD VSS VSS gf180mcu_as_sc_mcu7t3v3__fillcap_8
XFILLER_76_34 VDD VDD VSS VSS gf180mcu_as_sc_mcu7t3v3__fill_1
Xfanout540 VDD VDD VSS VSS fanout543/Y _3750_/B gf180mcu_as_sc_mcu7t3v3__buff_2
Xfanout551 VDD VDD VSS VSS fanout553/Y _3453_/B gf180mcu_as_sc_mcu7t3v3__buff_2
XFILLER_58_251 VDD VDD VSS VSS gf180mcu_as_sc_mcu7t3v3__fill_2
XPHY_EDGE_ROW_100_3_Left_234 VDD VSS gf180mcu_as_sc_mcu7t3v3__tap_2
Xfanout562 VDD VDD VSS VSS _4192_/C _4190_/C gf180mcu_as_sc_mcu7t3v3__buff_2
Xfanout573 VDD VDD VSS VSS _3905_/B _3908_/B gf180mcu_as_sc_mcu7t3v3__buff_2
Xfanout584 VDD VDD VSS VSS _4575_/B _4590_/B gf180mcu_as_sc_mcu7t3v3__buff_2
Xfanout595 VDD VDD VSS VSS fanout597/Y _4101_/B gf180mcu_as_sc_mcu7t3v3__buff_2
XFILLER_150_1186 VDD VDD VSS VSS gf180mcu_as_sc_mcu7t3v3__fillcap_4
Xclkbuf_leaf_12_clk_regs VDD VDD VSS VSS clkbuf_3_2_0_clk_regs/Y _5164_/CLK gf180mcu_as_sc_mcu7t3v3__clkbuff_12
XFILLER_73_298 VDD VDD VSS VSS gf180mcu_as_sc_mcu7t3v3__fill_2
XFILLER_92_88 VDD VDD VSS VSS gf180mcu_as_sc_mcu7t3v3__fillcap_4
XFILLER_163_1536 VDD VDD VSS VSS gf180mcu_as_sc_mcu7t3v3__fillcap_4
XFILLER_159_348 VDD VDD VSS VSS gf180mcu_as_sc_mcu7t3v3__fill_2
XFILLER_163_1558 VDD VDD VSS VSS gf180mcu_as_sc_mcu7t3v3__fillcap_8
XFILLER_168_871 VDD VDD VSS VSS gf180mcu_as_sc_mcu7t3v3__fillcap_4
XFILLER_127_212 VDD VDD VSS VSS gf180mcu_as_sc_mcu7t3v3__fill_2
XFILLER_161_1293 VDD VDD VSS VSS gf180mcu_as_sc_mcu7t3v3__fillcap_8
XFILLER_168_893 VDD VDD VSS VSS gf180mcu_as_sc_mcu7t3v3__fillcap_8
XFILLER_127_234 VDD VDD VSS VSS gf180mcu_as_sc_mcu7t3v3__fillcap_16
XPHY_EDGE_ROW_100_3_Right_419 VDD VSS gf180mcu_as_sc_mcu7t3v3__tap_2
XTAP_TAPCELL_ROW_136_1256 VDD VSS gf180mcu_as_sc_mcu7t3v3__tap_2
XTAP_TAPCELL_ROW_136_1245 VDD VSS gf180mcu_as_sc_mcu7t3v3__tap_2
XFILLER_157_1329 VDD VDD VSS VSS gf180mcu_as_sc_mcu7t3v3__fill_1
XFILLER_170_524 VDD VDD VSS VSS gf180mcu_as_sc_mcu7t3v3__fill_1
XFILLER_170_535 VDD VDD VSS VSS gf180mcu_as_sc_mcu7t3v3__fill_2
XFILLER_100_1564 VDD VDD VSS VSS gf180mcu_as_sc_mcu7t3v3__fillcap_4
XFILLER_83_1515 VDD VDD VSS VSS gf180mcu_as_sc_mcu7t3v3__fillcap_4
XFILLER_170_1507 VDD VDD VSS VSS gf180mcu_as_sc_mcu7t3v3__fillcap_16
XFILLER_83_1537 VDD VDD VSS VSS gf180mcu_as_sc_mcu7t3v3__fillcap_16
XPHY_EDGE_ROW_32_3_Left_166 VDD VSS gf180mcu_as_sc_mcu7t3v3__tap_2
XFILLER_110_145 VDD VDD VSS VSS gf180mcu_as_sc_mcu7t3v3__fillcap_4
XFILLER_2_53 VDD VDD VSS VSS gf180mcu_as_sc_mcu7t3v3__fillcap_16
XFILLER_49_251 VDD VDD VSS VSS gf180mcu_as_sc_mcu7t3v3__fill_1
X_4030_ VDD VDD VSS VSS _4030_/A _4118_/C _4121_/B _4030_/D _4031_/D gf180mcu_as_sc_mcu7t3v3__ao22_2
XFILLER_110_167 VDD VDD VSS VSS gf180mcu_as_sc_mcu7t3v3__fillcap_8
XTAP_TAPCELL_ROW_162_1817 VDD VSS gf180mcu_as_sc_mcu7t3v3__tap_2
XTAP_TAPCELL_ROW_162_1828 VDD VSS gf180mcu_as_sc_mcu7t3v3__tap_2
XFILLER_24_107 VDD VDD VSS VSS gf180mcu_as_sc_mcu7t3v3__fillcap_16
X_4932_ VDD VDD VSS VSS _5080_/CLK _4932_/D _4932_/Q gf180mcu_as_sc_mcu7t3v3__dfxtp_2
XFILLER_166_1193 VDD VDD VSS VSS gf180mcu_as_sc_mcu7t3v3__fillcap_16
XFILLER_178_613 VDD VDD VSS VSS gf180mcu_as_sc_mcu7t3v3__fillcap_8
X_4863_ VDD VDD VSS VSS _4863_/CLK _4863_/D _4863_/Q gf180mcu_as_sc_mcu7t3v3__dfxtp_2
XFILLER_178_679 VDD VDD VSS VSS gf180mcu_as_sc_mcu7t3v3__fill_2
XFILLER_18_1483 VDD VDD VSS VSS gf180mcu_as_sc_mcu7t3v3__fill_1
X_4794_ VDD VDD VSS VSS _4938_/CLK _4794_/D _4794_/Q gf180mcu_as_sc_mcu7t3v3__dfxtp_2
X_3814_ VDD VDD VSS VSS _3814_/B _3814_/A _3920_/B gf180mcu_as_sc_mcu7t3v3__or2_2
XFILLER_174_830 VDD VDD VSS VSS gf180mcu_as_sc_mcu7t3v3__fillcap_8
XFILLER_21_18 VDD VDD VSS VSS gf180mcu_as_sc_mcu7t3v3__fillcap_16
X_3745_ VDD VDD VSS VSS _3746_/C _3745_/C _3745_/B _4122_/A gf180mcu_as_sc_mcu7t3v3__aoi21_2
XFILLER_137_18 VDD VDD VSS VSS gf180mcu_as_sc_mcu7t3v3__fillcap_16
XFILLER_133_204 VDD VDD VSS VSS gf180mcu_as_sc_mcu7t3v3__fillcap_4
XFILLER_134_716 VDD VDD VSS VSS gf180mcu_as_sc_mcu7t3v3__fillcap_16
XFILLER_173_384 VDD VDD VSS VSS gf180mcu_as_sc_mcu7t3v3__fillcap_16
X_3676_ VDD VDD VSS VSS _3676_/A _3753_/B _3676_/C _4853_/D _3805_/C gf180mcu_as_sc_mcu7t3v3__aoi211_2
X_2627_ VDD VDD VSS VSS _2627_/D _4262_/B _2627_/B _2627_/C _2628_/B gf180mcu_as_sc_mcu7t3v3__ao31_2
XFILLER_142_771 VDD VDD VSS VSS gf180mcu_as_sc_mcu7t3v3__fillcap_16
X_2558_ VDD VDD VSS VSS _2558_/D _2558_/A _2558_/B _2558_/C _2559_/B gf180mcu_as_sc_mcu7t3v3__ao31_2
XFILLER_101_112 VDD VDD VSS VSS gf180mcu_as_sc_mcu7t3v3__fill_1
XFILLER_138_1284 VDD VDD VSS VSS gf180mcu_as_sc_mcu7t3v3__fillcap_8
XFILLER_173_1175 VDD VDD VSS VSS gf180mcu_as_sc_mcu7t3v3__fillcap_4
X_5277_ VDD VDD VSS VSS clkload5/A _5277_/D _5277_/Q gf180mcu_as_sc_mcu7t3v3__dfxtp_2
X_2489_ VDD VDD VSS VSS _4594_/A _4329_/A _4719_/A gf180mcu_as_sc_mcu7t3v3__nand2_2
XFILLER_101_134 VDD VDD VSS VSS gf180mcu_as_sc_mcu7t3v3__fillcap_4
XFILLER_5_1515 VDD VDD VSS VSS gf180mcu_as_sc_mcu7t3v3__fillcap_4
X_4228_ VDD VDD VSS VSS _4257_/B _4228_/B _4228_/C _5064_/Q _5064_/D gf180mcu_as_sc_mcu7t3v3__ao22_2
XFILLER_101_178 VDD VDD VSS VSS gf180mcu_as_sc_mcu7t3v3__fillcap_16
XFILLER_5_1537 VDD VDD VSS VSS gf180mcu_as_sc_mcu7t3v3__fillcap_16
XFILLER_151_1495 VDD VDD VSS VSS gf180mcu_as_sc_mcu7t3v3__fillcap_4
XFILLER_46_37 VDD VDD VSS VSS gf180mcu_as_sc_mcu7t3v3__fill_1
X_4159_ VDD VDD VSS VSS _4159_/A _4159_/B _4159_/C _4159_/D _4161_/C gf180mcu_as_sc_mcu7t3v3__ao22_2
XFILLER_70_202 VDD VDD VSS VSS gf180mcu_as_sc_mcu7t3v3__fill_1
XFILLER_55_298 VDD VDD VSS VSS gf180mcu_as_sc_mcu7t3v3__fill_2
XFILLER_168_101 VDD VDD VSS VSS gf180mcu_as_sc_mcu7t3v3__fillcap_4
XFILLER_169_624 VDD VDD VSS VSS gf180mcu_as_sc_mcu7t3v3__fillcap_4
XFILLER_184_1260 VDD VDD VSS VSS gf180mcu_as_sc_mcu7t3v3__fillcap_8
XTAP_TAPCELL_ROW_127_3_2540 VDD VSS gf180mcu_as_sc_mcu7t3v3__tap_2
XFILLER_168_123 VDD VDD VSS VSS gf180mcu_as_sc_mcu7t3v3__fillcap_16
XFILLER_141_1108 VDD VDD VSS VSS gf180mcu_as_sc_mcu7t3v3__fill_1
XFILLER_156_307 VDD VDD VSS VSS gf180mcu_as_sc_mcu7t3v3__fill_2
XFILLER_178_69 VDD VDD VSS VSS gf180mcu_as_sc_mcu7t3v3__fillcap_16
XFILLER_180_1157 VDD VDD VSS VSS gf180mcu_as_sc_mcu7t3v3__fillcap_4
XFILLER_36_1550 VDD VDD VSS VSS gf180mcu_as_sc_mcu7t3v3__fillcap_4
XFILLER_109_212 VDD VDD VSS VSS gf180mcu_as_sc_mcu7t3v3__fill_2
XFILLER_165_830 VDD VDD VSS VSS gf180mcu_as_sc_mcu7t3v3__fillcap_8
XFILLER_164_384 VDD VDD VSS VSS gf180mcu_as_sc_mcu7t3v3__fill_1
XFILLER_156_1362 VDD VDD VSS VSS gf180mcu_as_sc_mcu7t3v3__fill_2
XFILLER_2_2 VDD VDD VSS VSS gf180mcu_as_sc_mcu7t3v3__fillcap_16
XFILLER_87_22 VDD VDD VSS VSS gf180mcu_as_sc_mcu7t3v3__fill_1
XFILLER_43_1521 VDD VDD VSS VSS gf180mcu_as_sc_mcu7t3v3__fillcap_16
XFILLER_87_88 VDD VDD VSS VSS gf180mcu_as_sc_mcu7t3v3__fillcap_4
XFILLER_143_72 VDD VDD VSS VSS gf180mcu_as_sc_mcu7t3v3__fillcap_16
XTAP_TAPCELL_ROW_183_2286 VDD VSS gf180mcu_as_sc_mcu7t3v3__tap_2
XTAP_TAPCELL_ROW_183_2275 VDD VSS gf180mcu_as_sc_mcu7t3v3__tap_2
XFILLER_61_257 VDD VDD VSS VSS gf180mcu_as_sc_mcu7t3v3__fill_1
XFILLER_163_1344 VDD VDD VSS VSS gf180mcu_as_sc_mcu7t3v3__fill_2
XFILLER_163_1366 VDD VDD VSS VSS gf180mcu_as_sc_mcu7t3v3__fillcap_8
XFILLER_61_279 VDD VDD VSS VSS gf180mcu_as_sc_mcu7t3v3__fill_1
XFILLER_128_1486 VDD VDD VSS VSS gf180mcu_as_sc_mcu7t3v3__fillcap_16
XFILLER_163_1399 VDD VDD VSS VSS gf180mcu_as_sc_mcu7t3v3__fill_1
XFILLER_175_627 VDD VDD VSS VSS gf180mcu_as_sc_mcu7t3v3__fill_2
XFILLER_52_80 VDD VDD VSS VSS gf180mcu_as_sc_mcu7t3v3__fillcap_16
Xinput12 VDD VDD VSS VSS boot_data[0] _2685_/A gf180mcu_as_sc_mcu7t3v3__buff_2
XTAP_TAPCELL_ROW_11_1_679 VDD VSS gf180mcu_as_sc_mcu7t3v3__tap_2
XFILLER_156_874 VDD VDD VSS VSS gf180mcu_as_sc_mcu7t3v3__fill_1
Xinput23 VDD VDD VSS VSS dft_addr[10] _2583_/B gf180mcu_as_sc_mcu7t3v3__buff_2
Xinput34 VDD VDD VSS VSS dft_mode _2716_/A gf180mcu_as_sc_mcu7t3v3__buff_2
Xinput45 VDD VDD VSS VSS east_in[10] _4015_/A gf180mcu_as_sc_mcu7t3v3__buff_2
X_3530_ VDD VDD VSS VSS _3530_/B _3530_/A _3807_/B gf180mcu_as_sc_mcu7t3v3__and2_2
XTAP_TAPCELL_ROW_155_1665 VDD VSS gf180mcu_as_sc_mcu7t3v3__tap_2
XFILLER_183_693 VDD VDD VSS VSS gf180mcu_as_sc_mcu7t3v3__fill_1
Xinput89 VDD VDD VSS VSS ne_in[1] _3938_/A gf180mcu_as_sc_mcu7t3v3__buff_2
Xinput78 VDD VDD VSS VSS ne_in[0] _3925_/A gf180mcu_as_sc_mcu7t3v3__buff_2
Xinput67 VDD VDD VSS VSS east_in[30] _3797_/A gf180mcu_as_sc_mcu7t3v3__buff_2
Xinput56 VDD VDD VSS VSS east_in[20] _4096_/A gf180mcu_as_sc_mcu7t3v3__buff_2
XTAP_TAPCELL_ROW_155_1676 VDD VSS gf180mcu_as_sc_mcu7t3v3__tap_2
XTAP_TAPCELL_ROW_124_1_1132 VDD VSS gf180mcu_as_sc_mcu7t3v3__tap_2
XFILLER_143_546 VDD VDD VSS VSS gf180mcu_as_sc_mcu7t3v3__fillcap_4
X_3461_ VDD VDD VSS VSS _4110_/A _3474_/C _3476_/B _4114_/A _3462_/C gf180mcu_as_sc_mcu7t3v3__ao22_2
XFILLER_135_1402 VDD VDD VSS VSS gf180mcu_as_sc_mcu7t3v3__fillcap_16
XFILLER_170_365 VDD VDD VSS VSS gf180mcu_as_sc_mcu7t3v3__fillcap_16
XPHY_EDGE_ROW_31_1_Right_30 VDD VSS gf180mcu_as_sc_mcu7t3v3__tap_2
X_5200_ VDD VDD VSS VSS clkload2/A _5200_/D _5200_/Q gf180mcu_as_sc_mcu7t3v3__dfxtp_2
X_3392_ VDD VDD VSS VSS _4043_/A _3447_/B _3392_/C _4818_/D _3722_/D gf180mcu_as_sc_mcu7t3v3__aoi211_2
X_2412_ VDD VDD VSS VSS _2511_/C _5257_/Q gf180mcu_as_sc_mcu7t3v3__inv_2
XTAP_TAPCELL_ROW_57_3_2435 VDD VSS gf180mcu_as_sc_mcu7t3v3__tap_2
XFILLER_170_387 VDD VDD VSS VSS gf180mcu_as_sc_mcu7t3v3__fillcap_16
X_5131_ VDD VDD VSS VSS _5199_/CLK _5131_/D _5131_/Q gf180mcu_as_sc_mcu7t3v3__dfxtp_2
X_5062_ VDD VDD VSS VSS _5185_/CLK _5062_/D _5062_/Q gf180mcu_as_sc_mcu7t3v3__dfxtp_2
XTAP_TAPCELL_ROW_104_1_1052 VDD VSS gf180mcu_as_sc_mcu7t3v3__tap_2
XFILLER_96_187 VDD VDD VSS VSS gf180mcu_as_sc_mcu7t3v3__fillcap_16
X_4013_ VDD VDD VSS VSS _4013_/A _4101_/B _4101_/C _4013_/D _4015_/C gf180mcu_as_sc_mcu7t3v3__ao22_2
XFILLER_37_276 VDD VDD VSS VSS gf180mcu_as_sc_mcu7t3v3__fillcap_4
XFILLER_16_18 VDD VDD VSS VSS gf180mcu_as_sc_mcu7t3v3__fillcap_16
XFILLER_37_298 VDD VDD VSS VSS gf180mcu_as_sc_mcu7t3v3__fill_2
XFILLER_52_235 VDD VDD VSS VSS gf180mcu_as_sc_mcu7t3v3__fillcap_8
XFILLER_107_1515 VDD VDD VSS VSS gf180mcu_as_sc_mcu7t3v3__fillcap_4
X_4915_ VDD VDD VSS VSS _5046_/CLK _4915_/D _4915_/Q gf180mcu_as_sc_mcu7t3v3__dfxtp_2
XFILLER_107_1537 VDD VDD VSS VSS gf180mcu_as_sc_mcu7t3v3__fillcap_16
XFILLER_142_1428 VDD VDD VSS VSS gf180mcu_as_sc_mcu7t3v3__fillcap_4
XFILLER_179_988 VDD VDD VSS VSS gf180mcu_as_sc_mcu7t3v3__fillcap_8
X_4846_ VDD VDD VSS VSS _4867_/CLK _4846_/D _4846_/Q gf180mcu_as_sc_mcu7t3v3__dfxtp_2
XFILLER_148_17 VDD VDD VSS VSS gf180mcu_as_sc_mcu7t3v3__fillcap_16
XFILLER_165_104 VDD VDD VSS VSS gf180mcu_as_sc_mcu7t3v3__fillcap_16
XFILLER_140_1152 VDD VDD VSS VSS gf180mcu_as_sc_mcu7t3v3__fill_2
X_4777_ VDD VDD VSS VSS _4858_/CLK _4777_/D _4777_/Q gf180mcu_as_sc_mcu7t3v3__dfxtp_2
XFILLER_140_1174 VDD VDD VSS VSS gf180mcu_as_sc_mcu7t3v3__fillcap_16
XFILLER_174_660 VDD VDD VSS VSS gf180mcu_as_sc_mcu7t3v3__fillcap_4
XFILLER_180_107 VDD VDD VSS VSS gf180mcu_as_sc_mcu7t3v3__fillcap_16
X_3728_ VDD VDD VSS VSS _3728_/D _4104_/D _3728_/B _3728_/C _3729_/C gf180mcu_as_sc_mcu7t3v3__ao31_2
XFILLER_134_546 VDD VDD VSS VSS gf180mcu_as_sc_mcu7t3v3__fillcap_16
XFILLER_146_384 VDD VDD VSS VSS gf180mcu_as_sc_mcu7t3v3__fill_1
X_3659_ VDD VDD VSS VSS _4032_/A _3744_/B _3659_/C _3723_/B _3660_/C gf180mcu_as_sc_mcu7t3v3__ao211_2
XTAP_TAPCELL_ROW_92_3_2487 VDD VSS gf180mcu_as_sc_mcu7t3v3__tap_2
XFILLER_121_207 VDD VDD VSS VSS gf180mcu_as_sc_mcu7t3v3__fill_2
XFILLER_175_1259 VDD VDD VSS VSS gf180mcu_as_sc_mcu7t3v3__fill_1
XFILLER_153_1535 VDD VDD VSS VSS gf180mcu_as_sc_mcu7t3v3__fillcap_4
XFILLER_180_37 VDD VDD VSS VSS gf180mcu_as_sc_mcu7t3v3__fillcap_16
XFILLER_57_36 VDD VDD VSS VSS gf180mcu_as_sc_mcu7t3v3__fill_2
XFILLER_57_69 VDD VDD VSS VSS gf180mcu_as_sc_mcu7t3v3__fill_1
XFILLER_151_1270 VDD VDD VSS VSS gf180mcu_as_sc_mcu7t3v3__fillcap_4
XFILLER_87_198 VDD VDD VSS VSS gf180mcu_as_sc_mcu7t3v3__fill_1
XFILLER_73_35 VDD VDD VSS VSS gf180mcu_as_sc_mcu7t3v3__fill_2
XFILLER_145_1052 VDD VDD VSS VSS gf180mcu_as_sc_mcu7t3v3__fillcap_16
XFILLER_157_616 VDD VDD VSS VSS gf180mcu_as_sc_mcu7t3v3__fillcap_8
XFILLER_169_454 VDD VDD VSS VSS gf180mcu_as_sc_mcu7t3v3__fillcap_16
XFILLER_156_104 VDD VDD VSS VSS gf180mcu_as_sc_mcu7t3v3__fill_1
XFILLER_157_649 VDD VDD VSS VSS gf180mcu_as_sc_mcu7t3v3__fill_2
XFILLER_7_136 VDD VDD VSS VSS gf180mcu_as_sc_mcu7t3v3__fillcap_4
XFILLER_7_158 VDD VDD VSS VSS gf180mcu_as_sc_mcu7t3v3__fillcap_16
XFILLER_98_10 VDD VDD VSS VSS gf180mcu_as_sc_mcu7t3v3__fillcap_4
XFILLER_137_384 VDD VDD VSS VSS gf180mcu_as_sc_mcu7t3v3__fillcap_8
XFILLER_152_310 VDD VDD VSS VSS gf180mcu_as_sc_mcu7t3v3__fillcap_4
XFILLER_10_1564 VDD VDD VSS VSS gf180mcu_as_sc_mcu7t3v3__fillcap_4
XFILLER_140_505 VDD VDD VSS VSS gf180mcu_as_sc_mcu7t3v3__fillcap_16
XTAP_TAPCELL_ROW_150_1551 VDD VSS gf180mcu_as_sc_mcu7t3v3__tap_2
XFILLER_140_527 VDD VDD VSS VSS gf180mcu_as_sc_mcu7t3v3__fillcap_8
XFILLER_152_387 VDD VDD VSS VSS gf180mcu_as_sc_mcu7t3v3__fill_2
XTAP_TAPCELL_ROW_150_1562 VDD VSS gf180mcu_as_sc_mcu7t3v3__tap_2
XFILLER_152_1045 VDD VDD VSS VSS gf180mcu_as_sc_mcu7t3v3__fillcap_8
XFILLER_80_1518 VDD VDD VSS VSS gf180mcu_as_sc_mcu7t3v3__fillcap_16
XFILLER_152_1067 VDD VDD VSS VSS gf180mcu_as_sc_mcu7t3v3__fillcap_16
XFILLER_78_154 VDD VDD VSS VSS gf180mcu_as_sc_mcu7t3v3__fillcap_8
XFILLER_93_146 VDD VDD VSS VSS gf180mcu_as_sc_mcu7t3v3__fill_2
XFILLER_169_1520 VDD VDD VSS VSS gf180mcu_as_sc_mcu7t3v3__fillcap_16
XFILLER_19_276 VDD VDD VSS VSS gf180mcu_as_sc_mcu7t3v3__fillcap_4
XFILLER_19_298 VDD VDD VSS VSS gf180mcu_as_sc_mcu7t3v3__fill_2
XFILLER_34_279 VDD VDD VSS VSS gf180mcu_as_sc_mcu7t3v3__fillcap_16
X_2961_ VDD VDD VSS VSS _3178_/A _2961_/B _2961_/C _3178_/D _2962_/D gf180mcu_as_sc_mcu7t3v3__ao211_2
XFILLER_148_616 VDD VDD VSS VSS gf180mcu_as_sc_mcu7t3v3__fillcap_16
XFILLER_163_1152 VDD VDD VSS VSS gf180mcu_as_sc_mcu7t3v3__fillcap_16
X_4700_ VDD VDD VSS VSS _4733_/C _5483_/A _5256_/Q _4701_/A gf180mcu_as_sc_mcu7t3v3__mux2_2
XTAP_TAPCELL_ROW_157_1716 VDD VSS gf180mcu_as_sc_mcu7t3v3__tap_2
XTAP_TAPCELL_ROW_157_1705 VDD VSS gf180mcu_as_sc_mcu7t3v3__tap_2
XFILLER_147_104 VDD VDD VSS VSS gf180mcu_as_sc_mcu7t3v3__fillcap_4
XFILLER_176_947 VDD VDD VSS VSS gf180mcu_as_sc_mcu7t3v3__fill_2
X_4631_ VDD VDD VSS VSS _4680_/B _5119_/Q _5222_/Q _5222_/D gf180mcu_as_sc_mcu7t3v3__mux2_2
X_2892_ VDD VDD VSS VSS _3812_/A _3789_/A _3797_/A gf180mcu_as_sc_mcu7t3v3__nor2_2
XFILLER_147_148 VDD VDD VSS VSS gf180mcu_as_sc_mcu7t3v3__fill_1
XFILLER_89_1521 VDD VDD VSS VSS gf180mcu_as_sc_mcu7t3v3__fillcap_16
XFILLER_8_85 VDD VDD VSS VSS gf180mcu_as_sc_mcu7t3v3__fillcap_16
XFILLER_141_1472 VDD VDD VSS VSS gf180mcu_as_sc_mcu7t3v3__fillcap_16
XFILLER_162_107 VDD VDD VSS VSS gf180mcu_as_sc_mcu7t3v3__fillcap_16
X_4562_ VDD VDD VSS VSS _4565_/C _4562_/B _4562_/A gf180mcu_as_sc_mcu7t3v3__nor2_2
XFILLER_102_1467 VDD VDD VSS VSS gf180mcu_as_sc_mcu7t3v3__fillcap_16
X_4493_ VDD VDD VSS VSS _5178_/Q _4496_/B _4493_/C _5112_/Q _4494_/B gf180mcu_as_sc_mcu7t3v3__ao22_2
X_3513_ VDD VDD VSS VSS _3513_/A _3522_/B _3514_/B _3514_/C _3513_/D gf180mcu_as_sc_mcu7t3v3__aoi211_2
XFILLER_103_207 VDD VDD VSS VSS gf180mcu_as_sc_mcu7t3v3__fill_2
XFILLER_144_877 VDD VDD VSS VSS gf180mcu_as_sc_mcu7t3v3__fillcap_16
XFILLER_144_899 VDD VDD VSS VSS gf180mcu_as_sc_mcu7t3v3__fill_1
XFILLER_171_652 VDD VDD VSS VSS gf180mcu_as_sc_mcu7t3v3__fillcap_4
XFILLER_176_1568 VDD VDD VSS VSS gf180mcu_as_sc_mcu7t3v3__fill_1
X_3444_ VDD VDD VSS VSS _3467_/B _4093_/A _3444_/A _3446_/B gf180mcu_as_sc_mcu7t3v3__mux2_2
XFILLER_174_1281 VDD VDD VSS VSS gf180mcu_as_sc_mcu7t3v3__fill_2
X_3375_ VDD VDD VSS VSS _3470_/B _3375_/B _3375_/C _3376_/C gf180mcu_as_sc_mcu7t3v3__nor3_2
XFILLER_84_102 VDD VDD VSS VSS gf180mcu_as_sc_mcu7t3v3__fill_2
X_5114_ VDD VDD VSS VSS _5164_/CLK _5114_/D _5114_/Q gf180mcu_as_sc_mcu7t3v3__dfxtp_2
XFILLER_61_1451 VDD VDD VSS VSS gf180mcu_as_sc_mcu7t3v3__fillcap_16
XFILLER_69_198 VDD VDD VSS VSS gf180mcu_as_sc_mcu7t3v3__fill_1
X_5045_ VDD VDD VSS VSS _5074_/CLK _5045_/D _5045_/Q gf180mcu_as_sc_mcu7t3v3__dfxtp_2
XFILLER_150_18 VDD VDD VSS VSS gf180mcu_as_sc_mcu7t3v3__fillcap_16
XFILLER_2_1518 VDD VDD VSS VSS gf180mcu_as_sc_mcu7t3v3__fillcap_16
XFILLER_183_1539 VDD VDD VSS VSS gf180mcu_as_sc_mcu7t3v3__fill_1
XFILLER_146_1383 VDD VDD VSS VSS gf180mcu_as_sc_mcu7t3v3__fillcap_16
XFILLER_166_435 VDD VDD VSS VSS gf180mcu_as_sc_mcu7t3v3__fillcap_16
XFILLER_167_958 VDD VDD VSS VSS gf180mcu_as_sc_mcu7t3v3__fill_2
XFILLER_166_457 VDD VDD VSS VSS gf180mcu_as_sc_mcu7t3v3__fillcap_16
XFILLER_178_295 VDD VDD VSS VSS gf180mcu_as_sc_mcu7t3v3__fillcap_16
XFILLER_33_1553 VDD VDD VSS VSS gf180mcu_as_sc_mcu7t3v3__fillcap_16
X_4829_ VDD VDD VSS VSS _4863_/CLK _4829_/D _4829_/Q gf180mcu_as_sc_mcu7t3v3__dfxtp_2
XFILLER_120_1534 VDD VDD VSS VSS gf180mcu_as_sc_mcu7t3v3__fillcap_16
XFILLER_147_682 VDD VDD VSS VSS gf180mcu_as_sc_mcu7t3v3__fillcap_16
XFILLER_181_416 VDD VDD VSS VSS gf180mcu_as_sc_mcu7t3v3__fillcap_4
XFILLER_120_1556 VDD VDD VSS VSS gf180mcu_as_sc_mcu7t3v3__fill_1
XFILLER_134_332 VDD VDD VSS VSS gf180mcu_as_sc_mcu7t3v3__fill_1
XFILLER_181_438 VDD VDD VSS VSS gf180mcu_as_sc_mcu7t3v3__fillcap_16
XFILLER_4_139 VDD VDD VSS VSS gf180mcu_as_sc_mcu7t3v3__fillcap_16
XFILLER_150_803 VDD VDD VSS VSS gf180mcu_as_sc_mcu7t3v3__fill_2
XFILLER_162_652 VDD VDD VSS VSS gf180mcu_as_sc_mcu7t3v3__fill_2
XFILLER_175_1045 VDD VDD VSS VSS gf180mcu_as_sc_mcu7t3v3__fillcap_4
XFILLER_134_376 VDD VDD VSS VSS gf180mcu_as_sc_mcu7t3v3__fillcap_4
XFILLER_150_847 VDD VDD VSS VSS gf180mcu_as_sc_mcu7t3v3__fill_1
XTAP_TAPCELL_ROW_27_3_2390 VDD VSS gf180mcu_as_sc_mcu7t3v3__tap_2
XFILLER_153_1343 VDD VDD VSS VSS gf180mcu_as_sc_mcu7t3v3__fillcap_16
Xinput202 VDD VDD VSS VSS se_in[29] _3793_/A gf180mcu_as_sc_mcu7t3v3__buff_2
XFILLER_102_251 VDD VDD VSS VSS gf180mcu_as_sc_mcu7t3v3__fill_1
XFILLER_68_79 VDD VDD VSS VSS gf180mcu_as_sc_mcu7t3v3__fillcap_8
Xinput213 VDD VDD VSS VSS se_in[8] _4001_/A gf180mcu_as_sc_mcu7t3v3__buff_2
Xinput224 VDD VDD VSS VSS south_in[18] _4080_/D gf180mcu_as_sc_mcu7t3v3__buff_2
Xinput235 VDD VDD VSS VSS south_in[28] _4159_/D gf180mcu_as_sc_mcu7t3v3__buff_2
XFILLER_102_295 VDD VDD VSS VSS gf180mcu_as_sc_mcu7t3v3__fillcap_4
XFILLER_40_1502 VDD VDD VSS VSS gf180mcu_as_sc_mcu7t3v3__fillcap_16
Xinput246 VDD VDD VSS VSS south_in[7] _3989_/D gf180mcu_as_sc_mcu7t3v3__buff_2
Xinput257 VDD VDD VSS VSS sw_in[17] _2439_/A gf180mcu_as_sc_mcu7t3v3__buff_2
Xinput268 VDD VDD VSS VSS sw_in[27] _4156_/A gf180mcu_as_sc_mcu7t3v3__buff_2
Xinput279 VDD VDD VSS VSS sw_in[6] _3986_/A gf180mcu_as_sc_mcu7t3v3__buff_2
XTAP_TAPCELL_ROW_180_2223 VDD VSS gf180mcu_as_sc_mcu7t3v3__tap_2
XTAP_TAPCELL_ROW_180_2212 VDD VSS gf180mcu_as_sc_mcu7t3v3__tap_2
XTAP_TAPCELL_ROW_115_3_2522 VDD VSS gf180mcu_as_sc_mcu7t3v3__tap_2
XFILLER_84_45 VDD VDD VSS VSS gf180mcu_as_sc_mcu7t3v3__fill_2
XFILLER_17_50 VDD VDD VSS VSS gf180mcu_as_sc_mcu7t3v3__fillcap_16
XFILLER_40_1568 VDD VDD VSS VSS gf180mcu_as_sc_mcu7t3v3__fill_1
XFILLER_147_1114 VDD VDD VSS VSS gf180mcu_as_sc_mcu7t3v3__fillcap_4
XFILLER_17_72 VDD VDD VSS VSS gf180mcu_as_sc_mcu7t3v3__fillcap_16
XTAP_TAPCELL_ROW_178_2174 VDD VSS gf180mcu_as_sc_mcu7t3v3__tap_2
XTAP_TAPCELL_ROW_178_2163 VDD VSS gf180mcu_as_sc_mcu7t3v3__tap_2
XFILLER_125_1467 VDD VDD VSS VSS gf180mcu_as_sc_mcu7t3v3__fillcap_16
XFILLER_157_402 VDD VDD VSS VSS gf180mcu_as_sc_mcu7t3v3__fillcap_16
XFILLER_158_947 VDD VDD VSS VSS gf180mcu_as_sc_mcu7t3v3__fillcap_8
XFILLER_38_1486 VDD VDD VSS VSS gf180mcu_as_sc_mcu7t3v3__fillcap_16
XPHY_EDGE_ROW_41_3_Left_175 VDD VSS gf180mcu_as_sc_mcu7t3v3__tap_2
XFILLER_69_8 VDD VDD VSS VSS gf180mcu_as_sc_mcu7t3v3__fillcap_8
Xclkbuf_3_1_0_clk_regs VDD VDD VSS VSS clkbuf_0_clk_regs/Y clkbuf_3_1_0_clk_regs/Y
+ gf180mcu_as_sc_mcu7t3v3__clkbuff_12
XTAP_TAPCELL_ROW_152_1602 VDD VSS gf180mcu_as_sc_mcu7t3v3__tap_2
XFILLER_84_1451 VDD VDD VSS VSS gf180mcu_as_sc_mcu7t3v3__fillcap_16
XFILLER_98_216 VDD VDD VSS VSS gf180mcu_as_sc_mcu7t3v3__fill_2
XFILLER_140_379 VDD VDD VSS VSS gf180mcu_as_sc_mcu7t3v3__fillcap_4
XFILLER_171_1465 VDD VDD VSS VSS gf180mcu_as_sc_mcu7t3v3__fillcap_4
X_3160_ VDD VDD VSS VSS _4137_/A _3177_/B _3169_/C _4138_/D _3161_/C gf180mcu_as_sc_mcu7t3v3__ao22_2
Xmesh_tile_839 VDD VDD VSS VSS ne_out[14] gf180mcu_as_sc_mcu7t3v3__tiel_4
Xmesh_tile_828 VDD VDD VSS VSS ne_out[3] gf180mcu_as_sc_mcu7t3v3__tiel_4
X_3091_ VDD VDD VSS VSS _3143_/S _4069_/D _4072_/A _3094_/B gf180mcu_as_sc_mcu7t3v3__mux2_2
XFILLER_81_138 VDD VDD VSS VSS gf180mcu_as_sc_mcu7t3v3__fill_2
XFILLER_17_1515 VDD VDD VSS VSS gf180mcu_as_sc_mcu7t3v3__fillcap_4
XFILLER_56_1564 VDD VDD VSS VSS gf180mcu_as_sc_mcu7t3v3__fillcap_4
X_3993_ VDD VDD VSS VSS _3993_/A _4163_/B _3993_/C _3993_/D _3994_/B gf180mcu_as_sc_mcu7t3v3__ao211_2
XFILLER_148_402 VDD VDD VSS VSS gf180mcu_as_sc_mcu7t3v3__fillcap_8
XFILLER_176_711 VDD VDD VSS VSS gf180mcu_as_sc_mcu7t3v3__fill_1
XFILLER_17_1537 VDD VDD VSS VSS gf180mcu_as_sc_mcu7t3v3__fillcap_16
X_2944_ VDD VDD VSS VSS _3526_/B _3243_/A _3218_/B gf180mcu_as_sc_mcu7t3v3__and2_2
XFILLER_104_1518 VDD VDD VSS VSS gf180mcu_as_sc_mcu7t3v3__fillcap_16
XFILLER_148_457 VDD VDD VSS VSS gf180mcu_as_sc_mcu7t3v3__fillcap_16
XFILLER_176_766 VDD VDD VSS VSS gf180mcu_as_sc_mcu7t3v3__fillcap_4
XFILLER_91_1499 VDD VDD VSS VSS gf180mcu_as_sc_mcu7t3v3__fillcap_16
X_2875_ VDD VDD VSS VSS _2875_/B _4703_/B _4691_/C gf180mcu_as_sc_mcu7t3v3__and2_2
XTAP_TAPCELL_ROW_45_3_2417 VDD VSS gf180mcu_as_sc_mcu7t3v3__tap_2
XFILLER_175_276 VDD VDD VSS VSS gf180mcu_as_sc_mcu7t3v3__fillcap_4
XFILLER_176_777 VDD VDD VSS VSS gf180mcu_as_sc_mcu7t3v3__fillcap_16
X_4614_ VDD VDD VSS VSS _5208_/Q _4623_/B _4623_/C _5209_/Q _5208_/D gf180mcu_as_sc_mcu7t3v3__ao22_2
XFILLER_163_438 VDD VDD VSS VSS gf180mcu_as_sc_mcu7t3v3__fillcap_16
XFILLER_175_298 VDD VDD VSS VSS gf180mcu_as_sc_mcu7t3v3__fillcap_16
XFILLER_176_1321 VDD VDD VSS VSS gf180mcu_as_sc_mcu7t3v3__fill_2
X_4545_ VDD VDD VSS VSS _4546_/D _4545_/B _4581_/A gf180mcu_as_sc_mcu7t3v3__nor2_2
XFILLER_137_1327 VDD VDD VSS VSS gf180mcu_as_sc_mcu7t3v3__fill_2
XFILLER_171_482 VDD VDD VSS VSS gf180mcu_as_sc_mcu7t3v3__fill_1
X_4476_ VDD VDD VSS VSS _4476_/D _4553_/A _4476_/B _4476_/C _4477_/B gf180mcu_as_sc_mcu7t3v3__ao31_2
X_3427_ VDD VDD VSS VSS _3471_/B _4080_/A _3428_/D gf180mcu_as_sc_mcu7t3v3__and2_2
X_3358_ VDD VDD VSS VSS _4008_/A _3474_/C _3523_/B _4009_/A _3359_/C gf180mcu_as_sc_mcu7t3v3__ao22_2
XFILLER_150_1527 VDD VDD VSS VSS gf180mcu_as_sc_mcu7t3v3__fillcap_8
XFILLER_97_282 VDD VDD VSS VSS gf180mcu_as_sc_mcu7t3v3__fillcap_16
XFILLER_57_157 VDD VDD VSS VSS gf180mcu_as_sc_mcu7t3v3__fill_2
XFILLER_6_1451 VDD VDD VSS VSS gf180mcu_as_sc_mcu7t3v3__fillcap_16
X_3289_ VDD VDD VSS VSS _3936_/A _3462_/A _3289_/C _4805_/D _3573_/D gf180mcu_as_sc_mcu7t3v3__aoi211_2
XTAP_TAPCELL_ROW_1_3_2351 VDD VSS gf180mcu_as_sc_mcu7t3v3__tap_2
XFILLER_148_1401 VDD VDD VSS VSS gf180mcu_as_sc_mcu7t3v3__fill_1
XFILLER_173_8 VDD VDD VSS VSS gf180mcu_as_sc_mcu7t3v3__fillcap_4
X_5028_ VDD VDD VSS VSS _5173_/CLK _5028_/D _5028_/Q gf180mcu_as_sc_mcu7t3v3__dfxtp_2
XFILLER_54_37 VDD VDD VSS VSS gf180mcu_as_sc_mcu7t3v3__fillcap_16
XFILLER_65_190 VDD VDD VSS VSS gf180mcu_as_sc_mcu7t3v3__fillcap_16
XFILLER_110_10 VDD VDD VSS VSS gf180mcu_as_sc_mcu7t3v3__fill_2
XFILLER_110_32 VDD VDD VSS VSS gf180mcu_as_sc_mcu7t3v3__fill_2
XFILLER_110_65 VDD VDD VSS VSS gf180mcu_as_sc_mcu7t3v3__fillcap_4
XFILLER_142_1000 VDD VDD VSS VSS gf180mcu_as_sc_mcu7t3v3__fill_2
XFILLER_167_733 VDD VDD VSS VSS gf180mcu_as_sc_mcu7t3v3__fill_1
XTAP_TAPCELL_ROW_80_3_2469 VDD VSS gf180mcu_as_sc_mcu7t3v3__tap_2
XFILLER_142_1055 VDD VDD VSS VSS gf180mcu_as_sc_mcu7t3v3__fill_1
XFILLER_167_744 VDD VDD VSS VSS gf180mcu_as_sc_mcu7t3v3__fillcap_16
XFILLER_21_260 VDD VDD VSS VSS gf180mcu_as_sc_mcu7t3v3__fillcap_16
XFILLER_21_282 VDD VDD VSS VSS gf180mcu_as_sc_mcu7t3v3__fillcap_16
XFILLER_155_928 VDD VDD VSS VSS gf180mcu_as_sc_mcu7t3v3__fillcap_16
Xclkbuf_leaf_37_clk_regs VDD VDD VSS VSS clkbuf_3_5_0_clk_regs/Y _4938_/CLK gf180mcu_as_sc_mcu7t3v3__clkbuff_12
XTAP_TAPCELL_ROW_173_2071 VDD VSS gf180mcu_as_sc_mcu7t3v3__tap_2
XTAP_TAPCELL_ROW_173_2060 VDD VSS gf180mcu_as_sc_mcu7t3v3__tap_2
XFILLER_154_427 VDD VDD VSS VSS gf180mcu_as_sc_mcu7t3v3__fill_1
XFILLER_102_2 VDD VDD VSS VSS gf180mcu_as_sc_mcu7t3v3__fillcap_16
XFILLER_134_151 VDD VDD VSS VSS gf180mcu_as_sc_mcu7t3v3__fillcap_4
XFILLER_135_696 VDD VDD VSS VSS gf180mcu_as_sc_mcu7t3v3__fillcap_4
XFILLER_155_1438 VDD VDD VSS VSS gf180mcu_as_sc_mcu7t3v3__fill_1
XFILLER_0_120 VDD VDD VSS VSS gf180mcu_as_sc_mcu7t3v3__fill_2
XFILLER_153_1162 VDD VDD VSS VSS gf180mcu_as_sc_mcu7t3v3__fill_1
XFILLER_48_157 VDD VDD VSS VSS gf180mcu_as_sc_mcu7t3v3__fillcap_4
XFILLER_95_88 VDD VDD VSS VSS gf180mcu_as_sc_mcu7t3v3__fillcap_4
XTAP_TAPCELL_ROW_145_1450 VDD VSS gf180mcu_as_sc_mcu7t3v3__tap_2
XFILLER_151_72 VDD VDD VSS VSS gf180mcu_as_sc_mcu7t3v3__fillcap_16
XFILLER_166_1523 VDD VDD VSS VSS gf180mcu_as_sc_mcu7t3v3__fillcap_16
XFILLER_63_138 VDD VDD VSS VSS gf180mcu_as_sc_mcu7t3v3__fill_2
XFILLER_79_1553 VDD VDD VSS VSS gf180mcu_as_sc_mcu7t3v3__fillcap_16
XFILLER_166_1567 VDD VDD VSS VSS gf180mcu_as_sc_mcu7t3v3__fill_2
XTAP_TAPCELL_ROW_141_1358 VDD VSS gf180mcu_as_sc_mcu7t3v3__tap_2
XFILLER_177_508 VDD VDD VSS VSS gf180mcu_as_sc_mcu7t3v3__fillcap_16
XTAP_TAPCELL_ROW_141_1369 VDD VSS gf180mcu_as_sc_mcu7t3v3__tap_2
XFILLER_146_906 VDD VDD VSS VSS gf180mcu_as_sc_mcu7t3v3__fillcap_16
XFILLER_158_777 VDD VDD VSS VSS gf180mcu_as_sc_mcu7t3v3__fillcap_16
XPHY_EDGE_ROW_11_1_Left_463 VDD VSS gf180mcu_as_sc_mcu7t3v3__tap_2
X_2660_ VDD VDD VSS VSS _2673_/B _5131_/Q _5195_/Q _2661_/B gf180mcu_as_sc_mcu7t3v3__mux2_2
XFILLER_51_1483 VDD VDD VSS VSS gf180mcu_as_sc_mcu7t3v3__fillcap_16
XFILLER_60_80 VDD VDD VSS VSS gf180mcu_as_sc_mcu7t3v3__fillcap_8
XFILLER_86_1502 VDD VDD VSS VSS gf180mcu_as_sc_mcu7t3v3__fillcap_16
XFILLER_12_1467 VDD VDD VSS VSS gf180mcu_as_sc_mcu7t3v3__fillcap_16
X_2591_ VDD VDD VSS VSS _2882_/A _4767_/Q _4764_/Q _2591_/Y gf180mcu_as_sc_mcu7t3v3__nor3_2
XFILLER_125_151 VDD VDD VSS VSS gf180mcu_as_sc_mcu7t3v3__fillcap_8
XFILLER_153_471 VDD VDD VSS VSS gf180mcu_as_sc_mcu7t3v3__fill_2
XFILLER_172_279 VDD VDD VSS VSS gf180mcu_as_sc_mcu7t3v3__fillcap_16
XFILLER_86_1568 VDD VDD VSS VSS gf180mcu_as_sc_mcu7t3v3__fill_1
X_4330_ VDD VDD VSS VSS _5126_/Q _4739_/A _4332_/C gf180mcu_as_sc_mcu7t3v3__or2_2
XTAP_TAPCELL_ROW_79_1_952 VDD VSS gf180mcu_as_sc_mcu7t3v3__tap_2
X_4261_ VDD VDD VSS VSS _4265_/B _4748_/A _5097_/D gf180mcu_as_sc_mcu7t3v3__and2_2
XFILLER_141_699 VDD VDD VSS VSS gf180mcu_as_sc_mcu7t3v3__fill_1
XFILLER_171_1240 VDD VDD VSS VSS gf180mcu_as_sc_mcu7t3v3__fill_2
X_3212_ VDD VDD VSS VSS _3212_/D _3797_/A _3223_/B _3223_/C _3213_/C gf180mcu_as_sc_mcu7t3v3__ao31_2
XFILLER_171_1262 VDD VDD VSS VSS gf180mcu_as_sc_mcu7t3v3__fillcap_8
XFILLER_79_282 VDD VDD VSS VSS gf180mcu_as_sc_mcu7t3v3__fillcap_16
X_4192_ VDD VDD VSS VSS _4252_/B _4192_/B _4192_/C _5030_/Q _5030_/D gf180mcu_as_sc_mcu7t3v3__ao22_2
XTAP_TAPCELL_ROW_169_1984 VDD VSS gf180mcu_as_sc_mcu7t3v3__tap_2
XTAP_TAPCELL_ROW_169_1973 VDD VSS gf180mcu_as_sc_mcu7t3v3__tap_2
X_3143_ VDD VDD VSS VSS _3143_/S _4118_/D _4121_/A _3145_/B gf180mcu_as_sc_mcu7t3v3__mux2_2
X_3074_ VDD VDD VSS VSS _4056_/A _3142_/B _3142_/C _4056_/D _3080_/B gf180mcu_as_sc_mcu7t3v3__ao22_2
XFILLER_50_300 VDD VDD VSS VSS gf180mcu_as_sc_mcu7t3v3__fill_1
XFILLER_24_18 VDD VDD VSS VSS gf180mcu_as_sc_mcu7t3v3__fillcap_16
XFILLER_62_193 VDD VDD VSS VSS gf180mcu_as_sc_mcu7t3v3__fillcap_4
XFILLER_108_1451 VDD VDD VSS VSS gf180mcu_as_sc_mcu7t3v3__fillcap_16
X_3976_ VDD VDD VSS VSS _3976_/A _4104_/B _4104_/C _3976_/D _3977_/D gf180mcu_as_sc_mcu7t3v3__ao22_2
X_2927_ VDD VDD VSS VSS _3216_/C _2932_/C _2930_/A gf180mcu_as_sc_mcu7t3v3__nor2_2
XFILLER_108_107 VDD VDD VSS VSS gf180mcu_as_sc_mcu7t3v3__fill_2
XFILLER_136_416 VDD VDD VSS VSS gf180mcu_as_sc_mcu7t3v3__fill_1
XFILLER_149_788 VDD VDD VSS VSS gf180mcu_as_sc_mcu7t3v3__fillcap_8
XFILLER_163_235 VDD VDD VSS VSS gf180mcu_as_sc_mcu7t3v3__fillcap_16
XFILLER_30_1534 VDD VDD VSS VSS gf180mcu_as_sc_mcu7t3v3__fillcap_16
X_2858_ VDD VDD VSS VSS _2858_/Y _2858_/B _5097_/Q gf180mcu_as_sc_mcu7t3v3__nand2_2
XFILLER_30_1556 VDD VDD VSS VSS gf180mcu_as_sc_mcu7t3v3__fillcap_8
X_2789_ VDD VDD VSS VSS _5125_/Q _2789_/B _2789_/A _2791_/A gf180mcu_as_sc_mcu7t3v3__mux2_2
XTAP_TAPCELL_ROW_123_1_1128 VDD VSS gf180mcu_as_sc_mcu7t3v3__tap_2
XFILLER_116_173 VDD VDD VSS VSS gf180mcu_as_sc_mcu7t3v3__fill_2
XFILLER_176_1140 VDD VDD VSS VSS gf180mcu_as_sc_mcu7t3v3__fill_2
X_4528_ VDD VDD VSS VSS _4529_/D _4528_/B _4587_/A gf180mcu_as_sc_mcu7t3v3__nor2_2
XFILLER_131_121 VDD VDD VSS VSS gf180mcu_as_sc_mcu7t3v3__fill_1
XFILLER_172_1037 VDD VDD VSS VSS gf180mcu_as_sc_mcu7t3v3__fill_2
Xfanout700 VDD VDD VSS VSS _3465_/B _3440_/B gf180mcu_as_sc_mcu7t3v3__buff_2
X_4459_ VDD VDD VSS VSS _4460_/D _4459_/B _4589_/A gf180mcu_as_sc_mcu7t3v3__nor2_2
XFILLER_77_208 VDD VDD VSS VSS gf180mcu_as_sc_mcu7t3v3__fill_2
XFILLER_8_1502 VDD VDD VSS VSS gf180mcu_as_sc_mcu7t3v3__fillcap_16
Xfanout711 VDD VDD VSS VSS _3153_/D _3178_/D gf180mcu_as_sc_mcu7t3v3__buff_2
Xfanout722 VDD VDD VSS VSS _3177_/B _3233_/B gf180mcu_as_sc_mcu7t3v3__buff_2
Xfanout733 VDD VDD VSS VSS _2591_/Y _4974_/D gf180mcu_as_sc_mcu7t3v3__buff_2
XFILLER_150_1313 VDD VDD VSS VSS gf180mcu_as_sc_mcu7t3v3__fillcap_8
XFILLER_154_1471 VDD VDD VSS VSS gf180mcu_as_sc_mcu7t3v3__fillcap_8
XFILLER_8_1568 VDD VDD VSS VSS gf180mcu_as_sc_mcu7t3v3__fill_1
Xfanout744 VDD VDD VSS VSS _4748_/A _4745_/B gf180mcu_as_sc_mcu7t3v3__buff_2
Xfanout755 VDD VDD VSS VSS _5221_/Q _4703_/B gf180mcu_as_sc_mcu7t3v3__buff_2
Xfanout766 VDD VDD VSS VSS _5095_/Q _4553_/A gf180mcu_as_sc_mcu7t3v3__buff_2
XTAP_TAPCELL_ROW_103_1_1048 VDD VSS gf180mcu_as_sc_mcu7t3v3__tap_2
XFILLER_150_1335 VDD VDD VSS VSS gf180mcu_as_sc_mcu7t3v3__fill_2
Xfanout777 VDD VDD VSS VSS _4536_/S _4518_/S gf180mcu_as_sc_mcu7t3v3__buff_2
Xfanout788 VDD VDD VSS VSS _3907_/A _3624_/A gf180mcu_as_sc_mcu7t3v3__buff_2
Xfanout799 VDD VDD VSS VSS _3601_/D _3691_/D gf180mcu_as_sc_mcu7t3v3__buff_2
XPHY_EDGE_ROW_87_1_Left_539 VDD VSS gf180mcu_as_sc_mcu7t3v3__tap_2
XFILLER_115_1499 VDD VDD VSS VSS gf180mcu_as_sc_mcu7t3v3__fillcap_16
XFILLER_148_1242 VDD VDD VSS VSS gf180mcu_as_sc_mcu7t3v3__fillcap_4
XFILLER_183_1122 VDD VDD VSS VSS gf180mcu_as_sc_mcu7t3v3__fill_2
XFILLER_41_300 VDD VDD VSS VSS gf180mcu_as_sc_mcu7t3v3__fill_1
XFILLER_81_35 VDD VDD VSS VSS gf180mcu_as_sc_mcu7t3v3__fill_2
XTAP_TAPCELL_ROW_175_2100 VDD VSS gf180mcu_as_sc_mcu7t3v3__tap_2
XFILLER_148_1297 VDD VDD VSS VSS gf180mcu_as_sc_mcu7t3v3__fillcap_16
XFILLER_159_519 VDD VDD VSS VSS gf180mcu_as_sc_mcu7t3v3__fill_1
XTAP_TAPCELL_ROW_98_3_2496 VDD VSS gf180mcu_as_sc_mcu7t3v3__tap_2
XTAP_TAPCELL_ROW_175_2111 VDD VSS gf180mcu_as_sc_mcu7t3v3__tap_2
XFILLER_74_1483 VDD VDD VSS VSS gf180mcu_as_sc_mcu7t3v3__fill_1
XFILLER_139_243 VDD VDD VSS VSS gf180mcu_as_sc_mcu7t3v3__fillcap_16
XFILLER_35_1467 VDD VDD VSS VSS gf180mcu_as_sc_mcu7t3v3__fillcap_16
XTAP_TAPCELL_ROW_171_2019 VDD VSS gf180mcu_as_sc_mcu7t3v3__tap_2
XTAP_TAPCELL_ROW_171_2008 VDD VSS gf180mcu_as_sc_mcu7t3v3__tap_2
XTAP_TAPCELL_ROW_15_3_2372 VDD VSS gf180mcu_as_sc_mcu7t3v3__tap_2
XFILLER_5_212 VDD VDD VSS VSS gf180mcu_as_sc_mcu7t3v3__fillcap_16
XFILLER_143_909 VDD VDD VSS VSS gf180mcu_as_sc_mcu7t3v3__fill_1
XFILLER_151_920 VDD VDD VSS VSS gf180mcu_as_sc_mcu7t3v3__fillcap_4
XFILLER_154_279 VDD VDD VSS VSS gf180mcu_as_sc_mcu7t3v3__fillcap_4
XTAP_TAPCELL_ROW_134_1173 VDD VSS gf180mcu_as_sc_mcu7t3v3__tap_2
XTAP_TAPCELL_ROW_103_3_2504 VDD VSS gf180mcu_as_sc_mcu7t3v3__tap_2
XFILLER_122_132 VDD VDD VSS VSS gf180mcu_as_sc_mcu7t3v3__fillcap_8
XFILLER_155_1224 VDD VDD VSS VSS gf180mcu_as_sc_mcu7t3v3__fillcap_16
XTAP_TAPCELL_ROW_134_1195 VDD VSS gf180mcu_as_sc_mcu7t3v3__tap_2
XTAP_TAPCELL_ROW_134_1184 VDD VSS gf180mcu_as_sc_mcu7t3v3__tap_2
XFILLER_155_1257 VDD VDD VSS VSS gf180mcu_as_sc_mcu7t3v3__fill_2
XTAP_TAPCELL_ROW_147_1501 VDD VSS gf180mcu_as_sc_mcu7t3v3__tap_2
XTAP_TAPCELL_ROW_143_1409 VDD VSS gf180mcu_as_sc_mcu7t3v3__tap_2
XTAP_TAPCELL_ROW_164_1870 VDD VSS gf180mcu_as_sc_mcu7t3v3__tap_2
XFILLER_55_80 VDD VDD VSS VSS gf180mcu_as_sc_mcu7t3v3__fillcap_8
XFILLER_166_1375 VDD VDD VSS VSS gf180mcu_as_sc_mcu7t3v3__fill_2
XTAP_TAPCELL_ROW_160_1778 VDD VSS gf180mcu_as_sc_mcu7t3v3__tap_2
XTAP_TAPCELL_ROW_160_1767 VDD VSS gf180mcu_as_sc_mcu7t3v3__tap_2
XFILLER_44_193 VDD VDD VSS VSS gf180mcu_as_sc_mcu7t3v3__fillcap_4
X_3830_ VDD VDD VSS VSS _3835_/B _4909_/Q _4752_/C gf180mcu_as_sc_mcu7t3v3__and2_2
XFILLER_140_1504 VDD VDD VSS VSS gf180mcu_as_sc_mcu7t3v3__fill_1
X_3761_ VDD VDD VSS VSS _3791_/B _4146_/D _3765_/C gf180mcu_as_sc_mcu7t3v3__and2_2
XFILLER_140_1537 VDD VDD VSS VSS gf180mcu_as_sc_mcu7t3v3__fill_1
XFILLER_14_1518 VDD VDD VSS VSS gf180mcu_as_sc_mcu7t3v3__fillcap_16
X_2712_ VDD VDD VSS VSS _5161_/Q _4269_/S _4278_/S _5185_/Q _2713_/B gf180mcu_as_sc_mcu7t3v3__ao22_2
X_3692_ VDD VDD VSS VSS _4855_/D _3692_/C _3731_/B _4067_/A gf180mcu_as_sc_mcu7t3v3__aoi21_2
XFILLER_145_257 VDD VDD VSS VSS gf180mcu_as_sc_mcu7t3v3__fillcap_8
X_2643_ VDD VDD VSS VSS _4264_/B _2658_/S _2653_/S _2643_/C _2644_/C gf180mcu_as_sc_mcu7t3v3__ao31_2
XFILLER_99_300 VDD VDD VSS VSS gf180mcu_as_sc_mcu7t3v3__fill_1
Xoutput325 VDD VDD VSS VSS _4839_/Q east_out[0] gf180mcu_as_sc_mcu7t3v3__buff_2
X_2574_ VDD VDD VSS VSS _2575_/B _4350_/A _2849_/A gf180mcu_as_sc_mcu7t3v3__nand2_2
XFILLER_154_791 VDD VDD VSS VSS gf180mcu_as_sc_mcu7t3v3__fill_1
XFILLER_160_238 VDD VDD VSS VSS gf180mcu_as_sc_mcu7t3v3__fillcap_4
Xoutput369 VDD VDD VSS VSS _4790_/Q se_out[19] gf180mcu_as_sc_mcu7t3v3__buff_2
Xoutput358 VDD VDD VSS VSS _4848_/Q east_out[9] gf180mcu_as_sc_mcu7t3v3__buff_2
Xoutput347 VDD VDD VSS VSS _4841_/Q east_out[2] gf180mcu_as_sc_mcu7t3v3__buff_2
Xoutput336 VDD VDD VSS VSS _4840_/Q east_out[1] gf180mcu_as_sc_mcu7t3v3__buff_2
X_4313_ VDD VDD VSS VSS _4313_/S _5143_/Q _5142_/Q _5142_/D gf180mcu_as_sc_mcu7t3v3__mux2_2
XPHY_EDGE_ROW_129_3_Left_263 VDD VSS gf180mcu_as_sc_mcu7t3v3__tap_2
XFILLER_19_18 VDD VDD VSS VSS gf180mcu_as_sc_mcu7t3v3__fillcap_16
X_4244_ VDD VDD VSS VSS _4248_/S _4244_/B _5080_/Q _5080_/D gf180mcu_as_sc_mcu7t3v3__mux2_2
X_4175_ VDD VDD VSS VSS _4235_/B _4188_/B _4188_/C _5013_/Q _5013_/D gf180mcu_as_sc_mcu7t3v3__ao22_2
X_3126_ VDD VDD VSS VSS _3143_/S _4101_/A _4103_/A _3128_/B gf180mcu_as_sc_mcu7t3v3__mux2_2
XPHY_EDGE_ROW_66_3_Left_200 VDD VSS gf180mcu_as_sc_mcu7t3v3__tap_2
XFILLER_184_1420 VDD VDD VSS VSS gf180mcu_as_sc_mcu7t3v3__fillcap_8
XFILLER_82_255 VDD VDD VSS VSS gf180mcu_as_sc_mcu7t3v3__fillcap_4
XFILLER_97_1483 VDD VDD VSS VSS gf180mcu_as_sc_mcu7t3v3__fillcap_16
X_3057_ VDD VDD VSS VSS _3661_/A _3124_/B _3057_/C _4783_/D _3661_/D gf180mcu_as_sc_mcu7t3v3__aoi211_2
XFILLER_23_300 VDD VDD VSS VSS gf180mcu_as_sc_mcu7t3v3__fill_1
XFILLER_58_1467 VDD VDD VSS VSS gf180mcu_as_sc_mcu7t3v3__fillcap_16
XFILLER_145_1426 VDD VDD VSS VSS gf180mcu_as_sc_mcu7t3v3__fillcap_4
XFILLER_168_349 VDD VDD VSS VSS gf180mcu_as_sc_mcu7t3v3__fillcap_16
XFILLER_177_872 VDD VDD VSS VSS gf180mcu_as_sc_mcu7t3v3__fillcap_4
XFILLER_51_49 VDD VDD VSS VSS gf180mcu_as_sc_mcu7t3v3__fill_1
X_3959_ VDD VDD VSS VSS _3959_/A _4102_/B _4102_/C _4918_/Q _3960_/D gf180mcu_as_sc_mcu7t3v3__ao22_2
XFILLER_164_522 VDD VDD VSS VSS gf180mcu_as_sc_mcu7t3v3__fill_2
XFILLER_177_894 VDD VDD VSS VSS gf180mcu_as_sc_mcu7t3v3__fill_1
XFILLER_178_1268 VDD VDD VSS VSS gf180mcu_as_sc_mcu7t3v3__fill_2
XFILLER_183_48 VDD VDD VSS VSS gf180mcu_as_sc_mcu7t3v3__fillcap_16
XFILLER_104_132 VDD VDD VSS VSS gf180mcu_as_sc_mcu7t3v3__fillcap_16
Xfanout530 VDD VDD VSS VSS _4141_/B _4110_/C gf180mcu_as_sc_mcu7t3v3__buff_2
Xfanout541 VDD VDD VSS VSS fanout543/Y _3726_/B gf180mcu_as_sc_mcu7t3v3__buff_2
XFILLER_58_241 VDD VDD VSS VSS gf180mcu_as_sc_mcu7t3v3__fillcap_4
Xfanout552 VDD VDD VSS VSS fanout553/Y _3467_/C gf180mcu_as_sc_mcu7t3v3__buff_2
Xfanout563 VDD VDD VSS VSS _4192_/C _4188_/C gf180mcu_as_sc_mcu7t3v3__buff_2
Xfanout574 VDD VDD VSS VSS _3874_/Y _3905_/B gf180mcu_as_sc_mcu7t3v3__buff_2
XFILLER_150_1154 VDD VDD VSS VSS gf180mcu_as_sc_mcu7t3v3__fill_1
XPHY_EDGE_ROW_50_3_Left_184 VDD VSS gf180mcu_as_sc_mcu7t3v3__tap_2
Xfanout585 VDD VDD VSS VSS _4373_/D _4575_/B gf180mcu_as_sc_mcu7t3v3__buff_2
Xfanout596 VDD VDD VSS VSS fanout597/Y _4118_/C gf180mcu_as_sc_mcu7t3v3__buff_2
XFILLER_58_296 VDD VDD VSS VSS gf180mcu_as_sc_mcu7t3v3__fillcap_4
XFILLER_92_34 VDD VDD VSS VSS gf180mcu_as_sc_mcu7t3v3__fill_1
XFILLER_148_1050 VDD VDD VSS VSS gf180mcu_as_sc_mcu7t3v3__fillcap_4
XFILLER_163_1504 VDD VDD VSS VSS gf180mcu_as_sc_mcu7t3v3__fillcap_16
XFILLER_26_171 VDD VDD VSS VSS gf180mcu_as_sc_mcu7t3v3__fillcap_4
XFILLER_76_1534 VDD VDD VSS VSS gf180mcu_as_sc_mcu7t3v3__fillcap_16
XFILLER_76_1556 VDD VDD VSS VSS gf180mcu_as_sc_mcu7t3v3__fillcap_8
XFILLER_159_305 VDD VDD VSS VSS gf180mcu_as_sc_mcu7t3v3__fill_1
XFILLER_25_50 VDD VDD VSS VSS gf180mcu_as_sc_mcu7t3v3__fillcap_16
XFILLER_25_72 VDD VDD VSS VSS gf180mcu_as_sc_mcu7t3v3__fillcap_16
XFILLER_26_193 VDD VDD VSS VSS gf180mcu_as_sc_mcu7t3v3__fillcap_16
XFILLER_143_706 VDD VDD VSS VSS gf180mcu_as_sc_mcu7t3v3__fill_2
XTAP_TAPCELL_ROW_136_1257 VDD VSS gf180mcu_as_sc_mcu7t3v3__tap_2
XTAP_TAPCELL_ROW_136_1246 VDD VSS gf180mcu_as_sc_mcu7t3v3__tap_2
XFILLER_142_205 VDD VDD VSS VSS gf180mcu_as_sc_mcu7t3v3__fill_2
XFILLER_151_761 VDD VDD VSS VSS gf180mcu_as_sc_mcu7t3v3__fillcap_8
XFILLER_151_772 VDD VDD VSS VSS gf180mcu_as_sc_mcu7t3v3__fillcap_16
XFILLER_155_1043 VDD VDD VSS VSS gf180mcu_as_sc_mcu7t3v3__fillcap_4
XTAP_TAPCELL_ROW_49_1_830 VDD VSS gf180mcu_as_sc_mcu7t3v3__tap_2
XFILLER_49_241 VDD VDD VSS VSS gf180mcu_as_sc_mcu7t3v3__fillcap_8
XTAP_TAPCELL_ROW_166_1910 VDD VSS gf180mcu_as_sc_mcu7t3v3__tap_2
XFILLER_168_1415 VDD VDD VSS VSS gf180mcu_as_sc_mcu7t3v3__fillcap_16
XTAP_TAPCELL_ROW_162_1829 VDD VSS gf180mcu_as_sc_mcu7t3v3__tap_2
XTAP_TAPCELL_ROW_162_1818 VDD VSS gf180mcu_as_sc_mcu7t3v3__tap_2
XFILLER_168_1448 VDD VDD VSS VSS gf180mcu_as_sc_mcu7t3v3__fillcap_4
XFILLER_64_299 VDD VDD VSS VSS gf180mcu_as_sc_mcu7t3v3__fill_2
X_4931_ VDD VDD VSS VSS _5080_/CLK _4931_/D _4931_/Q gf180mcu_as_sc_mcu7t3v3__dfxtp_2
XFILLER_166_1161 VDD VDD VSS VSS gf180mcu_as_sc_mcu7t3v3__fill_2
XFILLER_178_625 VDD VDD VSS VSS gf180mcu_as_sc_mcu7t3v3__fill_2
X_4862_ VDD VDD VSS VSS _4938_/CLK _4862_/D _4862_/Q gf180mcu_as_sc_mcu7t3v3__dfxtp_2
XFILLER_178_647 VDD VDD VSS VSS gf180mcu_as_sc_mcu7t3v3__fillcap_4
X_3813_ VDD VDD VSS VSS _3917_/A _3931_/A _3924_/A gf180mcu_as_sc_mcu7t3v3__nor2b_2
XFILLER_144_1481 VDD VDD VSS VSS gf180mcu_as_sc_mcu7t3v3__fill_2
XFILLER_165_319 VDD VDD VSS VSS gf180mcu_as_sc_mcu7t3v3__fillcap_16
XFILLER_18_1451 VDD VDD VSS VSS gf180mcu_as_sc_mcu7t3v3__fillcap_16
X_4793_ VDD VDD VSS VSS _4863_/CLK _4793_/D _4793_/Q gf180mcu_as_sc_mcu7t3v3__dfxtp_2
XFILLER_140_1345 VDD VDD VSS VSS gf180mcu_as_sc_mcu7t3v3__fillcap_16
XFILLER_146_500 VDD VDD VSS VSS gf180mcu_as_sc_mcu7t3v3__fill_1
XFILLER_179_1511 VDD VDD VSS VSS gf180mcu_as_sc_mcu7t3v3__fillcap_16
X_3744_ VDD VDD VSS VSS _4119_/A _3744_/B _3744_/C _3746_/B _3745_/C gf180mcu_as_sc_mcu7t3v3__ao211_2
XFILLER_140_1367 VDD VDD VSS VSS gf180mcu_as_sc_mcu7t3v3__fillcap_8
XFILLER_173_330 VDD VDD VSS VSS gf180mcu_as_sc_mcu7t3v3__fillcap_16
XFILLER_174_842 VDD VDD VSS VSS gf180mcu_as_sc_mcu7t3v3__fill_1
X_3675_ VDD VDD VSS VSS _4049_/A _3752_/B _3753_/B _3676_/C _3675_/D gf180mcu_as_sc_mcu7t3v3__aoi211_2
XFILLER_173_352 VDD VDD VSS VSS gf180mcu_as_sc_mcu7t3v3__fillcap_16
X_2626_ VDD VDD VSS VSS _2626_/B _4264_/B _2627_/D gf180mcu_as_sc_mcu7t3v3__and2_2
XFILLER_133_249 VDD VDD VSS VSS gf180mcu_as_sc_mcu7t3v3__fill_2
XFILLER_173_1143 VDD VDD VSS VSS gf180mcu_as_sc_mcu7t3v3__fill_2
X_2557_ VDD VDD VSS VSS _2558_/C _2557_/A _4294_/B gf180mcu_as_sc_mcu7t3v3__and2_2
XFILLER_141_282 VDD VDD VSS VSS gf180mcu_as_sc_mcu7t3v3__fill_2
XFILLER_153_18 VDD VDD VSS VSS gf180mcu_as_sc_mcu7t3v3__fillcap_16
XFILLER_99_174 VDD VDD VSS VSS gf180mcu_as_sc_mcu7t3v3__fillcap_4
XFILLER_99_196 VDD VDD VSS VSS gf180mcu_as_sc_mcu7t3v3__fill_2
X_5276_ VDD VDD VSS VSS clkload5/A _5276_/D _5276_/Q gf180mcu_as_sc_mcu7t3v3__dfxtp_2
X_2488_ VDD VDD VSS VSS _4329_/A _2534_/B _2534_/A gf180mcu_as_sc_mcu7t3v3__nand2_2
XFILLER_116_1550 VDD VDD VSS VSS gf180mcu_as_sc_mcu7t3v3__fillcap_4
XFILLER_151_1430 VDD VDD VSS VSS gf180mcu_as_sc_mcu7t3v3__fillcap_4
X_4227_ VDD VDD VSS VSS _4256_/B _4228_/B _4228_/C _5063_/Q _5063_/D gf180mcu_as_sc_mcu7t3v3__ao22_2
XFILLER_25_1499 VDD VDD VSS VSS gf180mcu_as_sc_mcu7t3v3__fillcap_16
X_4158_ VDD VDD VSS VSS _5005_/Q _4166_/B _4256_/B _4166_/D _5005_/D gf180mcu_as_sc_mcu7t3v3__ao22_2
X_4089_ VDD VDD VSS VSS _4089_/A _4105_/B _4089_/C _4089_/D _4090_/B gf180mcu_as_sc_mcu7t3v3__ao211_2
X_3109_ VDD VDD VSS VSS _3118_/S _4085_/D _4088_/A _3112_/B gf180mcu_as_sc_mcu7t3v3__mux2_2
XFILLER_102_88 VDD VDD VSS VSS gf180mcu_as_sc_mcu7t3v3__fillcap_4
XFILLER_62_37 VDD VDD VSS VSS gf180mcu_as_sc_mcu7t3v3__fillcap_4
XFILLER_70_247 VDD VDD VSS VSS gf180mcu_as_sc_mcu7t3v3__fillcap_4
XTAP_TAPCELL_ROW_66_1_900 VDD VSS gf180mcu_as_sc_mcu7t3v3__tap_2
XFILLER_169_647 VDD VDD VSS VSS gf180mcu_as_sc_mcu7t3v3__fill_1
XFILLER_178_37 VDD VDD VSS VSS gf180mcu_as_sc_mcu7t3v3__fillcap_16
XFILLER_180_1136 VDD VDD VSS VSS gf180mcu_as_sc_mcu7t3v3__fill_2
XFILLER_23_174 VDD VDD VSS VSS gf180mcu_as_sc_mcu7t3v3__fillcap_16
XFILLER_123_1521 VDD VDD VSS VSS gf180mcu_as_sc_mcu7t3v3__fillcap_16
XFILLER_177_680 VDD VDD VSS VSS gf180mcu_as_sc_mcu7t3v3__fill_1
XFILLER_109_257 VDD VDD VSS VSS gf180mcu_as_sc_mcu7t3v3__fillcap_4
XFILLER_165_853 VDD VDD VSS VSS gf180mcu_as_sc_mcu7t3v3__fillcap_4
XFILLER_183_138 VDD VDD VSS VSS gf180mcu_as_sc_mcu7t3v3__fill_2
XFILLER_109_279 VDD VDD VSS VSS gf180mcu_as_sc_mcu7t3v3__fill_1
XFILLER_178_1043 VDD VDD VSS VSS gf180mcu_as_sc_mcu7t3v3__fillcap_16
XTAP_TAPCELL_ROW_7_3_2360 VDD VSS gf180mcu_as_sc_mcu7t3v3__tap_2
XFILLER_139_1049 VDD VDD VSS VSS gf180mcu_as_sc_mcu7t3v3__fill_1
XFILLER_178_1098 VDD VDD VSS VSS gf180mcu_as_sc_mcu7t3v3__fillcap_8
XFILLER_156_1341 VDD VDD VSS VSS gf180mcu_as_sc_mcu7t3v3__fill_1
XTAP_TAPCELL_ROW_89_1_990 VDD VSS gf180mcu_as_sc_mcu7t3v3__tap_2
XFILLER_152_1227 VDD VDD VSS VSS gf180mcu_as_sc_mcu7t3v3__fill_2
XFILLER_143_40 VDD VDD VSS VSS gf180mcu_as_sc_mcu7t3v3__fillcap_16
XTAP_TAPCELL_ROW_183_2276 VDD VSS gf180mcu_as_sc_mcu7t3v3__tap_2
XTAP_TAPCELL_ROW_86_3_2478 VDD VSS gf180mcu_as_sc_mcu7t3v3__tap_2
XTAP_TAPCELL_ROW_183_2287 VDD VSS gf180mcu_as_sc_mcu7t3v3__tap_2
XFILLER_46_244 VDD VDD VSS VSS gf180mcu_as_sc_mcu7t3v3__fill_1
XPHY_EDGE_ROW_137_Left_589 VDD VSS gf180mcu_as_sc_mcu7t3v3__tap_2
XPHY_EDGE_ROW_20_1_Left_472 VDD VSS gf180mcu_as_sc_mcu7t3v3__tap_2
XFILLER_46_299 VDD VDD VSS VSS gf180mcu_as_sc_mcu7t3v3__fill_2
XFILLER_163_1312 VDD VDD VSS VSS gf180mcu_as_sc_mcu7t3v3__fillcap_8
XFILLER_175_606 VDD VDD VSS VSS gf180mcu_as_sc_mcu7t3v3__fill_2
Xinput13 VDD VDD VSS VSS boot_data[1] _2692_/A gf180mcu_as_sc_mcu7t3v3__buff_2
XFILLER_167_190 VDD VDD VSS VSS gf180mcu_as_sc_mcu7t3v3__fillcap_16
XPHY_EDGE_ROW_146_Left_598 VDD VSS gf180mcu_as_sc_mcu7t3v3__tap_2
Xinput24 VDD VDD VSS VSS dft_addr[1] _2610_/B gf180mcu_as_sc_mcu7t3v3__buff_2
Xinput46 VDD VDD VSS VSS east_in[11] _4024_/A gf180mcu_as_sc_mcu7t3v3__buff_2
Xinput35 VDD VDD VSS VSS dft_wdata[0] _2686_/B gf180mcu_as_sc_mcu7t3v3__buff_2
XFILLER_115_205 VDD VDD VSS VSS gf180mcu_as_sc_mcu7t3v3__fillcap_4
XFILLER_143_503 VDD VDD VSS VSS gf180mcu_as_sc_mcu7t3v3__fillcap_16
XFILLER_155_352 VDD VDD VSS VSS gf180mcu_as_sc_mcu7t3v3__fillcap_4
Xinput79 VDD VDD VSS VSS ne_in[10] _4016_/D gf180mcu_as_sc_mcu7t3v3__buff_2
Xinput68 VDD VDD VSS VSS east_in[31] _3508_/A gf180mcu_as_sc_mcu7t3v3__buff_2
Xinput57 VDD VDD VSS VSS east_in[21] _4103_/A gf180mcu_as_sc_mcu7t3v3__buff_2
XTAP_TAPCELL_ROW_155_1677 VDD VSS gf180mcu_as_sc_mcu7t3v3__tap_2
XTAP_TAPCELL_ROW_155_1666 VDD VSS gf180mcu_as_sc_mcu7t3v3__tap_2
XTAP_TAPCELL_ROW_124_1_1133 VDD VSS gf180mcu_as_sc_mcu7t3v3__tap_2
XFILLER_115_249 VDD VDD VSS VSS gf180mcu_as_sc_mcu7t3v3__fill_2
XFILLER_155_385 VDD VDD VSS VSS gf180mcu_as_sc_mcu7t3v3__fill_2
XFILLER_157_1138 VDD VDD VSS VSS gf180mcu_as_sc_mcu7t3v3__fill_2
XFILLER_170_311 VDD VDD VSS VSS gf180mcu_as_sc_mcu7t3v3__fillcap_4
XFILLER_170_333 VDD VDD VSS VSS gf180mcu_as_sc_mcu7t3v3__fillcap_16
XFILLER_182_193 VDD VDD VSS VSS gf180mcu_as_sc_mcu7t3v3__fillcap_16
X_3460_ VDD VDD VSS VSS _3474_/B _4109_/A _3460_/A _3462_/B gf180mcu_as_sc_mcu7t3v3__mux2_2
X_3391_ VDD VDD VSS VSS _3447_/B _3391_/B _3391_/C _3392_/C gf180mcu_as_sc_mcu7t3v3__nor3_2
X_2411_ VDD VDD VSS VSS _2538_/A _5162_/Q gf180mcu_as_sc_mcu7t3v3__inv_2
X_5130_ VDD VDD VSS VSS _5199_/CLK _5130_/D _5130_/Q gf180mcu_as_sc_mcu7t3v3__dfxtp_2
XFILLER_123_282 VDD VDD VSS VSS gf180mcu_as_sc_mcu7t3v3__fillcap_16
XFILLER_174_1496 VDD VDD VSS VSS gf180mcu_as_sc_mcu7t3v3__fillcap_8
XFILLER_28_2 VDD VDD VSS VSS gf180mcu_as_sc_mcu7t3v3__fillcap_16
XFILLER_96_144 VDD VDD VSS VSS gf180mcu_as_sc_mcu7t3v3__fill_1
X_5061_ VDD VDD VSS VSS _5172_/CLK _5061_/D _5061_/Q gf180mcu_as_sc_mcu7t3v3__dfxtp_2
XTAP_TAPCELL_ROW_104_1_1053 VDD VSS gf180mcu_as_sc_mcu7t3v3__tap_2
X_4012_ VDD VDD VSS VSS _4987_/Q _4117_/B _4238_/B _4108_/D _4987_/D gf180mcu_as_sc_mcu7t3v3__ao22_2
XFILLER_37_244 VDD VDD VSS VSS gf180mcu_as_sc_mcu7t3v3__fillcap_16
XFILLER_168_1267 VDD VDD VSS VSS gf180mcu_as_sc_mcu7t3v3__fillcap_4
XFILLER_168_1289 VDD VDD VSS VSS gf180mcu_as_sc_mcu7t3v3__fillcap_4
XFILLER_52_247 VDD VDD VSS VSS gf180mcu_as_sc_mcu7t3v3__fillcap_8
X_4914_ VDD VDD VSS VSS _4914_/CLK _4914_/D _4914_/Q gf180mcu_as_sc_mcu7t3v3__dfxtp_2
XFILLER_94_1486 VDD VDD VSS VSS gf180mcu_as_sc_mcu7t3v3__fillcap_16
XPHY_EDGE_ROW_173_Right_307 VDD VSS gf180mcu_as_sc_mcu7t3v3__tap_2
XFILLER_32_18 VDD VDD VSS VSS gf180mcu_as_sc_mcu7t3v3__fillcap_16
X_4845_ VDD VDD VSS VSS _4858_/CLK _4845_/D _4845_/Q gf180mcu_as_sc_mcu7t3v3__dfxtp_2
XFILLER_147_820 VDD VDD VSS VSS gf180mcu_as_sc_mcu7t3v3__fillcap_4
XFILLER_159_680 VDD VDD VSS VSS gf180mcu_as_sc_mcu7t3v3__fill_1
XFILLER_20_155 VDD VDD VSS VSS gf180mcu_as_sc_mcu7t3v3__fillcap_16
X_4776_ VDD VDD VSS VSS _4928_/CLK _4776_/D _4776_/Q gf180mcu_as_sc_mcu7t3v3__dfxtp_2
XFILLER_147_842 VDD VDD VSS VSS gf180mcu_as_sc_mcu7t3v3__fillcap_16
XFILLER_20_177 VDD VDD VSS VSS gf180mcu_as_sc_mcu7t3v3__fillcap_16
X_3727_ VDD VDD VSS VSS _4936_/Q _3740_/B _3741_/C _4101_/D _3728_/D gf180mcu_as_sc_mcu7t3v3__ao22_2
XPHY_EDGE_ROW_96_1_Left_548 VDD VSS gf180mcu_as_sc_mcu7t3v3__tap_2
XFILLER_162_801 VDD VDD VSS VSS gf180mcu_as_sc_mcu7t3v3__fillcap_4
XFILLER_175_1205 VDD VDD VSS VSS gf180mcu_as_sc_mcu7t3v3__fillcap_8
X_3658_ VDD VDD VSS VSS _3659_/C _4032_/D _3750_/C _3658_/C gf180mcu_as_sc_mcu7t3v3__ao21_2
XTAP_TAPCELL_ROW_92_3_2488 VDD VSS gf180mcu_as_sc_mcu7t3v3__tap_2
X_3589_ VDD VDD VSS VSS _4918_/Q _3740_/B _3740_/C _3959_/A _3590_/D gf180mcu_as_sc_mcu7t3v3__ao22_2
X_2609_ VDD VDD VSS VSS _2692_/S _2609_/B input3/Y _2610_/A gf180mcu_as_sc_mcu7t3v3__mux2_2
XFILLER_138_1082 VDD VDD VSS VSS gf180mcu_as_sc_mcu7t3v3__fill_2
XFILLER_87_144 VDD VDD VSS VSS gf180mcu_as_sc_mcu7t3v3__fill_1
XFILLER_87_155 VDD VDD VSS VSS gf180mcu_as_sc_mcu7t3v3__fillcap_4
XFILLER_87_166 VDD VDD VSS VSS gf180mcu_as_sc_mcu7t3v3__fillcap_16
X_5259_ VDD VDD VSS VSS _5266_/CLK _5259_/D _5259_/Q gf180mcu_as_sc_mcu7t3v3__dfxtp_2
XFILLER_113_10 VDD VDD VSS VSS gf180mcu_as_sc_mcu7t3v3__fillcap_4
XFILLER_169_1009 VDD VDD VSS VSS gf180mcu_as_sc_mcu7t3v3__fillcap_16
XFILLER_113_65 VDD VDD VSS VSS gf180mcu_as_sc_mcu7t3v3__fillcap_4
XFILLER_28_299 VDD VDD VSS VSS gf180mcu_as_sc_mcu7t3v3__fill_2
XPHY_EDGE_ROW_30_3_Right_349 VDD VSS gf180mcu_as_sc_mcu7t3v3__tap_2
XFILLER_147_1329 VDD VDD VSS VSS gf180mcu_as_sc_mcu7t3v3__fill_1
XFILLER_169_400 VDD VDD VSS VSS gf180mcu_as_sc_mcu7t3v3__fillcap_16
XFILLER_73_69 VDD VDD VSS VSS gf180mcu_as_sc_mcu7t3v3__fill_1
XFILLER_169_422 VDD VDD VSS VSS gf180mcu_as_sc_mcu7t3v3__fillcap_16
XFILLER_73_1515 VDD VDD VSS VSS gf180mcu_as_sc_mcu7t3v3__fillcap_4
XFILLER_73_1537 VDD VDD VSS VSS gf180mcu_as_sc_mcu7t3v3__fillcap_16
XTAP_TAPCELL_ROW_130_1_1154 VDD VSS gf180mcu_as_sc_mcu7t3v3__tap_2
XFILLER_160_1507 VDD VDD VSS VSS gf180mcu_as_sc_mcu7t3v3__fillcap_16
Xsram2048.u_bank0_810 VDD VDD VSS VSS sram2048.u_bank0/WEN[0] gf180mcu_as_sc_mcu7t3v3__tiel_4
XFILLER_132_2 VDD VDD VSS VSS gf180mcu_as_sc_mcu7t3v3__fillcap_16
XFILLER_157_628 VDD VDD VSS VSS gf180mcu_as_sc_mcu7t3v3__fill_2
XFILLER_7_104 VDD VDD VSS VSS gf180mcu_as_sc_mcu7t3v3__fillcap_16
XPHY_EDGE_ROW_9_1_Right_8 VDD VSS gf180mcu_as_sc_mcu7t3v3__tap_2
XFILLER_138_842 VDD VDD VSS VSS gf180mcu_as_sc_mcu7t3v3__fillcap_4
XFILLER_137_352 VDD VDD VSS VSS gf180mcu_as_sc_mcu7t3v3__fillcap_16
XTAP_TAPCELL_ROW_110_1_1074 VDD VSS gf180mcu_as_sc_mcu7t3v3__tap_2
XFILLER_152_333 VDD VDD VSS VSS gf180mcu_as_sc_mcu7t3v3__fillcap_4
XFILLER_164_171 VDD VDD VSS VSS gf180mcu_as_sc_mcu7t3v3__fillcap_4
XFILLER_164_193 VDD VDD VSS VSS gf180mcu_as_sc_mcu7t3v3__fillcap_16
XFILLER_165_694 VDD VDD VSS VSS gf180mcu_as_sc_mcu7t3v3__fillcap_4
XFILLER_180_675 VDD VDD VSS VSS gf180mcu_as_sc_mcu7t3v3__fillcap_4
XTAP_TAPCELL_ROW_150_1552 VDD VSS gf180mcu_as_sc_mcu7t3v3__tap_2
XFILLER_98_88 VDD VDD VSS VSS gf180mcu_as_sc_mcu7t3v3__fillcap_4
XTAP_TAPCELL_ROW_150_1563 VDD VSS gf180mcu_as_sc_mcu7t3v3__tap_2
XFILLER_105_282 VDD VDD VSS VSS gf180mcu_as_sc_mcu7t3v3__fillcap_16
XFILLER_152_1013 VDD VDD VSS VSS gf180mcu_as_sc_mcu7t3v3__fill_2
XFILLER_78_166 VDD VDD VSS VSS gf180mcu_as_sc_mcu7t3v3__fill_2
XFILLER_78_177 VDD VDD VSS VSS gf180mcu_as_sc_mcu7t3v3__fillcap_16
XFILLER_134_1480 VDD VDD VSS VSS gf180mcu_as_sc_mcu7t3v3__fillcap_8
XFILLER_19_244 VDD VDD VSS VSS gf180mcu_as_sc_mcu7t3v3__fillcap_16
XFILLER_34_225 VDD VDD VSS VSS gf180mcu_as_sc_mcu7t3v3__fillcap_16
XFILLER_165_1418 VDD VDD VSS VSS gf180mcu_as_sc_mcu7t3v3__fillcap_16
XFILLER_34_247 VDD VDD VSS VSS gf180mcu_as_sc_mcu7t3v3__fillcap_16
XPHY_EDGE_ROW_13_3_Left_147 VDD VSS gf180mcu_as_sc_mcu7t3v3__tap_2
X_2960_ VDD VDD VSS VSS _3940_/A _3177_/B _3236_/C _3941_/A _2961_/C gf180mcu_as_sc_mcu7t3v3__ao22_2
X_2891_ VDD VDD VSS VSS _3257_/A _3533_/B _3533_/A gf180mcu_as_sc_mcu7t3v3__nor2b_2
XTAP_TAPCELL_ROW_157_1706 VDD VSS gf180mcu_as_sc_mcu7t3v3__tap_2
XTAP_TAPCELL_ROW_109_3_2513 VDD VSS gf180mcu_as_sc_mcu7t3v3__tap_2
XFILLER_176_937 VDD VDD VSS VSS gf180mcu_as_sc_mcu7t3v3__fillcap_8
XPHY_EDGE_ROW_154_Left_606 VDD VSS gf180mcu_as_sc_mcu7t3v3__tap_2
X_4630_ VDD VDD VSS VSS _4680_/B _5118_/Q _5221_/Q _5221_/D gf180mcu_as_sc_mcu7t3v3__mux2_2
XTAP_TAPCELL_ROW_157_1717 VDD VSS gf180mcu_as_sc_mcu7t3v3__tap_2
XFILLER_8_53 VDD VDD VSS VSS gf180mcu_as_sc_mcu7t3v3__fillcap_16
XFILLER_176_1503 VDD VDD VSS VSS gf180mcu_as_sc_mcu7t3v3__fill_2
X_4561_ VDD VDD VSS VSS _4561_/D _4587_/A _4561_/B _4561_/C _4562_/B gf180mcu_as_sc_mcu7t3v3__ao31_2
XFILLER_143_333 VDD VDD VSS VSS gf180mcu_as_sc_mcu7t3v3__fillcap_4
XFILLER_155_160 VDD VDD VSS VSS gf180mcu_as_sc_mcu7t3v3__fill_1
XFILLER_156_683 VDD VDD VSS VSS gf180mcu_as_sc_mcu7t3v3__fillcap_16
X_4492_ VDD VDD VSS VSS _4495_/C _4492_/B _4547_/A gf180mcu_as_sc_mcu7t3v3__nor2_2
X_3512_ VDD VDD VSS VSS _3513_/D _3512_/A _3521_/B _3512_/C gf180mcu_as_sc_mcu7t3v3__ao21_2
XFILLER_171_675 VDD VDD VSS VSS gf180mcu_as_sc_mcu7t3v3__fillcap_4
X_3443_ VDD VDD VSS VSS _4093_/D _3468_/B _3443_/C _3443_/D _3444_/A gf180mcu_as_sc_mcu7t3v3__ao22_2
XFILLER_139_1380 VDD VDD VSS VSS gf180mcu_as_sc_mcu7t3v3__fillcap_16
XFILLER_69_144 VDD VDD VSS VSS gf180mcu_as_sc_mcu7t3v3__fill_1
X_5113_ VDD VDD VSS VSS clkload9/A _5113_/D _5113_/Q gf180mcu_as_sc_mcu7t3v3__dfxtp_2
X_3374_ VDD VDD VSS VSS _4022_/A _3467_/C _3469_/B _4025_/A _3375_/C gf180mcu_as_sc_mcu7t3v3__ao22_2
XFILLER_111_241 VDD VDD VSS VSS gf180mcu_as_sc_mcu7t3v3__fillcap_16
XFILLER_170_1157 VDD VDD VSS VSS gf180mcu_as_sc_mcu7t3v3__fillcap_4
XFILLER_26_1550 VDD VDD VSS VSS gf180mcu_as_sc_mcu7t3v3__fillcap_4
XPHY_EDGE_ROW_163_Left_615 VDD VSS gf180mcu_as_sc_mcu7t3v3__tap_2
XFILLER_27_18 VDD VDD VSS VSS gf180mcu_as_sc_mcu7t3v3__fillcap_16
XFILLER_69_188 VDD VDD VSS VSS gf180mcu_as_sc_mcu7t3v3__fillcap_8
X_5044_ VDD VDD VSS VSS _5088_/CLK _5044_/D _5044_/Q gf180mcu_as_sc_mcu7t3v3__dfxtp_2
XFILLER_113_1553 VDD VDD VSS VSS gf180mcu_as_sc_mcu7t3v3__fillcap_8
XFILLER_168_1053 VDD VDD VSS VSS gf180mcu_as_sc_mcu7t3v3__fill_2
XFILLER_168_1075 VDD VDD VSS VSS gf180mcu_as_sc_mcu7t3v3__fillcap_8
XFILLER_179_731 VDD VDD VSS VSS gf180mcu_as_sc_mcu7t3v3__fill_2
XFILLER_146_1362 VDD VDD VSS VSS gf180mcu_as_sc_mcu7t3v3__fill_2
XFILLER_178_241 VDD VDD VSS VSS gf180mcu_as_sc_mcu7t3v3__fillcap_4
XPHY_EDGE_ROW_172_Left_624 VDD VSS gf180mcu_as_sc_mcu7t3v3__tap_2
XFILLER_139_617 VDD VDD VSS VSS gf180mcu_as_sc_mcu7t3v3__fillcap_8
XFILLER_166_403 VDD VDD VSS VSS gf180mcu_as_sc_mcu7t3v3__fillcap_16
XFILLER_178_263 VDD VDD VSS VSS gf180mcu_as_sc_mcu7t3v3__fillcap_16
XFILLER_33_1521 VDD VDD VSS VSS gf180mcu_as_sc_mcu7t3v3__fillcap_16
X_4828_ VDD VDD VSS VSS _4938_/CLK _4828_/D _4828_/Q gf180mcu_as_sc_mcu7t3v3__dfxtp_2
XFILLER_120_1502 VDD VDD VSS VSS gf180mcu_as_sc_mcu7t3v3__fillcap_16
XFILLER_154_609 VDD VDD VSS VSS gf180mcu_as_sc_mcu7t3v3__fillcap_16
X_4759_ VDD VDD VSS VSS clkload1/A _4759_/D _4759_/Q gf180mcu_as_sc_mcu7t3v3__dfxtp_2
XFILLER_162_620 VDD VDD VSS VSS gf180mcu_as_sc_mcu7t3v3__fillcap_8
XFILLER_174_491 VDD VDD VSS VSS gf180mcu_as_sc_mcu7t3v3__fill_1
XFILLER_4_107 VDD VDD VSS VSS gf180mcu_as_sc_mcu7t3v3__fillcap_16
XFILLER_135_878 VDD VDD VSS VSS gf180mcu_as_sc_mcu7t3v3__fillcap_16
XFILLER_146_193 VDD VDD VSS VSS gf180mcu_as_sc_mcu7t3v3__fillcap_16
XFILLER_162_675 VDD VDD VSS VSS gf180mcu_as_sc_mcu7t3v3__fillcap_4
XFILLER_108_65 VDD VDD VSS VSS gf180mcu_as_sc_mcu7t3v3__fill_1
XFILLER_161_174 VDD VDD VSS VSS gf180mcu_as_sc_mcu7t3v3__fillcap_16
XTAP_TAPCELL_ROW_39_3_2408 VDD VSS gf180mcu_as_sc_mcu7t3v3__tap_2
XFILLER_102_230 VDD VDD VSS VSS gf180mcu_as_sc_mcu7t3v3__fill_1
XFILLER_157_1480 VDD VDD VSS VSS gf180mcu_as_sc_mcu7t3v3__fillcap_4
XPHY_EDGE_ROW_181_Left_633 VDD VSS gf180mcu_as_sc_mcu7t3v3__tap_2
XFILLER_102_241 VDD VDD VSS VSS gf180mcu_as_sc_mcu7t3v3__fillcap_4
XFILLER_118_1486 VDD VDD VSS VSS gf180mcu_as_sc_mcu7t3v3__fillcap_16
Xinput203 VDD VDD VSS VSS se_in[2] _3952_/A gf180mcu_as_sc_mcu7t3v3__buff_2
Xinput214 VDD VDD VSS VSS se_in[9] _4009_/A gf180mcu_as_sc_mcu7t3v3__buff_2
Xinput225 VDD VDD VSS VSS south_in[19] _4088_/D gf180mcu_as_sc_mcu7t3v3__buff_2
Xinput236 VDD VDD VSS VSS south_in[29] _3788_/D gf180mcu_as_sc_mcu7t3v3__buff_2
XFILLER_153_1399 VDD VDD VSS VSS gf180mcu_as_sc_mcu7t3v3__fill_1
Xinput247 VDD VDD VSS VSS south_in[8] _4000_/D gf180mcu_as_sc_mcu7t3v3__buff_2
Xinput258 VDD VDD VSS VSS sw_in[18] _2440_/A gf180mcu_as_sc_mcu7t3v3__buff_2
Xinput269 VDD VDD VSS VSS sw_in[28] _4164_/A gf180mcu_as_sc_mcu7t3v3__buff_2
XTAP_TAPCELL_ROW_180_2224 VDD VSS gf180mcu_as_sc_mcu7t3v3__tap_2
XTAP_TAPCELL_ROW_180_2213 VDD VSS gf180mcu_as_sc_mcu7t3v3__tap_2
XFILLER_147_1126 VDD VDD VSS VSS gf180mcu_as_sc_mcu7t3v3__fill_1
XFILLER_16_225 VDD VDD VSS VSS gf180mcu_as_sc_mcu7t3v3__fillcap_16
XFILLER_16_247 VDD VDD VSS VSS gf180mcu_as_sc_mcu7t3v3__fillcap_16
XFILLER_182_1017 VDD VDD VSS VSS gf180mcu_as_sc_mcu7t3v3__fill_1
XFILLER_31_206 VDD VDD VSS VSS gf180mcu_as_sc_mcu7t3v3__fillcap_4
XFILLER_31_228 VDD VDD VSS VSS gf180mcu_as_sc_mcu7t3v3__fillcap_16
XTAP_TAPCELL_ROW_178_2175 VDD VSS gf180mcu_as_sc_mcu7t3v3__tap_2
XTAP_TAPCELL_ROW_178_2164 VDD VSS gf180mcu_as_sc_mcu7t3v3__tap_2
XFILLER_33_50 VDD VDD VSS VSS gf180mcu_as_sc_mcu7t3v3__fillcap_16
XFILLER_129_138 VDD VDD VSS VSS gf180mcu_as_sc_mcu7t3v3__fill_2
XFILLER_149_50 VDD VDD VSS VSS gf180mcu_as_sc_mcu7t3v3__fillcap_16
XFILLER_157_436 VDD VDD VSS VSS gf180mcu_as_sc_mcu7t3v3__fill_1
XFILLER_158_959 VDD VDD VSS VSS gf180mcu_as_sc_mcu7t3v3__fill_2
XFILLER_184_222 VDD VDD VSS VSS gf180mcu_as_sc_mcu7t3v3__fillcap_16
XFILLER_33_72 VDD VDD VSS VSS gf180mcu_as_sc_mcu7t3v3__fillcap_16
XFILLER_149_72 VDD VDD VSS VSS gf180mcu_as_sc_mcu7t3v3__fillcap_16
XTAP_TAPCELL_ROW_152_1603 VDD VSS gf180mcu_as_sc_mcu7t3v3__tap_2
XFILLER_125_300 VDD VDD VSS VSS gf180mcu_as_sc_mcu7t3v3__fill_1
XFILLER_138_683 VDD VDD VSS VSS gf180mcu_as_sc_mcu7t3v3__fillcap_8
XFILLER_158_1200 VDD VDD VSS VSS gf180mcu_as_sc_mcu7t3v3__fillcap_16
XFILLER_140_303 VDD VDD VSS VSS gf180mcu_as_sc_mcu7t3v3__fillcap_4
XFILLER_153_697 VDD VDD VSS VSS gf180mcu_as_sc_mcu7t3v3__fill_2
XFILLER_136_1531 VDD VDD VSS VSS gf180mcu_as_sc_mcu7t3v3__fillcap_4
XFILLER_140_358 VDD VDD VSS VSS gf180mcu_as_sc_mcu7t3v3__fill_1
XFILLER_171_1488 VDD VDD VSS VSS gf180mcu_as_sc_mcu7t3v3__fillcap_16
XFILLER_58_80 VDD VDD VSS VSS gf180mcu_as_sc_mcu7t3v3__fillcap_8
Xmesh_tile_829 VDD VDD VSS VSS ne_out[4] gf180mcu_as_sc_mcu7t3v3__tiel_4
X_3090_ VDD VDD VSS VSS _3097_/B _3130_/B _4073_/A gf180mcu_as_sc_mcu7t3v3__nand2_2
XPHY_EDGE_ROW_12_1_Right_11 VDD VSS gf180mcu_as_sc_mcu7t3v3__tap_2
Xclkbuf_leaf_7_clk_regs VDD VDD VSS VSS clkbuf_3_1_0_clk_regs/Y clkload6/A gf180mcu_as_sc_mcu7t3v3__clkbuff_12
XFILLER_165_1259 VDD VDD VSS VSS gf180mcu_as_sc_mcu7t3v3__fill_1
X_3992_ VDD VDD VSS VSS _3992_/A _4162_/B _4160_/B _3992_/D _3993_/D gf180mcu_as_sc_mcu7t3v3__ao22_2
XFILLER_182_1551 VDD VDD VSS VSS gf180mcu_as_sc_mcu7t3v3__fillcap_4
XFILLER_95_2 VDD VDD VSS VSS gf180mcu_as_sc_mcu7t3v3__fillcap_16
X_2943_ VDD VDD VSS VSS _3243_/B _3526_/B _3283_/A gf180mcu_as_sc_mcu7t3v3__nand2_2
XFILLER_143_1535 VDD VDD VSS VSS gf180mcu_as_sc_mcu7t3v3__fillcap_4
XFILLER_149_926 VDD VDD VSS VSS gf180mcu_as_sc_mcu7t3v3__fill_1
XFILLER_149_948 VDD VDD VSS VSS gf180mcu_as_sc_mcu7t3v3__fill_1
XFILLER_176_723 VDD VDD VSS VSS gf180mcu_as_sc_mcu7t3v3__fillcap_8
XFILLER_91_1467 VDD VDD VSS VSS gf180mcu_as_sc_mcu7t3v3__fillcap_16
XFILLER_175_244 VDD VDD VSS VSS gf180mcu_as_sc_mcu7t3v3__fillcap_16
XPHY_EDGE_ROW_108_1_Left_560 VDD VSS gf180mcu_as_sc_mcu7t3v3__tap_2
X_2874_ VDD VDD VSS VSS _4768_/D _4742_/C _4749_/B _4733_/B gf180mcu_as_sc_mcu7t3v3__aoi21_2
XFILLER_141_1270 VDD VDD VSS VSS gf180mcu_as_sc_mcu7t3v3__fill_2
X_4613_ VDD VDD VSS VSS _5207_/Q _4623_/B _4623_/C _5208_/Q _5207_/D gf180mcu_as_sc_mcu7t3v3__ao22_2
XFILLER_135_119 VDD VDD VSS VSS gf180mcu_as_sc_mcu7t3v3__fill_2
XFILLER_144_620 VDD VDD VSS VSS gf180mcu_as_sc_mcu7t3v3__fillcap_16
X_4544_ VDD VDD VSS VSS _4544_/S _5025_/Q _5054_/Q _4545_/B gf180mcu_as_sc_mcu7t3v3__mux2_2
XFILLER_144_675 VDD VDD VSS VSS gf180mcu_as_sc_mcu7t3v3__fillcap_4
XFILLER_145_19 VDD VDD VSS VSS gf180mcu_as_sc_mcu7t3v3__fillcap_16
XFILLER_89_228 VDD VDD VSS VSS gf180mcu_as_sc_mcu7t3v3__fillcap_16
X_4475_ VDD VDD VSS VSS _4476_/D _4475_/B _4553_/A gf180mcu_as_sc_mcu7t3v3__nor2_2
XFILLER_171_494 VDD VDD VSS VSS gf180mcu_as_sc_mcu7t3v3__fill_1
X_3426_ VDD VDD VSS VSS _3428_/C _4080_/D _3473_/B _3426_/C gf180mcu_as_sc_mcu7t3v3__ao21_2
XFILLER_135_1052 VDD VDD VSS VSS gf180mcu_as_sc_mcu7t3v3__fillcap_4
X_3357_ VDD VDD VSS VSS _3452_/S _4008_/D _3357_/A _3359_/B gf180mcu_as_sc_mcu7t3v3__mux2_2
XFILLER_135_1085 VDD VDD VSS VSS gf180mcu_as_sc_mcu7t3v3__fill_1
XFILLER_161_18 VDD VDD VSS VSS gf180mcu_as_sc_mcu7t3v3__fillcap_16
X_5027_ VDD VDD VSS VSS _5088_/CLK _5027_/D _5027_/Q gf180mcu_as_sc_mcu7t3v3__dfxtp_2
X_3288_ VDD VDD VSS VSS _3288_/A _3462_/A _3288_/C _3289_/C gf180mcu_as_sc_mcu7t3v3__nor3_2
XFILLER_148_1413 VDD VDD VSS VSS gf180mcu_as_sc_mcu7t3v3__fillcap_16
XFILLER_13_206 VDD VDD VSS VSS gf180mcu_as_sc_mcu7t3v3__fillcap_4
XFILLER_13_228 VDD VDD VSS VSS gf180mcu_as_sc_mcu7t3v3__fillcap_16
XFILLER_167_723 VDD VDD VSS VSS gf180mcu_as_sc_mcu7t3v3__fillcap_8
XFILLER_70_1518 VDD VDD VSS VSS gf180mcu_as_sc_mcu7t3v3__fillcap_16
XFILLER_110_88 VDD VDD VSS VSS gf180mcu_as_sc_mcu7t3v3__fillcap_4
XFILLER_110_99 VDD VDD VSS VSS gf180mcu_as_sc_mcu7t3v3__fillcap_4
XFILLER_142_1045 VDD VDD VSS VSS gf180mcu_as_sc_mcu7t3v3__fillcap_8
XFILLER_70_37 VDD VDD VSS VSS gf180mcu_as_sc_mcu7t3v3__fillcap_8
XFILLER_166_244 VDD VDD VSS VSS gf180mcu_as_sc_mcu7t3v3__fill_1
XTAP_TAPCELL_ROW_173_2072 VDD VSS gf180mcu_as_sc_mcu7t3v3__tap_2
XTAP_TAPCELL_ROW_173_2061 VDD VSS gf180mcu_as_sc_mcu7t3v3__tap_2
XFILLER_107_300 VDD VDD VSS VSS gf180mcu_as_sc_mcu7t3v3__fill_1
XFILLER_177_1108 VDD VDD VSS VSS gf180mcu_as_sc_mcu7t3v3__fill_1
XFILLER_177_1119 VDD VDD VSS VSS gf180mcu_as_sc_mcu7t3v3__fill_1
XFILLER_79_35 VDD VDD VSS VSS gf180mcu_as_sc_mcu7t3v3__fillcap_4
XFILLER_150_601 VDD VDD VSS VSS gf180mcu_as_sc_mcu7t3v3__fill_2
XFILLER_79_46 VDD VDD VSS VSS gf180mcu_as_sc_mcu7t3v3__fillcap_8
XFILLER_79_68 VDD VDD VSS VSS gf180mcu_as_sc_mcu7t3v3__fill_2
XFILLER_0_154 VDD VDD VSS VSS gf180mcu_as_sc_mcu7t3v3__fill_1
XFILLER_150_667 VDD VDD VSS VSS gf180mcu_as_sc_mcu7t3v3__fillcap_8
XFILLER_95_209 VDD VDD VSS VSS gf180mcu_as_sc_mcu7t3v3__fill_1
XFILLER_153_1174 VDD VDD VSS VSS gf180mcu_as_sc_mcu7t3v3__fillcap_4
XFILLER_48_103 VDD VDD VSS VSS gf180mcu_as_sc_mcu7t3v3__fill_2
XFILLER_131_1483 VDD VDD VSS VSS gf180mcu_as_sc_mcu7t3v3__fillcap_16
XFILLER_79_1521 VDD VDD VSS VSS gf180mcu_as_sc_mcu7t3v3__fillcap_16
XTAP_TAPCELL_ROW_145_1451 VDD VSS gf180mcu_as_sc_mcu7t3v3__tap_2
XTAP_TAPCELL_ROW_145_1440 VDD VSS gf180mcu_as_sc_mcu7t3v3__tap_2
XTAP_TAPCELL_ROW_141_1359 VDD VSS gf180mcu_as_sc_mcu7t3v3__tap_2
XTAP_TAPCELL_ROW_141_1348 VDD VSS gf180mcu_as_sc_mcu7t3v3__tap_2
XFILLER_158_723 VDD VDD VSS VSS gf180mcu_as_sc_mcu7t3v3__fillcap_8
XFILLER_164_1281 VDD VDD VSS VSS gf180mcu_as_sc_mcu7t3v3__fillcap_8
XFILLER_139_970 VDD VDD VSS VSS gf180mcu_as_sc_mcu7t3v3__fillcap_8
XFILLER_160_1178 VDD VDD VSS VSS gf180mcu_as_sc_mcu7t3v3__fillcap_4
XFILLER_51_1451 VDD VDD VSS VSS gf180mcu_as_sc_mcu7t3v3__fillcap_16
XFILLER_117_119 VDD VDD VSS VSS gf180mcu_as_sc_mcu7t3v3__fillcap_8
XFILLER_138_480 VDD VDD VSS VSS gf180mcu_as_sc_mcu7t3v3__fill_1
XFILLER_172_225 VDD VDD VSS VSS gf180mcu_as_sc_mcu7t3v3__fillcap_16
XFILLER_60_92 VDD VDD VSS VSS gf180mcu_as_sc_mcu7t3v3__fill_1
XFILLER_172_247 VDD VDD VSS VSS gf180mcu_as_sc_mcu7t3v3__fillcap_16
X_2590_ VDD VDD VSS VSS _4949_/D _2590_/B _3907_/A gf180mcu_as_sc_mcu7t3v3__nand2_2
XFILLER_154_995 VDD VDD VSS VSS gf180mcu_as_sc_mcu7t3v3__fillcap_8
XTAP_TAPCELL_ROW_79_1_953 VDD VSS gf180mcu_as_sc_mcu7t3v3__tap_2
XFILLER_125_196 VDD VDD VSS VSS gf180mcu_as_sc_mcu7t3v3__fill_2
X_4260_ VDD VDD VSS VSS _5096_/D _4260_/B _4260_/A gf180mcu_as_sc_mcu7t3v3__nor2_2
XFILLER_136_1361 VDD VDD VSS VSS gf180mcu_as_sc_mcu7t3v3__fillcap_4
XFILLER_141_678 VDD VDD VSS VSS gf180mcu_as_sc_mcu7t3v3__fill_2
X_4191_ VDD VDD VSS VSS _4251_/B _4192_/B _4192_/C _5029_/Q _5029_/D gf180mcu_as_sc_mcu7t3v3__ao22_2
X_3211_ VDD VDD VSS VSS _3233_/B _3796_/D _3787_/A _3255_/B _3212_/D gf180mcu_as_sc_mcu7t3v3__ao31_2
XFILLER_136_1383 VDD VDD VSS VSS gf180mcu_as_sc_mcu7t3v3__fillcap_8
XFILLER_140_177 VDD VDD VSS VSS gf180mcu_as_sc_mcu7t3v3__fillcap_16
X_3142_ VDD VDD VSS VSS _4119_/A _3142_/B _3142_/C _4118_/A _3148_/B gf180mcu_as_sc_mcu7t3v3__ao22_2
XTAP_TAPCELL_ROW_169_1985 VDD VSS gf180mcu_as_sc_mcu7t3v3__tap_2
XTAP_TAPCELL_ROW_169_1974 VDD VSS gf180mcu_as_sc_mcu7t3v3__tap_2
XFILLER_10_2 VDD VDD VSS VSS gf180mcu_as_sc_mcu7t3v3__fillcap_16
XFILLER_39_158 VDD VDD VSS VSS gf180mcu_as_sc_mcu7t3v3__fill_2
XFILLER_23_1553 VDD VDD VSS VSS gf180mcu_as_sc_mcu7t3v3__fillcap_16
X_3073_ VDD VDD VSS VSS _3676_/A _3156_/A _3073_/C _4785_/D _3706_/D gf180mcu_as_sc_mcu7t3v3__aoi211_2
XFILLER_110_1534 VDD VDD VSS VSS gf180mcu_as_sc_mcu7t3v3__fillcap_16
XFILLER_110_1556 VDD VDD VSS VSS gf180mcu_as_sc_mcu7t3v3__fillcap_8
XFILLER_54_139 VDD VDD VSS VSS gf180mcu_as_sc_mcu7t3v3__fillcap_4
XFILLER_169_1170 VDD VDD VSS VSS gf180mcu_as_sc_mcu7t3v3__fillcap_4
XFILLER_169_1192 VDD VDD VSS VSS gf180mcu_as_sc_mcu7t3v3__fill_2
XFILLER_165_1045 VDD VDD VSS VSS gf180mcu_as_sc_mcu7t3v3__fillcap_4
XFILLER_168_509 VDD VDD VSS VSS gf180mcu_as_sc_mcu7t3v3__fillcap_16
XFILLER_165_1078 VDD VDD VSS VSS gf180mcu_as_sc_mcu7t3v3__fill_1
X_3975_ VDD VDD VSS VSS _3975_/A _4103_/B _3975_/C _3975_/D _3977_/C gf180mcu_as_sc_mcu7t3v3__ao211_2
XFILLER_10_209 VDD VDD VSS VSS gf180mcu_as_sc_mcu7t3v3__fillcap_16
XFILLER_143_1332 VDD VDD VSS VSS gf180mcu_as_sc_mcu7t3v3__fillcap_16
XFILLER_176_531 VDD VDD VSS VSS gf180mcu_as_sc_mcu7t3v3__fill_2
X_2926_ VDD VDD VSS VSS _3216_/B _3266_/B _3531_/A gf180mcu_as_sc_mcu7t3v3__nand2_2
XFILLER_137_907 VDD VDD VSS VSS gf180mcu_as_sc_mcu7t3v3__fill_2
XFILLER_143_1376 VDD VDD VSS VSS gf180mcu_as_sc_mcu7t3v3__fill_1
XFILLER_30_1502 VDD VDD VSS VSS gf180mcu_as_sc_mcu7t3v3__fillcap_16
X_2857_ VDD VDD VSS VSS _2858_/B _5097_/Q _2857_/Y gf180mcu_as_sc_mcu7t3v3__and2_2
XFILLER_156_18 VDD VDD VSS VSS gf180mcu_as_sc_mcu7t3v3__fillcap_16
XFILLER_164_737 VDD VDD VSS VSS gf180mcu_as_sc_mcu7t3v3__fillcap_4
XFILLER_176_597 VDD VDD VSS VSS gf180mcu_as_sc_mcu7t3v3__fillcap_8
XFILLER_178_1428 VDD VDD VSS VSS gf180mcu_as_sc_mcu7t3v3__fill_2
XFILLER_30_1568 VDD VDD VSS VSS gf180mcu_as_sc_mcu7t3v3__fill_1
X_2788_ VDD VDD VSS VSS _5126_/Q _5181_/Q _5165_/Q _2789_/A gf180mcu_as_sc_mcu7t3v3__mux2_2
XTAP_TAPCELL_ROW_123_1_1129 VDD VSS gf180mcu_as_sc_mcu7t3v3__tap_2
XFILLER_176_1152 VDD VDD VSS VSS gf180mcu_as_sc_mcu7t3v3__fill_2
X_4527_ VDD VDD VSS VSS _4559_/S _5023_/Q _5052_/Q _4528_/B gf180mcu_as_sc_mcu7t3v3__mux2_2
X_4458_ VDD VDD VSS VSS _4458_/D _4587_/A _4458_/B _4458_/C _4459_/B gf180mcu_as_sc_mcu7t3v3__ao31_2
XFILLER_160_976 VDD VDD VSS VSS gf180mcu_as_sc_mcu7t3v3__fillcap_16
Xfanout701 VDD VDD VSS VSS _3250_/Y _3465_/B gf180mcu_as_sc_mcu7t3v3__buff_2
Xfanout712 VDD VDD VSS VSS _3145_/D _3120_/D gf180mcu_as_sc_mcu7t3v3__buff_2
Xfanout723 VDD VDD VSS VSS _3144_/B _3177_/B gf180mcu_as_sc_mcu7t3v3__buff_2
X_3409_ VDD VDD VSS VSS _4931_/Q _3465_/B _3465_/C _4061_/A _3410_/C gf180mcu_as_sc_mcu7t3v3__ao22_2
XFILLER_105_22 VDD VDD VSS VSS gf180mcu_as_sc_mcu7t3v3__fill_1
XFILLER_131_188 VDD VDD VSS VSS gf180mcu_as_sc_mcu7t3v3__fillcap_16
XFILLER_154_1483 VDD VDD VSS VSS gf180mcu_as_sc_mcu7t3v3__fill_1
XFILLER_28_1486 VDD VDD VSS VSS gf180mcu_as_sc_mcu7t3v3__fillcap_16
Xfanout734 VDD VDD VSS VSS _2591_/Y _2658_/S gf180mcu_as_sc_mcu7t3v3__buff_2
Xfanout745 VDD VDD VSS VSS _2564_/Y _4748_/A gf180mcu_as_sc_mcu7t3v3__buff_2
Xfanout756 VDD VDD VSS VSS _4264_/A _2717_/S gf180mcu_as_sc_mcu7t3v3__buff_2
Xfanout767 VDD VDD VSS VSS _4447_/S _4341_/S gf180mcu_as_sc_mcu7t3v3__buff_2
X_4389_ VDD VDD VSS VSS _5165_/Q _4592_/B _4389_/C _4389_/D _5165_/D gf180mcu_as_sc_mcu7t3v3__ao211_2
XTAP_TAPCELL_ROW_103_1_1049 VDD VSS gf180mcu_as_sc_mcu7t3v3__tap_2
XFILLER_105_55 VDD VDD VSS VSS gf180mcu_as_sc_mcu7t3v3__fill_2
XFILLER_115_1467 VDD VDD VSS VSS gf180mcu_as_sc_mcu7t3v3__fillcap_16
Xfanout778 VDD VDD VSS VSS _5094_/Q _4536_/S gf180mcu_as_sc_mcu7t3v3__buff_2
Xfanout789 VDD VDD VSS VSS _2394_/Y _3907_/A gf180mcu_as_sc_mcu7t3v3__buff_2
XTAP_TAPCELL_ROW_132_3_2547 VDD VSS gf180mcu_as_sc_mcu7t3v3__tap_2
XFILLER_105_88 VDD VDD VSS VSS gf180mcu_as_sc_mcu7t3v3__fillcap_4
XFILLER_85_275 VDD VDD VSS VSS gf180mcu_as_sc_mcu7t3v3__fillcap_4
XFILLER_121_10 VDD VDD VSS VSS gf180mcu_as_sc_mcu7t3v3__fillcap_4
XFILLER_45_139 VDD VDD VSS VSS gf180mcu_as_sc_mcu7t3v3__fill_1
XFILLER_148_1221 VDD VDD VSS VSS gf180mcu_as_sc_mcu7t3v3__fillcap_4
XFILLER_121_65 VDD VDD VSS VSS gf180mcu_as_sc_mcu7t3v3__fillcap_4
XFILLER_144_1107 VDD VDD VSS VSS gf180mcu_as_sc_mcu7t3v3__fill_2
XFILLER_159_509 VDD VDD VSS VSS gf180mcu_as_sc_mcu7t3v3__fillcap_8
XFILLER_74_1451 VDD VDD VSS VSS gf180mcu_as_sc_mcu7t3v3__fillcap_16
XTAP_TAPCELL_ROW_98_3_2497 VDD VSS gf180mcu_as_sc_mcu7t3v3__tap_2
XTAP_TAPCELL_ROW_175_2112 VDD VSS gf180mcu_as_sc_mcu7t3v3__tap_2
XTAP_TAPCELL_ROW_175_2101 VDD VSS gf180mcu_as_sc_mcu7t3v3__tap_2
XFILLER_139_200 VDD VDD VSS VSS gf180mcu_as_sc_mcu7t3v3__fillcap_8
XFILLER_14_85 VDD VDD VSS VSS gf180mcu_as_sc_mcu7t3v3__fillcap_16
XFILLER_161_1465 VDD VDD VSS VSS gf180mcu_as_sc_mcu7t3v3__fillcap_4
XPHY_EDGE_ROW_111_1_Right_110 VDD VSS gf180mcu_as_sc_mcu7t3v3__tap_2
XTAP_TAPCELL_ROW_171_2009 VDD VSS gf180mcu_as_sc_mcu7t3v3__tap_2
XFILLER_154_225 VDD VDD VSS VSS gf180mcu_as_sc_mcu7t3v3__fillcap_16
XFILLER_154_247 VDD VDD VSS VSS gf180mcu_as_sc_mcu7t3v3__fillcap_4
XFILLER_135_494 VDD VDD VSS VSS gf180mcu_as_sc_mcu7t3v3__fill_1
XTAP_TAPCELL_ROW_67_1_902 VDD VSS gf180mcu_as_sc_mcu7t3v3__tap_2
XTAP_TAPCELL_ROW_134_1196 VDD VSS gf180mcu_as_sc_mcu7t3v3__tap_2
XTAP_TAPCELL_ROW_134_1185 VDD VSS gf180mcu_as_sc_mcu7t3v3__tap_2
XTAP_TAPCELL_ROW_134_1174 VDD VSS gf180mcu_as_sc_mcu7t3v3__tap_2
XFILLER_122_144 VDD VDD VSS VSS gf180mcu_as_sc_mcu7t3v3__fill_1
XFILLER_150_475 VDD VDD VSS VSS gf180mcu_as_sc_mcu7t3v3__fill_1
XFILLER_151_998 VDD VDD VSS VSS gf180mcu_as_sc_mcu7t3v3__fillcap_16
XPHY_EDGE_ROW_22_3_Left_156 VDD VSS gf180mcu_as_sc_mcu7t3v3__tap_2
XFILLER_122_177 VDD VDD VSS VSS gf180mcu_as_sc_mcu7t3v3__fillcap_16
XFILLER_46_1564 VDD VDD VSS VSS gf180mcu_as_sc_mcu7t3v3__fillcap_4
XFILLER_81_1499 VDD VDD VSS VSS gf180mcu_as_sc_mcu7t3v3__fillcap_16
XFILLER_149_1029 VDD VDD VSS VSS gf180mcu_as_sc_mcu7t3v3__fillcap_4
XFILLER_36_139 VDD VDD VSS VSS gf180mcu_as_sc_mcu7t3v3__fillcap_8
XFILLER_76_297 VDD VDD VSS VSS gf180mcu_as_sc_mcu7t3v3__fillcap_4
XFILLER_91_212 VDD VDD VSS VSS gf180mcu_as_sc_mcu7t3v3__fillcap_4
XTAP_TAPCELL_ROW_164_1871 VDD VSS gf180mcu_as_sc_mcu7t3v3__tap_2
XTAP_TAPCELL_ROW_164_1860 VDD VSS gf180mcu_as_sc_mcu7t3v3__tap_2
XTAP_TAPCELL_ROW_160_1779 VDD VSS gf180mcu_as_sc_mcu7t3v3__tap_2
XTAP_TAPCELL_ROW_160_1768 VDD VSS gf180mcu_as_sc_mcu7t3v3__tap_2
XFILLER_92_1551 VDD VDD VSS VSS gf180mcu_as_sc_mcu7t3v3__fill_2
X_3760_ VDD VDD VSS VSS _4141_/A _3802_/C _3760_/C _4864_/D _3825_/C gf180mcu_as_sc_mcu7t3v3__aoi211_2
XFILLER_140_1527 VDD VDD VSS VSS gf180mcu_as_sc_mcu7t3v3__fillcap_8
XFILLER_71_80 VDD VDD VSS VSS gf180mcu_as_sc_mcu7t3v3__fillcap_8
X_2711_ VDD VDD VSS VSS _2711_/S _4961_/Q _4970_/Q _2713_/A gf180mcu_as_sc_mcu7t3v3__mux2_2
XFILLER_158_597 VDD VDD VSS VSS gf180mcu_as_sc_mcu7t3v3__fillcap_4
X_3691_ VDD VDD VSS VSS _3691_/D _3730_/A _3691_/B _3691_/C _3692_/C gf180mcu_as_sc_mcu7t3v3__ao31_2
XPHY_EDGE_ROW_121_3_Right_440 VDD VSS gf180mcu_as_sc_mcu7t3v3__tap_2
X_2642_ VDD VDD VSS VSS _2650_/C _2737_/A _2736_/B input6/Y gf180mcu_as_sc_mcu7t3v3__aoi21_2
XFILLER_173_578 VDD VDD VSS VSS gf180mcu_as_sc_mcu7t3v3__fill_2
Xoutput326 VDD VDD VSS VSS _4849_/Q east_out[10] gf180mcu_as_sc_mcu7t3v3__buff_2
X_2573_ VDD VDD VSS VSS _5156_/Q _5155_/Q _4338_/A gf180mcu_as_sc_mcu7t3v3__or2_2
XFILLER_138_1434 VDD VDD VSS VSS gf180mcu_as_sc_mcu7t3v3__fill_1
XFILLER_142_932 VDD VDD VSS VSS gf180mcu_as_sc_mcu7t3v3__fillcap_8
XFILLER_177_1472 VDD VDD VSS VSS gf180mcu_as_sc_mcu7t3v3__fillcap_8
Xoutput359 VDD VDD VSS VSS _4771_/Q se_out[0] gf180mcu_as_sc_mcu7t3v3__buff_2
Xoutput348 VDD VDD VSS VSS _4869_/Q east_out[30] gf180mcu_as_sc_mcu7t3v3__buff_2
Xoutput337 VDD VDD VSS VSS _4859_/Q east_out[20] gf180mcu_as_sc_mcu7t3v3__buff_2
X_4312_ VDD VDD VSS VSS _4313_/S _5142_/Q _5141_/Q _5141_/D gf180mcu_as_sc_mcu7t3v3__mux2_2
XFILLER_113_144 VDD VDD VSS VSS gf180mcu_as_sc_mcu7t3v3__fill_1
XFILLER_142_976 VDD VDD VSS VSS gf180mcu_as_sc_mcu7t3v3__fillcap_16
X_4243_ VDD VDD VSS VSS _4250_/S _4243_/B _5079_/Q _5079_/D gf180mcu_as_sc_mcu7t3v3__mux2_2
XFILLER_113_188 VDD VDD VSS VSS gf180mcu_as_sc_mcu7t3v3__fillcap_16
X_4174_ VDD VDD VSS VSS _4234_/B _4188_/B _4188_/C _5012_/Q _5012_/D gf180mcu_as_sc_mcu7t3v3__ao22_2
X_3125_ VDD VDD VSS VSS _4104_/A _3125_/B _3125_/C _4104_/D _3131_/B gf180mcu_as_sc_mcu7t3v3__ao22_2
X_3056_ VDD VDD VSS VSS _3124_/B _3056_/B _3056_/C _3057_/C gf180mcu_as_sc_mcu7t3v3__nor3_2
XFILLER_97_1451 VDD VDD VSS VSS gf180mcu_as_sc_mcu7t3v3__fillcap_16
XFILLER_3_1499 VDD VDD VSS VSS gf180mcu_as_sc_mcu7t3v3__fillcap_16
XFILLER_168_317 VDD VDD VSS VSS gf180mcu_as_sc_mcu7t3v3__fillcap_16
XFILLER_137_704 VDD VDD VSS VSS gf180mcu_as_sc_mcu7t3v3__fill_1
XFILLER_143_1162 VDD VDD VSS VSS gf180mcu_as_sc_mcu7t3v3__fill_1
XFILLER_149_553 VDD VDD VSS VSS gf180mcu_as_sc_mcu7t3v3__fillcap_4
X_3958_ VDD VDD VSS VSS _4101_/C _3958_/A _3960_/C gf180mcu_as_sc_mcu7t3v3__and2_2
XFILLER_177_884 VDD VDD VSS VSS gf180mcu_as_sc_mcu7t3v3__fillcap_8
XFILLER_178_1203 VDD VDD VSS VSS gf180mcu_as_sc_mcu7t3v3__fillcap_8
X_3889_ VDD VDD VSS VSS _4946_/D _5179_/Q _4929_/D gf180mcu_as_sc_mcu7t3v3__and2_2
X_2909_ VDD VDD VSS VSS _3202_/B _3537_/A _2909_/Y gf180mcu_as_sc_mcu7t3v3__and2_2
XFILLER_136_247 VDD VDD VSS VSS gf180mcu_as_sc_mcu7t3v3__fillcap_16
XFILLER_151_206 VDD VDD VSS VSS gf180mcu_as_sc_mcu7t3v3__fillcap_4
XFILLER_69_1553 VDD VDD VSS VSS gf180mcu_as_sc_mcu7t3v3__fillcap_16
XFILLER_104_111 VDD VDD VSS VSS gf180mcu_as_sc_mcu7t3v3__fill_1
XFILLER_151_228 VDD VDD VSS VSS gf180mcu_as_sc_mcu7t3v3__fillcap_16
XFILLER_156_1523 VDD VDD VSS VSS gf180mcu_as_sc_mcu7t3v3__fillcap_16
XFILLER_183_16 VDD VDD VSS VSS gf180mcu_as_sc_mcu7t3v3__fillcap_16
XFILLER_116_10 VDD VDD VSS VSS gf180mcu_as_sc_mcu7t3v3__fillcap_4
XFILLER_104_177 VDD VDD VSS VSS gf180mcu_as_sc_mcu7t3v3__fillcap_16
Xfanout520 VDD VDD VSS VSS _4574_/B _4565_/B gf180mcu_as_sc_mcu7t3v3__buff_2
Xfanout531 VDD VDD VSS VSS _4115_/B _4141_/B gf180mcu_as_sc_mcu7t3v3__buff_2
Xfanout542 VDD VDD VSS VSS fanout543/Y _3744_/B gf180mcu_as_sc_mcu7t3v3__buff_2
Xfanout553 VDD VDD VSS VSS _3278_/Y fanout553/Y gf180mcu_as_sc_mcu7t3v3__buff_2
Xfanout564 VDD VDD VSS VSS _4168_/Y _4192_/C gf180mcu_as_sc_mcu7t3v3__buff_2
Xfanout575 VDD VDD VSS VSS _3874_/Y _3897_/B gf180mcu_as_sc_mcu7t3v3__buff_2
XFILLER_58_253 VDD VDD VSS VSS gf180mcu_as_sc_mcu7t3v3__fill_1
XFILLER_76_69 VDD VDD VSS VSS gf180mcu_as_sc_mcu7t3v3__fill_1
Xfanout586 VDD VDD VSS VSS _2852_/Y _4373_/D gf180mcu_as_sc_mcu7t3v3__buff_2
Xfanout597 VDD VDD VSS VSS _3924_/Y fanout597/Y gf180mcu_as_sc_mcu7t3v3__buff_2
XFILLER_18_139 VDD VDD VSS VSS gf180mcu_as_sc_mcu7t3v3__fillcap_16
XFILLER_41_1483 VDD VDD VSS VSS gf180mcu_as_sc_mcu7t3v3__fillcap_16
XFILLER_76_1502 VDD VDD VSS VSS gf180mcu_as_sc_mcu7t3v3__fillcap_16
XFILLER_76_1568 VDD VDD VSS VSS gf180mcu_as_sc_mcu7t3v3__fill_1
XFILLER_41_142 VDD VDD VSS VSS gf180mcu_as_sc_mcu7t3v3__fill_2
XFILLER_161_1262 VDD VDD VSS VSS gf180mcu_as_sc_mcu7t3v3__fillcap_8
XFILLER_127_214 VDD VDD VSS VSS gf180mcu_as_sc_mcu7t3v3__fill_1
XFILLER_41_72 VDD VDD VSS VSS gf180mcu_as_sc_mcu7t3v3__fillcap_16
XPHY_EDGE_ROW_112_1_Right_111 VDD VSS gf180mcu_as_sc_mcu7t3v3__tap_2
Xclkbuf_leaf_21_clk_regs VDD VDD VSS VSS clkbuf_3_7_0_clk_regs/Y _4867_/CLK gf180mcu_as_sc_mcu7t3v3__clkbuff_12
XTAP_TAPCELL_ROW_136_1258 VDD VSS gf180mcu_as_sc_mcu7t3v3__tap_2
XTAP_TAPCELL_ROW_136_1247 VDD VSS gf180mcu_as_sc_mcu7t3v3__tap_2
XFILLER_157_72 VDD VDD VSS VSS gf180mcu_as_sc_mcu7t3v3__fillcap_16
XFILLER_170_537 VDD VDD VSS VSS gf180mcu_as_sc_mcu7t3v3__fill_1
XPHY_EDGE_ROW_21_1_Right_20 VDD VSS gf180mcu_as_sc_mcu7t3v3__tap_2
XFILLER_44_8 VDD VDD VSS VSS gf180mcu_as_sc_mcu7t3v3__fill_2
XFILLER_110_103 VDD VDD VSS VSS gf180mcu_as_sc_mcu7t3v3__fill_2
XTAP_TAPCELL_ROW_49_1_831 VDD VSS gf180mcu_as_sc_mcu7t3v3__tap_2
XTAP_TAPCELL_ROW_166_1900 VDD VSS gf180mcu_as_sc_mcu7t3v3__tap_2
XFILLER_155_1099 VDD VDD VSS VSS gf180mcu_as_sc_mcu7t3v3__fillcap_16
XFILLER_1_282 VDD VDD VSS VSS gf180mcu_as_sc_mcu7t3v3__fill_1
XTAP_TAPCELL_ROW_166_1911 VDD VSS gf180mcu_as_sc_mcu7t3v3__tap_2
XFILLER_66_80 VDD VDD VSS VSS gf180mcu_as_sc_mcu7t3v3__fillcap_16
XTAP_TAPCELL_ROW_162_1819 VDD VSS gf180mcu_as_sc_mcu7t3v3__tap_2
XFILLER_20_1534 VDD VDD VSS VSS gf180mcu_as_sc_mcu7t3v3__fillcap_16
XFILLER_20_1556 VDD VDD VSS VSS gf180mcu_as_sc_mcu7t3v3__fillcap_8
XFILLER_166_1140 VDD VDD VSS VSS gf180mcu_as_sc_mcu7t3v3__fill_2
X_4930_ VDD VDD VSS VSS _5088_/CLK _4930_/D _4930_/Q gf180mcu_as_sc_mcu7t3v3__dfxtp_2
XFILLER_166_1173 VDD VDD VSS VSS gf180mcu_as_sc_mcu7t3v3__fillcap_8
X_4861_ VDD VDD VSS VSS _4863_/CLK _4861_/D _4861_/Q gf180mcu_as_sc_mcu7t3v3__dfxtp_2
XFILLER_177_136 VDD VDD VSS VSS gf180mcu_as_sc_mcu7t3v3__fillcap_4
X_3812_ VDD VDD VSS VSS _3812_/B _3812_/A _3931_/A gf180mcu_as_sc_mcu7t3v3__and2_2
XFILLER_177_158 VDD VDD VSS VSS gf180mcu_as_sc_mcu7t3v3__fillcap_16
X_4792_ VDD VDD VSS VSS _4858_/CLK _4792_/D _4792_/Q gf180mcu_as_sc_mcu7t3v3__dfxtp_2
XFILLER_140_1313 VDD VDD VSS VSS gf180mcu_as_sc_mcu7t3v3__fillcap_16
XFILLER_158_372 VDD VDD VSS VSS gf180mcu_as_sc_mcu7t3v3__fill_2
XFILLER_159_884 VDD VDD VSS VSS gf180mcu_as_sc_mcu7t3v3__fillcap_8
X_3743_ VDD VDD VSS VSS _3744_/C _4118_/A _3743_/B _3743_/C gf180mcu_as_sc_mcu7t3v3__ao21_2
XFILLER_105_1499 VDD VDD VSS VSS gf180mcu_as_sc_mcu7t3v3__fillcap_16
XFILLER_118_247 VDD VDD VSS VSS gf180mcu_as_sc_mcu7t3v3__fillcap_8
XFILLER_140_1379 VDD VDD VSS VSS gf180mcu_as_sc_mcu7t3v3__fill_1
X_3674_ VDD VDD VSS VSS _4046_/A _3781_/S _3674_/C _3674_/D _3675_/D gf180mcu_as_sc_mcu7t3v3__ao211_2
XPHY_EDGE_ROW_7_3_Left_141 VDD VSS gf180mcu_as_sc_mcu7t3v3__tap_2
XPHY_EDGE_ROW_122_3_Right_441 VDD VSS gf180mcu_as_sc_mcu7t3v3__tap_2
X_2625_ VDD VDD VSS VSS _2673_/B _5127_/Q _5191_/Q _2626_/B gf180mcu_as_sc_mcu7t3v3__mux2_2
XFILLER_138_1253 VDD VDD VSS VSS gf180mcu_as_sc_mcu7t3v3__fillcap_16
XFILLER_173_1133 VDD VDD VSS VSS gf180mcu_as_sc_mcu7t3v3__fill_2
XFILLER_177_1280 VDD VDD VSS VSS gf180mcu_as_sc_mcu7t3v3__fill_1
XFILLER_99_142 VDD VDD VSS VSS gf180mcu_as_sc_mcu7t3v3__fill_2
X_2556_ VDD VDD VSS VSS _4956_/Q _4754_/Q _2556_/B _4705_/A _2558_/C gf180mcu_as_sc_mcu7t3v3__ao31_2
XFILLER_134_1106 VDD VDD VSS VSS gf180mcu_as_sc_mcu7t3v3__fillcap_16
XFILLER_138_1297 VDD VDD VSS VSS gf180mcu_as_sc_mcu7t3v3__fillcap_16
X_5275_ VDD VDD VSS VSS clkload5/A _5275_/D _5275_/Q gf180mcu_as_sc_mcu7t3v3__dfxtp_2
X_2487_ VDD VDD VSS VSS _2558_/A _2747_/B _2840_/A _2806_/D _2534_/B gf180mcu_as_sc_mcu7t3v3__ao31_2
XFILLER_64_1483 VDD VDD VSS VSS gf180mcu_as_sc_mcu7t3v3__fill_1
X_4226_ VDD VDD VSS VSS _4255_/B _4228_/B _4228_/C _5062_/Q _5062_/D gf180mcu_as_sc_mcu7t3v3__ao22_2
XFILLER_101_158 VDD VDD VSS VSS gf180mcu_as_sc_mcu7t3v3__fillcap_8
XFILLER_25_1467 VDD VDD VSS VSS gf180mcu_as_sc_mcu7t3v3__fillcap_16
X_4157_ VDD VDD VSS VSS _4157_/B _4165_/A _4256_/B gf180mcu_as_sc_mcu7t3v3__and2_2
X_3108_ VDD VDD VSS VSS _3115_/B _3130_/B _4089_/A gf180mcu_as_sc_mcu7t3v3__nand2_2
X_4088_ VDD VDD VSS VSS _4088_/A _4103_/B _4101_/C _4088_/D _4089_/D gf180mcu_as_sc_mcu7t3v3__ao22_2
XFILLER_102_34 VDD VDD VSS VSS gf180mcu_as_sc_mcu7t3v3__fill_1
X_3039_ VDD VDD VSS VSS _3040_/C _3039_/C _3125_/C _4016_/D gf180mcu_as_sc_mcu7t3v3__aoi21_2
XFILLER_145_1224 VDD VDD VSS VSS gf180mcu_as_sc_mcu7t3v3__fillcap_4
XFILLER_149_1382 VDD VDD VSS VSS gf180mcu_as_sc_mcu7t3v3__fillcap_16
XFILLER_23_120 VDD VDD VSS VSS gf180mcu_as_sc_mcu7t3v3__fillcap_8
XFILLER_62_27 VDD VDD VSS VSS gf180mcu_as_sc_mcu7t3v3__fillcap_8
XFILLER_70_237 VDD VDD VSS VSS gf180mcu_as_sc_mcu7t3v3__fillcap_8
XTAP_TAPCELL_ROW_66_1_901 VDD VSS gf180mcu_as_sc_mcu7t3v3__tap_2
XFILLER_23_142 VDD VDD VSS VSS gf180mcu_as_sc_mcu7t3v3__fillcap_16
XFILLER_177_670 VDD VDD VSS VSS gf180mcu_as_sc_mcu7t3v3__fillcap_8
XTAP_TAPCELL_ROW_32_3_2397 VDD VSS gf180mcu_as_sc_mcu7t3v3__tap_2
XFILLER_164_364 VDD VDD VSS VSS gf180mcu_as_sc_mcu7t3v3__fillcap_16
XFILLER_124_239 VDD VDD VSS VSS gf180mcu_as_sc_mcu7t3v3__fillcap_4
XTAP_TAPCELL_ROW_120_3_2529 VDD VSS gf180mcu_as_sc_mcu7t3v3__tap_2
XTAP_TAPCELL_ROW_89_1_991 VDD VSS gf180mcu_as_sc_mcu7t3v3__tap_2
XFILLER_152_1217 VDD VDD VSS VSS gf180mcu_as_sc_mcu7t3v3__fillcap_8
XFILLER_156_1364 VDD VDD VSS VSS gf180mcu_as_sc_mcu7t3v3__fill_1
XFILLER_82_1550 VDD VDD VSS VSS gf180mcu_as_sc_mcu7t3v3__fillcap_4
XFILLER_87_35 VDD VDD VSS VSS gf180mcu_as_sc_mcu7t3v3__fill_2
XFILLER_87_68 VDD VDD VSS VSS gf180mcu_as_sc_mcu7t3v3__fill_2
XTAP_TAPCELL_ROW_183_2277 VDD VSS gf180mcu_as_sc_mcu7t3v3__tap_2
XFILLER_143_96 VDD VDD VSS VSS gf180mcu_as_sc_mcu7t3v3__fillcap_4
XTAP_TAPCELL_ROW_86_3_2479 VDD VSS gf180mcu_as_sc_mcu7t3v3__tap_2
XTAP_TAPCELL_ROW_183_2288 VDD VSS gf180mcu_as_sc_mcu7t3v3__tap_2
XTAP_TAPCELL_ROW_0_3_2348 VDD VSS gf180mcu_as_sc_mcu7t3v3__tap_2
XFILLER_61_204 VDD VDD VSS VSS gf180mcu_as_sc_mcu7t3v3__fillcap_4
XFILLER_163_1346 VDD VDD VSS VSS gf180mcu_as_sc_mcu7t3v3__fill_1
XFILLER_159_136 VDD VDD VSS VSS gf180mcu_as_sc_mcu7t3v3__fillcap_4
XFILLER_159_158 VDD VDD VSS VSS gf180mcu_as_sc_mcu7t3v3__fillcap_16
XFILLER_175_629 VDD VDD VSS VSS gf180mcu_as_sc_mcu7t3v3__fill_1
XFILLER_155_320 VDD VDD VSS VSS gf180mcu_as_sc_mcu7t3v3__fill_1
XFILLER_168_692 VDD VDD VSS VSS gf180mcu_as_sc_mcu7t3v3__fillcap_8
XFILLER_174_139 VDD VDD VSS VSS gf180mcu_as_sc_mcu7t3v3__fillcap_16
Xinput14 VDD VDD VSS VSS boot_data[2] _2700_/A gf180mcu_as_sc_mcu7t3v3__buff_2
Xinput25 VDD VDD VSS VSS dft_addr[2] _2629_/B gf180mcu_as_sc_mcu7t3v3__buff_2
Xwire740 VDD VDD VSS VSS _2744_/Y _5485_/A gf180mcu_as_sc_mcu7t3v3__clkbuff_12
Xinput36 VDD VDD VSS VSS dft_wdata[1] _2693_/B gf180mcu_as_sc_mcu7t3v3__buff_2
XTAP_TAPCELL_ROW_155_1656 VDD VSS gf180mcu_as_sc_mcu7t3v3__tap_2
XFILLER_157_1106 VDD VDD VSS VSS gf180mcu_as_sc_mcu7t3v3__fill_2
XFILLER_171_813 VDD VDD VSS VSS gf180mcu_as_sc_mcu7t3v3__fillcap_8
XPHY_EDGE_ROW_113_1_Right_112 VDD VSS gf180mcu_as_sc_mcu7t3v3__tap_2
Xinput69 VDD VDD VSS VSS east_in[32] _3517_/A gf180mcu_as_sc_mcu7t3v3__buff_2
Xinput58 VDD VDD VSS VSS east_in[22] _4113_/A gf180mcu_as_sc_mcu7t3v3__buff_2
Xinput47 VDD VDD VSS VSS east_in[12] _4030_/D gf180mcu_as_sc_mcu7t3v3__buff_2
XTAP_TAPCELL_ROW_1_1_638 VDD VSS gf180mcu_as_sc_mcu7t3v3__tap_2
XTAP_TAPCELL_ROW_155_1667 VDD VSS gf180mcu_as_sc_mcu7t3v3__tap_2
XPHY_EDGE_ROW_149_Right_283 VDD VSS gf180mcu_as_sc_mcu7t3v3__tap_2
X_2410_ VDD VDD VSS VSS _4370_/A _5161_/Q gf180mcu_as_sc_mcu7t3v3__inv_2
XFILLER_174_1431 VDD VDD VSS VSS gf180mcu_as_sc_mcu7t3v3__fillcap_4
XFILLER_184_70 VDD VDD VSS VSS gf180mcu_as_sc_mcu7t3v3__fillcap_16
XFILLER_87_1483 VDD VDD VSS VSS gf180mcu_as_sc_mcu7t3v3__fillcap_16
X_3390_ VDD VDD VSS VSS _4038_/A _3467_/C _3469_/B _4041_/A _3391_/C gf180mcu_as_sc_mcu7t3v3__ao22_2
XFILLER_151_570 VDD VDD VSS VSS gf180mcu_as_sc_mcu7t3v3__fillcap_4
XFILLER_174_1464 VDD VDD VSS VSS gf180mcu_as_sc_mcu7t3v3__fillcap_16
XFILLER_48_1467 VDD VDD VSS VSS gf180mcu_as_sc_mcu7t3v3__fillcap_16
XFILLER_96_134 VDD VDD VSS VSS gf180mcu_as_sc_mcu7t3v3__fillcap_8
X_5060_ VDD VDD VSS VSS _5094_/CLK _5060_/D _5060_/Q gf180mcu_as_sc_mcu7t3v3__dfxtp_2
X_4011_ VDD VDD VSS VSS _4011_/B _4165_/A _4238_/B gf180mcu_as_sc_mcu7t3v3__and2_2
XFILLER_37_212 VDD VDD VSS VSS gf180mcu_as_sc_mcu7t3v3__fillcap_16
XFILLER_4_1550 VDD VDD VSS VSS gf180mcu_as_sc_mcu7t3v3__fillcap_4
XFILLER_146_1522 VDD VDD VSS VSS gf180mcu_as_sc_mcu7t3v3__fill_1
X_4913_ VDD VDD VSS VSS _5159_/CLK _4913_/D _4913_/Q gf180mcu_as_sc_mcu7t3v3__dfxtp_2
XFILLER_179_946 VDD VDD VSS VSS gf180mcu_as_sc_mcu7t3v3__fill_2
XFILLER_179_979 VDD VDD VSS VSS gf180mcu_as_sc_mcu7t3v3__fill_1
XFILLER_20_101 VDD VDD VSS VSS gf180mcu_as_sc_mcu7t3v3__fillcap_4
XFILLER_20_123 VDD VDD VSS VSS gf180mcu_as_sc_mcu7t3v3__fillcap_16
X_4844_ VDD VDD VSS VSS _4928_/CLK _4844_/D _4844_/Q gf180mcu_as_sc_mcu7t3v3__dfxtp_2
XFILLER_178_489 VDD VDD VSS VSS gf180mcu_as_sc_mcu7t3v3__fillcap_4
X_4775_ VDD VDD VSS VSS _5052_/CLK _4775_/D _4775_/Q gf180mcu_as_sc_mcu7t3v3__dfxtp_2
XFILLER_140_1154 VDD VDD VSS VSS gf180mcu_as_sc_mcu7t3v3__fill_1
XFILLER_159_692 VDD VDD VSS VSS gf180mcu_as_sc_mcu7t3v3__fillcap_8
X_3726_ VDD VDD VSS VSS _3730_/B _3726_/C _3726_/B _4104_/A gf180mcu_as_sc_mcu7t3v3__aoi21_2
XFILLER_146_353 VDD VDD VSS VSS gf180mcu_as_sc_mcu7t3v3__fillcap_4
XFILLER_179_1364 VDD VDD VSS VSS gf180mcu_as_sc_mcu7t3v3__fillcap_8
XFILLER_9_190 VDD VDD VSS VSS gf180mcu_as_sc_mcu7t3v3__fillcap_16
XFILLER_162_846 VDD VDD VSS VSS gf180mcu_as_sc_mcu7t3v3__fillcap_4
X_3657_ VDD VDD VSS VSS _4030_/A _3717_/B _3657_/C _3657_/D _3658_/C gf180mcu_as_sc_mcu7t3v3__ao211_2
XFILLER_161_356 VDD VDD VSS VSS gf180mcu_as_sc_mcu7t3v3__fill_2
XFILLER_164_18 VDD VDD VSS VSS gf180mcu_as_sc_mcu7t3v3__fillcap_16
XFILLER_66_1534 VDD VDD VSS VSS gf180mcu_as_sc_mcu7t3v3__fillcap_16
XPHY_EDGE_ROW_123_3_Right_442 VDD VSS gf180mcu_as_sc_mcu7t3v3__tap_2
X_3588_ VDD VDD VSS VSS _3741_/C _3958_/A _3590_/C gf180mcu_as_sc_mcu7t3v3__and2_2
X_2608_ VDD VDD VSS VSS _4262_/B _2608_/B _5099_/Q _2609_/B gf180mcu_as_sc_mcu7t3v3__mux2_2
XFILLER_121_209 VDD VDD VSS VSS gf180mcu_as_sc_mcu7t3v3__fill_1
XFILLER_142_581 VDD VDD VSS VSS gf180mcu_as_sc_mcu7t3v3__fill_2
XFILLER_66_1556 VDD VDD VSS VSS gf180mcu_as_sc_mcu7t3v3__fillcap_8
X_2539_ VDD VDD VSS VSS _4366_/S _2539_/B _2539_/A _4372_/D gf180mcu_as_sc_mcu7t3v3__mux2_2
XFILLER_9_1483 VDD VDD VSS VSS gf180mcu_as_sc_mcu7t3v3__fillcap_16
X_5258_ VDD VDD VSS VSS _5266_/CLK _5258_/D _5258_/Q gf180mcu_as_sc_mcu7t3v3__dfxtp_2
X_5189_ VDD VDD VSS VSS _5199_/CLK _5189_/D _5189_/Q gf180mcu_as_sc_mcu7t3v3__dfxtp_2
X_4209_ VDD VDD VSS VSS _4238_/B _4218_/B _4221_/C _5045_/Q _5045_/D gf180mcu_as_sc_mcu7t3v3__ao22_2
XFILLER_113_88 VDD VDD VSS VSS gf180mcu_as_sc_mcu7t3v3__fillcap_4
XFILLER_43_204 VDD VDD VSS VSS gf180mcu_as_sc_mcu7t3v3__fillcap_4
XFILLER_73_37 VDD VDD VSS VSS gf180mcu_as_sc_mcu7t3v3__fill_1
XTAP_TAPCELL_ROW_130_1_1155 VDD VSS gf180mcu_as_sc_mcu7t3v3__tap_2
XPHY_EDGE_ROW_31_3_Left_165 VDD VSS gf180mcu_as_sc_mcu7t3v3__tap_2
Xsram2048.u_bank0_811 VDD VDD VSS VSS sram2048.u_bank0/WEN[1] gf180mcu_as_sc_mcu7t3v3__tiel_4
XFILLER_145_1076 VDD VDD VSS VSS gf180mcu_as_sc_mcu7t3v3__fill_2
XFILLER_184_426 VDD VDD VSS VSS gf180mcu_as_sc_mcu7t3v3__fillcap_16
XFILLER_125_2 VDD VDD VSS VSS gf180mcu_as_sc_mcu7t3v3__fillcap_16
XFILLER_156_139 VDD VDD VSS VSS gf180mcu_as_sc_mcu7t3v3__fillcap_16
XFILLER_22_85 VDD VDD VSS VSS gf180mcu_as_sc_mcu7t3v3__fillcap_16
XTAP_TAPCELL_ROW_110_1_1075 VDD VSS gf180mcu_as_sc_mcu7t3v3__tap_2
XFILLER_138_85 VDD VDD VSS VSS gf180mcu_as_sc_mcu7t3v3__fillcap_16
XFILLER_152_301 VDD VDD VSS VSS gf180mcu_as_sc_mcu7t3v3__fillcap_4
XFILLER_153_857 VDD VDD VSS VSS gf180mcu_as_sc_mcu7t3v3__fillcap_4
XFILLER_158_1415 VDD VDD VSS VSS gf180mcu_as_sc_mcu7t3v3__fillcap_16
XFILLER_158_1437 VDD VDD VSS VSS gf180mcu_as_sc_mcu7t3v3__fill_1
XFILLER_112_209 VDD VDD VSS VSS gf180mcu_as_sc_mcu7t3v3__fillcap_16
XFILLER_152_389 VDD VDD VSS VSS gf180mcu_as_sc_mcu7t3v3__fill_1
XTAP_TAPCELL_ROW_150_1564 VDD VSS gf180mcu_as_sc_mcu7t3v3__tap_2
XTAP_TAPCELL_ROW_150_1553 VDD VSS gf180mcu_as_sc_mcu7t3v3__tap_2
XFILLER_78_134 VDD VDD VSS VSS gf180mcu_as_sc_mcu7t3v3__fillcap_8
XFILLER_120_242 VDD VDD VSS VSS gf180mcu_as_sc_mcu7t3v3__fill_2
XFILLER_19_212 VDD VDD VSS VSS gf180mcu_as_sc_mcu7t3v3__fillcap_16
XFILLER_93_148 VDD VDD VSS VSS gf180mcu_as_sc_mcu7t3v3__fill_1
XFILLER_148_607 VDD VDD VSS VSS gf180mcu_as_sc_mcu7t3v3__fill_2
XFILLER_163_1132 VDD VDD VSS VSS gf180mcu_as_sc_mcu7t3v3__fillcap_8
XFILLER_63_92 VDD VDD VSS VSS gf180mcu_as_sc_mcu7t3v3__fill_2
X_2890_ VDD VDD VSS VSS _3533_/B _3508_/A _3517_/A gf180mcu_as_sc_mcu7t3v3__nor2_2
XTAP_TAPCELL_ROW_157_1707 VDD VSS gf180mcu_as_sc_mcu7t3v3__tap_2
XTAP_TAPCELL_ROW_157_1718 VDD VSS gf180mcu_as_sc_mcu7t3v3__tap_2
XFILLER_106_1550 VDD VDD VSS VSS gf180mcu_as_sc_mcu7t3v3__fillcap_4
XFILLER_141_1430 VDD VDD VSS VSS gf180mcu_as_sc_mcu7t3v3__fill_1
X_4560_ VDD VDD VSS VSS _4561_/D _4560_/B _4587_/A gf180mcu_as_sc_mcu7t3v3__nor2_2
XFILLER_156_662 VDD VDD VSS VSS gf180mcu_as_sc_mcu7t3v3__fill_2
XFILLER_15_1499 VDD VDD VSS VSS gf180mcu_as_sc_mcu7t3v3__fillcap_16
XFILLER_183_470 VDD VDD VSS VSS gf180mcu_as_sc_mcu7t3v3__fillcap_16
XFILLER_183_492 VDD VDD VSS VSS gf180mcu_as_sc_mcu7t3v3__fill_2
XFILLER_6_171 VDD VDD VSS VSS gf180mcu_as_sc_mcu7t3v3__fillcap_4
XPHY_EDGE_ROW_160_Right_294 VDD VSS gf180mcu_as_sc_mcu7t3v3__tap_2
X_4491_ VDD VDD VSS VSS _4491_/D _4587_/A _4491_/B _4491_/C _4492_/B gf180mcu_as_sc_mcu7t3v3__ao31_2
X_3511_ VDD VDD VSS VSS _3511_/A _3520_/B _3511_/C _3511_/D _3512_/C gf180mcu_as_sc_mcu7t3v3__ao211_2
XFILLER_6_193 VDD VDD VSS VSS gf180mcu_as_sc_mcu7t3v3__fillcap_16
XPHY_EDGE_ROW_114_1_Right_113 VDD VSS gf180mcu_as_sc_mcu7t3v3__tap_2
X_3442_ VDD VDD VSS VSS _3442_/B _4096_/A _3443_/D gf180mcu_as_sc_mcu7t3v3__or2_2
XFILLER_103_209 VDD VDD VSS VSS gf180mcu_as_sc_mcu7t3v3__fill_1
XFILLER_171_687 VDD VDD VSS VSS gf180mcu_as_sc_mcu7t3v3__fill_1
X_3373_ VDD VDD VSS VSS _3467_/B _4021_/A _3373_/A _3375_/B gf180mcu_as_sc_mcu7t3v3__mux2_2
XFILLER_174_1283 VDD VDD VSS VSS gf180mcu_as_sc_mcu7t3v3__fill_1
XFILLER_69_134 VDD VDD VSS VSS gf180mcu_as_sc_mcu7t3v3__fillcap_4
X_5112_ VDD VDD VSS VSS _5164_/CLK _5112_/D _5112_/Q gf180mcu_as_sc_mcu7t3v3__dfxtp_2
XFILLER_170_1147 VDD VDD VSS VSS gf180mcu_as_sc_mcu7t3v3__fillcap_8
XFILLER_113_1521 VDD VDD VSS VSS gf180mcu_as_sc_mcu7t3v3__fillcap_16
XFILLER_84_104 VDD VDD VSS VSS gf180mcu_as_sc_mcu7t3v3__fill_1
X_5043_ VDD VDD VSS VSS _5172_/CLK _5043_/D _5043_/Q gf180mcu_as_sc_mcu7t3v3__dfxtp_2
XFILLER_168_1087 VDD VDD VSS VSS gf180mcu_as_sc_mcu7t3v3__fillcap_16
XFILLER_142_1205 VDD VDD VSS VSS gf180mcu_as_sc_mcu7t3v3__fillcap_8
XFILLER_159_18 VDD VDD VSS VSS gf180mcu_as_sc_mcu7t3v3__fillcap_16
XFILLER_167_905 VDD VDD VSS VSS gf180mcu_as_sc_mcu7t3v3__fillcap_4
XFILLER_139_629 VDD VDD VSS VSS gf180mcu_as_sc_mcu7t3v3__fill_1
XFILLER_167_938 VDD VDD VSS VSS gf180mcu_as_sc_mcu7t3v3__fillcap_16
X_4827_ VDD VDD VSS VSS _4863_/CLK _4827_/D _4827_/Q gf180mcu_as_sc_mcu7t3v3__dfxtp_2
XFILLER_147_640 VDD VDD VSS VSS gf180mcu_as_sc_mcu7t3v3__fill_2
X_4758_ VDD VDD VSS VSS clkload1/A _4758_/D _4758_/Q gf180mcu_as_sc_mcu7t3v3__dfxtp_2
XFILLER_135_835 VDD VDD VSS VSS gf180mcu_as_sc_mcu7t3v3__fillcap_4
XFILLER_146_172 VDD VDD VSS VSS gf180mcu_as_sc_mcu7t3v3__fill_2
XFILLER_179_1150 VDD VDD VSS VSS gf180mcu_as_sc_mcu7t3v3__fillcap_8
X_4689_ VDD VDD VSS VSS _4723_/A _4719_/A _4703_/D _4749_/B _4690_/C gf180mcu_as_sc_mcu7t3v3__ao31_2
X_3709_ VDD VDD VSS VSS _3710_/C _4085_/D _3717_/B _3709_/C gf180mcu_as_sc_mcu7t3v3__ao21_2
XFILLER_161_120 VDD VDD VSS VSS gf180mcu_as_sc_mcu7t3v3__fillcap_16
XFILLER_161_142 VDD VDD VSS VSS gf180mcu_as_sc_mcu7t3v3__fillcap_16
XPHY_EDGE_ROW_124_3_Right_443 VDD VSS gf180mcu_as_sc_mcu7t3v3__tap_2
XFILLER_108_88 VDD VDD VSS VSS gf180mcu_as_sc_mcu7t3v3__fillcap_4
XFILLER_68_37 VDD VDD VSS VSS gf180mcu_as_sc_mcu7t3v3__fill_1
XFILLER_124_10 VDD VDD VSS VSS gf180mcu_as_sc_mcu7t3v3__fill_2
Xinput204 VDD VDD VSS VSS se_in[30] _3802_/A gf180mcu_as_sc_mcu7t3v3__buff_2
Xinput215 VDD VDD VSS VSS south_in[0] _3933_/D gf180mcu_as_sc_mcu7t3v3__buff_2
Xinput226 VDD VDD VSS VSS south_in[1] _3941_/A gf180mcu_as_sc_mcu7t3v3__buff_2
XFILLER_102_264 VDD VDD VSS VSS gf180mcu_as_sc_mcu7t3v3__fillcap_4
XFILLER_75_104 VDD VDD VSS VSS gf180mcu_as_sc_mcu7t3v3__fill_2
Xinput237 VDD VDD VSS VSS south_in[2] _3949_/A gf180mcu_as_sc_mcu7t3v3__buff_2
Xinput248 VDD VDD VSS VSS south_in[9] _4007_/A gf180mcu_as_sc_mcu7t3v3__buff_2
Xinput259 VDD VDD VSS VSS sw_in[19] _2441_/A gf180mcu_as_sc_mcu7t3v3__buff_2
XTAP_TAPCELL_ROW_180_2225 VDD VSS gf180mcu_as_sc_mcu7t3v3__tap_2
XTAP_TAPCELL_ROW_180_2214 VDD VSS gf180mcu_as_sc_mcu7t3v3__tap_2
XFILLER_84_47 VDD VDD VSS VSS gf180mcu_as_sc_mcu7t3v3__fill_1
XFILLER_90_107 VDD VDD VSS VSS gf180mcu_as_sc_mcu7t3v3__fillcap_16
XTAP_TAPCELL_ROW_20_3_2379 VDD VSS gf180mcu_as_sc_mcu7t3v3__tap_2
XFILLER_147_1149 VDD VDD VSS VSS gf180mcu_as_sc_mcu7t3v3__fillcap_16
XFILLER_140_97 VDD VDD VSS VSS gf180mcu_as_sc_mcu7t3v3__fillcap_8
XTAP_TAPCELL_ROW_178_2176 VDD VSS gf180mcu_as_sc_mcu7t3v3__tap_2
XTAP_TAPCELL_ROW_178_2165 VDD VSS gf180mcu_as_sc_mcu7t3v3__tap_2
XFILLER_158_938 VDD VDD VSS VSS gf180mcu_as_sc_mcu7t3v3__fillcap_4
XFILLER_164_1485 VDD VDD VSS VSS gf180mcu_as_sc_mcu7t3v3__fillcap_16
XFILLER_184_201 VDD VDD VSS VSS gf180mcu_as_sc_mcu7t3v3__fill_2
XFILLER_184_256 VDD VDD VSS VSS gf180mcu_as_sc_mcu7t3v3__fillcap_4
XFILLER_184_267 VDD VDD VSS VSS gf180mcu_as_sc_mcu7t3v3__fillcap_4
XFILLER_137_161 VDD VDD VSS VSS gf180mcu_as_sc_mcu7t3v3__fill_1
XFILLER_138_695 VDD VDD VSS VSS gf180mcu_as_sc_mcu7t3v3__fill_1
XTAP_TAPCELL_ROW_152_1604 VDD VSS gf180mcu_as_sc_mcu7t3v3__tap_2
XFILLER_165_492 VDD VDD VSS VSS gf180mcu_as_sc_mcu7t3v3__fillcap_4
XFILLER_180_451 VDD VDD VSS VSS gf180mcu_as_sc_mcu7t3v3__fillcap_4
XFILLER_141_838 VDD VDD VSS VSS gf180mcu_as_sc_mcu7t3v3__fill_2
XFILLER_158_1267 VDD VDD VSS VSS gf180mcu_as_sc_mcu7t3v3__fill_2
XFILLER_158_1289 VDD VDD VSS VSS gf180mcu_as_sc_mcu7t3v3__fillcap_4
XFILLER_165_50 VDD VDD VSS VSS gf180mcu_as_sc_mcu7t3v3__fillcap_16
XFILLER_165_72 VDD VDD VSS VSS gf180mcu_as_sc_mcu7t3v3__fillcap_16
XFILLER_180_473 VDD VDD VSS VSS gf180mcu_as_sc_mcu7t3v3__fillcap_8
XFILLER_181_996 VDD VDD VSS VSS gf180mcu_as_sc_mcu7t3v3__fillcap_4
XFILLER_98_218 VDD VDD VSS VSS gf180mcu_as_sc_mcu7t3v3__fill_1
XFILLER_140_348 VDD VDD VSS VSS gf180mcu_as_sc_mcu7t3v3__fillcap_8
XFILLER_3_174 VDD VDD VSS VSS gf180mcu_as_sc_mcu7t3v3__fillcap_16
XFILLER_171_1434 VDD VDD VSS VSS gf180mcu_as_sc_mcu7t3v3__fillcap_8
XFILLER_84_1486 VDD VDD VSS VSS gf180mcu_as_sc_mcu7t3v3__fillcap_16
XFILLER_58_92 VDD VDD VSS VSS gf180mcu_as_sc_mcu7t3v3__fill_1
XFILLER_66_104 VDD VDD VSS VSS gf180mcu_as_sc_mcu7t3v3__fill_1
XFILLER_66_115 VDD VDD VSS VSS gf180mcu_as_sc_mcu7t3v3__fill_1
XFILLER_165_1216 VDD VDD VSS VSS gf180mcu_as_sc_mcu7t3v3__fill_1
XFILLER_169_1374 VDD VDD VSS VSS gf180mcu_as_sc_mcu7t3v3__fill_2
XFILLER_1_1553 VDD VDD VSS VSS gf180mcu_as_sc_mcu7t3v3__fillcap_16
XFILLER_74_91 VDD VDD VSS VSS gf180mcu_as_sc_mcu7t3v3__fill_1
X_3991_ VDD VDD VSS VSS _3991_/A _4159_/B _3991_/C _3991_/D _3993_/C gf180mcu_as_sc_mcu7t3v3__ao211_2
X_2942_ VDD VDD VSS VSS _3526_/B _3817_/C _3817_/A gf180mcu_as_sc_mcu7t3v3__nor2b_2
XFILLER_149_938 VDD VDD VSS VSS gf180mcu_as_sc_mcu7t3v3__fillcap_8
XFILLER_175_212 VDD VDD VSS VSS gf180mcu_as_sc_mcu7t3v3__fillcap_16
XFILLER_88_2 VDD VDD VSS VSS gf180mcu_as_sc_mcu7t3v3__fillcap_16
X_2873_ VDD VDD VSS VSS _4748_/A _4742_/A _2873_/C _2873_/D _4767_/D gf180mcu_as_sc_mcu7t3v3__ao22_2
XFILLER_163_418 VDD VDD VSS VSS gf180mcu_as_sc_mcu7t3v3__fill_2
XFILLER_30_295 VDD VDD VSS VSS gf180mcu_as_sc_mcu7t3v3__fillcap_4
X_4612_ VDD VDD VSS VSS _5206_/Q _4612_/B _4612_/C _5207_/Q _5206_/D gf180mcu_as_sc_mcu7t3v3__ao22_2
XFILLER_128_150 VDD VDD VSS VSS gf180mcu_as_sc_mcu7t3v3__fill_1
XFILLER_157_982 VDD VDD VSS VSS gf180mcu_as_sc_mcu7t3v3__fillcap_16
X_4543_ VDD VDD VSS VSS _4546_/C _4996_/Q _4579_/S gf180mcu_as_sc_mcu7t3v3__nand2b_2
XFILLER_144_643 VDD VDD VSS VSS gf180mcu_as_sc_mcu7t3v3__fillcap_8
XFILLER_176_1323 VDD VDD VSS VSS gf180mcu_as_sc_mcu7t3v3__fill_1
XFILLER_137_1329 VDD VDD VSS VSS gf180mcu_as_sc_mcu7t3v3__fill_1
XFILLER_143_142 VDD VDD VSS VSS gf180mcu_as_sc_mcu7t3v3__fillcap_16
XFILLER_176_1356 VDD VDD VSS VSS gf180mcu_as_sc_mcu7t3v3__fill_1
XFILLER_176_1367 VDD VDD VSS VSS gf180mcu_as_sc_mcu7t3v3__fillcap_8
XFILLER_89_207 VDD VDD VSS VSS gf180mcu_as_sc_mcu7t3v3__fill_2
XPHY_EDGE_ROW_115_1_Right_114 VDD VSS gf180mcu_as_sc_mcu7t3v3__tap_2
X_4474_ VDD VDD VSS VSS _4552_/A _5017_/Q _5046_/Q _4475_/B gf180mcu_as_sc_mcu7t3v3__mux2_2
XFILLER_143_186 VDD VDD VSS VSS gf180mcu_as_sc_mcu7t3v3__fillcap_8
XFILLER_63_1515 VDD VDD VSS VSS gf180mcu_as_sc_mcu7t3v3__fillcap_4
X_3425_ VDD VDD VSS VSS _4933_/Q _3486_/B _3472_/C _4079_/A _3426_/C gf180mcu_as_sc_mcu7t3v3__ao22_2
XFILLER_150_1507 VDD VDD VSS VSS gf180mcu_as_sc_mcu7t3v3__fillcap_4
XFILLER_63_1537 VDD VDD VSS VSS gf180mcu_as_sc_mcu7t3v3__fillcap_16
Xsram2048.u_bank0 _2672_/Y _2668_/Y wire461/Y wire464/Y wire465/Y wire462/Y _2629_/Y
+ wire463/Y wire466/Y hold1009/Y clkbuf_1_1__f_clk/Y wire477/Y wire478/Y wire479/Y
+ wire480/Y _2709_/Y _2702_/Y _2693_/Y _2686_/Y wire512/Y _2744_/A _2743_/A _2742_/A
+ _2741_/A _2740_/A _2739_/A _2738_/A _2478_/A sram2048.u_bank0/VDD sram2048.u_bank0/VSS
+ sram2048.u_bank0/WEN[7] sram2048.u_bank0/WEN[6] sram2048.u_bank0/WEN[5] sram2048.u_bank0/WEN[4]
+ sram2048.u_bank0/WEN[3] sram2048.u_bank0/WEN[2] sram2048.u_bank0/WEN[1] sram2048.u_bank0/WEN[0]
+ _2676_/Y gf180mcu_ocd_ip_sram__sram1024x8m8wm1
X_3356_ VDD VDD VSS VSS _4006_/A _3451_/B _3356_/C _3356_/D _3357_/A gf180mcu_as_sc_mcu7t3v3__ao211_2
XPHY_EDGE_ROW_77_1_Left_529 VDD VSS gf180mcu_as_sc_mcu7t3v3__tap_2
XFILLER_140_893 VDD VDD VSS VSS gf180mcu_as_sc_mcu7t3v3__fill_2
XFILLER_57_104 VDD VDD VSS VSS gf180mcu_as_sc_mcu7t3v3__fillcap_4
X_3287_ VDD VDD VSS VSS _3926_/A _3504_/B _3514_/B _3934_/A _3288_/C gf180mcu_as_sc_mcu7t3v3__ao22_2
XFILLER_57_159 VDD VDD VSS VSS gf180mcu_as_sc_mcu7t3v3__fill_1
X_5026_ VDD VDD VSS VSS _5084_/CLK _5026_/D _5026_/Q gf180mcu_as_sc_mcu7t3v3__dfxtp_2
XFILLER_6_1486 VDD VDD VSS VSS gf180mcu_as_sc_mcu7t3v3__fillcap_16
XFILLER_72_107 VDD VDD VSS VSS gf180mcu_as_sc_mcu7t3v3__fillcap_8
XFILLER_110_34 VDD VDD VSS VSS gf180mcu_as_sc_mcu7t3v3__fill_1
XFILLER_148_1469 VDD VDD VSS VSS gf180mcu_as_sc_mcu7t3v3__fillcap_16
XFILLER_142_1013 VDD VDD VSS VSS gf180mcu_as_sc_mcu7t3v3__fill_2
XFILLER_167_702 VDD VDD VSS VSS gf180mcu_as_sc_mcu7t3v3__fillcap_8
XFILLER_179_562 VDD VDD VSS VSS gf180mcu_as_sc_mcu7t3v3__fillcap_8
XFILLER_80_195 VDD VDD VSS VSS gf180mcu_as_sc_mcu7t3v3__fillcap_4
XFILLER_142_1024 VDD VDD VSS VSS gf180mcu_as_sc_mcu7t3v3__fillcap_8
XFILLER_154_407 VDD VDD VSS VSS gf180mcu_as_sc_mcu7t3v3__fillcap_4
XFILLER_167_768 VDD VDD VSS VSS gf180mcu_as_sc_mcu7t3v3__fill_2
XTAP_TAPCELL_ROW_173_2073 VDD VSS gf180mcu_as_sc_mcu7t3v3__tap_2
XTAP_TAPCELL_ROW_173_2062 VDD VSS gf180mcu_as_sc_mcu7t3v3__tap_2
XFILLER_119_150 VDD VDD VSS VSS gf180mcu_as_sc_mcu7t3v3__fillcap_4
XFILLER_119_65 VDD VDD VSS VSS gf180mcu_as_sc_mcu7t3v3__fillcap_4
XFILLER_134_131 VDD VDD VSS VSS gf180mcu_as_sc_mcu7t3v3__fillcap_4
XFILLER_147_492 VDD VDD VSS VSS gf180mcu_as_sc_mcu7t3v3__fillcap_8
XFILLER_79_14 VDD VDD VSS VSS gf180mcu_as_sc_mcu7t3v3__fill_2
XFILLER_134_142 VDD VDD VSS VSS gf180mcu_as_sc_mcu7t3v3__fill_2
XFILLER_150_624 VDD VDD VSS VSS gf180mcu_as_sc_mcu7t3v3__fill_2
XFILLER_155_1418 VDD VDD VSS VSS gf180mcu_as_sc_mcu7t3v3__fillcap_16
XFILLER_162_473 VDD VDD VSS VSS gf180mcu_as_sc_mcu7t3v3__fill_1
XPHY_EDGE_ROW_90_1_Right_89 VDD VSS gf180mcu_as_sc_mcu7t3v3__tap_2
XFILLER_150_679 VDD VDD VSS VSS gf180mcu_as_sc_mcu7t3v3__fill_2
XFILLER_88_251 VDD VDD VSS VSS gf180mcu_as_sc_mcu7t3v3__fill_1
XPHY_EDGE_ROW_125_3_Right_444 VDD VSS gf180mcu_as_sc_mcu7t3v3__tap_2
XFILLER_0_188 VDD VDD VSS VSS gf180mcu_as_sc_mcu7t3v3__fillcap_16
XFILLER_95_35 VDD VDD VSS VSS gf180mcu_as_sc_mcu7t3v3__fill_2
XFILLER_131_1451 VDD VDD VSS VSS gf180mcu_as_sc_mcu7t3v3__fillcap_16
XTAP_TAPCELL_ROW_145_1441 VDD VSS gf180mcu_as_sc_mcu7t3v3__tap_2
XFILLER_166_1503 VDD VDD VSS VSS gf180mcu_as_sc_mcu7t3v3__fill_2
XFILLER_56_170 VDD VDD VSS VSS gf180mcu_as_sc_mcu7t3v3__fillcap_4
XTAP_TAPCELL_ROW_145_1452 VDD VSS gf180mcu_as_sc_mcu7t3v3__tap_2
XTAP_TAPCELL_ROW_141_1349 VDD VSS gf180mcu_as_sc_mcu7t3v3__tap_2
XTAP_TAPCELL_ROW_126_3_2538 VDD VSS gf180mcu_as_sc_mcu7t3v3__tap_2
XFILLER_164_1293 VDD VDD VSS VSS gf180mcu_as_sc_mcu7t3v3__fill_2
XFILLER_12_295 VDD VDD VSS VSS gf180mcu_as_sc_mcu7t3v3__fillcap_4
XFILLER_145_407 VDD VDD VSS VSS gf180mcu_as_sc_mcu7t3v3__fillcap_4
XFILLER_160_1157 VDD VDD VSS VSS gf180mcu_as_sc_mcu7t3v3__fillcap_4
XFILLER_16_1550 VDD VDD VSS VSS gf180mcu_as_sc_mcu7t3v3__fillcap_4
XFILLER_74_8 VDD VDD VSS VSS gf180mcu_as_sc_mcu7t3v3__fillcap_8
XFILLER_103_1553 VDD VDD VSS VSS gf180mcu_as_sc_mcu7t3v3__fillcap_16
XFILLER_139_982 VDD VDD VSS VSS gf180mcu_as_sc_mcu7t3v3__fillcap_16
XFILLER_138_492 VDD VDD VSS VSS gf180mcu_as_sc_mcu7t3v3__fillcap_16
XFILLER_8_299 VDD VDD VSS VSS gf180mcu_as_sc_mcu7t3v3__fill_2
XFILLER_125_142 VDD VDD VSS VSS gf180mcu_as_sc_mcu7t3v3__fill_2
XFILLER_153_473 VDD VDD VSS VSS gf180mcu_as_sc_mcu7t3v3__fill_1
XFILLER_158_1053 VDD VDD VSS VSS gf180mcu_as_sc_mcu7t3v3__fillcap_4
XPHY_EDGE_ROW_119_3_Left_253 VDD VSS gf180mcu_as_sc_mcu7t3v3__tap_2
XFILLER_141_624 VDD VDD VSS VSS gf180mcu_as_sc_mcu7t3v3__fillcap_4
XFILLER_5_66 VDD VDD VSS VSS gf180mcu_as_sc_mcu7t3v3__fillcap_4
XFILLER_5_88 VDD VDD VSS VSS gf180mcu_as_sc_mcu7t3v3__fillcap_16
X_4190_ VDD VDD VSS VSS _4250_/B _4192_/B _4190_/C _5028_/Q _5028_/D gf180mcu_as_sc_mcu7t3v3__ao22_2
X_3210_ VDD VDD VSS VSS _3210_/B _3535_/A _3213_/B gf180mcu_as_sc_mcu7t3v3__or2_2
XFILLER_79_273 VDD VDD VSS VSS gf180mcu_as_sc_mcu7t3v3__fillcap_4
X_3141_ VDD VDD VSS VSS _4793_/D _3141_/C _3156_/A _4115_/A gf180mcu_as_sc_mcu7t3v3__aoi21_2
XTAP_TAPCELL_ROW_169_1975 VDD VSS gf180mcu_as_sc_mcu7t3v3__tap_2
XTAP_TAPCELL_ROW_169_1964 VDD VSS gf180mcu_as_sc_mcu7t3v3__tap_2
XFILLER_23_1521 VDD VDD VSS VSS gf180mcu_as_sc_mcu7t3v3__fillcap_16
XFILLER_94_221 VDD VDD VSS VSS gf180mcu_as_sc_mcu7t3v3__fillcap_16
XFILLER_110_1502 VDD VDD VSS VSS gf180mcu_as_sc_mcu7t3v3__fillcap_16
XFILLER_54_107 VDD VDD VSS VSS gf180mcu_as_sc_mcu7t3v3__fillcap_16
X_3072_ VDD VDD VSS VSS _3156_/A _3072_/B _3072_/C _3073_/C gf180mcu_as_sc_mcu7t3v3__nor3_2
XFILLER_169_1160 VDD VDD VSS VSS gf180mcu_as_sc_mcu7t3v3__fillcap_4
XFILLER_94_298 VDD VDD VSS VSS gf180mcu_as_sc_mcu7t3v3__fill_2
XFILLER_110_1568 VDD VDD VSS VSS gf180mcu_as_sc_mcu7t3v3__fill_1
XFILLER_62_173 VDD VDD VSS VSS gf180mcu_as_sc_mcu7t3v3__fill_2
XTAP_TAPCELL_ROW_131_1_1160 VDD VSS gf180mcu_as_sc_mcu7t3v3__tap_2
X_3974_ VDD VDD VSS VSS _3974_/A _4102_/B _4102_/C _4920_/Q _3975_/D gf180mcu_as_sc_mcu7t3v3__ao22_2
XFILLER_149_757 VDD VDD VSS VSS gf180mcu_as_sc_mcu7t3v3__fill_2
X_2925_ VDD VDD VSS VSS _3266_/B _3530_/B _3530_/A gf180mcu_as_sc_mcu7t3v3__nor2b_2
XFILLER_108_1486 VDD VDD VSS VSS gf180mcu_as_sc_mcu7t3v3__fillcap_16
XFILLER_143_1366 VDD VDD VSS VSS gf180mcu_as_sc_mcu7t3v3__fillcap_8
XFILLER_143_1388 VDD VDD VSS VSS gf180mcu_as_sc_mcu7t3v3__fillcap_8
X_2856_ VDD VDD VSS VSS _4733_/B _2856_/A _2856_/B _4746_/C gf180mcu_as_sc_mcu7t3v3__ao21_2
XTAP_TAPCELL_ROW_111_1_1080 VDD VSS gf180mcu_as_sc_mcu7t3v3__tap_2
XFILLER_145_963 VDD VDD VSS VSS gf180mcu_as_sc_mcu7t3v3__fillcap_16
X_2787_ VDD VDD VSS VSS _5126_/Q _5157_/Q _5173_/Q _2789_/B gf180mcu_as_sc_mcu7t3v3__mux2_2
XFILLER_116_142 VDD VDD VSS VSS gf180mcu_as_sc_mcu7t3v3__fillcap_4
XFILLER_144_473 VDD VDD VSS VSS gf180mcu_as_sc_mcu7t3v3__fillcap_8
XFILLER_172_760 VDD VDD VSS VSS gf180mcu_as_sc_mcu7t3v3__fillcap_16
X_4526_ VDD VDD VSS VSS _4529_/C _4994_/Q _4559_/S gf180mcu_as_sc_mcu7t3v3__nand2b_2
XFILLER_116_197 VDD VDD VSS VSS gf180mcu_as_sc_mcu7t3v3__fill_2
XFILLER_137_1126 VDD VDD VSS VSS gf180mcu_as_sc_mcu7t3v3__fill_1
XFILLER_160_944 VDD VDD VSS VSS gf180mcu_as_sc_mcu7t3v3__fill_1
XFILLER_172_1017 VDD VDD VSS VSS gf180mcu_as_sc_mcu7t3v3__fillcap_4
X_4457_ VDD VDD VSS VSS _4458_/D _4457_/B _4587_/A gf180mcu_as_sc_mcu7t3v3__nor2_2
XFILLER_131_134 VDD VDD VSS VSS gf180mcu_as_sc_mcu7t3v3__fillcap_4
XFILLER_172_18 VDD VDD VSS VSS gf180mcu_as_sc_mcu7t3v3__fillcap_16
XFILLER_49_39 VDD VDD VSS VSS gf180mcu_as_sc_mcu7t3v3__fill_2
XPHY_EDGE_ROW_116_1_Right_115 VDD VSS gf180mcu_as_sc_mcu7t3v3__tap_2
Xfanout702 VDD VDD VSS VSS _3169_/C _3236_/C gf180mcu_as_sc_mcu7t3v3__buff_2
Xfanout713 VDD VDD VSS VSS _3153_/D _3145_/D gf180mcu_as_sc_mcu7t3v3__buff_2
Xfanout724 VDD VDD VSS VSS _3152_/B _3127_/B gf180mcu_as_sc_mcu7t3v3__buff_2
X_3408_ VDD VDD VSS VSS _3684_/A _3455_/B _3408_/C _4820_/D _3730_/D gf180mcu_as_sc_mcu7t3v3__aoi211_2
Xfanout735 VDD VDD VSS VSS _2852_/B _2673_/B gf180mcu_as_sc_mcu7t3v3__buff_2
Xfanout746 VDD VDD VSS VSS _2815_/A _2833_/A gf180mcu_as_sc_mcu7t3v3__buff_2
Xfanout757 VDD VDD VSS VSS _5098_/Q _4264_/A gf180mcu_as_sc_mcu7t3v3__buff_2
X_4388_ VDD VDD VSS VSS _4388_/B _4591_/A _4389_/D gf180mcu_as_sc_mcu7t3v3__and2_2
XFILLER_150_1348 VDD VDD VSS VSS gf180mcu_as_sc_mcu7t3v3__fillcap_16
XPHY_EDGE_ROW_40_3_Left_174 VDD VSS gf180mcu_as_sc_mcu7t3v3__tap_2
Xfanout768 VDD VDD VSS VSS _4570_/S _4447_/S gf180mcu_as_sc_mcu7t3v3__buff_2
Xfanout779 VDD VDD VSS VSS _4975_/Q _2711_/S gf180mcu_as_sc_mcu7t3v3__buff_2
X_3339_ VDD VDD VSS VSS _3340_/A _3989_/A _3500_/B _3339_/C gf180mcu_as_sc_mcu7t3v3__ao21_2
XTAP_TAPCELL_ROW_132_3_2548 VDD VSS gf180mcu_as_sc_mcu7t3v3__tap_2
XFILLER_65_27 VDD VDD VSS VSS gf180mcu_as_sc_mcu7t3v3__fillcap_16
XFILLER_85_298 VDD VDD VSS VSS gf180mcu_as_sc_mcu7t3v3__fill_2
X_5009_ VDD VDD VSS VSS _5074_/CLK _5009_/D _5009_/Q gf180mcu_as_sc_mcu7t3v3__dfxtp_2
XFILLER_148_1255 VDD VDD VSS VSS gf180mcu_as_sc_mcu7t3v3__fillcap_8
XFILLER_183_1124 VDD VDD VSS VSS gf180mcu_as_sc_mcu7t3v3__fill_1
XFILLER_121_88 VDD VDD VSS VSS gf180mcu_as_sc_mcu7t3v3__fillcap_4
XFILLER_81_37 VDD VDD VSS VSS gf180mcu_as_sc_mcu7t3v3__fill_1
XTAP_TAPCELL_ROW_175_2113 VDD VSS gf180mcu_as_sc_mcu7t3v3__tap_2
XTAP_TAPCELL_ROW_175_2102 VDD VSS gf180mcu_as_sc_mcu7t3v3__tap_2
XFILLER_139_212 VDD VDD VSS VSS gf180mcu_as_sc_mcu7t3v3__fill_1
XFILLER_14_53 VDD VDD VSS VSS gf180mcu_as_sc_mcu7t3v3__fillcap_16
XFILLER_161_1433 VDD VDD VSS VSS gf180mcu_as_sc_mcu7t3v3__fillcap_16
XFILLER_161_1488 VDD VDD VSS VSS gf180mcu_as_sc_mcu7t3v3__fillcap_16
XFILLER_139_278 VDD VDD VSS VSS gf180mcu_as_sc_mcu7t3v3__fill_2
XFILLER_107_142 VDD VDD VSS VSS gf180mcu_as_sc_mcu7t3v3__fillcap_4
XFILLER_182_579 VDD VDD VSS VSS gf180mcu_as_sc_mcu7t3v3__fill_2
XFILLER_122_123 VDD VDD VSS VSS gf180mcu_as_sc_mcu7t3v3__fill_2
XFILLER_30_85 VDD VDD VSS VSS gf180mcu_as_sc_mcu7t3v3__fillcap_16
XTAP_TAPCELL_ROW_67_1_903 VDD VSS gf180mcu_as_sc_mcu7t3v3__tap_2
XTAP_TAPCELL_ROW_134_1197 VDD VSS gf180mcu_as_sc_mcu7t3v3__tap_2
XTAP_TAPCELL_ROW_134_1186 VDD VSS gf180mcu_as_sc_mcu7t3v3__tap_2
XTAP_TAPCELL_ROW_134_1175 VDD VSS gf180mcu_as_sc_mcu7t3v3__tap_2
XFILLER_146_85 VDD VDD VSS VSS gf180mcu_as_sc_mcu7t3v3__fillcap_16
XFILLER_151_977 VDD VDD VSS VSS gf180mcu_as_sc_mcu7t3v3__fill_2
XFILLER_155_1259 VDD VDD VSS VSS gf180mcu_as_sc_mcu7t3v3__fill_1
XFILLER_81_1467 VDD VDD VSS VSS gf180mcu_as_sc_mcu7t3v3__fillcap_16
XPHY_EDGE_ROW_126_3_Right_445 VDD VSS gf180mcu_as_sc_mcu7t3v3__tap_2
XFILLER_39_72 VDD VDD VSS VSS gf180mcu_as_sc_mcu7t3v3__fillcap_16
XFILLER_76_243 VDD VDD VSS VSS gf180mcu_as_sc_mcu7t3v3__fill_2
XFILLER_36_107 VDD VDD VSS VSS gf180mcu_as_sc_mcu7t3v3__fillcap_16
XFILLER_29_170 VDD VDD VSS VSS gf180mcu_as_sc_mcu7t3v3__fillcap_16
XTAP_TAPCELL_ROW_164_1872 VDD VSS gf180mcu_as_sc_mcu7t3v3__tap_2
XTAP_TAPCELL_ROW_164_1861 VDD VSS gf180mcu_as_sc_mcu7t3v3__tap_2
XFILLER_91_279 VDD VDD VSS VSS gf180mcu_as_sc_mcu7t3v3__fill_1
XTAP_TAPCELL_ROW_160_1769 VDD VSS gf180mcu_as_sc_mcu7t3v3__tap_2
XFILLER_162_1208 VDD VDD VSS VSS gf180mcu_as_sc_mcu7t3v3__fillcap_16
XFILLER_158_521 VDD VDD VSS VSS gf180mcu_as_sc_mcu7t3v3__fillcap_4
XFILLER_71_92 VDD VDD VSS VSS gf180mcu_as_sc_mcu7t3v3__fill_2
X_2710_ VDD VDD VSS VSS _2717_/S _5177_/Q _5169_/Q _2714_/B gf180mcu_as_sc_mcu7t3v3__mux2_2
XFILLER_145_204 VDD VDD VSS VSS gf180mcu_as_sc_mcu7t3v3__fillcap_4
X_3690_ VDD VDD VSS VSS _3691_/C _3690_/C _3729_/B _4066_/A gf180mcu_as_sc_mcu7t3v3__aoi21_2
XFILLER_145_226 VDD VDD VSS VSS gf180mcu_as_sc_mcu7t3v3__fill_2
X_2641_ VDD VDD VSS VSS _2832_/S _2641_/B _2641_/A _2641_/Y gf180mcu_as_sc_mcu7t3v3__mux2_2
X_2572_ VDD VDD VSS VSS _4350_/A _5156_/Q _5155_/Q gf180mcu_as_sc_mcu7t3v3__nor2_2
XFILLER_142_944 VDD VDD VSS VSS gf180mcu_as_sc_mcu7t3v3__fill_1
XFILLER_160_229 VDD VDD VSS VSS gf180mcu_as_sc_mcu7t3v3__fill_2
XFILLER_177_1495 VDD VDD VSS VSS gf180mcu_as_sc_mcu7t3v3__fillcap_16
Xoutput349 VDD VDD VSS VSS _4870_/Q east_out[31] gf180mcu_as_sc_mcu7t3v3__buff_2
Xoutput338 VDD VDD VSS VSS _4860_/Q east_out[21] gf180mcu_as_sc_mcu7t3v3__buff_2
Xoutput327 VDD VDD VSS VSS _4850_/Q east_out[11] gf180mcu_as_sc_mcu7t3v3__buff_2
X_4311_ VDD VDD VSS VSS _4313_/S _5141_/Q _5140_/Q _5140_/D gf180mcu_as_sc_mcu7t3v3__mux2_2
XFILLER_113_123 VDD VDD VSS VSS gf180mcu_as_sc_mcu7t3v3__fill_1
XFILLER_113_134 VDD VDD VSS VSS gf180mcu_as_sc_mcu7t3v3__fillcap_4
X_4242_ VDD VDD VSS VSS _4248_/S _4242_/B _5078_/Q _5078_/D gf180mcu_as_sc_mcu7t3v3__mux2_2
XFILLER_141_487 VDD VDD VSS VSS gf180mcu_as_sc_mcu7t3v3__fill_2
XFILLER_60_1518 VDD VDD VSS VSS gf180mcu_as_sc_mcu7t3v3__fillcap_16
X_4173_ VDD VDD VSS VSS _4233_/B _4187_/B _4190_/C _5011_/Q _5011_/D gf180mcu_as_sc_mcu7t3v3__ao22_2
X_3124_ VDD VDD VSS VSS _4099_/A _3124_/B _3124_/C _4791_/D _3661_/D gf180mcu_as_sc_mcu7t3v3__aoi211_2
XFILLER_167_1108 VDD VDD VSS VSS gf180mcu_as_sc_mcu7t3v3__fill_1
XFILLER_167_1119 VDD VDD VSS VSS gf180mcu_as_sc_mcu7t3v3__fill_1
XFILLER_67_298 VDD VDD VSS VSS gf180mcu_as_sc_mcu7t3v3__fill_2
X_3055_ VDD VDD VSS VSS _4033_/A _3147_/B _3055_/C _3055_/D _3056_/C gf180mcu_as_sc_mcu7t3v3__ao22_2
XFILLER_3_1467 VDD VDD VSS VSS gf180mcu_as_sc_mcu7t3v3__fillcap_16
XFILLER_145_1406 VDD VDD VSS VSS gf180mcu_as_sc_mcu7t3v3__fill_1
XFILLER_180_1308 VDD VDD VSS VSS gf180mcu_as_sc_mcu7t3v3__fill_1
XFILLER_50_143 VDD VDD VSS VSS gf180mcu_as_sc_mcu7t3v3__fill_2
X_3957_ VDD VDD VSS VSS _3957_/A _4162_/B _4110_/C _3962_/C _3957_/D gf180mcu_as_sc_mcu7t3v3__aoi211_2
XFILLER_143_1152 VDD VDD VSS VSS gf180mcu_as_sc_mcu7t3v3__fillcap_8
XFILLER_167_18 VDD VDD VSS VSS gf180mcu_as_sc_mcu7t3v3__fillcap_16
XFILLER_182_1190 VDD VDD VSS VSS gf180mcu_as_sc_mcu7t3v3__fill_1
Xclkbuf_0_clk_regs VDD VDD VSS VSS clkbuf_regs_0_clk/Y clkbuf_0_clk_regs/Y gf180mcu_as_sc_mcu7t3v3__clkbuff_12
X_2908_ VDD VDD VSS VSS _3245_/C _3534_/A _3202_/B gf180mcu_as_sc_mcu7t3v3__and2_2
XFILLER_164_524 VDD VDD VSS VSS gf180mcu_as_sc_mcu7t3v3__fill_1
X_3888_ VDD VDD VSS VSS _4946_/D _5178_/Q _4928_/D gf180mcu_as_sc_mcu7t3v3__and2_2
XFILLER_178_1215 VDD VDD VSS VSS gf180mcu_as_sc_mcu7t3v3__fill_2
XFILLER_69_1521 VDD VDD VSS VSS gf180mcu_as_sc_mcu7t3v3__fillcap_16
X_2839_ VDD VDD VSS VSS _2842_/B _2839_/B _2842_/D gf180mcu_as_sc_mcu7t3v3__nor2_2
XFILLER_121_1483 VDD VDD VSS VSS gf180mcu_as_sc_mcu7t3v3__fillcap_16
X_4509_ VDD VDD VSS VSS _4544_/S _5021_/Q _5050_/Q _4510_/B gf180mcu_as_sc_mcu7t3v3__mux2_2
XFILLER_160_741 VDD VDD VSS VSS gf180mcu_as_sc_mcu7t3v3__fillcap_8
XPHY_EDGE_ROW_117_1_Right_116 VDD VSS gf180mcu_as_sc_mcu7t3v3__tap_2
Xfanout510 VDD VDD VSS VSS _3455_/B _3447_/B gf180mcu_as_sc_mcu7t3v3__buff_2
Xfanout521 VDD VDD VSS VSS _4592_/B _4548_/B gf180mcu_as_sc_mcu7t3v3__buff_2
Xfanout532 VDD VDD VSS VSS _4099_/B _4124_/B gf180mcu_as_sc_mcu7t3v3__buff_2
XFILLER_150_1123 VDD VDD VSS VSS gf180mcu_as_sc_mcu7t3v3__fill_2
XFILLER_76_37 VDD VDD VSS VSS gf180mcu_as_sc_mcu7t3v3__fill_1
Xfanout543 VDD VDD VSS VSS _3561_/Y fanout543/Y gf180mcu_as_sc_mcu7t3v3__buff_2
Xfanout554 VDD VDD VSS VSS _3140_/A _3194_/S gf180mcu_as_sc_mcu7t3v3__buff_2
Xfanout565 VDD VDD VSS VSS fanout569/Y _4162_/B gf180mcu_as_sc_mcu7t3v3__buff_2
XFILLER_18_107 VDD VDD VSS VSS gf180mcu_as_sc_mcu7t3v3__fillcap_16
XPHY_EDGE_ROW_10_1_Left_462 VDD VSS gf180mcu_as_sc_mcu7t3v3__tap_2
Xfanout576 VDD VDD VSS VSS _3874_/Y _4946_/D gf180mcu_as_sc_mcu7t3v3__buff_2
Xfanout587 VDD VDD VSS VSS _4496_/B _4470_/B gf180mcu_as_sc_mcu7t3v3__buff_2
Xfanout598 VDD VDD VSS VSS fanout602/Y _4160_/B gf180mcu_as_sc_mcu7t3v3__buff_2
XFILLER_41_1451 VDD VDD VSS VSS gf180mcu_as_sc_mcu7t3v3__fillcap_16
XFILLER_73_279 VDD VDD VSS VSS gf180mcu_as_sc_mcu7t3v3__fill_1
XFILLER_155_502 VDD VDD VSS VSS gf180mcu_as_sc_mcu7t3v3__fillcap_16
XFILLER_167_384 VDD VDD VSS VSS gf180mcu_as_sc_mcu7t3v3__fillcap_16
XFILLER_13_1553 VDD VDD VSS VSS gf180mcu_as_sc_mcu7t3v3__fillcap_16
XFILLER_155_557 VDD VDD VSS VSS gf180mcu_as_sc_mcu7t3v3__fill_2
XFILLER_183_855 VDD VDD VSS VSS gf180mcu_as_sc_mcu7t3v3__fill_2
XFILLER_41_51 VDD VDD VSS VSS gf180mcu_as_sc_mcu7t3v3__fillcap_8
XTAP_TAPCELL_ROW_136_1248 VDD VSS gf180mcu_as_sc_mcu7t3v3__tap_2
XFILLER_100_1534 VDD VDD VSS VSS gf180mcu_as_sc_mcu7t3v3__fillcap_16
XFILLER_142_207 VDD VDD VSS VSS gf180mcu_as_sc_mcu7t3v3__fill_1
XFILLER_143_708 VDD VDD VSS VSS gf180mcu_as_sc_mcu7t3v3__fill_1
XFILLER_182_365 VDD VDD VSS VSS gf180mcu_as_sc_mcu7t3v3__fillcap_16
XTAP_TAPCELL_ROW_136_1259 VDD VSS gf180mcu_as_sc_mcu7t3v3__tap_2
XFILLER_100_1556 VDD VDD VSS VSS gf180mcu_as_sc_mcu7t3v3__fillcap_8
XFILLER_170_527 VDD VDD VSS VSS gf180mcu_as_sc_mcu7t3v3__fillcap_8
XFILLER_182_387 VDD VDD VSS VSS gf180mcu_as_sc_mcu7t3v3__fillcap_16
XPHY_EDGE_ROW_176_Right_310 VDD VSS gf180mcu_as_sc_mcu7t3v3__tap_2
XFILLER_155_1034 VDD VDD VSS VSS gf180mcu_as_sc_mcu7t3v3__fillcap_4
XFILLER_159_1192 VDD VDD VSS VSS gf180mcu_as_sc_mcu7t3v3__fillcap_4
XTAP_TAPCELL_ROW_26_3_2388 VDD VSS gf180mcu_as_sc_mcu7t3v3__tap_2
XTAP_TAPCELL_ROW_49_1_832 VDD VSS gf180mcu_as_sc_mcu7t3v3__tap_2
XFILLER_110_137 VDD VDD VSS VSS gf180mcu_as_sc_mcu7t3v3__fillcap_8
XFILLER_150_295 VDD VDD VSS VSS gf180mcu_as_sc_mcu7t3v3__fillcap_8
XFILLER_172_1392 VDD VDD VSS VSS gf180mcu_as_sc_mcu7t3v3__fill_2
XFILLER_173_72 VDD VDD VSS VSS gf180mcu_as_sc_mcu7t3v3__fillcap_16
XFILLER_2_34 VDD VDD VSS VSS gf180mcu_as_sc_mcu7t3v3__fill_1
XTAP_TAPCELL_ROW_166_1912 VDD VSS gf180mcu_as_sc_mcu7t3v3__tap_2
XTAP_TAPCELL_ROW_166_1901 VDD VSS gf180mcu_as_sc_mcu7t3v3__tap_2
XPHY_EDGE_ROW_127_3_Right_446 VDD VSS gf180mcu_as_sc_mcu7t3v3__tap_2
XFILLER_20_1502 VDD VDD VSS VSS gf180mcu_as_sc_mcu7t3v3__fillcap_16
XFILLER_49_298 VDD VDD VSS VSS gf180mcu_as_sc_mcu7t3v3__fill_2
XFILLER_20_1568 VDD VDD VSS VSS gf180mcu_as_sc_mcu7t3v3__fill_1
XFILLER_64_279 VDD VDD VSS VSS gf180mcu_as_sc_mcu7t3v3__fillcap_16
XFILLER_166_1152 VDD VDD VSS VSS gf180mcu_as_sc_mcu7t3v3__fill_2
XFILLER_178_605 VDD VDD VSS VSS gf180mcu_as_sc_mcu7t3v3__fill_1
X_4860_ VDD VDD VSS VSS _5052_/CLK _4860_/D _4860_/Q gf180mcu_as_sc_mcu7t3v3__dfxtp_2
XFILLER_162_1049 VDD VDD VSS VSS gf180mcu_as_sc_mcu7t3v3__fillcap_16
XFILLER_177_104 VDD VDD VSS VSS gf180mcu_as_sc_mcu7t3v3__fillcap_16
XFILLER_82_80 VDD VDD VSS VSS gf180mcu_as_sc_mcu7t3v3__fillcap_16
X_3811_ VDD VDD VSS VSS _3924_/A _3811_/B _3811_/A gf180mcu_as_sc_mcu7t3v3__nand2_2
X_4791_ VDD VDD VSS VSS _4904_/CLK _4791_/D _4791_/Q gf180mcu_as_sc_mcu7t3v3__dfxtp_2
XFILLER_144_1483 VDD VDD VSS VSS gf180mcu_as_sc_mcu7t3v3__fill_1
XFILLER_159_896 VDD VDD VSS VSS gf180mcu_as_sc_mcu7t3v3__fill_2
XFILLER_18_1486 VDD VDD VSS VSS gf180mcu_as_sc_mcu7t3v3__fillcap_16
XFILLER_70_2 VDD VDD VSS VSS gf180mcu_as_sc_mcu7t3v3__fillcap_16
X_3742_ VDD VDD VSS VSS _4118_/D _3742_/B _3742_/C _3742_/D _3743_/C gf180mcu_as_sc_mcu7t3v3__ao211_2
XPHY_EDGE_ROW_86_1_Left_538 VDD VSS gf180mcu_as_sc_mcu7t3v3__tap_2
XFILLER_105_1467 VDD VDD VSS VSS gf180mcu_as_sc_mcu7t3v3__fillcap_16
XFILLER_118_226 VDD VDD VSS VSS gf180mcu_as_sc_mcu7t3v3__fill_2
XFILLER_146_524 VDD VDD VSS VSS gf180mcu_as_sc_mcu7t3v3__fill_1
XFILLER_179_1535 VDD VDD VSS VSS gf180mcu_as_sc_mcu7t3v3__fillcap_4
X_3673_ VDD VDD VSS VSS _4048_/A _3750_/B _3750_/C _4048_/D _3674_/D gf180mcu_as_sc_mcu7t3v3__ao22_2
XFILLER_161_516 VDD VDD VSS VSS gf180mcu_as_sc_mcu7t3v3__fillcap_4
XFILLER_174_877 VDD VDD VSS VSS gf180mcu_as_sc_mcu7t3v3__fillcap_16
X_2624_ VDD VDD VSS VSS _2711_/S _2624_/B _2624_/C _2653_/S _2627_/C gf180mcu_as_sc_mcu7t3v3__ao211_2
XFILLER_138_1221 VDD VDD VSS VSS gf180mcu_as_sc_mcu7t3v3__fillcap_4
X_2555_ VDD VDD VSS VSS _2558_/B _2558_/A _4294_/A gf180mcu_as_sc_mcu7t3v3__and2_2
XFILLER_141_251 VDD VDD VSS VSS gf180mcu_as_sc_mcu7t3v3__fill_1
XFILLER_64_1451 VDD VDD VSS VSS gf180mcu_as_sc_mcu7t3v3__fillcap_16
X_5274_ VDD VDD VSS VSS clkload5/A _5274_/D _5274_/Q gf180mcu_as_sc_mcu7t3v3__dfxtp_2
X_2486_ VDD VDD VSS VSS _2790_/C _2806_/D gf180mcu_as_sc_mcu7t3v3__inv_2
XFILLER_141_295 VDD VDD VSS VSS gf180mcu_as_sc_mcu7t3v3__fillcap_16
XFILLER_99_198 VDD VDD VSS VSS gf180mcu_as_sc_mcu7t3v3__fill_1
X_4225_ VDD VDD VSS VSS _4254_/B _4228_/B _4228_/C _5061_/Q _5061_/D gf180mcu_as_sc_mcu7t3v3__ao22_2
XFILLER_151_1465 VDD VDD VSS VSS gf180mcu_as_sc_mcu7t3v3__fillcap_4
X_4156_ VDD VDD VSS VSS _4164_/S _4156_/B _4156_/A _4157_/B gf180mcu_as_sc_mcu7t3v3__mux2_2
X_3107_ VDD VDD VSS VSS _4789_/D _3107_/C _3156_/A _4083_/A gf180mcu_as_sc_mcu7t3v3__aoi21_2
X_4087_ VDD VDD VSS VSS _4087_/A _4102_/B _4102_/C _4934_/Q _4089_/C gf180mcu_as_sc_mcu7t3v3__ao22_2
XFILLER_55_279 VDD VDD VSS VSS gf180mcu_as_sc_mcu7t3v3__fill_1
X_3038_ VDD VDD VSS VSS _4016_/A _3125_/B _3038_/C _3038_/D _3039_/C gf180mcu_as_sc_mcu7t3v3__ao22_2
XFILLER_169_605 VDD VDD VSS VSS gf180mcu_as_sc_mcu7t3v3__fill_1
XFILLER_169_616 VDD VDD VSS VSS gf180mcu_as_sc_mcu7t3v3__fillcap_8
XFILLER_36_1564 VDD VDD VSS VSS gf180mcu_as_sc_mcu7t3v3__fillcap_4
X_4989_ VDD VDD VSS VSS _5188_/CLK _4989_/D _4989_/Q gf180mcu_as_sc_mcu7t3v3__dfxtp_2
XFILLER_109_204 VDD VDD VSS VSS gf180mcu_as_sc_mcu7t3v3__fillcap_4
XFILLER_149_373 VDD VDD VSS VSS gf180mcu_as_sc_mcu7t3v3__fill_2
XTAP_TAPCELL_ROW_32_3_2398 VDD VSS gf180mcu_as_sc_mcu7t3v3__tap_2
XFILLER_178_1001 VDD VDD VSS VSS gf180mcu_as_sc_mcu7t3v3__fill_1
XFILLER_71_1499 VDD VDD VSS VSS gf180mcu_as_sc_mcu7t3v3__fillcap_16
XFILLER_180_814 VDD VDD VSS VSS gf180mcu_as_sc_mcu7t3v3__fill_1
XFILLER_139_1029 VDD VDD VSS VSS gf180mcu_as_sc_mcu7t3v3__fillcap_16
XFILLER_164_387 VDD VDD VSS VSS gf180mcu_as_sc_mcu7t3v3__fillcap_4
XFILLER_127_65 VDD VDD VSS VSS gf180mcu_as_sc_mcu7t3v3__fillcap_4
XFILLER_156_1354 VDD VDD VSS VSS gf180mcu_as_sc_mcu7t3v3__fillcap_8
XTAP_TAPCELL_ROW_89_1_992 VDD VSS gf180mcu_as_sc_mcu7t3v3__tap_2
XFILLER_132_251 VDD VDD VSS VSS gf180mcu_as_sc_mcu7t3v3__fill_1
Xdelaybuf_1_clk VDD VDD VSS VSS delaybuf_1_clk/A clkbuf_0_clk/A gf180mcu_as_sc_mcu7t3v3__clkbuff_12
XFILLER_132_295 VDD VDD VSS VSS gf180mcu_as_sc_mcu7t3v3__fillcap_4
XFILLER_152_1229 VDD VDD VSS VSS gf180mcu_as_sc_mcu7t3v3__fill_1
XFILLER_43_1568 VDD VDD VSS VSS gf180mcu_as_sc_mcu7t3v3__fill_1
XPHY_EDGE_ROW_118_1_Right_117 VDD VSS gf180mcu_as_sc_mcu7t3v3__tap_2
XFILLER_130_1527 VDD VDD VSS VSS gf180mcu_as_sc_mcu7t3v3__fillcap_16
XFILLER_143_64 VDD VDD VSS VSS gf180mcu_as_sc_mcu7t3v3__fillcap_4
XTAP_TAPCELL_ROW_183_2289 VDD VSS gf180mcu_as_sc_mcu7t3v3__tap_2
XTAP_TAPCELL_ROW_183_2278 VDD VSS gf180mcu_as_sc_mcu7t3v3__tap_2
XTAP_TAPCELL_ROW_0_3_2349 VDD VSS gf180mcu_as_sc_mcu7t3v3__tap_2
XPHY_EDGE_ROW_51_3_Right_370 VDD VSS gf180mcu_as_sc_mcu7t3v3__tap_2
XFILLER_46_279 VDD VDD VSS VSS gf180mcu_as_sc_mcu7t3v3__fillcap_16
XFILLER_61_216 VDD VDD VSS VSS gf180mcu_as_sc_mcu7t3v3__fill_2
XFILLER_167_1472 VDD VDD VSS VSS gf180mcu_as_sc_mcu7t3v3__fillcap_16
XFILLER_128_1467 VDD VDD VSS VSS gf180mcu_as_sc_mcu7t3v3__fillcap_16
XFILLER_159_104 VDD VDD VSS VSS gf180mcu_as_sc_mcu7t3v3__fillcap_16
XPHY_EDGE_ROW_128_3_Left_262 VDD VSS gf180mcu_as_sc_mcu7t3v3__tap_2
XPHY_EDGE_ROW_141_Right_275 VDD VSS gf180mcu_as_sc_mcu7t3v3__tap_2
XFILLER_163_1358 VDD VDD VSS VSS gf180mcu_as_sc_mcu7t3v3__fill_2
XFILLER_156_800 VDD VDD VSS VSS gf180mcu_as_sc_mcu7t3v3__fillcap_4
XFILLER_161_1060 VDD VDD VSS VSS gf180mcu_as_sc_mcu7t3v3__fillcap_4
XFILLER_174_107 VDD VDD VSS VSS gf180mcu_as_sc_mcu7t3v3__fillcap_16
XTAP_TAPCELL_ROW_159_1760 VDD VSS gf180mcu_as_sc_mcu7t3v3__tap_2
XFILLER_161_1082 VDD VDD VSS VSS gf180mcu_as_sc_mcu7t3v3__fillcap_16
Xinput15 VDD VDD VSS VSS boot_data[3] _2708_/A gf180mcu_as_sc_mcu7t3v3__buff_2
Xinput26 VDD VDD VSS VSS dft_addr[3] _2641_/B gf180mcu_as_sc_mcu7t3v3__buff_2
Xwire741 VDD VDD VSS VSS _2743_/Y _5484_/A gf180mcu_as_sc_mcu7t3v3__buff_8
Xinput37 VDD VDD VSS VSS dft_wdata[2] _2702_/B gf180mcu_as_sc_mcu7t3v3__buff_2
XFILLER_156_877 VDD VDD VSS VSS gf180mcu_as_sc_mcu7t3v3__fillcap_16
Xinput59 VDD VDD VSS VSS east_in[23] _4121_/A gf180mcu_as_sc_mcu7t3v3__buff_2
Xinput48 VDD VDD VSS VSS east_in[13] _4040_/A gf180mcu_as_sc_mcu7t3v3__buff_2
XTAP_TAPCELL_ROW_1_1_639 VDD VSS gf180mcu_as_sc_mcu7t3v3__tap_2
XTAP_TAPCELL_ROW_155_1668 VDD VSS gf180mcu_as_sc_mcu7t3v3__tap_2
XTAP_TAPCELL_ROW_155_1657 VDD VSS gf180mcu_as_sc_mcu7t3v3__tap_2
XFILLER_143_527 VDD VDD VSS VSS gf180mcu_as_sc_mcu7t3v3__fillcap_4
XFILLER_155_398 VDD VDD VSS VSS gf180mcu_as_sc_mcu7t3v3__fillcap_16
XFILLER_171_858 VDD VDD VSS VSS gf180mcu_as_sc_mcu7t3v3__fillcap_16
XFILLER_87_1451 VDD VDD VSS VSS gf180mcu_as_sc_mcu7t3v3__fillcap_16
Xmax_cap529 VDD VDD VSS VSS _4164_/S _4050_/S gf180mcu_as_sc_mcu7t3v3__buff_8
XFILLER_108_292 VDD VDD VSS VSS gf180mcu_as_sc_mcu7t3v3__fillcap_8
XFILLER_123_251 VDD VDD VSS VSS gf180mcu_as_sc_mcu7t3v3__fill_1
XFILLER_77_80 VDD VDD VSS VSS gf180mcu_as_sc_mcu7t3v3__fillcap_8
XFILLER_96_168 VDD VDD VSS VSS gf180mcu_as_sc_mcu7t3v3__fillcap_4
X_4010_ VDD VDD VSS VSS _4050_/S _4010_/B _4010_/A _4011_/B gf180mcu_as_sc_mcu7t3v3__mux2_2
XPHY_EDGE_ROW_128_3_Right_447 VDD VSS gf180mcu_as_sc_mcu7t3v3__tap_2
XFILLER_0_1459 VDD VDD VSS VSS gf180mcu_as_sc_mcu7t3v3__fillcap_16
XFILLER_59_1553 VDD VDD VSS VSS gf180mcu_as_sc_mcu7t3v3__fillcap_16
X_4912_ VDD VDD VSS VSS _4914_/CLK _4912_/D _4912_/Q gf180mcu_as_sc_mcu7t3v3__dfxtp_2
XFILLER_178_435 VDD VDD VSS VSS gf180mcu_as_sc_mcu7t3v3__fillcap_16
XFILLER_178_457 VDD VDD VSS VSS gf180mcu_as_sc_mcu7t3v3__fillcap_16
X_4843_ VDD VDD VSS VSS _4863_/CLK _4843_/D _4843_/Q gf180mcu_as_sc_mcu7t3v3__dfxtp_2
X_4774_ VDD VDD VSS VSS _4863_/CLK _4774_/D _4774_/Q gf180mcu_as_sc_mcu7t3v3__dfxtp_2
X_3725_ VDD VDD VSS VSS _3726_/C _4101_/A _3742_/B _3725_/C gf180mcu_as_sc_mcu7t3v3__ao21_2
XFILLER_134_505 VDD VDD VSS VSS gf180mcu_as_sc_mcu7t3v3__fillcap_4
XFILLER_179_1332 VDD VDD VSS VSS gf180mcu_as_sc_mcu7t3v3__fill_1
XFILLER_146_387 VDD VDD VSS VSS gf180mcu_as_sc_mcu7t3v3__fillcap_4
XFILLER_179_1376 VDD VDD VSS VSS gf180mcu_as_sc_mcu7t3v3__fill_2
XFILLER_31_1483 VDD VDD VSS VSS gf180mcu_as_sc_mcu7t3v3__fillcap_16
XFILLER_66_1502 VDD VDD VSS VSS gf180mcu_as_sc_mcu7t3v3__fillcap_16
X_3656_ VDD VDD VSS VSS _4030_/D _3716_/B _3719_/C _4031_/A _3657_/D gf180mcu_as_sc_mcu7t3v3__ao22_2
XFILLER_162_858 VDD VDD VSS VSS gf180mcu_as_sc_mcu7t3v3__fillcap_16
X_3587_ VDD VDD VSS VSS _3953_/A _3802_/C _3587_/C _4841_/D _3825_/C gf180mcu_as_sc_mcu7t3v3__aoi211_2
X_2607_ VDD VDD VSS VSS _2727_/S _2699_/A _2735_/A gf180mcu_as_sc_mcu7t3v3__and2_2
XFILLER_114_251 VDD VDD VSS VSS gf180mcu_as_sc_mcu7t3v3__fill_1
XFILLER_138_1040 VDD VDD VSS VSS gf180mcu_as_sc_mcu7t3v3__fillcap_16
XFILLER_142_571 VDD VDD VSS VSS gf180mcu_as_sc_mcu7t3v3__fill_2
XFILLER_153_1516 VDD VDD VSS VSS gf180mcu_as_sc_mcu7t3v3__fill_1
XFILLER_66_1568 VDD VDD VSS VSS gf180mcu_as_sc_mcu7t3v3__fill_1
X_2538_ VDD VDD VSS VSS _4365_/A _2538_/A _2539_/A gf180mcu_as_sc_mcu7t3v3__xnor2_2
XFILLER_114_295 VDD VDD VSS VSS gf180mcu_as_sc_mcu7t3v3__fillcap_4
XFILLER_138_1084 VDD VDD VSS VSS gf180mcu_as_sc_mcu7t3v3__fill_1
XFILLER_138_1095 VDD VDD VSS VSS gf180mcu_as_sc_mcu7t3v3__fillcap_8
XFILLER_153_1527 VDD VDD VSS VSS gf180mcu_as_sc_mcu7t3v3__fillcap_8
X_5257_ VDD VDD VSS VSS _5266_/CLK _5257_/D _5257_/Q gf180mcu_as_sc_mcu7t3v3__dfxtp_2
XFILLER_180_18 VDD VDD VSS VSS gf180mcu_as_sc_mcu7t3v3__fillcap_16
XFILLER_9_1451 VDD VDD VSS VSS gf180mcu_as_sc_mcu7t3v3__fillcap_16
X_4208_ VDD VDD VSS VSS _4237_/B _4219_/B _4219_/C _5044_/Q _5044_/D gf180mcu_as_sc_mcu7t3v3__ao22_2
X_2469_ VDD VDD VSS VSS _2472_/C _2469_/C _5063_/Q _4341_/S gf180mcu_as_sc_mcu7t3v3__aoi21b_2
XFILLER_151_1262 VDD VDD VSS VSS gf180mcu_as_sc_mcu7t3v3__fillcap_8
X_5188_ VDD VDD VSS VSS _5188_/CLK _5188_/D _5188_/Q gf180mcu_as_sc_mcu7t3v3__dfxtp_2
X_4139_ VDD VDD VSS VSS _4139_/A _4163_/B _4139_/C _4139_/D _4140_/B gf180mcu_as_sc_mcu7t3v3__ao211_2
XFILLER_28_279 VDD VDD VSS VSS gf180mcu_as_sc_mcu7t3v3__fillcap_16
XFILLER_73_49 VDD VDD VSS VSS gf180mcu_as_sc_mcu7t3v3__fill_1
XTAP_TAPCELL_ROW_130_1_1156 VDD VSS gf180mcu_as_sc_mcu7t3v3__tap_2
XFILLER_51_282 VDD VDD VSS VSS gf180mcu_as_sc_mcu7t3v3__fillcap_16
Xsram2048.u_bank0_812 VDD VDD VSS VSS sram2048.u_bank0/WEN[2] gf180mcu_as_sc_mcu7t3v3__tiel_4
XFILLER_138_800 VDD VDD VSS VSS gf180mcu_as_sc_mcu7t3v3__fillcap_4
XFILLER_145_1088 VDD VDD VSS VSS gf180mcu_as_sc_mcu7t3v3__fillcap_16
XFILLER_156_107 VDD VDD VSS VSS gf180mcu_as_sc_mcu7t3v3__fillcap_16
XFILLER_149_170 VDD VDD VSS VSS gf180mcu_as_sc_mcu7t3v3__fill_2
XFILLER_178_991 VDD VDD VSS VSS gf180mcu_as_sc_mcu7t3v3__fillcap_8
XFILLER_138_877 VDD VDD VSS VSS gf180mcu_as_sc_mcu7t3v3__fillcap_16
XFILLER_22_53 VDD VDD VSS VSS gf180mcu_as_sc_mcu7t3v3__fillcap_16
XTAP_TAPCELL_ROW_110_1_1076 VDD VSS gf180mcu_as_sc_mcu7t3v3__tap_2
XFILLER_10_1534 VDD VDD VSS VSS gf180mcu_as_sc_mcu7t3v3__fillcap_16
XFILLER_118_2 VDD VDD VSS VSS gf180mcu_as_sc_mcu7t3v3__fillcap_16
XFILLER_138_53 VDD VDD VSS VSS gf180mcu_as_sc_mcu7t3v3__fillcap_16
XFILLER_10_1556 VDD VDD VSS VSS gf180mcu_as_sc_mcu7t3v3__fillcap_8
XFILLER_98_68 VDD VDD VSS VSS gf180mcu_as_sc_mcu7t3v3__fill_1
XFILLER_0_2 VDD VDD VSS VSS gf180mcu_as_sc_mcu7t3v3__fillcap_16
XTAP_TAPCELL_ROW_150_1565 VDD VSS gf180mcu_as_sc_mcu7t3v3__tap_2
XTAP_TAPCELL_ROW_150_1554 VDD VSS gf180mcu_as_sc_mcu7t3v3__tap_2
XFILLER_156_1173 VDD VDD VSS VSS gf180mcu_as_sc_mcu7t3v3__fillcap_16
XFILLER_78_124 VDD VDD VSS VSS gf180mcu_as_sc_mcu7t3v3__fill_2
XFILLER_78_146 VDD VDD VSS VSS gf180mcu_as_sc_mcu7t3v3__fill_1
XFILLER_120_298 VDD VDD VSS VSS gf180mcu_as_sc_mcu7t3v3__fill_2
XPHY_EDGE_ROW_119_1_Right_118 VDD VSS gf180mcu_as_sc_mcu7t3v3__tap_2
XFILLER_47_72 VDD VDD VSS VSS gf180mcu_as_sc_mcu7t3v3__fillcap_16
XTAP_TAPCELL_ROW_19_1_710 VDD VSS gf180mcu_as_sc_mcu7t3v3__tap_2
XPHY_EDGE_ROW_52_3_Right_371 VDD VSS gf180mcu_as_sc_mcu7t3v3__tap_2
XFILLER_163_1188 VDD VDD VSS VSS gf180mcu_as_sc_mcu7t3v3__fill_2
XFILLER_175_416 VDD VDD VSS VSS gf180mcu_as_sc_mcu7t3v3__fillcap_4
XTAP_TAPCELL_ROW_157_1719 VDD VSS gf180mcu_as_sc_mcu7t3v3__tap_2
XTAP_TAPCELL_ROW_157_1708 VDD VSS gf180mcu_as_sc_mcu7t3v3__tap_2
XFILLER_141_1453 VDD VDD VSS VSS gf180mcu_as_sc_mcu7t3v3__fillcap_4
XFILLER_169_991 VDD VDD VSS VSS gf180mcu_as_sc_mcu7t3v3__fillcap_8
XFILLER_175_438 VDD VDD VSS VSS gf180mcu_as_sc_mcu7t3v3__fillcap_16
XFILLER_54_1483 VDD VDD VSS VSS gf180mcu_as_sc_mcu7t3v3__fill_1
XFILLER_15_1467 VDD VDD VSS VSS gf180mcu_as_sc_mcu7t3v3__fillcap_16
XFILLER_184_950 VDD VDD VSS VSS gf180mcu_as_sc_mcu7t3v3__fill_2
X_3510_ VDD VDD VSS VSS _3510_/D _3510_/A _3818_/B _3510_/C _3511_/D gf180mcu_as_sc_mcu7t3v3__ao31_2
X_4490_ VDD VDD VSS VSS _4491_/D _4490_/B _4587_/A gf180mcu_as_sc_mcu7t3v3__nor2_2
XFILLER_144_869 VDD VDD VSS VSS gf180mcu_as_sc_mcu7t3v3__fillcap_4
XFILLER_171_644 VDD VDD VSS VSS gf180mcu_as_sc_mcu7t3v3__fillcap_8
X_3441_ VDD VDD VSS VSS _4096_/D _3466_/B _3441_/C _3464_/B _3443_/C gf180mcu_as_sc_mcu7t3v3__ao211_2
XFILLER_135_1202 VDD VDD VSS VSS gf180mcu_as_sc_mcu7t3v3__fillcap_16
XFILLER_143_368 VDD VDD VSS VSS gf180mcu_as_sc_mcu7t3v3__fillcap_4
XFILLER_174_1251 VDD VDD VSS VSS gf180mcu_as_sc_mcu7t3v3__fill_2
X_3372_ VDD VDD VSS VSS _4021_/D _3468_/B _3372_/C _3372_/D _3373_/A gf180mcu_as_sc_mcu7t3v3__ao22_2
XFILLER_33_2 VDD VDD VSS VSS gf180mcu_as_sc_mcu7t3v3__fillcap_16
X_5111_ VDD VDD VSS VSS _5186_/CLK _5111_/D _5111_/Q gf180mcu_as_sc_mcu7t3v3__dfxtp_2
XFILLER_111_265 VDD VDD VSS VSS gf180mcu_as_sc_mcu7t3v3__fillcap_4
XFILLER_84_116 VDD VDD VSS VSS gf180mcu_as_sc_mcu7t3v3__fillcap_4
X_5042_ VDD VDD VSS VSS _5080_/CLK _5042_/D _5042_/Q gf180mcu_as_sc_mcu7t3v3__dfxtp_2
XFILLER_111_298 VDD VDD VSS VSS gf180mcu_as_sc_mcu7t3v3__fill_2
XFILLER_168_1033 VDD VDD VSS VSS gf180mcu_as_sc_mcu7t3v3__fillcap_16
XFILLER_80_300 VDD VDD VSS VSS gf180mcu_as_sc_mcu7t3v3__fill_1
XPHY_EDGE_ROW_129_3_Right_448 VDD VSS gf180mcu_as_sc_mcu7t3v3__tap_2
XFILLER_168_1055 VDD VDD VSS VSS gf180mcu_as_sc_mcu7t3v3__fill_1
XFILLER_92_171 VDD VDD VSS VSS gf180mcu_as_sc_mcu7t3v3__fillcap_4
XFILLER_92_193 VDD VDD VSS VSS gf180mcu_as_sc_mcu7t3v3__fillcap_4
XFILLER_179_733 VDD VDD VSS VSS gf180mcu_as_sc_mcu7t3v3__fill_1
XFILLER_146_1364 VDD VDD VSS VSS gf180mcu_as_sc_mcu7t3v3__fill_1
XFILLER_33_260 VDD VDD VSS VSS gf180mcu_as_sc_mcu7t3v3__fillcap_16
XFILLER_167_928 VDD VDD VSS VSS gf180mcu_as_sc_mcu7t3v3__fillcap_4
XFILLER_33_282 VDD VDD VSS VSS gf180mcu_as_sc_mcu7t3v3__fillcap_16
XFILLER_72_1550 VDD VDD VSS VSS gf180mcu_as_sc_mcu7t3v3__fillcap_4
X_4826_ VDD VDD VSS VSS _4858_/CLK _4826_/D _4826_/Q gf180mcu_as_sc_mcu7t3v3__dfxtp_2
XFILLER_146_140 VDD VDD VSS VSS gf180mcu_as_sc_mcu7t3v3__fillcap_16
X_4757_ VDD VDD VSS VSS clkload1/A _4757_/D _4757_/Q gf180mcu_as_sc_mcu7t3v3__dfxtp_2
XFILLER_175_1004 VDD VDD VSS VSS gf180mcu_as_sc_mcu7t3v3__fill_1
XFILLER_175_18 VDD VDD VSS VSS gf180mcu_as_sc_mcu7t3v3__fillcap_16
XFILLER_179_1162 VDD VDD VSS VSS gf180mcu_as_sc_mcu7t3v3__fill_1
X_4688_ VDD VDD VSS VSS _4688_/B _5123_/Q _4723_/A gf180mcu_as_sc_mcu7t3v3__and2_2
X_3708_ VDD VDD VSS VSS _4088_/A _3716_/B _3716_/C _4087_/A _3709_/C gf180mcu_as_sc_mcu7t3v3__ao22_2
XFILLER_108_34 VDD VDD VSS VSS gf180mcu_as_sc_mcu7t3v3__fill_1
XFILLER_134_324 VDD VDD VSS VSS gf180mcu_as_sc_mcu7t3v3__fillcap_8
X_3639_ VDD VDD VSS VSS _4848_/D _3639_/C _3707_/B _3639_/A gf180mcu_as_sc_mcu7t3v3__aoi21_2
XFILLER_150_839 VDD VDD VSS VSS gf180mcu_as_sc_mcu7t3v3__fillcap_8
XFILLER_143_891 VDD VDD VSS VSS gf180mcu_as_sc_mcu7t3v3__fillcap_16
XFILLER_153_1302 VDD VDD VSS VSS gf180mcu_as_sc_mcu7t3v3__fillcap_16
XFILLER_68_27 VDD VDD VSS VSS gf180mcu_as_sc_mcu7t3v3__fillcap_8
Xinput205 VDD VDD VSS VSS se_in[31] _3514_/A gf180mcu_as_sc_mcu7t3v3__buff_2
Xinput216 VDD VDD VSS VSS south_in[10] _4013_/D gf180mcu_as_sc_mcu7t3v3__buff_2
Xinput227 VDD VDD VSS VSS south_in[20] _4096_/D gf180mcu_as_sc_mcu7t3v3__buff_2
XTAP_TAPCELL_ROW_59_1_870 VDD VSS gf180mcu_as_sc_mcu7t3v3__tap_2
XFILLER_124_33 VDD VDD VSS VSS gf180mcu_as_sc_mcu7t3v3__fill_2
Xinput238 VDD VDD VSS VSS south_in[30] _3796_/D gf180mcu_as_sc_mcu7t3v3__buff_2
Xinput249 VDD VDD VSS VSS sw_in[0] _2955_/A gf180mcu_as_sc_mcu7t3v3__buff_2
XTAP_TAPCELL_ROW_180_2215 VDD VSS gf180mcu_as_sc_mcu7t3v3__tap_2
XFILLER_124_88 VDD VDD VSS VSS gf180mcu_as_sc_mcu7t3v3__fillcap_4
XFILLER_151_1081 VDD VDD VSS VSS gf180mcu_as_sc_mcu7t3v3__fill_1
XFILLER_75_138 VDD VDD VSS VSS gf180mcu_as_sc_mcu7t3v3__fill_2
XFILLER_84_37 VDD VDD VSS VSS gf180mcu_as_sc_mcu7t3v3__fillcap_8
XTAP_TAPCELL_ROW_180_2226 VDD VSS gf180mcu_as_sc_mcu7t3v3__tap_2
XFILLER_71_300 VDD VDD VSS VSS gf180mcu_as_sc_mcu7t3v3__fill_1
XFILLER_140_32 VDD VDD VSS VSS gf180mcu_as_sc_mcu7t3v3__fill_2
XFILLER_140_65 VDD VDD VSS VSS gf180mcu_as_sc_mcu7t3v3__fillcap_16
XFILLER_164_1420 VDD VDD VSS VSS gf180mcu_as_sc_mcu7t3v3__fillcap_8
XFILLER_164_1453 VDD VDD VSS VSS gf180mcu_as_sc_mcu7t3v3__fillcap_16
XFILLER_24_271 VDD VDD VSS VSS gf180mcu_as_sc_mcu7t3v3__fillcap_4
XFILLER_38_1467 VDD VDD VSS VSS gf180mcu_as_sc_mcu7t3v3__fillcap_16
XFILLER_77_1483 VDD VDD VSS VSS gf180mcu_as_sc_mcu7t3v3__fillcap_16
XTAP_TAPCELL_ROW_178_2177 VDD VSS gf180mcu_as_sc_mcu7t3v3__tap_2
XTAP_TAPCELL_ROW_178_2166 VDD VSS gf180mcu_as_sc_mcu7t3v3__tap_2
XFILLER_169_276 VDD VDD VSS VSS gf180mcu_as_sc_mcu7t3v3__fillcap_4
XFILLER_160_1339 VDD VDD VSS VSS gf180mcu_as_sc_mcu7t3v3__fill_2
XFILLER_169_298 VDD VDD VSS VSS gf180mcu_as_sc_mcu7t3v3__fillcap_16
XFILLER_165_482 VDD VDD VSS VSS gf180mcu_as_sc_mcu7t3v3__fillcap_8
XFILLER_172_419 VDD VDD VSS VSS gf180mcu_as_sc_mcu7t3v3__fillcap_16
XTAP_TAPCELL_ROW_152_1605 VDD VSS gf180mcu_as_sc_mcu7t3v3__tap_2
XFILLER_137_184 VDD VDD VSS VSS gf180mcu_as_sc_mcu7t3v3__fillcap_16
XFILLER_153_655 VDD VDD VSS VSS gf180mcu_as_sc_mcu7t3v3__fillcap_4
XFILLER_158_1246 VDD VDD VSS VSS gf180mcu_as_sc_mcu7t3v3__fill_2
XFILLER_3_120 VDD VDD VSS VSS gf180mcu_as_sc_mcu7t3v3__fillcap_16
XFILLER_153_699 VDD VDD VSS VSS gf180mcu_as_sc_mcu7t3v3__fill_1
XFILLER_175_1560 VDD VDD VSS VSS gf180mcu_as_sc_mcu7t3v3__fill_1
XFILLER_3_142 VDD VDD VSS VSS gf180mcu_as_sc_mcu7t3v3__fillcap_16
XFILLER_171_1402 VDD VDD VSS VSS gf180mcu_as_sc_mcu7t3v3__fillcap_4
XFILLER_181_72 VDD VDD VSS VSS gf180mcu_as_sc_mcu7t3v3__fillcap_16
XPHY_EDGE_ROW_95_1_Left_547 VDD VSS gf180mcu_as_sc_mcu7t3v3__tap_2
XFILLER_1_1521 VDD VDD VSS VSS gf180mcu_as_sc_mcu7t3v3__fillcap_16
XFILLER_74_81 VDD VDD VSS VSS gf180mcu_as_sc_mcu7t3v3__fillcap_8
XPHY_EDGE_ROW_53_3_Right_372 VDD VSS gf180mcu_as_sc_mcu7t3v3__tap_2
X_3990_ VDD VDD VSS VSS _3990_/A _4160_/C _4152_/C _4922_/Q _3991_/D gf180mcu_as_sc_mcu7t3v3__ao22_2
XFILLER_149_906 VDD VDD VSS VSS gf180mcu_as_sc_mcu7t3v3__fillcap_4
XFILLER_15_260 VDD VDD VSS VSS gf180mcu_as_sc_mcu7t3v3__fillcap_16
XFILLER_56_1534 VDD VDD VSS VSS gf180mcu_as_sc_mcu7t3v3__fillcap_16
XFILLER_56_1556 VDD VDD VSS VSS gf180mcu_as_sc_mcu7t3v3__fillcap_8
X_2941_ VDD VDD VSS VSS _3817_/C _3515_/A _3524_/A gf180mcu_as_sc_mcu7t3v3__nor2_2
XTAP_TAPCELL_ROW_76_1_940 VDD VSS gf180mcu_as_sc_mcu7t3v3__tap_2
XFILLER_15_282 VDD VDD VSS VSS gf180mcu_as_sc_mcu7t3v3__fillcap_16
XFILLER_30_241 VDD VDD VSS VSS gf180mcu_as_sc_mcu7t3v3__fillcap_4
XFILLER_30_263 VDD VDD VSS VSS gf180mcu_as_sc_mcu7t3v3__fillcap_16
XFILLER_90_80 VDD VDD VSS VSS gf180mcu_as_sc_mcu7t3v3__fillcap_8
X_4611_ VDD VDD VSS VSS _5205_/Q _4612_/B _4612_/C _5206_/Q _5205_/D gf180mcu_as_sc_mcu7t3v3__ao22_2
X_2872_ VDD VDD VSS VSS _4767_/Q _2882_/A _2873_/D gf180mcu_as_sc_mcu7t3v3__xnor2_2
X_4542_ VDD VDD VSS VSS _4546_/B _5083_/Q _4544_/S gf180mcu_as_sc_mcu7t3v3__nand2_2
XFILLER_172_942 VDD VDD VSS VSS gf180mcu_as_sc_mcu7t3v3__fill_2
X_4473_ VDD VDD VSS VSS _4476_/C _4988_/Q _4552_/A gf180mcu_as_sc_mcu7t3v3__nand2b_2
XFILLER_172_997 VDD VDD VSS VSS gf180mcu_as_sc_mcu7t3v3__fillcap_4
XFILLER_176_1379 VDD VDD VSS VSS gf180mcu_as_sc_mcu7t3v3__fill_2
X_3424_ VDD VDD VSS VSS _4075_/A _3424_/B _3424_/C _4822_/D _3699_/D gf180mcu_as_sc_mcu7t3v3__aoi211_2
XFILLER_143_198 VDD VDD VSS VSS gf180mcu_as_sc_mcu7t3v3__fill_1
XFILLER_174_1081 VDD VDD VSS VSS gf180mcu_as_sc_mcu7t3v3__fillcap_4
Xsram2048.u_bank1 _2672_/Y _2668_/Y wire461/Y wire464/Y wire465/Y wire462/Y _2629_/Y
+ wire463/Y wire466/Y hold1004/Y clkbuf_1_0__f_clk/Y wire477/Y wire478/Y wire479/Y
+ wire480/Y _2709_/Y _2702_/Y _2693_/Y _2686_/Y wire512/Y _2744_/B _2743_/B _2742_/B
+ _2741_/B _2740_/B _2739_/B _2738_/B _2478_/B sram2048.u_bank1/VDD sram2048.u_bank1/VSS
+ sram2048.u_bank1/WEN[7] sram2048.u_bank1/WEN[6] sram2048.u_bank1/WEN[5] sram2048.u_bank1/WEN[4]
+ sram2048.u_bank1/WEN[3] sram2048.u_bank1/WEN[2] sram2048.u_bank1/WEN[1] sram2048.u_bank1/WEN[0]
+ _2676_/Y gf180mcu_ocd_ip_sram__sram1024x8m8wm1
X_3355_ VDD VDD VSS VSS _3450_/B _4006_/D _3356_/D gf180mcu_as_sc_mcu7t3v3__and2_2
X_3286_ VDD VDD VSS VSS _3286_/Y _3286_/B _3526_/C gf180mcu_as_sc_mcu7t3v3__nor2_2
XFILLER_135_1098 VDD VDD VSS VSS gf180mcu_as_sc_mcu7t3v3__fillcap_16
X_5025_ VDD VDD VSS VSS _5183_/CLK _5025_/D _5025_/Q gf180mcu_as_sc_mcu7t3v3__dfxtp_2
XFILLER_53_300 VDD VDD VSS VSS gf180mcu_as_sc_mcu7t3v3__fill_1
XFILLER_148_1437 VDD VDD VSS VSS gf180mcu_as_sc_mcu7t3v3__fillcap_16
XFILLER_110_24 VDD VDD VSS VSS gf180mcu_as_sc_mcu7t3v3__fillcap_8
XFILLER_179_574 VDD VDD VSS VSS gf180mcu_as_sc_mcu7t3v3__fill_1
XFILLER_181_1052 VDD VDD VSS VSS gf180mcu_as_sc_mcu7t3v3__fillcap_4
XFILLER_139_438 VDD VDD VSS VSS gf180mcu_as_sc_mcu7t3v3__fillcap_4
XFILLER_142_1036 VDD VDD VSS VSS gf180mcu_as_sc_mcu7t3v3__fill_2
X_4809_ VDD VDD VSS VSS _5052_/CLK _4809_/D _4809_/Q gf180mcu_as_sc_mcu7t3v3__dfxtp_2
XTAP_TAPCELL_ROW_173_2063 VDD VSS gf180mcu_as_sc_mcu7t3v3__tap_2
XTAP_TAPCELL_ROW_173_2052 VDD VSS gf180mcu_as_sc_mcu7t3v3__tap_2
XFILLER_147_471 VDD VDD VSS VSS gf180mcu_as_sc_mcu7t3v3__fillcap_16
XFILLER_148_972 VDD VDD VSS VSS gf180mcu_as_sc_mcu7t3v3__fillcap_16
XFILLER_154_419 VDD VDD VSS VSS gf180mcu_as_sc_mcu7t3v3__fillcap_8
XFILLER_166_279 VDD VDD VSS VSS gf180mcu_as_sc_mcu7t3v3__fillcap_16
XFILLER_159_1522 VDD VDD VSS VSS gf180mcu_as_sc_mcu7t3v3__fillcap_16
XFILLER_163_942 VDD VDD VSS VSS gf180mcu_as_sc_mcu7t3v3__fillcap_16
XFILLER_119_88 VDD VDD VSS VSS gf180mcu_as_sc_mcu7t3v3__fillcap_4
XFILLER_135_688 VDD VDD VSS VSS gf180mcu_as_sc_mcu7t3v3__fillcap_8
XFILLER_150_603 VDD VDD VSS VSS gf180mcu_as_sc_mcu7t3v3__fill_1
XPHY_EDGE_ROW_12_3_Left_146 VDD VSS gf180mcu_as_sc_mcu7t3v3__tap_2
XFILLER_135_32 VDD VDD VSS VSS gf180mcu_as_sc_mcu7t3v3__fillcap_4
XFILLER_0_134 VDD VDD VSS VSS gf180mcu_as_sc_mcu7t3v3__fill_2
XFILLER_135_65 VDD VDD VSS VSS gf180mcu_as_sc_mcu7t3v3__fillcap_4
XFILLER_88_241 VDD VDD VSS VSS gf180mcu_as_sc_mcu7t3v3__fillcap_4
XFILLER_95_69 VDD VDD VSS VSS gf180mcu_as_sc_mcu7t3v3__fill_1
XTAP_TAPCELL_ROW_145_1442 VDD VSS gf180mcu_as_sc_mcu7t3v3__tap_2
XFILLER_151_64 VDD VDD VSS VSS gf180mcu_as_sc_mcu7t3v3__fillcap_4
XFILLER_28_85 VDD VDD VSS VSS gf180mcu_as_sc_mcu7t3v3__fillcap_16
XTAP_TAPCELL_ROW_145_1453 VDD VSS gf180mcu_as_sc_mcu7t3v3__tap_2
XFILLER_56_193 VDD VDD VSS VSS gf180mcu_as_sc_mcu7t3v3__fillcap_8
Xclkbuf_leaf_15_clk_regs VDD VDD VSS VSS clkbuf_3_3_0_clk_regs/Y _5159_/CLK gf180mcu_as_sc_mcu7t3v3__clkbuff_12
XFILLER_160_1103 VDD VDD VSS VSS gf180mcu_as_sc_mcu7t3v3__fillcap_4
XTAP_TAPCELL_ROW_126_3_2539 VDD VSS gf180mcu_as_sc_mcu7t3v3__tap_2
XFILLER_12_263 VDD VDD VSS VSS gf180mcu_as_sc_mcu7t3v3__fillcap_16
XFILLER_157_202 VDD VDD VSS VSS gf180mcu_as_sc_mcu7t3v3__fill_1
XFILLER_160_1136 VDD VDD VSS VSS gf180mcu_as_sc_mcu7t3v3__fillcap_16
XFILLER_103_1521 VDD VDD VSS VSS gf180mcu_as_sc_mcu7t3v3__fillcap_16
XFILLER_157_279 VDD VDD VSS VSS gf180mcu_as_sc_mcu7t3v3__fill_1
XFILLER_154_942 VDD VDD VSS VSS gf180mcu_as_sc_mcu7t3v3__fill_2
XFILLER_181_772 VDD VDD VSS VSS gf180mcu_as_sc_mcu7t3v3__fillcap_16
XFILLER_5_34 VDD VDD VSS VSS gf180mcu_as_sc_mcu7t3v3__fillcap_16
XTAP_TAPCELL_ROW_6_3_2358 VDD VSS gf180mcu_as_sc_mcu7t3v3__tap_2
XFILLER_125_198 VDD VDD VSS VSS gf180mcu_as_sc_mcu7t3v3__fill_1
XFILLER_140_124 VDD VDD VSS VSS gf180mcu_as_sc_mcu7t3v3__fillcap_16
XFILLER_158_1087 VDD VDD VSS VSS gf180mcu_as_sc_mcu7t3v3__fill_1
XFILLER_158_1098 VDD VDD VSS VSS gf180mcu_as_sc_mcu7t3v3__fillcap_8
XFILLER_79_241 VDD VDD VSS VSS gf180mcu_as_sc_mcu7t3v3__fillcap_16
XFILLER_39_116 VDD VDD VSS VSS gf180mcu_as_sc_mcu7t3v3__fill_2
X_3140_ VDD VDD VSS VSS _3753_/D _3140_/A _3140_/B _3140_/C _3141_/C gf180mcu_as_sc_mcu7t3v3__ao31_2
XTAP_TAPCELL_ROW_169_1976 VDD VSS gf180mcu_as_sc_mcu7t3v3__tap_2
XTAP_TAPCELL_ROW_169_1965 VDD VSS gf180mcu_as_sc_mcu7t3v3__tap_2
XFILLER_39_138 VDD VDD VSS VSS gf180mcu_as_sc_mcu7t3v3__fill_2
XFILLER_85_80 VDD VDD VSS VSS gf180mcu_as_sc_mcu7t3v3__fillcap_8
XFILLER_94_255 VDD VDD VSS VSS gf180mcu_as_sc_mcu7t3v3__fill_2
X_3071_ VDD VDD VSS VSS _4049_/A _3241_/B _3071_/C _3071_/D _3072_/C gf180mcu_as_sc_mcu7t3v3__ao22_2
XFILLER_35_300 VDD VDD VSS VSS gf180mcu_as_sc_mcu7t3v3__fill_1
XTAP_TAPCELL_ROW_131_1_1161 VDD VSS gf180mcu_as_sc_mcu7t3v3__tap_2
XFILLER_143_1301 VDD VDD VSS VSS gf180mcu_as_sc_mcu7t3v3__fillcap_16
XPHY_EDGE_ROW_54_3_Right_373 VDD VSS gf180mcu_as_sc_mcu7t3v3__tap_2
X_3973_ VDD VDD VSS VSS _3973_/A _4101_/B _4101_/C _3973_/D _3975_/C gf180mcu_as_sc_mcu7t3v3__ao22_2
XFILLER_149_725 VDD VDD VSS VSS gf180mcu_as_sc_mcu7t3v3__fillcap_16
XFILLER_176_533 VDD VDD VSS VSS gf180mcu_as_sc_mcu7t3v3__fill_1
X_2924_ VDD VDD VSS VSS _3530_/B _3512_/A _3521_/A gf180mcu_as_sc_mcu7t3v3__nor2_2
XFILLER_137_909 VDD VDD VSS VSS gf180mcu_as_sc_mcu7t3v3__fill_1
X_2855_ VDD VDD VSS VSS _2856_/B _2875_/B _2855_/A gf180mcu_as_sc_mcu7t3v3__nand2_2
XFILLER_163_216 VDD VDD VSS VSS gf180mcu_as_sc_mcu7t3v3__fill_1
XTAP_TAPCELL_ROW_111_1_1081 VDD VSS gf180mcu_as_sc_mcu7t3v3__tap_2
X_4525_ VDD VDD VSS VSS _4529_/B _5081_/Q _4559_/S gf180mcu_as_sc_mcu7t3v3__nand2_2
X_2786_ VDD VDD VSS VSS _4649_/B _2786_/B _2786_/C _2786_/D _2806_/A gf180mcu_as_sc_mcu7t3v3__ao211_2
XFILLER_160_901 VDD VDD VSS VSS gf180mcu_as_sc_mcu7t3v3__fill_1
XFILLER_176_1154 VDD VDD VSS VSS gf180mcu_as_sc_mcu7t3v3__fill_1
XFILLER_171_260 VDD VDD VSS VSS gf180mcu_as_sc_mcu7t3v3__fillcap_16
XFILLER_171_282 VDD VDD VSS VSS gf180mcu_as_sc_mcu7t3v3__fillcap_16
X_4456_ VDD VDD VSS VSS _4559_/S _5015_/Q _5044_/Q _4457_/B gf180mcu_as_sc_mcu7t3v3__mux2_2
XFILLER_172_1029 VDD VDD VSS VSS gf180mcu_as_sc_mcu7t3v3__fillcap_8
Xfanout703 VDD VDD VSS VSS _3152_/C _3127_/C gf180mcu_as_sc_mcu7t3v3__buff_2
Xfanout714 VDD VDD VSS VSS _2902_/Y _3153_/D gf180mcu_as_sc_mcu7t3v3__buff_2
X_4387_ VDD VDD VSS VSS _5166_/Q _4470_/B _4493_/C _5116_/Q _4388_/B gf180mcu_as_sc_mcu7t3v3__ao22_2
X_3407_ VDD VDD VSS VSS _3455_/B _3407_/B _3407_/C _3408_/C gf180mcu_as_sc_mcu7t3v3__nor3_2
Xfanout725 VDD VDD VSS VSS _3144_/B _3152_/B gf180mcu_as_sc_mcu7t3v3__buff_2
Xfanout736 VDD VDD VSS VSS _4187_/B _4197_/B gf180mcu_as_sc_mcu7t3v3__buff_2
Xfanout747 VDD VDD VSS VSS _5271_/Q _4739_/A gf180mcu_as_sc_mcu7t3v3__buff_2
Xfanout758 VDD VDD VSS VSS _4510_/A _4448_/A gf180mcu_as_sc_mcu7t3v3__buff_2
X_3338_ VDD VDD VSS VSS _3442_/B _3338_/B _3991_/A _3339_/C gf180mcu_as_sc_mcu7t3v3__mux2_2
XFILLER_105_35 VDD VDD VSS VSS gf180mcu_as_sc_mcu7t3v3__fill_2
XFILLER_105_57 VDD VDD VSS VSS gf180mcu_as_sc_mcu7t3v3__fill_1
XFILLER_140_691 VDD VDD VSS VSS gf180mcu_as_sc_mcu7t3v3__fillcap_4
Xfanout769 VDD VDD VSS VSS _4544_/S _4403_/S gf180mcu_as_sc_mcu7t3v3__buff_2
Xclkbuf_3_0_0_clk_regs VDD VDD VSS VSS clkbuf_0_clk_regs/Y clkbuf_3_0_0_clk_regs/Y
+ gf180mcu_as_sc_mcu7t3v3__clkbuff_12
X_3269_ VDD VDD VSS VSS _4915_/Q _3493_/B _3501_/B _3930_/A _3274_/C gf180mcu_as_sc_mcu7t3v3__ao22_2
XFILLER_38_171 VDD VDD VSS VSS gf180mcu_as_sc_mcu7t3v3__fillcap_4
XFILLER_45_119 VDD VDD VSS VSS gf180mcu_as_sc_mcu7t3v3__fillcap_16
XPHY_EDGE_ROW_169_Left_621 VDD VSS gf180mcu_as_sc_mcu7t3v3__tap_2
X_5008_ VDD VDD VSS VSS _5074_/CLK _5008_/D _5008_/Q gf180mcu_as_sc_mcu7t3v3__dfxtp_2
XFILLER_38_193 VDD VDD VSS VSS gf180mcu_as_sc_mcu7t3v3__fillcap_16
XFILLER_148_1267 VDD VDD VSS VSS gf180mcu_as_sc_mcu7t3v3__fill_2
XFILLER_81_27 VDD VDD VSS VSS gf180mcu_as_sc_mcu7t3v3__fillcap_8
XFILLER_148_1289 VDD VDD VSS VSS gf180mcu_as_sc_mcu7t3v3__fillcap_4
XTAP_TAPCELL_ROW_175_2114 VDD VSS gf180mcu_as_sc_mcu7t3v3__tap_2
XTAP_TAPCELL_ROW_175_2103 VDD VSS gf180mcu_as_sc_mcu7t3v3__tap_2
XFILLER_74_1486 VDD VDD VSS VSS gf180mcu_as_sc_mcu7t3v3__fillcap_16
XFILLER_167_544 VDD VDD VSS VSS gf180mcu_as_sc_mcu7t3v3__fill_2
XPHY_EDGE_ROW_178_Left_630 VDD VSS gf180mcu_as_sc_mcu7t3v3__tap_2
XFILLER_107_110 VDD VDD VSS VSS gf180mcu_as_sc_mcu7t3v3__fill_1
XFILLER_136_942 VDD VDD VSS VSS gf180mcu_as_sc_mcu7t3v3__fill_2
XPHY_EDGE_ROW_11_1_Right_10 VDD VSS gf180mcu_as_sc_mcu7t3v3__tap_2
XTAP_TAPCELL_ROW_138_1290 VDD VSS gf180mcu_as_sc_mcu7t3v3__tap_2
XFILLER_135_463 VDD VDD VSS VSS gf180mcu_as_sc_mcu7t3v3__fillcap_16
XFILLER_151_912 VDD VDD VSS VSS gf180mcu_as_sc_mcu7t3v3__fillcap_8
XFILLER_163_772 VDD VDD VSS VSS gf180mcu_as_sc_mcu7t3v3__fillcap_16
XFILLER_30_53 VDD VDD VSS VSS gf180mcu_as_sc_mcu7t3v3__fillcap_16
XFILLER_100_2 VDD VDD VSS VSS gf180mcu_as_sc_mcu7t3v3__fillcap_8
XFILLER_107_176 VDD VDD VSS VSS gf180mcu_as_sc_mcu7t3v3__fill_2
XFILLER_146_53 VDD VDD VSS VSS gf180mcu_as_sc_mcu7t3v3__fillcap_16
XFILLER_159_1396 VDD VDD VSS VSS gf180mcu_as_sc_mcu7t3v3__fillcap_4
XTAP_TAPCELL_ROW_67_1_904 VDD VSS gf180mcu_as_sc_mcu7t3v3__tap_2
XTAP_TAPCELL_ROW_134_1198 VDD VSS gf180mcu_as_sc_mcu7t3v3__tap_2
XTAP_TAPCELL_ROW_134_1187 VDD VSS gf180mcu_as_sc_mcu7t3v3__tap_2
XTAP_TAPCELL_ROW_134_1176 VDD VSS gf180mcu_as_sc_mcu7t3v3__tap_2
XFILLER_155_1249 VDD VDD VSS VSS gf180mcu_as_sc_mcu7t3v3__fillcap_8
XFILLER_133_1514 VDD VDD VSS VSS gf180mcu_as_sc_mcu7t3v3__fillcap_4
XFILLER_172_1563 VDD VDD VSS VSS gf180mcu_as_sc_mcu7t3v3__fillcap_4
XFILLER_76_211 VDD VDD VSS VSS gf180mcu_as_sc_mcu7t3v3__fill_1
XFILLER_162_85 VDD VDD VSS VSS gf180mcu_as_sc_mcu7t3v3__fillcap_16
XFILLER_76_255 VDD VDD VSS VSS gf180mcu_as_sc_mcu7t3v3__fillcap_4
XFILLER_17_300 VDD VDD VSS VSS gf180mcu_as_sc_mcu7t3v3__fill_1
XFILLER_91_236 VDD VDD VSS VSS gf180mcu_as_sc_mcu7t3v3__fillcap_16
XTAP_TAPCELL_ROW_164_1873 VDD VSS gf180mcu_as_sc_mcu7t3v3__tap_2
XTAP_TAPCELL_ROW_164_1862 VDD VSS gf180mcu_as_sc_mcu7t3v3__tap_2
XFILLER_55_72 VDD VDD VSS VSS gf180mcu_as_sc_mcu7t3v3__fillcap_4
XFILLER_166_1345 VDD VDD VSS VSS gf180mcu_as_sc_mcu7t3v3__fillcap_16
XFILLER_166_1367 VDD VDD VSS VSS gf180mcu_as_sc_mcu7t3v3__fillcap_8
XFILLER_92_1553 VDD VDD VSS VSS gf180mcu_as_sc_mcu7t3v3__fill_1
XFILLER_53_1515 VDD VDD VSS VSS gf180mcu_as_sc_mcu7t3v3__fillcap_4
XFILLER_53_1537 VDD VDD VSS VSS gf180mcu_as_sc_mcu7t3v3__fillcap_16
XFILLER_92_1564 VDD VDD VSS VSS gf180mcu_as_sc_mcu7t3v3__fillcap_4
XFILLER_140_1507 VDD VDD VSS VSS gf180mcu_as_sc_mcu7t3v3__fill_2
X_2640_ VDD VDD VSS VSS _2692_/S _2640_/B input5/Y _2641_/A gf180mcu_as_sc_mcu7t3v3__mux2_2
XTAP_TAPCELL_ROW_95_1_1014 VDD VSS gf180mcu_as_sc_mcu7t3v3__tap_2
XFILLER_173_558 VDD VDD VSS VSS gf180mcu_as_sc_mcu7t3v3__fill_2
XFILLER_142_901 VDD VDD VSS VSS gf180mcu_as_sc_mcu7t3v3__fillcap_4
XFILLER_177_1441 VDD VDD VSS VSS gf180mcu_as_sc_mcu7t3v3__fill_1
XFILLER_177_1452 VDD VDD VSS VSS gf180mcu_as_sc_mcu7t3v3__fill_2
Xoutput317 VDD VDD VSS VSS _5478_/Y dft_rdata[0] gf180mcu_as_sc_mcu7t3v3__buff_2
X_2571_ VDD VDD VSS VSS _2849_/A _2571_/B _2855_/A gf180mcu_as_sc_mcu7t3v3__nor2_2
XFILLER_141_422 VDD VDD VSS VSS gf180mcu_as_sc_mcu7t3v3__fillcap_16
XFILLER_153_282 VDD VDD VSS VSS gf180mcu_as_sc_mcu7t3v3__fillcap_16
XFILLER_173_1327 VDD VDD VSS VSS gf180mcu_as_sc_mcu7t3v3__fill_2
Xoutput339 VDD VDD VSS VSS _4861_/Q east_out[22] gf180mcu_as_sc_mcu7t3v3__buff_2
Xoutput328 VDD VDD VSS VSS _4851_/Q east_out[12] gf180mcu_as_sc_mcu7t3v3__buff_2
X_4310_ VDD VDD VSS VSS _4313_/S _5140_/Q _5139_/Q _5139_/D gf180mcu_as_sc_mcu7t3v3__mux2_2
XFILLER_141_455 VDD VDD VSS VSS gf180mcu_as_sc_mcu7t3v3__fillcap_16
X_4241_ VDD VDD VSS VSS _4248_/S _4241_/B _5077_/Q _5077_/D gf180mcu_as_sc_mcu7t3v3__mux2_2
XPHY_EDGE_ROW_39_1_Left_491 VDD VSS gf180mcu_as_sc_mcu7t3v3__tap_2
X_4172_ VDD VDD VSS VSS _4232_/B _4187_/B _4190_/C _5010_/Q _5010_/D gf180mcu_as_sc_mcu7t3v3__ao22_2
XFILLER_171_1095 VDD VDD VSS VSS gf180mcu_as_sc_mcu7t3v3__fillcap_8
XPHY_EDGE_ROW_155_Right_289 VDD VSS gf180mcu_as_sc_mcu7t3v3__tap_2
X_3123_ VDD VDD VSS VSS _3124_/B _3123_/B _3123_/C _3124_/C gf180mcu_as_sc_mcu7t3v3__nor3_2
X_3054_ VDD VDD VSS VSS _3121_/B _4927_/Q _3055_/D gf180mcu_as_sc_mcu7t3v3__or2_2
XFILLER_82_247 VDD VDD VSS VSS gf180mcu_as_sc_mcu7t3v3__fillcap_8
XFILLER_35_174 VDD VDD VSS VSS gf180mcu_as_sc_mcu7t3v3__fillcap_16
XFILLER_145_1418 VDD VDD VSS VSS gf180mcu_as_sc_mcu7t3v3__fillcap_8
XFILLER_184_1478 VDD VDD VSS VSS gf180mcu_as_sc_mcu7t3v3__fillcap_4
XPHY_EDGE_ROW_55_3_Right_374 VDD VSS gf180mcu_as_sc_mcu7t3v3__tap_2
X_3956_ VDD VDD VSS VSS _3956_/A _4160_/B _4161_/B _3956_/D _3957_/D gf180mcu_as_sc_mcu7t3v3__ao22_2
XFILLER_50_177 VDD VDD VSS VSS gf180mcu_as_sc_mcu7t3v3__fillcap_4
XFILLER_50_188 VDD VDD VSS VSS gf180mcu_as_sc_mcu7t3v3__fillcap_16
X_2907_ VDD VDD VSS VSS _3510_/A _3519_/A _3245_/C gf180mcu_as_sc_mcu7t3v3__or2_2
XFILLER_137_739 VDD VDD VSS VSS gf180mcu_as_sc_mcu7t3v3__fillcap_8
X_3887_ VDD VDD VSS VSS _4946_/D _5177_/Q _4927_/D gf180mcu_as_sc_mcu7t3v3__and2_2
XTAP_TAPCELL_ROW_170_2000 VDD VSS gf180mcu_as_sc_mcu7t3v3__tap_2
XFILLER_121_1451 VDD VDD VSS VSS gf180mcu_as_sc_mcu7t3v3__fillcap_16
X_2838_ VDD VDD VSS VSS _2839_/B _2838_/B _5124_/Q gf180mcu_as_sc_mcu7t3v3__nor2_2
XFILLER_145_772 VDD VDD VSS VSS gf180mcu_as_sc_mcu7t3v3__fillcap_16
XFILLER_164_569 VDD VDD VSS VSS gf180mcu_as_sc_mcu7t3v3__fillcap_16
X_2769_ VDD VDD VSS VSS _5124_/Q _2838_/B _2845_/B _2770_/D gf180mcu_as_sc_mcu7t3v3__nand3_2
XFILLER_156_1503 VDD VDD VSS VSS gf180mcu_as_sc_mcu7t3v3__fill_2
XFILLER_160_731 VDD VDD VSS VSS gf180mcu_as_sc_mcu7t3v3__fillcap_4
X_4508_ VDD VDD VSS VSS _4511_/C _4992_/Q _4544_/S gf180mcu_as_sc_mcu7t3v3__nand2b_2
X_4439_ VDD VDD VSS VSS _4440_/D _4439_/B _4520_/A gf180mcu_as_sc_mcu7t3v3__nor2_2
XFILLER_116_45 VDD VDD VSS VSS gf180mcu_as_sc_mcu7t3v3__fillcap_16
Xfanout500 VDD VDD VSS VSS _3559_/Y _3803_/B gf180mcu_as_sc_mcu7t3v3__buff_2
Xfanout511 VDD VDD VSS VSS _3284_/Y _3455_/B gf180mcu_as_sc_mcu7t3v3__buff_2
Xfanout522 VDD VDD VSS VSS _4574_/B _4592_/B gf180mcu_as_sc_mcu7t3v3__buff_2
Xfanout533 VDD VDD VSS VSS _4115_/B _4099_/B gf180mcu_as_sc_mcu7t3v3__buff_2
Xfanout544 VDD VDD VSS VSS _3523_/B _3514_/B gf180mcu_as_sc_mcu7t3v3__buff_2
Xfanout555 VDD VDD VSS VSS _3182_/B _3156_/A gf180mcu_as_sc_mcu7t3v3__buff_2
Xfanout566 VDD VDD VSS VSS fanout569/Y _4127_/B gf180mcu_as_sc_mcu7t3v3__buff_2
XFILLER_150_1157 VDD VDD VSS VSS gf180mcu_as_sc_mcu7t3v3__fillcap_16
Xfanout577 VDD VDD VSS VSS _3750_/C _3791_/B gf180mcu_as_sc_mcu7t3v3__buff_2
Xfanout588 VDD VDD VSS VSS _4566_/B _4496_/B gf180mcu_as_sc_mcu7t3v3__buff_2
Xfanout599 VDD VDD VSS VSS fanout602/Y _4126_/B gf180mcu_as_sc_mcu7t3v3__buff_2
XFILLER_58_288 VDD VDD VSS VSS gf180mcu_as_sc_mcu7t3v3__fillcap_8
XFILLER_73_247 VDD VDD VSS VSS gf180mcu_as_sc_mcu7t3v3__fillcap_4
XFILLER_132_88 VDD VDD VSS VSS gf180mcu_as_sc_mcu7t3v3__fillcap_4
XFILLER_148_1042 VDD VDD VSS VSS gf180mcu_as_sc_mcu7t3v3__fillcap_8
XFILLER_92_37 VDD VDD VSS VSS gf180mcu_as_sc_mcu7t3v3__fill_1
XFILLER_148_2 VDD VDD VSS VSS gf180mcu_as_sc_mcu7t3v3__fillcap_8
XFILLER_41_144 VDD VDD VSS VSS gf180mcu_as_sc_mcu7t3v3__fill_1
XFILLER_167_330 VDD VDD VSS VSS gf180mcu_as_sc_mcu7t3v3__fillcap_16
XFILLER_179_190 VDD VDD VSS VSS gf180mcu_as_sc_mcu7t3v3__fillcap_16
XFILLER_41_188 VDD VDD VSS VSS gf180mcu_as_sc_mcu7t3v3__fillcap_16
XFILLER_127_205 VDD VDD VSS VSS gf180mcu_as_sc_mcu7t3v3__fillcap_4
XFILLER_167_352 VDD VDD VSS VSS gf180mcu_as_sc_mcu7t3v3__fillcap_16
XFILLER_100_1502 VDD VDD VSS VSS gf180mcu_as_sc_mcu7t3v3__fillcap_16
XFILLER_13_1521 VDD VDD VSS VSS gf180mcu_as_sc_mcu7t3v3__fillcap_16
XFILLER_182_311 VDD VDD VSS VSS gf180mcu_as_sc_mcu7t3v3__fillcap_4
XFILLER_182_333 VDD VDD VSS VSS gf180mcu_as_sc_mcu7t3v3__fillcap_16
XTAP_TAPCELL_ROW_136_1249 VDD VSS gf180mcu_as_sc_mcu7t3v3__tap_2
XTAP_TAPCELL_ROW_136_1238 VDD VSS gf180mcu_as_sc_mcu7t3v3__tap_2
XFILLER_170_517 VDD VDD VSS VSS gf180mcu_as_sc_mcu7t3v3__fill_2
XFILLER_100_1568 VDD VDD VSS VSS gf180mcu_as_sc_mcu7t3v3__fill_1
XFILLER_159_1160 VDD VDD VSS VSS gf180mcu_as_sc_mcu7t3v3__fill_2
XFILLER_135_282 VDD VDD VSS VSS gf180mcu_as_sc_mcu7t3v3__fill_2
XFILLER_151_731 VDD VDD VSS VSS gf180mcu_as_sc_mcu7t3v3__fill_2
XTAP_TAPCELL_ROW_26_3_2389 VDD VSS gf180mcu_as_sc_mcu7t3v3__tap_2
XFILLER_150_241 VDD VDD VSS VSS gf180mcu_as_sc_mcu7t3v3__fillcap_4
XFILLER_150_263 VDD VDD VSS VSS gf180mcu_as_sc_mcu7t3v3__fillcap_4
XFILLER_1_295 VDD VDD VSS VSS gf180mcu_as_sc_mcu7t3v3__fillcap_4
XTAP_TAPCELL_ROW_49_1_833 VDD VSS gf180mcu_as_sc_mcu7t3v3__tap_2
XTAP_TAPCELL_ROW_166_1913 VDD VSS gf180mcu_as_sc_mcu7t3v3__tap_2
XTAP_TAPCELL_ROW_166_1902 VDD VSS gf180mcu_as_sc_mcu7t3v3__tap_2
Xclkbuf_leaf_30_clk_regs VDD VDD VSS VSS clkbuf_3_4_0_clk_regs/Y _4863_/CLK gf180mcu_as_sc_mcu7t3v3__clkbuff_12
XFILLER_64_247 VDD VDD VSS VSS gf180mcu_as_sc_mcu7t3v3__fillcap_16
XFILLER_17_174 VDD VDD VSS VSS gf180mcu_as_sc_mcu7t3v3__fillcap_16
XFILLER_162_1017 VDD VDD VSS VSS gf180mcu_as_sc_mcu7t3v3__fillcap_16
XFILLER_178_639 VDD VDD VSS VSS gf180mcu_as_sc_mcu7t3v3__fillcap_8
XFILLER_32_155 VDD VDD VSS VSS gf180mcu_as_sc_mcu7t3v3__fillcap_16
X_4790_ VDD VDD VSS VSS _4858_/CLK _4790_/D _4790_/Q gf180mcu_as_sc_mcu7t3v3__dfxtp_2
X_3810_ VDD VDD VSS VSS _3927_/A _3922_/B _3922_/A gf180mcu_as_sc_mcu7t3v3__nand2_2
XFILLER_144_1451 VDD VDD VSS VSS gf180mcu_as_sc_mcu7t3v3__fillcap_4
XFILLER_159_842 VDD VDD VSS VSS gf180mcu_as_sc_mcu7t3v3__fillcap_4
XFILLER_32_177 VDD VDD VSS VSS gf180mcu_as_sc_mcu7t3v3__fillcap_16
X_3741_ VDD VDD VSS VSS _4121_/A _3741_/B _3741_/C _4121_/D _3742_/D gf180mcu_as_sc_mcu7t3v3__ao22_2
XFILLER_144_1473 VDD VDD VSS VSS gf180mcu_as_sc_mcu7t3v3__fillcap_8
XFILLER_144_1495 VDD VDD VSS VSS gf180mcu_as_sc_mcu7t3v3__fillcap_8
XPHY_EDGE_ROW_4_1_Right_3 VDD VSS gf180mcu_as_sc_mcu7t3v3__tap_2
X_3672_ VDD VDD VSS VSS _4046_/D _3779_/B _3672_/C _3672_/D _3674_/C gf180mcu_as_sc_mcu7t3v3__ao211_2
XFILLER_179_1558 VDD VDD VSS VSS gf180mcu_as_sc_mcu7t3v3__fillcap_4
X_2623_ VDD VDD VSS VSS _2624_/C _2644_/B _5262_/Q gf180mcu_as_sc_mcu7t3v3__nor2_2
XFILLER_133_208 VDD VDD VSS VSS gf180mcu_as_sc_mcu7t3v3__fill_2
X_2554_ VDD VDD VSS VSS _4634_/A _2838_/B _2554_/C _2558_/B _2765_/B gf180mcu_as_sc_mcu7t3v3__aoi31_2
XFILLER_126_293 VDD VDD VSS VSS gf180mcu_as_sc_mcu7t3v3__fillcap_8
XFILLER_142_731 VDD VDD VSS VSS gf180mcu_as_sc_mcu7t3v3__fillcap_4
XFILLER_173_1135 VDD VDD VSS VSS gf180mcu_as_sc_mcu7t3v3__fill_1
XFILLER_99_133 VDD VDD VSS VSS gf180mcu_as_sc_mcu7t3v3__fillcap_4
XFILLER_99_144 VDD VDD VSS VSS gf180mcu_as_sc_mcu7t3v3__fill_1
XFILLER_141_241 VDD VDD VSS VSS gf180mcu_as_sc_mcu7t3v3__fillcap_8
XFILLER_141_263 VDD VDD VSS VSS gf180mcu_as_sc_mcu7t3v3__fillcap_16
XFILLER_99_166 VDD VDD VSS VSS gf180mcu_as_sc_mcu7t3v3__fillcap_8
X_5273_ VDD VDD VSS VSS clkload4/A _5273_/D _5273_/Q gf180mcu_as_sc_mcu7t3v3__dfxtp_2
X_2485_ VDD VDD VSS VSS _5227_/Q _5226_/Q _2806_/D gf180mcu_as_sc_mcu7t3v3__or2_2
XFILLER_101_138 VDD VDD VSS VSS gf180mcu_as_sc_mcu7t3v3__fill_2
XFILLER_99_188 VDD VDD VSS VSS gf180mcu_as_sc_mcu7t3v3__fillcap_8
X_4224_ VDD VDD VSS VSS _4253_/B _4228_/B _4228_/C _5060_/Q _5060_/D gf180mcu_as_sc_mcu7t3v3__ao22_2
XFILLER_99_1515 VDD VDD VSS VSS gf180mcu_as_sc_mcu7t3v3__fillcap_4
X_4155_ VDD VDD VSS VSS _4155_/A _4163_/B _4155_/C _4155_/D _4156_/B gf180mcu_as_sc_mcu7t3v3__ao211_2
XFILLER_151_1499 VDD VDD VSS VSS gf180mcu_as_sc_mcu7t3v3__fill_1
XFILLER_55_203 VDD VDD VSS VSS gf180mcu_as_sc_mcu7t3v3__fillcap_4
XFILLER_99_1537 VDD VDD VSS VSS gf180mcu_as_sc_mcu7t3v3__fillcap_16
X_3106_ VDD VDD VSS VSS _3706_/D _3194_/S _3106_/B _3106_/C _3107_/C gf180mcu_as_sc_mcu7t3v3__ao31_2
XFILLER_55_247 VDD VDD VSS VSS gf180mcu_as_sc_mcu7t3v3__fillcap_4
X_4086_ VDD VDD VSS VSS _4086_/A _4104_/B _4099_/B _4086_/D _4090_/A gf180mcu_as_sc_mcu7t3v3__ao211_2
X_3037_ VDD VDD VSS VSS _3145_/A _3037_/B _3037_/C _3145_/D _3038_/D gf180mcu_as_sc_mcu7t3v3__ao211_2
XFILLER_169_628 VDD VDD VSS VSS gf180mcu_as_sc_mcu7t3v3__fill_2
XFILLER_178_18 VDD VDD VSS VSS gf180mcu_as_sc_mcu7t3v3__fillcap_16
XPHY_EDGE_ROW_21_3_Left_155 VDD VSS gf180mcu_as_sc_mcu7t3v3__tap_2
X_4904__963 VDD VDD VSS VSS _4904_/D gf180mcu_as_sc_mcu7t3v3__tiel_4
XFILLER_145_1259 VDD VDD VSS VSS gf180mcu_as_sc_mcu7t3v3__fill_1
X_4988_ VDD VDD VSS VSS _5084_/CLK _4988_/D _4988_/Q gf180mcu_as_sc_mcu7t3v3__dfxtp_2
XFILLER_149_352 VDD VDD VSS VSS gf180mcu_as_sc_mcu7t3v3__fillcap_4
XFILLER_183_119 VDD VDD VSS VSS gf180mcu_as_sc_mcu7t3v3__fill_1
XFILLER_71_1467 VDD VDD VSS VSS gf180mcu_as_sc_mcu7t3v3__fillcap_16
XPHY_EDGE_ROW_56_3_Right_375 VDD VSS gf180mcu_as_sc_mcu7t3v3__tap_2
X_3939_ VDD VDD VSS VSS _3939_/A _4162_/B _4110_/C _3944_/C _3939_/D gf180mcu_as_sc_mcu7t3v3__aoi211_2
XFILLER_164_333 VDD VDD VSS VSS gf180mcu_as_sc_mcu7t3v3__fill_2
XFILLER_176_171 VDD VDD VSS VSS gf180mcu_as_sc_mcu7t3v3__fillcap_4
XFILLER_176_193 VDD VDD VSS VSS gf180mcu_as_sc_mcu7t3v3__fillcap_16
XFILLER_178_1013 VDD VDD VSS VSS gf180mcu_as_sc_mcu7t3v3__fill_2
XFILLER_137_558 VDD VDD VSS VSS gf180mcu_as_sc_mcu7t3v3__fill_2
XFILLER_117_260 VDD VDD VSS VSS gf180mcu_as_sc_mcu7t3v3__fillcap_8
XFILLER_11_66 VDD VDD VSS VSS gf180mcu_as_sc_mcu7t3v3__fillcap_4
XFILLER_180_837 VDD VDD VSS VSS gf180mcu_as_sc_mcu7t3v3__fillcap_4
XFILLER_117_282 VDD VDD VSS VSS gf180mcu_as_sc_mcu7t3v3__fillcap_16
XFILLER_11_88 VDD VDD VSS VSS gf180mcu_as_sc_mcu7t3v3__fillcap_16
XTAP_TAPCELL_ROW_89_1_993 VDD VSS gf180mcu_as_sc_mcu7t3v3__tap_2
XFILLER_127_88 VDD VDD VSS VSS gf180mcu_as_sc_mcu7t3v3__fillcap_16
XFILLER_132_241 VDD VDD VSS VSS gf180mcu_as_sc_mcu7t3v3__fillcap_4
XFILLER_132_263 VDD VDD VSS VSS gf180mcu_as_sc_mcu7t3v3__fillcap_4
XFILLER_160_561 VDD VDD VSS VSS gf180mcu_as_sc_mcu7t3v3__fillcap_16
XFILLER_87_37 VDD VDD VSS VSS gf180mcu_as_sc_mcu7t3v3__fill_1
XFILLER_156_1399 VDD VDD VSS VSS gf180mcu_as_sc_mcu7t3v3__fillcap_16
XFILLER_160_594 VDD VDD VSS VSS gf180mcu_as_sc_mcu7t3v3__fill_1
XTAP_TAPCELL_ROW_183_2279 VDD VSS gf180mcu_as_sc_mcu7t3v3__tap_2
XFILLER_100_193 VDD VDD VSS VSS gf180mcu_as_sc_mcu7t3v3__fillcap_4
XFILLER_46_236 VDD VDD VSS VSS gf180mcu_as_sc_mcu7t3v3__fillcap_8
XFILLER_46_247 VDD VDD VSS VSS gf180mcu_as_sc_mcu7t3v3__fillcap_16
XFILLER_36_85 VDD VDD VSS VSS gf180mcu_as_sc_mcu7t3v3__fillcap_16
XFILLER_54_280 VDD VDD VSS VSS gf180mcu_as_sc_mcu7t3v3__fillcap_16
XFILLER_14_155 VDD VDD VSS VSS gf180mcu_as_sc_mcu7t3v3__fillcap_16
XFILLER_14_177 VDD VDD VSS VSS gf180mcu_as_sc_mcu7t3v3__fillcap_16
XFILLER_168_650 VDD VDD VSS VSS gf180mcu_as_sc_mcu7t3v3__fill_2
XFILLER_50_1518 VDD VDD VSS VSS gf180mcu_as_sc_mcu7t3v3__fillcap_16
XTAP_TAPCELL_ROW_159_1761 VDD VSS gf180mcu_as_sc_mcu7t3v3__tap_2
XTAP_TAPCELL_ROW_159_1750 VDD VSS gf180mcu_as_sc_mcu7t3v3__tap_2
XFILLER_156_823 VDD VDD VSS VSS gf180mcu_as_sc_mcu7t3v3__fillcap_16
Xinput16 VDD VDD VSS VSS boot_data[4] _2715_/A gf180mcu_as_sc_mcu7t3v3__buff_2
Xinput27 VDD VDD VSS VSS dft_addr[4] _2420_/A gf180mcu_as_sc_mcu7t3v3__buff_2
Xinput49 VDD VDD VSS VSS east_in[14] _4046_/D gf180mcu_as_sc_mcu7t3v3__buff_2
Xinput38 VDD VDD VSS VSS dft_wdata[3] _2709_/B gf180mcu_as_sc_mcu7t3v3__buff_2
XTAP_TAPCELL_ROW_155_1669 VDD VSS gf180mcu_as_sc_mcu7t3v3__tap_2
XTAP_TAPCELL_ROW_155_1658 VDD VSS gf180mcu_as_sc_mcu7t3v3__tap_2
XFILLER_155_377 VDD VDD VSS VSS gf180mcu_as_sc_mcu7t3v3__fillcap_8
XFILLER_157_1108 VDD VDD VSS VSS gf180mcu_as_sc_mcu7t3v3__fill_1
XFILLER_139_1542 VDD VDD VSS VSS gf180mcu_as_sc_mcu7t3v3__fill_2
XFILLER_123_241 VDD VDD VSS VSS gf180mcu_as_sc_mcu7t3v3__fillcap_8
XFILLER_184_94 VDD VDD VSS VSS gf180mcu_as_sc_mcu7t3v3__fill_2
XFILLER_168_1259 VDD VDD VSS VSS gf180mcu_as_sc_mcu7t3v3__fillcap_8
XFILLER_59_1521 VDD VDD VSS VSS gf180mcu_as_sc_mcu7t3v3__fillcap_16
XFILLER_111_1483 VDD VDD VSS VSS gf180mcu_as_sc_mcu7t3v3__fillcap_16
XFILLER_93_91 VDD VDD VSS VSS gf180mcu_as_sc_mcu7t3v3__fill_1
X_4911_ VDD VDD VSS VSS _4943_/CLK _4911_/D _4911_/Q gf180mcu_as_sc_mcu7t3v3__dfxtp_2
XFILLER_146_1535 VDD VDD VSS VSS gf180mcu_as_sc_mcu7t3v3__fillcap_4
XFILLER_178_403 VDD VDD VSS VSS gf180mcu_as_sc_mcu7t3v3__fillcap_16
XFILLER_179_948 VDD VDD VSS VSS gf180mcu_as_sc_mcu7t3v3__fill_1
XFILLER_94_1467 VDD VDD VSS VSS gf180mcu_as_sc_mcu7t3v3__fillcap_16
X_4842_ VDD VDD VSS VSS _4863_/CLK _4842_/D _4842_/Q gf180mcu_as_sc_mcu7t3v3__dfxtp_2
X_4773_ VDD VDD VSS VSS _4867_/CLK _4773_/D _4773_/Q gf180mcu_as_sc_mcu7t3v3__dfxtp_2
XFILLER_146_311 VDD VDD VSS VSS gf180mcu_as_sc_mcu7t3v3__fillcap_4
XFILLER_158_171 VDD VDD VSS VSS gf180mcu_as_sc_mcu7t3v3__fillcap_4
XFILLER_179_1311 VDD VDD VSS VSS gf180mcu_as_sc_mcu7t3v3__fillcap_8
X_3724_ VDD VDD VSS VSS _4103_/A _3741_/B _3740_/C _4102_/A _3725_/C gf180mcu_as_sc_mcu7t3v3__ao22_2
XFILLER_158_193 VDD VDD VSS VSS gf180mcu_as_sc_mcu7t3v3__fillcap_8
XFILLER_174_664 VDD VDD VSS VSS gf180mcu_as_sc_mcu7t3v3__fill_1
XFILLER_31_1451 VDD VDD VSS VSS gf180mcu_as_sc_mcu7t3v3__fillcap_16
X_3655_ VDD VDD VSS VSS _4927_/Q _3719_/B _3716_/C _4029_/A _3657_/C gf180mcu_as_sc_mcu7t3v3__ao22_2
XFILLER_134_539 VDD VDD VSS VSS gf180mcu_as_sc_mcu7t3v3__fillcap_4
XFILLER_161_303 VDD VDD VSS VSS gf180mcu_as_sc_mcu7t3v3__fillcap_4
XFILLER_173_174 VDD VDD VSS VSS gf180mcu_as_sc_mcu7t3v3__fillcap_16
X_2606_ VDD VDD VSS VSS _2606_/B _4766_/Q _2608_/B gf180mcu_as_sc_mcu7t3v3__xnor2_2
XFILLER_161_358 VDD VDD VSS VSS gf180mcu_as_sc_mcu7t3v3__fill_1
XFILLER_179_1399 VDD VDD VSS VSS gf180mcu_as_sc_mcu7t3v3__fill_1
X_3586_ VDD VDD VSS VSS _3587_/C _3586_/C _3802_/B _3952_/A gf180mcu_as_sc_mcu7t3v3__aoi21_2
XFILLER_170_870 VDD VDD VSS VSS gf180mcu_as_sc_mcu7t3v3__fillcap_4
X_2537_ VDD VDD VSS VSS _4364_/A _4370_/A _4364_/B _4365_/A gf180mcu_as_sc_mcu7t3v3__nand3_2
XTAP_TAPCELL_ROW_77_1_942 VDD VSS gf180mcu_as_sc_mcu7t3v3__tap_2
XFILLER_142_583 VDD VDD VSS VSS gf180mcu_as_sc_mcu7t3v3__fill_1
XFILLER_153_1539 VDD VDD VSS VSS gf180mcu_as_sc_mcu7t3v3__fill_1
XFILLER_87_136 VDD VDD VSS VSS gf180mcu_as_sc_mcu7t3v3__fillcap_4
X_5256_ VDD VDD VSS VSS _5266_/CLK _5256_/D _5256_/Q gf180mcu_as_sc_mcu7t3v3__dfxtp_2
X_2468_ VDD VDD VSS VSS _2469_/C _4341_/S _5034_/Q _4448_/A gf180mcu_as_sc_mcu7t3v3__ao21_2
X_4207_ VDD VDD VSS VSS _4236_/B _4228_/B _4228_/C _5043_/Q _5043_/D gf180mcu_as_sc_mcu7t3v3__ao22_2
XFILLER_151_1274 VDD VDD VSS VSS gf180mcu_as_sc_mcu7t3v3__fill_2
X_5187_ VDD VDD VSS VSS _5188_/CLK _5187_/D _5187_/Q gf180mcu_as_sc_mcu7t3v3__dfxtp_2
X_2399_ VDD VDD VSS VSS _2802_/A _5227_/Q gf180mcu_as_sc_mcu7t3v3__inv_2
XFILLER_113_35 VDD VDD VSS VSS gf180mcu_as_sc_mcu7t3v3__fill_2
XFILLER_28_225 VDD VDD VSS VSS gf180mcu_as_sc_mcu7t3v3__fillcap_16
XFILLER_28_247 VDD VDD VSS VSS gf180mcu_as_sc_mcu7t3v3__fillcap_16
X_4138_ VDD VDD VSS VSS _4138_/A _4159_/B _4159_/C _4138_/D _4139_/D gf180mcu_as_sc_mcu7t3v3__ao22_2
XPHY_EDGE_ROW_142_Left_594 VDD VSS gf180mcu_as_sc_mcu7t3v3__tap_2
X_4069_ VDD VDD VSS VSS _4069_/A _4104_/C _4101_/B _4069_/D _4070_/D gf180mcu_as_sc_mcu7t3v3__ao22_2
XFILLER_43_228 VDD VDD VSS VSS gf180mcu_as_sc_mcu7t3v3__fillcap_16
XTAP_TAPCELL_ROW_130_1_1157 VDD VSS gf180mcu_as_sc_mcu7t3v3__tap_2
XFILLER_145_1034 VDD VDD VSS VSS gf180mcu_as_sc_mcu7t3v3__fillcap_4
XFILLER_145_1045 VDD VDD VSS VSS gf180mcu_as_sc_mcu7t3v3__fillcap_4
Xsram2048.u_bank0_813 VDD VDD VSS VSS sram2048.u_bank0/WEN[3] gf180mcu_as_sc_mcu7t3v3__tiel_4
XFILLER_11_136 VDD VDD VSS VSS gf180mcu_as_sc_mcu7t3v3__fillcap_4
XFILLER_11_158 VDD VDD VSS VSS gf180mcu_as_sc_mcu7t3v3__fillcap_16
XPHY_EDGE_ROW_57_3_Right_376 VDD VSS gf180mcu_as_sc_mcu7t3v3__tap_2
XFILLER_10_1502 VDD VDD VSS VSS gf180mcu_as_sc_mcu7t3v3__fillcap_16
XFILLER_153_804 VDD VDD VSS VSS gf180mcu_as_sc_mcu7t3v3__fillcap_4
XTAP_TAPCELL_ROW_110_1_1077 VDD VSS gf180mcu_as_sc_mcu7t3v3__tap_2
XFILLER_152_314 VDD VDD VSS VSS gf180mcu_as_sc_mcu7t3v3__fill_1
XFILLER_153_837 VDD VDD VSS VSS gf180mcu_as_sc_mcu7t3v3__fill_2
XFILLER_98_14 VDD VDD VSS VSS gf180mcu_as_sc_mcu7t3v3__fill_2
XFILLER_10_1568 VDD VDD VSS VSS gf180mcu_as_sc_mcu7t3v3__fill_1
XFILLER_180_667 VDD VDD VSS VSS gf180mcu_as_sc_mcu7t3v3__fillcap_8
XFILLER_105_230 VDD VDD VSS VSS gf180mcu_as_sc_mcu7t3v3__fill_1
XFILLER_105_241 VDD VDD VSS VSS gf180mcu_as_sc_mcu7t3v3__fillcap_16
XFILLER_156_1152 VDD VDD VSS VSS gf180mcu_as_sc_mcu7t3v3__fill_2
XTAP_TAPCELL_ROW_150_1566 VDD VSS gf180mcu_as_sc_mcu7t3v3__tap_2
XTAP_TAPCELL_ROW_150_1555 VDD VSS gf180mcu_as_sc_mcu7t3v3__tap_2
XFILLER_160_380 VDD VDD VSS VSS gf180mcu_as_sc_mcu7t3v3__fillcap_4
XFILLER_120_244 VDD VDD VSS VSS gf180mcu_as_sc_mcu7t3v3__fill_1
XFILLER_154_97 VDD VDD VSS VSS gf180mcu_as_sc_mcu7t3v3__fillcap_8
XFILLER_47_40 VDD VDD VSS VSS gf180mcu_as_sc_mcu7t3v3__fillcap_4
XTAP_TAPCELL_ROW_19_1_711 VDD VSS gf180mcu_as_sc_mcu7t3v3__tap_2
XPHY_EDGE_ROW_6_3_Left_140 VDD VSS gf180mcu_as_sc_mcu7t3v3__tap_2
XFILLER_170_85 VDD VDD VSS VSS gf180mcu_as_sc_mcu7t3v3__fillcap_16
XFILLER_179_50 VDD VDD VSS VSS gf180mcu_as_sc_mcu7t3v3__fillcap_16
XFILLER_63_72 VDD VDD VSS VSS gf180mcu_as_sc_mcu7t3v3__fillcap_16
XFILLER_63_94 VDD VDD VSS VSS gf180mcu_as_sc_mcu7t3v3__fill_1
XFILLER_179_72 VDD VDD VSS VSS gf180mcu_as_sc_mcu7t3v3__fillcap_16
XFILLER_54_1451 VDD VDD VSS VSS gf180mcu_as_sc_mcu7t3v3__fillcap_16
XTAP_TAPCELL_ROW_157_1709 VDD VSS gf180mcu_as_sc_mcu7t3v3__tap_2
XFILLER_180_1481 VDD VDD VSS VSS gf180mcu_as_sc_mcu7t3v3__fill_2
XFILLER_8_34 VDD VDD VSS VSS gf180mcu_as_sc_mcu7t3v3__fill_1
XFILLER_156_664 VDD VDD VSS VSS gf180mcu_as_sc_mcu7t3v3__fill_1
XFILLER_144_837 VDD VDD VSS VSS gf180mcu_as_sc_mcu7t3v3__fillcap_4
XFILLER_184_984 VDD VDD VSS VSS gf180mcu_as_sc_mcu7t3v3__fill_2
XFILLER_171_656 VDD VDD VSS VSS gf180mcu_as_sc_mcu7t3v3__fill_1
XFILLER_176_1539 VDD VDD VSS VSS gf180mcu_as_sc_mcu7t3v3__fill_2
XFILLER_183_494 VDD VDD VSS VSS gf180mcu_as_sc_mcu7t3v3__fill_1
X_3440_ VDD VDD VSS VSS _4935_/Q _3440_/B _3440_/C _4095_/A _3441_/C gf180mcu_as_sc_mcu7t3v3__ao22_2
XFILLER_170_155 VDD VDD VSS VSS gf180mcu_as_sc_mcu7t3v3__fillcap_16
XFILLER_171_667 VDD VDD VSS VSS gf180mcu_as_sc_mcu7t3v3__fillcap_8
X_3371_ VDD VDD VSS VSS _3442_/B _4024_/A _3372_/D gf180mcu_as_sc_mcu7t3v3__or2_2
XFILLER_170_177 VDD VDD VSS VSS gf180mcu_as_sc_mcu7t3v3__fillcap_16
XFILLER_88_80 VDD VDD VSS VSS gf180mcu_as_sc_mcu7t3v3__fillcap_8
X_5110_ VDD VDD VSS VSS _5186_/CLK _5110_/D _5110_/Q gf180mcu_as_sc_mcu7t3v3__dfxtp_2
XPHY_EDGE_ROW_67_1_Left_519 VDD VSS gf180mcu_as_sc_mcu7t3v3__tap_2
X_5041_ VDD VDD VSS VSS _5084_/CLK _5041_/D _5041_/Q gf180mcu_as_sc_mcu7t3v3__dfxtp_2
XFILLER_26_1564 VDD VDD VSS VSS gf180mcu_as_sc_mcu7t3v3__fillcap_4
XFILLER_26_2 VDD VDD VSS VSS gf180mcu_as_sc_mcu7t3v3__fillcap_16
XFILLER_61_1499 VDD VDD VSS VSS gf180mcu_as_sc_mcu7t3v3__fillcap_16
XFILLER_25_206 VDD VDD VSS VSS gf180mcu_as_sc_mcu7t3v3__fillcap_4
XFILLER_96_1518 VDD VDD VSS VSS gf180mcu_as_sc_mcu7t3v3__fillcap_16
XFILLER_25_228 VDD VDD VSS VSS gf180mcu_as_sc_mcu7t3v3__fillcap_16
XFILLER_146_1321 VDD VDD VSS VSS gf180mcu_as_sc_mcu7t3v3__fill_2
XFILLER_179_723 VDD VDD VSS VSS gf180mcu_as_sc_mcu7t3v3__fillcap_8
XFILLER_181_1212 VDD VDD VSS VSS gf180mcu_as_sc_mcu7t3v3__fillcap_4
XFILLER_40_209 VDD VDD VSS VSS gf180mcu_as_sc_mcu7t3v3__fillcap_16
X_4901__966 VDD VDD VSS VSS _4901_/D gf180mcu_as_sc_mcu7t3v3__tiel_4
X_4825_ VDD VDD VSS VSS _4904_/CLK _4825_/D _4825_/Q gf180mcu_as_sc_mcu7t3v3__dfxtp_2
XFILLER_119_300 VDD VDD VSS VSS gf180mcu_as_sc_mcu7t3v3__fill_1
X_4756_ VDD VDD VSS VSS clkload1/A _4756_/D _4756_/Q gf180mcu_as_sc_mcu7t3v3__dfxtp_2
XFILLER_134_303 VDD VDD VSS VSS gf180mcu_as_sc_mcu7t3v3__fill_2
XFILLER_146_174 VDD VDD VSS VSS gf180mcu_as_sc_mcu7t3v3__fill_1
X_4687_ VDD VDD VSS VSS _4749_/B _4708_/C _4691_/D gf180mcu_as_sc_mcu7t3v3__and2_2
X_3707_ VDD VDD VSS VSS _4857_/D _3707_/C _3707_/B _4083_/A gf180mcu_as_sc_mcu7t3v3__aoi21_2
X_3638_ VDD VDD VSS VSS _3753_/D _3794_/S _3638_/B _3638_/C _3639_/C gf180mcu_as_sc_mcu7t3v3__ao31_2
XPHY_EDGE_ROW_80_1_Right_79 VDD VSS gf180mcu_as_sc_mcu7t3v3__tap_2
XFILLER_134_358 VDD VDD VSS VSS gf180mcu_as_sc_mcu7t3v3__fillcap_4
XFILLER_150_807 VDD VDD VSS VSS gf180mcu_as_sc_mcu7t3v3__fillcap_16
XFILLER_162_667 VDD VDD VSS VSS gf180mcu_as_sc_mcu7t3v3__fillcap_8
XFILLER_175_1049 VDD VDD VSS VSS gf180mcu_as_sc_mcu7t3v3__fill_1
X_3569_ VDD VDD VSS VSS _3728_/C _3736_/B _3743_/B gf180mcu_as_sc_mcu7t3v3__and2_2
XFILLER_142_380 VDD VDD VSS VSS gf180mcu_as_sc_mcu7t3v3__fillcap_4
XFILLER_157_1472 VDD VDD VSS VSS gf180mcu_as_sc_mcu7t3v3__fillcap_8
XFILLER_118_1467 VDD VDD VSS VSS gf180mcu_as_sc_mcu7t3v3__fillcap_16
XFILLER_124_12 VDD VDD VSS VSS gf180mcu_as_sc_mcu7t3v3__fill_1
Xinput206 VDD VDD VSS VSS se_in[32] _3523_/A gf180mcu_as_sc_mcu7t3v3__buff_2
Xinput217 VDD VDD VSS VSS south_in[11] _4024_/D gf180mcu_as_sc_mcu7t3v3__buff_2
XTAP_TAPCELL_ROW_59_1_871 VDD VSS gf180mcu_as_sc_mcu7t3v3__tap_2
XTAP_TAPCELL_ROW_184_2330 VDD VSS gf180mcu_as_sc_mcu7t3v3__tap_2
XFILLER_75_106 VDD VDD VSS VSS gf180mcu_as_sc_mcu7t3v3__fill_1
X_5239_ VDD VDD VSS VSS clkload5/A _5239_/D _5239_/Q gf180mcu_as_sc_mcu7t3v3__dfxtp_2
Xinput228 VDD VDD VSS VSS south_in[21] _4101_/D gf180mcu_as_sc_mcu7t3v3__buff_2
Xinput239 VDD VDD VSS VSS south_in[31] _3253_/A gf180mcu_as_sc_mcu7t3v3__buff_2
XTAP_TAPCELL_ROW_180_2216 VDD VSS gf180mcu_as_sc_mcu7t3v3__tap_2
XFILLER_102_299 VDD VDD VSS VSS gf180mcu_as_sc_mcu7t3v3__fill_2
XFILLER_84_27 VDD VDD VSS VSS gf180mcu_as_sc_mcu7t3v3__fillcap_8
XPHY_EDGE_ROW_150_Left_602 VDD VSS gf180mcu_as_sc_mcu7t3v3__tap_2
XTAP_TAPCELL_ROW_180_2227 VDD VSS gf180mcu_as_sc_mcu7t3v3__tap_2
XFILLER_147_1118 VDD VDD VSS VSS gf180mcu_as_sc_mcu7t3v3__fill_2
XFILLER_77_1451 VDD VDD VSS VSS gf180mcu_as_sc_mcu7t3v3__fillcap_16
XFILLER_164_1432 VDD VDD VSS VSS gf180mcu_as_sc_mcu7t3v3__fill_2
XTAP_TAPCELL_ROW_178_2167 VDD VSS gf180mcu_as_sc_mcu7t3v3__tap_2
XTAP_TAPCELL_ROW_143_1392 VDD VSS gf180mcu_as_sc_mcu7t3v3__tap_2
XFILLER_169_244 VDD VDD VSS VSS gf180mcu_as_sc_mcu7t3v3__fillcap_16
XTAP_TAPCELL_ROW_178_2178 VDD VSS gf180mcu_as_sc_mcu7t3v3__tap_2
XFILLER_130_2 VDD VDD VSS VSS gf180mcu_as_sc_mcu7t3v3__fillcap_16
XFILLER_184_203 VDD VDD VSS VSS gf180mcu_as_sc_mcu7t3v3__fill_1
XFILLER_153_601 VDD VDD VSS VSS gf180mcu_as_sc_mcu7t3v3__fillcap_16
XPHY_EDGE_ROW_58_3_Right_377 VDD VSS gf180mcu_as_sc_mcu7t3v3__tap_2
XTAP_TAPCELL_ROW_152_1606 VDD VSS gf180mcu_as_sc_mcu7t3v3__tap_2
XPHY_EDGE_ROW_109_3_Left_243 VDD VSS gf180mcu_as_sc_mcu7t3v3__tap_2
XFILLER_136_1501 VDD VDD VSS VSS gf180mcu_as_sc_mcu7t3v3__fillcap_4
XFILLER_152_155 VDD VDD VSS VSS gf180mcu_as_sc_mcu7t3v3__fillcap_16
XFILLER_153_678 VDD VDD VSS VSS gf180mcu_as_sc_mcu7t3v3__fill_2
XFILLER_158_1269 VDD VDD VSS VSS gf180mcu_as_sc_mcu7t3v3__fill_1
XFILLER_49_1553 VDD VDD VSS VSS gf180mcu_as_sc_mcu7t3v3__fillcap_16
XFILLER_136_1523 VDD VDD VSS VSS gf180mcu_as_sc_mcu7t3v3__fillcap_8
XFILLER_140_317 VDD VDD VSS VSS gf180mcu_as_sc_mcu7t3v3__fillcap_4
XFILLER_152_177 VDD VDD VSS VSS gf180mcu_as_sc_mcu7t3v3__fillcap_16
XFILLER_171_1469 VDD VDD VSS VSS gf180mcu_as_sc_mcu7t3v3__fill_1
XFILLER_58_50 VDD VDD VSS VSS gf180mcu_as_sc_mcu7t3v3__fill_2
XFILLER_169_1354 VDD VDD VSS VSS gf180mcu_as_sc_mcu7t3v3__fillcap_16
XFILLER_169_1376 VDD VDD VSS VSS gf180mcu_as_sc_mcu7t3v3__fill_1
XFILLER_74_161 VDD VDD VSS VSS gf180mcu_as_sc_mcu7t3v3__fill_1
XFILLER_21_1483 VDD VDD VSS VSS gf180mcu_as_sc_mcu7t3v3__fillcap_16
XFILLER_56_1502 VDD VDD VSS VSS gf180mcu_as_sc_mcu7t3v3__fillcap_16
XTAP_TAPCELL_ROW_68_1_906 VDD VSS gf180mcu_as_sc_mcu7t3v3__tap_2
XFILLER_182_1543 VDD VDD VSS VSS gf180mcu_as_sc_mcu7t3v3__fillcap_8
XFILLER_22_209 VDD VDD VSS VSS gf180mcu_as_sc_mcu7t3v3__fillcap_16
X_2940_ VDD VDD VSS VSS _3794_/A _3803_/A _3283_/A gf180mcu_as_sc_mcu7t3v3__or2_2
XTAP_TAPCELL_ROW_76_1_941 VDD VSS gf180mcu_as_sc_mcu7t3v3__tap_2
XFILLER_143_1527 VDD VDD VSS VSS gf180mcu_as_sc_mcu7t3v3__fillcap_8
XFILLER_56_1568 VDD VDD VSS VSS gf180mcu_as_sc_mcu7t3v3__fill_1
X_2871_ VDD VDD VSS VSS _4742_/A _2871_/B _2871_/C _4766_/D gf180mcu_as_sc_mcu7t3v3__nor3_2
X_4610_ VDD VDD VSS VSS _5204_/Q _4612_/B _4612_/C _5205_/Q _5204_/D gf180mcu_as_sc_mcu7t3v3__ao22_2
XFILLER_141_1262 VDD VDD VSS VSS gf180mcu_as_sc_mcu7t3v3__fillcap_8
XFILLER_157_962 VDD VDD VSS VSS gf180mcu_as_sc_mcu7t3v3__fill_1
XFILLER_157_973 VDD VDD VSS VSS gf180mcu_as_sc_mcu7t3v3__fillcap_4
XFILLER_184_781 VDD VDD VSS VSS gf180mcu_as_sc_mcu7t3v3__fill_1
X_4541_ VDD VDD VSS VSS _4541_/B _4576_/A _4548_/C gf180mcu_as_sc_mcu7t3v3__and2_2
X_4472_ VDD VDD VSS VSS _4476_/B _5075_/Q _4552_/A gf180mcu_as_sc_mcu7t3v3__nand2_2
XFILLER_144_667 VDD VDD VSS VSS gf180mcu_as_sc_mcu7t3v3__fillcap_8
XFILLER_172_976 VDD VDD VSS VSS gf180mcu_as_sc_mcu7t3v3__fill_2
XFILLER_89_209 VDD VDD VSS VSS gf180mcu_as_sc_mcu7t3v3__fill_1
X_3423_ VDD VDD VSS VSS _3424_/B _3423_/B _3423_/C _3424_/C gf180mcu_as_sc_mcu7t3v3__nor3_2
XFILLER_174_1093 VDD VDD VSS VSS gf180mcu_as_sc_mcu7t3v3__fillcap_16
XPHY_EDGE_ROW_30_3_Left_164 VDD VSS gf180mcu_as_sc_mcu7t3v3__tap_2
X_3354_ VDD VDD VSS VSS _3356_/C _4007_/A _3449_/B _3354_/C gf180mcu_as_sc_mcu7t3v3__ao21_2
XFILLER_97_253 VDD VDD VSS VSS gf180mcu_as_sc_mcu7t3v3__fillcap_16
X_3285_ VDD VDD VSS VSS _3505_/S _3524_/C _3526_/B gf180mcu_as_sc_mcu7t3v3__nand2_2
XFILLER_57_139 VDD VDD VSS VSS gf180mcu_as_sc_mcu7t3v3__fill_1
X_5024_ VDD VDD VSS VSS _5053_/CLK _5024_/D _5024_/Q gf180mcu_as_sc_mcu7t3v3__dfxtp_2
XFILLER_183_1318 VDD VDD VSS VSS gf180mcu_as_sc_mcu7t3v3__fillcap_4
XFILLER_80_142 VDD VDD VSS VSS gf180mcu_as_sc_mcu7t3v3__fill_2
XFILLER_146_1173 VDD VDD VSS VSS gf180mcu_as_sc_mcu7t3v3__fillcap_16
XFILLER_139_417 VDD VDD VSS VSS gf180mcu_as_sc_mcu7t3v3__fill_2
XFILLER_179_586 VDD VDD VSS VSS gf180mcu_as_sc_mcu7t3v3__fillcap_16
XFILLER_70_18 VDD VDD VSS VSS gf180mcu_as_sc_mcu7t3v3__fillcap_16
XFILLER_166_247 VDD VDD VSS VSS gf180mcu_as_sc_mcu7t3v3__fillcap_16
X_4808_ VDD VDD VSS VSS _4863_/CLK _4808_/D _4808_/Q gf180mcu_as_sc_mcu7t3v3__dfxtp_2
XTAP_TAPCELL_ROW_173_2064 VDD VSS gf180mcu_as_sc_mcu7t3v3__tap_2
XTAP_TAPCELL_ROW_173_2053 VDD VSS gf180mcu_as_sc_mcu7t3v3__tap_2
XFILLER_119_34 VDD VDD VSS VSS gf180mcu_as_sc_mcu7t3v3__fillcap_4
X_4739_ VDD VDD VSS VSS _4739_/B _4739_/A _4740_/B gf180mcu_as_sc_mcu7t3v3__or2_2
XFILLER_162_431 VDD VDD VSS VSS gf180mcu_as_sc_mcu7t3v3__fillcap_16
XFILLER_175_792 VDD VDD VSS VSS gf180mcu_as_sc_mcu7t3v3__fill_1
XFILLER_181_228 VDD VDD VSS VSS gf180mcu_as_sc_mcu7t3v3__fillcap_16
XFILLER_79_27 VDD VDD VSS VSS gf180mcu_as_sc_mcu7t3v3__fillcap_8
XFILLER_134_144 VDD VDD VSS VSS gf180mcu_as_sc_mcu7t3v3__fill_1
XFILLER_135_678 VDD VDD VSS VSS gf180mcu_as_sc_mcu7t3v3__fill_2
XFILLER_163_998 VDD VDD VSS VSS gf180mcu_as_sc_mcu7t3v3__fillcap_4
XFILLER_134_166 VDD VDD VSS VSS gf180mcu_as_sc_mcu7t3v3__fillcap_4
XFILLER_134_188 VDD VDD VSS VSS gf180mcu_as_sc_mcu7t3v3__fillcap_16
XFILLER_150_626 VDD VDD VSS VSS gf180mcu_as_sc_mcu7t3v3__fill_1
XFILLER_153_1122 VDD VDD VSS VSS gf180mcu_as_sc_mcu7t3v3__fillcap_4
XFILLER_135_88 VDD VDD VSS VSS gf180mcu_as_sc_mcu7t3v3__fillcap_4
XFILLER_88_275 VDD VDD VSS VSS gf180mcu_as_sc_mcu7t3v3__fillcap_16
XFILLER_95_37 VDD VDD VSS VSS gf180mcu_as_sc_mcu7t3v3__fill_1
XFILLER_153_1188 VDD VDD VSS VSS gf180mcu_as_sc_mcu7t3v3__fill_2
XFILLER_44_1483 VDD VDD VSS VSS gf180mcu_as_sc_mcu7t3v3__fill_1
XFILLER_151_32 VDD VDD VSS VSS gf180mcu_as_sc_mcu7t3v3__fillcap_16
XFILLER_28_53 VDD VDD VSS VSS gf180mcu_as_sc_mcu7t3v3__fillcap_16
XFILLER_178_2 VDD VDD VSS VSS gf180mcu_as_sc_mcu7t3v3__fillcap_16
XTAP_TAPCELL_ROW_145_1454 VDD VSS gf180mcu_as_sc_mcu7t3v3__tap_2
XTAP_TAPCELL_ROW_145_1443 VDD VSS gf180mcu_as_sc_mcu7t3v3__tap_2
XFILLER_71_142 VDD VDD VSS VSS gf180mcu_as_sc_mcu7t3v3__fill_2
XFILLER_44_96 VDD VDD VSS VSS gf180mcu_as_sc_mcu7t3v3__fillcap_8
XFILLER_71_186 VDD VDD VSS VSS gf180mcu_as_sc_mcu7t3v3__fillcap_16
XFILLER_12_231 VDD VDD VSS VSS gf180mcu_as_sc_mcu7t3v3__fillcap_8
XFILLER_158_737 VDD VDD VSS VSS gf180mcu_as_sc_mcu7t3v3__fill_2
XFILLER_157_247 VDD VDD VSS VSS gf180mcu_as_sc_mcu7t3v3__fillcap_4
XFILLER_8_279 VDD VDD VSS VSS gf180mcu_as_sc_mcu7t3v3__fillcap_4
XFILLER_166_792 VDD VDD VSS VSS gf180mcu_as_sc_mcu7t3v3__fillcap_8
XPHY_EDGE_ROW_59_3_Right_378 VDD VSS gf180mcu_as_sc_mcu7t3v3__tap_2
XFILLER_125_144 VDD VDD VSS VSS gf180mcu_as_sc_mcu7t3v3__fill_1
XTAP_TAPCELL_ROW_6_3_2359 VDD VSS gf180mcu_as_sc_mcu7t3v3__tap_2
XFILLER_125_188 VDD VDD VSS VSS gf180mcu_as_sc_mcu7t3v3__fillcap_8
XTAP_TAPCELL_ROW_169_1977 VDD VSS gf180mcu_as_sc_mcu7t3v3__tap_2
XTAP_TAPCELL_ROW_169_1966 VDD VSS gf180mcu_as_sc_mcu7t3v3__tap_2
XFILLER_171_1299 VDD VDD VSS VSS gf180mcu_as_sc_mcu7t3v3__fillcap_16
XFILLER_62_1550 VDD VDD VSS VSS gf180mcu_as_sc_mcu7t3v3__fillcap_4
X_3070_ VDD VDD VSS VSS _3179_/B _4929_/Q _3071_/D gf180mcu_as_sc_mcu7t3v3__or2_2
XPHY_EDGE_ROW_182_Right_316 VDD VSS gf180mcu_as_sc_mcu7t3v3__tap_2
XFILLER_85_92 VDD VDD VSS VSS gf180mcu_as_sc_mcu7t3v3__fill_2
XFILLER_62_142 VDD VDD VSS VSS gf180mcu_as_sc_mcu7t3v3__fill_2
XFILLER_165_1037 VDD VDD VSS VSS gf180mcu_as_sc_mcu7t3v3__fillcap_8
XFILLER_182_1362 VDD VDD VSS VSS gf180mcu_as_sc_mcu7t3v3__fill_2
XFILLER_62_197 VDD VDD VSS VSS gf180mcu_as_sc_mcu7t3v3__fill_2
XFILLER_93_2 VDD VDD VSS VSS gf180mcu_as_sc_mcu7t3v3__fillcap_16
X_3972_ VDD VDD VSS VSS _4982_/Q _4117_/B _4233_/B _4108_/D _4982_/D gf180mcu_as_sc_mcu7t3v3__ao22_2
X_2923_ VDD VDD VSS VSS _3791_/A _3800_/A _3531_/A gf180mcu_as_sc_mcu7t3v3__or2_2
XFILLER_148_225 VDD VDD VSS VSS gf180mcu_as_sc_mcu7t3v3__fillcap_16
XFILLER_148_247 VDD VDD VSS VSS gf180mcu_as_sc_mcu7t3v3__fillcap_4
X_2854_ VDD VDD VSS VSS _4742_/A _4748_/B _2854_/B _2854_/C gf180mcu_as_sc_mcu7t3v3__ao21_2
XFILLER_163_206 VDD VDD VSS VSS gf180mcu_as_sc_mcu7t3v3__fillcap_4
X_2785_ VDD VDD VSS VSS _5236_/Q _4649_/A _4643_/A _5096_/Q _2786_/B gf180mcu_as_sc_mcu7t3v3__ao22_2
X_4524_ VDD VDD VSS VSS _4524_/B _4576_/A _4531_/C gf180mcu_as_sc_mcu7t3v3__and2_2
XFILLER_116_177 VDD VDD VSS VSS gf180mcu_as_sc_mcu7t3v3__fillcap_16
XFILLER_137_1106 VDD VDD VSS VSS gf180mcu_as_sc_mcu7t3v3__fill_2
XFILLER_145_998 VDD VDD VSS VSS gf180mcu_as_sc_mcu7t3v3__fillcap_8
XFILLER_160_924 VDD VDD VSS VSS gf180mcu_as_sc_mcu7t3v3__fillcap_16
XFILLER_172_784 VDD VDD VSS VSS gf180mcu_as_sc_mcu7t3v3__fillcap_4
X_4455_ VDD VDD VSS VSS _4458_/C _4986_/Q _4559_/S gf180mcu_as_sc_mcu7t3v3__nand2b_2
XFILLER_154_1431 VDD VDD VSS VSS gf180mcu_as_sc_mcu7t3v3__fillcap_4
XFILLER_67_1483 VDD VDD VSS VSS gf180mcu_as_sc_mcu7t3v3__fillcap_16
Xfanout704 VDD VDD VSS VSS _3169_/C _3152_/C gf180mcu_as_sc_mcu7t3v3__buff_2
Xfanout715 VDD VDD VSS VSS _2858_/Y _4749_/B gf180mcu_as_sc_mcu7t3v3__buff_2
X_4386_ VDD VDD VSS VSS _4389_/C _4386_/B _4562_/A gf180mcu_as_sc_mcu7t3v3__nor2_2
X_3406_ VDD VDD VSS VSS _4056_/A _3453_/B _3453_/C _4057_/A _3407_/C gf180mcu_as_sc_mcu7t3v3__ao22_2
XFILLER_131_158 VDD VDD VSS VSS gf180mcu_as_sc_mcu7t3v3__fill_2
XFILLER_28_1467 VDD VDD VSS VSS gf180mcu_as_sc_mcu7t3v3__fillcap_16
Xfanout726 VDD VDD VSS VSS _2909_/Y _3144_/B gf180mcu_as_sc_mcu7t3v3__buff_2
Xfanout737 VDD VDD VSS VSS _4192_/B _4187_/B gf180mcu_as_sc_mcu7t3v3__buff_2
Xfanout748 VDD VDD VSS VSS _5228_/Q _2847_/A gf180mcu_as_sc_mcu7t3v3__buff_2
X_3337_ VDD VDD VSS VSS _3338_/B _3989_/D _3503_/B _3337_/C gf180mcu_as_sc_mcu7t3v3__ao21_2
XFILLER_85_212 VDD VDD VSS VSS gf180mcu_as_sc_mcu7t3v3__fill_1
Xfanout759 VDD VDD VSS VSS _4511_/A _4510_/A gf180mcu_as_sc_mcu7t3v3__buff_2
XFILLER_85_256 VDD VDD VSS VSS gf180mcu_as_sc_mcu7t3v3__fillcap_4
X_3268_ VDD VDD VSS VSS _3268_/Y _3493_/B _3268_/A gf180mcu_as_sc_mcu7t3v3__nor2_2
X_5007_ VDD VDD VSS VSS _5172_/CLK _5007_/D _5007_/Q gf180mcu_as_sc_mcu7t3v3__dfxtp_2
X_3199_ VDD VDD VSS VSS _3199_/B _4943_/Q _3213_/D gf180mcu_as_sc_mcu7t3v3__and2_2
XFILLER_121_35 VDD VDD VSS VSS gf180mcu_as_sc_mcu7t3v3__fill_2
XFILLER_183_1115 VDD VDD VSS VSS gf180mcu_as_sc_mcu7t3v3__fillcap_4
XFILLER_53_142 VDD VDD VSS VSS gf180mcu_as_sc_mcu7t3v3__fill_2
XFILLER_161_1402 VDD VDD VSS VSS gf180mcu_as_sc_mcu7t3v3__fill_1
XTAP_TAPCELL_ROW_175_2115 VDD VSS gf180mcu_as_sc_mcu7t3v3__tap_2
XTAP_TAPCELL_ROW_175_2104 VDD VSS gf180mcu_as_sc_mcu7t3v3__tap_2
XTAP_TAPCELL_ROW_140_1340 VDD VSS gf180mcu_as_sc_mcu7t3v3__tap_2
XFILLER_155_718 VDD VDD VSS VSS gf180mcu_as_sc_mcu7t3v3__fillcap_16
XFILLER_167_578 VDD VDD VSS VSS gf180mcu_as_sc_mcu7t3v3__fillcap_16
XFILLER_30_32 VDD VDD VSS VSS gf180mcu_as_sc_mcu7t3v3__fill_2
XFILLER_136_976 VDD VDD VSS VSS gf180mcu_as_sc_mcu7t3v3__fillcap_4
XFILLER_146_10 VDD VDD VSS VSS gf180mcu_as_sc_mcu7t3v3__fillcap_4
XTAP_TAPCELL_ROW_138_1291 VDD VSS gf180mcu_as_sc_mcu7t3v3__tap_2
XFILLER_107_188 VDD VDD VSS VSS gf180mcu_as_sc_mcu7t3v3__fillcap_16
XFILLER_150_423 VDD VDD VSS VSS gf180mcu_as_sc_mcu7t3v3__fillcap_4
XFILLER_151_924 VDD VDD VSS VSS gf180mcu_as_sc_mcu7t3v3__fill_2
XFILLER_151_946 VDD VDD VSS VSS gf180mcu_as_sc_mcu7t3v3__fill_2
XFILLER_159_1364 VDD VDD VSS VSS gf180mcu_as_sc_mcu7t3v3__fillcap_16
XTAP_TAPCELL_ROW_67_1_905 VDD VSS gf180mcu_as_sc_mcu7t3v3__tap_2
XTAP_TAPCELL_ROW_134_1188 VDD VSS gf180mcu_as_sc_mcu7t3v3__tap_2
XTAP_TAPCELL_ROW_134_1177 VDD VSS gf180mcu_as_sc_mcu7t3v3__tap_2
XFILLER_151_979 VDD VDD VSS VSS gf180mcu_as_sc_mcu7t3v3__fill_1
XFILLER_46_1534 VDD VDD VSS VSS gf180mcu_as_sc_mcu7t3v3__fillcap_16
XTAP_TAPCELL_ROW_134_1199 VDD VSS gf180mcu_as_sc_mcu7t3v3__tap_2
XFILLER_46_1556 VDD VDD VSS VSS gf180mcu_as_sc_mcu7t3v3__fillcap_8
XFILLER_133_1537 VDD VDD VSS VSS gf180mcu_as_sc_mcu7t3v3__fillcap_8
XFILLER_162_53 VDD VDD VSS VSS gf180mcu_as_sc_mcu7t3v3__fillcap_16
XFILLER_39_96 VDD VDD VSS VSS gf180mcu_as_sc_mcu7t3v3__fill_2
XFILLER_76_289 VDD VDD VSS VSS gf180mcu_as_sc_mcu7t3v3__fillcap_8
XTAP_TAPCELL_ROW_164_1863 VDD VSS gf180mcu_as_sc_mcu7t3v3__tap_2
XFILLER_166_1313 VDD VDD VSS VSS gf180mcu_as_sc_mcu7t3v3__fillcap_16
XTAP_TAPCELL_ROW_164_1874 VDD VSS gf180mcu_as_sc_mcu7t3v3__tap_2
XFILLER_44_197 VDD VDD VSS VSS gf180mcu_as_sc_mcu7t3v3__fill_2
XFILLER_92_1543 VDD VDD VSS VSS gf180mcu_as_sc_mcu7t3v3__fillcap_8
XFILLER_111_90 VDD VDD VSS VSS gf180mcu_as_sc_mcu7t3v3__fill_2
XPHY_EDGE_ROW_76_1_Left_528 VDD VSS gf180mcu_as_sc_mcu7t3v3__tap_2
XFILLER_158_534 VDD VDD VSS VSS gf180mcu_as_sc_mcu7t3v3__fill_1
XFILLER_158_545 VDD VDD VSS VSS gf180mcu_as_sc_mcu7t3v3__fillcap_16
XFILLER_71_72 VDD VDD VSS VSS gf180mcu_as_sc_mcu7t3v3__fill_1
XFILLER_173_515 VDD VDD VSS VSS gf180mcu_as_sc_mcu7t3v3__fillcap_4
XFILLER_71_94 VDD VDD VSS VSS gf180mcu_as_sc_mcu7t3v3__fill_1
XTAP_TAPCELL_ROW_95_1_1015 VDD VSS gf180mcu_as_sc_mcu7t3v3__tap_2
XFILLER_145_228 VDD VDD VSS VSS gf180mcu_as_sc_mcu7t3v3__fill_1
XFILLER_160_209 VDD VDD VSS VSS gf180mcu_as_sc_mcu7t3v3__fillcap_4
X_2570_ VDD VDD VSS VSS _5277_/Q _4708_/C _2875_/B _2571_/B gf180mcu_as_sc_mcu7t3v3__nand3_2
XFILLER_113_103 VDD VDD VSS VSS gf180mcu_as_sc_mcu7t3v3__fillcap_16
Xoutput329 VDD VDD VSS VSS _4852_/Q east_out[13] gf180mcu_as_sc_mcu7t3v3__buff_2
Xoutput318 VDD VDD VSS VSS _5479_/Y dft_rdata[1] gf180mcu_as_sc_mcu7t3v3__buff_2
XTAP_TAPCELL_ROW_41_3_2411 VDD VSS gf180mcu_as_sc_mcu7t3v3__tap_2
X_4240_ VDD VDD VSS VSS _4250_/S _4240_/B _5076_/Q _5076_/D gf180mcu_as_sc_mcu7t3v3__mux2_2
XFILLER_113_158 VDD VDD VSS VSS gf180mcu_as_sc_mcu7t3v3__fill_2
XFILLER_136_1161 VDD VDD VSS VSS gf180mcu_as_sc_mcu7t3v3__fill_2
XFILLER_141_489 VDD VDD VSS VSS gf180mcu_as_sc_mcu7t3v3__fill_1
X_4171_ VDD VDD VSS VSS _4231_/B _4197_/B _4197_/C _5009_/Q _5009_/D gf180mcu_as_sc_mcu7t3v3__ao22_2
XFILLER_171_1052 VDD VDD VSS VSS gf180mcu_as_sc_mcu7t3v3__fillcap_4
XFILLER_67_223 VDD VDD VSS VSS gf180mcu_as_sc_mcu7t3v3__fillcap_16
XFILLER_96_80 VDD VDD VSS VSS gf180mcu_as_sc_mcu7t3v3__fillcap_16
X_3122_ VDD VDD VSS VSS _4097_/A _3147_/B _3122_/C _3122_/D _3123_/C gf180mcu_as_sc_mcu7t3v3__ao22_2
XFILLER_121_191 VDD VDD VSS VSS gf180mcu_as_sc_mcu7t3v3__fillcap_16
XFILLER_82_204 VDD VDD VSS VSS gf180mcu_as_sc_mcu7t3v3__fillcap_16
X_3053_ VDD VDD VSS VSS _3120_/A _3053_/B _3053_/C _3120_/D _3055_/C gf180mcu_as_sc_mcu7t3v3__ao211_2
XFILLER_35_120 VDD VDD VSS VSS gf180mcu_as_sc_mcu7t3v3__fillcap_16
XFILLER_82_259 VDD VDD VSS VSS gf180mcu_as_sc_mcu7t3v3__fill_2
XFILLER_35_142 VDD VDD VSS VSS gf180mcu_as_sc_mcu7t3v3__fillcap_16
XFILLER_50_123 VDD VDD VSS VSS gf180mcu_as_sc_mcu7t3v3__fillcap_16
XFILLER_177_810 VDD VDD VSS VSS gf180mcu_as_sc_mcu7t3v3__fill_1
XFILLER_50_156 VDD VDD VSS VSS gf180mcu_as_sc_mcu7t3v3__fillcap_4
X_3955_ VDD VDD VSS VSS _4980_/Q _4166_/B _4231_/B _4108_/D _4980_/D gf180mcu_as_sc_mcu7t3v3__ao22_2
X_2906_ VDD VDD VSS VSS _3818_/A _3510_/A _3519_/A gf180mcu_as_sc_mcu7t3v3__nor2_2
XFILLER_177_876 VDD VDD VSS VSS gf180mcu_as_sc_mcu7t3v3__fill_1
X_3886_ VDD VDD VSS VSS _3897_/B _5176_/Q _4926_/D gf180mcu_as_sc_mcu7t3v3__and2_2
XTAP_TAPCELL_ROW_170_2001 VDD VSS gf180mcu_as_sc_mcu7t3v3__tap_2
XFILLER_164_537 VDD VDD VSS VSS gf180mcu_as_sc_mcu7t3v3__fillcap_16
Xclkbuf_leaf_0_clk_regs VDD VDD VSS VSS clkbuf_3_0_0_clk_regs/Y clkload0/A gf180mcu_as_sc_mcu7t3v3__clkbuff_12
X_2837_ VDD VDD VSS VSS _4746_/C _4748_/B gf180mcu_as_sc_mcu7t3v3__inv_2
X_2768_ VDD VDD VSS VSS _2792_/A _5227_/Q _2845_/B gf180mcu_as_sc_mcu7t3v3__and2_2
X_4507_ VDD VDD VSS VSS _4511_/B _5079_/Q _4544_/S gf180mcu_as_sc_mcu7t3v3__nand2_2
X_2699_ VDD VDD VSS VSS _2699_/A _2699_/B _2699_/C _4262_/B _2701_/C gf180mcu_as_sc_mcu7t3v3__ao211_2
X_4438_ VDD VDD VSS VSS _4518_/S _5013_/Q _5042_/Q _4439_/B gf180mcu_as_sc_mcu7t3v3__mux2_2
Xfanout501 VDD VDD VSS VSS fanout505/Y _3802_/B gf180mcu_as_sc_mcu7t3v3__buff_2
Xfanout523 VDD VDD VSS VSS fanout527/Y _4163_/B gf180mcu_as_sc_mcu7t3v3__buff_2
XFILLER_150_1103 VDD VDD VSS VSS gf180mcu_as_sc_mcu7t3v3__fillcap_16
XFILLER_150_1125 VDD VDD VSS VSS gf180mcu_as_sc_mcu7t3v3__fill_1
Xfanout534 VDD VDD VSS VSS _4059_/A _4165_/A gf180mcu_as_sc_mcu7t3v3__buff_2
Xfanout545 VDD VDD VSS VSS _3476_/B _3523_/B gf180mcu_as_sc_mcu7t3v3__buff_2
Xfanout556 VDD VDD VSS VSS fanout560/Y _3182_/B gf180mcu_as_sc_mcu7t3v3__buff_2
X_4369_ VDD VDD VSS VSS _4370_/C _4369_/C _4369_/B _4562_/A gf180mcu_as_sc_mcu7t3v3__aoi21b_2
Xfanout567 VDD VDD VSS VSS fanout569/Y _4104_/B gf180mcu_as_sc_mcu7t3v3__buff_2
Xfanout578 VDD VDD VSS VSS _3743_/B _3750_/C gf180mcu_as_sc_mcu7t3v3__buff_2
Xfanout589 VDD VDD VSS VSS _2852_/Y _4566_/B gf180mcu_as_sc_mcu7t3v3__buff_2
XFILLER_132_34 VDD VDD VSS VSS gf180mcu_as_sc_mcu7t3v3__fill_1
Xmesh_tile_960 VDD VDD VSS VSS sw_out[33] gf180mcu_as_sc_mcu7t3v3__tiel_4
XPHY_EDGE_ROW_118_3_Left_252 VDD VSS gf180mcu_as_sc_mcu7t3v3__tap_2
XFILLER_148_1054 VDD VDD VSS VSS gf180mcu_as_sc_mcu7t3v3__fill_2
XFILLER_148_1087 VDD VDD VSS VSS gf180mcu_as_sc_mcu7t3v3__fill_1
XFILLER_148_1098 VDD VDD VSS VSS gf180mcu_as_sc_mcu7t3v3__fillcap_16
XFILLER_41_134 VDD VDD VSS VSS gf180mcu_as_sc_mcu7t3v3__fillcap_4
XFILLER_41_156 VDD VDD VSS VSS gf180mcu_as_sc_mcu7t3v3__fillcap_4
XFILLER_161_1254 VDD VDD VSS VSS gf180mcu_as_sc_mcu7t3v3__fillcap_4
XTAP_TAPCELL_ROW_136_1239 VDD VSS gf180mcu_as_sc_mcu7t3v3__tap_2
XFILLER_155_559 VDD VDD VSS VSS gf180mcu_as_sc_mcu7t3v3__fill_1
XFILLER_151_710 VDD VDD VSS VSS gf180mcu_as_sc_mcu7t3v3__fill_2
XFILLER_163_570 VDD VDD VSS VSS gf180mcu_as_sc_mcu7t3v3__fillcap_4
XFILLER_155_1047 VDD VDD VSS VSS gf180mcu_as_sc_mcu7t3v3__fill_2
XFILLER_1_241 VDD VDD VSS VSS gf180mcu_as_sc_mcu7t3v3__fillcap_8
XFILLER_49_212 VDD VDD VSS VSS gf180mcu_as_sc_mcu7t3v3__fillcap_16
XTAP_TAPCELL_ROW_166_1914 VDD VSS gf180mcu_as_sc_mcu7t3v3__tap_2
XTAP_TAPCELL_ROW_166_1903 VDD VSS gf180mcu_as_sc_mcu7t3v3__tap_2
XFILLER_172_1394 VDD VDD VSS VSS gf180mcu_as_sc_mcu7t3v3__fill_1
XFILLER_2_69 VDD VDD VSS VSS gf180mcu_as_sc_mcu7t3v3__fillcap_16
XFILLER_17_120 VDD VDD VSS VSS gf180mcu_as_sc_mcu7t3v3__fillcap_16
XFILLER_17_142 VDD VDD VSS VSS gf180mcu_as_sc_mcu7t3v3__fillcap_16
XFILLER_166_1154 VDD VDD VSS VSS gf180mcu_as_sc_mcu7t3v3__fill_1
XFILLER_32_101 VDD VDD VSS VSS gf180mcu_as_sc_mcu7t3v3__fillcap_4
XFILLER_32_123 VDD VDD VSS VSS gf180mcu_as_sc_mcu7t3v3__fillcap_16
XFILLER_72_281 VDD VDD VSS VSS gf180mcu_as_sc_mcu7t3v3__fillcap_16
X_3740_ VDD VDD VSS VSS _4938_/Q _3740_/B _3740_/C _4120_/A _3742_/C gf180mcu_as_sc_mcu7t3v3__ao22_2
XFILLER_158_364 VDD VDD VSS VSS gf180mcu_as_sc_mcu7t3v3__fillcap_8
XFILLER_159_898 VDD VDD VSS VSS gf180mcu_as_sc_mcu7t3v3__fill_1
XFILLER_118_228 VDD VDD VSS VSS gf180mcu_as_sc_mcu7t3v3__fill_1
X_3671_ VDD VDD VSS VSS _4929_/Q _3762_/B _3770_/C _4045_/A _3672_/D gf180mcu_as_sc_mcu7t3v3__ao22_2
X_2622_ VDD VDD VSS VSS _2644_/B _4655_/B _2695_/A gf180mcu_as_sc_mcu7t3v3__nand2_2
X_2553_ VDD VDD VSS VSS _5222_/Q _4703_/B _2554_/C gf180mcu_as_sc_mcu7t3v3__xnor2_2
XFILLER_142_787 VDD VDD VSS VSS gf180mcu_as_sc_mcu7t3v3__fillcap_16
X_5272_ VDD VDD VSS VSS clkload5/A _5272_/D _5272_/Q gf180mcu_as_sc_mcu7t3v3__dfxtp_2
X_2484_ VDD VDD VSS VSS _2840_/A _2847_/A _5227_/Q gf180mcu_as_sc_mcu7t3v3__nand2_2
X_4223_ VDD VDD VSS VSS _4252_/B _4223_/B _4223_/C _5059_/Q _5059_/D gf180mcu_as_sc_mcu7t3v3__ao22_2
XFILLER_64_1486 VDD VDD VSS VSS gf180mcu_as_sc_mcu7t3v3__fillcap_16
X_4154_ VDD VDD VSS VSS _4154_/A _4162_/B _4160_/B _4154_/D _4155_/D gf180mcu_as_sc_mcu7t3v3__ao22_2
X_4085_ VDD VDD VSS VSS _4085_/A _4104_/C _4101_/B _4085_/D _4086_/D gf180mcu_as_sc_mcu7t3v3__ao22_2
X_3105_ VDD VDD VSS VSS _3106_/C _3105_/C _3150_/C _4077_/A gf180mcu_as_sc_mcu7t3v3__aoi21_2
X_3036_ VDD VDD VSS VSS _4014_/A _3152_/B _3152_/C _4013_/D _3037_/C gf180mcu_as_sc_mcu7t3v3__ao22_2
XFILLER_102_37 VDD VDD VSS VSS gf180mcu_as_sc_mcu7t3v3__fillcap_16
XFILLER_149_1352 VDD VDD VSS VSS gf180mcu_as_sc_mcu7t3v3__fill_2
XFILLER_23_134 VDD VDD VSS VSS gf180mcu_as_sc_mcu7t3v3__fillcap_4
XFILLER_168_139 VDD VDD VSS VSS gf180mcu_as_sc_mcu7t3v3__fillcap_16
X_4987_ VDD VDD VSS VSS _5183_/CLK _4987_/D _4987_/Q gf180mcu_as_sc_mcu7t3v3__dfxtp_2
X_3938_ VDD VDD VSS VSS _3938_/A _4160_/B _4161_/B _3938_/D _3939_/D gf180mcu_as_sc_mcu7t3v3__ao22_2
XFILLER_164_312 VDD VDD VSS VSS gf180mcu_as_sc_mcu7t3v3__fill_2
X_3869_ VDD VDD VSS VSS _3869_/A _3869_/B _3869_/C _3869_/D _4339_/B gf180mcu_as_sc_mcu7t3v3__nand4_2
XTAP_TAPCELL_ROW_94_3_2490 VDD VSS gf180mcu_as_sc_mcu7t3v3__tap_2
XFILLER_11_34 VDD VDD VSS VSS gf180mcu_as_sc_mcu7t3v3__fillcap_16
XFILLER_127_34 VDD VDD VSS VSS gf180mcu_as_sc_mcu7t3v3__fillcap_4
XFILLER_156_1367 VDD VDD VSS VSS gf180mcu_as_sc_mcu7t3v3__fillcap_16
XFILLER_87_27 VDD VDD VSS VSS gf180mcu_as_sc_mcu7t3v3__fillcap_8
XFILLER_43_1515 VDD VDD VSS VSS gf180mcu_as_sc_mcu7t3v3__fillcap_4
XFILLER_82_1564 VDD VDD VSS VSS gf180mcu_as_sc_mcu7t3v3__fillcap_4
XFILLER_43_1537 VDD VDD VSS VSS gf180mcu_as_sc_mcu7t3v3__fillcap_4
XFILLER_143_88 VDD VDD VSS VSS gf180mcu_as_sc_mcu7t3v3__fillcap_8
XFILLER_46_204 VDD VDD VSS VSS gf180mcu_as_sc_mcu7t3v3__fillcap_16
XFILLER_36_20 VDD VDD VSS VSS gf180mcu_as_sc_mcu7t3v3__fillcap_8
XTAP_TAPCELL_ROW_161_1800 VDD VSS gf180mcu_as_sc_mcu7t3v3__tap_2
XFILLER_36_53 VDD VDD VSS VSS gf180mcu_as_sc_mcu7t3v3__fillcap_16
XFILLER_14_101 VDD VDD VSS VSS gf180mcu_as_sc_mcu7t3v3__fillcap_4
XFILLER_160_2 VDD VDD VSS VSS gf180mcu_as_sc_mcu7t3v3__fillcap_16
XFILLER_167_1452 VDD VDD VSS VSS gf180mcu_as_sc_mcu7t3v3__fillcap_16
XFILLER_61_229 VDD VDD VSS VSS gf180mcu_as_sc_mcu7t3v3__fillcap_16
XFILLER_14_123 VDD VDD VSS VSS gf180mcu_as_sc_mcu7t3v3__fillcap_16
XTAP_TAPCELL_ROW_159_1762 VDD VSS gf180mcu_as_sc_mcu7t3v3__tap_2
XTAP_TAPCELL_ROW_159_1751 VDD VSS gf180mcu_as_sc_mcu7t3v3__tap_2
XFILLER_168_85 VDD VDD VSS VSS gf180mcu_as_sc_mcu7t3v3__fillcap_16
XFILLER_183_632 VDD VDD VSS VSS gf180mcu_as_sc_mcu7t3v3__fill_1
XFILLER_52_96 VDD VDD VSS VSS gf180mcu_as_sc_mcu7t3v3__fillcap_8
Xinput17 VDD VDD VSS VSS boot_data[5] _2722_/A gf180mcu_as_sc_mcu7t3v3__buff_2
Xinput28 VDD VDD VSS VSS dft_addr[5] _2421_/A gf180mcu_as_sc_mcu7t3v3__buff_2
XFILLER_155_356 VDD VDD VSS VSS gf180mcu_as_sc_mcu7t3v3__fill_2
XFILLER_182_142 VDD VDD VSS VSS gf180mcu_as_sc_mcu7t3v3__fillcap_4
Xinput39 VDD VDD VSS VSS dft_wdata[4] _2716_/B gf180mcu_as_sc_mcu7t3v3__buff_2
XTAP_TAPCELL_ROW_155_1659 VDD VSS gf180mcu_as_sc_mcu7t3v3__tap_2
XFILLER_115_209 VDD VDD VSS VSS gf180mcu_as_sc_mcu7t3v3__fill_1
XFILLER_139_1510 VDD VDD VSS VSS gf180mcu_as_sc_mcu7t3v3__fill_1
XFILLER_171_838 VDD VDD VSS VSS gf180mcu_as_sc_mcu7t3v3__fill_2
XFILLER_135_1418 VDD VDD VSS VSS gf180mcu_as_sc_mcu7t3v3__fillcap_16
XFILLER_151_562 VDD VDD VSS VSS gf180mcu_as_sc_mcu7t3v3__fillcap_8
XFILLER_96_104 VDD VDD VSS VSS gf180mcu_as_sc_mcu7t3v3__fill_1
XFILLER_77_60 VDD VDD VSS VSS gf180mcu_as_sc_mcu7t3v3__fill_2
XFILLER_168_1205 VDD VDD VSS VSS gf180mcu_as_sc_mcu7t3v3__fillcap_16
XFILLER_111_1451 VDD VDD VSS VSS gf180mcu_as_sc_mcu7t3v3__fillcap_16
XFILLER_168_1227 VDD VDD VSS VSS gf180mcu_as_sc_mcu7t3v3__fillcap_16
XFILLER_4_1564 VDD VDD VSS VSS gf180mcu_as_sc_mcu7t3v3__fillcap_4
XFILLER_146_1503 VDD VDD VSS VSS gf180mcu_as_sc_mcu7t3v3__fill_2
X_4910_ VDD VDD VSS VSS _5159_/CLK _4910_/D _4910_/Q gf180mcu_as_sc_mcu7t3v3__dfxtp_2
XFILLER_179_938 VDD VDD VSS VSS gf180mcu_as_sc_mcu7t3v3__fillcap_8
X_4841_ VDD VDD VSS VSS _4867_/CLK _4841_/D _4841_/Q gf180mcu_as_sc_mcu7t3v3__dfxtp_2
XFILLER_159_662 VDD VDD VSS VSS gf180mcu_as_sc_mcu7t3v3__fillcap_16
XFILLER_60_295 VDD VDD VSS VSS gf180mcu_as_sc_mcu7t3v3__fillcap_4
X_4772_ VDD VDD VSS VSS _5046_/CLK _4772_/D _4772_/Q gf180mcu_as_sc_mcu7t3v3__dfxtp_2
XFILLER_174_621 VDD VDD VSS VSS gf180mcu_as_sc_mcu7t3v3__fillcap_4
X_3723_ VDD VDD VSS VSS _4859_/D _3723_/C _3723_/B _4099_/A gf180mcu_as_sc_mcu7t3v3__aoi21_2
XFILLER_140_1157 VDD VDD VSS VSS gf180mcu_as_sc_mcu7t3v3__fillcap_4
XFILLER_146_345 VDD VDD VSS VSS gf180mcu_as_sc_mcu7t3v3__fillcap_8
XFILLER_173_120 VDD VDD VSS VSS gf180mcu_as_sc_mcu7t3v3__fillcap_16
XFILLER_173_142 VDD VDD VSS VSS gf180mcu_as_sc_mcu7t3v3__fillcap_16
XFILLER_179_1323 VDD VDD VSS VSS gf180mcu_as_sc_mcu7t3v3__fill_1
X_3654_ VDD VDD VSS VSS _4027_/A _3746_/B _3654_/C _4850_/D _3746_/D gf180mcu_as_sc_mcu7t3v3__aoi211_2
XFILLER_146_378 VDD VDD VSS VSS gf180mcu_as_sc_mcu7t3v3__fillcap_4
XFILLER_179_1378 VDD VDD VSS VSS gf180mcu_as_sc_mcu7t3v3__fill_1
X_2605_ VDD VDD VSS VSS _4764_/Q _4765_/Q _2653_/S _2606_/B gf180mcu_as_sc_mcu7t3v3__nor3_2
XFILLER_161_348 VDD VDD VSS VSS gf180mcu_as_sc_mcu7t3v3__fill_2
X_3585_ VDD VDD VSS VSS _3948_/A _3792_/B _3585_/C _3802_/C _3586_/C gf180mcu_as_sc_mcu7t3v3__ao211_2
X_2536_ VDD VDD VSS VSS _5159_/Q _5157_/Q _5158_/Q _4364_/B gf180mcu_as_sc_mcu7t3v3__nor3_2
XTAP_TAPCELL_ROW_77_1_943 VDD VSS gf180mcu_as_sc_mcu7t3v3__tap_2
XFILLER_114_264 VDD VDD VSS VSS gf180mcu_as_sc_mcu7t3v3__fillcap_4
XFILLER_142_573 VDD VDD VSS VSS gf180mcu_as_sc_mcu7t3v3__fill_1
XFILLER_170_893 VDD VDD VSS VSS gf180mcu_as_sc_mcu7t3v3__fillcap_4
X_5255_ VDD VDD VSS VSS clkload6/A _5255_/D _5255_/Q gf180mcu_as_sc_mcu7t3v3__dfxtp_2
X_2467_ VDD VDD VSS VSS _4369_/B _2467_/C _2467_/B _4448_/A gf180mcu_as_sc_mcu7t3v3__aoi21_2
XPHY_EDGE_ROW_1_3_Right_320 VDD VSS gf180mcu_as_sc_mcu7t3v3__tap_2
X_4206_ VDD VDD VSS VSS _4235_/B _4219_/B _4219_/C _5042_/Q _5042_/D gf180mcu_as_sc_mcu7t3v3__ao22_2
X_5186_ VDD VDD VSS VSS _5186_/CLK _5186_/D _5186_/Q gf180mcu_as_sc_mcu7t3v3__dfxtp_2
X_2398_ VDD VDD VSS VSS _2767_/A _5226_/Q gf180mcu_as_sc_mcu7t3v3__inv_2
XFILLER_113_14 VDD VDD VSS VSS gf180mcu_as_sc_mcu7t3v3__fill_2
X_4137_ VDD VDD VSS VSS _4137_/A _4160_/C _4152_/C _4940_/Q _4139_/C gf180mcu_as_sc_mcu7t3v3__ao22_2
XFILLER_113_69 VDD VDD VSS VSS gf180mcu_as_sc_mcu7t3v3__fill_1
X_4068_ VDD VDD VSS VSS _4994_/Q _4125_/B _4245_/B _4125_/D _4994_/D gf180mcu_as_sc_mcu7t3v3__ao22_2
X_3019_ VDD VDD VSS VSS _3120_/A _3019_/B _3019_/C _3120_/D _3021_/C gf180mcu_as_sc_mcu7t3v3__ao211_2
XFILLER_11_104 VDD VDD VSS VSS gf180mcu_as_sc_mcu7t3v3__fillcap_16
XFILLER_51_251 VDD VDD VSS VSS gf180mcu_as_sc_mcu7t3v3__fill_1
Xsram2048.u_bank0_814 VDD VDD VSS VSS sram2048.u_bank0/WEN[4] gf180mcu_as_sc_mcu7t3v3__tiel_4
XFILLER_145_1068 VDD VDD VSS VSS gf180mcu_as_sc_mcu7t3v3__fillcap_8
XFILLER_138_846 VDD VDD VSS VSS gf180mcu_as_sc_mcu7t3v3__fill_2
XFILLER_177_470 VDD VDD VSS VSS gf180mcu_as_sc_mcu7t3v3__fillcap_8
XTAP_TAPCELL_ROW_96_1_1020 VDD VSS gf180mcu_as_sc_mcu7t3v3__tap_2
XFILLER_165_632 VDD VDD VSS VSS gf180mcu_as_sc_mcu7t3v3__fillcap_4
XFILLER_165_698 VDD VDD VSS VSS gf180mcu_as_sc_mcu7t3v3__fill_2
XFILLER_180_624 VDD VDD VSS VSS gf180mcu_as_sc_mcu7t3v3__fillcap_4
XFILLER_152_348 VDD VDD VSS VSS gf180mcu_as_sc_mcu7t3v3__fillcap_16
XFILLER_153_849 VDD VDD VSS VSS gf180mcu_as_sc_mcu7t3v3__fillcap_8
XFILLER_98_37 VDD VDD VSS VSS gf180mcu_as_sc_mcu7t3v3__fill_1
XFILLER_180_679 VDD VDD VSS VSS gf180mcu_as_sc_mcu7t3v3__fill_2
XTAP_TAPCELL_ROW_150_1567 VDD VSS gf180mcu_as_sc_mcu7t3v3__tap_2
XTAP_TAPCELL_ROW_150_1556 VDD VSS gf180mcu_as_sc_mcu7t3v3__tap_2
XFILLER_152_1017 VDD VDD VSS VSS gf180mcu_as_sc_mcu7t3v3__fillcap_16
XFILLER_78_104 VDD VDD VSS VSS gf180mcu_as_sc_mcu7t3v3__fill_1
XFILLER_78_115 VDD VDD VSS VSS gf180mcu_as_sc_mcu7t3v3__fill_1
XFILLER_78_126 VDD VDD VSS VSS gf180mcu_as_sc_mcu7t3v3__fill_1
XFILLER_154_65 VDD VDD VSS VSS gf180mcu_as_sc_mcu7t3v3__fillcap_16
XFILLER_93_118 VDD VDD VSS VSS gf180mcu_as_sc_mcu7t3v3__fill_2
XPHY_EDGE_ROW_85_1_Left_537 VDD VSS gf180mcu_as_sc_mcu7t3v3__tap_2
XFILLER_47_52 VDD VDD VSS VSS gf180mcu_as_sc_mcu7t3v3__fillcap_4
XTAP_TAPCELL_ROW_19_1_712 VDD VSS gf180mcu_as_sc_mcu7t3v3__tap_2
XFILLER_169_1536 VDD VDD VSS VSS gf180mcu_as_sc_mcu7t3v3__fillcap_4
XFILLER_170_53 VDD VDD VSS VSS gf180mcu_as_sc_mcu7t3v3__fillcap_16
XFILLER_163_1168 VDD VDD VSS VSS gf180mcu_as_sc_mcu7t3v3__fill_1
XFILLER_42_295 VDD VDD VSS VSS gf180mcu_as_sc_mcu7t3v3__fillcap_4
XFILLER_106_1564 VDD VDD VSS VSS gf180mcu_as_sc_mcu7t3v3__fillcap_4
XFILLER_169_982 VDD VDD VSS VSS gf180mcu_as_sc_mcu7t3v3__fill_2
XFILLER_155_120 VDD VDD VSS VSS gf180mcu_as_sc_mcu7t3v3__fillcap_16
XFILLER_89_1515 VDD VDD VSS VSS gf180mcu_as_sc_mcu7t3v3__fillcap_4
XFILLER_89_1537 VDD VDD VSS VSS gf180mcu_as_sc_mcu7t3v3__fillcap_16
XFILLER_155_142 VDD VDD VSS VSS gf180mcu_as_sc_mcu7t3v3__fillcap_16
XFILLER_171_624 VDD VDD VSS VSS gf180mcu_as_sc_mcu7t3v3__fillcap_4
XFILLER_176_1507 VDD VDD VSS VSS gf180mcu_as_sc_mcu7t3v3__fillcap_16
XFILLER_184_996 VDD VDD VSS VSS gf180mcu_as_sc_mcu7t3v3__fillcap_4
XFILLER_143_348 VDD VDD VSS VSS gf180mcu_as_sc_mcu7t3v3__fill_2
XFILLER_170_101 VDD VDD VSS VSS gf180mcu_as_sc_mcu7t3v3__fillcap_4
XFILLER_170_123 VDD VDD VSS VSS gf180mcu_as_sc_mcu7t3v3__fillcap_16
XFILLER_171_679 VDD VDD VSS VSS gf180mcu_as_sc_mcu7t3v3__fill_2
X_3370_ VDD VDD VSS VSS _4024_/D _3466_/B _3370_/C _3464_/B _3372_/C gf180mcu_as_sc_mcu7t3v3__ao211_2
XFILLER_111_212 VDD VDD VSS VSS gf180mcu_as_sc_mcu7t3v3__fill_2
XFILLER_135_1226 VDD VDD VSS VSS gf180mcu_as_sc_mcu7t3v3__fillcap_4
XFILLER_152_893 VDD VDD VSS VSS gf180mcu_as_sc_mcu7t3v3__fillcap_8
XFILLER_135_1259 VDD VDD VSS VSS gf180mcu_as_sc_mcu7t3v3__fill_1
X_5040_ VDD VDD VSS VSS _5173_/CLK _5040_/D _5040_/Q gf180mcu_as_sc_mcu7t3v3__dfxtp_2
XFILLER_84_107 VDD VDD VSS VSS gf180mcu_as_sc_mcu7t3v3__fill_2
XFILLER_19_2 VDD VDD VSS VSS gf180mcu_as_sc_mcu7t3v3__fillcap_16
XFILLER_61_1467 VDD VDD VSS VSS gf180mcu_as_sc_mcu7t3v3__fillcap_16
XFILLER_168_1013 VDD VDD VSS VSS gf180mcu_as_sc_mcu7t3v3__fill_2
XFILLER_92_162 VDD VDD VSS VSS gf180mcu_as_sc_mcu7t3v3__fill_2
XFILLER_179_702 VDD VDD VSS VSS gf180mcu_as_sc_mcu7t3v3__fill_1
XFILLER_146_1399 VDD VDD VSS VSS gf180mcu_as_sc_mcu7t3v3__fillcap_4
X_4824_ VDD VDD VSS VSS _4858_/CLK _4824_/D _4824_/Q gf180mcu_as_sc_mcu7t3v3__dfxtp_2
XTAP_TAPCELL_ROW_47_3_2420 VDD VSS gf180mcu_as_sc_mcu7t3v3__tap_2
X_4755_ VDD VDD VSS VSS clkload1/A _4755_/D _4755_/Q gf180mcu_as_sc_mcu7t3v3__dfxtp_2
XFILLER_147_632 VDD VDD VSS VSS gf180mcu_as_sc_mcu7t3v3__fillcap_8
XFILLER_159_492 VDD VDD VSS VSS gf180mcu_as_sc_mcu7t3v3__fillcap_8
X_3706_ VDD VDD VSS VSS _3706_/D _3794_/S _3706_/B _3706_/C _3707_/C gf180mcu_as_sc_mcu7t3v3__ao31_2
XFILLER_135_827 VDD VDD VSS VSS gf180mcu_as_sc_mcu7t3v3__fillcap_8
XFILLER_174_451 VDD VDD VSS VSS gf180mcu_as_sc_mcu7t3v3__fillcap_4
XFILLER_174_473 VDD VDD VSS VSS gf180mcu_as_sc_mcu7t3v3__fillcap_16
X_4686_ VDD VDD VSS VSS _4686_/D _4686_/A _4686_/B _4686_/C _5249_/D gf180mcu_as_sc_mcu7t3v3__ao31_2
XFILLER_147_698 VDD VDD VSS VSS gf180mcu_as_sc_mcu7t3v3__fill_2
X_3637_ VDD VDD VSS VSS _3638_/C _3637_/C _3752_/B _4009_/A gf180mcu_as_sc_mcu7t3v3__aoi21_2
XFILLER_162_679 VDD VDD VSS VSS gf180mcu_as_sc_mcu7t3v3__fill_2
X_3568_ VDD VDD VSS VSS _3933_/A _3779_/B _3568_/C _3568_/D _3571_/C gf180mcu_as_sc_mcu7t3v3__ao211_2
XFILLER_142_370 VDD VDD VSS VSS gf180mcu_as_sc_mcu7t3v3__fill_2
XFILLER_153_1326 VDD VDD VSS VSS gf180mcu_as_sc_mcu7t3v3__fillcap_4
XPHY_EDGE_ROW_127_3_Left_261 VDD VSS gf180mcu_as_sc_mcu7t3v3__tap_2
X_2519_ VDD VDD VSS VSS _4704_/B _4684_/A _2545_/B gf180mcu_as_sc_mcu7t3v3__or2_2
XFILLER_153_1359 VDD VDD VSS VSS gf180mcu_as_sc_mcu7t3v3__fillcap_16
Xinput207 VDD VDD VSS VSS se_in[33] _3528_/A gf180mcu_as_sc_mcu7t3v3__buff_2
Xinput218 VDD VDD VSS VSS south_in[12] _4031_/A gf180mcu_as_sc_mcu7t3v3__buff_2
X_3499_ VDD VDD VSS VSS _3499_/B _3795_/A _4832_/D gf180mcu_as_sc_mcu7t3v3__and2_2
XTAP_TAPCELL_ROW_184_2331 VDD VSS gf180mcu_as_sc_mcu7t3v3__tap_2
XTAP_TAPCELL_ROW_184_2320 VDD VSS gf180mcu_as_sc_mcu7t3v3__tap_2
X_5238_ VDD VDD VSS VSS clkload5/A _5238_/D _5238_/Q gf180mcu_as_sc_mcu7t3v3__dfxtp_2
Xinput229 VDD VDD VSS VSS south_in[22] _4111_/A gf180mcu_as_sc_mcu7t3v3__buff_2
XTAP_TAPCELL_ROW_59_1_872 VDD VSS gf180mcu_as_sc_mcu7t3v3__tap_2
XTAP_TAPCELL_ROW_180_2206 VDD VSS gf180mcu_as_sc_mcu7t3v3__tap_2
XFILLER_40_1518 VDD VDD VSS VSS gf180mcu_as_sc_mcu7t3v3__fillcap_16
XPHY_EDGE_ROW_2_3_Right_321 VDD VSS gf180mcu_as_sc_mcu7t3v3__tap_2
X_5169_ VDD VDD VSS VSS _5183_/CLK _5169_/D _5169_/Q gf180mcu_as_sc_mcu7t3v3__dfxtp_2
XTAP_TAPCELL_ROW_180_2217 VDD VSS gf180mcu_as_sc_mcu7t3v3__tap_2
XFILLER_151_1094 VDD VDD VSS VSS gf180mcu_as_sc_mcu7t3v3__fillcap_8
XFILLER_68_192 VDD VDD VSS VSS gf180mcu_as_sc_mcu7t3v3__fillcap_4
XFILLER_140_34 VDD VDD VSS VSS gf180mcu_as_sc_mcu7t3v3__fill_1
XFILLER_17_66 VDD VDD VSS VSS gf180mcu_as_sc_mcu7t3v3__fillcap_4
XFILLER_17_88 VDD VDD VSS VSS gf180mcu_as_sc_mcu7t3v3__fillcap_16
XFILLER_169_212 VDD VDD VSS VSS gf180mcu_as_sc_mcu7t3v3__fillcap_16
XTAP_TAPCELL_ROW_82_3_2472 VDD VSS gf180mcu_as_sc_mcu7t3v3__tap_2
XTAP_TAPCELL_ROW_178_2168 VDD VSS gf180mcu_as_sc_mcu7t3v3__tap_2
XTAP_TAPCELL_ROW_143_1393 VDD VSS gf180mcu_as_sc_mcu7t3v3__tap_2
XFILLER_158_919 VDD VDD VSS VSS gf180mcu_as_sc_mcu7t3v3__fillcap_8
XFILLER_24_295 VDD VDD VSS VSS gf180mcu_as_sc_mcu7t3v3__fillcap_4
XTAP_TAPCELL_ROW_178_2179 VDD VSS gf180mcu_as_sc_mcu7t3v3__tap_2
XFILLER_157_418 VDD VDD VSS VSS gf180mcu_as_sc_mcu7t3v3__fill_2
XFILLER_123_2 VDD VDD VSS VSS gf180mcu_as_sc_mcu7t3v3__fillcap_16
XFILLER_138_643 VDD VDD VSS VSS gf180mcu_as_sc_mcu7t3v3__fill_2
XFILLER_137_142 VDD VDD VSS VSS gf180mcu_as_sc_mcu7t3v3__fill_2
XTAP_TAPCELL_ROW_152_1607 VDD VSS gf180mcu_as_sc_mcu7t3v3__tap_2
XFILLER_152_101 VDD VDD VSS VSS gf180mcu_as_sc_mcu7t3v3__fillcap_4
XFILLER_152_123 VDD VDD VSS VSS gf180mcu_as_sc_mcu7t3v3__fillcap_16
XFILLER_101_1483 VDD VDD VSS VSS gf180mcu_as_sc_mcu7t3v3__fillcap_16
XFILLER_140_307 VDD VDD VSS VSS gf180mcu_as_sc_mcu7t3v3__fill_1
XFILLER_158_1259 VDD VDD VSS VSS gf180mcu_as_sc_mcu7t3v3__fillcap_8
XFILLER_181_988 VDD VDD VSS VSS gf180mcu_as_sc_mcu7t3v3__fillcap_8
XFILLER_49_1521 VDD VDD VSS VSS gf180mcu_as_sc_mcu7t3v3__fillcap_16
XPHY_EDGE_ROW_59_3_Left_193 VDD VSS gf180mcu_as_sc_mcu7t3v3__tap_2
XFILLER_136_1535 VDD VDD VSS VSS gf180mcu_as_sc_mcu7t3v3__fill_2
XFILLER_84_1467 VDD VDD VSS VSS gf180mcu_as_sc_mcu7t3v3__fillcap_16
XTAP_TAPCELL_ROW_119_1_1110 VDD VSS gf180mcu_as_sc_mcu7t3v3__tap_2
XFILLER_66_107 VDD VDD VSS VSS gf180mcu_as_sc_mcu7t3v3__fillcap_8
XFILLER_169_1300 VDD VDD VSS VSS gf180mcu_as_sc_mcu7t3v3__fill_2
XFILLER_59_192 VDD VDD VSS VSS gf180mcu_as_sc_mcu7t3v3__fillcap_8
XFILLER_21_1451 VDD VDD VSS VSS gf180mcu_as_sc_mcu7t3v3__fillcap_16
XFILLER_165_1208 VDD VDD VSS VSS gf180mcu_as_sc_mcu7t3v3__fillcap_8
XFILLER_169_1388 VDD VDD VSS VSS gf180mcu_as_sc_mcu7t3v3__fill_1
XFILLER_182_1511 VDD VDD VSS VSS gf180mcu_as_sc_mcu7t3v3__fillcap_16
XTAP_TAPCELL_ROW_68_1_907 VDD VSS gf180mcu_as_sc_mcu7t3v3__tap_2
XFILLER_182_1555 VDD VDD VSS VSS gf180mcu_as_sc_mcu7t3v3__fill_2
X_2870_ VDD VDD VSS VSS _2870_/B _4766_/Q _2871_/C gf180mcu_as_sc_mcu7t3v3__xnor2_2
XFILLER_143_1539 VDD VDD VSS VSS gf180mcu_as_sc_mcu7t3v3__fill_1
X_4540_ VDD VDD VSS VSS _5184_/Q _4566_/B _4566_/C _5102_/Q _4541_/B gf180mcu_as_sc_mcu7t3v3__ao22_2
XFILLER_172_944 VDD VDD VSS VSS gf180mcu_as_sc_mcu7t3v3__fill_1
X_4471_ VDD VDD VSS VSS _4471_/B _4506_/A _4478_/C gf180mcu_as_sc_mcu7t3v3__and2_2
XFILLER_143_134 VDD VDD VSS VSS gf180mcu_as_sc_mcu7t3v3__fillcap_4
XFILLER_144_679 VDD VDD VSS VSS gf180mcu_as_sc_mcu7t3v3__fill_2
XFILLER_171_454 VDD VDD VSS VSS gf180mcu_as_sc_mcu7t3v3__fillcap_16
XFILLER_99_80 VDD VDD VSS VSS gf180mcu_as_sc_mcu7t3v3__fillcap_8
X_3422_ VDD VDD VSS VSS _4070_/A _3453_/B _3453_/C _4073_/A _3423_/C gf180mcu_as_sc_mcu7t3v3__ao22_2
XFILLER_135_1001 VDD VDD VSS VSS gf180mcu_as_sc_mcu7t3v3__fill_1
XFILLER_135_1045 VDD VDD VSS VSS gf180mcu_as_sc_mcu7t3v3__fillcap_4
X_3353_ VDD VDD VSS VSS _4924_/Q _3465_/B _3465_/C _4005_/A _3354_/C gf180mcu_as_sc_mcu7t3v3__ao22_2
X_3284_ VDD VDD VSS VSS _3524_/C _3526_/B _3284_/Y gf180mcu_as_sc_mcu7t3v3__and2_2
XFILLER_97_298 VDD VDD VSS VSS gf180mcu_as_sc_mcu7t3v3__fill_2
X_5023_ VDD VDD VSS VSS _5085_/CLK _5023_/D _5023_/Q gf180mcu_as_sc_mcu7t3v3__dfxtp_2
XFILLER_6_1467 VDD VDD VSS VSS gf180mcu_as_sc_mcu7t3v3__fillcap_16
XFILLER_146_1130 VDD VDD VSS VSS gf180mcu_as_sc_mcu7t3v3__fillcap_8
XFILLER_179_532 VDD VDD VSS VSS gf180mcu_as_sc_mcu7t3v3__fillcap_16
XFILLER_110_37 VDD VDD VSS VSS gf180mcu_as_sc_mcu7t3v3__fill_1
XFILLER_80_187 VDD VDD VSS VSS gf180mcu_as_sc_mcu7t3v3__fillcap_8
XFILLER_142_1038 VDD VDD VSS VSS gf180mcu_as_sc_mcu7t3v3__fill_1
X_4807_ VDD VDD VSS VSS _4867_/CLK _4807_/D _4807_/Q gf180mcu_as_sc_mcu7t3v3__dfxtp_2
XFILLER_181_1098 VDD VDD VSS VSS gf180mcu_as_sc_mcu7t3v3__fillcap_8
XFILLER_21_276 VDD VDD VSS VSS gf180mcu_as_sc_mcu7t3v3__fillcap_4
X_2999_ VDD VDD VSS VSS _3984_/A _3125_/B _3125_/C _3984_/D _3005_/B gf180mcu_as_sc_mcu7t3v3__ao22_2
XTAP_TAPCELL_ROW_173_2054 VDD VSS gf180mcu_as_sc_mcu7t3v3__tap_2
XFILLER_119_142 VDD VDD VSS VSS gf180mcu_as_sc_mcu7t3v3__fillcap_8
XFILLER_124_1483 VDD VDD VSS VSS gf180mcu_as_sc_mcu7t3v3__fill_1
XFILLER_175_760 VDD VDD VSS VSS gf180mcu_as_sc_mcu7t3v3__fillcap_8
XFILLER_21_298 VDD VDD VSS VSS gf180mcu_as_sc_mcu7t3v3__fill_2
X_4738_ VDD VDD VSS VSS _4745_/B _4749_/A _4750_/B gf180mcu_as_sc_mcu7t3v3__and2_2
XTAP_TAPCELL_ROW_173_2065 VDD VSS gf180mcu_as_sc_mcu7t3v3__tap_2
XFILLER_135_624 VDD VDD VSS VSS gf180mcu_as_sc_mcu7t3v3__fillcap_4
X_4669_ VDD VDD VSS VSS _5112_/Q _4680_/B _4681_/C _5243_/Q _4670_/C gf180mcu_as_sc_mcu7t3v3__ao22_2
XFILLER_150_616 VDD VDD VSS VSS gf180mcu_as_sc_mcu7t3v3__fillcap_8
XFILLER_157_1281 VDD VDD VSS VSS gf180mcu_as_sc_mcu7t3v3__fillcap_4
Xclkbuf_1_1__f_clk VDD VDD VSS VSS clkbuf_0_clk/Y clkbuf_1_1__f_clk/Y gf180mcu_as_sc_mcu7t3v3__clkbuff_12
XFILLER_0_169 VDD VDD VSS VSS gf180mcu_as_sc_mcu7t3v3__fill_1
XFILLER_95_27 VDD VDD VSS VSS gf180mcu_as_sc_mcu7t3v3__fillcap_8
XFILLER_44_1451 VDD VDD VSS VSS gf180mcu_as_sc_mcu7t3v3__fillcap_16
XFILLER_95_49 VDD VDD VSS VSS gf180mcu_as_sc_mcu7t3v3__fillcap_16
XPHY_EDGE_ROW_3_3_Right_322 VDD VSS gf180mcu_as_sc_mcu7t3v3__tap_2
XFILLER_56_151 VDD VDD VSS VSS gf180mcu_as_sc_mcu7t3v3__fill_1
XTAP_TAPCELL_ROW_145_1455 VDD VSS gf180mcu_as_sc_mcu7t3v3__tap_2
XTAP_TAPCELL_ROW_145_1444 VDD VSS gf180mcu_as_sc_mcu7t3v3__tap_2
XFILLER_151_88 VDD VDD VSS VSS gf180mcu_as_sc_mcu7t3v3__fillcap_16
XFILLER_166_1539 VDD VDD VSS VSS gf180mcu_as_sc_mcu7t3v3__fillcap_16
XFILLER_12_243 VDD VDD VSS VSS gf180mcu_as_sc_mcu7t3v3__fill_2
XFILLER_16_1564 VDD VDD VSS VSS gf180mcu_as_sc_mcu7t3v3__fillcap_4
XFILLER_8_225 VDD VDD VSS VSS gf180mcu_as_sc_mcu7t3v3__fillcap_16
XPHY_EDGE_ROW_158_Right_292 VDD VSS gf180mcu_as_sc_mcu7t3v3__tap_2
XFILLER_8_247 VDD VDD VSS VSS gf180mcu_as_sc_mcu7t3v3__fillcap_16
XFILLER_153_410 VDD VDD VSS VSS gf180mcu_as_sc_mcu7t3v3__fill_2
XFILLER_154_922 VDD VDD VSS VSS gf180mcu_as_sc_mcu7t3v3__fillcap_16
XFILLER_154_944 VDD VDD VSS VSS gf180mcu_as_sc_mcu7t3v3__fill_1
XFILLER_158_1001 VDD VDD VSS VSS gf180mcu_as_sc_mcu7t3v3__fill_1
XFILLER_51_1499 VDD VDD VSS VSS gf180mcu_as_sc_mcu7t3v3__fillcap_16
XFILLER_86_1518 VDD VDD VSS VSS gf180mcu_as_sc_mcu7t3v3__fillcap_16
Xclkbuf_leaf_24_clk_regs VDD VDD VSS VSS clkbuf_3_6_0_clk_regs/Y _5188_/CLK gf180mcu_as_sc_mcu7t3v3__clkbuff_12
XFILLER_125_134 VDD VDD VSS VSS gf180mcu_as_sc_mcu7t3v3__fillcap_4
XFILLER_176_85 VDD VDD VSS VSS gf180mcu_as_sc_mcu7t3v3__fillcap_16
XFILLER_140_115 VDD VDD VSS VSS gf180mcu_as_sc_mcu7t3v3__fill_2
XFILLER_141_616 VDD VDD VSS VSS gf180mcu_as_sc_mcu7t3v3__fillcap_8
XPHY_EDGE_ROW_29_1_Left_481 VDD VSS gf180mcu_as_sc_mcu7t3v3__tap_2
XFILLER_140_148 VDD VDD VSS VSS gf180mcu_as_sc_mcu7t3v3__fillcap_4
XFILLER_180_295 VDD VDD VSS VSS gf180mcu_as_sc_mcu7t3v3__fillcap_16
XFILLER_69_72 VDD VDD VSS VSS gf180mcu_as_sc_mcu7t3v3__fillcap_16
XFILLER_140_159 VDD VDD VSS VSS gf180mcu_as_sc_mcu7t3v3__fill_1
XTAP_TAPCELL_ROW_169_1967 VDD VSS gf180mcu_as_sc_mcu7t3v3__tap_2
XFILLER_79_298 VDD VDD VSS VSS gf180mcu_as_sc_mcu7t3v3__fill_2
XTAP_TAPCELL_ROW_169_1978 VDD VSS gf180mcu_as_sc_mcu7t3v3__tap_2
XFILLER_169_1174 VDD VDD VSS VSS gf180mcu_as_sc_mcu7t3v3__fill_2
XFILLER_165_1049 VDD VDD VSS VSS gf180mcu_as_sc_mcu7t3v3__fill_1
X_3971_ VDD VDD VSS VSS _3971_/A _4110_/C _3971_/C _4233_/B _4091_/D gf180mcu_as_sc_mcu7t3v3__aoi211_2
XFILLER_147_1472 VDD VDD VSS VSS gf180mcu_as_sc_mcu7t3v3__fillcap_16
X_2922_ VDD VDD VSS VSS _3807_/A _3791_/A _3800_/A gf180mcu_as_sc_mcu7t3v3__nor2_2
XFILLER_143_1325 VDD VDD VSS VSS gf180mcu_as_sc_mcu7t3v3__fillcap_4
XFILLER_108_1467 VDD VDD VSS VSS gf180mcu_as_sc_mcu7t3v3__fillcap_16
XFILLER_86_2 VDD VDD VSS VSS gf180mcu_as_sc_mcu7t3v3__fillcap_16
X_2853_ VDD VDD VSS VSS _2854_/C _4373_/D _2853_/A gf180mcu_as_sc_mcu7t3v3__nand2_2
XFILLER_148_259 VDD VDD VSS VSS gf180mcu_as_sc_mcu7t3v3__fillcap_16
XFILLER_157_760 VDD VDD VSS VSS gf180mcu_as_sc_mcu7t3v3__fillcap_8
X_2784_ VDD VDD VSS VSS _4647_/A _5234_/Q _2786_/C gf180mcu_as_sc_mcu7t3v3__and2_2
X_4523_ VDD VDD VSS VSS _5182_/Q _4566_/B _4566_/C _5100_/Q _4524_/B gf180mcu_as_sc_mcu7t3v3__ao22_2
XFILLER_116_134 VDD VDD VSS VSS gf180mcu_as_sc_mcu7t3v3__fillcap_8
XFILLER_160_947 VDD VDD VSS VSS gf180mcu_as_sc_mcu7t3v3__fill_2
XFILLER_67_1451 VDD VDD VSS VSS gf180mcu_as_sc_mcu7t3v3__fillcap_16
X_4454_ VDD VDD VSS VSS _4458_/B _5073_/Q _4559_/S gf180mcu_as_sc_mcu7t3v3__nand2_2
Xfanout705 VDD VDD VSS VSS _2931_/Y _3169_/C gf180mcu_as_sc_mcu7t3v3__buff_2
X_4385_ VDD VDD VSS VSS _4385_/D _4510_/A _4385_/B _4385_/C _4386_/B gf180mcu_as_sc_mcu7t3v3__ao31_2
X_3405_ VDD VDD VSS VSS _3452_/S _4056_/D _3405_/A _3407_/B gf180mcu_as_sc_mcu7t3v3__mux2_2
XFILLER_8_1518 VDD VDD VSS VSS gf180mcu_as_sc_mcu7t3v3__fillcap_16
Xfanout716 VDD VDD VSS VSS _2858_/Y _4721_/A gf180mcu_as_sc_mcu7t3v3__buff_2
Xfanout727 VDD VDD VSS VSS _2894_/Y _3176_/S gf180mcu_as_sc_mcu7t3v3__buff_2
Xfanout738 VDD VDD VSS VSS _4192_/B _4188_/B gf180mcu_as_sc_mcu7t3v3__buff_2
Xfanout749 VDD VDD VSS VSS _4684_/A _2845_/D gf180mcu_as_sc_mcu7t3v3__buff_2
X_3336_ VDD VDD VSS VSS _4922_/Q _3493_/B _3501_/B _3990_/A _3337_/C gf180mcu_as_sc_mcu7t3v3__ao22_2
XFILLER_105_37 VDD VDD VSS VSS gf180mcu_as_sc_mcu7t3v3__fill_1
XFILLER_154_1498 VDD VDD VSS VSS gf180mcu_as_sc_mcu7t3v3__fillcap_4
X_5006_ VDD VDD VSS VSS _5094_/CLK _5006_/D _5006_/Q gf180mcu_as_sc_mcu7t3v3__dfxtp_2
X_3267_ VDD VDD VSS VSS _3267_/Y _3275_/B _3275_/A gf180mcu_as_sc_mcu7t3v3__nor2b_2
XFILLER_85_279 VDD VDD VSS VSS gf180mcu_as_sc_mcu7t3v3__fill_1
X_3198_ VDD VDD VSS VSS _3198_/B _3204_/C _3206_/C gf180mcu_as_sc_mcu7t3v3__or2_2
XTAP_TAPCELL_ROW_35_3_2402 VDD VSS gf180mcu_as_sc_mcu7t3v3__tap_2
XTAP_TAPCELL_ROW_29_1_750 VDD VSS gf180mcu_as_sc_mcu7t3v3__tap_2
XFILLER_121_14 VDD VDD VSS VSS gf180mcu_as_sc_mcu7t3v3__fill_1
XFILLER_121_69 VDD VDD VSS VSS gf180mcu_as_sc_mcu7t3v3__fill_1
XTAP_TAPCELL_ROW_140_1330 VDD VSS gf180mcu_as_sc_mcu7t3v3__tap_2
XFILLER_148_1269 VDD VDD VSS VSS gf180mcu_as_sc_mcu7t3v3__fill_1
XFILLER_157_8 VDD VDD VSS VSS gf180mcu_as_sc_mcu7t3v3__fillcap_16
XFILLER_39_1553 VDD VDD VSS VSS gf180mcu_as_sc_mcu7t3v3__fillcap_16
XTAP_TAPCELL_ROW_175_2105 VDD VSS gf180mcu_as_sc_mcu7t3v3__tap_2
XTAP_TAPCELL_ROW_140_1341 VDD VSS gf180mcu_as_sc_mcu7t3v3__tap_2
XFILLER_126_1534 VDD VDD VSS VSS gf180mcu_as_sc_mcu7t3v3__fillcap_16
XFILLER_126_1556 VDD VDD VSS VSS gf180mcu_as_sc_mcu7t3v3__fillcap_4
XFILLER_14_34 VDD VDD VSS VSS gf180mcu_as_sc_mcu7t3v3__fill_1
XTAP_TAPCELL_ROW_175_2116 VDD VSS gf180mcu_as_sc_mcu7t3v3__tap_2
XFILLER_161_1469 VDD VDD VSS VSS gf180mcu_as_sc_mcu7t3v3__fill_1
XFILLER_179_384 VDD VDD VSS VSS gf180mcu_as_sc_mcu7t3v3__fillcap_16
XFILLER_139_259 VDD VDD VSS VSS gf180mcu_as_sc_mcu7t3v3__fillcap_8
XPHY_EDGE_ROW_94_1_Left_546 VDD VSS gf180mcu_as_sc_mcu7t3v3__tap_2
XFILLER_135_410 VDD VDD VSS VSS gf180mcu_as_sc_mcu7t3v3__fillcap_4
XFILLER_136_922 VDD VDD VSS VSS gf180mcu_as_sc_mcu7t3v3__fillcap_4
XFILLER_136_944 VDD VDD VSS VSS gf180mcu_as_sc_mcu7t3v3__fill_1
XFILLER_148_782 VDD VDD VSS VSS gf180mcu_as_sc_mcu7t3v3__fillcap_4
XFILLER_182_527 VDD VDD VSS VSS gf180mcu_as_sc_mcu7t3v3__fill_1
XFILLER_5_206 VDD VDD VSS VSS gf180mcu_as_sc_mcu7t3v3__fillcap_4
XFILLER_5_228 VDD VDD VSS VSS gf180mcu_as_sc_mcu7t3v3__fillcap_16
XFILLER_159_1332 VDD VDD VSS VSS gf180mcu_as_sc_mcu7t3v3__fillcap_16
XTAP_TAPCELL_ROW_138_1292 VDD VSS gf180mcu_as_sc_mcu7t3v3__tap_2
XFILLER_11_1483 VDD VDD VSS VSS gf180mcu_as_sc_mcu7t3v3__fillcap_16
XFILLER_122_104 VDD VDD VSS VSS gf180mcu_as_sc_mcu7t3v3__fill_1
XFILLER_136_999 VDD VDD VSS VSS gf180mcu_as_sc_mcu7t3v3__fill_2
XTAP_TAPCELL_ROW_134_1189 VDD VSS gf180mcu_as_sc_mcu7t3v3__tap_2
XTAP_TAPCELL_ROW_134_1178 VDD VSS gf180mcu_as_sc_mcu7t3v3__tap_2
XFILLER_150_457 VDD VDD VSS VSS gf180mcu_as_sc_mcu7t3v3__fillcap_16
XFILLER_162_295 VDD VDD VSS VSS gf180mcu_as_sc_mcu7t3v3__fillcap_8
XFILLER_46_1502 VDD VDD VSS VSS gf180mcu_as_sc_mcu7t3v3__fillcap_16
XFILLER_46_1568 VDD VDD VSS VSS gf180mcu_as_sc_mcu7t3v3__fill_1
XFILLER_162_32 VDD VDD VSS VSS gf180mcu_as_sc_mcu7t3v3__fill_2
XFILLER_76_235 VDD VDD VSS VSS gf180mcu_as_sc_mcu7t3v3__fillcap_8
XTAP_TAPCELL_ROW_70_3_2454 VDD VSS gf180mcu_as_sc_mcu7t3v3__tap_2
XFILLER_91_216 VDD VDD VSS VSS gf180mcu_as_sc_mcu7t3v3__fill_2
XTAP_TAPCELL_ROW_164_1864 VDD VSS gf180mcu_as_sc_mcu7t3v3__tap_2
XPHY_EDGE_ROW_4_3_Right_323 VDD VSS gf180mcu_as_sc_mcu7t3v3__tap_2
XTAP_TAPCELL_ROW_164_1875 VDD VSS gf180mcu_as_sc_mcu7t3v3__tap_2
XFILLER_92_1511 VDD VDD VSS VSS gf180mcu_as_sc_mcu7t3v3__fillcap_16
XTAP_TAPCELL_ROW_116_1_1098 VDD VSS gf180mcu_as_sc_mcu7t3v3__tap_2
XFILLER_158_513 VDD VDD VSS VSS gf180mcu_as_sc_mcu7t3v3__fillcap_8
XTAP_TAPCELL_ROW_95_1_1016 VDD VSS gf180mcu_as_sc_mcu7t3v3__tap_2
XTAP_TAPCELL_ROW_46_1_820 VDD VSS gf180mcu_as_sc_mcu7t3v3__tap_2
XFILLER_173_538 VDD VDD VSS VSS gf180mcu_as_sc_mcu7t3v3__fillcap_16
XFILLER_154_785 VDD VDD VSS VSS gf180mcu_as_sc_mcu7t3v3__fillcap_4
XFILLER_173_1307 VDD VDD VSS VSS gf180mcu_as_sc_mcu7t3v3__fillcap_16
Xoutput319 VDD VDD VSS VSS _5480_/Y dft_rdata[2] gf180mcu_as_sc_mcu7t3v3__buff_2
XFILLER_141_446 VDD VDD VSS VSS gf180mcu_as_sc_mcu7t3v3__fill_2
XFILLER_142_947 VDD VDD VSS VSS gf180mcu_as_sc_mcu7t3v3__fill_2
XFILLER_173_1329 VDD VDD VSS VSS gf180mcu_as_sc_mcu7t3v3__fill_1
X_4170_ VDD VDD VSS VSS _4230_/B _4187_/B _4197_/C _5008_/Q _5008_/D gf180mcu_as_sc_mcu7t3v3__ao22_2
XFILLER_136_1173 VDD VDD VSS VSS gf180mcu_as_sc_mcu7t3v3__fillcap_4
XFILLER_150_991 VDD VDD VSS VSS gf180mcu_as_sc_mcu7t3v3__fillcap_8
X_3121_ VDD VDD VSS VSS _3121_/B _4935_/Q _3122_/D gf180mcu_as_sc_mcu7t3v3__or2_2
XFILLER_67_279 VDD VDD VSS VSS gf180mcu_as_sc_mcu7t3v3__fill_1
X_3052_ VDD VDD VSS VSS _4029_/A _3127_/B _3127_/C _4031_/A _3053_/C gf180mcu_as_sc_mcu7t3v3__ao22_2
XFILLER_149_1512 VDD VDD VSS VSS gf180mcu_as_sc_mcu7t3v3__fill_2
XFILLER_97_1499 VDD VDD VSS VSS gf180mcu_as_sc_mcu7t3v3__fillcap_16
XPHY_EDGE_ROW_11_3_Left_145 VDD VSS gf180mcu_as_sc_mcu7t3v3__tap_2
XFILLER_90_293 VDD VDD VSS VSS gf180mcu_as_sc_mcu7t3v3__fillcap_8
X_3954_ VDD VDD VSS VSS _4231_/B _3954_/B _4141_/D gf180mcu_as_sc_mcu7t3v3__nor2_2
XFILLER_149_524 VDD VDD VSS VSS gf180mcu_as_sc_mcu7t3v3__fill_2
X_3885_ VDD VDD VSS VSS _3897_/B _5175_/Q _4925_/D gf180mcu_as_sc_mcu7t3v3__and2_2
X_2905_ VDD VDD VSS VSS _3790_/A _3535_/A _3537_/A gf180mcu_as_sc_mcu7t3v3__or2_2
XFILLER_149_557 VDD VDD VSS VSS gf180mcu_as_sc_mcu7t3v3__fill_2
XFILLER_176_365 VDD VDD VSS VSS gf180mcu_as_sc_mcu7t3v3__fillcap_16
X_2836_ VDD VDD VSS VSS _4748_/B _4749_/A _4329_/A gf180mcu_as_sc_mcu7t3v3__nor2_2
XTAP_TAPCELL_ROW_170_2002 VDD VSS gf180mcu_as_sc_mcu7t3v3__tap_2
XFILLER_164_527 VDD VDD VSS VSS gf180mcu_as_sc_mcu7t3v3__fillcap_4
XFILLER_176_387 VDD VDD VSS VSS gf180mcu_as_sc_mcu7t3v3__fillcap_16
XFILLER_34_1483 VDD VDD VSS VSS gf180mcu_as_sc_mcu7t3v3__fill_1
X_2767_ VDD VDD VSS VSS _2767_/A _2847_/A _2840_/B _2840_/C _2770_/C gf180mcu_as_sc_mcu7t3v3__nand4_2
XFILLER_145_796 VDD VDD VSS VSS gf180mcu_as_sc_mcu7t3v3__fill_2
XFILLER_160_711 VDD VDD VSS VSS gf180mcu_as_sc_mcu7t3v3__fill_1
X_4506_ VDD VDD VSS VSS _4506_/B _4506_/A _4513_/C gf180mcu_as_sc_mcu7t3v3__and2_2
X_2698_ VDD VDD VSS VSS _5159_/Q _4269_/S _4278_/S _5183_/Q _2699_/C gf180mcu_as_sc_mcu7t3v3__ao22_2
XFILLER_116_14 VDD VDD VSS VSS gf180mcu_as_sc_mcu7t3v3__fill_1
X_4437_ VDD VDD VSS VSS _4440_/C _4984_/Q _4518_/S gf180mcu_as_sc_mcu7t3v3__nand2b_2
XFILLER_104_148 VDD VDD VSS VSS gf180mcu_as_sc_mcu7t3v3__fill_2
XFILLER_160_777 VDD VDD VSS VSS gf180mcu_as_sc_mcu7t3v3__fillcap_16
Xfanout502 VDD VDD VSS VSS fanout505/Y _3752_/B gf180mcu_as_sc_mcu7t3v3__buff_2
Xfanout513 VDD VDD VSS VSS _4590_/C _4566_/C gf180mcu_as_sc_mcu7t3v3__buff_2
Xfanout524 VDD VDD VSS VSS fanout527/Y _4131_/B gf180mcu_as_sc_mcu7t3v3__buff_2
XFILLER_58_213 VDD VDD VSS VSS gf180mcu_as_sc_mcu7t3v3__fill_1
XFILLER_76_18 VDD VDD VSS VSS gf180mcu_as_sc_mcu7t3v3__fillcap_16
Xfanout535 VDD VDD VSS VSS _4250_/S _4257_/S gf180mcu_as_sc_mcu7t3v3__buff_2
Xfanout546 VDD VDD VSS VSS _3476_/B _3453_/C gf180mcu_as_sc_mcu7t3v3__buff_2
Xfanout557 VDD VDD VSS VSS fanout560/Y _3149_/B gf180mcu_as_sc_mcu7t3v3__buff_2
X_4368_ VDD VDD VSS VSS _5482_/A _4566_/C _4368_/C _4378_/D _4369_/C gf180mcu_as_sc_mcu7t3v3__ao211_2
XFILLER_150_1137 VDD VDD VSS VSS gf180mcu_as_sc_mcu7t3v3__fillcap_4
Xfanout568 VDD VDD VSS VSS fanout569/Y _4119_/B gf180mcu_as_sc_mcu7t3v3__buff_2
Xfanout579 VDD VDD VSS VSS fanout583/Y _3240_/B gf180mcu_as_sc_mcu7t3v3__buff_2
X_4299_ VDD VDD VSS VSS _4305_/S _5129_/Q _5128_/Q _5128_/D gf180mcu_as_sc_mcu7t3v3__mux2_2
X_3319_ VDD VDD VSS VSS _3971_/A _3424_/B _3319_/C _4809_/D _3601_/D gf180mcu_as_sc_mcu7t3v3__aoi211_2
Xmesh_tile_950 VDD VDD VSS VSS sw_out[23] gf180mcu_as_sc_mcu7t3v3__tiel_4
XFILLER_81_282 VDD VDD VSS VSS gf180mcu_as_sc_mcu7t3v3__fillcap_16
XFILLER_165_1380 VDD VDD VSS VSS gf180mcu_as_sc_mcu7t3v3__fillcap_16
XFILLER_25_66 VDD VDD VSS VSS gf180mcu_as_sc_mcu7t3v3__fillcap_4
XFILLER_25_88 VDD VDD VSS VSS gf180mcu_as_sc_mcu7t3v3__fillcap_16
XTAP_TAPCELL_ROW_86_1_980 VDD VSS gf180mcu_as_sc_mcu7t3v3__tap_2
XFILLER_161_1277 VDD VDD VSS VSS gf180mcu_as_sc_mcu7t3v3__fillcap_16
XFILLER_168_877 VDD VDD VSS VSS gf180mcu_as_sc_mcu7t3v3__fillcap_16
XFILLER_41_10 VDD VDD VSS VSS gf180mcu_as_sc_mcu7t3v3__fill_1
XFILLER_52_1550 VDD VDD VSS VSS gf180mcu_as_sc_mcu7t3v3__fillcap_4
XFILLER_155_549 VDD VDD VSS VSS gf180mcu_as_sc_mcu7t3v3__fillcap_8
XFILLER_157_32 VDD VDD VSS VSS gf180mcu_as_sc_mcu7t3v3__fillcap_4
XFILLER_183_836 VDD VDD VSS VSS gf180mcu_as_sc_mcu7t3v3__fillcap_4
XFILLER_136_741 VDD VDD VSS VSS gf180mcu_as_sc_mcu7t3v3__fill_2
XFILLER_157_65 VDD VDD VSS VSS gf180mcu_as_sc_mcu7t3v3__fillcap_4
XFILLER_135_251 VDD VDD VSS VSS gf180mcu_as_sc_mcu7t3v3__fill_1
XFILLER_136_785 VDD VDD VSS VSS gf180mcu_as_sc_mcu7t3v3__fillcap_4
XFILLER_159_1162 VDD VDD VSS VSS gf180mcu_as_sc_mcu7t3v3__fill_1
XFILLER_170_519 VDD VDD VSS VSS gf180mcu_as_sc_mcu7t3v3__fill_1
XFILLER_135_295 VDD VDD VSS VSS gf180mcu_as_sc_mcu7t3v3__fillcap_8
XFILLER_151_733 VDD VDD VSS VSS gf180mcu_as_sc_mcu7t3v3__fill_1
XFILLER_163_582 VDD VDD VSS VSS gf180mcu_as_sc_mcu7t3v3__fill_2
XFILLER_110_107 VDD VDD VSS VSS gf180mcu_as_sc_mcu7t3v3__fillcap_4
XFILLER_173_64 VDD VDD VSS VSS gf180mcu_as_sc_mcu7t3v3__fillcap_4
XFILLER_1_253 VDD VDD VSS VSS gf180mcu_as_sc_mcu7t3v3__fill_2
XTAP_TAPCELL_ROW_166_1915 VDD VSS gf180mcu_as_sc_mcu7t3v3__tap_2
XTAP_TAPCELL_ROW_166_1904 VDD VSS gf180mcu_as_sc_mcu7t3v3__tap_2
XFILLER_106_80 VDD VDD VSS VSS gf180mcu_as_sc_mcu7t3v3__fillcap_16
XFILLER_2_37 VDD VDD VSS VSS gf180mcu_as_sc_mcu7t3v3__fillcap_16
XTAP_TAPCELL_ROW_88_3_2481 VDD VSS gf180mcu_as_sc_mcu7t3v3__tap_2
XFILLER_49_279 VDD VDD VSS VSS gf180mcu_as_sc_mcu7t3v3__fill_1
XPHY_EDGE_ROW_5_3_Right_324 VDD VSS gf180mcu_as_sc_mcu7t3v3__tap_2
XFILLER_144_1420 VDD VDD VSS VSS gf180mcu_as_sc_mcu7t3v3__fillcap_8
XFILLER_183_1480 VDD VDD VSS VSS gf180mcu_as_sc_mcu7t3v3__fillcap_4
XFILLER_57_1483 VDD VDD VSS VSS gf180mcu_as_sc_mcu7t3v3__fillcap_16
XFILLER_174_814 VDD VDD VSS VSS gf180mcu_as_sc_mcu7t3v3__fillcap_16
XFILLER_18_1467 VDD VDD VSS VSS gf180mcu_as_sc_mcu7t3v3__fillcap_16
XFILLER_158_387 VDD VDD VSS VSS gf180mcu_as_sc_mcu7t3v3__fill_2
XFILLER_179_1527 VDD VDD VSS VSS gf180mcu_as_sc_mcu7t3v3__fillcap_8
X_3670_ VDD VDD VSS VSS _3778_/B _4047_/A _3672_/C gf180mcu_as_sc_mcu7t3v3__and2_2
XFILLER_173_346 VDD VDD VSS VSS gf180mcu_as_sc_mcu7t3v3__fillcap_4
X_2621_ VDD VDD VSS VSS _2621_/B _4643_/B _2624_/B gf180mcu_as_sc_mcu7t3v3__or2_2
XFILLER_154_571 VDD VDD VSS VSS gf180mcu_as_sc_mcu7t3v3__fill_2
XFILLER_161_508 VDD VDD VSS VSS gf180mcu_as_sc_mcu7t3v3__fillcap_8
XFILLER_173_368 VDD VDD VSS VSS gf180mcu_as_sc_mcu7t3v3__fillcap_16
XFILLER_99_102 VDD VDD VSS VSS gf180mcu_as_sc_mcu7t3v3__fillcap_8
X_2552_ VDD VDD VSS VSS _4649_/A _5272_/Q _2838_/B gf180mcu_as_sc_mcu7t3v3__and2_2
XFILLER_154_593 VDD VDD VSS VSS gf180mcu_as_sc_mcu7t3v3__fill_2
XFILLER_173_1104 VDD VDD VSS VSS gf180mcu_as_sc_mcu7t3v3__fillcap_4
XFILLER_173_1115 VDD VDD VSS VSS gf180mcu_as_sc_mcu7t3v3__fillcap_4
XFILLER_177_1262 VDD VDD VSS VSS gf180mcu_as_sc_mcu7t3v3__fillcap_8
X_5271_ VDD VDD VSS VSS clkload5/A _5271_/D _5271_/Q gf180mcu_as_sc_mcu7t3v3__dfxtp_2
XFILLER_173_1159 VDD VDD VSS VSS gf180mcu_as_sc_mcu7t3v3__fillcap_4
X_4222_ VDD VDD VSS VSS _4251_/B _4223_/B _4223_/C _5058_/Q _5058_/D gf180mcu_as_sc_mcu7t3v3__ao22_2
X_2483_ VDD VDD VSS VSS _2747_/B _4703_/B _2845_/D gf180mcu_as_sc_mcu7t3v3__nor2_2
XFILLER_151_1457 VDD VDD VSS VSS gf180mcu_as_sc_mcu7t3v3__fillcap_8
X_4153_ VDD VDD VSS VSS _4153_/A _4159_/B _4153_/C _4153_/D _4155_/C gf180mcu_as_sc_mcu7t3v3__ao211_2
XTAP_TAPCELL_ROW_118_1_1106 VDD VSS gf180mcu_as_sc_mcu7t3v3__tap_2
X_4084_ VDD VDD VSS VSS _4996_/Q _4117_/B _4247_/B _4108_/D _4996_/D gf180mcu_as_sc_mcu7t3v3__ao22_2
X_3104_ VDD VDD VSS VSS _4078_/A _3150_/B _3104_/C _3104_/D _3105_/C gf180mcu_as_sc_mcu7t3v3__ao22_2
X_3035_ VDD VDD VSS VSS _3137_/B _4925_/Q _3038_/C gf180mcu_as_sc_mcu7t3v3__or2_2
XFILLER_63_271 VDD VDD VSS VSS gf180mcu_as_sc_mcu7t3v3__fillcap_8
XFILLER_63_282 VDD VDD VSS VSS gf180mcu_as_sc_mcu7t3v3__fillcap_16
XFILLER_145_1228 VDD VDD VSS VSS gf180mcu_as_sc_mcu7t3v3__fill_1
XFILLER_168_107 VDD VDD VSS VSS gf180mcu_as_sc_mcu7t3v3__fillcap_16
X_4986_ VDD VDD VSS VSS _5088_/CLK _4986_/D _4986_/Q gf180mcu_as_sc_mcu7t3v3__dfxtp_2
XFILLER_36_1534 VDD VDD VSS VSS gf180mcu_as_sc_mcu7t3v3__fillcap_16
XFILLER_36_1556 VDD VDD VSS VSS gf180mcu_as_sc_mcu7t3v3__fillcap_8
X_3937_ VDD VDD VSS VSS _4978_/Q _4166_/B _4229_/B _4166_/D _4978_/D gf180mcu_as_sc_mcu7t3v3__ao22_2
XFILLER_123_1515 VDD VDD VSS VSS gf180mcu_as_sc_mcu7t3v3__fillcap_4
XFILLER_123_1537 VDD VDD VSS VSS gf180mcu_as_sc_mcu7t3v3__fillcap_16
XFILLER_137_516 VDD VDD VSS VSS gf180mcu_as_sc_mcu7t3v3__fillcap_4
XFILLER_137_538 VDD VDD VSS VSS gf180mcu_as_sc_mcu7t3v3__fillcap_4
XFILLER_31_190 VDD VDD VSS VSS gf180mcu_as_sc_mcu7t3v3__fillcap_16
X_3868_ VDD VDD VSS VSS _3869_/D _3868_/A _3868_/B _3868_/C gf180mcu_as_sc_mcu7t3v3__ao21_2
XFILLER_164_335 VDD VDD VSS VSS gf180mcu_as_sc_mcu7t3v3__fill_1
X_3799_ VDD VDD VSS VSS _3799_/A _3799_/B _3799_/C _3800_/D _3799_/D gf180mcu_as_sc_mcu7t3v3__oai211_2
X_2819_ VDD VDD VSS VSS _5482_/A _2833_/A _2828_/B gf180mcu_as_sc_mcu7t3v3__and2_2
XTAP_TAPCELL_ROW_94_3_2491 VDD VSS gf180mcu_as_sc_mcu7t3v3__tap_2
XFILLER_178_1059 VDD VDD VSS VSS gf180mcu_as_sc_mcu7t3v3__fill_1
XFILLER_156_1313 VDD VDD VSS VSS gf180mcu_as_sc_mcu7t3v3__fillcap_16
XFILLER_154_1081 VDD VDD VSS VSS gf180mcu_as_sc_mcu7t3v3__fillcap_4
XFILLER_143_56 VDD VDD VSS VSS gf180mcu_as_sc_mcu7t3v3__fillcap_8
XTAP_TAPCELL_ROW_161_1801 VDD VSS gf180mcu_as_sc_mcu7t3v3__tap_2
XFILLER_36_32 VDD VDD VSS VSS gf180mcu_as_sc_mcu7t3v3__fill_2
XFILLER_61_208 VDD VDD VSS VSS gf180mcu_as_sc_mcu7t3v3__fill_2
XFILLER_153_2 VDD VDD VSS VSS gf180mcu_as_sc_mcu7t3v3__fillcap_16
XPHY_EDGE_ROW_38_1_Left_490 VDD VSS gf180mcu_as_sc_mcu7t3v3__tap_2
XFILLER_161_1052 VDD VDD VSS VSS gf180mcu_as_sc_mcu7t3v3__fillcap_8
XFILLER_168_652 VDD VDD VSS VSS gf180mcu_as_sc_mcu7t3v3__fill_1
XTAP_TAPCELL_ROW_159_1763 VDD VSS gf180mcu_as_sc_mcu7t3v3__tap_2
XTAP_TAPCELL_ROW_159_1752 VDD VSS gf180mcu_as_sc_mcu7t3v3__tap_2
XFILLER_156_847 VDD VDD VSS VSS gf180mcu_as_sc_mcu7t3v3__fill_2
XFILLER_168_53 VDD VDD VSS VSS gf180mcu_as_sc_mcu7t3v3__fillcap_16
Xinput18 VDD VDD VSS VSS boot_data[6] _2729_/A gf180mcu_as_sc_mcu7t3v3__buff_2
Xinput29 VDD VDD VSS VSS dft_addr[6] _2664_/B gf180mcu_as_sc_mcu7t3v3__buff_2
XFILLER_143_519 VDD VDD VSS VSS gf180mcu_as_sc_mcu7t3v3__fillcap_8
XFILLER_136_593 VDD VDD VSS VSS gf180mcu_as_sc_mcu7t3v3__fill_2
XFILLER_139_1544 VDD VDD VSS VSS gf180mcu_as_sc_mcu7t3v3__fill_1
XFILLER_170_349 VDD VDD VSS VSS gf180mcu_as_sc_mcu7t3v3__fillcap_16
XFILLER_184_52 VDD VDD VSS VSS gf180mcu_as_sc_mcu7t3v3__fillcap_16
XPHY_EDGE_ROW_57_1_Left_509 VDD VSS gf180mcu_as_sc_mcu7t3v3__tap_2
XFILLER_123_298 VDD VDD VSS VSS gf180mcu_as_sc_mcu7t3v3__fill_2
XFILLER_77_72 VDD VDD VSS VSS gf180mcu_as_sc_mcu7t3v3__fill_1
XFILLER_98_1550 VDD VDD VSS VSS gf180mcu_as_sc_mcu7t3v3__fillcap_4
XFILLER_45_260 VDD VDD VSS VSS gf180mcu_as_sc_mcu7t3v3__fillcap_16
XFILLER_181_1428 VDD VDD VSS VSS gf180mcu_as_sc_mcu7t3v3__fill_2
XFILLER_45_282 VDD VDD VSS VSS gf180mcu_as_sc_mcu7t3v3__fillcap_16
X_4840_ VDD VDD VSS VSS _4863_/CLK _4840_/D _4840_/Q gf180mcu_as_sc_mcu7t3v3__dfxtp_2
XPHY_EDGE_ROW_6_3_Right_325 VDD VSS gf180mcu_as_sc_mcu7t3v3__tap_2
XFILLER_144_1261 VDD VDD VSS VSS gf180mcu_as_sc_mcu7t3v3__fillcap_8
X_4771_ VDD VDD VSS VSS _4869_/CLK _4771_/D _4771_/Q gf180mcu_as_sc_mcu7t3v3__dfxtp_2
XFILLER_13_190 VDD VDD VSS VSS gf180mcu_as_sc_mcu7t3v3__fillcap_16
XFILLER_140_1136 VDD VDD VSS VSS gf180mcu_as_sc_mcu7t3v3__fillcap_4
XFILLER_144_1294 VDD VDD VSS VSS gf180mcu_as_sc_mcu7t3v3__fill_1
XFILLER_147_836 VDD VDD VSS VSS gf180mcu_as_sc_mcu7t3v3__fillcap_4
X_3722_ VDD VDD VSS VSS _3722_/D _3730_/A _3722_/B _3722_/C _3723_/C gf180mcu_as_sc_mcu7t3v3__ao31_2
XFILLER_147_858 VDD VDD VSS VSS gf180mcu_as_sc_mcu7t3v3__fillcap_4
X_3653_ VDD VDD VSS VSS _3654_/C _3653_/C _3745_/B _4025_/A gf180mcu_as_sc_mcu7t3v3__aoi21_2
XPHY_EDGE_ROW_70_1_Right_69 VDD VSS gf180mcu_as_sc_mcu7t3v3__tap_2
XFILLER_146_357 VDD VDD VSS VSS gf180mcu_as_sc_mcu7t3v3__fill_2
X_2604_ VDD VDD VSS VSS _2730_/A _2604_/B _2604_/A _2604_/Y gf180mcu_as_sc_mcu7t3v3__mux2_2
X_3584_ VDD VDD VSS VSS _3585_/C _3947_/A _3791_/B _3584_/C gf180mcu_as_sc_mcu7t3v3__ao21_2
XFILLER_114_243 VDD VDD VSS VSS gf180mcu_as_sc_mcu7t3v3__fill_2
XFILLER_142_563 VDD VDD VSS VSS gf180mcu_as_sc_mcu7t3v3__fillcap_8
XFILLER_153_1508 VDD VDD VSS VSS gf180mcu_as_sc_mcu7t3v3__fillcap_8
X_2535_ VDD VDD VSS VSS _5158_/Q _5157_/Q _4354_/B gf180mcu_as_sc_mcu7t3v3__or2_2
XTAP_TAPCELL_ROW_77_1_944 VDD VSS gf180mcu_as_sc_mcu7t3v3__tap_2
XFILLER_138_1087 VDD VDD VSS VSS gf180mcu_as_sc_mcu7t3v3__fill_1
X_5254_ VDD VDD VSS VSS clkload6/A _5254_/D _5254_/Q gf180mcu_as_sc_mcu7t3v3__dfxtp_2
X_2466_ VDD VDD VSS VSS _2467_/B _2466_/A gf180mcu_as_sc_mcu7t3v3__inv_2
XFILLER_151_1232 VDD VDD VSS VSS gf180mcu_as_sc_mcu7t3v3__fill_2
X_5185_ VDD VDD VSS VSS _5185_/CLK _5185_/D _5185_/Q gf180mcu_as_sc_mcu7t3v3__dfxtp_2
X_4205_ VDD VDD VSS VSS _4234_/B _4219_/B _4219_/C _5041_/Q _5041_/D gf180mcu_as_sc_mcu7t3v3__ao22_2
XFILLER_83_300 VDD VDD VSS VSS gf180mcu_as_sc_mcu7t3v3__fill_1
X_4136_ VDD VDD VSS VSS _4136_/A _4162_/B _4141_/B _4136_/D _4140_/A gf180mcu_as_sc_mcu7t3v3__ao211_2
X_2397_ VDD VDD VSS VSS _2558_/A _4703_/A gf180mcu_as_sc_mcu7t3v3__inv_2
XFILLER_113_37 VDD VDD VSS VSS gf180mcu_as_sc_mcu7t3v3__fill_1
XTAP_TAPCELL_ROW_182_2270 VDD VSS gf180mcu_as_sc_mcu7t3v3__tap_2
X_4067_ VDD VDD VSS VSS _4067_/A _4099_/B _4067_/C _4245_/B _4091_/D gf180mcu_as_sc_mcu7t3v3__aoi211_2
XFILLER_43_208 VDD VDD VSS VSS gf180mcu_as_sc_mcu7t3v3__fill_2
X_3018_ VDD VDD VSS VSS _3999_/A _3127_/B _3127_/C _4000_/D _3019_/C gf180mcu_as_sc_mcu7t3v3__ao22_2
XFILLER_169_416 VDD VDD VSS VSS gf180mcu_as_sc_mcu7t3v3__fillcap_4
XFILLER_184_1041 VDD VDD VSS VSS gf180mcu_as_sc_mcu7t3v3__fillcap_8
XFILLER_169_438 VDD VDD VSS VSS gf180mcu_as_sc_mcu7t3v3__fillcap_16
XFILLER_184_1096 VDD VDD VSS VSS gf180mcu_as_sc_mcu7t3v3__fillcap_8
XFILLER_51_241 VDD VDD VSS VSS gf180mcu_as_sc_mcu7t3v3__fillcap_8
X_4969_ VDD VDD VSS VSS _5146_/CLK _4969_/D _4969_/Q gf180mcu_as_sc_mcu7t3v3__dfxtp_2
Xsram2048.u_bank0_815 VDD VDD VSS VSS sram2048.u_bank0/WEN[5] gf180mcu_as_sc_mcu7t3v3__tiel_4
XFILLER_177_482 VDD VDD VSS VSS gf180mcu_as_sc_mcu7t3v3__fill_1
XFILLER_22_34 VDD VDD VSS VSS gf180mcu_as_sc_mcu7t3v3__fill_1
XTAP_TAPCELL_ROW_96_1_1021 VDD VSS gf180mcu_as_sc_mcu7t3v3__tap_2
XFILLER_138_34 VDD VDD VSS VSS gf180mcu_as_sc_mcu7t3v3__fill_1
XFILLER_149_184 VDD VDD VSS VSS gf180mcu_as_sc_mcu7t3v3__fillcap_16
XFILLER_137_368 VDD VDD VSS VSS gf180mcu_as_sc_mcu7t3v3__fillcap_16
XFILLER_152_305 VDD VDD VSS VSS gf180mcu_as_sc_mcu7t3v3__fill_1
XFILLER_153_839 VDD VDD VSS VSS gf180mcu_as_sc_mcu7t3v3__fill_1
XFILLER_98_16 VDD VDD VSS VSS gf180mcu_as_sc_mcu7t3v3__fill_1
XFILLER_180_636 VDD VDD VSS VSS gf180mcu_as_sc_mcu7t3v3__fillcap_4
XFILLER_98_27 VDD VDD VSS VSS gf180mcu_as_sc_mcu7t3v3__fillcap_8
XFILLER_145_390 VDD VDD VSS VSS gf180mcu_as_sc_mcu7t3v3__fill_2
XFILLER_156_1132 VDD VDD VSS VSS gf180mcu_as_sc_mcu7t3v3__fillcap_16
XTAP_TAPCELL_ROW_150_1557 VDD VSS gf180mcu_as_sc_mcu7t3v3__tap_2
XTAP_TAPCELL_ROW_150_1546 VDD VSS gf180mcu_as_sc_mcu7t3v3__tap_2
XFILLER_156_1154 VDD VDD VSS VSS gf180mcu_as_sc_mcu7t3v3__fill_1
XFILLER_105_298 VDD VDD VSS VSS gf180mcu_as_sc_mcu7t3v3__fill_2
XFILLER_134_1430 VDD VDD VSS VSS gf180mcu_as_sc_mcu7t3v3__fillcap_16
XFILLER_169_1504 VDD VDD VSS VSS gf180mcu_as_sc_mcu7t3v3__fillcap_16
XFILLER_74_300 VDD VDD VSS VSS gf180mcu_as_sc_mcu7t3v3__fill_1
XPHY_EDGE_ROW_110_3_Right_429 VDD VSS gf180mcu_as_sc_mcu7t3v3__tap_2
XTAP_TAPCELL_ROW_19_1_713 VDD VSS gf180mcu_as_sc_mcu7t3v3__tap_2
XFILLER_27_260 VDD VDD VSS VSS gf180mcu_as_sc_mcu7t3v3__fillcap_16
XFILLER_27_282 VDD VDD VSS VSS gf180mcu_as_sc_mcu7t3v3__fillcap_16
XFILLER_167_1294 VDD VDD VSS VSS gf180mcu_as_sc_mcu7t3v3__fillcap_8
XFILLER_42_263 VDD VDD VSS VSS gf180mcu_as_sc_mcu7t3v3__fillcap_16
XFILLER_168_471 VDD VDD VSS VSS gf180mcu_as_sc_mcu7t3v3__fill_1
XFILLER_180_1483 VDD VDD VSS VSS gf180mcu_as_sc_mcu7t3v3__fill_1
XFILLER_54_1486 VDD VDD VSS VSS gf180mcu_as_sc_mcu7t3v3__fillcap_16
XFILLER_141_1445 VDD VDD VSS VSS gf180mcu_as_sc_mcu7t3v3__fillcap_8
XFILLER_180_1494 VDD VDD VSS VSS gf180mcu_as_sc_mcu7t3v3__fillcap_8
XFILLER_8_69 VDD VDD VSS VSS gf180mcu_as_sc_mcu7t3v3__fillcap_16
XFILLER_10_171 VDD VDD VSS VSS gf180mcu_as_sc_mcu7t3v3__fillcap_4
XFILLER_10_193 VDD VDD VSS VSS gf180mcu_as_sc_mcu7t3v3__fillcap_16
XFILLER_156_699 VDD VDD VSS VSS gf180mcu_as_sc_mcu7t3v3__fillcap_8
XTAP_TAPCELL_ROW_76_3_2463 VDD VSS gf180mcu_as_sc_mcu7t3v3__tap_2
XFILLER_152_850 VDD VDD VSS VSS gf180mcu_as_sc_mcu7t3v3__fillcap_8
XFILLER_139_1396 VDD VDD VSS VSS gf180mcu_as_sc_mcu7t3v3__fillcap_4
XPHY_EDGE_ROW_20_3_Left_154 VDD VSS gf180mcu_as_sc_mcu7t3v3__tap_2
XFILLER_69_138 VDD VDD VSS VSS gf180mcu_as_sc_mcu7t3v3__fill_2
XFILLER_111_257 VDD VDD VSS VSS gf180mcu_as_sc_mcu7t3v3__fillcap_8
XFILLER_111_279 VDD VDD VSS VSS gf180mcu_as_sc_mcu7t3v3__fill_1
XFILLER_65_300 VDD VDD VSS VSS gf180mcu_as_sc_mcu7t3v3__fill_1
XFILLER_77_160 VDD VDD VSS VSS gf180mcu_as_sc_mcu7t3v3__fill_2
XFILLER_92_130 VDD VDD VSS VSS gf180mcu_as_sc_mcu7t3v3__fillcap_16
XFILLER_146_1323 VDD VDD VSS VSS gf180mcu_as_sc_mcu7t3v3__fill_1
XFILLER_18_271 VDD VDD VSS VSS gf180mcu_as_sc_mcu7t3v3__fillcap_4
XPHY_EDGE_ROW_7_3_Right_326 VDD VSS gf180mcu_as_sc_mcu7t3v3__tap_2
XFILLER_146_1367 VDD VDD VSS VSS gf180mcu_as_sc_mcu7t3v3__fillcap_16
XFILLER_167_909 VDD VDD VSS VSS gf180mcu_as_sc_mcu7t3v3__fill_1
X_4823_ VDD VDD VSS VSS _5053_/CLK _4823_/D _4823_/Q gf180mcu_as_sc_mcu7t3v3__dfxtp_2
XFILLER_159_471 VDD VDD VSS VSS gf180mcu_as_sc_mcu7t3v3__fillcap_16
XFILLER_166_419 VDD VDD VSS VSS gf180mcu_as_sc_mcu7t3v3__fillcap_16
XFILLER_178_279 VDD VDD VSS VSS gf180mcu_as_sc_mcu7t3v3__fillcap_16
XFILLER_33_1515 VDD VDD VSS VSS gf180mcu_as_sc_mcu7t3v3__fillcap_4
XFILLER_33_1537 VDD VDD VSS VSS gf180mcu_as_sc_mcu7t3v3__fillcap_16
XFILLER_72_1564 VDD VDD VSS VSS gf180mcu_as_sc_mcu7t3v3__fillcap_4
X_4754_ VDD VDD VSS VSS clkload1/A _4754_/D _4754_/Q gf180mcu_as_sc_mcu7t3v3__dfxtp_2
XFILLER_120_1518 VDD VDD VSS VSS gf180mcu_as_sc_mcu7t3v3__fillcap_16
X_3705_ VDD VDD VSS VSS _3706_/C _3705_/C _3752_/B _4081_/A gf180mcu_as_sc_mcu7t3v3__aoi21_2
XFILLER_134_305 VDD VDD VSS VSS gf180mcu_as_sc_mcu7t3v3__fill_1
XFILLER_147_666 VDD VDD VSS VSS gf180mcu_as_sc_mcu7t3v3__fillcap_16
X_4685_ VDD VDD VSS VSS _5103_/Q _4731_/B _4685_/C _5249_/Q _4686_/D gf180mcu_as_sc_mcu7t3v3__ao22_2
XFILLER_135_839 VDD VDD VSS VSS gf180mcu_as_sc_mcu7t3v3__fill_1
XFILLER_179_1187 VDD VDD VSS VSS gf180mcu_as_sc_mcu7t3v3__fill_2
X_3636_ VDD VDD VSS VSS _3636_/D _4008_/D _3736_/B _3728_/C _3637_/C gf180mcu_as_sc_mcu7t3v3__ao31_2
XFILLER_108_37 VDD VDD VSS VSS gf180mcu_as_sc_mcu7t3v3__fill_1
XFILLER_157_1430 VDD VDD VSS VSS gf180mcu_as_sc_mcu7t3v3__fill_1
X_3567_ VDD VDD VSS VSS _4915_/Q _3799_/B _3770_/C _3930_/A _3568_/D gf180mcu_as_sc_mcu7t3v3__ao22_2
X_2518_ VDD VDD VSS VSS _4704_/B _4703_/B _2747_/A gf180mcu_as_sc_mcu7t3v3__nand2_2
X_5237_ VDD VDD VSS VSS clkload5/A _5237_/D _5237_/Q gf180mcu_as_sc_mcu7t3v3__dfxtp_2
Xinput208 VDD VDD VSS VSS se_in[3] _3961_/A gf180mcu_as_sc_mcu7t3v3__buff_2
X_3498_ VDD VDD VSS VSS _3505_/S _3498_/B _4156_/A _3499_/B gf180mcu_as_sc_mcu7t3v3__mux2_2
XTAP_TAPCELL_ROW_184_2332 VDD VSS gf180mcu_as_sc_mcu7t3v3__tap_2
XTAP_TAPCELL_ROW_184_2321 VDD VSS gf180mcu_as_sc_mcu7t3v3__tap_2
XTAP_TAPCELL_ROW_184_2310 VDD VSS gf180mcu_as_sc_mcu7t3v3__tap_2
XFILLER_124_25 VDD VDD VSS VSS gf180mcu_as_sc_mcu7t3v3__fillcap_8
Xinput219 VDD VDD VSS VSS south_in[13] _4040_/D gf180mcu_as_sc_mcu7t3v3__buff_2
X_2449_ VDD VDD VSS VSS _3192_/D _4160_/A gf180mcu_as_sc_mcu7t3v3__inv_2
XTAP_TAPCELL_ROW_59_1_873 VDD VSS gf180mcu_as_sc_mcu7t3v3__tap_2
XTAP_TAPCELL_ROW_180_2207 VDD VSS gf180mcu_as_sc_mcu7t3v3__tap_2
XFILLER_56_300 VDD VDD VSS VSS gf180mcu_as_sc_mcu7t3v3__fill_1
X_5168_ VDD VDD VSS VSS _5183_/CLK _5168_/D _5168_/Q gf180mcu_as_sc_mcu7t3v3__dfxtp_2
XTAP_TAPCELL_ROW_180_2218 VDD VSS gf180mcu_as_sc_mcu7t3v3__tap_2
X_5099_ VDD VDD VSS VSS clkload4/A _5099_/D _5099_/Q gf180mcu_as_sc_mcu7t3v3__dfxtp_2
X_4119_ VDD VDD VSS VSS _4119_/A _4119_/B _4124_/B _4119_/D _4123_/A gf180mcu_as_sc_mcu7t3v3__ao211_2
XFILLER_17_34 VDD VDD VSS VSS gf180mcu_as_sc_mcu7t3v3__fillcap_16
XPHY_EDGE_ROW_139_Right_273 VDD VSS gf180mcu_as_sc_mcu7t3v3__tap_2
XFILLER_129_1521 VDD VDD VSS VSS gf180mcu_as_sc_mcu7t3v3__fillcap_16
XFILLER_83_185 VDD VDD VSS VSS gf180mcu_as_sc_mcu7t3v3__fillcap_16
XFILLER_164_1434 VDD VDD VSS VSS gf180mcu_as_sc_mcu7t3v3__fill_1
XFILLER_24_241 VDD VDD VSS VSS gf180mcu_as_sc_mcu7t3v3__fillcap_4
XFILLER_24_263 VDD VDD VSS VSS gf180mcu_as_sc_mcu7t3v3__fillcap_8
XTAP_TAPCELL_ROW_82_3_2473 VDD VSS gf180mcu_as_sc_mcu7t3v3__tap_2
XTAP_TAPCELL_ROW_143_1394 VDD VSS gf180mcu_as_sc_mcu7t3v3__tap_2
XTAP_TAPCELL_ROW_178_2169 VDD VSS gf180mcu_as_sc_mcu7t3v3__tap_2
XFILLER_33_66 VDD VDD VSS VSS gf180mcu_as_sc_mcu7t3v3__fillcap_4
XFILLER_149_66 VDD VDD VSS VSS gf180mcu_as_sc_mcu7t3v3__fillcap_4
XFILLER_166_942 VDD VDD VSS VSS gf180mcu_as_sc_mcu7t3v3__fill_2
XFILLER_33_88 VDD VDD VSS VSS gf180mcu_as_sc_mcu7t3v3__fillcap_16
XFILLER_149_88 VDD VDD VSS VSS gf180mcu_as_sc_mcu7t3v3__fillcap_16
XFILLER_165_463 VDD VDD VSS VSS gf180mcu_as_sc_mcu7t3v3__fillcap_4
XFILLER_166_986 VDD VDD VSS VSS gf180mcu_as_sc_mcu7t3v3__fillcap_16
XTAP_TAPCELL_ROW_152_1608 VDD VSS gf180mcu_as_sc_mcu7t3v3__tap_2
XFILLER_101_1451 VDD VDD VSS VSS gf180mcu_as_sc_mcu7t3v3__fillcap_16
XFILLER_116_2 VDD VDD VSS VSS gf180mcu_as_sc_mcu7t3v3__fillcap_8
XFILLER_153_625 VDD VDD VSS VSS gf180mcu_as_sc_mcu7t3v3__fillcap_4
XFILLER_158_1216 VDD VDD VSS VSS gf180mcu_as_sc_mcu7t3v3__fill_2
XFILLER_158_1238 VDD VDD VSS VSS gf180mcu_as_sc_mcu7t3v3__fillcap_8
XFILLER_165_496 VDD VDD VSS VSS gf180mcu_as_sc_mcu7t3v3__fill_2
XFILLER_181_945 VDD VDD VSS VSS gf180mcu_as_sc_mcu7t3v3__fillcap_4
XFILLER_134_894 VDD VDD VSS VSS gf180mcu_as_sc_mcu7t3v3__fillcap_4
XTAP_TAPCELL_ROW_119_1_1111 VDD VSS gf180mcu_as_sc_mcu7t3v3__tap_2
XFILLER_58_52 VDD VDD VSS VSS gf180mcu_as_sc_mcu7t3v3__fill_1
XFILLER_134_1260 VDD VDD VSS VSS gf180mcu_as_sc_mcu7t3v3__fillcap_16
XFILLER_47_300 VDD VDD VSS VSS gf180mcu_as_sc_mcu7t3v3__fill_1
XFILLER_59_160 VDD VDD VSS VSS gf180mcu_as_sc_mcu7t3v3__fillcap_16
XFILLER_114_80 VDD VDD VSS VSS gf180mcu_as_sc_mcu7t3v3__fillcap_8
XTAP_TAPCELL_ROW_68_1_908 VDD VSS gf180mcu_as_sc_mcu7t3v3__tap_2
XFILLER_143_1518 VDD VDD VSS VSS gf180mcu_as_sc_mcu7t3v3__fill_1
XFILLER_128_132 VDD VDD VSS VSS gf180mcu_as_sc_mcu7t3v3__fillcap_16
XFILLER_172_901 VDD VDD VSS VSS gf180mcu_as_sc_mcu7t3v3__fill_2
XFILLER_184_750 VDD VDD VSS VSS gf180mcu_as_sc_mcu7t3v3__fill_2
XFILLER_30_299 VDD VDD VSS VSS gf180mcu_as_sc_mcu7t3v3__fill_2
XFILLER_171_400 VDD VDD VSS VSS gf180mcu_as_sc_mcu7t3v3__fillcap_16
XFILLER_171_422 VDD VDD VSS VSS gf180mcu_as_sc_mcu7t3v3__fillcap_16
XFILLER_183_282 VDD VDD VSS VSS gf180mcu_as_sc_mcu7t3v3__fillcap_16
X_4470_ VDD VDD VSS VSS _5176_/Q _4470_/B _4493_/C _5110_/Q _4471_/B gf180mcu_as_sc_mcu7t3v3__ao22_2
XFILLER_172_978 VDD VDD VSS VSS gf180mcu_as_sc_mcu7t3v3__fill_1
XFILLER_172_989 VDD VDD VSS VSS gf180mcu_as_sc_mcu7t3v3__fillcap_8
XFILLER_99_92 VDD VDD VSS VSS gf180mcu_as_sc_mcu7t3v3__fill_2
X_3421_ VDD VDD VSS VSS _3452_/S _4069_/A _3421_/A _3423_/B gf180mcu_as_sc_mcu7t3v3__mux2_2
X_3352_ VDD VDD VSS VSS _4003_/A _3470_/B _3352_/C _4813_/D _3746_/D gf180mcu_as_sc_mcu7t3v3__aoi211_2
XFILLER_31_2 VDD VDD VSS VSS gf180mcu_as_sc_mcu7t3v3__fillcap_16
XFILLER_151_190 VDD VDD VSS VSS gf180mcu_as_sc_mcu7t3v3__fillcap_16
XFILLER_57_108 VDD VDD VSS VSS gf180mcu_as_sc_mcu7t3v3__fill_2
X_3283_ VDD VDD VSS VSS _3283_/A _3526_/C _3526_/D _3524_/C gf180mcu_as_sc_mcu7t3v3__nor3_2
XTAP_TAPCELL_ROW_47_1_822 VDD VSS gf180mcu_as_sc_mcu7t3v3__tap_2
X_5022_ VDD VDD VSS VSS _5080_/CLK _5022_/D _5022_/Q gf180mcu_as_sc_mcu7t3v3__dfxtp_2
XFILLER_65_174 VDD VDD VSS VSS gf180mcu_as_sc_mcu7t3v3__fillcap_16
XFILLER_0_70 VDD VDD VSS VSS gf180mcu_as_sc_mcu7t3v3__fillcap_16
XFILLER_148_1429 VDD VDD VSS VSS gf180mcu_as_sc_mcu7t3v3__fillcap_4
XFILLER_181_1000 VDD VDD VSS VSS gf180mcu_as_sc_mcu7t3v3__fill_2
XFILLER_80_144 VDD VDD VSS VSS gf180mcu_as_sc_mcu7t3v3__fill_1
XFILLER_80_155 VDD VDD VSS VSS gf180mcu_as_sc_mcu7t3v3__fillcap_4
XFILLER_146_1153 VDD VDD VSS VSS gf180mcu_as_sc_mcu7t3v3__fill_2
XFILLER_139_419 VDD VDD VSS VSS gf180mcu_as_sc_mcu7t3v3__fill_1
XFILLER_21_244 VDD VDD VSS VSS gf180mcu_as_sc_mcu7t3v3__fillcap_16
X_4806_ VDD VDD VSS VSS _5046_/CLK _4806_/D _4806_/Q gf180mcu_as_sc_mcu7t3v3__dfxtp_2
XPHY_EDGE_ROW_8_3_Right_327 VDD VSS gf180mcu_as_sc_mcu7t3v3__tap_2
XFILLER_124_1451 VDD VDD VSS VSS gf180mcu_as_sc_mcu7t3v3__fillcap_16
XFILLER_147_430 VDD VDD VSS VSS gf180mcu_as_sc_mcu7t3v3__fillcap_4
XFILLER_148_942 VDD VDD VSS VSS gf180mcu_as_sc_mcu7t3v3__fill_2
X_2998_ VDD VDD VSS VSS _3608_/A _3149_/B _2998_/C _4776_/D _3661_/D gf180mcu_as_sc_mcu7t3v3__aoi211_2
XTAP_TAPCELL_ROW_173_2055 VDD VSS gf180mcu_as_sc_mcu7t3v3__tap_2
XFILLER_119_154 VDD VDD VSS VSS gf180mcu_as_sc_mcu7t3v3__fill_1
XFILLER_175_772 VDD VDD VSS VSS gf180mcu_as_sc_mcu7t3v3__fillcap_16
XFILLER_181_208 VDD VDD VSS VSS gf180mcu_as_sc_mcu7t3v3__fill_2
X_4737_ VDD VDD VSS VSS _4739_/B _4742_/C _4737_/C _5270_/D gf180mcu_as_sc_mcu7t3v3__nor3_2
XTAP_TAPCELL_ROW_173_2066 VDD VSS gf180mcu_as_sc_mcu7t3v3__tap_2
XFILLER_119_69 VDD VDD VSS VSS gf180mcu_as_sc_mcu7t3v3__fill_1
X_4668_ VDD VDD VSS VSS _5241_/D _5241_/Q _4685_/C _4668_/C gf180mcu_as_sc_mcu7t3v3__ao21_2
XFILLER_134_135 VDD VDD VSS VSS gf180mcu_as_sc_mcu7t3v3__fill_1
XFILLER_163_978 VDD VDD VSS VSS gf180mcu_as_sc_mcu7t3v3__fill_2
X_3619_ VDD VDD VSS VSS _3991_/A _3779_/B _3778_/B _3989_/D _3620_/D gf180mcu_as_sc_mcu7t3v3__ao22_2
X_4599_ VDD VDD VSS VSS _5193_/Q _4750_/D _4600_/C _5194_/Q _5193_/D gf180mcu_as_sc_mcu7t3v3__ao22_2
XFILLER_0_104 VDD VDD VSS VSS gf180mcu_as_sc_mcu7t3v3__fillcap_16
XFILLER_135_24 VDD VDD VSS VSS gf180mcu_as_sc_mcu7t3v3__fillcap_8
XFILLER_88_233 VDD VDD VSS VSS gf180mcu_as_sc_mcu7t3v3__fillcap_8
XPHY_EDGE_ROW_139_Left_591 VDD VSS gf180mcu_as_sc_mcu7t3v3__tap_2
XFILLER_29_300 VDD VDD VSS VSS gf180mcu_as_sc_mcu7t3v3__fill_1
XFILLER_88_299 VDD VDD VSS VSS gf180mcu_as_sc_mcu7t3v3__fill_2
XFILLER_79_1515 VDD VDD VSS VSS gf180mcu_as_sc_mcu7t3v3__fillcap_4
XFILLER_131_1499 VDD VDD VSS VSS gf180mcu_as_sc_mcu7t3v3__fillcap_16
XFILLER_56_174 VDD VDD VSS VSS gf180mcu_as_sc_mcu7t3v3__fill_1
XFILLER_79_1537 VDD VDD VSS VSS gf180mcu_as_sc_mcu7t3v3__fillcap_16
XPHY_EDGE_ROW_150_Right_284 VDD VSS gf180mcu_as_sc_mcu7t3v3__tap_2
XTAP_TAPCELL_ROW_145_1456 VDD VSS gf180mcu_as_sc_mcu7t3v3__tap_2
XTAP_TAPCELL_ROW_145_1445 VDD VSS gf180mcu_as_sc_mcu7t3v3__tap_2
XFILLER_166_1507 VDD VDD VSS VSS gf180mcu_as_sc_mcu7t3v3__fillcap_16
XFILLER_44_10 VDD VDD VSS VSS gf180mcu_as_sc_mcu7t3v3__fill_1
XFILLER_44_32 VDD VDD VSS VSS gf180mcu_as_sc_mcu7t3v3__fill_2
XFILLER_71_144 VDD VDD VSS VSS gf180mcu_as_sc_mcu7t3v3__fill_1
XFILLER_158_706 VDD VDD VSS VSS gf180mcu_as_sc_mcu7t3v3__fill_2
XPHY_EDGE_ROW_66_1_Left_518 VDD VSS gf180mcu_as_sc_mcu7t3v3__tap_2
XFILLER_164_1297 VDD VDD VSS VSS gf180mcu_as_sc_mcu7t3v3__fillcap_4
XFILLER_60_31 VDD VDD VSS VSS gf180mcu_as_sc_mcu7t3v3__fillcap_4
XFILLER_90_1483 VDD VDD VSS VSS gf180mcu_as_sc_mcu7t3v3__fill_1
XFILLER_12_299 VDD VDD VSS VSS gf180mcu_as_sc_mcu7t3v3__fill_2
XFILLER_51_1467 VDD VDD VSS VSS gf180mcu_as_sc_mcu7t3v3__fillcap_16
XFILLER_153_422 VDD VDD VSS VSS gf180mcu_as_sc_mcu7t3v3__fillcap_4
XFILLER_158_1013 VDD VDD VSS VSS gf180mcu_as_sc_mcu7t3v3__fill_2
XFILLER_165_271 VDD VDD VSS VSS gf180mcu_as_sc_mcu7t3v3__fillcap_8
XFILLER_165_282 VDD VDD VSS VSS gf180mcu_as_sc_mcu7t3v3__fillcap_16
XFILLER_176_53 VDD VDD VSS VSS gf180mcu_as_sc_mcu7t3v3__fillcap_16
XFILLER_181_731 VDD VDD VSS VSS gf180mcu_as_sc_mcu7t3v3__fillcap_4
XFILLER_153_455 VDD VDD VSS VSS gf180mcu_as_sc_mcu7t3v3__fillcap_16
XFILLER_180_241 VDD VDD VSS VSS gf180mcu_as_sc_mcu7t3v3__fillcap_4
XFILLER_109_80 VDD VDD VSS VSS gf180mcu_as_sc_mcu7t3v3__fillcap_8
XFILLER_125_179 VDD VDD VSS VSS gf180mcu_as_sc_mcu7t3v3__fill_2
XFILLER_141_628 VDD VDD VSS VSS gf180mcu_as_sc_mcu7t3v3__fill_2
XFILLER_141_639 VDD VDD VSS VSS gf180mcu_as_sc_mcu7t3v3__fillcap_4
XFILLER_158_1068 VDD VDD VSS VSS gf180mcu_as_sc_mcu7t3v3__fill_2
XFILLER_180_263 VDD VDD VSS VSS gf180mcu_as_sc_mcu7t3v3__fillcap_16
XFILLER_171_1213 VDD VDD VSS VSS gf180mcu_as_sc_mcu7t3v3__fillcap_4
XTAP_TAPCELL_ROW_87_1_982 VDD VSS gf180mcu_as_sc_mcu7t3v3__tap_2
XTAP_TAPCELL_ROW_169_1968 VDD VSS gf180mcu_as_sc_mcu7t3v3__tap_2
XFILLER_79_277 VDD VDD VSS VSS gf180mcu_as_sc_mcu7t3v3__fill_2
XFILLER_94_203 VDD VDD VSS VSS gf180mcu_as_sc_mcu7t3v3__fill_1
XTAP_TAPCELL_ROW_169_1979 VDD VSS gf180mcu_as_sc_mcu7t3v3__tap_2
XFILLER_134_1090 VDD VDD VSS VSS gf180mcu_as_sc_mcu7t3v3__fillcap_16
XFILLER_94_247 VDD VDD VSS VSS gf180mcu_as_sc_mcu7t3v3__fillcap_8
XFILLER_85_72 VDD VDD VSS VSS gf180mcu_as_sc_mcu7t3v3__fill_1
XFILLER_62_144 VDD VDD VSS VSS gf180mcu_as_sc_mcu7t3v3__fill_1
X_3970_ VDD VDD VSS VSS _3971_/C _3970_/B _3970_/A gf180mcu_as_sc_mcu7t3v3__nor2_2
XFILLER_62_177 VDD VDD VSS VSS gf180mcu_as_sc_mcu7t3v3__fillcap_16
X_2921_ VDD VDD VSS VSS _3553_/A _3554_/A _3814_/A _2932_/C gf180mcu_as_sc_mcu7t3v3__nand3_2
XFILLER_182_1364 VDD VDD VSS VSS gf180mcu_as_sc_mcu7t3v3__fill_1
XFILLER_182_1375 VDD VDD VSS VSS gf180mcu_as_sc_mcu7t3v3__fill_2
XTAP_TAPCELL_ROW_64_3_2445 VDD VSS gf180mcu_as_sc_mcu7t3v3__tap_2
XFILLER_143_1348 VDD VDD VSS VSS gf180mcu_as_sc_mcu7t3v3__fillcap_4
X_2852_ VDD VDD VSS VSS _2852_/Y _3874_/A _2852_/B _5097_/Q gf180mcu_as_sc_mcu7t3v3__aoi21_2
XFILLER_30_1518 VDD VDD VSS VSS gf180mcu_as_sc_mcu7t3v3__fillcap_16
XFILLER_79_2 VDD VDD VSS VSS gf180mcu_as_sc_mcu7t3v3__fillcap_8
X_2783_ VDD VDD VSS VSS _2783_/B _2783_/A _4647_/A gf180mcu_as_sc_mcu7t3v3__and2_2
XFILLER_141_1083 VDD VDD VSS VSS gf180mcu_as_sc_mcu7t3v3__fill_2
XFILLER_144_400 VDD VDD VSS VSS gf180mcu_as_sc_mcu7t3v3__fillcap_16
XFILLER_145_923 VDD VDD VSS VSS gf180mcu_as_sc_mcu7t3v3__fillcap_16
XFILLER_157_772 VDD VDD VSS VSS gf180mcu_as_sc_mcu7t3v3__fillcap_16
XFILLER_172_731 VDD VDD VSS VSS gf180mcu_as_sc_mcu7t3v3__fillcap_4
XFILLER_184_580 VDD VDD VSS VSS gf180mcu_as_sc_mcu7t3v3__fill_2
X_4522_ VDD VDD VSS VSS _5180_/Q _4565_/B _4522_/C _4522_/D _5180_/D gf180mcu_as_sc_mcu7t3v3__ao211_2
X_4453_ VDD VDD VSS VSS _4453_/B _4591_/A _4460_/C gf180mcu_as_sc_mcu7t3v3__and2_2
XFILLER_116_157 VDD VDD VSS VSS gf180mcu_as_sc_mcu7t3v3__fillcap_16
XFILLER_137_1108 VDD VDD VSS VSS gf180mcu_as_sc_mcu7t3v3__fill_1
XFILLER_176_1157 VDD VDD VSS VSS gf180mcu_as_sc_mcu7t3v3__fillcap_4
X_3404_ VDD VDD VSS VSS _4053_/A _3451_/B _3404_/C _3404_/D _3405_/A gf180mcu_as_sc_mcu7t3v3__ao211_2
XFILLER_119_1553 VDD VDD VSS VSS gf180mcu_as_sc_mcu7t3v3__fillcap_4
XFILLER_131_138 VDD VDD VSS VSS gf180mcu_as_sc_mcu7t3v3__fill_2
Xfanout706 VDD VDD VSS VSS _3179_/B _3236_/B gf180mcu_as_sc_mcu7t3v3__buff_2
X_4384_ VDD VDD VSS VSS _4385_/D _4384_/B _4510_/A gf180mcu_as_sc_mcu7t3v3__nor2_2
XFILLER_154_1455 VDD VDD VSS VSS gf180mcu_as_sc_mcu7t3v3__fillcap_4
Xfanout717 VDD VDD VSS VSS _4720_/A _4733_/C gf180mcu_as_sc_mcu7t3v3__buff_2
Xfanout728 VDD VDD VSS VSS _2894_/Y _3151_/S gf180mcu_as_sc_mcu7t3v3__buff_2
Xfanout739 VDD VDD VSS VSS _4167_/Y _4192_/B gf180mcu_as_sc_mcu7t3v3__buff_2
X_3335_ VDD VDD VSS VSS _3616_/A _3455_/B _3335_/C _4811_/D _3722_/D gf180mcu_as_sc_mcu7t3v3__aoi211_2
XFILLER_105_27 VDD VDD VSS VSS gf180mcu_as_sc_mcu7t3v3__fillcap_8
XFILLER_140_683 VDD VDD VSS VSS gf180mcu_as_sc_mcu7t3v3__fillcap_8
X_3266_ VDD VDD VSS VSS _3275_/B _3266_/B _3807_/A gf180mcu_as_sc_mcu7t3v3__nand2_2
X_5005_ VDD VDD VSS VSS _5094_/CLK _5005_/D _5005_/Q gf180mcu_as_sc_mcu7t3v3__dfxtp_2
X_3197_ VDD VDD VSS VSS _3227_/S _3197_/B _3788_/A _3198_/B gf180mcu_as_sc_mcu7t3v3__mux2_2
XTAP_TAPCELL_ROW_29_1_751 VDD VSS gf180mcu_as_sc_mcu7t3v3__tap_2
XPHY_EDGE_ROW_108_3_Left_242 VDD VSS gf180mcu_as_sc_mcu7t3v3__tap_2
XFILLER_121_37 VDD VDD VSS VSS gf180mcu_as_sc_mcu7t3v3__fill_1
XFILLER_183_1106 VDD VDD VSS VSS gf180mcu_as_sc_mcu7t3v3__fill_2
XFILLER_39_1521 VDD VDD VSS VSS gf180mcu_as_sc_mcu7t3v3__fillcap_16
XFILLER_53_144 VDD VDD VSS VSS gf180mcu_as_sc_mcu7t3v3__fill_1
XFILLER_126_1502 VDD VDD VSS VSS gf180mcu_as_sc_mcu7t3v3__fillcap_16
XFILLER_179_330 VDD VDD VSS VSS gf180mcu_as_sc_mcu7t3v3__fillcap_16
XFILLER_53_188 VDD VDD VSS VSS gf180mcu_as_sc_mcu7t3v3__fillcap_16
XTAP_TAPCELL_ROW_175_2106 VDD VSS gf180mcu_as_sc_mcu7t3v3__tap_2
XTAP_TAPCELL_ROW_140_1342 VDD VSS gf180mcu_as_sc_mcu7t3v3__tap_2
XTAP_TAPCELL_ROW_140_1331 VDD VSS gf180mcu_as_sc_mcu7t3v3__tap_2
XFILLER_179_352 VDD VDD VSS VSS gf180mcu_as_sc_mcu7t3v3__fillcap_16
XFILLER_74_1467 VDD VDD VSS VSS gf180mcu_as_sc_mcu7t3v3__fillcap_16
XTAP_TAPCELL_ROW_175_2117 VDD VSS gf180mcu_as_sc_mcu7t3v3__tap_2
XFILLER_139_227 VDD VDD VSS VSS gf180mcu_as_sc_mcu7t3v3__fillcap_16
XFILLER_167_525 VDD VDD VSS VSS gf180mcu_as_sc_mcu7t3v3__fill_1
XFILLER_167_536 VDD VDD VSS VSS gf180mcu_as_sc_mcu7t3v3__fillcap_8
XPHY_EDGE_ROW_9_3_Right_328 VDD VSS gf180mcu_as_sc_mcu7t3v3__tap_2
XFILLER_11_1451 VDD VDD VSS VSS gf180mcu_as_sc_mcu7t3v3__fillcap_16
XFILLER_147_282 VDD VDD VSS VSS gf180mcu_as_sc_mcu7t3v3__fillcap_16
XFILLER_163_731 VDD VDD VSS VSS gf180mcu_as_sc_mcu7t3v3__fill_2
XFILLER_30_34 VDD VDD VSS VSS gf180mcu_as_sc_mcu7t3v3__fill_1
XTAP_TAPCELL_ROW_138_1293 VDD VSS gf180mcu_as_sc_mcu7t3v3__tap_2
XTAP_TAPCELL_ROW_138_1282 VDD VSS gf180mcu_as_sc_mcu7t3v3__tap_2
XFILLER_107_168 VDD VDD VSS VSS gf180mcu_as_sc_mcu7t3v3__fillcap_8
XFILLER_151_926 VDD VDD VSS VSS gf180mcu_as_sc_mcu7t3v3__fill_1
XFILLER_155_1208 VDD VDD VSS VSS gf180mcu_as_sc_mcu7t3v3__fillcap_16
XFILLER_162_263 VDD VDD VSS VSS gf180mcu_as_sc_mcu7t3v3__fillcap_4
XTAP_TAPCELL_ROW_134_1179 VDD VSS gf180mcu_as_sc_mcu7t3v3__tap_2
XFILLER_151_948 VDD VDD VSS VSS gf180mcu_as_sc_mcu7t3v3__fill_1
XFILLER_172_1555 VDD VDD VSS VSS gf180mcu_as_sc_mcu7t3v3__fillcap_8
XFILLER_39_65 VDD VDD VSS VSS gf180mcu_as_sc_mcu7t3v3__fillcap_4
XFILLER_76_247 VDD VDD VSS VSS gf180mcu_as_sc_mcu7t3v3__fillcap_8
XTAP_TAPCELL_ROW_70_3_2455 VDD VSS gf180mcu_as_sc_mcu7t3v3__tap_2
XFILLER_183_2 VDD VDD VSS VSS gf180mcu_as_sc_mcu7t3v3__fillcap_8
XTAP_TAPCELL_ROW_164_1854 VDD VSS gf180mcu_as_sc_mcu7t3v3__tap_2
XTAP_TAPCELL_ROW_164_1865 VDD VSS gf180mcu_as_sc_mcu7t3v3__tap_2
XFILLER_44_177 VDD VDD VSS VSS gf180mcu_as_sc_mcu7t3v3__fillcap_16
XTAP_TAPCELL_ROW_116_1_1099 VDD VSS gf180mcu_as_sc_mcu7t3v3__tap_2
XFILLER_164_1061 VDD VDD VSS VSS gf180mcu_as_sc_mcu7t3v3__fillcap_4
XFILLER_92_1556 VDD VDD VSS VSS gf180mcu_as_sc_mcu7t3v3__fillcap_8
XTAP_TAPCELL_ROW_95_1_1017 VDD VSS gf180mcu_as_sc_mcu7t3v3__tap_2
XTAP_TAPCELL_ROW_46_1_821 VDD VSS gf180mcu_as_sc_mcu7t3v3__tap_2
XFILLER_138_271 VDD VDD VSS VSS gf180mcu_as_sc_mcu7t3v3__fillcap_8
XFILLER_139_772 VDD VDD VSS VSS gf180mcu_as_sc_mcu7t3v3__fillcap_16
XFILLER_142_1392 VDD VDD VSS VSS gf180mcu_as_sc_mcu7t3v3__fill_1
XFILLER_145_208 VDD VDD VSS VSS gf180mcu_as_sc_mcu7t3v3__fill_2
XFILLER_154_753 VDD VDD VSS VSS gf180mcu_as_sc_mcu7t3v3__fill_2
XFILLER_65_8 VDD VDD VSS VSS gf180mcu_as_sc_mcu7t3v3__fill_2
XFILLER_138_1428 VDD VDD VSS VSS gf180mcu_as_sc_mcu7t3v3__fillcap_4
XFILLER_153_252 VDD VDD VSS VSS gf180mcu_as_sc_mcu7t3v3__fillcap_4
XFILLER_4_240 VDD VDD VSS VSS gf180mcu_as_sc_mcu7t3v3__fillcap_4
XFILLER_4_251 VDD VDD VSS VSS gf180mcu_as_sc_mcu7t3v3__fill_1
XFILLER_113_138 VDD VDD VSS VSS gf180mcu_as_sc_mcu7t3v3__fill_2
XFILLER_136_1152 VDD VDD VSS VSS gf180mcu_as_sc_mcu7t3v3__fill_2
XFILLER_4_295 VDD VDD VSS VSS gf180mcu_as_sc_mcu7t3v3__fillcap_4
X_3120_ VDD VDD VSS VSS _3120_/A _3120_/B _3120_/C _3120_/D _3122_/C gf180mcu_as_sc_mcu7t3v3__ao211_2
XFILLER_67_247 VDD VDD VSS VSS gf180mcu_as_sc_mcu7t3v3__fillcap_4
XFILLER_114_1483 VDD VDD VSS VSS gf180mcu_as_sc_mcu7t3v3__fill_1
X_3051_ VDD VDD VSS VSS _3118_/S _4030_/A _4030_/D _3053_/B gf180mcu_as_sc_mcu7t3v3__mux2_2
XFILLER_82_228 VDD VDD VSS VSS gf180mcu_as_sc_mcu7t3v3__fill_1
XFILLER_149_1535 VDD VDD VSS VSS gf180mcu_as_sc_mcu7t3v3__fillcap_4
XFILLER_97_1467 VDD VDD VSS VSS gf180mcu_as_sc_mcu7t3v3__fillcap_16
XFILLER_50_103 VDD VDD VSS VSS gf180mcu_as_sc_mcu7t3v3__fill_2
XFILLER_182_1161 VDD VDD VSS VSS gf180mcu_as_sc_mcu7t3v3__fill_2
X_3953_ VDD VDD VSS VSS _3953_/A _4141_/B _3953_/C _3953_/D _3954_/B gf180mcu_as_sc_mcu7t3v3__ao22_2
XFILLER_176_311 VDD VDD VSS VSS gf180mcu_as_sc_mcu7t3v3__fillcap_4
XFILLER_50_169 VDD VDD VSS VSS gf180mcu_as_sc_mcu7t3v3__fillcap_4
X_3884_ VDD VDD VSS VSS _3897_/B _5174_/Q _4924_/D gf180mcu_as_sc_mcu7t3v3__and2_2
X_2904_ VDD VDD VSS VSS _3932_/A _3790_/A _3535_/A gf180mcu_as_sc_mcu7t3v3__nor2_2
XFILLER_176_333 VDD VDD VSS VSS gf180mcu_as_sc_mcu7t3v3__fillcap_16
XFILLER_34_1451 VDD VDD VSS VSS gf180mcu_as_sc_mcu7t3v3__fillcap_16
X_2835_ VDD VDD VSS VSS _4745_/B _2835_/A _4762_/D gf180mcu_as_sc_mcu7t3v3__and2_2
XTAP_TAPCELL_ROW_170_2003 VDD VSS gf180mcu_as_sc_mcu7t3v3__tap_2
XFILLER_129_282 VDD VDD VSS VSS gf180mcu_as_sc_mcu7t3v3__fill_2
X_2766_ VDD VDD VSS VSS _4691_/A _2766_/B _2766_/C _4754_/Q _2840_/C gf180mcu_as_sc_mcu7t3v3__ao211_2
X_5485_ VDD VDD VSS VSS _5485_/A _5485_/Y gf180mcu_as_sc_mcu7t3v3__buff_2
X_4505_ VDD VDD VSS VSS _5180_/Q _4566_/B _4505_/C _5114_/Q _4506_/B gf180mcu_as_sc_mcu7t3v3__ao22_2
X_2697_ VDD VDD VSS VSS _2717_/S _5175_/Q _5167_/Q _2699_/B gf180mcu_as_sc_mcu7t3v3__mux2_2
XFILLER_160_723 VDD VDD VSS VSS gf180mcu_as_sc_mcu7t3v3__fillcap_8
XFILLER_172_583 VDD VDD VSS VSS gf180mcu_as_sc_mcu7t3v3__fillcap_4
XFILLER_172_594 VDD VDD VSS VSS gf180mcu_as_sc_mcu7t3v3__fill_1
X_4436_ VDD VDD VSS VSS _4440_/B _5071_/Q _4518_/S gf180mcu_as_sc_mcu7t3v3__nand2_2
XFILLER_116_37 VDD VDD VSS VSS gf180mcu_as_sc_mcu7t3v3__fill_1
Xfanout503 VDD VDD VSS VSS fanout505/Y _3729_/B gf180mcu_as_sc_mcu7t3v3__buff_2
Xfanout514 VDD VDD VSS VSS _4338_/Y _4590_/C gf180mcu_as_sc_mcu7t3v3__buff_2
X_4367_ VDD VDD VSS VSS _4367_/B _4590_/B _4368_/C gf180mcu_as_sc_mcu7t3v3__and2_2
XFILLER_100_300 VDD VDD VSS VSS gf180mcu_as_sc_mcu7t3v3__fill_1
Xfanout525 VDD VDD VSS VSS fanout527/Y _4105_/B gf180mcu_as_sc_mcu7t3v3__buff_2
Xfanout536 VDD VDD VSS VSS _4252_/S _4250_/S gf180mcu_as_sc_mcu7t3v3__buff_2
Xfanout547 VDD VDD VSS VSS _3476_/B _3469_/B gf180mcu_as_sc_mcu7t3v3__buff_2
X_3318_ VDD VDD VSS VSS _3424_/B _3318_/B _3318_/C _3319_/C gf180mcu_as_sc_mcu7t3v3__nor3_2
XFILLER_112_193 VDD VDD VSS VSS gf180mcu_as_sc_mcu7t3v3__fillcap_16
XFILLER_58_247 VDD VDD VSS VSS gf180mcu_as_sc_mcu7t3v3__fillcap_4
Xfanout558 VDD VDD VSS VSS fanout560/Y _3124_/B gf180mcu_as_sc_mcu7t3v3__buff_2
Xfanout569 VDD VDD VSS VSS _3919_/Y fanout569/Y gf180mcu_as_sc_mcu7t3v3__buff_2
X_4298_ VDD VDD VSS VSS _4305_/S _5128_/Q _5127_/Q _5127_/D gf180mcu_as_sc_mcu7t3v3__mux2_2
Xmesh_tile_951 VDD VDD VSS VSS sw_out[24] gf180mcu_as_sc_mcu7t3v3__tiel_4
Xmesh_tile_940 VDD VDD VSS VSS sw_out[13] gf180mcu_as_sc_mcu7t3v3__tiel_4
X_3249_ VDD VDD VSS VSS _3510_/C _3249_/B _3914_/A gf180mcu_as_sc_mcu7t3v3__nand2_2
XFILLER_73_239 VDD VDD VSS VSS gf180mcu_as_sc_mcu7t3v3__fillcap_8
XFILLER_92_18 VDD VDD VSS VSS gf180mcu_as_sc_mcu7t3v3__fillcap_16
XFILLER_148_1012 VDD VDD VSS VSS gf180mcu_as_sc_mcu7t3v3__fill_2
XFILLER_26_155 VDD VDD VSS VSS gf180mcu_as_sc_mcu7t3v3__fillcap_16
XFILLER_41_1499 VDD VDD VSS VSS gf180mcu_as_sc_mcu7t3v3__fillcap_16
XFILLER_66_291 VDD VDD VSS VSS gf180mcu_as_sc_mcu7t3v3__fillcap_8
XFILLER_76_1518 VDD VDD VSS VSS gf180mcu_as_sc_mcu7t3v3__fillcap_16
XFILLER_148_1067 VDD VDD VSS VSS gf180mcu_as_sc_mcu7t3v3__fill_2
XFILLER_25_34 VDD VDD VSS VSS gf180mcu_as_sc_mcu7t3v3__fillcap_16
XFILLER_26_177 VDD VDD VSS VSS gf180mcu_as_sc_mcu7t3v3__fillcap_16
XFILLER_41_103 VDD VDD VSS VSS gf180mcu_as_sc_mcu7t3v3__fillcap_4
XTAP_TAPCELL_ROW_78_1_946 VDD VSS gf180mcu_as_sc_mcu7t3v3__tap_2
XFILLER_168_801 VDD VDD VSS VSS gf180mcu_as_sc_mcu7t3v3__fillcap_4
XFILLER_168_823 VDD VDD VSS VSS gf180mcu_as_sc_mcu7t3v3__fillcap_16
XFILLER_168_856 VDD VDD VSS VSS gf180mcu_as_sc_mcu7t3v3__fill_2
XTAP_TAPCELL_ROW_86_1_981 VDD VSS gf180mcu_as_sc_mcu7t3v3__tap_2
XFILLER_136_731 VDD VDD VSS VSS gf180mcu_as_sc_mcu7t3v3__fillcap_4
XFILLER_148_591 VDD VDD VSS VSS gf180mcu_as_sc_mcu7t3v3__fillcap_4
XFILLER_41_88 VDD VDD VSS VSS gf180mcu_as_sc_mcu7t3v3__fillcap_4
XTAP_TAPCELL_ROW_122_3_2532 VDD VSS gf180mcu_as_sc_mcu7t3v3__tap_2
XFILLER_157_88 VDD VDD VSS VSS gf180mcu_as_sc_mcu7t3v3__fillcap_4
XFILLER_159_1152 VDD VDD VSS VSS gf180mcu_as_sc_mcu7t3v3__fillcap_8
XFILLER_170_509 VDD VDD VSS VSS gf180mcu_as_sc_mcu7t3v3__fillcap_8
XFILLER_151_723 VDD VDD VSS VSS gf180mcu_as_sc_mcu7t3v3__fillcap_8
XFILLER_151_745 VDD VDD VSS VSS gf180mcu_as_sc_mcu7t3v3__fillcap_16
XFILLER_159_1196 VDD VDD VSS VSS gf180mcu_as_sc_mcu7t3v3__fill_2
XFILLER_9_2 VDD VDD VSS VSS gf180mcu_as_sc_mcu7t3v3__fillcap_16
XFILLER_155_1038 VDD VDD VSS VSS gf180mcu_as_sc_mcu7t3v3__fill_1
XFILLER_155_1049 VDD VDD VSS VSS gf180mcu_as_sc_mcu7t3v3__fill_1
XFILLER_173_32 VDD VDD VSS VSS gf180mcu_as_sc_mcu7t3v3__fillcap_16
XFILLER_103_160 VDD VDD VSS VSS gf180mcu_as_sc_mcu7t3v3__fill_1
XFILLER_137_1472 VDD VDD VSS VSS gf180mcu_as_sc_mcu7t3v3__fillcap_16
XFILLER_172_1363 VDD VDD VSS VSS gf180mcu_as_sc_mcu7t3v3__fill_2
XTAP_TAPCELL_ROW_166_1916 VDD VSS gf180mcu_as_sc_mcu7t3v3__tap_2
XTAP_TAPCELL_ROW_166_1905 VDD VSS gf180mcu_as_sc_mcu7t3v3__tap_2
XTAP_TAPCELL_ROW_88_3_2482 VDD VSS gf180mcu_as_sc_mcu7t3v3__tap_2
XFILLER_66_96 VDD VDD VSS VSS gf180mcu_as_sc_mcu7t3v3__fillcap_8
XFILLER_122_80 VDD VDD VSS VSS gf180mcu_as_sc_mcu7t3v3__fillcap_8
XFILLER_57_1451 VDD VDD VSS VSS gf180mcu_as_sc_mcu7t3v3__fillcap_16
XFILLER_144_1432 VDD VDD VSS VSS gf180mcu_as_sc_mcu7t3v3__fill_2
XFILLER_140_1329 VDD VDD VSS VSS gf180mcu_as_sc_mcu7t3v3__fillcap_16
XFILLER_173_314 VDD VDD VSS VSS gf180mcu_as_sc_mcu7t3v3__fillcap_16
X_2620_ VDD VDD VSS VSS _5245_/Q _2658_/S _2653_/S _2627_/B _2620_/D gf180mcu_as_sc_mcu7t3v3__oai211_2
XFILLER_179_1539 VDD VDD VSS VSS gf180mcu_as_sc_mcu7t3v3__fill_1
X_2551_ VDD VDD VSS VSS _2558_/D _2557_/A gf180mcu_as_sc_mcu7t3v3__inv_2
XFILLER_142_723 VDD VDD VSS VSS gf180mcu_as_sc_mcu7t3v3__fillcap_8
XFILLER_142_745 VDD VDD VSS VSS gf180mcu_as_sc_mcu7t3v3__fill_2
XFILLER_182_892 VDD VDD VSS VSS gf180mcu_as_sc_mcu7t3v3__fill_2
X_5270_ VDD VDD VSS VSS clkload5/A _5270_/D _5270_/Q gf180mcu_as_sc_mcu7t3v3__dfxtp_2
X_2482_ VDD VDD VSS VSS _2482_/B _4291_/A _4719_/A gf180mcu_as_sc_mcu7t3v3__or2_2
XFILLER_138_1269 VDD VDD VSS VSS gf180mcu_as_sc_mcu7t3v3__fillcap_4
XFILLER_29_1553 VDD VDD VSS VSS gf180mcu_as_sc_mcu7t3v3__fillcap_16
X_4221_ VDD VDD VSS VSS _4250_/B _4223_/B _4221_/C _5057_/Q _5057_/D gf180mcu_as_sc_mcu7t3v3__ao22_2
XFILLER_116_1534 VDD VDD VSS VSS gf180mcu_as_sc_mcu7t3v3__fillcap_16
XFILLER_151_1414 VDD VDD VSS VSS gf180mcu_as_sc_mcu7t3v3__fillcap_16
XFILLER_116_1556 VDD VDD VSS VSS gf180mcu_as_sc_mcu7t3v3__fill_1
X_4152_ VDD VDD VSS VSS _4152_/A _4160_/C _4152_/C _4942_/Q _4153_/D gf180mcu_as_sc_mcu7t3v3__ao22_2
XTAP_TAPCELL_ROW_118_1_1107 VDD VSS gf180mcu_as_sc_mcu7t3v3__tap_2
XFILLER_151_1469 VDD VDD VSS VSS gf180mcu_as_sc_mcu7t3v3__fill_1
X_4083_ VDD VDD VSS VSS _4083_/A _4110_/C _4083_/C _4247_/B _4091_/D gf180mcu_as_sc_mcu7t3v3__aoi211_2
X_3103_ VDD VDD VSS VSS _3153_/A _3103_/B _3103_/C _3153_/D _3104_/D gf180mcu_as_sc_mcu7t3v3__ao211_2
XFILLER_55_239 VDD VDD VSS VSS gf180mcu_as_sc_mcu7t3v3__fillcap_8
X_3034_ VDD VDD VSS VSS _3143_/S _4013_/A _4015_/A _3037_/B gf180mcu_as_sc_mcu7t3v3__mux2_2
XTAP_TAPCELL_ROW_52_3_2427 VDD VSS gf180mcu_as_sc_mcu7t3v3__tap_2
XFILLER_149_1332 VDD VDD VSS VSS gf180mcu_as_sc_mcu7t3v3__fillcap_16
XFILLER_184_1212 VDD VDD VSS VSS gf180mcu_as_sc_mcu7t3v3__fillcap_4
XFILLER_149_1354 VDD VDD VSS VSS gf180mcu_as_sc_mcu7t3v3__fill_1
XFILLER_184_1223 VDD VDD VSS VSS gf180mcu_as_sc_mcu7t3v3__fill_1
XFILLER_149_1398 VDD VDD VSS VSS gf180mcu_as_sc_mcu7t3v3__fill_2
XFILLER_184_1256 VDD VDD VSS VSS gf180mcu_as_sc_mcu7t3v3__fill_2
XFILLER_36_1502 VDD VDD VSS VSS gf180mcu_as_sc_mcu7t3v3__fillcap_16
X_4985_ VDD VDD VSS VSS _5172_/CLK _4985_/D _4985_/Q gf180mcu_as_sc_mcu7t3v3__dfxtp_2
XFILLER_23_158 VDD VDD VSS VSS gf180mcu_as_sc_mcu7t3v3__fillcap_16
X_3936_ VDD VDD VSS VSS _3936_/A _4141_/B _3936_/C _4229_/B _4141_/D gf180mcu_as_sc_mcu7t3v3__aoi211_2
XTAP_TAPCELL_ROW_74_1_930 VDD VSS gf180mcu_as_sc_mcu7t3v3__tap_2
XFILLER_149_333 VDD VDD VSS VSS gf180mcu_as_sc_mcu7t3v3__fill_2
XFILLER_36_1568 VDD VDD VSS VSS gf180mcu_as_sc_mcu7t3v3__fill_1
XFILLER_109_208 VDD VDD VSS VSS gf180mcu_as_sc_mcu7t3v3__fill_2
XFILLER_164_314 VDD VDD VSS VSS gf180mcu_as_sc_mcu7t3v3__fill_1
XFILLER_165_815 VDD VDD VSS VSS gf180mcu_as_sc_mcu7t3v3__fillcap_4
X_3867_ VDD VDD VSS VSS _3873_/B _3868_/B _3868_/A gf180mcu_as_sc_mcu7t3v3__nand2_2
X_3798_ VDD VDD VSS VSS _3799_/C _3798_/B _3798_/A gf180mcu_as_sc_mcu7t3v3__nand2_2
X_2818_ VDD VDD VSS VSS _4974_/D _2827_/B _4758_/Q _4757_/D gf180mcu_as_sc_mcu7t3v3__mux2_2
XFILLER_152_509 VDD VDD VSS VSS gf180mcu_as_sc_mcu7t3v3__fillcap_16
XFILLER_180_829 VDD VDD VSS VSS gf180mcu_as_sc_mcu7t3v3__fillcap_8
X_2749_ VDD VDD VSS VSS _4953_/Q _2765_/D _2810_/A gf180mcu_as_sc_mcu7t3v3__xnor2_2
XTAP_TAPCELL_ROW_135_1230 VDD VSS gf180mcu_as_sc_mcu7t3v3__tap_2
XFILLER_127_69 VDD VDD VSS VSS gf180mcu_as_sc_mcu7t3v3__fill_1
XFILLER_132_233 VDD VDD VSS VSS gf180mcu_as_sc_mcu7t3v3__fillcap_8
XFILLER_87_18 VDD VDD VSS VSS gf180mcu_as_sc_mcu7t3v3__fillcap_4
XFILLER_132_288 VDD VDD VSS VSS gf180mcu_as_sc_mcu7t3v3__fill_1
X_4419_ VDD VDD VSS VSS _4579_/S _5069_/Q _4982_/Q _4420_/A gf180mcu_as_sc_mcu7t3v3__mux2_2
XPHY_EDGE_ROW_75_1_Left_527 VDD VSS gf180mcu_as_sc_mcu7t3v3__tap_2
XFILLER_132_299 VDD VDD VSS VSS gf180mcu_as_sc_mcu7t3v3__fill_2
XFILLER_143_24 VDD VDD VSS VSS gf180mcu_as_sc_mcu7t3v3__fillcap_16
XFILLER_100_152 VDD VDD VSS VSS gf180mcu_as_sc_mcu7t3v3__fill_2
XFILLER_143_68 VDD VDD VSS VSS gf180mcu_as_sc_mcu7t3v3__fill_2
XFILLER_100_174 VDD VDD VSS VSS gf180mcu_as_sc_mcu7t3v3__fill_1
XTAP_TAPCELL_ROW_161_1802 VDD VSS gf180mcu_as_sc_mcu7t3v3__tap_2
XFILLER_146_2 VDD VDD VSS VSS gf180mcu_as_sc_mcu7t3v3__fillcap_8
XFILLER_156_804 VDD VDD VSS VSS gf180mcu_as_sc_mcu7t3v3__fill_1
XFILLER_161_1020 VDD VDD VSS VSS gf180mcu_as_sc_mcu7t3v3__fill_1
XFILLER_161_1031 VDD VDD VSS VSS gf180mcu_as_sc_mcu7t3v3__fillcap_16
XTAP_TAPCELL_ROW_159_1764 VDD VSS gf180mcu_as_sc_mcu7t3v3__tap_2
XTAP_TAPCELL_ROW_159_1753 VDD VSS gf180mcu_as_sc_mcu7t3v3__tap_2
XPHY_EDGE_ROW_99_1_Right_98 VDD VSS gf180mcu_as_sc_mcu7t3v3__tap_2
XFILLER_155_303 VDD VDD VSS VSS gf180mcu_as_sc_mcu7t3v3__fill_2
XFILLER_161_1064 VDD VDD VSS VSS gf180mcu_as_sc_mcu7t3v3__fill_1
XFILLER_167_174 VDD VDD VSS VSS gf180mcu_as_sc_mcu7t3v3__fillcap_16
XFILLER_168_675 VDD VDD VSS VSS gf180mcu_as_sc_mcu7t3v3__fillcap_4
Xinput19 VDD VDD VSS VSS boot_data[7] _2736_/A gf180mcu_as_sc_mcu7t3v3__buff_2
XFILLER_155_358 VDD VDD VSS VSS gf180mcu_as_sc_mcu7t3v3__fill_1
XFILLER_155_369 VDD VDD VSS VSS gf180mcu_as_sc_mcu7t3v3__fill_1
XFILLER_183_678 VDD VDD VSS VSS gf180mcu_as_sc_mcu7t3v3__fill_2
XFILLER_108_263 VDD VDD VSS VSS gf180mcu_as_sc_mcu7t3v3__fill_2
XFILLER_136_572 VDD VDD VSS VSS gf180mcu_as_sc_mcu7t3v3__fill_2
XFILLER_164_892 VDD VDD VSS VSS gf180mcu_as_sc_mcu7t3v3__fill_2
XFILLER_170_317 VDD VDD VSS VSS gf180mcu_as_sc_mcu7t3v3__fillcap_16
XFILLER_182_177 VDD VDD VSS VSS gf180mcu_as_sc_mcu7t3v3__fillcap_16
XFILLER_184_86 VDD VDD VSS VSS gf180mcu_as_sc_mcu7t3v3__fillcap_8
XFILLER_87_1499 VDD VDD VSS VSS gf180mcu_as_sc_mcu7t3v3__fillcap_16
XFILLER_77_40 VDD VDD VSS VSS gf180mcu_as_sc_mcu7t3v3__fill_1
XFILLER_77_62 VDD VDD VSS VSS gf180mcu_as_sc_mcu7t3v3__fill_1
XFILLER_37_206 VDD VDD VSS VSS gf180mcu_as_sc_mcu7t3v3__fillcap_4
XFILLER_24_1483 VDD VDD VSS VSS gf180mcu_as_sc_mcu7t3v3__fill_1
XFILLER_37_228 VDD VDD VSS VSS gf180mcu_as_sc_mcu7t3v3__fillcap_16
XFILLER_146_1527 VDD VDD VSS VSS gf180mcu_as_sc_mcu7t3v3__fillcap_8
XFILLER_179_907 VDD VDD VSS VSS gf180mcu_as_sc_mcu7t3v3__fill_2
XFILLER_179_918 VDD VDD VSS VSS gf180mcu_as_sc_mcu7t3v3__fill_2
XFILLER_20_139 VDD VDD VSS VSS gf180mcu_as_sc_mcu7t3v3__fillcap_16
X_4770_ VDD VDD VSS VSS _5266_/CLK _4770_/D _4770_/Q gf180mcu_as_sc_mcu7t3v3__dfxtp_2
XFILLER_144_1273 VDD VDD VSS VSS gf180mcu_as_sc_mcu7t3v3__fill_2
X_3721_ VDD VDD VSS VSS _3722_/C _3721_/C _3745_/B _4097_/A gf180mcu_as_sc_mcu7t3v3__aoi21_2
XFILLER_174_645 VDD VDD VSS VSS gf180mcu_as_sc_mcu7t3v3__fillcap_4
X_3652_ VDD VDD VSS VSS _4022_/A _3744_/B _3652_/C _3746_/B _3653_/C gf180mcu_as_sc_mcu7t3v3__ao211_2
XFILLER_134_509 VDD VDD VSS VSS gf180mcu_as_sc_mcu7t3v3__fill_1
XFILLER_162_807 VDD VDD VSS VSS gf180mcu_as_sc_mcu7t3v3__fill_1
XFILLER_174_667 VDD VDD VSS VSS gf180mcu_as_sc_mcu7t3v3__fillcap_16
X_3583_ VDD VDD VSS VSS _3947_/D _3781_/S _3583_/C _3583_/D _3584_/C gf180mcu_as_sc_mcu7t3v3__ao211_2
X_2603_ VDD VDD VSS VSS _2692_/S _2603_/B input1/Y _2604_/A gf180mcu_as_sc_mcu7t3v3__mux2_2
XPHY_EDGE_ROW_117_3_Left_251 VDD VSS gf180mcu_as_sc_mcu7t3v3__tap_2
X_2534_ VDD VDD VSS VSS _4371_/B _2534_/A _2534_/B _2534_/C _4366_/S gf180mcu_as_sc_mcu7t3v3__ao31_2
XFILLER_142_553 VDD VDD VSS VSS gf180mcu_as_sc_mcu7t3v3__fill_2
XFILLER_170_840 VDD VDD VSS VSS gf180mcu_as_sc_mcu7t3v3__fill_2
XFILLER_138_1066 VDD VDD VSS VSS gf180mcu_as_sc_mcu7t3v3__fillcap_16
X_5253_ VDD VDD VSS VSS clkload1/A _5253_/D _5253_/Q gf180mcu_as_sc_mcu7t3v3__dfxtp_2
X_2465_ VDD VDD VSS VSS _4447_/S _5093_/Q _5006_/Q _2466_/A gf180mcu_as_sc_mcu7t3v3__mux2_2
XTAP_TAPCELL_ROW_77_1_945 VDD VSS gf180mcu_as_sc_mcu7t3v3__tap_2
XFILLER_114_299 VDD VDD VSS VSS gf180mcu_as_sc_mcu7t3v3__fill_2
XFILLER_142_597 VDD VDD VSS VSS gf180mcu_as_sc_mcu7t3v3__fillcap_16
XFILLER_155_1380 VDD VDD VSS VSS gf180mcu_as_sc_mcu7t3v3__fillcap_16
X_5184_ VDD VDD VSS VSS _5185_/CLK _5184_/D _5184_/Q gf180mcu_as_sc_mcu7t3v3__dfxtp_2
X_4204_ VDD VDD VSS VSS _4233_/B _4218_/B _4221_/C _5040_/Q _5040_/D gf180mcu_as_sc_mcu7t3v3__ao22_2
X_2396_ VDD VDD VSS VSS _4746_/D _2845_/D gf180mcu_as_sc_mcu7t3v3__inv_2
XFILLER_9_1499 VDD VDD VSS VSS gf180mcu_as_sc_mcu7t3v3__fillcap_16
X_4135_ VDD VDD VSS VSS _4135_/A _4160_/B _4161_/B _4135_/D _4136_/D gf180mcu_as_sc_mcu7t3v3__ao22_2
XFILLER_113_27 VDD VDD VSS VSS gf180mcu_as_sc_mcu7t3v3__fillcap_8
XFILLER_42_1550 VDD VDD VSS VSS gf180mcu_as_sc_mcu7t3v3__fillcap_4
XTAP_TAPCELL_ROW_182_2271 VDD VSS gf180mcu_as_sc_mcu7t3v3__tap_2
XTAP_TAPCELL_ROW_182_2260 VDD VSS gf180mcu_as_sc_mcu7t3v3__tap_2
X_4066_ VDD VDD VSS VSS _4066_/A _4105_/B _4066_/C _4067_/C _4099_/B gf180mcu_as_sc_mcu7t3v3__aoi211_2
XPHY_EDGE_ROW_166_Right_300 VDD VSS gf180mcu_as_sc_mcu7t3v3__tap_2
X_3017_ VDD VDD VSS VSS _3118_/S _3997_/D _4000_/A _3019_/B gf180mcu_as_sc_mcu7t3v3__mux2_2
XFILLER_184_1053 VDD VDD VSS VSS gf180mcu_as_sc_mcu7t3v3__fill_1
XFILLER_149_1184 VDD VDD VSS VSS gf180mcu_as_sc_mcu7t3v3__fillcap_4
XFILLER_184_1086 VDD VDD VSS VSS gf180mcu_as_sc_mcu7t3v3__fill_2
X_4968_ VDD VDD VSS VSS _5146_/CLK _4968_/D _4968_/Q gf180mcu_as_sc_mcu7t3v3__dfxtp_2
Xsram2048.u_bank0_816 VDD VDD VSS VSS sram2048.u_bank0/WEN[6] gf180mcu_as_sc_mcu7t3v3__tiel_4
XFILLER_138_804 VDD VDD VSS VSS gf180mcu_as_sc_mcu7t3v3__fill_1
XFILLER_138_826 VDD VDD VSS VSS gf180mcu_as_sc_mcu7t3v3__fillcap_16
X_4899_ VDD VDD VSS VSS _4928_/CLK _4899_/D _4899_/Q gf180mcu_as_sc_mcu7t3v3__dfxtp_2
X_3919_ VDD VDD VSS VSS _3919_/Y _3920_/A _3920_/B gf180mcu_as_sc_mcu7t3v3__nor2_2
XFILLER_137_314 VDD VDD VSS VSS gf180mcu_as_sc_mcu7t3v3__fillcap_4
XFILLER_164_155 VDD VDD VSS VSS gf180mcu_as_sc_mcu7t3v3__fillcap_16
XFILLER_165_678 VDD VDD VSS VSS gf180mcu_as_sc_mcu7t3v3__fillcap_4
XPHY_EDGE_ROW_49_3_Left_183 VDD VSS gf180mcu_as_sc_mcu7t3v3__tap_2
XTAP_TAPCELL_ROW_154_1650 VDD VSS gf180mcu_as_sc_mcu7t3v3__tap_2
XFILLER_152_317 VDD VDD VSS VSS gf180mcu_as_sc_mcu7t3v3__fillcap_16
XFILLER_164_177 VDD VDD VSS VSS gf180mcu_as_sc_mcu7t3v3__fillcap_16
XTAP_TAPCELL_ROW_150_1558 VDD VSS gf180mcu_as_sc_mcu7t3v3__tap_2
XTAP_TAPCELL_ROW_150_1547 VDD VSS gf180mcu_as_sc_mcu7t3v3__tap_2
XFILLER_154_34 VDD VDD VSS VSS gf180mcu_as_sc_mcu7t3v3__fill_1
XFILLER_161_884 VDD VDD VSS VSS gf180mcu_as_sc_mcu7t3v3__fillcap_16
XFILLER_47_1483 VDD VDD VSS VSS gf180mcu_as_sc_mcu7t3v3__fillcap_16
XFILLER_120_247 VDD VDD VSS VSS gf180mcu_as_sc_mcu7t3v3__fillcap_16
XFILLER_134_1464 VDD VDD VSS VSS gf180mcu_as_sc_mcu7t3v3__fillcap_16
XFILLER_86_150 VDD VDD VSS VSS gf180mcu_as_sc_mcu7t3v3__fillcap_4
XFILLER_19_206 VDD VDD VSS VSS gf180mcu_as_sc_mcu7t3v3__fillcap_4
XFILLER_19_228 VDD VDD VSS VSS gf180mcu_as_sc_mcu7t3v3__fillcap_16
XTAP_TAPCELL_ROW_22_3_2382 VDD VSS gf180mcu_as_sc_mcu7t3v3__tap_2
XFILLER_34_209 VDD VDD VSS VSS gf180mcu_as_sc_mcu7t3v3__fillcap_16
XFILLER_167_1262 VDD VDD VSS VSS gf180mcu_as_sc_mcu7t3v3__fillcap_16
XFILLER_42_242 VDD VDD VSS VSS gf180mcu_as_sc_mcu7t3v3__fill_2
Xclkbuf_leaf_18_clk_regs VDD VDD VSS VSS clkbuf_3_3_0_clk_regs/Y _5094_/CLK gf180mcu_as_sc_mcu7t3v3__clkbuff_12
XTAP_TAPCELL_ROW_110_3_2514 VDD VSS gf180mcu_as_sc_mcu7t3v3__tap_2
XFILLER_141_1402 VDD VDD VSS VSS gf180mcu_as_sc_mcu7t3v3__fillcap_16
XFILLER_180_1473 VDD VDD VSS VSS gf180mcu_as_sc_mcu7t3v3__fillcap_8
XFILLER_8_37 VDD VDD VSS VSS gf180mcu_as_sc_mcu7t3v3__fillcap_16
XFILLER_141_1457 VDD VDD VSS VSS gf180mcu_as_sc_mcu7t3v3__fill_2
XFILLER_168_494 VDD VDD VSS VSS gf180mcu_as_sc_mcu7t3v3__fill_1
XFILLER_144_807 VDD VDD VSS VSS gf180mcu_as_sc_mcu7t3v3__fillcap_8
XFILLER_144_829 VDD VDD VSS VSS gf180mcu_as_sc_mcu7t3v3__fillcap_8
XFILLER_156_667 VDD VDD VSS VSS gf180mcu_as_sc_mcu7t3v3__fillcap_16
XFILLER_137_892 VDD VDD VSS VSS gf180mcu_as_sc_mcu7t3v3__fill_2
XFILLER_155_188 VDD VDD VSS VSS gf180mcu_as_sc_mcu7t3v3__fillcap_16
XFILLER_183_486 VDD VDD VSS VSS gf180mcu_as_sc_mcu7t3v3__fillcap_4
XTAP_TAPCELL_ROW_76_3_2464 VDD VSS gf180mcu_as_sc_mcu7t3v3__tap_2
XFILLER_139_1364 VDD VDD VSS VSS gf180mcu_as_sc_mcu7t3v3__fillcap_16
XFILLER_151_372 VDD VDD VSS VSS gf180mcu_as_sc_mcu7t3v3__fill_2
XFILLER_152_873 VDD VDD VSS VSS gf180mcu_as_sc_mcu7t3v3__fill_2
XPHY_EDGE_ROW_164_Right_298 VDD VSS gf180mcu_as_sc_mcu7t3v3__tap_2
XFILLER_26_1534 VDD VDD VSS VSS gf180mcu_as_sc_mcu7t3v3__fillcap_16
XFILLER_113_1515 VDD VDD VSS VSS gf180mcu_as_sc_mcu7t3v3__fillcap_4
XFILLER_26_1556 VDD VDD VSS VSS gf180mcu_as_sc_mcu7t3v3__fillcap_8
XFILLER_113_1537 VDD VDD VSS VSS gf180mcu_as_sc_mcu7t3v3__fillcap_16
XFILLER_146_1313 VDD VDD VSS VSS gf180mcu_as_sc_mcu7t3v3__fillcap_8
XFILLER_92_197 VDD VDD VSS VSS gf180mcu_as_sc_mcu7t3v3__fill_2
XFILLER_178_225 VDD VDD VSS VSS gf180mcu_as_sc_mcu7t3v3__fillcap_16
XFILLER_181_1204 VDD VDD VSS VSS gf180mcu_as_sc_mcu7t3v3__fillcap_8
XFILLER_178_247 VDD VDD VSS VSS gf180mcu_as_sc_mcu7t3v3__fillcap_16
XFILLER_181_1248 VDD VDD VSS VSS gf180mcu_as_sc_mcu7t3v3__fill_1
XFILLER_181_1259 VDD VDD VSS VSS gf180mcu_as_sc_mcu7t3v3__fill_1
X_4822_ VDD VDD VSS VSS _4928_/CLK _4822_/D _4822_/Q gf180mcu_as_sc_mcu7t3v3__dfxtp_2
X_4753_ VDD VDD VSS VSS _5095_/D _4753_/B _4753_/A gf180mcu_as_sc_mcu7t3v3__nor2_2
XFILLER_175_943 VDD VDD VSS VSS gf180mcu_as_sc_mcu7t3v3__fillcap_4
X_3704_ VDD VDD VSS VSS _3704_/D _4077_/A _3736_/B _3800_/C _3705_/C gf180mcu_as_sc_mcu7t3v3__ao31_2
XFILLER_162_604 VDD VDD VSS VSS gf180mcu_as_sc_mcu7t3v3__fillcap_16
XFILLER_179_1122 VDD VDD VSS VSS gf180mcu_as_sc_mcu7t3v3__fill_1
X_4684_ VDD VDD VSS VSS _5257_/Q _4684_/A _4686_/C gf180mcu_as_sc_mcu7t3v3__or2_2
XFILLER_146_177 VDD VDD VSS VSS gf180mcu_as_sc_mcu7t3v3__fillcap_16
X_3635_ VDD VDD VSS VSS _4924_/Q _3740_/B _3741_/C _4007_/A _3636_/D gf180mcu_as_sc_mcu7t3v3__ao22_2
XFILLER_161_136 VDD VDD VSS VSS gf180mcu_as_sc_mcu7t3v3__fillcap_4
XFILLER_161_158 VDD VDD VSS VSS gf180mcu_as_sc_mcu7t3v3__fillcap_16
X_3566_ VDD VDD VSS VSS _3566_/Y _3799_/B _3790_/C gf180mcu_as_sc_mcu7t3v3__nor2_2
XFILLER_157_1464 VDD VDD VSS VSS gf180mcu_as_sc_mcu7t3v3__fillcap_4
X_3497_ VDD VDD VSS VSS _4155_/A _3514_/B _3497_/C _3497_/D _3498_/B gf180mcu_as_sc_mcu7t3v3__ao211_2
X_2517_ VDD VDD VSS VSS _2517_/D _4749_/A _2517_/B _2517_/C _2765_/B gf180mcu_as_sc_mcu7t3v3__ao31_2
XTAP_TAPCELL_ROW_40_3_2409 VDD VSS gf180mcu_as_sc_mcu7t3v3__tap_2
XTAP_TAPCELL_ROW_184_2300 VDD VSS gf180mcu_as_sc_mcu7t3v3__tap_2
XFILLER_142_372 VDD VDD VSS VSS gf180mcu_as_sc_mcu7t3v3__fill_1
X_5236_ VDD VDD VSS VSS clkload4/A _5236_/D _5236_/Q gf180mcu_as_sc_mcu7t3v3__dfxtp_2
Xinput209 VDD VDD VSS VSS se_in[4] _3969_/A gf180mcu_as_sc_mcu7t3v3__buff_2
X_2448_ VDD VDD VSS VSS _3775_/A _4156_/A gf180mcu_as_sc_mcu7t3v3__inv_2
XTAP_TAPCELL_ROW_184_2333 VDD VSS gf180mcu_as_sc_mcu7t3v3__tap_2
XTAP_TAPCELL_ROW_184_2322 VDD VSS gf180mcu_as_sc_mcu7t3v3__tap_2
XTAP_TAPCELL_ROW_184_2311 VDD VSS gf180mcu_as_sc_mcu7t3v3__tap_2
XFILLER_102_247 VDD VDD VSS VSS gf180mcu_as_sc_mcu7t3v3__fillcap_4
XFILLER_102_258 VDD VDD VSS VSS gf180mcu_as_sc_mcu7t3v3__fill_2
XFILLER_124_37 VDD VDD VSS VSS gf180mcu_as_sc_mcu7t3v3__fillcap_4
XFILLER_151_1030 VDD VDD VSS VSS gf180mcu_as_sc_mcu7t3v3__fillcap_16
XFILLER_151_1052 VDD VDD VSS VSS gf180mcu_as_sc_mcu7t3v3__fillcap_4
X_5167_ VDD VDD VSS VSS _5172_/CLK _5167_/D _5167_/Q gf180mcu_as_sc_mcu7t3v3__dfxtp_2
XTAP_TAPCELL_ROW_180_2219 VDD VSS gf180mcu_as_sc_mcu7t3v3__tap_2
XTAP_TAPCELL_ROW_180_2208 VDD VSS gf180mcu_as_sc_mcu7t3v3__tap_2
XFILLER_83_142 VDD VDD VSS VSS gf180mcu_as_sc_mcu7t3v3__fillcap_16
X_5098_ VDD VDD VSS VSS clkload4/A _5098_/D _5098_/Q gf180mcu_as_sc_mcu7t3v3__dfxtp_2
X_4118_ VDD VDD VSS VSS _4118_/A _4118_/B _4118_/C _4118_/D _4119_/D gf180mcu_as_sc_mcu7t3v3__ao22_2
XFILLER_16_209 VDD VDD VSS VSS gf180mcu_as_sc_mcu7t3v3__fillcap_16
X_4049_ VDD VDD VSS VSS _4049_/A _4131_/B _4049_/C _4049_/D _4050_/B gf180mcu_as_sc_mcu7t3v3__ao211_2
XFILLER_168_1560 VDD VDD VSS VSS gf180mcu_as_sc_mcu7t3v3__fill_2
XTAP_TAPCELL_ROW_143_1395 VDD VSS gf180mcu_as_sc_mcu7t3v3__tap_2
XFILLER_24_275 VDD VDD VSS VSS gf180mcu_as_sc_mcu7t3v3__fill_2
XFILLER_33_34 VDD VDD VSS VSS gf180mcu_as_sc_mcu7t3v3__fillcap_16
XFILLER_149_34 VDD VDD VSS VSS gf180mcu_as_sc_mcu7t3v3__fillcap_16
XFILLER_184_206 VDD VDD VSS VSS gf180mcu_as_sc_mcu7t3v3__fillcap_16
XFILLER_162_1192 VDD VDD VSS VSS gf180mcu_as_sc_mcu7t3v3__fillcap_16
XFILLER_137_144 VDD VDD VSS VSS gf180mcu_as_sc_mcu7t3v3__fill_1
XFILLER_138_667 VDD VDD VSS VSS gf180mcu_as_sc_mcu7t3v3__fillcap_16
XTAP_TAPCELL_ROW_152_1609 VDD VSS gf180mcu_as_sc_mcu7t3v3__tap_2
XFILLER_88_1550 VDD VDD VSS VSS gf180mcu_as_sc_mcu7t3v3__fillcap_4
XFILLER_109_2 VDD VDD VSS VSS gf180mcu_as_sc_mcu7t3v3__fillcap_8
XFILLER_134_840 VDD VDD VSS VSS gf180mcu_as_sc_mcu7t3v3__fill_2
XPHY_EDGE_ROW_19_1_Left_471 VDD VSS gf180mcu_as_sc_mcu7t3v3__tap_2
XFILLER_161_670 VDD VDD VSS VSS gf180mcu_as_sc_mcu7t3v3__fillcap_16
XFILLER_165_66 VDD VDD VSS VSS gf180mcu_as_sc_mcu7t3v3__fillcap_4
XFILLER_165_88 VDD VDD VSS VSS gf180mcu_as_sc_mcu7t3v3__fillcap_16
XFILLER_171_1406 VDD VDD VSS VSS gf180mcu_as_sc_mcu7t3v3__fill_1
XFILLER_175_1542 VDD VDD VSS VSS gf180mcu_as_sc_mcu7t3v3__fillcap_16
XFILLER_136_1537 VDD VDD VSS VSS gf180mcu_as_sc_mcu7t3v3__fill_1
XFILLER_58_31 VDD VDD VSS VSS gf180mcu_as_sc_mcu7t3v3__fillcap_4
XTAP_TAPCELL_ROW_119_1_1112 VDD VSS gf180mcu_as_sc_mcu7t3v3__tap_2
XFILLER_181_65 VDD VDD VSS VSS gf180mcu_as_sc_mcu7t3v3__fillcap_4
XFILLER_134_1294 VDD VDD VSS VSS gf180mcu_as_sc_mcu7t3v3__fillcap_16
XFILLER_169_1313 VDD VDD VSS VSS gf180mcu_as_sc_mcu7t3v3__fillcap_16
XFILLER_182_1502 VDD VDD VSS VSS gf180mcu_as_sc_mcu7t3v3__fill_2
XFILLER_95_1521 VDD VDD VSS VSS gf180mcu_as_sc_mcu7t3v3__fillcap_16
XTAP_TAPCELL_ROW_128_3_2541 VDD VSS gf180mcu_as_sc_mcu7t3v3__tap_2
XTAP_TAPCELL_ROW_68_1_909 VDD VSS gf180mcu_as_sc_mcu7t3v3__tap_2
XFILLER_130_80 VDD VDD VSS VSS gf180mcu_as_sc_mcu7t3v3__fillcap_8
XFILLER_176_707 VDD VDD VSS VSS gf180mcu_as_sc_mcu7t3v3__fillcap_4
XFILLER_175_206 VDD VDD VSS VSS gf180mcu_as_sc_mcu7t3v3__fillcap_4
XFILLER_90_62 VDD VDD VSS VSS gf180mcu_as_sc_mcu7t3v3__fill_1
XFILLER_141_1221 VDD VDD VSS VSS gf180mcu_as_sc_mcu7t3v3__fillcap_8
XFILLER_157_954 VDD VDD VSS VSS gf180mcu_as_sc_mcu7t3v3__fillcap_8
XFILLER_175_228 VDD VDD VSS VSS gf180mcu_as_sc_mcu7t3v3__fillcap_16
XFILLER_144_604 VDD VDD VSS VSS gf180mcu_as_sc_mcu7t3v3__fillcap_16
XFILLER_128_188 VDD VDD VSS VSS gf180mcu_as_sc_mcu7t3v3__fillcap_16
XFILLER_157_998 VDD VDD VSS VSS gf180mcu_as_sc_mcu7t3v3__fillcap_4
XFILLER_176_1317 VDD VDD VSS VSS gf180mcu_as_sc_mcu7t3v3__fillcap_4
XFILLER_183_272 VDD VDD VSS VSS gf180mcu_as_sc_mcu7t3v3__fillcap_8
XFILLER_184_784 VDD VDD VSS VSS gf180mcu_as_sc_mcu7t3v3__fillcap_4
X_3420_ VDD VDD VSS VSS _4069_/D _3451_/B _3420_/C _3420_/D _3421_/A gf180mcu_as_sc_mcu7t3v3__ao22_2
XFILLER_143_158 VDD VDD VSS VSS gf180mcu_as_sc_mcu7t3v3__fill_2
XFILLER_171_478 VDD VDD VSS VSS gf180mcu_as_sc_mcu7t3v3__fillcap_4
X_3351_ VDD VDD VSS VSS _3470_/B _3351_/B _3351_/C _3352_/C gf180mcu_as_sc_mcu7t3v3__nor3_2
XFILLER_152_681 VDD VDD VSS VSS gf180mcu_as_sc_mcu7t3v3__fill_1
XFILLER_97_212 VDD VDD VSS VSS gf180mcu_as_sc_mcu7t3v3__fillcap_4
X_3282_ VDD VDD VSS VSS _3526_/D _3286_/B gf180mcu_as_sc_mcu7t3v3__inv_2
XFILLER_24_2 VDD VDD VSS VSS gf180mcu_as_sc_mcu7t3v3__fillcap_16
X_5021_ VDD VDD VSS VSS _5074_/CLK _5021_/D _5021_/Q gf180mcu_as_sc_mcu7t3v3__dfxtp_2
XTAP_TAPCELL_ROW_47_1_823 VDD VSS gf180mcu_as_sc_mcu7t3v3__tap_2
XFILLER_65_142 VDD VDD VSS VSS gf180mcu_as_sc_mcu7t3v3__fillcap_16
XFILLER_80_134 VDD VDD VSS VSS gf180mcu_as_sc_mcu7t3v3__fillcap_8
XFILLER_179_556 VDD VDD VSS VSS gf180mcu_as_sc_mcu7t3v3__fillcap_4
XFILLER_181_1045 VDD VDD VSS VSS gf180mcu_as_sc_mcu7t3v3__fillcap_4
XFILLER_21_212 VDD VDD VSS VSS gf180mcu_as_sc_mcu7t3v3__fillcap_16
X_4899__968 VDD VDD VSS VSS _4899_/D gf180mcu_as_sc_mcu7t3v3__tiel_4
X_4805_ VDD VDD VSS VSS _5053_/CLK _4805_/D _4805_/Q gf180mcu_as_sc_mcu7t3v3__dfxtp_2
X_2997_ VDD VDD VSS VSS _3149_/B _2997_/B _2997_/C _2998_/C gf180mcu_as_sc_mcu7t3v3__nor3_2
XPHY_EDGE_ROW_84_1_Left_536 VDD VSS gf180mcu_as_sc_mcu7t3v3__tap_2
XFILLER_175_751 VDD VDD VSS VSS gf180mcu_as_sc_mcu7t3v3__fill_2
X_4736_ VDD VDD VSS VSS _4737_/C _4736_/B _5270_/Q gf180mcu_as_sc_mcu7t3v3__nor2_2
XTAP_TAPCELL_ROW_173_2067 VDD VSS gf180mcu_as_sc_mcu7t3v3__tap_2
XTAP_TAPCELL_ROW_173_2056 VDD VSS gf180mcu_as_sc_mcu7t3v3__tap_2
XFILLER_119_188 VDD VDD VSS VSS gf180mcu_as_sc_mcu7t3v3__fillcap_16
XPHY_EDGE_ROW_40_3_Right_359 VDD VSS gf180mcu_as_sc_mcu7t3v3__tap_2
X_4667_ VDD VDD VSS VSS _5104_/Q _4680_/B _4681_/C _5242_/Q _4668_/C gf180mcu_as_sc_mcu7t3v3__ao22_2
X_3618_ VDD VDD VSS VSS _4922_/Q _3799_/B _3770_/C _3990_/A _3620_/C gf180mcu_as_sc_mcu7t3v3__ao22_2
XTAP_TAPCELL_ROW_58_3_2436 VDD VSS gf180mcu_as_sc_mcu7t3v3__tap_2
XFILLER_157_1250 VDD VDD VSS VSS gf180mcu_as_sc_mcu7t3v3__fill_2
X_4598_ VDD VDD VSS VSS _5192_/Q _4750_/D _4600_/C _5193_/Q _5192_/D gf180mcu_as_sc_mcu7t3v3__ao22_2
XFILLER_135_36 VDD VDD VSS VSS gf180mcu_as_sc_mcu7t3v3__fill_2
XFILLER_143_692 VDD VDD VSS VSS gf180mcu_as_sc_mcu7t3v3__fillcap_8
XFILLER_153_1114 VDD VDD VSS VSS gf180mcu_as_sc_mcu7t3v3__fillcap_4
X_3549_ VDD VDD VSS VSS _3562_/B _3811_/B _3776_/B gf180mcu_as_sc_mcu7t3v3__nand2_2
XFILLER_0_138 VDD VDD VSS VSS gf180mcu_as_sc_mcu7t3v3__fillcap_16
XFILLER_135_69 VDD VDD VSS VSS gf180mcu_as_sc_mcu7t3v3__fill_1
XFILLER_153_1158 VDD VDD VSS VSS gf180mcu_as_sc_mcu7t3v3__fillcap_4
XFILLER_95_18 VDD VDD VSS VSS gf180mcu_as_sc_mcu7t3v3__fill_2
X_5219_ VDD VDD VSS VSS clkload2/A _5219_/D _5219_/Q gf180mcu_as_sc_mcu7t3v3__dfxtp_2
XFILLER_28_34 VDD VDD VSS VSS gf180mcu_as_sc_mcu7t3v3__fill_1
XFILLER_44_1486 VDD VDD VSS VSS gf180mcu_as_sc_mcu7t3v3__fillcap_16
XFILLER_131_1467 VDD VDD VSS VSS gf180mcu_as_sc_mcu7t3v3__fillcap_16
XFILLER_151_68 VDD VDD VSS VSS gf180mcu_as_sc_mcu7t3v3__fill_2
XTAP_TAPCELL_ROW_145_1457 VDD VSS gf180mcu_as_sc_mcu7t3v3__tap_2
XTAP_TAPCELL_ROW_145_1446 VDD VSS gf180mcu_as_sc_mcu7t3v3__tap_2
XFILLER_164_1221 VDD VDD VSS VSS gf180mcu_as_sc_mcu7t3v3__fillcap_4
XFILLER_71_134 VDD VDD VSS VSS gf180mcu_as_sc_mcu7t3v3__fillcap_4
XFILLER_160_1107 VDD VDD VSS VSS gf180mcu_as_sc_mcu7t3v3__fill_2
XFILLER_60_10 VDD VDD VSS VSS gf180mcu_as_sc_mcu7t3v3__fill_1
XFILLER_90_1451 VDD VDD VSS VSS gf180mcu_as_sc_mcu7t3v3__fillcap_16
XFILLER_138_431 VDD VDD VSS VSS gf180mcu_as_sc_mcu7t3v3__fillcap_8
XFILLER_138_453 VDD VDD VSS VSS gf180mcu_as_sc_mcu7t3v3__fill_2
XFILLER_125_103 VDD VDD VSS VSS gf180mcu_as_sc_mcu7t3v3__fillcap_4
XFILLER_139_998 VDD VDD VSS VSS gf180mcu_as_sc_mcu7t3v3__fillcap_4
XFILLER_153_412 VDD VDD VSS VSS gf180mcu_as_sc_mcu7t3v3__fill_1
XFILLER_172_209 VDD VDD VSS VSS gf180mcu_as_sc_mcu7t3v3__fillcap_16
XFILLER_154_979 VDD VDD VSS VSS gf180mcu_as_sc_mcu7t3v3__fillcap_16
XFILLER_153_489 VDD VDD VSS VSS gf180mcu_as_sc_mcu7t3v3__fill_1
XFILLER_134_670 VDD VDD VSS VSS gf180mcu_as_sc_mcu7t3v3__fillcap_8
XFILLER_79_212 VDD VDD VSS VSS gf180mcu_as_sc_mcu7t3v3__fill_2
XTAP_TAPCELL_ROW_87_1_983 VDD VSS gf180mcu_as_sc_mcu7t3v3__tap_2
XTAP_TAPCELL_ROW_10_3_2364 VDD VSS gf180mcu_as_sc_mcu7t3v3__tap_2
XFILLER_136_1345 VDD VDD VSS VSS gf180mcu_as_sc_mcu7t3v3__fillcap_16
XFILLER_136_1367 VDD VDD VSS VSS gf180mcu_as_sc_mcu7t3v3__fillcap_16
XFILLER_23_1515 VDD VDD VSS VSS gf180mcu_as_sc_mcu7t3v3__fillcap_4
XFILLER_62_1564 VDD VDD VSS VSS gf180mcu_as_sc_mcu7t3v3__fillcap_4
XTAP_TAPCELL_ROW_169_1969 VDD VSS gf180mcu_as_sc_mcu7t3v3__tap_2
XFILLER_23_1537 VDD VDD VSS VSS gf180mcu_as_sc_mcu7t3v3__fillcap_16
XFILLER_94_237 VDD VDD VSS VSS gf180mcu_as_sc_mcu7t3v3__fillcap_8
XFILLER_110_1518 VDD VDD VSS VSS gf180mcu_as_sc_mcu7t3v3__fillcap_16
XFILLER_47_142 VDD VDD VSS VSS gf180mcu_as_sc_mcu7t3v3__fillcap_4
Xclkbuf_leaf_33_clk_regs VDD VDD VSS VSS clkbuf_3_4_0_clk_regs/Y _4858_/CLK gf180mcu_as_sc_mcu7t3v3__clkbuff_12
XFILLER_169_1176 VDD VDD VSS VSS gf180mcu_as_sc_mcu7t3v3__fill_1
XFILLER_62_134 VDD VDD VSS VSS gf180mcu_as_sc_mcu7t3v3__fillcap_8
XFILLER_182_1321 VDD VDD VSS VSS gf180mcu_as_sc_mcu7t3v3__fillcap_4
XPHY_EDGE_ROW_126_3_Left_260 VDD VSS gf180mcu_as_sc_mcu7t3v3__tap_2
X_2920_ VDD VDD VSS VSS _3513_/A _3522_/A _3814_/A gf180mcu_as_sc_mcu7t3v3__or2_2
XTAP_TAPCELL_ROW_64_3_2446 VDD VSS gf180mcu_as_sc_mcu7t3v3__tap_2
X_2851_ VDD VDD VSS VSS _3874_/A _2851_/B _4199_/A gf180mcu_as_sc_mcu7t3v3__nor2_2
X_2782_ VDD VDD VSS VSS _4649_/A _5275_/Q _2783_/B gf180mcu_as_sc_mcu7t3v3__and2_2
XFILLER_7_260 VDD VDD VSS VSS gf180mcu_as_sc_mcu7t3v3__fillcap_4
X_4521_ VDD VDD VSS VSS _4522_/D _4521_/B _4573_/A gf180mcu_as_sc_mcu7t3v3__nor2_2
XFILLER_116_114 VDD VDD VSS VSS gf180mcu_as_sc_mcu7t3v3__fill_2
XFILLER_145_979 VDD VDD VSS VSS gf180mcu_as_sc_mcu7t3v3__fill_1
XFILLER_7_282 VDD VDD VSS VSS gf180mcu_as_sc_mcu7t3v3__fill_1
X_4452_ VDD VDD VSS VSS _5174_/Q _4470_/B _4505_/C _5108_/Q _4453_/B gf180mcu_as_sc_mcu7t3v3__ao22_2
XFILLER_172_776 VDD VDD VSS VSS gf180mcu_as_sc_mcu7t3v3__fillcap_8
X_3403_ VDD VDD VSS VSS _3449_/B _4053_/D _3403_/A _3404_/D gf180mcu_as_sc_mcu7t3v3__mux2_2
XFILLER_119_1521 VDD VDD VSS VSS gf180mcu_as_sc_mcu7t3v3__fillcap_16
X_4383_ VDD VDD VSS VSS _4403_/S _5007_/Q _5036_/Q _4384_/B gf180mcu_as_sc_mcu7t3v3__mux2_2
Xfanout707 VDD VDD VSS VSS _3168_/B _3179_/B gf180mcu_as_sc_mcu7t3v3__buff_2
Xfanout718 VDD VDD VSS VSS _4688_/B _4680_/B gf180mcu_as_sc_mcu7t3v3__buff_2
Xfanout729 VDD VDD VSS VSS _3143_/S _3118_/S gf180mcu_as_sc_mcu7t3v3__buff_2
X_3334_ VDD VDD VSS VSS _3455_/B _3334_/B _3334_/C _3335_/C gf180mcu_as_sc_mcu7t3v3__nor3_2
XFILLER_140_695 VDD VDD VSS VSS gf180mcu_as_sc_mcu7t3v3__fill_1
X_3265_ VDD VDD VSS VSS _3265_/B _3275_/A _3521_/B gf180mcu_as_sc_mcu7t3v3__and2_2
X_5004_ VDD VDD VSS VSS _5185_/CLK _5004_/D _5004_/Q gf180mcu_as_sc_mcu7t3v3__dfxtp_2
X_3196_ VDD VDD VSS VSS _3216_/B _3791_/A _3197_/B gf180mcu_as_sc_mcu7t3v3__or2_2
XTAP_TAPCELL_ROW_29_1_752 VDD VSS gf180mcu_as_sc_mcu7t3v3__tap_2
XFILLER_148_1205 VDD VDD VSS VSS gf180mcu_as_sc_mcu7t3v3__fillcap_16
XFILLER_121_27 VDD VDD VSS VSS gf180mcu_as_sc_mcu7t3v3__fillcap_8
XFILLER_148_1227 VDD VDD VSS VSS gf180mcu_as_sc_mcu7t3v3__fill_2
XFILLER_53_134 VDD VDD VSS VSS gf180mcu_as_sc_mcu7t3v3__fillcap_4
XPHY_EDGE_ROW_58_3_Left_192 VDD VSS gf180mcu_as_sc_mcu7t3v3__tap_2
XTAP_TAPCELL_ROW_140_1343 VDD VSS gf180mcu_as_sc_mcu7t3v3__tap_2
XTAP_TAPCELL_ROW_140_1332 VDD VSS gf180mcu_as_sc_mcu7t3v3__tap_2
XTAP_TAPCELL_ROW_175_2107 VDD VSS gf180mcu_as_sc_mcu7t3v3__tap_2
XFILLER_14_69 VDD VDD VSS VSS gf180mcu_as_sc_mcu7t3v3__fillcap_16
XFILLER_161_1449 VDD VDD VSS VSS gf180mcu_as_sc_mcu7t3v3__fillcap_16
XFILLER_154_209 VDD VDD VSS VSS gf180mcu_as_sc_mcu7t3v3__fillcap_16
XFILLER_159_1301 VDD VDD VSS VSS gf180mcu_as_sc_mcu7t3v3__fill_1
XFILLER_175_570 VDD VDD VSS VSS gf180mcu_as_sc_mcu7t3v3__fillcap_4
X_4719_ VDD VDD VSS VSS _4721_/B _4719_/B _4719_/A gf180mcu_as_sc_mcu7t3v3__nand2_2
XFILLER_163_754 VDD VDD VSS VSS gf180mcu_as_sc_mcu7t3v3__fill_2
XFILLER_30_24 VDD VDD VSS VSS gf180mcu_as_sc_mcu7t3v3__fillcap_8
XTAP_TAPCELL_ROW_138_1294 VDD VSS gf180mcu_as_sc_mcu7t3v3__tap_2
XTAP_TAPCELL_ROW_138_1283 VDD VSS gf180mcu_as_sc_mcu7t3v3__tap_2
XFILLER_151_938 VDD VDD VSS VSS gf180mcu_as_sc_mcu7t3v3__fillcap_8
XFILLER_150_415 VDD VDD VSS VSS gf180mcu_as_sc_mcu7t3v3__fillcap_8
XFILLER_172_1523 VDD VDD VSS VSS gf180mcu_as_sc_mcu7t3v3__fillcap_16
XFILLER_85_1553 VDD VDD VSS VSS gf180mcu_as_sc_mcu7t3v3__fillcap_16
XFILLER_133_1518 VDD VDD VSS VSS gf180mcu_as_sc_mcu7t3v3__fill_1
XFILLER_162_34 VDD VDD VSS VSS gf180mcu_as_sc_mcu7t3v3__fill_1
XFILLER_172_1567 VDD VDD VSS VSS gf180mcu_as_sc_mcu7t3v3__fill_2
XPHY_EDGE_ROW_7_1_Left_459 VDD VSS gf180mcu_as_sc_mcu7t3v3__tap_2
XFILLER_29_120 VDD VDD VSS VSS gf180mcu_as_sc_mcu7t3v3__fill_2
XFILLER_39_88 VDD VDD VSS VSS gf180mcu_as_sc_mcu7t3v3__fillcap_8
XFILLER_76_259 VDD VDD VSS VSS gf180mcu_as_sc_mcu7t3v3__fill_2
XFILLER_29_142 VDD VDD VSS VSS gf180mcu_as_sc_mcu7t3v3__fillcap_4
XFILLER_55_10 VDD VDD VSS VSS gf180mcu_as_sc_mcu7t3v3__fill_1
XTAP_TAPCELL_ROW_164_1855 VDD VSS gf180mcu_as_sc_mcu7t3v3__tap_2
XFILLER_166_1305 VDD VDD VSS VSS gf180mcu_as_sc_mcu7t3v3__fill_2
XFILLER_176_2 VDD VDD VSS VSS gf180mcu_as_sc_mcu7t3v3__fillcap_16
XFILLER_29_186 VDD VDD VSS VSS gf180mcu_as_sc_mcu7t3v3__fillcap_16
XTAP_TAPCELL_ROW_164_1866 VDD VSS gf180mcu_as_sc_mcu7t3v3__tap_2
XFILLER_44_123 VDD VDD VSS VSS gf180mcu_as_sc_mcu7t3v3__fillcap_16
XFILLER_84_292 VDD VDD VSS VSS gf180mcu_as_sc_mcu7t3v3__fillcap_8
XFILLER_71_20 VDD VDD VSS VSS gf180mcu_as_sc_mcu7t3v3__fill_1
XFILLER_92_1568 VDD VDD VSS VSS gf180mcu_as_sc_mcu7t3v3__fill_1
XFILLER_173_507 VDD VDD VSS VSS gf180mcu_as_sc_mcu7t3v3__fillcap_8
XFILLER_154_721 VDD VDD VSS VSS gf180mcu_as_sc_mcu7t3v3__fillcap_8
XFILLER_166_592 VDD VDD VSS VSS gf180mcu_as_sc_mcu7t3v3__fill_2
XFILLER_181_562 VDD VDD VSS VSS gf180mcu_as_sc_mcu7t3v3__fillcap_16
XFILLER_58_8 VDD VDD VSS VSS gf180mcu_as_sc_mcu7t3v3__fill_2
XTAP_TAPCELL_ROW_28_3_2391 VDD VSS gf180mcu_as_sc_mcu7t3v3__tap_2
XFILLER_150_971 VDD VDD VSS VSS gf180mcu_as_sc_mcu7t3v3__fillcap_8
X_4889__978 VDD VDD VSS VSS _4889_/D gf180mcu_as_sc_mcu7t3v3__tiel_4
XTAP_TAPCELL_ROW_116_3_2523 VDD VSS gf180mcu_as_sc_mcu7t3v3__tap_2
XFILLER_7_1553 VDD VDD VSS VSS gf180mcu_as_sc_mcu7t3v3__fillcap_16
X_3050_ VDD VDD VSS VSS _4032_/A _3142_/B _3142_/C _4032_/D _3056_/B gf180mcu_as_sc_mcu7t3v3__ao22_2
XFILLER_114_1451 VDD VDD VSS VSS gf180mcu_as_sc_mcu7t3v3__fillcap_16
XFILLER_149_1514 VDD VDD VSS VSS gf180mcu_as_sc_mcu7t3v3__fill_1
X_3952_ VDD VDD VSS VSS _3953_/D _3952_/C _4163_/B _3952_/A gf180mcu_as_sc_mcu7t3v3__aoi21_2
XFILLER_149_526 VDD VDD VSS VSS gf180mcu_as_sc_mcu7t3v3__fill_1
XFILLER_149_537 VDD VDD VSS VSS gf180mcu_as_sc_mcu7t3v3__fillcap_16
XFILLER_91_2 VDD VDD VSS VSS gf180mcu_as_sc_mcu7t3v3__fillcap_8
X_3883_ VDD VDD VSS VSS _3897_/B _5173_/Q _4923_/D gf180mcu_as_sc_mcu7t3v3__and2_2
X_2903_ VDD VDD VSS VSS _2903_/Y _3199_/B _3542_/A gf180mcu_as_sc_mcu7t3v3__nand2_2
XFILLER_149_559 VDD VDD VSS VSS gf180mcu_as_sc_mcu7t3v3__fill_1
X_2834_ VDD VDD VSS VSS _4751_/B _4974_/D _4761_/D gf180mcu_as_sc_mcu7t3v3__and2_2
XFILLER_157_570 VDD VDD VSS VSS gf180mcu_as_sc_mcu7t3v3__fillcap_4
XFILLER_164_518 VDD VDD VSS VSS gf180mcu_as_sc_mcu7t3v3__fillcap_4
XTAP_TAPCELL_ROW_170_2004 VDD VSS gf180mcu_as_sc_mcu7t3v3__tap_2
XFILLER_145_721 VDD VDD VSS VSS gf180mcu_as_sc_mcu7t3v3__fillcap_16
XFILLER_69_1515 VDD VDD VSS VSS gf180mcu_as_sc_mcu7t3v3__fillcap_4
X_4504_ VDD VDD VSS VSS _5178_/Q _4592_/B _4504_/C _4504_/D _5178_/D gf180mcu_as_sc_mcu7t3v3__ao211_2
X_2765_ VDD VDD VSS VSS _4691_/A _2765_/B _2765_/C _2765_/D _2840_/B gf180mcu_as_sc_mcu7t3v3__ao211_2
XFILLER_121_1499 VDD VDD VSS VSS gf180mcu_as_sc_mcu7t3v3__fillcap_16
XFILLER_144_242 VDD VDD VSS VSS gf180mcu_as_sc_mcu7t3v3__fill_2
XFILLER_156_1507 VDD VDD VSS VSS gf180mcu_as_sc_mcu7t3v3__fill_2
XFILLER_172_551 VDD VDD VSS VSS gf180mcu_as_sc_mcu7t3v3__fill_1
XFILLER_69_1537 VDD VDD VSS VSS gf180mcu_as_sc_mcu7t3v3__fillcap_16
X_5484_ VDD VDD VSS VSS _5484_/A _5484_/Y gf180mcu_as_sc_mcu7t3v3__buff_2
X_2696_ VDD VDD VSS VSS _2717_/S _2699_/A _4289_/S gf180mcu_as_sc_mcu7t3v3__and2_2
X_4435_ VDD VDD VSS VSS _4435_/B _4506_/A _4442_/C gf180mcu_as_sc_mcu7t3v3__and2_2
XFILLER_116_27 VDD VDD VSS VSS gf180mcu_as_sc_mcu7t3v3__fillcap_8
XFILLER_154_1231 VDD VDD VSS VSS gf180mcu_as_sc_mcu7t3v3__fill_1
Xfanout504 VDD VDD VSS VSS fanout505/Y _3745_/B gf180mcu_as_sc_mcu7t3v3__buff_2
Xfanout515 VDD VDD VSS VSS _4505_/C _4493_/C gf180mcu_as_sc_mcu7t3v3__buff_2
X_4366_ VDD VDD VSS VSS _4366_/S _5162_/Q _4366_/A _4367_/B gf180mcu_as_sc_mcu7t3v3__mux2_2
XFILLER_141_982 VDD VDD VSS VSS gf180mcu_as_sc_mcu7t3v3__fillcap_16
XFILLER_154_1275 VDD VDD VSS VSS gf180mcu_as_sc_mcu7t3v3__fill_1
Xfanout526 VDD VDD VSS VSS fanout527/Y _4122_/B gf180mcu_as_sc_mcu7t3v3__buff_2
Xfanout537 VDD VDD VSS VSS _4252_/S _4248_/S gf180mcu_as_sc_mcu7t3v3__buff_2
Xfanout548 VDD VDD VSS VSS _3286_/Y _3476_/B gf180mcu_as_sc_mcu7t3v3__buff_2
X_3317_ VDD VDD VSS VSS _3966_/A _3474_/C _3523_/B _3969_/A _3318_/C gf180mcu_as_sc_mcu7t3v3__ao22_2
XFILLER_154_1297 VDD VDD VSS VSS gf180mcu_as_sc_mcu7t3v3__fillcap_16
Xfanout559 VDD VDD VSS VSS fanout560/Y _3132_/B gf180mcu_as_sc_mcu7t3v3__buff_2
X_4297_ VDD VDD VSS VSS _4297_/S _5126_/Q _4297_/A _5126_/D gf180mcu_as_sc_mcu7t3v3__mux2_2
XFILLER_80_1483 VDD VDD VSS VSS gf180mcu_as_sc_mcu7t3v3__fill_1
Xmesh_tile_952 VDD VDD VSS VSS sw_out[25] gf180mcu_as_sc_mcu7t3v3__tiel_4
Xmesh_tile_941 VDD VDD VSS VSS sw_out[14] gf180mcu_as_sc_mcu7t3v3__tiel_4
Xmesh_tile_930 VDD VDD VSS VSS sw_out[3] gf180mcu_as_sc_mcu7t3v3__tiel_4
X_3248_ VDD VDD VSS VSS _3249_/B _3914_/A _3519_/D gf180mcu_as_sc_mcu7t3v3__and2_2
XFILLER_132_37 VDD VDD VSS VSS gf180mcu_as_sc_mcu7t3v3__fillcap_16
XFILLER_26_101 VDD VDD VSS VSS gf180mcu_as_sc_mcu7t3v3__fillcap_4
XFILLER_41_1467 VDD VDD VSS VSS gf180mcu_as_sc_mcu7t3v3__fillcap_16
X_3179_ VDD VDD VSS VSS _3179_/B _4942_/Q _3180_/D gf180mcu_as_sc_mcu7t3v3__or2_2
XFILLER_26_123 VDD VDD VSS VSS gf180mcu_as_sc_mcu7t3v3__fillcap_16
XFILLER_81_240 VDD VDD VSS VSS gf180mcu_as_sc_mcu7t3v3__fillcap_8
XFILLER_162_8 VDD VDD VSS VSS gf180mcu_as_sc_mcu7t3v3__fillcap_4
XPHY_EDGE_ROW_28_1_Left_480 VDD VSS gf180mcu_as_sc_mcu7t3v3__tap_2
XTAP_TAPCELL_ROW_78_1_947 VDD VSS gf180mcu_as_sc_mcu7t3v3__tap_2
XTAP_TAPCELL_ROW_46_3_2418 VDD VSS gf180mcu_as_sc_mcu7t3v3__tap_2
XFILLER_127_209 VDD VDD VSS VSS gf180mcu_as_sc_mcu7t3v3__fill_1
XFILLER_155_518 VDD VDD VSS VSS gf180mcu_as_sc_mcu7t3v3__fillcap_4
XTAP_TAPCELL_ROW_122_3_2533 VDD VSS gf180mcu_as_sc_mcu7t3v3__tap_2
XFILLER_135_231 VDD VDD VSS VSS gf180mcu_as_sc_mcu7t3v3__fillcap_16
XFILLER_151_702 VDD VDD VSS VSS gf180mcu_as_sc_mcu7t3v3__fillcap_8
XFILLER_163_562 VDD VDD VSS VSS gf180mcu_as_sc_mcu7t3v3__fillcap_8
XFILLER_155_1006 VDD VDD VSS VSS gf180mcu_as_sc_mcu7t3v3__fill_1
XFILLER_159_1186 VDD VDD VSS VSS gf180mcu_as_sc_mcu7t3v3__fillcap_4
XFILLER_163_584 VDD VDD VSS VSS gf180mcu_as_sc_mcu7t3v3__fill_1
XFILLER_150_267 VDD VDD VSS VSS gf180mcu_as_sc_mcu7t3v3__fill_1
XFILLER_49_204 VDD VDD VSS VSS gf180mcu_as_sc_mcu7t3v3__fillcap_4
XTAP_TAPCELL_ROW_166_1906 VDD VSS gf180mcu_as_sc_mcu7t3v3__tap_2
XFILLER_172_1375 VDD VDD VSS VSS gf180mcu_as_sc_mcu7t3v3__fill_2
XFILLER_173_88 VDD VDD VSS VSS gf180mcu_as_sc_mcu7t3v3__fillcap_16
XFILLER_1_299 VDD VDD VSS VSS gf180mcu_as_sc_mcu7t3v3__fill_2
XTAP_TAPCELL_ROW_2_3_2352 VDD VSS gf180mcu_as_sc_mcu7t3v3__tap_2
XTAP_TAPCELL_ROW_166_1917 VDD VSS gf180mcu_as_sc_mcu7t3v3__tap_2
XFILLER_20_1518 VDD VDD VSS VSS gf180mcu_as_sc_mcu7t3v3__fillcap_16
XFILLER_166_1157 VDD VDD VSS VSS gf180mcu_as_sc_mcu7t3v3__fillcap_4
XFILLER_2_1483 VDD VDD VSS VSS gf180mcu_as_sc_mcu7t3v3__fill_1
XFILLER_72_251 VDD VDD VSS VSS gf180mcu_as_sc_mcu7t3v3__fill_1
XFILLER_109_1553 VDD VDD VSS VSS gf180mcu_as_sc_mcu7t3v3__fillcap_8
XFILLER_159_835 VDD VDD VSS VSS gf180mcu_as_sc_mcu7t3v3__fillcap_4
XFILLER_82_96 VDD VDD VSS VSS gf180mcu_as_sc_mcu7t3v3__fillcap_8
XFILLER_9_300 VDD VDD VSS VSS gf180mcu_as_sc_mcu7t3v3__fill_1
XFILLER_159_868 VDD VDD VSS VSS gf180mcu_as_sc_mcu7t3v3__fillcap_16
XFILLER_139_570 VDD VDD VSS VSS gf180mcu_as_sc_mcu7t3v3__fillcap_4
XFILLER_174_838 VDD VDD VSS VSS gf180mcu_as_sc_mcu7t3v3__fillcap_4
XPHY_EDGE_ROW_60_1_Right_59 VDD VSS gf180mcu_as_sc_mcu7t3v3__tap_2
XPHY_EDGE_ROW_157_Left_609 VDD VSS gf180mcu_as_sc_mcu7t3v3__tap_2
X_2550_ VDD VDD VSS VSS _4754_/Q _4956_/Q _2556_/B _4705_/A _2557_/A gf180mcu_as_sc_mcu7t3v3__nand4_2
XFILLER_141_212 VDD VDD VSS VSS gf180mcu_as_sc_mcu7t3v3__fillcap_4
XFILLER_154_573 VDD VDD VSS VSS gf180mcu_as_sc_mcu7t3v3__fill_1
X_2481_ VDD VDD VSS VSS _4708_/C _2482_/B _4291_/A gf180mcu_as_sc_mcu7t3v3__nor2_2
XFILLER_29_1521 VDD VDD VSS VSS gf180mcu_as_sc_mcu7t3v3__fillcap_16
XFILLER_99_137 VDD VDD VSS VSS gf180mcu_as_sc_mcu7t3v3__fill_2
X_4220_ VDD VDD VSS VSS _4249_/B _4223_/B _4223_/C _5056_/Q _5056_/D gf180mcu_as_sc_mcu7t3v3__ao22_2
XFILLER_116_1502 VDD VDD VSS VSS gf180mcu_as_sc_mcu7t3v3__fillcap_16
XFILLER_64_1467 VDD VDD VSS VSS gf180mcu_as_sc_mcu7t3v3__fillcap_16
X_4151_ VDD VDD VSS VSS _4151_/A _4161_/B _4159_/C _4151_/D _4153_/C gf180mcu_as_sc_mcu7t3v3__ao22_2
XTAP_TAPCELL_ROW_118_1_1108 VDD VSS gf180mcu_as_sc_mcu7t3v3__tap_2
XFILLER_55_207 VDD VDD VSS VSS gf180mcu_as_sc_mcu7t3v3__fill_2
XPHY_EDGE_ROW_166_Left_618 VDD VSS gf180mcu_as_sc_mcu7t3v3__tap_2
X_4082_ VDD VDD VSS VSS _4083_/C _4082_/B _4082_/A gf180mcu_as_sc_mcu7t3v3__nor2_2
X_3102_ VDD VDD VSS VSS _4079_/A _3177_/B _3169_/C _4080_/D _3103_/C gf180mcu_as_sc_mcu7t3v3__ao22_2
XPHY_EDGE_ROW_93_1_Left_545 VDD VSS gf180mcu_as_sc_mcu7t3v3__tap_2
X_3033_ VDD VDD VSS VSS _3040_/B _3130_/B _4017_/A gf180mcu_as_sc_mcu7t3v3__nand2_2
XTAP_TAPCELL_ROW_52_3_2428 VDD VSS gf180mcu_as_sc_mcu7t3v3__tap_2
XFILLER_102_18 VDD VDD VSS VSS gf180mcu_as_sc_mcu7t3v3__fillcap_16
XFILLER_149_1366 VDD VDD VSS VSS gf180mcu_as_sc_mcu7t3v3__fillcap_16
XFILLER_23_104 VDD VDD VSS VSS gf180mcu_as_sc_mcu7t3v3__fillcap_16
XFILLER_145_1208 VDD VDD VSS VSS gf180mcu_as_sc_mcu7t3v3__fillcap_16
XFILLER_162_1500 VDD VDD VSS VSS gf180mcu_as_sc_mcu7t3v3__fillcap_4
XFILLER_184_1268 VDD VDD VSS VSS gf180mcu_as_sc_mcu7t3v3__fill_2
X_4984_ VDD VDD VSS VSS _5080_/CLK _4984_/D _4984_/Q gf180mcu_as_sc_mcu7t3v3__dfxtp_2
X_3935_ VDD VDD VSS VSS _3936_/C _3935_/B _3935_/A gf180mcu_as_sc_mcu7t3v3__nor2_2
XTAP_TAPCELL_ROW_74_1_931 VDD VSS gf180mcu_as_sc_mcu7t3v3__tap_2
XFILLER_149_356 VDD VDD VSS VSS gf180mcu_as_sc_mcu7t3v3__fill_2
XFILLER_162_1555 VDD VDD VSS VSS gf180mcu_as_sc_mcu7t3v3__fillcap_8
XFILLER_177_632 VDD VDD VSS VSS gf180mcu_as_sc_mcu7t3v3__fillcap_4
XPHY_EDGE_ROW_175_Left_627 VDD VSS gf180mcu_as_sc_mcu7t3v3__tap_2
XFILLER_165_838 VDD VDD VSS VSS gf180mcu_as_sc_mcu7t3v3__fill_2
X_3866_ VDD VDD VSS VSS _5137_/Q _5138_/Q _3866_/C _3868_/B gf180mcu_as_sc_mcu7t3v3__nor3_2
XFILLER_164_348 VDD VDD VSS VSS gf180mcu_as_sc_mcu7t3v3__fillcap_16
X_3797_ VDD VDD VSS VSS _3797_/D _3797_/A _3812_/B _3797_/C _3798_/B gf180mcu_as_sc_mcu7t3v3__ao31_2
X_2817_ VDD VDD VSS VSS _5481_/A _2833_/A _2827_/B gf180mcu_as_sc_mcu7t3v3__and2_2
XTAP_TAPCELL_ROW_135_1220 VDD VSS gf180mcu_as_sc_mcu7t3v3__tap_2
XFILLER_145_562 VDD VDD VSS VSS gf180mcu_as_sc_mcu7t3v3__fillcap_16
X_2748_ VDD VDD VSS VSS _4953_/Q _4754_/Q _2810_/D gf180mcu_as_sc_mcu7t3v3__and2_2
XTAP_TAPCELL_ROW_135_1231 VDD VSS gf180mcu_as_sc_mcu7t3v3__tap_2
XFILLER_172_381 VDD VDD VSS VSS gf180mcu_as_sc_mcu7t3v3__fillcap_4
XFILLER_156_1337 VDD VDD VSS VSS gf180mcu_as_sc_mcu7t3v3__fillcap_4
X_4418_ VDD VDD VSS VSS _4421_/C _4418_/C _5040_/Q _4568_/A gf180mcu_as_sc_mcu7t3v3__aoi21b_2
X_2679_ VDD VDD VSS VSS _2717_/S _5173_/Q _5165_/Q _2684_/B gf180mcu_as_sc_mcu7t3v3__mux2_2
XFILLER_132_267 VDD VDD VSS VSS gf180mcu_as_sc_mcu7t3v3__fill_2
XFILLER_82_1534 VDD VDD VSS VSS gf180mcu_as_sc_mcu7t3v3__fillcap_16
XFILLER_82_1556 VDD VDD VSS VSS gf180mcu_as_sc_mcu7t3v3__fillcap_8
XPHY_EDGE_ROW_184_Left_636 VDD VSS gf180mcu_as_sc_mcu7t3v3__tap_2
X_4349_ VDD VDD VSS VSS _4366_/S _5159_/Q _4349_/A _4351_/B gf180mcu_as_sc_mcu7t3v3__mux2_2
XFILLER_154_1094 VDD VDD VSS VSS gf180mcu_as_sc_mcu7t3v3__fillcap_16
XPHY_EDGE_ROW_121_1_Right_120 VDD VSS gf180mcu_as_sc_mcu7t3v3__tap_2
XTAP_TAPCELL_ROW_161_1803 VDD VSS gf180mcu_as_sc_mcu7t3v3__tap_2
XFILLER_100_197 VDD VDD VSS VSS gf180mcu_as_sc_mcu7t3v3__fill_2
XFILLER_36_34 VDD VDD VSS VSS gf180mcu_as_sc_mcu7t3v3__fill_1
XFILLER_54_251 VDD VDD VSS VSS gf180mcu_as_sc_mcu7t3v3__fill_1
XFILLER_167_1488 VDD VDD VSS VSS gf180mcu_as_sc_mcu7t3v3__fillcap_16
XFILLER_167_120 VDD VDD VSS VSS gf180mcu_as_sc_mcu7t3v3__fillcap_16
XTAP_TAPCELL_ROW_159_1754 VDD VSS gf180mcu_as_sc_mcu7t3v3__tap_2
XFILLER_139_2 VDD VDD VSS VSS gf180mcu_as_sc_mcu7t3v3__fillcap_16
XFILLER_167_142 VDD VDD VSS VSS gf180mcu_as_sc_mcu7t3v3__fillcap_16
XPHY_EDGE_ROW_145_Right_279 VDD VSS gf180mcu_as_sc_mcu7t3v3__tap_2
X_4879__988 VDD VDD VSS VSS _4879_/D gf180mcu_as_sc_mcu7t3v3__tiel_4
XTAP_TAPCELL_ROW_159_1765 VDD VSS gf180mcu_as_sc_mcu7t3v3__tap_2
XFILLER_155_348 VDD VDD VSS VSS gf180mcu_as_sc_mcu7t3v3__fill_2
XFILLER_156_849 VDD VDD VSS VSS gf180mcu_as_sc_mcu7t3v3__fill_1
XFILLER_161_1098 VDD VDD VSS VSS gf180mcu_as_sc_mcu7t3v3__fillcap_8
XFILLER_183_624 VDD VDD VSS VSS gf180mcu_as_sc_mcu7t3v3__fillcap_4
XFILLER_104_1483 VDD VDD VSS VSS gf180mcu_as_sc_mcu7t3v3__fill_1
XFILLER_139_1502 VDD VDD VSS VSS gf180mcu_as_sc_mcu7t3v3__fillcap_8
XFILLER_182_134 VDD VDD VSS VSS gf180mcu_as_sc_mcu7t3v3__fillcap_8
XTAP_TAPCELL_ROW_16_1_700 VDD VSS gf180mcu_as_sc_mcu7t3v3__tap_2
XFILLER_123_212 VDD VDD VSS VSS gf180mcu_as_sc_mcu7t3v3__fill_2
XFILLER_139_1535 VDD VDD VSS VSS gf180mcu_as_sc_mcu7t3v3__fillcap_4
XFILLER_174_1415 VDD VDD VSS VSS gf180mcu_as_sc_mcu7t3v3__fillcap_16
XFILLER_184_32 VDD VDD VSS VSS gf180mcu_as_sc_mcu7t3v3__fill_2
XFILLER_87_1467 VDD VDD VSS VSS gf180mcu_as_sc_mcu7t3v3__fillcap_16
XPHY_EDGE_ROW_10_3_Left_144 VDD VSS gf180mcu_as_sc_mcu7t3v3__tap_2
XFILLER_174_1448 VDD VDD VSS VSS gf180mcu_as_sc_mcu7t3v3__fillcap_16
XFILLER_96_107 VDD VDD VSS VSS gf180mcu_as_sc_mcu7t3v3__fillcap_16
XFILLER_137_1270 VDD VDD VSS VSS gf180mcu_as_sc_mcu7t3v3__fill_2
XFILLER_172_1150 VDD VDD VSS VSS gf180mcu_as_sc_mcu7t3v3__fillcap_4
XFILLER_172_1161 VDD VDD VSS VSS gf180mcu_as_sc_mcu7t3v3__fill_2
XFILLER_24_1451 VDD VDD VSS VSS gf180mcu_as_sc_mcu7t3v3__fillcap_16
XFILLER_4_1534 VDD VDD VSS VSS gf180mcu_as_sc_mcu7t3v3__fillcap_16
XPHY_EDGE_ROW_131_3_Right_450 VDD VSS gf180mcu_as_sc_mcu7t3v3__tap_2
XFILLER_133_80 VDD VDD VSS VSS gf180mcu_as_sc_mcu7t3v3__fillcap_16
XFILLER_150_1481 VDD VDD VSS VSS gf180mcu_as_sc_mcu7t3v3__fillcap_4
XFILLER_4_1556 VDD VDD VSS VSS gf180mcu_as_sc_mcu7t3v3__fillcap_8
XTAP_TAPCELL_ROW_39_1_790 VDD VSS gf180mcu_as_sc_mcu7t3v3__tap_2
XFILLER_60_243 VDD VDD VSS VSS gf180mcu_as_sc_mcu7t3v3__fill_2
XFILLER_159_632 VDD VDD VSS VSS gf180mcu_as_sc_mcu7t3v3__fillcap_8
XFILLER_20_107 VDD VDD VSS VSS gf180mcu_as_sc_mcu7t3v3__fillcap_16
XFILLER_60_287 VDD VDD VSS VSS gf180mcu_as_sc_mcu7t3v3__fillcap_8
X_3720_ VDD VDD VSS VSS _3720_/D _4093_/A _3728_/B _3800_/C _3721_/C gf180mcu_as_sc_mcu7t3v3__ao31_2
XTAP_TAPCELL_ROW_16_3_2373 VDD VSS gf180mcu_as_sc_mcu7t3v3__tap_2
XFILLER_174_613 VDD VDD VSS VSS gf180mcu_as_sc_mcu7t3v3__fillcap_8
XFILLER_122_1550 VDD VDD VSS VSS gf180mcu_as_sc_mcu7t3v3__fillcap_4
XFILLER_9_174 VDD VDD VSS VSS gf180mcu_as_sc_mcu7t3v3__fillcap_16
X_3651_ VDD VDD VSS VSS _3652_/C _4021_/A _3750_/C _3651_/C gf180mcu_as_sc_mcu7t3v3__ao21_2
XFILLER_161_307 VDD VDD VSS VSS gf180mcu_as_sc_mcu7t3v3__fill_2
X_3582_ VDD VDD VSS VSS _3951_/A _3779_/B _3778_/B _3949_/A _3583_/D gf180mcu_as_sc_mcu7t3v3__ao22_2
X_2602_ VDD VDD VSS VSS _4262_/B _2602_/B _4264_/A _2603_/B gf180mcu_as_sc_mcu7t3v3__mux2_2
XTAP_TAPCELL_ROW_104_3_2505 VDD VSS gf180mcu_as_sc_mcu7t3v3__tap_2
XFILLER_114_201 VDD VDD VSS VSS gf180mcu_as_sc_mcu7t3v3__fillcap_4
XFILLER_155_893 VDD VDD VSS VSS gf180mcu_as_sc_mcu7t3v3__fillcap_4
XFILLER_31_1499 VDD VDD VSS VSS gf180mcu_as_sc_mcu7t3v3__fillcap_16
XFILLER_54_2 VDD VDD VSS VSS gf180mcu_as_sc_mcu7t3v3__fill_2
XFILLER_66_1518 VDD VDD VSS VSS gf180mcu_as_sc_mcu7t3v3__fillcap_16
X_2533_ VDD VDD VSS VSS _4372_/B _4329_/A _2534_/C gf180mcu_as_sc_mcu7t3v3__nor2b_2
XFILLER_142_543 VDD VDD VSS VSS gf180mcu_as_sc_mcu7t3v3__fill_2
XFILLER_170_874 VDD VDD VSS VSS gf180mcu_as_sc_mcu7t3v3__fill_1
X_5252_ VDD VDD VSS VSS clkload6/A _5252_/D _5252_/Q gf180mcu_as_sc_mcu7t3v3__dfxtp_2
X_2464_ VDD VDD VSS VSS _2467_/C _2464_/C _5064_/Q _4447_/S gf180mcu_as_sc_mcu7t3v3__aoi21b_2
X_5183_ VDD VDD VSS VSS _5183_/CLK _5183_/D _5183_/Q gf180mcu_as_sc_mcu7t3v3__dfxtp_2
X_4203_ VDD VDD VSS VSS _4232_/B _4218_/B _4221_/C _5039_/Q _5039_/D gf180mcu_as_sc_mcu7t3v3__ao22_2
X_2395_ VDD VDD VSS VSS _4733_/A _5268_/Q gf180mcu_as_sc_mcu7t3v3__inv_2
XFILLER_9_1467 VDD VDD VSS VSS gf180mcu_as_sc_mcu7t3v3__fillcap_16
X_4134_ VDD VDD VSS VSS _5002_/Q _4166_/B _4253_/B _4166_/D _5002_/D gf180mcu_as_sc_mcu7t3v3__ao22_2
XTAP_TAPCELL_ROW_182_2261 VDD VSS gf180mcu_as_sc_mcu7t3v3__tap_2
XTAP_TAPCELL_ROW_182_2250 VDD VSS gf180mcu_as_sc_mcu7t3v3__tap_2
X_4065_ VDD VDD VSS VSS _4065_/A _4101_/B _4065_/C _4065_/D _4066_/C gf180mcu_as_sc_mcu7t3v3__ao211_2
XFILLER_149_1130 VDD VDD VSS VSS gf180mcu_as_sc_mcu7t3v3__fillcap_4
X_3016_ VDD VDD VSS VSS _3998_/A _3125_/B _3125_/C _3997_/A _3022_/B gf180mcu_as_sc_mcu7t3v3__ao22_2
XFILLER_149_1152 VDD VDD VSS VSS gf180mcu_as_sc_mcu7t3v3__fillcap_16
XFILLER_36_295 VDD VDD VSS VSS gf180mcu_as_sc_mcu7t3v3__fillcap_4
XFILLER_145_1049 VDD VDD VSS VSS gf180mcu_as_sc_mcu7t3v3__fill_1
XFILLER_149_120 VDD VDD VSS VSS gf180mcu_as_sc_mcu7t3v3__fillcap_16
XFILLER_162_1341 VDD VDD VSS VSS gf180mcu_as_sc_mcu7t3v3__fill_1
XFILLER_51_298 VDD VDD VSS VSS gf180mcu_as_sc_mcu7t3v3__fill_2
X_4967_ VDD VDD VSS VSS clkload9/A _4967_/D _4967_/Q gf180mcu_as_sc_mcu7t3v3__dfxtp_2
Xsram2048.u_bank0_817 VDD VDD VSS VSS sram2048.u_bank0/WEN[7] gf180mcu_as_sc_mcu7t3v3__tiel_4
XFILLER_127_1483 VDD VDD VSS VSS gf180mcu_as_sc_mcu7t3v3__fillcap_16
XFILLER_149_142 VDD VDD VSS VSS gf180mcu_as_sc_mcu7t3v3__fillcap_16
XFILLER_162_1363 VDD VDD VSS VSS gf180mcu_as_sc_mcu7t3v3__fill_2
X_4898_ VDD VDD VSS VSS _4928_/CLK _4898_/D _4898_/Q gf180mcu_as_sc_mcu7t3v3__dfxtp_2
X_3918_ VDD VDD VSS VSS _3920_/A _3923_/B _3918_/A gf180mcu_as_sc_mcu7t3v3__nand2_2
XFILLER_164_101 VDD VDD VSS VSS gf180mcu_as_sc_mcu7t3v3__fillcap_4
XFILLER_164_123 VDD VDD VSS VSS gf180mcu_as_sc_mcu7t3v3__fillcap_16
XFILLER_165_624 VDD VDD VSS VSS gf180mcu_as_sc_mcu7t3v3__fillcap_4
X_3849_ VDD VDD VSS VSS _3850_/C _5134_/Q _5131_/Q gf180mcu_as_sc_mcu7t3v3__nor2_2
XTAP_TAPCELL_ROW_56_1_860 VDD VSS gf180mcu_as_sc_mcu7t3v3__tap_2
XFILLER_137_348 VDD VDD VSS VSS gf180mcu_as_sc_mcu7t3v3__fill_2
XFILLER_153_808 VDD VDD VSS VSS gf180mcu_as_sc_mcu7t3v3__fill_2
XFILLER_22_69 VDD VDD VSS VSS gf180mcu_as_sc_mcu7t3v3__fillcap_16
XTAP_TAPCELL_ROW_154_1651 VDD VSS gf180mcu_as_sc_mcu7t3v3__tap_2
XTAP_TAPCELL_ROW_154_1640 VDD VSS gf180mcu_as_sc_mcu7t3v3__tap_2
XFILLER_138_69 VDD VDD VSS VSS gf180mcu_as_sc_mcu7t3v3__fillcap_16
XFILLER_146_893 VDD VDD VSS VSS gf180mcu_as_sc_mcu7t3v3__fill_2
XFILLER_180_616 VDD VDD VSS VSS gf180mcu_as_sc_mcu7t3v3__fillcap_8
XFILLER_105_212 VDD VDD VSS VSS gf180mcu_as_sc_mcu7t3v3__fillcap_16
XTAP_TAPCELL_ROW_150_1559 VDD VSS gf180mcu_as_sc_mcu7t3v3__tap_2
XTAP_TAPCELL_ROW_150_1548 VDD VSS gf180mcu_as_sc_mcu7t3v3__tap_2
XFILLER_47_1451 VDD VDD VSS VSS gf180mcu_as_sc_mcu7t3v3__fillcap_16
XFILLER_78_107 VDD VDD VSS VSS gf180mcu_as_sc_mcu7t3v3__fillcap_8
Xoutput460 VDD VDD VSS VSS _4882_/Q west_out[9] gf180mcu_as_sc_mcu7t3v3__buff_2
XFILLER_160_384 VDD VDD VSS VSS gf180mcu_as_sc_mcu7t3v3__fill_1
XFILLER_134_1498 VDD VDD VSS VSS gf180mcu_as_sc_mcu7t3v3__fillcap_16
XFILLER_47_44 VDD VDD VSS VSS gf180mcu_as_sc_mcu7t3v3__fill_2
XPHY_EDGE_ROW_122_1_Right_121 VDD VSS gf180mcu_as_sc_mcu7t3v3__tap_2
XFILLER_170_34 VDD VDD VSS VSS gf180mcu_as_sc_mcu7t3v3__fill_1
XFILLER_47_88 VDD VDD VSS VSS gf180mcu_as_sc_mcu7t3v3__fillcap_4
XTAP_TAPCELL_ROW_22_3_2383 VDD VSS gf180mcu_as_sc_mcu7t3v3__tap_2
XFILLER_103_72 VDD VDD VSS VSS gf180mcu_as_sc_mcu7t3v3__fillcap_16
XFILLER_63_10 VDD VDD VSS VSS gf180mcu_as_sc_mcu7t3v3__fill_1
XFILLER_63_32 VDD VDD VSS VSS gf180mcu_as_sc_mcu7t3v3__fillcap_4
XFILLER_63_65 VDD VDD VSS VSS gf180mcu_as_sc_mcu7t3v3__fillcap_4
XTAP_TAPCELL_ROW_110_3_2515 VDD VSS gf180mcu_as_sc_mcu7t3v3__tap_2
XFILLER_180_1430 VDD VDD VSS VSS gf180mcu_as_sc_mcu7t3v3__fill_1
XFILLER_19_1553 VDD VDD VSS VSS gf180mcu_as_sc_mcu7t3v3__fillcap_16
XFILLER_106_1534 VDD VDD VSS VSS gf180mcu_as_sc_mcu7t3v3__fillcap_16
XFILLER_168_451 VDD VDD VSS VSS gf180mcu_as_sc_mcu7t3v3__fillcap_4
XFILLER_169_963 VDD VDD VSS VSS gf180mcu_as_sc_mcu7t3v3__fillcap_4
XFILLER_106_1556 VDD VDD VSS VSS gf180mcu_as_sc_mcu7t3v3__fillcap_8
XFILLER_156_635 VDD VDD VSS VSS gf180mcu_as_sc_mcu7t3v3__fill_2
XFILLER_183_454 VDD VDD VSS VSS gf180mcu_as_sc_mcu7t3v3__fillcap_16
XFILLER_184_988 VDD VDD VSS VSS gf180mcu_as_sc_mcu7t3v3__fillcap_8
XFILLER_171_616 VDD VDD VSS VSS gf180mcu_as_sc_mcu7t3v3__fillcap_8
XFILLER_6_155 VDD VDD VSS VSS gf180mcu_as_sc_mcu7t3v3__fillcap_16
XFILLER_6_177 VDD VDD VSS VSS gf180mcu_as_sc_mcu7t3v3__fillcap_16
XFILLER_128_80 VDD VDD VSS VSS gf180mcu_as_sc_mcu7t3v3__fillcap_8
XFILLER_139_1332 VDD VDD VSS VSS gf180mcu_as_sc_mcu7t3v3__fillcap_16
XFILLER_174_1223 VDD VDD VSS VSS gf180mcu_as_sc_mcu7t3v3__fill_2
XFILLER_178_1381 VDD VDD VSS VSS gf180mcu_as_sc_mcu7t3v3__fill_1
XFILLER_178_1392 VDD VDD VSS VSS gf180mcu_as_sc_mcu7t3v3__fill_2
XFILLER_135_1218 VDD VDD VSS VSS gf180mcu_as_sc_mcu7t3v3__fillcap_8
XFILLER_174_1267 VDD VDD VSS VSS gf180mcu_as_sc_mcu7t3v3__fill_2
XFILLER_40_8 VDD VDD VSS VSS gf180mcu_as_sc_mcu7t3v3__fill_2
XFILLER_111_204 VDD VDD VSS VSS gf180mcu_as_sc_mcu7t3v3__fillcap_4
XFILLER_170_1109 VDD VDD VSS VSS gf180mcu_as_sc_mcu7t3v3__fillcap_4
XFILLER_26_1502 VDD VDD VSS VSS gf180mcu_as_sc_mcu7t3v3__fillcap_16
XFILLER_26_1568 VDD VDD VSS VSS gf180mcu_as_sc_mcu7t3v3__fill_1
XPHY_EDGE_ROW_132_3_Right_451 VDD VSS gf180mcu_as_sc_mcu7t3v3__tap_2
XFILLER_168_1049 VDD VDD VSS VSS gf180mcu_as_sc_mcu7t3v3__fillcap_4
XFILLER_18_295 VDD VDD VSS VSS gf180mcu_as_sc_mcu7t3v3__fillcap_4
XFILLER_181_1216 VDD VDD VSS VSS gf180mcu_as_sc_mcu7t3v3__fill_1
X_4821_ VDD VDD VSS VSS _5052_/CLK _4821_/D _4821_/Q gf180mcu_as_sc_mcu7t3v3__dfxtp_2
XFILLER_33_276 VDD VDD VSS VSS gf180mcu_as_sc_mcu7t3v3__fillcap_4
XFILLER_33_298 VDD VDD VSS VSS gf180mcu_as_sc_mcu7t3v3__fill_2
X_4752_ VDD VDD VSS VSS _4753_/A _4752_/B _4752_/C _5094_/D gf180mcu_as_sc_mcu7t3v3__nor3_2
XFILLER_144_1082 VDD VDD VSS VSS gf180mcu_as_sc_mcu7t3v3__fill_2
XFILLER_146_101 VDD VDD VSS VSS gf180mcu_as_sc_mcu7t3v3__fillcap_4
X_4683_ VDD VDD VSS VSS _4686_/B _4731_/B _4684_/A _4703_/D gf180mcu_as_sc_mcu7t3v3__aoi21b_2
X_3703_ VDD VDD VSS VSS _4933_/Q _3762_/B _3747_/B _4080_/D _3704_/D gf180mcu_as_sc_mcu7t3v3__ao22_2
XFILLER_146_156 VDD VDD VSS VSS gf180mcu_as_sc_mcu7t3v3__fillcap_16
XFILLER_175_988 VDD VDD VSS VSS gf180mcu_as_sc_mcu7t3v3__fillcap_16
X_3634_ VDD VDD VSS VSS _3638_/B _3634_/C _3750_/B _4008_/A gf180mcu_as_sc_mcu7t3v3__aoi21_2
XFILLER_161_104 VDD VDD VSS VSS gf180mcu_as_sc_mcu7t3v3__fillcap_16
XFILLER_143_830 VDD VDD VSS VSS gf180mcu_as_sc_mcu7t3v3__fillcap_8
XFILLER_179_1189 VDD VDD VSS VSS gf180mcu_as_sc_mcu7t3v3__fill_1
X_3565_ VDD VDD VSS VSS _3778_/B _3933_/D _3568_/C gf180mcu_as_sc_mcu7t3v3__and2_2
X_3496_ VDD VDD VSS VSS _4154_/D _3502_/B _3504_/B _4154_/A _3497_/D gf180mcu_as_sc_mcu7t3v3__ao22_2
X_2516_ VDD VDD VSS VSS _4749_/A _2517_/B _2517_/C _2766_/B _2517_/D gf180mcu_as_sc_mcu7t3v3__aoi31_2
XFILLER_102_226 VDD VDD VSS VSS gf180mcu_as_sc_mcu7t3v3__fillcap_4
XFILLER_142_384 VDD VDD VSS VSS gf180mcu_as_sc_mcu7t3v3__fill_1
XFILLER_153_1318 VDD VDD VSS VSS gf180mcu_as_sc_mcu7t3v3__fillcap_8
X_5235_ VDD VDD VSS VSS clkload4/A _5235_/D _5235_/Q gf180mcu_as_sc_mcu7t3v3__dfxtp_2
X_2447_ VDD VDD VSS VSS _4141_/A _3483_/A gf180mcu_as_sc_mcu7t3v3__inv_2
XTAP_TAPCELL_ROW_184_2323 VDD VSS gf180mcu_as_sc_mcu7t3v3__tap_2
XTAP_TAPCELL_ROW_184_2312 VDD VSS gf180mcu_as_sc_mcu7t3v3__tap_2
XTAP_TAPCELL_ROW_184_2301 VDD VSS gf180mcu_as_sc_mcu7t3v3__tap_2
XTAP_TAPCELL_ROW_184_2334 VDD VSS gf180mcu_as_sc_mcu7t3v3__tap_2
XFILLER_68_151 VDD VDD VSS VSS gf180mcu_as_sc_mcu7t3v3__fill_1
X_5166_ VDD VDD VSS VSS _5188_/CLK _5166_/D _5166_/Q gf180mcu_as_sc_mcu7t3v3__dfxtp_2
XTAP_TAPCELL_ROW_180_2209 VDD VSS gf180mcu_as_sc_mcu7t3v3__tap_2
XFILLER_68_184 VDD VDD VSS VSS gf180mcu_as_sc_mcu7t3v3__fillcap_8
X_5097_ VDD VDD VSS VSS clkload4/A _5097_/D _5097_/Q gf180mcu_as_sc_mcu7t3v3__dfxtp_2
X_4117_ VDD VDD VSS VSS _5000_/Q _4117_/B _4251_/B _4125_/D _5000_/D gf180mcu_as_sc_mcu7t3v3__ao22_2
X_4048_ VDD VDD VSS VSS _4048_/A _4127_/B _4126_/B _4048_/D _4049_/D gf180mcu_as_sc_mcu7t3v3__ao22_2
XFILLER_140_37 VDD VDD VSS VSS gf180mcu_as_sc_mcu7t3v3__fill_1
XPHY_EDGE_ROW_56_1_Left_508 VDD VSS gf180mcu_as_sc_mcu7t3v3__tap_2
XTAP_TAPCELL_ROW_143_1396 VDD VSS gf180mcu_as_sc_mcu7t3v3__tap_2
XFILLER_164_1469 VDD VDD VSS VSS gf180mcu_as_sc_mcu7t3v3__fillcap_16
XFILLER_77_1499 VDD VDD VSS VSS gf180mcu_as_sc_mcu7t3v3__fillcap_16
XFILLER_138_624 VDD VDD VSS VSS gf180mcu_as_sc_mcu7t3v3__fillcap_8
XFILLER_166_944 VDD VDD VSS VSS gf180mcu_as_sc_mcu7t3v3__fill_1
XFILLER_137_134 VDD VDD VSS VSS gf180mcu_as_sc_mcu7t3v3__fillcap_4
XFILLER_166_955 VDD VDD VSS VSS gf180mcu_as_sc_mcu7t3v3__fillcap_4
XFILLER_14_1483 VDD VDD VSS VSS gf180mcu_as_sc_mcu7t3v3__fill_1
XFILLER_165_498 VDD VDD VSS VSS gf180mcu_as_sc_mcu7t3v3__fill_1
XFILLER_134_852 VDD VDD VSS VSS gf180mcu_as_sc_mcu7t3v3__fillcap_4
XFILLER_165_34 VDD VDD VSS VSS gf180mcu_as_sc_mcu7t3v3__fillcap_16
XFILLER_180_435 VDD VDD VSS VSS gf180mcu_as_sc_mcu7t3v3__fillcap_16
XFILLER_180_457 VDD VDD VSS VSS gf180mcu_as_sc_mcu7t3v3__fillcap_16
XFILLER_3_136 VDD VDD VSS VSS gf180mcu_as_sc_mcu7t3v3__fillcap_4
XFILLER_3_158 VDD VDD VSS VSS gf180mcu_as_sc_mcu7t3v3__fillcap_16
XFILLER_171_1418 VDD VDD VSS VSS gf180mcu_as_sc_mcu7t3v3__fillcap_16
XFILLER_58_10 VDD VDD VSS VSS gf180mcu_as_sc_mcu7t3v3__fill_1
XTAP_TAPCELL_ROW_119_1_1113 VDD VSS gf180mcu_as_sc_mcu7t3v3__tap_2
XFILLER_181_88 VDD VDD VSS VSS gf180mcu_as_sc_mcu7t3v3__fillcap_16
XFILLER_1_1515 VDD VDD VSS VSS gf180mcu_as_sc_mcu7t3v3__fillcap_4
XPHY_EDGE_ROW_123_1_Right_122 VDD VSS gf180mcu_as_sc_mcu7t3v3__tap_2
XFILLER_1_1537 VDD VDD VSS VSS gf180mcu_as_sc_mcu7t3v3__fillcap_16
XFILLER_74_187 VDD VDD VSS VSS gf180mcu_as_sc_mcu7t3v3__fillcap_16
XTAP_TAPCELL_ROW_128_3_2542 VDD VSS gf180mcu_as_sc_mcu7t3v3__tap_2
XFILLER_15_276 VDD VDD VSS VSS gf180mcu_as_sc_mcu7t3v3__fillcap_4
XFILLER_15_298 VDD VDD VSS VSS gf180mcu_as_sc_mcu7t3v3__fill_2
XFILLER_90_41 VDD VDD VSS VSS gf180mcu_as_sc_mcu7t3v3__fill_2
XFILLER_30_279 VDD VDD VSS VSS gf180mcu_as_sc_mcu7t3v3__fillcap_16
XFILLER_156_432 VDD VDD VSS VSS gf180mcu_as_sc_mcu7t3v3__fillcap_4
XFILLER_157_977 VDD VDD VSS VSS gf180mcu_as_sc_mcu7t3v3__fill_2
XFILLER_184_752 VDD VDD VSS VSS gf180mcu_as_sc_mcu7t3v3__fill_1
XFILLER_32_1550 VDD VDD VSS VSS gf180mcu_as_sc_mcu7t3v3__fillcap_4
XFILLER_141_1299 VDD VDD VSS VSS gf180mcu_as_sc_mcu7t3v3__fillcap_16
XFILLER_156_465 VDD VDD VSS VSS gf180mcu_as_sc_mcu7t3v3__fillcap_4
XFILLER_172_947 VDD VDD VSS VSS gf180mcu_as_sc_mcu7t3v3__fill_2
XTAP_TAPCELL_ROW_8_3_2361 VDD VSS gf180mcu_as_sc_mcu7t3v3__tap_2
XFILLER_99_72 VDD VDD VSS VSS gf180mcu_as_sc_mcu7t3v3__fill_1
XFILLER_99_94 VDD VDD VSS VSS gf180mcu_as_sc_mcu7t3v3__fill_1
X_3350_ VDD VDD VSS VSS _3998_/A _3453_/B _3453_/C _4001_/A _3351_/C gf180mcu_as_sc_mcu7t3v3__ao22_2
XFILLER_140_844 VDD VDD VSS VSS gf180mcu_as_sc_mcu7t3v3__fillcap_4
XFILLER_174_1053 VDD VDD VSS VSS gf180mcu_as_sc_mcu7t3v3__fillcap_4
XFILLER_97_202 VDD VDD VSS VSS gf180mcu_as_sc_mcu7t3v3__fillcap_8
XFILLER_135_1037 VDD VDD VSS VSS gf180mcu_as_sc_mcu7t3v3__fill_1
XFILLER_140_877 VDD VDD VSS VSS gf180mcu_as_sc_mcu7t3v3__fillcap_16
X_5020_ VDD VDD VSS VSS _5085_/CLK _5020_/D _5020_/Q gf180mcu_as_sc_mcu7t3v3__dfxtp_2
X_3281_ VDD VDD VSS VSS _3286_/B _3281_/B _3922_/A gf180mcu_as_sc_mcu7t3v3__nand2_2
XFILLER_152_1362 VDD VDD VSS VSS gf180mcu_as_sc_mcu7t3v3__fill_2
XTAP_TAPCELL_ROW_47_1_824 VDD VSS gf180mcu_as_sc_mcu7t3v3__tap_2
XFILLER_17_2 VDD VDD VSS VSS gf180mcu_as_sc_mcu7t3v3__fillcap_16
XFILLER_65_110 VDD VDD VSS VSS gf180mcu_as_sc_mcu7t3v3__fillcap_4
XFILLER_65_121 VDD VDD VSS VSS gf180mcu_as_sc_mcu7t3v3__fillcap_16
XPHY_EDGE_ROW_133_3_Right_452 VDD VSS gf180mcu_as_sc_mcu7t3v3__tap_2
X_4804_ VDD VDD VSS VSS _4869_/CLK _4804_/D _4804_/Q gf180mcu_as_sc_mcu7t3v3__dfxtp_2
XTAP_TAPCELL_ROW_177_2160 VDD VSS gf180mcu_as_sc_mcu7t3v3__tap_2
XFILLER_148_922 VDD VDD VSS VSS gf180mcu_as_sc_mcu7t3v3__fillcap_16
XFILLER_148_944 VDD VDD VSS VSS gf180mcu_as_sc_mcu7t3v3__fill_1
XFILLER_37_1483 VDD VDD VSS VSS gf180mcu_as_sc_mcu7t3v3__fillcap_16
X_4735_ VDD VDD VSS VSS _5269_/D _4735_/B _4736_/B gf180mcu_as_sc_mcu7t3v3__nor2_2
X_2996_ VDD VDD VSS VSS _3977_/A _3130_/B _2996_/C _2996_/D _2997_/C gf180mcu_as_sc_mcu7t3v3__ao22_2
XFILLER_124_1486 VDD VDD VSS VSS gf180mcu_as_sc_mcu7t3v3__fillcap_16
XTAP_TAPCELL_ROW_173_2068 VDD VSS gf180mcu_as_sc_mcu7t3v3__tap_2
XTAP_TAPCELL_ROW_173_2057 VDD VSS gf180mcu_as_sc_mcu7t3v3__tap_2
XTAP_TAPCELL_ROW_125_1_1134 VDD VSS gf180mcu_as_sc_mcu7t3v3__tap_2
XFILLER_135_616 VDD VDD VSS VSS gf180mcu_as_sc_mcu7t3v3__fillcap_8
XFILLER_147_487 VDD VDD VSS VSS gf180mcu_as_sc_mcu7t3v3__fill_2
XFILLER_148_988 VDD VDD VSS VSS gf180mcu_as_sc_mcu7t3v3__fillcap_16
X_4666_ VDD VDD VSS VSS _4666_/B _4749_/B _4681_/C gf180mcu_as_sc_mcu7t3v3__and2_2
XFILLER_159_1538 VDD VDD VSS VSS gf180mcu_as_sc_mcu7t3v3__fill_2
XFILLER_174_295 VDD VDD VSS VSS gf180mcu_as_sc_mcu7t3v3__fillcap_16
Xclkbuf_leaf_3_clk_regs VDD VDD VSS VSS clkbuf_3_1_0_clk_regs/Y _5199_/CLK gf180mcu_as_sc_mcu7t3v3__clkbuff_12
X_4597_ VDD VDD VSS VSS _5191_/Q _4750_/D _4600_/C _5192_/Q _5191_/D gf180mcu_as_sc_mcu7t3v3__ao22_2
X_3617_ VDD VDD VSS VSS _3791_/B _3992_/D _3621_/C gf180mcu_as_sc_mcu7t3v3__and2_2
XTAP_TAPCELL_ROW_58_3_2437 VDD VSS gf180mcu_as_sc_mcu7t3v3__tap_2
XFILLER_162_457 VDD VDD VSS VSS gf180mcu_as_sc_mcu7t3v3__fillcap_16
X_3548_ VDD VDD VSS VSS _3780_/A _3548_/A _3811_/B gf180mcu_as_sc_mcu7t3v3__and2_2
XFILLER_157_1262 VDD VDD VSS VSS gf180mcu_as_sc_mcu7t3v3__fillcap_8
XFILLER_171_991 VDD VDD VSS VSS gf180mcu_as_sc_mcu7t3v3__fillcap_8
XFILLER_153_1126 VDD VDD VSS VSS gf180mcu_as_sc_mcu7t3v3__fill_1
X_3479_ VDD VDD VSS VSS _4940_/Q _3493_/B _3501_/C _4138_/A _3480_/D gf180mcu_as_sc_mcu7t3v3__ao22_2
XTAP_TAPCELL_ROW_105_1_1054 VDD VSS gf180mcu_as_sc_mcu7t3v3__tap_2
X_5218_ VDD VDD VSS VSS clkload2/A _5218_/D _5218_/Q gf180mcu_as_sc_mcu7t3v3__dfxtp_2
XFILLER_170_1473 VDD VDD VSS VSS gf180mcu_as_sc_mcu7t3v3__fillcap_16
X_5149_ VDD VDD VSS VSS clkload9/A _5149_/D _5149_/Q gf180mcu_as_sc_mcu7t3v3__dfxtp_2
XTAP_TAPCELL_ROW_145_1447 VDD VSS gf180mcu_as_sc_mcu7t3v3__tap_2
XTAP_TAPCELL_ROW_145_1436 VDD VSS gf180mcu_as_sc_mcu7t3v3__tap_2
XFILLER_71_102 VDD VDD VSS VSS gf180mcu_as_sc_mcu7t3v3__fillcap_4
XFILLER_44_34 VDD VDD VSS VSS gf180mcu_as_sc_mcu7t3v3__fill_1
XFILLER_158_708 VDD VDD VSS VSS gf180mcu_as_sc_mcu7t3v3__fill_1
XFILLER_12_279 VDD VDD VSS VSS gf180mcu_as_sc_mcu7t3v3__fillcap_16
XFILLER_138_410 VDD VDD VSS VSS gf180mcu_as_sc_mcu7t3v3__fill_2
XFILLER_16_1534 VDD VDD VSS VSS gf180mcu_as_sc_mcu7t3v3__fillcap_16
XFILLER_100_95 VDD VDD VSS VSS gf180mcu_as_sc_mcu7t3v3__fillcap_8
XFILLER_103_1515 VDD VDD VSS VSS gf180mcu_as_sc_mcu7t3v3__fillcap_4
XFILLER_16_1556 VDD VDD VSS VSS gf180mcu_as_sc_mcu7t3v3__fillcap_8
XFILLER_103_1537 VDD VDD VSS VSS gf180mcu_as_sc_mcu7t3v3__fillcap_16
XFILLER_121_2 VDD VDD VSS VSS gf180mcu_as_sc_mcu7t3v3__fillcap_8
XFILLER_138_465 VDD VDD VSS VSS gf180mcu_as_sc_mcu7t3v3__fill_2
XFILLER_153_402 VDD VDD VSS VSS gf180mcu_as_sc_mcu7t3v3__fillcap_8
XFILLER_60_88 VDD VDD VSS VSS gf180mcu_as_sc_mcu7t3v3__fillcap_4
XFILLER_154_947 VDD VDD VSS VSS gf180mcu_as_sc_mcu7t3v3__fill_2
XFILLER_158_1037 VDD VDD VSS VSS gf180mcu_as_sc_mcu7t3v3__fillcap_16
XTAP_TAPCELL_ROW_93_3_2489 VDD VSS gf180mcu_as_sc_mcu7t3v3__tap_2
XFILLER_181_788 VDD VDD VSS VSS gf180mcu_as_sc_mcu7t3v3__fill_2
XFILLER_134_682 VDD VDD VSS VSS gf180mcu_as_sc_mcu7t3v3__fillcap_16
XFILLER_136_1313 VDD VDD VSS VSS gf180mcu_as_sc_mcu7t3v3__fillcap_16
XFILLER_140_107 VDD VDD VSS VSS gf180mcu_as_sc_mcu7t3v3__fillcap_4
XFILLER_175_1373 VDD VDD VSS VSS gf180mcu_as_sc_mcu7t3v3__fillcap_4
XTAP_TAPCELL_ROW_87_1_984 VDD VSS gf180mcu_as_sc_mcu7t3v3__tap_2
XTAP_TAPCELL_ROW_10_3_2365 VDD VSS gf180mcu_as_sc_mcu7t3v3__tap_2
XFILLER_79_257 VDD VDD VSS VSS gf180mcu_as_sc_mcu7t3v3__fillcap_4
XFILLER_171_1259 VDD VDD VSS VSS gf180mcu_as_sc_mcu7t3v3__fill_1
XFILLER_79_279 VDD VDD VSS VSS gf180mcu_as_sc_mcu7t3v3__fill_1
XFILLER_169_1144 VDD VDD VSS VSS gf180mcu_as_sc_mcu7t3v3__fillcap_16
XPHY_EDGE_ROW_124_1_Right_123 VDD VSS gf180mcu_as_sc_mcu7t3v3__tap_2
XFILLER_169_1188 VDD VDD VSS VSS gf180mcu_as_sc_mcu7t3v3__fill_2
XFILLER_147_1453 VDD VDD VSS VSS gf180mcu_as_sc_mcu7t3v3__fillcap_4
XFILLER_143_1317 VDD VDD VSS VSS gf180mcu_as_sc_mcu7t3v3__fillcap_8
X_2850_ VDD VDD VSS VSS _3869_/B _2851_/B gf180mcu_as_sc_mcu7t3v3__inv_2
XFILLER_176_527 VDD VDD VSS VSS gf180mcu_as_sc_mcu7t3v3__fillcap_4
XFILLER_141_1052 VDD VDD VSS VSS gf180mcu_as_sc_mcu7t3v3__fillcap_4
X_2781_ VDD VDD VSS VSS _2781_/D _2783_/A _2781_/B _4734_/B _2786_/D gf180mcu_as_sc_mcu7t3v3__ao31_2
XFILLER_116_104 VDD VDD VSS VSS gf180mcu_as_sc_mcu7t3v3__fill_1
XFILLER_141_1085 VDD VDD VSS VSS gf180mcu_as_sc_mcu7t3v3__fill_1
XFILLER_157_796 VDD VDD VSS VSS gf180mcu_as_sc_mcu7t3v3__fill_1
X_4520_ VDD VDD VSS VSS _4520_/D _4520_/A _4520_/B _4520_/C _4521_/B gf180mcu_as_sc_mcu7t3v3__ao31_2
XFILLER_144_424 VDD VDD VSS VSS gf180mcu_as_sc_mcu7t3v3__fillcap_4
XFILLER_145_947 VDD VDD VSS VSS gf180mcu_as_sc_mcu7t3v3__fill_2
XFILLER_156_295 VDD VDD VSS VSS gf180mcu_as_sc_mcu7t3v3__fillcap_8
X_4451_ VDD VDD VSS VSS _5172_/Q _4565_/B _4451_/C _4451_/D _5172_/D gf180mcu_as_sc_mcu7t3v3__ao211_2
XFILLER_144_457 VDD VDD VSS VSS gf180mcu_as_sc_mcu7t3v3__fillcap_16
XFILLER_172_788 VDD VDD VSS VSS gf180mcu_as_sc_mcu7t3v3__fill_2
X_3402_ VDD VDD VSS VSS _4930_/Q _3440_/B _3440_/C _4054_/A _3403_/A gf180mcu_as_sc_mcu7t3v3__ao22_2
XPHY_EDGE_ROW_95_3_Left_229 VDD VSS gf180mcu_as_sc_mcu7t3v3__tap_2
XFILLER_171_276 VDD VDD VSS VSS gf180mcu_as_sc_mcu7t3v3__fillcap_4
XFILLER_171_298 VDD VDD VSS VSS gf180mcu_as_sc_mcu7t3v3__fillcap_16
X_4382_ VDD VDD VSS VSS _4385_/C _4978_/Q _4403_/S gf180mcu_as_sc_mcu7t3v3__nand2b_2
Xfanout708 VDD VDD VSS VSS _3137_/B _3121_/B gf180mcu_as_sc_mcu7t3v3__buff_2
Xfanout719 VDD VDD VSS VSS _4720_/A _4688_/B gf180mcu_as_sc_mcu7t3v3__buff_2
X_3333_ VDD VDD VSS VSS _3984_/A _3453_/B _3453_/C _3985_/A _3334_/C gf180mcu_as_sc_mcu7t3v3__ao22_2
XFILLER_105_18 VDD VDD VSS VSS gf180mcu_as_sc_mcu7t3v3__fillcap_4
XFILLER_154_1479 VDD VDD VSS VSS gf180mcu_as_sc_mcu7t3v3__fillcap_4
X_3264_ VDD VDD VSS VSS _3807_/A _3530_/A _3265_/B gf180mcu_as_sc_mcu7t3v3__and2_2
X_5003_ VDD VDD VSS VSS _5185_/CLK _5003_/D _5003_/Q gf180mcu_as_sc_mcu7t3v3__dfxtp_2
X_3195_ VDD VDD VSS VSS _3195_/B _3795_/A _4799_/D gf180mcu_as_sc_mcu7t3v3__and2_2
XTAP_TAPCELL_ROW_29_1_753 VDD VSS gf180mcu_as_sc_mcu7t3v3__tap_2
XFILLER_93_282 VDD VDD VSS VSS gf180mcu_as_sc_mcu7t3v3__fillcap_16
XFILLER_165_1520 VDD VDD VSS VSS gf180mcu_as_sc_mcu7t3v3__fillcap_16
XFILLER_183_1108 VDD VDD VSS VSS gf180mcu_as_sc_mcu7t3v3__fill_1
XFILLER_183_1119 VDD VDD VSS VSS gf180mcu_as_sc_mcu7t3v3__fill_1
XFILLER_78_1550 VDD VDD VSS VSS gf180mcu_as_sc_mcu7t3v3__fillcap_4
XTAP_TAPCELL_ROW_179_2200 VDD VSS gf180mcu_as_sc_mcu7t3v3__tap_2
XFILLER_165_1542 VDD VDD VSS VSS gf180mcu_as_sc_mcu7t3v3__fillcap_16
XTAP_TAPCELL_ROW_140_1344 VDD VSS gf180mcu_as_sc_mcu7t3v3__tap_2
XTAP_TAPCELL_ROW_140_1333 VDD VSS gf180mcu_as_sc_mcu7t3v3__tap_2
XFILLER_161_1417 VDD VDD VSS VSS gf180mcu_as_sc_mcu7t3v3__fillcap_16
XTAP_TAPCELL_ROW_175_2108 VDD VSS gf180mcu_as_sc_mcu7t3v3__tap_2
XFILLER_14_37 VDD VDD VSS VSS gf180mcu_as_sc_mcu7t3v3__fillcap_16
X_2979_ VDD VDD VSS VSS _3961_/A _3241_/B _2979_/C _2979_/D _2980_/C gf180mcu_as_sc_mcu7t3v3__ao22_2
XFILLER_135_402 VDD VDD VSS VSS gf180mcu_as_sc_mcu7t3v3__fillcap_8
XFILLER_147_251 VDD VDD VSS VSS gf180mcu_as_sc_mcu7t3v3__fill_1
X_4718_ VDD VDD VSS VSS _4721_/A _4718_/B _5478_/A _5261_/D gf180mcu_as_sc_mcu7t3v3__mux2_2
XFILLER_107_137 VDD VDD VSS VSS gf180mcu_as_sc_mcu7t3v3__fill_2
XFILLER_136_947 VDD VDD VSS VSS gf180mcu_as_sc_mcu7t3v3__fill_2
XFILLER_146_14 VDD VDD VSS VSS gf180mcu_as_sc_mcu7t3v3__fill_1
XFILLER_159_1313 VDD VDD VSS VSS gf180mcu_as_sc_mcu7t3v3__fillcap_16
XFILLER_163_733 VDD VDD VSS VSS gf180mcu_as_sc_mcu7t3v3__fill_1
X_4649_ VDD VDD VSS VSS _4659_/B _4649_/A _4649_/B _4649_/C gf180mcu_as_sc_mcu7t3v3__ao21_2
XTAP_TAPCELL_ROW_138_1295 VDD VSS gf180mcu_as_sc_mcu7t3v3__tap_2
XTAP_TAPCELL_ROW_138_1284 VDD VSS gf180mcu_as_sc_mcu7t3v3__tap_2
XFILLER_151_906 VDD VDD VSS VSS gf180mcu_as_sc_mcu7t3v3__fillcap_4
XFILLER_30_69 VDD VDD VSS VSS gf180mcu_as_sc_mcu7t3v3__fillcap_16
XFILLER_85_1521 VDD VDD VSS VSS gf180mcu_as_sc_mcu7t3v3__fillcap_16
XFILLER_122_107 VDD VDD VSS VSS gf180mcu_as_sc_mcu7t3v3__fillcap_16
XFILLER_144_991 VDD VDD VSS VSS gf180mcu_as_sc_mcu7t3v3__fillcap_16
XFILLER_146_69 VDD VDD VSS VSS gf180mcu_as_sc_mcu7t3v3__fillcap_16
XFILLER_150_427 VDD VDD VSS VSS gf180mcu_as_sc_mcu7t3v3__fill_2
XFILLER_130_151 VDD VDD VSS VSS gf180mcu_as_sc_mcu7t3v3__fillcap_8
XFILLER_130_173 VDD VDD VSS VSS gf180mcu_as_sc_mcu7t3v3__fill_2
XFILLER_130_195 VDD VDD VSS VSS gf180mcu_as_sc_mcu7t3v3__fillcap_4
XFILLER_29_132 VDD VDD VSS VSS gf180mcu_as_sc_mcu7t3v3__fillcap_8
XFILLER_29_154 VDD VDD VSS VSS gf180mcu_as_sc_mcu7t3v3__fillcap_16
XTAP_TAPCELL_ROW_164_1867 VDD VSS gf180mcu_as_sc_mcu7t3v3__tap_2
XTAP_TAPCELL_ROW_164_1856 VDD VSS gf180mcu_as_sc_mcu7t3v3__tap_2
XFILLER_169_2 VDD VDD VSS VSS gf180mcu_as_sc_mcu7t3v3__fillcap_16
XFILLER_55_55 VDD VDD VSS VSS gf180mcu_as_sc_mcu7t3v3__fill_2
XFILLER_55_88 VDD VDD VSS VSS gf180mcu_as_sc_mcu7t3v3__fillcap_4
XFILLER_71_65 VDD VDD VSS VSS gf180mcu_as_sc_mcu7t3v3__fillcap_4
XFILLER_173_519 VDD VDD VSS VSS gf180mcu_as_sc_mcu7t3v3__fill_1
XFILLER_139_796 VDD VDD VSS VSS gf180mcu_as_sc_mcu7t3v3__fillcap_4
XFILLER_154_733 VDD VDD VSS VSS gf180mcu_as_sc_mcu7t3v3__fill_2
XFILLER_177_1402 VDD VDD VSS VSS gf180mcu_as_sc_mcu7t3v3__fill_2
XFILLER_154_777 VDD VDD VSS VSS gf180mcu_as_sc_mcu7t3v3__fillcap_8
XFILLER_177_1468 VDD VDD VSS VSS gf180mcu_as_sc_mcu7t3v3__fill_2
XTAP_TAPCELL_ROW_28_3_2392 VDD VSS gf180mcu_as_sc_mcu7t3v3__tap_2
XFILLER_135_991 VDD VDD VSS VSS gf180mcu_as_sc_mcu7t3v3__fillcap_8
XFILLER_141_438 VDD VDD VSS VSS gf180mcu_as_sc_mcu7t3v3__fillcap_8
XFILLER_153_298 VDD VDD VSS VSS gf180mcu_as_sc_mcu7t3v3__fillcap_8
XFILLER_154_799 VDD VDD VSS VSS gf180mcu_as_sc_mcu7t3v3__fillcap_4
XFILLER_171_1001 VDD VDD VSS VSS gf180mcu_as_sc_mcu7t3v3__fill_1
XFILLER_175_1192 VDD VDD VSS VSS gf180mcu_as_sc_mcu7t3v3__fill_2
XFILLER_136_1154 VDD VDD VSS VSS gf180mcu_as_sc_mcu7t3v3__fill_1
XFILLER_171_1045 VDD VDD VSS VSS gf180mcu_as_sc_mcu7t3v3__fillcap_4
XFILLER_7_1521 VDD VDD VSS VSS gf180mcu_as_sc_mcu7t3v3__fillcap_16
XFILLER_171_1067 VDD VDD VSS VSS gf180mcu_as_sc_mcu7t3v3__fillcap_4
XTAP_TAPCELL_ROW_116_3_2524 VDD VSS gf180mcu_as_sc_mcu7t3v3__tap_2
XFILLER_75_282 VDD VDD VSS VSS gf180mcu_as_sc_mcu7t3v3__fillcap_16
XTAP_TAPCELL_ROW_17_1_702 VDD VSS gf180mcu_as_sc_mcu7t3v3__tap_2
XFILLER_90_241 VDD VDD VSS VSS gf180mcu_as_sc_mcu7t3v3__fillcap_4
XPHY_EDGE_ROW_125_1_Right_124 VDD VSS gf180mcu_as_sc_mcu7t3v3__tap_2
X_3951_ VDD VDD VSS VSS _3951_/A _4159_/B _3951_/C _3951_/D _3952_/C gf180mcu_as_sc_mcu7t3v3__ao211_2
XFILLER_182_1152 VDD VDD VSS VSS gf180mcu_as_sc_mcu7t3v3__fill_2
X_2902_ VDD VDD VSS VSS _3199_/B _3542_/A _2902_/Y gf180mcu_as_sc_mcu7t3v3__and2_2
XFILLER_143_1114 VDD VDD VSS VSS gf180mcu_as_sc_mcu7t3v3__fillcap_4
X_3882_ VDD VDD VSS VSS _3905_/B _5172_/Q _4922_/D gf180mcu_as_sc_mcu7t3v3__and2_2
XFILLER_84_2 VDD VDD VSS VSS gf180mcu_as_sc_mcu7t3v3__fillcap_8
X_2833_ VDD VDD VSS VSS _5485_/A _2833_/A _4751_/B gf180mcu_as_sc_mcu7t3v3__and2_2
XFILLER_129_251 VDD VDD VSS VSS gf180mcu_as_sc_mcu7t3v3__fill_2
XFILLER_34_1486 VDD VDD VSS VSS gf180mcu_as_sc_mcu7t3v3__fillcap_16
X_2764_ VDD VDD VSS VSS _2764_/B _2764_/A _2842_/A gf180mcu_as_sc_mcu7t3v3__xnor2_2
XTAP_TAPCELL_ROW_170_2005 VDD VSS gf180mcu_as_sc_mcu7t3v3__tap_2
XFILLER_121_1467 VDD VDD VSS VSS gf180mcu_as_sc_mcu7t3v3__fillcap_16
XFILLER_129_295 VDD VDD VSS VSS gf180mcu_as_sc_mcu7t3v3__fillcap_4
X_4503_ VDD VDD VSS VSS _4504_/D _4503_/B _4547_/A gf180mcu_as_sc_mcu7t3v3__nor2_2
XFILLER_172_541 VDD VDD VSS VSS gf180mcu_as_sc_mcu7t3v3__fillcap_8
X_5483_ VDD VDD VSS VSS _5483_/A _5483_/Y gf180mcu_as_sc_mcu7t3v3__buff_2
X_2695_ VDD VDD VSS VSS _2695_/A _4968_/Q _2727_/S _2695_/D _2701_/B gf180mcu_as_sc_mcu7t3v3__ao211_2
XFILLER_104_107 VDD VDD VSS VSS gf180mcu_as_sc_mcu7t3v3__fillcap_4
XFILLER_144_287 VDD VDD VSS VSS gf180mcu_as_sc_mcu7t3v3__fillcap_16
XFILLER_145_788 VDD VDD VSS VSS gf180mcu_as_sc_mcu7t3v3__fillcap_8
X_4434_ VDD VDD VSS VSS _5172_/Q _4566_/B _4505_/C _5122_/Q _4435_/B gf180mcu_as_sc_mcu7t3v3__ao22_2
XFILLER_154_1221 VDD VDD VSS VSS gf180mcu_as_sc_mcu7t3v3__fillcap_4
Xfanout505 VDD VDD VSS VSS _3556_/Y fanout505/Y gf180mcu_as_sc_mcu7t3v3__buff_2
X_4365_ VDD VDD VSS VSS _4366_/A _4365_/B _4365_/A gf180mcu_as_sc_mcu7t3v3__nand2_2
XPHY_EDGE_ROW_65_1_Left_517 VDD VSS gf180mcu_as_sc_mcu7t3v3__tap_2
Xfanout516 VDD VDD VSS VSS _4338_/Y _4505_/C gf180mcu_as_sc_mcu7t3v3__buff_2
Xfanout527 VDD VDD VSS VSS _3927_/Y fanout527/Y gf180mcu_as_sc_mcu7t3v3__buff_2
Xfanout538 VDD VDD VSS VSS _3825_/Y _4252_/S gf180mcu_as_sc_mcu7t3v3__buff_2
X_3316_ VDD VDD VSS VSS _3474_/B _3965_/A _3316_/A _3318_/B gf180mcu_as_sc_mcu7t3v3__mux2_2
XFILLER_112_173 VDD VDD VSS VSS gf180mcu_as_sc_mcu7t3v3__fill_2
XFILLER_154_1287 VDD VDD VSS VSS gf180mcu_as_sc_mcu7t3v3__fillcap_8
XFILLER_80_1451 VDD VDD VSS VSS gf180mcu_as_sc_mcu7t3v3__fillcap_16
Xfanout549 VDD VDD VSS VSS fanout553/Y _3504_/B gf180mcu_as_sc_mcu7t3v3__buff_2
Xmesh_tile_920 VDD VDD VSS VSS nw_out[27] gf180mcu_as_sc_mcu7t3v3__tiel_4
X_4296_ VDD VDD VSS VSS _4297_/A _5127_/Q _4329_/A _4328_/B gf180mcu_as_sc_mcu7t3v3__ao21_2
XFILLER_132_1552 VDD VDD VSS VSS gf180mcu_as_sc_mcu7t3v3__fill_2
Xmesh_tile_953 VDD VDD VSS VSS sw_out[26] gf180mcu_as_sc_mcu7t3v3__tiel_4
Xmesh_tile_942 VDD VDD VSS VSS sw_out[15] gf180mcu_as_sc_mcu7t3v3__tiel_4
Xmesh_tile_931 VDD VDD VSS VSS sw_out[4] gf180mcu_as_sc_mcu7t3v3__tiel_4
X_3247_ VDD VDD VSS VSS _3247_/B _3542_/A _3519_/C gf180mcu_as_sc_mcu7t3v3__or2_2
X_3178_ VDD VDD VSS VSS _3178_/A _3178_/B _3178_/C _3178_/D _3180_/C gf180mcu_as_sc_mcu7t3v3__ao211_2
XFILLER_148_1014 VDD VDD VSS VSS gf180mcu_as_sc_mcu7t3v3__fill_1
XFILLER_148_1025 VDD VDD VSS VSS gf180mcu_as_sc_mcu7t3v3__fillcap_4
XFILLER_81_252 VDD VDD VSS VSS gf180mcu_as_sc_mcu7t3v3__fill_1
XTAP_TAPCELL_ROW_78_1_948 VDD VSS gf180mcu_as_sc_mcu7t3v3__tap_2
XFILLER_148_1069 VDD VDD VSS VSS gf180mcu_as_sc_mcu7t3v3__fill_1
XFILLER_41_138 VDD VDD VSS VSS gf180mcu_as_sc_mcu7t3v3__fill_2
XFILLER_168_847 VDD VDD VSS VSS gf180mcu_as_sc_mcu7t3v3__fill_2
XTAP_TAPCELL_ROW_46_3_2419 VDD VSS gf180mcu_as_sc_mcu7t3v3__tap_2
XPHY_EDGE_ROW_89_1_Right_88 VDD VSS gf180mcu_as_sc_mcu7t3v3__tap_2
XFILLER_161_1258 VDD VDD VSS VSS gf180mcu_as_sc_mcu7t3v3__fill_2
XFILLER_167_346 VDD VDD VSS VSS gf180mcu_as_sc_mcu7t3v3__fillcap_4
XFILLER_168_858 VDD VDD VSS VSS gf180mcu_as_sc_mcu7t3v3__fill_1
XFILLER_13_1515 VDD VDD VSS VSS gf180mcu_as_sc_mcu7t3v3__fillcap_4
XFILLER_157_24 VDD VDD VSS VSS gf180mcu_as_sc_mcu7t3v3__fillcap_8
XFILLER_167_368 VDD VDD VSS VSS gf180mcu_as_sc_mcu7t3v3__fillcap_16
XFILLER_183_828 VDD VDD VSS VSS gf180mcu_as_sc_mcu7t3v3__fillcap_8
XFILLER_41_24 VDD VDD VSS VSS gf180mcu_as_sc_mcu7t3v3__fillcap_16
XFILLER_52_1564 VDD VDD VSS VSS gf180mcu_as_sc_mcu7t3v3__fillcap_4
XPHY_EDGE_ROW_172_Right_306 VDD VSS gf180mcu_as_sc_mcu7t3v3__tap_2
XFILLER_100_1518 VDD VDD VSS VSS gf180mcu_as_sc_mcu7t3v3__fillcap_16
XFILLER_13_1537 VDD VDD VSS VSS gf180mcu_as_sc_mcu7t3v3__fillcap_16
XFILLER_176_891 VDD VDD VSS VSS gf180mcu_as_sc_mcu7t3v3__fillcap_4
XFILLER_182_349 VDD VDD VSS VSS gf180mcu_as_sc_mcu7t3v3__fillcap_16
XFILLER_136_777 VDD VDD VSS VSS gf180mcu_as_sc_mcu7t3v3__fillcap_8
XFILLER_163_541 VDD VDD VSS VSS gf180mcu_as_sc_mcu7t3v3__fillcap_16
XFILLER_155_1018 VDD VDD VSS VSS gf180mcu_as_sc_mcu7t3v3__fillcap_16
XFILLER_163_574 VDD VDD VSS VSS gf180mcu_as_sc_mcu7t3v3__fill_1
XFILLER_151_769 VDD VDD VSS VSS gf180mcu_as_sc_mcu7t3v3__fill_1
XFILLER_159_1198 VDD VDD VSS VSS gf180mcu_as_sc_mcu7t3v3__fill_1
XFILLER_172_1321 VDD VDD VSS VSS gf180mcu_as_sc_mcu7t3v3__fill_2
XFILLER_1_212 VDD VDD VSS VSS gf180mcu_as_sc_mcu7t3v3__fill_1
XFILLER_137_1463 VDD VDD VSS VSS gf180mcu_as_sc_mcu7t3v3__fillcap_4
XFILLER_172_1343 VDD VDD VSS VSS gf180mcu_as_sc_mcu7t3v3__fillcap_16
XTAP_TAPCELL_ROW_166_1907 VDD VSS gf180mcu_as_sc_mcu7t3v3__tap_2
XFILLER_106_50 VDD VDD VSS VSS gf180mcu_as_sc_mcu7t3v3__fillcap_16
XFILLER_2_18 VDD VDD VSS VSS gf180mcu_as_sc_mcu7t3v3__fillcap_16
XTAP_TAPCELL_ROW_166_1918 VDD VSS gf180mcu_as_sc_mcu7t3v3__tap_2
XFILLER_103_195 VDD VDD VSS VSS gf180mcu_as_sc_mcu7t3v3__fillcap_8
XFILLER_49_249 VDD VDD VSS VSS gf180mcu_as_sc_mcu7t3v3__fill_2
XTAP_TAPCELL_ROW_57_1_862 VDD VSS gf180mcu_as_sc_mcu7t3v3__tap_2
XTAP_TAPCELL_ROW_2_3_2353 VDD VSS gf180mcu_as_sc_mcu7t3v3__tap_2
XFILLER_166_1103 VDD VDD VSS VSS gf180mcu_as_sc_mcu7t3v3__fillcap_4
XFILLER_57_282 VDD VDD VSS VSS gf180mcu_as_sc_mcu7t3v3__fillcap_16
XFILLER_166_1136 VDD VDD VSS VSS gf180mcu_as_sc_mcu7t3v3__fillcap_4
XFILLER_109_1521 VDD VDD VSS VSS gf180mcu_as_sc_mcu7t3v3__fillcap_16
XFILLER_144_1434 VDD VDD VSS VSS gf180mcu_as_sc_mcu7t3v3__fill_1
XFILLER_158_302 VDD VDD VSS VSS gf180mcu_as_sc_mcu7t3v3__fillcap_4
XFILLER_183_1472 VDD VDD VSS VSS gf180mcu_as_sc_mcu7t3v3__fillcap_8
XFILLER_25_190 VDD VDD VSS VSS gf180mcu_as_sc_mcu7t3v3__fillcap_16
XFILLER_146_508 VDD VDD VSS VSS gf180mcu_as_sc_mcu7t3v3__fillcap_16
XFILLER_40_193 VDD VDD VSS VSS gf180mcu_as_sc_mcu7t3v3__fillcap_16
X_4895__972 VDD VDD VSS VSS _4895_/D gf180mcu_as_sc_mcu7t3v3__tiel_4
XFILLER_177_1210 VDD VDD VSS VSS gf180mcu_as_sc_mcu7t3v3__fillcap_4
XFILLER_154_563 VDD VDD VSS VSS gf180mcu_as_sc_mcu7t3v3__fillcap_8
XPHY_EDGE_ROW_107_3_Left_241 VDD VSS gf180mcu_as_sc_mcu7t3v3__tap_2
XFILLER_138_1205 VDD VDD VSS VSS gf180mcu_as_sc_mcu7t3v3__fillcap_16
XFILLER_138_1227 VDD VDD VSS VSS gf180mcu_as_sc_mcu7t3v3__fillcap_16
XFILLER_182_894 VDD VDD VSS VSS gf180mcu_as_sc_mcu7t3v3__fill_1
X_2480_ VDD VDD VSS VSS _5274_/Q _5275_/Q _2482_/B gf180mcu_as_sc_mcu7t3v3__or2_2
XPHY_EDGE_ROW_8_1_Right_7 VDD VSS gf180mcu_as_sc_mcu7t3v3__tap_2
XFILLER_142_747 VDD VDD VSS VSS gf180mcu_as_sc_mcu7t3v3__fill_1
XFILLER_141_279 VDD VDD VSS VSS gf180mcu_as_sc_mcu7t3v3__fill_1
X_4150_ VDD VDD VSS VSS _5004_/Q _4166_/B _4255_/B _4166_/D _5004_/D gf180mcu_as_sc_mcu7t3v3__ao22_2
XFILLER_95_300 VDD VDD VSS VSS gf180mcu_as_sc_mcu7t3v3__fill_1
X_3101_ VDD VDD VSS VSS _3179_/B _4933_/Q _3104_/C gf180mcu_as_sc_mcu7t3v3__or2_2
XTAP_TAPCELL_ROW_118_1_1109 VDD VSS gf180mcu_as_sc_mcu7t3v3__tap_2
X_4081_ VDD VDD VSS VSS _4081_/A _4131_/B _4081_/C _4081_/D _4082_/B gf180mcu_as_sc_mcu7t3v3__ao211_2
Xinput190 VDD VDD VSS VSS se_in[18] _4081_/A gf180mcu_as_sc_mcu7t3v3__buff_2
X_3032_ VDD VDD VSS VSS _4780_/D _3032_/C _3156_/A _3639_/A gf180mcu_as_sc_mcu7t3v3__aoi21_2
XFILLER_23_138 VDD VDD VSS VSS gf180mcu_as_sc_mcu7t3v3__fill_2
XFILLER_75_1553 VDD VDD VSS VSS gf180mcu_as_sc_mcu7t3v3__fillcap_16
XPHY_EDGE_ROW_126_1_Right_125 VDD VSS gf180mcu_as_sc_mcu7t3v3__tap_2
X_4983_ VDD VDD VSS VSS _5084_/CLK _4983_/D _4983_/Q gf180mcu_as_sc_mcu7t3v3__dfxtp_2
XFILLER_162_1523 VDD VDD VSS VSS gf180mcu_as_sc_mcu7t3v3__fillcap_16
X_3934_ VDD VDD VSS VSS _3934_/A _4163_/B _3934_/C _3934_/D _3935_/B gf180mcu_as_sc_mcu7t3v3__ao211_2
X_3865_ VDD VDD VSS VSS _5136_/Q _5135_/Q _3866_/C gf180mcu_as_sc_mcu7t3v3__or2_2
XTAP_TAPCELL_ROW_74_1_932 VDD VSS gf180mcu_as_sc_mcu7t3v3__tap_2
XFILLER_137_508 VDD VDD VSS VSS gf180mcu_as_sc_mcu7t3v3__fillcap_8
X_2816_ VDD VDD VSS VSS _4974_/D _2826_/B _4757_/Q _4756_/D gf180mcu_as_sc_mcu7t3v3__mux2_2
XPHY_EDGE_ROW_39_3_Left_173 VDD VSS gf180mcu_as_sc_mcu7t3v3__tap_2
X_3796_ VDD VDD VSS VSS _3796_/A _3796_/B _3796_/C _3796_/D _3797_/D gf180mcu_as_sc_mcu7t3v3__ao22_2
X_2747_ VDD VDD VSS VSS _2747_/B _2747_/A _2845_/A gf180mcu_as_sc_mcu7t3v3__and2_2
XTAP_TAPCELL_ROW_135_1232 VDD VSS gf180mcu_as_sc_mcu7t3v3__tap_2
XTAP_TAPCELL_ROW_135_1221 VDD VSS gf180mcu_as_sc_mcu7t3v3__tap_2
XFILLER_173_894 VDD VDD VSS VSS gf180mcu_as_sc_mcu7t3v3__fillcap_8
X_2678_ VDD VDD VSS VSS _4273_/S _2727_/S _4265_/B gf180mcu_as_sc_mcu7t3v3__and2_2
XFILLER_117_298 VDD VDD VSS VSS gf180mcu_as_sc_mcu7t3v3__fill_2
XFILLER_82_1502 VDD VDD VSS VSS gf180mcu_as_sc_mcu7t3v3__fillcap_16
X_4417_ VDD VDD VSS VSS _4418_/C _4568_/A _5011_/Q _4572_/A gf180mcu_as_sc_mcu7t3v3__ao21_2
XTAP_TAPCELL_ROW_152_1590 VDD VSS gf180mcu_as_sc_mcu7t3v3__tap_2
XFILLER_154_1040 VDD VDD VSS VSS gf180mcu_as_sc_mcu7t3v3__fillcap_16
XFILLER_154_1073 VDD VDD VSS VSS gf180mcu_as_sc_mcu7t3v3__fillcap_8
XFILLER_82_1568 VDD VDD VSS VSS gf180mcu_as_sc_mcu7t3v3__fill_1
XFILLER_98_171 VDD VDD VSS VSS gf180mcu_as_sc_mcu7t3v3__fillcap_4
X_4348_ VDD VDD VSS VSS _5158_/Q _5157_/Q _4349_/A gf180mcu_as_sc_mcu7t3v3__xnor2_2
XFILLER_100_143 VDD VDD VSS VSS gf180mcu_as_sc_mcu7t3v3__fill_2
X_4279_ VDD VDD VSS VSS _4281_/S _5483_/A _5113_/Q _5113_/D gf180mcu_as_sc_mcu7t3v3__mux2_2
XFILLER_100_154 VDD VDD VSS VSS gf180mcu_as_sc_mcu7t3v3__fill_1
XFILLER_39_260 VDD VDD VSS VSS gf180mcu_as_sc_mcu7t3v3__fillcap_16
XFILLER_39_282 VDD VDD VSS VSS gf180mcu_as_sc_mcu7t3v3__fillcap_16
XTAP_TAPCELL_ROW_161_1804 VDD VSS gf180mcu_as_sc_mcu7t3v3__tap_2
XFILLER_54_296 VDD VDD VSS VSS gf180mcu_as_sc_mcu7t3v3__fillcap_4
XTAP_TAPCELL_ROW_159_1755 VDD VSS gf180mcu_as_sc_mcu7t3v3__tap_2
XTAP_TAPCELL_ROW_159_1744 VDD VSS gf180mcu_as_sc_mcu7t3v3__tap_2
XFILLER_155_305 VDD VDD VSS VSS gf180mcu_as_sc_mcu7t3v3__fill_1
XFILLER_168_34 VDD VDD VSS VSS gf180mcu_as_sc_mcu7t3v3__fill_1
XFILLER_22_171 VDD VDD VSS VSS gf180mcu_as_sc_mcu7t3v3__fillcap_4
XFILLER_22_193 VDD VDD VSS VSS gf180mcu_as_sc_mcu7t3v3__fillcap_16
XFILLER_104_1451 VDD VDD VSS VSS gf180mcu_as_sc_mcu7t3v3__fillcap_16
XFILLER_156_839 VDD VDD VSS VSS gf180mcu_as_sc_mcu7t3v3__fillcap_8
XFILLER_108_243 VDD VDD VSS VSS gf180mcu_as_sc_mcu7t3v3__fill_2
XFILLER_182_146 VDD VDD VSS VSS gf180mcu_as_sc_mcu7t3v3__fill_2
XTAP_TAPCELL_ROW_16_1_701 VDD VSS gf180mcu_as_sc_mcu7t3v3__tap_2
XFILLER_136_574 VDD VDD VSS VSS gf180mcu_as_sc_mcu7t3v3__fill_1
XFILLER_164_894 VDD VDD VSS VSS gf180mcu_as_sc_mcu7t3v3__fill_1
XFILLER_123_279 VDD VDD VSS VSS gf180mcu_as_sc_mcu7t3v3__fill_1
XFILLER_77_300 VDD VDD VSS VSS gf180mcu_as_sc_mcu7t3v3__fill_1
XFILLER_89_171 VDD VDD VSS VSS gf180mcu_as_sc_mcu7t3v3__fillcap_16
XFILLER_4_1502 VDD VDD VSS VSS gf180mcu_as_sc_mcu7t3v3__fillcap_16
XFILLER_4_1568 VDD VDD VSS VSS gf180mcu_as_sc_mcu7t3v3__fill_1
XFILLER_59_1515 VDD VDD VSS VSS gf180mcu_as_sc_mcu7t3v3__fillcap_4
XFILLER_98_1564 VDD VDD VSS VSS gf180mcu_as_sc_mcu7t3v3__fillcap_4
XTAP_TAPCELL_ROW_39_1_791 VDD VSS gf180mcu_as_sc_mcu7t3v3__tap_2
XFILLER_59_1537 VDD VDD VSS VSS gf180mcu_as_sc_mcu7t3v3__fillcap_16
XFILLER_111_1499 VDD VDD VSS VSS gf180mcu_as_sc_mcu7t3v3__fillcap_16
XFILLER_146_1507 VDD VDD VSS VSS gf180mcu_as_sc_mcu7t3v3__fill_1
XFILLER_179_909 VDD VDD VSS VSS gf180mcu_as_sc_mcu7t3v3__fill_1
XTAP_TAPCELL_ROW_99_3_2498 VDD VSS gf180mcu_as_sc_mcu7t3v3__tap_2
XFILLER_178_419 VDD VDD VSS VSS gf180mcu_as_sc_mcu7t3v3__fillcap_16
XFILLER_60_255 VDD VDD VSS VSS gf180mcu_as_sc_mcu7t3v3__fillcap_4
XTAP_TAPCELL_ROW_16_3_2374 VDD VSS gf180mcu_as_sc_mcu7t3v3__tap_2
XFILLER_140_1106 VDD VDD VSS VSS gf180mcu_as_sc_mcu7t3v3__fill_2
XFILLER_144_1286 VDD VDD VSS VSS gf180mcu_as_sc_mcu7t3v3__fillcap_8
XFILLER_147_828 VDD VDD VSS VSS gf180mcu_as_sc_mcu7t3v3__fillcap_8
XFILLER_60_299 VDD VDD VSS VSS gf180mcu_as_sc_mcu7t3v3__fill_2
XFILLER_9_120 VDD VDD VSS VSS gf180mcu_as_sc_mcu7t3v3__fillcap_16
XFILLER_9_142 VDD VDD VSS VSS gf180mcu_as_sc_mcu7t3v3__fillcap_16
XFILLER_144_1297 VDD VDD VSS VSS gf180mcu_as_sc_mcu7t3v3__fillcap_16
XFILLER_174_625 VDD VDD VSS VSS gf180mcu_as_sc_mcu7t3v3__fill_2
XFILLER_70_1483 VDD VDD VSS VSS gf180mcu_as_sc_mcu7t3v3__fill_1
X_3650_ VDD VDD VSS VSS _4021_/D _3717_/B _3650_/C _3650_/D _3651_/C gf180mcu_as_sc_mcu7t3v3__ao211_2
XFILLER_31_1467 VDD VDD VSS VSS gf180mcu_as_sc_mcu7t3v3__fillcap_16
X_3581_ VDD VDD VSS VSS _4917_/Q _3799_/B _3770_/C _3950_/A _3583_/C gf180mcu_as_sc_mcu7t3v3__ao22_2
X_2601_ VDD VDD VSS VSS _2602_/B _4765_/Q _2653_/S _2601_/C _2601_/D gf180mcu_as_sc_mcu7t3v3__aoi22_2
XFILLER_177_1040 VDD VDD VSS VSS gf180mcu_as_sc_mcu7t3v3__fillcap_8
X_2532_ VDD VDD VSS VSS _4749_/A _2792_/A _2534_/C gf180mcu_as_sc_mcu7t3v3__or2_2
XTAP_TAPCELL_ROW_104_3_2506 VDD VSS gf180mcu_as_sc_mcu7t3v3__tap_2
XFILLER_138_1024 VDD VDD VSS VSS gf180mcu_as_sc_mcu7t3v3__fillcap_16
XFILLER_170_842 VDD VDD VSS VSS gf180mcu_as_sc_mcu7t3v3__fill_1
XFILLER_182_691 VDD VDD VSS VSS gf180mcu_as_sc_mcu7t3v3__fillcap_4
X_5251_ VDD VDD VSS VSS _5266_/CLK _5251_/D _5251_/Q gf180mcu_as_sc_mcu7t3v3__dfxtp_2
XFILLER_142_555 VDD VDD VSS VSS gf180mcu_as_sc_mcu7t3v3__fill_1
XFILLER_47_2 VDD VDD VSS VSS gf180mcu_as_sc_mcu7t3v3__fill_2
X_4202_ VDD VDD VSS VSS _4231_/B _4228_/B _4228_/C _5038_/Q _5038_/D gf180mcu_as_sc_mcu7t3v3__ao22_2
X_2463_ VDD VDD VSS VSS _2464_/C _4341_/S _5035_/Q _4448_/A gf180mcu_as_sc_mcu7t3v3__ao21_2
XFILLER_170_897 VDD VDD VSS VSS gf180mcu_as_sc_mcu7t3v3__fill_1
XFILLER_68_300 VDD VDD VSS VSS gf180mcu_as_sc_mcu7t3v3__fill_1
X_5182_ VDD VDD VSS VSS _5185_/CLK _5182_/D _5182_/Q gf180mcu_as_sc_mcu7t3v3__dfxtp_2
X_2394_ VDD VDD VSS VSS _2394_/Y _4753_/A gf180mcu_as_sc_mcu7t3v3__inv_2
XFILLER_151_1224 VDD VDD VSS VSS gf180mcu_as_sc_mcu7t3v3__fillcap_8
XFILLER_3_50 VDD VDD VSS VSS gf180mcu_as_sc_mcu7t3v3__fillcap_16
XFILLER_3_72 VDD VDD VSS VSS gf180mcu_as_sc_mcu7t3v3__fillcap_16
XFILLER_95_130 VDD VDD VSS VSS gf180mcu_as_sc_mcu7t3v3__fillcap_8
X_4133_ VDD VDD VSS VSS _4253_/B _4133_/B _4141_/D gf180mcu_as_sc_mcu7t3v3__nor2_2
XFILLER_95_152 VDD VDD VSS VSS gf180mcu_as_sc_mcu7t3v3__fillcap_16
X_4064_ VDD VDD VSS VSS _4064_/A _4104_/B _4104_/C _4064_/D _4065_/D gf180mcu_as_sc_mcu7t3v3__ao22_2
XTAP_TAPCELL_ROW_182_2262 VDD VSS gf180mcu_as_sc_mcu7t3v3__tap_2
XTAP_TAPCELL_ROW_182_2251 VDD VSS gf180mcu_as_sc_mcu7t3v3__tap_2
X_3015_ VDD VDD VSS VSS _3015_/B _3624_/A _4778_/D gf180mcu_as_sc_mcu7t3v3__and2_2
XFILLER_184_1000 VDD VDD VSS VSS gf180mcu_as_sc_mcu7t3v3__fill_2
XFILLER_36_241 VDD VDD VSS VSS gf180mcu_as_sc_mcu7t3v3__fillcap_4
XFILLER_145_1006 VDD VDD VSS VSS gf180mcu_as_sc_mcu7t3v3__fill_1
XFILLER_36_263 VDD VDD VSS VSS gf180mcu_as_sc_mcu7t3v3__fillcap_16
XFILLER_127_1451 VDD VDD VSS VSS gf180mcu_as_sc_mcu7t3v3__fillcap_16
XFILLER_178_942 VDD VDD VSS VSS gf180mcu_as_sc_mcu7t3v3__fill_2
XPHY_EDGE_ROW_127_1_Right_126 VDD VSS gf180mcu_as_sc_mcu7t3v3__tap_2
X_4966_ VDD VDD VSS VSS clkload9/A _4966_/D _4966_/Q gf180mcu_as_sc_mcu7t3v3__dfxtp_2
XFILLER_162_1375 VDD VDD VSS VSS gf180mcu_as_sc_mcu7t3v3__fill_2
X_4897_ VDD VDD VSS VSS _5159_/CLK _4897_/D _4897_/Q gf180mcu_as_sc_mcu7t3v3__dfxtp_2
X_3917_ VDD VDD VSS VSS _3931_/B _3917_/A _3923_/B gf180mcu_as_sc_mcu7t3v3__and2_2
XTAP_TAPCELL_ROW_48_1_826 VDD VSS gf180mcu_as_sc_mcu7t3v3__tap_2
XFILLER_22_37 VDD VDD VSS VSS gf180mcu_as_sc_mcu7t3v3__fillcap_16
X_3848_ VDD VDD VSS VSS _3848_/B _3907_/A _4913_/D gf180mcu_as_sc_mcu7t3v3__and2_2
XTAP_TAPCELL_ROW_56_1_861 VDD VSS gf180mcu_as_sc_mcu7t3v3__tap_2
XFILLER_138_37 VDD VDD VSS VSS gf180mcu_as_sc_mcu7t3v3__fillcap_16
X_3779_ VDD VDD VSS VSS _4159_/A _3779_/B _3779_/C _3779_/D _3781_/A gf180mcu_as_sc_mcu7t3v3__ao211_2
XTAP_TAPCELL_ROW_154_1641 VDD VSS gf180mcu_as_sc_mcu7t3v3__tap_2
XFILLER_105_202 VDD VDD VSS VSS gf180mcu_as_sc_mcu7t3v3__fill_2
XFILLER_10_1518 VDD VDD VSS VSS gf180mcu_as_sc_mcu7t3v3__fillcap_16
XFILLER_146_872 VDD VDD VSS VSS gf180mcu_as_sc_mcu7t3v3__fill_2
XFILLER_180_628 VDD VDD VSS VSS gf180mcu_as_sc_mcu7t3v3__fill_1
XTAP_TAPCELL_ROW_154_1652 VDD VSS gf180mcu_as_sc_mcu7t3v3__tap_2
XFILLER_161_842 VDD VDD VSS VSS gf180mcu_as_sc_mcu7t3v3__fill_2
XTAP_TAPCELL_ROW_150_1549 VDD VSS gf180mcu_as_sc_mcu7t3v3__tap_2
XFILLER_156_1157 VDD VDD VSS VSS gf180mcu_as_sc_mcu7t3v3__fillcap_16
XFILLER_161_875 VDD VDD VSS VSS gf180mcu_as_sc_mcu7t3v3__fill_2
Xoutput450 VDD VDD VSS VSS _4903_/Q west_out[30] gf180mcu_as_sc_mcu7t3v3__buff_2
XFILLER_105_279 VDD VDD VSS VSS gf180mcu_as_sc_mcu7t3v3__fill_1
XFILLER_59_300 VDD VDD VSS VSS gf180mcu_as_sc_mcu7t3v3__fill_1
XFILLER_120_238 VDD VDD VSS VSS gf180mcu_as_sc_mcu7t3v3__fillcap_4
XFILLER_134_1488 VDD VDD VSS VSS gf180mcu_as_sc_mcu7t3v3__fill_1
XFILLER_47_56 VDD VDD VSS VSS gf180mcu_as_sc_mcu7t3v3__fill_2
X_4885__982 VDD VDD VSS VSS _4885_/D gf180mcu_as_sc_mcu7t3v3__tiel_4
XFILLER_163_1106 VDD VDD VSS VSS gf180mcu_as_sc_mcu7t3v3__fill_2
XFILLER_19_1521 VDD VDD VSS VSS gf180mcu_as_sc_mcu7t3v3__fillcap_16
XFILLER_42_244 VDD VDD VSS VSS gf180mcu_as_sc_mcu7t3v3__fill_1
XFILLER_106_1502 VDD VDD VSS VSS gf180mcu_as_sc_mcu7t3v3__fillcap_16
XFILLER_169_942 VDD VDD VSS VSS gf180mcu_as_sc_mcu7t3v3__fillcap_4
XFILLER_179_66 VDD VDD VSS VSS gf180mcu_as_sc_mcu7t3v3__fillcap_4
XFILLER_180_1420 VDD VDD VSS VSS gf180mcu_as_sc_mcu7t3v3__fillcap_8
XFILLER_63_88 VDD VDD VSS VSS gf180mcu_as_sc_mcu7t3v3__fillcap_4
XFILLER_93_1483 VDD VDD VSS VSS gf180mcu_as_sc_mcu7t3v3__fillcap_16
XFILLER_141_1426 VDD VDD VSS VSS gf180mcu_as_sc_mcu7t3v3__fillcap_4
XFILLER_156_603 VDD VDD VSS VSS gf180mcu_as_sc_mcu7t3v3__fillcap_16
XFILLER_179_88 VDD VDD VSS VSS gf180mcu_as_sc_mcu7t3v3__fillcap_16
XFILLER_42_299 VDD VDD VSS VSS gf180mcu_as_sc_mcu7t3v3__fill_2
XFILLER_54_1467 VDD VDD VSS VSS gf180mcu_as_sc_mcu7t3v3__fillcap_16
XFILLER_106_1568 VDD VDD VSS VSS gf180mcu_as_sc_mcu7t3v3__fill_1
XFILLER_183_400 VDD VDD VSS VSS gf180mcu_as_sc_mcu7t3v3__fillcap_16
XFILLER_183_422 VDD VDD VSS VSS gf180mcu_as_sc_mcu7t3v3__fillcap_16
XFILLER_6_101 VDD VDD VSS VSS gf180mcu_as_sc_mcu7t3v3__fillcap_4
XFILLER_156_658 VDD VDD VSS VSS gf180mcu_as_sc_mcu7t3v3__fillcap_4
XFILLER_6_123 VDD VDD VSS VSS gf180mcu_as_sc_mcu7t3v3__fillcap_16
XFILLER_137_894 VDD VDD VSS VSS gf180mcu_as_sc_mcu7t3v3__fill_1
XFILLER_171_628 VDD VDD VSS VSS gf180mcu_as_sc_mcu7t3v3__fill_2
X_4892__975 VDD VDD VSS VSS _4892_/D gf180mcu_as_sc_mcu7t3v3__tiel_4
XFILLER_136_393 VDD VDD VSS VSS gf180mcu_as_sc_mcu7t3v3__fill_2
XFILLER_174_1213 VDD VDD VSS VSS gf180mcu_as_sc_mcu7t3v3__fillcap_4
Xclkbuf_leaf_27_clk_regs VDD VDD VSS VSS clkbuf_3_7_0_clk_regs/Y _5053_/CLK gf180mcu_as_sc_mcu7t3v3__clkbuff_12
XFILLER_151_352 VDD VDD VSS VSS gf180mcu_as_sc_mcu7t3v3__fillcap_16
XFILLER_163_190 VDD VDD VSS VSS gf180mcu_as_sc_mcu7t3v3__fillcap_16
XFILLER_88_52 VDD VDD VSS VSS gf180mcu_as_sc_mcu7t3v3__fill_1
XFILLER_151_374 VDD VDD VSS VSS gf180mcu_as_sc_mcu7t3v3__fill_1
XFILLER_152_1511 VDD VDD VSS VSS gf180mcu_as_sc_mcu7t3v3__fill_2
XFILLER_69_119 VDD VDD VSS VSS gf180mcu_as_sc_mcu7t3v3__fill_1
XFILLER_77_152 VDD VDD VSS VSS gf180mcu_as_sc_mcu7t3v3__fillcap_8
XFILLER_168_1017 VDD VDD VSS VSS gf180mcu_as_sc_mcu7t3v3__fillcap_16
XFILLER_18_241 VDD VDD VSS VSS gf180mcu_as_sc_mcu7t3v3__fillcap_4
XFILLER_18_263 VDD VDD VSS VSS gf180mcu_as_sc_mcu7t3v3__fillcap_8
XFILLER_92_177 VDD VDD VSS VSS gf180mcu_as_sc_mcu7t3v3__fillcap_16
XFILLER_33_244 VDD VDD VSS VSS gf180mcu_as_sc_mcu7t3v3__fillcap_16
X_4820_ VDD VDD VSS VSS _4858_/CLK _4820_/D _4820_/Q gf180mcu_as_sc_mcu7t3v3__dfxtp_2
XTAP_TAPCELL_ROW_88_1_986 VDD VSS gf180mcu_as_sc_mcu7t3v3__tap_2
XFILLER_72_1534 VDD VDD VSS VSS gf180mcu_as_sc_mcu7t3v3__fillcap_16
XPHY_EDGE_ROW_74_1_Left_526 VDD VSS gf180mcu_as_sc_mcu7t3v3__tap_2
XFILLER_175_901 VDD VDD VSS VSS gf180mcu_as_sc_mcu7t3v3__fill_2
XFILLER_175_912 VDD VDD VSS VSS gf180mcu_as_sc_mcu7t3v3__fill_1
XFILLER_72_1556 VDD VDD VSS VSS gf180mcu_as_sc_mcu7t3v3__fillcap_8
X_4751_ VDD VDD VSS VSS _4751_/B _4751_/A _5285_/D gf180mcu_as_sc_mcu7t3v3__and2_2
XFILLER_147_625 VDD VDD VSS VSS gf180mcu_as_sc_mcu7t3v3__fillcap_4
XFILLER_175_923 VDD VDD VSS VSS gf180mcu_as_sc_mcu7t3v3__fill_1
X_4682_ VDD VDD VSS VSS _5248_/D _5102_/Q _4731_/B _4682_/C gf180mcu_as_sc_mcu7t3v3__ao21_2
X_3702_ VDD VDD VSS VSS _3706_/B _3702_/C _3750_/B _4078_/A gf180mcu_as_sc_mcu7t3v3__aoi21_2
XFILLER_146_124 VDD VDD VSS VSS gf180mcu_as_sc_mcu7t3v3__fillcap_16
X_3633_ VDD VDD VSS VSS _3634_/C _4006_/A _3742_/B _3633_/C gf180mcu_as_sc_mcu7t3v3__ao21_2
XTAP_TAPCELL_ROW_44_1_810 VDD VSS gf180mcu_as_sc_mcu7t3v3__tap_2
XFILLER_134_308 VDD VDD VSS VSS gf180mcu_as_sc_mcu7t3v3__fillcap_16
XFILLER_162_628 VDD VDD VSS VSS gf180mcu_as_sc_mcu7t3v3__fill_1
XFILLER_108_18 VDD VDD VSS VSS gf180mcu_as_sc_mcu7t3v3__fillcap_16
XFILLER_143_842 VDD VDD VSS VSS gf180mcu_as_sc_mcu7t3v3__fillcap_4
X_3564_ VDD VDD VSS VSS _3564_/Y _3797_/C _3798_/A gf180mcu_as_sc_mcu7t3v3__nor2b_2
XFILLER_143_875 VDD VDD VSS VSS gf180mcu_as_sc_mcu7t3v3__fillcap_16
XFILLER_170_650 VDD VDD VSS VSS gf180mcu_as_sc_mcu7t3v3__fillcap_8
X_3495_ VDD VDD VSS VSS _4151_/A _3500_/B _3495_/C _3495_/D _3497_/C gf180mcu_as_sc_mcu7t3v3__ao211_2
X_2515_ VDD VDD VSS VSS _2517_/D _4749_/A _4663_/A _5240_/Q gf180mcu_as_sc_mcu7t3v3__aoi21_2
XFILLER_157_1488 VDD VDD VSS VSS gf180mcu_as_sc_mcu7t3v3__fill_2
X_5234_ VDD VDD VSS VSS clkload4/A _5234_/D _5234_/Q gf180mcu_as_sc_mcu7t3v3__dfxtp_2
X_2446_ VDD VDD VSS VSS _4132_/A _2446_/A gf180mcu_as_sc_mcu7t3v3__inv_2
XTAP_TAPCELL_ROW_184_2324 VDD VSS gf180mcu_as_sc_mcu7t3v3__tap_2
XTAP_TAPCELL_ROW_184_2313 VDD VSS gf180mcu_as_sc_mcu7t3v3__tap_2
XTAP_TAPCELL_ROW_184_2302 VDD VSS gf180mcu_as_sc_mcu7t3v3__tap_2
X_5165_ VDD VDD VSS VSS _5172_/CLK _5165_/D _5165_/Q gf180mcu_as_sc_mcu7t3v3__dfxtp_2
XTAP_TAPCELL_ROW_184_2335 VDD VSS gf180mcu_as_sc_mcu7t3v3__tap_2
XPHY_EDGE_ROW_98_1_Right_97 VDD VSS gf180mcu_as_sc_mcu7t3v3__tap_2
X_4116_ VDD VDD VSS VSS _4251_/B _4116_/B _4141_/D gf180mcu_as_sc_mcu7t3v3__nor2_2
XFILLER_68_196 VDD VDD VSS VSS gf180mcu_as_sc_mcu7t3v3__fill_2
XFILLER_83_111 VDD VDD VSS VSS gf180mcu_as_sc_mcu7t3v3__fillcap_4
XFILLER_83_122 VDD VDD VSS VSS gf180mcu_as_sc_mcu7t3v3__fillcap_4
X_5096_ VDD VDD VSS VSS clkload5/A _5096_/D _5096_/Q gf180mcu_as_sc_mcu7t3v3__dfxtp_2
XFILLER_140_16 VDD VDD VSS VSS gf180mcu_as_sc_mcu7t3v3__fillcap_16
XFILLER_83_166 VDD VDD VSS VSS gf180mcu_as_sc_mcu7t3v3__fillcap_4
X_4047_ VDD VDD VSS VSS _4047_/A _4128_/B _4047_/C _4047_/D _4049_/C gf180mcu_as_sc_mcu7t3v3__ao211_2
XFILLER_168_1562 VDD VDD VSS VSS gf180mcu_as_sc_mcu7t3v3__fill_1
XFILLER_164_1437 VDD VDD VSS VSS gf180mcu_as_sc_mcu7t3v3__fillcap_16
XFILLER_77_1467 VDD VDD VSS VSS gf180mcu_as_sc_mcu7t3v3__fillcap_16
XTAP_TAPCELL_ROW_143_1397 VDD VSS gf180mcu_as_sc_mcu7t3v3__tap_2
XFILLER_129_1568 VDD VDD VSS VSS gf180mcu_as_sc_mcu7t3v3__fill_1
XFILLER_24_299 VDD VDD VSS VSS gf180mcu_as_sc_mcu7t3v3__fill_2
XPHY_EDGE_ROW_128_1_Right_127 VDD VSS gf180mcu_as_sc_mcu7t3v3__tap_2
X_4949_ VDD VDD VSS VSS _5159_/CLK _4949_/D _4949_/Q gf180mcu_as_sc_mcu7t3v3__dfxtp_2
XFILLER_165_400 VDD VDD VSS VSS gf180mcu_as_sc_mcu7t3v3__fillcap_16
XFILLER_165_422 VDD VDD VSS VSS gf180mcu_as_sc_mcu7t3v3__fillcap_4
XFILLER_177_260 VDD VDD VSS VSS gf180mcu_as_sc_mcu7t3v3__fillcap_16
XFILLER_14_1451 VDD VDD VSS VSS gf180mcu_as_sc_mcu7t3v3__fillcap_16
XFILLER_165_455 VDD VDD VSS VSS gf180mcu_as_sc_mcu7t3v3__fillcap_8
XFILLER_177_282 VDD VDD VSS VSS gf180mcu_as_sc_mcu7t3v3__fillcap_16
XPHY_EDGE_ROW_61_3_Right_380 VDD VSS gf180mcu_as_sc_mcu7t3v3__tap_2
XFILLER_137_157 VDD VDD VSS VSS gf180mcu_as_sc_mcu7t3v3__fillcap_4
XFILLER_153_617 VDD VDD VSS VSS gf180mcu_as_sc_mcu7t3v3__fillcap_8
XFILLER_180_403 VDD VDD VSS VSS gf180mcu_as_sc_mcu7t3v3__fillcap_16
XFILLER_181_937 VDD VDD VSS VSS gf180mcu_as_sc_mcu7t3v3__fillcap_8
XFILLER_153_639 VDD VDD VSS VSS gf180mcu_as_sc_mcu7t3v3__fillcap_16
XFILLER_175_1511 VDD VDD VSS VSS gf180mcu_as_sc_mcu7t3v3__fillcap_16
XFILLER_3_104 VDD VDD VSS VSS gf180mcu_as_sc_mcu7t3v3__fillcap_16
XFILLER_134_886 VDD VDD VSS VSS gf180mcu_as_sc_mcu7t3v3__fillcap_8
XFILLER_160_171 VDD VDD VSS VSS gf180mcu_as_sc_mcu7t3v3__fillcap_4
XFILLER_161_694 VDD VDD VSS VSS gf180mcu_as_sc_mcu7t3v3__fillcap_4
XFILLER_160_193 VDD VDD VSS VSS gf180mcu_as_sc_mcu7t3v3__fillcap_16
XFILLER_181_34 VDD VDD VSS VSS gf180mcu_as_sc_mcu7t3v3__fillcap_4
XFILLER_58_88 VDD VDD VSS VSS gf180mcu_as_sc_mcu7t3v3__fillcap_4
XFILLER_101_282 VDD VDD VSS VSS gf180mcu_as_sc_mcu7t3v3__fillcap_16
XFILLER_112_1550 VDD VDD VSS VSS gf180mcu_as_sc_mcu7t3v3__fillcap_4
XFILLER_74_155 VDD VDD VSS VSS gf180mcu_as_sc_mcu7t3v3__fillcap_4
XFILLER_74_65 VDD VDD VSS VSS gf180mcu_as_sc_mcu7t3v3__fillcap_16
XPHY_EDGE_ROW_116_3_Left_250 VDD VSS gf180mcu_as_sc_mcu7t3v3__tap_2
XFILLER_15_244 VDD VDD VSS VSS gf180mcu_as_sc_mcu7t3v3__fillcap_16
XFILLER_182_1504 VDD VDD VSS VSS gf180mcu_as_sc_mcu7t3v3__fill_1
XFILLER_21_1499 VDD VDD VSS VSS gf180mcu_as_sc_mcu7t3v3__fillcap_16
XFILLER_56_1518 VDD VDD VSS VSS gf180mcu_as_sc_mcu7t3v3__fillcap_16
XFILLER_30_225 VDD VDD VSS VSS gf180mcu_as_sc_mcu7t3v3__fillcap_16
XTAP_TAPCELL_ROW_84_1_970 VDD VSS gf180mcu_as_sc_mcu7t3v3__tap_2
XFILLER_156_400 VDD VDD VSS VSS gf180mcu_as_sc_mcu7t3v3__fillcap_16
XFILLER_169_772 VDD VDD VSS VSS gf180mcu_as_sc_mcu7t3v3__fillcap_16
XFILLER_30_247 VDD VDD VSS VSS gf180mcu_as_sc_mcu7t3v3__fillcap_16
XFILLER_141_1256 VDD VDD VSS VSS gf180mcu_as_sc_mcu7t3v3__fillcap_4
XFILLER_184_731 VDD VDD VSS VSS gf180mcu_as_sc_mcu7t3v3__fillcap_4
XTAP_TAPCELL_ROW_8_3_2362 VDD VSS gf180mcu_as_sc_mcu7t3v3__tap_2
XFILLER_143_138 VDD VDD VSS VSS gf180mcu_as_sc_mcu7t3v3__fill_2
XFILLER_139_1185 VDD VDD VSS VSS gf180mcu_as_sc_mcu7t3v3__fillcap_4
X_3280_ VDD VDD VSS VSS _3280_/D _3553_/A _3280_/B _3814_/A _3526_/C gf180mcu_as_sc_mcu7t3v3__ao31_2
XFILLER_135_1049 VDD VDD VSS VSS gf180mcu_as_sc_mcu7t3v3__fill_1
XFILLER_2_170 VDD VDD VSS VSS gf180mcu_as_sc_mcu7t3v3__fillcap_4
XFILLER_117_1483 VDD VDD VSS VSS gf180mcu_as_sc_mcu7t3v3__fillcap_16
XFILLER_97_269 VDD VDD VSS VSS gf180mcu_as_sc_mcu7t3v3__fill_1
XTAP_TAPCELL_ROW_47_1_825 VDD VSS gf180mcu_as_sc_mcu7t3v3__tap_2
XPHY_EDGE_ROW_48_3_Left_182 VDD VSS gf180mcu_as_sc_mcu7t3v3__tap_2
XFILLER_80_103 VDD VDD VSS VSS gf180mcu_as_sc_mcu7t3v3__fill_2
XFILLER_146_1145 VDD VDD VSS VSS gf180mcu_as_sc_mcu7t3v3__fillcap_8
XFILLER_146_1189 VDD VDD VSS VSS gf180mcu_as_sc_mcu7t3v3__fillcap_16
XFILLER_37_1451 VDD VDD VSS VSS gf180mcu_as_sc_mcu7t3v3__fillcap_16
X_4803_ VDD VDD VSS VSS _4867_/CLK _4803_/D _4803_/Q gf180mcu_as_sc_mcu7t3v3__dfxtp_2
XTAP_TAPCELL_ROW_177_2161 VDD VSS gf180mcu_as_sc_mcu7t3v3__tap_2
XTAP_TAPCELL_ROW_177_2150 VDD VSS gf180mcu_as_sc_mcu7t3v3__tap_2
X_4734_ VDD VDD VSS VSS _4735_/B _4734_/B _4748_/A gf180mcu_as_sc_mcu7t3v3__nand2_2
X_2995_ VDD VDD VSS VSS _3121_/B _4920_/Q _2996_/D gf180mcu_as_sc_mcu7t3v3__or2_2
XFILLER_119_124 VDD VDD VSS VSS gf180mcu_as_sc_mcu7t3v3__fillcap_16
XFILLER_147_422 VDD VDD VSS VSS gf180mcu_as_sc_mcu7t3v3__fillcap_8
XFILLER_159_282 VDD VDD VSS VSS gf180mcu_as_sc_mcu7t3v3__fillcap_4
XFILLER_175_731 VDD VDD VSS VSS gf180mcu_as_sc_mcu7t3v3__fillcap_4
XFILLER_175_753 VDD VDD VSS VSS gf180mcu_as_sc_mcu7t3v3__fill_1
XTAP_TAPCELL_ROW_173_2069 VDD VSS gf180mcu_as_sc_mcu7t3v3__tap_2
XTAP_TAPCELL_ROW_173_2058 VDD VSS gf180mcu_as_sc_mcu7t3v3__tap_2
XFILLER_135_628 VDD VDD VSS VSS gf180mcu_as_sc_mcu7t3v3__fill_2
XFILLER_147_455 VDD VDD VSS VSS gf180mcu_as_sc_mcu7t3v3__fillcap_16
XFILLER_159_1506 VDD VDD VSS VSS gf180mcu_as_sc_mcu7t3v3__fillcap_16
XFILLER_163_926 VDD VDD VSS VSS gf180mcu_as_sc_mcu7t3v3__fillcap_16
XFILLER_174_241 VDD VDD VSS VSS gf180mcu_as_sc_mcu7t3v3__fillcap_4
XFILLER_174_263 VDD VDD VSS VSS gf180mcu_as_sc_mcu7t3v3__fillcap_16
X_4665_ VDD VDD VSS VSS _4686_/A _4685_/C gf180mcu_as_sc_mcu7t3v3__inv_2
XTAP_TAPCELL_ROW_125_1_1135 VDD VSS gf180mcu_as_sc_mcu7t3v3__tap_2
XFILLER_134_138 VDD VDD VSS VSS gf180mcu_as_sc_mcu7t3v3__fillcap_4
XFILLER_135_639 VDD VDD VSS VSS gf180mcu_as_sc_mcu7t3v3__fillcap_4
XFILLER_162_447 VDD VDD VSS VSS gf180mcu_as_sc_mcu7t3v3__fillcap_8
X_4875__992 VDD VDD VSS VSS _4875_/D gf180mcu_as_sc_mcu7t3v3__tiel_4
X_4596_ VDD VDD VSS VSS _5190_/Q _4750_/D _4600_/C _5191_/Q _5190_/D gf180mcu_as_sc_mcu7t3v3__ao22_2
X_3616_ VDD VDD VSS VSS _4845_/D _3616_/C _3746_/B _3616_/A gf180mcu_as_sc_mcu7t3v3__aoi21_2
X_3547_ VDD VDD VSS VSS _3786_/A _3798_/A _3562_/A gf180mcu_as_sc_mcu7t3v3__and2_2
XFILLER_157_1285 VDD VDD VSS VSS gf180mcu_as_sc_mcu7t3v3__fill_1
XFILLER_142_193 VDD VDD VSS VSS gf180mcu_as_sc_mcu7t3v3__fillcap_8
XFILLER_170_491 VDD VDD VSS VSS gf180mcu_as_sc_mcu7t3v3__fill_2
XFILLER_88_247 VDD VDD VSS VSS gf180mcu_as_sc_mcu7t3v3__fillcap_4
X_3478_ VDD VDD VSS VSS _4137_/A _3501_/B _3503_/B _4138_/D _3480_/C gf180mcu_as_sc_mcu7t3v3__ao22_2
XTAP_TAPCELL_ROW_105_1_1055 VDD VSS gf180mcu_as_sc_mcu7t3v3__tap_2
X_5217_ VDD VDD VSS VSS clkload0/A _5217_/D _5217_/Q gf180mcu_as_sc_mcu7t3v3__dfxtp_2
X_2429_ VDD VDD VSS VSS _3616_/A _3986_/A gf180mcu_as_sc_mcu7t3v3__inv_2
XTAP_TAPCELL_ROW_149_1540 VDD VSS gf180mcu_as_sc_mcu7t3v3__tap_2
X_5148_ VDD VDD VSS VSS clkload9/A _5148_/D _5148_/Q gf180mcu_as_sc_mcu7t3v3__dfxtp_2
XFILLER_151_48 VDD VDD VSS VSS gf180mcu_as_sc_mcu7t3v3__fillcap_16
XFILLER_28_69 VDD VDD VSS VSS gf180mcu_as_sc_mcu7t3v3__fillcap_16
X_5079_ VDD VDD VSS VSS _5183_/CLK _5079_/D _5079_/Q gf180mcu_as_sc_mcu7t3v3__dfxtp_2
XTAP_TAPCELL_ROW_145_1448 VDD VSS gf180mcu_as_sc_mcu7t3v3__tap_2
XTAP_TAPCELL_ROW_145_1437 VDD VSS gf180mcu_as_sc_mcu7t3v3__tap_2
XFILLER_56_177 VDD VDD VSS VSS gf180mcu_as_sc_mcu7t3v3__fillcap_16
XFILLER_44_24 VDD VDD VSS VSS gf180mcu_as_sc_mcu7t3v3__fillcap_8
X_4882__985 VDD VDD VSS VSS _4882_/D gf180mcu_as_sc_mcu7t3v3__tiel_4
XFILLER_164_1267 VDD VDD VSS VSS gf180mcu_as_sc_mcu7t3v3__fill_2
XFILLER_16_1502 VDD VDD VSS VSS gf180mcu_as_sc_mcu7t3v3__fillcap_16
XFILLER_12_247 VDD VDD VSS VSS gf180mcu_as_sc_mcu7t3v3__fillcap_16
XFILLER_164_1289 VDD VDD VSS VSS gf180mcu_as_sc_mcu7t3v3__fillcap_4
XFILLER_166_731 VDD VDD VSS VSS gf180mcu_as_sc_mcu7t3v3__fillcap_4
XFILLER_16_1568 VDD VDD VSS VSS gf180mcu_as_sc_mcu7t3v3__fill_1
XFILLER_60_23 VDD VDD VSS VSS gf180mcu_as_sc_mcu7t3v3__fillcap_8
XFILLER_90_1486 VDD VDD VSS VSS gf180mcu_as_sc_mcu7t3v3__fillcap_16
XPHY_EDGE_ROW_129_1_Right_128 VDD VSS gf180mcu_as_sc_mcu7t3v3__tap_2
XFILLER_139_978 VDD VDD VSS VSS gf180mcu_as_sc_mcu7t3v3__fill_2
XFILLER_176_34 VDD VDD VSS VSS gf180mcu_as_sc_mcu7t3v3__fill_1
XFILLER_114_2 VDD VDD VSS VSS gf180mcu_as_sc_mcu7t3v3__fillcap_8
XFILLER_125_138 VDD VDD VSS VSS gf180mcu_as_sc_mcu7t3v3__fill_2
XFILLER_181_723 VDD VDD VSS VSS gf180mcu_as_sc_mcu7t3v3__fillcap_8
XFILLER_5_18 VDD VDD VSS VSS gf180mcu_as_sc_mcu7t3v3__fillcap_16
XPHY_EDGE_ROW_62_3_Right_381 VDD VSS gf180mcu_as_sc_mcu7t3v3__tap_2
XFILLER_109_72 VDD VDD VSS VSS gf180mcu_as_sc_mcu7t3v3__fillcap_4
XFILLER_121_300 VDD VDD VSS VSS gf180mcu_as_sc_mcu7t3v3__fill_1
XFILLER_171_1205 VDD VDD VSS VSS gf180mcu_as_sc_mcu7t3v3__fillcap_8
XFILLER_69_65 VDD VDD VSS VSS gf180mcu_as_sc_mcu7t3v3__fillcap_4
XTAP_TAPCELL_ROW_87_1_985 VDD VSS gf180mcu_as_sc_mcu7t3v3__tap_2
XFILLER_134_1082 VDD VDD VSS VSS gf180mcu_as_sc_mcu7t3v3__fillcap_4
XFILLER_47_188 VDD VDD VSS VSS gf180mcu_as_sc_mcu7t3v3__fillcap_16
XFILLER_62_169 VDD VDD VSS VSS gf180mcu_as_sc_mcu7t3v3__fillcap_4
XFILLER_143_1329 VDD VDD VSS VSS gf180mcu_as_sc_mcu7t3v3__fill_1
XFILLER_149_709 VDD VDD VSS VSS gf180mcu_as_sc_mcu7t3v3__fillcap_16
XFILLER_182_1367 VDD VDD VSS VSS gf180mcu_as_sc_mcu7t3v3__fillcap_8
XFILLER_157_731 VDD VDD VSS VSS gf180mcu_as_sc_mcu7t3v3__fillcap_4
X_2780_ VDD VDD VSS VSS _2781_/D _2780_/B _2883_/B gf180mcu_as_sc_mcu7t3v3__nor2_2
XFILLER_116_116 VDD VDD VSS VSS gf180mcu_as_sc_mcu7t3v3__fill_1
XFILLER_172_723 VDD VDD VSS VSS gf180mcu_as_sc_mcu7t3v3__fillcap_8
X_4450_ VDD VDD VSS VSS _4451_/D _4450_/B _4547_/A gf180mcu_as_sc_mcu7t3v3__nor2_2
XFILLER_171_244 VDD VDD VSS VSS gf180mcu_as_sc_mcu7t3v3__fillcap_16
XFILLER_7_295 VDD VDD VSS VSS gf180mcu_as_sc_mcu7t3v3__fillcap_4
X_4381_ VDD VDD VSS VSS _4385_/B _5065_/Q _4403_/S gf180mcu_as_sc_mcu7t3v3__nand2_2
X_3401_ VDD VDD VSS VSS _3450_/B _4055_/A _3404_/C gf180mcu_as_sc_mcu7t3v3__and2_2
XFILLER_131_119 VDD VDD VSS VSS gf180mcu_as_sc_mcu7t3v3__fill_2
X_3332_ VDD VDD VSS VSS _3452_/S _3984_/D _3332_/A _3334_/B gf180mcu_as_sc_mcu7t3v3__mux2_2
XFILLER_67_1499 VDD VDD VSS VSS gf180mcu_as_sc_mcu7t3v3__fillcap_16
Xfanout709 VDD VDD VSS VSS _3168_/B _3137_/B gf180mcu_as_sc_mcu7t3v3__buff_2
X_3263_ VDD VDD VSS VSS _3263_/B _3263_/A _3275_/A gf180mcu_as_sc_mcu7t3v3__and2_2
X_5002_ VDD VDD VSS VSS _5094_/CLK _5002_/D _5002_/Q gf180mcu_as_sc_mcu7t3v3__dfxtp_2
X_3194_ VDD VDD VSS VSS _3194_/S _3194_/B _4164_/A _3195_/B gf180mcu_as_sc_mcu7t3v3__mux2_2
XFILLER_152_1182 VDD VDD VSS VSS gf180mcu_as_sc_mcu7t3v3__fill_2
XFILLER_38_155 VDD VDD VSS VSS gf180mcu_as_sc_mcu7t3v3__fillcap_16
XFILLER_38_177 VDD VDD VSS VSS gf180mcu_as_sc_mcu7t3v3__fillcap_16
XFILLER_53_103 VDD VDD VSS VSS gf180mcu_as_sc_mcu7t3v3__fillcap_4
XFILLER_148_1229 VDD VDD VSS VSS gf180mcu_as_sc_mcu7t3v3__fill_1
XPHY_EDGE_ROW_18_1_Left_470 VDD VSS gf180mcu_as_sc_mcu7t3v3__tap_2
XTAP_TAPCELL_ROW_179_2201 VDD VSS gf180mcu_as_sc_mcu7t3v3__tap_2
XTAP_TAPCELL_ROW_140_1345 VDD VSS gf180mcu_as_sc_mcu7t3v3__tap_2
XTAP_TAPCELL_ROW_140_1334 VDD VSS gf180mcu_as_sc_mcu7t3v3__tap_2
XTAP_TAPCELL_ROW_175_2109 VDD VSS gf180mcu_as_sc_mcu7t3v3__tap_2
XFILLER_139_208 VDD VDD VSS VSS gf180mcu_as_sc_mcu7t3v3__fill_2
XFILLER_148_753 VDD VDD VSS VSS gf180mcu_as_sc_mcu7t3v3__fill_2
X_2978_ VDD VDD VSS VSS _3137_/B _4918_/Q _2979_/D gf180mcu_as_sc_mcu7t3v3__or2_2
XFILLER_148_786 VDD VDD VSS VSS gf180mcu_as_sc_mcu7t3v3__fill_2
XFILLER_182_509 VDD VDD VSS VSS gf180mcu_as_sc_mcu7t3v3__fillcap_16
X_4717_ VDD VDD VSS VSS _4717_/S _5261_/Q _5251_/Q _4718_/B gf180mcu_as_sc_mcu7t3v3__mux2_2
XFILLER_163_723 VDD VDD VSS VSS gf180mcu_as_sc_mcu7t3v3__fillcap_8
XFILLER_30_37 VDD VDD VSS VSS gf180mcu_as_sc_mcu7t3v3__fillcap_16
X_4648_ VDD VDD VSS VSS _4649_/C _5234_/Q _5235_/Q _5235_/D gf180mcu_as_sc_mcu7t3v3__mux2_2
XTAP_TAPCELL_ROW_138_1296 VDD VSS gf180mcu_as_sc_mcu7t3v3__tap_2
XTAP_TAPCELL_ROW_138_1285 VDD VSS gf180mcu_as_sc_mcu7t3v3__tap_2
XFILLER_135_447 VDD VDD VSS VSS gf180mcu_as_sc_mcu7t3v3__fillcap_16
XFILLER_146_37 VDD VDD VSS VSS gf180mcu_as_sc_mcu7t3v3__fillcap_16
XFILLER_162_244 VDD VDD VSS VSS gf180mcu_as_sc_mcu7t3v3__fill_1
XFILLER_103_300 VDD VDD VSS VSS gf180mcu_as_sc_mcu7t3v3__fill_1
XFILLER_115_160 VDD VDD VSS VSS gf180mcu_as_sc_mcu7t3v3__fill_1
X_4579_ VDD VDD VSS VSS _4579_/S _5029_/Q _5058_/Q _4580_/B gf180mcu_as_sc_mcu7t3v3__mux2_2
XTAP_TAPCELL_ROW_75_1_934 VDD VSS gf180mcu_as_sc_mcu7t3v3__tap_2
XFILLER_39_35 VDD VDD VSS VSS gf180mcu_as_sc_mcu7t3v3__fill_2
XFILLER_135_1380 VDD VDD VSS VSS gf180mcu_as_sc_mcu7t3v3__fillcap_16
XFILLER_170_1271 VDD VDD VSS VSS gf180mcu_as_sc_mcu7t3v3__fill_1
XTAP_TAPCELL_ROW_168_1960 VDD VSS gf180mcu_as_sc_mcu7t3v3__tap_2
XFILLER_162_69 VDD VDD VSS VSS gf180mcu_as_sc_mcu7t3v3__fillcap_16
XFILLER_91_209 VDD VDD VSS VSS gf180mcu_as_sc_mcu7t3v3__fill_1
XFILLER_22_1550 VDD VDD VSS VSS gf180mcu_as_sc_mcu7t3v3__fillcap_4
XFILLER_55_23 VDD VDD VSS VSS gf180mcu_as_sc_mcu7t3v3__fillcap_16
XTAP_TAPCELL_ROW_164_1868 VDD VSS gf180mcu_as_sc_mcu7t3v3__tap_2
XTAP_TAPCELL_ROW_164_1857 VDD VSS gf180mcu_as_sc_mcu7t3v3__tap_2
XFILLER_166_1329 VDD VDD VSS VSS gf180mcu_as_sc_mcu7t3v3__fillcap_16
XFILLER_44_147 VDD VDD VSS VSS gf180mcu_as_sc_mcu7t3v3__fill_2
XFILLER_164_1053 VDD VDD VSS VSS gf180mcu_as_sc_mcu7t3v3__fillcap_8
XFILLER_71_88 VDD VDD VSS VSS gf180mcu_as_sc_mcu7t3v3__fillcap_4
XPHY_EDGE_ROW_50_1_Right_49 VDD VSS gf180mcu_as_sc_mcu7t3v3__tap_2
XFILLER_138_230 VDD VDD VSS VSS gf180mcu_as_sc_mcu7t3v3__fillcap_8
XFILLER_142_1362 VDD VDD VSS VSS gf180mcu_as_sc_mcu7t3v3__fill_2
XFILLER_166_561 VDD VDD VSS VSS gf180mcu_as_sc_mcu7t3v3__fillcap_8
XFILLER_166_594 VDD VDD VSS VSS gf180mcu_as_sc_mcu7t3v3__fill_1
XFILLER_153_244 VDD VDD VSS VSS gf180mcu_as_sc_mcu7t3v3__fillcap_8
XPHY_EDGE_ROW_63_3_Right_382 VDD VSS gf180mcu_as_sc_mcu7t3v3__tap_2
XFILLER_113_119 VDD VDD VSS VSS gf180mcu_as_sc_mcu7t3v3__fillcap_4
XFILLER_154_789 VDD VDD VSS VSS gf180mcu_as_sc_mcu7t3v3__fill_2
XFILLER_181_586 VDD VDD VSS VSS gf180mcu_as_sc_mcu7t3v3__fillcap_4
XFILLER_106_193 VDD VDD VSS VSS gf180mcu_as_sc_mcu7t3v3__fillcap_8
XFILLER_134_491 VDD VDD VSS VSS gf180mcu_as_sc_mcu7t3v3__fill_1
XFILLER_171_1013 VDD VDD VSS VSS gf180mcu_as_sc_mcu7t3v3__fillcap_16
XFILLER_136_1177 VDD VDD VSS VSS gf180mcu_as_sc_mcu7t3v3__fill_1
XFILLER_67_206 VDD VDD VSS VSS gf180mcu_as_sc_mcu7t3v3__fillcap_4
XFILLER_27_1483 VDD VDD VSS VSS gf180mcu_as_sc_mcu7t3v3__fillcap_16
XFILLER_67_239 VDD VDD VSS VSS gf180mcu_as_sc_mcu7t3v3__fillcap_8
XFILLER_96_96 VDD VDD VSS VSS gf180mcu_as_sc_mcu7t3v3__fillcap_8
XPHY_EDGE_ROW_83_1_Left_535 VDD VSS gf180mcu_as_sc_mcu7t3v3__tap_2
Xmesh_tile VDD VDD VSS VSS ne_out[0] gf180mcu_as_sc_mcu7t3v3__tiel_4
XFILLER_114_1486 VDD VDD VSS VSS gf180mcu_as_sc_mcu7t3v3__fillcap_16
XTAP_TAPCELL_ROW_17_1_703 VDD VSS gf180mcu_as_sc_mcu7t3v3__tap_2
XFILLER_149_1527 VDD VDD VSS VSS gf180mcu_as_sc_mcu7t3v3__fillcap_8
XFILLER_35_136 VDD VDD VSS VSS gf180mcu_as_sc_mcu7t3v3__fillcap_4
XFILLER_90_220 VDD VDD VSS VSS gf180mcu_as_sc_mcu7t3v3__fillcap_4
XFILLER_35_158 VDD VDD VSS VSS gf180mcu_as_sc_mcu7t3v3__fillcap_16
X_3950_ VDD VDD VSS VSS _3950_/A _4160_/C _4152_/C _4917_/Q _3951_/D gf180mcu_as_sc_mcu7t3v3__ao22_2
XFILLER_147_1262 VDD VDD VSS VSS gf180mcu_as_sc_mcu7t3v3__fillcap_8
XFILLER_50_139 VDD VDD VSS VSS gf180mcu_as_sc_mcu7t3v3__fillcap_4
X_2901_ VDD VDD VSS VSS _3199_/B _3247_/B _3249_/B gf180mcu_as_sc_mcu7t3v3__nand2b_2
XFILLER_177_837 VDD VDD VSS VSS gf180mcu_as_sc_mcu7t3v3__fill_2
X_3881_ VDD VDD VSS VSS _4946_/D _5171_/Q _4921_/D gf180mcu_as_sc_mcu7t3v3__and2_2
X_2832_ VDD VDD VSS VSS _2832_/S _2832_/B _2832_/A _2832_/Y gf180mcu_as_sc_mcu7t3v3__mux2_2
XFILLER_77_2 VDD VDD VSS VSS gf180mcu_as_sc_mcu7t3v3__fillcap_16
X_2763_ VDD VDD VSS VSS _2764_/B _2810_/A _2771_/B gf180mcu_as_sc_mcu7t3v3__xnor2_2
XTAP_TAPCELL_ROW_170_2006 VDD VSS gf180mcu_as_sc_mcu7t3v3__tap_2
X_4502_ VDD VDD VSS VSS _4502_/D _4588_/A _4502_/B _4502_/C _4503_/B gf180mcu_as_sc_mcu7t3v3__ao31_2
XFILLER_144_244 VDD VDD VSS VSS gf180mcu_as_sc_mcu7t3v3__fill_1
XFILLER_144_255 VDD VDD VSS VSS gf180mcu_as_sc_mcu7t3v3__fillcap_4
X_5482_ VDD VDD VSS VSS _5482_/A _5482_/Y gf180mcu_as_sc_mcu7t3v3__buff_2
X_2694_ VDD VDD VSS VSS _4959_/Q _2711_/S _2695_/D gf180mcu_as_sc_mcu7t3v3__and2_2
XFILLER_172_575 VDD VDD VSS VSS gf180mcu_as_sc_mcu7t3v3__fill_1
X_4433_ VDD VDD VSS VSS _5170_/Q _4548_/B _4433_/C _4433_/D _5170_/D gf180mcu_as_sc_mcu7t3v3__ao211_2
Xfanout506 VDD VDD VSS VSS _3477_/B _3462_/A gf180mcu_as_sc_mcu7t3v3__buff_2
X_4364_ VDD VDD VSS VSS _4365_/B _4364_/A _4364_/B _4370_/A gf180mcu_as_sc_mcu7t3v3__ao21_2
Xfanout517 VDD VDD VSS VSS _4506_/A _4591_/A gf180mcu_as_sc_mcu7t3v3__buff_2
Xfanout528 VDD VDD VSS VSS _4106_/S _4164_/S gf180mcu_as_sc_mcu7t3v3__buff_2
Xfanout539 VDD VDD VSS VSS fanout543/Y _3792_/B gf180mcu_as_sc_mcu7t3v3__buff_2
X_4295_ VDD VDD VSS VSS _4328_/B _4295_/B _4329_/A gf180mcu_as_sc_mcu7t3v3__nor2_2
X_3315_ VDD VDD VSS VSS _3965_/D _3475_/B _3315_/C _3315_/D _3316_/A gf180mcu_as_sc_mcu7t3v3__ao22_2
XFILLER_140_494 VDD VDD VSS VSS gf180mcu_as_sc_mcu7t3v3__fillcap_4
XFILLER_150_1119 VDD VDD VSS VSS gf180mcu_as_sc_mcu7t3v3__fillcap_4
XPHY_EDGE_ROW_148_Right_282 VDD VSS gf180mcu_as_sc_mcu7t3v3__tap_2
Xmesh_tile_910 VDD VDD VSS VSS nw_out[17] gf180mcu_as_sc_mcu7t3v3__tiel_4
X_3246_ VDD VDD VSS VSS _3510_/D _3247_/B _3542_/A gf180mcu_as_sc_mcu7t3v3__nor2_2
Xmesh_tile_954 VDD VDD VSS VSS sw_out[27] gf180mcu_as_sc_mcu7t3v3__tiel_4
Xmesh_tile_943 VDD VDD VSS VSS sw_out[16] gf180mcu_as_sc_mcu7t3v3__tiel_4
Xmesh_tile_932 VDD VDD VSS VSS sw_out[5] gf180mcu_as_sc_mcu7t3v3__tiel_4
Xmesh_tile_921 VDD VDD VSS VSS nw_out[28] gf180mcu_as_sc_mcu7t3v3__tiel_4
X_3177_ VDD VDD VSS VSS _4152_/A _3177_/B _3236_/C _4151_/D _3178_/C gf180mcu_as_sc_mcu7t3v3__ao22_2
XFILLER_148_1004 VDD VDD VSS VSS gf180mcu_as_sc_mcu7t3v3__fillcap_8
XTAP_TAPCELL_ROW_78_1_949 VDD VSS gf180mcu_as_sc_mcu7t3v3__tap_2
XFILLER_167_314 VDD VDD VSS VSS gf180mcu_as_sc_mcu7t3v3__fillcap_16
XFILLER_179_174 VDD VDD VSS VSS gf180mcu_as_sc_mcu7t3v3__fillcap_16
XFILLER_136_723 VDD VDD VSS VSS gf180mcu_as_sc_mcu7t3v3__fillcap_8
XFILLER_157_36 VDD VDD VSS VSS gf180mcu_as_sc_mcu7t3v3__fill_2
XFILLER_182_317 VDD VDD VSS VSS gf180mcu_as_sc_mcu7t3v3__fillcap_16
XFILLER_157_69 VDD VDD VSS VSS gf180mcu_as_sc_mcu7t3v3__fill_1
XFILLER_159_1133 VDD VDD VSS VSS gf180mcu_as_sc_mcu7t3v3__fillcap_8
XFILLER_150_225 VDD VDD VSS VSS gf180mcu_as_sc_mcu7t3v3__fillcap_16
XFILLER_150_247 VDD VDD VSS VSS gf180mcu_as_sc_mcu7t3v3__fillcap_16
XFILLER_1_202 VDD VDD VSS VSS gf180mcu_as_sc_mcu7t3v3__fill_2
XFILLER_173_68 VDD VDD VSS VSS gf180mcu_as_sc_mcu7t3v3__fill_2
XFILLER_172_1388 VDD VDD VSS VSS gf180mcu_as_sc_mcu7t3v3__fillcap_4
XFILLER_49_228 VDD VDD VSS VSS gf180mcu_as_sc_mcu7t3v3__fill_1
XTAP_TAPCELL_ROW_166_1919 VDD VSS gf180mcu_as_sc_mcu7t3v3__tap_2
XTAP_TAPCELL_ROW_166_1908 VDD VSS gf180mcu_as_sc_mcu7t3v3__tap_2
XFILLER_66_44 VDD VDD VSS VSS gf180mcu_as_sc_mcu7t3v3__fill_2
XTAP_TAPCELL_ROW_57_1_863 VDD VSS gf180mcu_as_sc_mcu7t3v3__tap_2
XFILLER_181_2 VDD VDD VSS VSS gf180mcu_as_sc_mcu7t3v3__fillcap_16
XFILLER_17_136 VDD VDD VSS VSS gf180mcu_as_sc_mcu7t3v3__fillcap_4
XFILLER_17_158 VDD VDD VSS VSS gf180mcu_as_sc_mcu7t3v3__fillcap_16
XFILLER_72_264 VDD VDD VSS VSS gf180mcu_as_sc_mcu7t3v3__fillcap_4
XFILLER_82_10 VDD VDD VSS VSS gf180mcu_as_sc_mcu7t3v3__fill_2
XFILLER_72_297 VDD VDD VSS VSS gf180mcu_as_sc_mcu7t3v3__fillcap_4
XFILLER_32_139 VDD VDD VSS VSS gf180mcu_as_sc_mcu7t3v3__fillcap_16
XTAP_TAPCELL_ROW_126_1_1140 VDD VSS gf180mcu_as_sc_mcu7t3v3__tap_2
XFILLER_126_200 VDD VDD VSS VSS gf180mcu_as_sc_mcu7t3v3__fillcap_4
XFILLER_154_520 VDD VDD VSS VSS gf180mcu_as_sc_mcu7t3v3__fillcap_4
XFILLER_63_8 VDD VDD VSS VSS gf180mcu_as_sc_mcu7t3v3__fill_2
XFILLER_126_255 VDD VDD VSS VSS gf180mcu_as_sc_mcu7t3v3__fillcap_4
XFILLER_141_203 VDD VDD VSS VSS gf180mcu_as_sc_mcu7t3v3__fillcap_4
XFILLER_173_1108 VDD VDD VSS VSS gf180mcu_as_sc_mcu7t3v3__fill_1
XFILLER_182_884 VDD VDD VSS VSS gf180mcu_as_sc_mcu7t3v3__fillcap_8
XFILLER_68_1550 VDD VDD VSS VSS gf180mcu_as_sc_mcu7t3v3__fillcap_4
XFILLER_99_117 VDD VDD VSS VSS gf180mcu_as_sc_mcu7t3v3__fillcap_16
XPHY_EDGE_ROW_57_3_Left_191 VDD VSS gf180mcu_as_sc_mcu7t3v3__tap_2
XFILLER_142_737 VDD VDD VSS VSS gf180mcu_as_sc_mcu7t3v3__fillcap_8
XFILLER_155_1520 VDD VDD VSS VSS gf180mcu_as_sc_mcu7t3v3__fill_2
XFILLER_173_1119 VDD VDD VSS VSS gf180mcu_as_sc_mcu7t3v3__fill_1
XFILLER_177_1299 VDD VDD VSS VSS gf180mcu_as_sc_mcu7t3v3__fillcap_4
XFILLER_99_139 VDD VDD VSS VSS gf180mcu_as_sc_mcu7t3v3__fill_1
XPHY_EDGE_ROW_64_3_Right_383 VDD VSS gf180mcu_as_sc_mcu7t3v3__tap_2
XTAP_TAPCELL_ROW_106_1_1060 VDD VSS gf180mcu_as_sc_mcu7t3v3__tap_2
X_3100_ VDD VDD VSS VSS _3151_/S _4077_/D _4080_/A _3103_/B gf180mcu_as_sc_mcu7t3v3__mux2_2
X_4080_ VDD VDD VSS VSS _4080_/A _4130_/B _4128_/B _4080_/D _4081_/D gf180mcu_as_sc_mcu7t3v3__ao22_2
XFILLER_55_209 VDD VDD VSS VSS gf180mcu_as_sc_mcu7t3v3__fill_1
Xinput180 VDD VDD VSS VSS rst input180/Y gf180mcu_as_sc_mcu7t3v3__buff_2
X_3031_ VDD VDD VSS VSS _3601_/D _3194_/S _3031_/B _3031_/C _3032_/C gf180mcu_as_sc_mcu7t3v3__ao31_2
XFILLER_184_1204 VDD VDD VSS VSS gf180mcu_as_sc_mcu7t3v3__fillcap_8
Xinput191 VDD VDD VSS VSS se_in[19] _4089_/A gf180mcu_as_sc_mcu7t3v3__buff_2
XFILLER_75_1521 VDD VDD VSS VSS gf180mcu_as_sc_mcu7t3v3__fillcap_16
X_4982_ VDD VDD VSS VSS _5173_/CLK _4982_/D _4982_/Q gf180mcu_as_sc_mcu7t3v3__dfxtp_2
X_3933_ VDD VDD VSS VSS _3933_/A _4159_/B _4159_/C _3933_/D _3934_/D gf180mcu_as_sc_mcu7t3v3__ao22_2
X_3864_ VDD VDD VSS VSS _5141_/Q _5142_/Q _3864_/C _3868_/A gf180mcu_as_sc_mcu7t3v3__nor3_2
XTAP_TAPCELL_ROW_74_1_933 VDD VSS gf180mcu_as_sc_mcu7t3v3__tap_2
XPHY_EDGE_ROW_6_1_Left_458 VDD VSS gf180mcu_as_sc_mcu7t3v3__tap_2
XFILLER_149_358 VDD VDD VSS VSS gf180mcu_as_sc_mcu7t3v3__fill_1
XFILLER_149_369 VDD VDD VSS VSS gf180mcu_as_sc_mcu7t3v3__fillcap_4
XFILLER_176_155 VDD VDD VSS VSS gf180mcu_as_sc_mcu7t3v3__fillcap_16
XFILLER_177_678 VDD VDD VSS VSS gf180mcu_as_sc_mcu7t3v3__fill_2
X_2815_ VDD VDD VSS VSS _5480_/A _2815_/A _2826_/B gf180mcu_as_sc_mcu7t3v3__and2_2
XFILLER_160_1281 VDD VDD VSS VSS gf180mcu_as_sc_mcu7t3v3__fillcap_8
XFILLER_164_317 VDD VDD VSS VSS gf180mcu_as_sc_mcu7t3v3__fillcap_16
XFILLER_176_177 VDD VDD VSS VSS gf180mcu_as_sc_mcu7t3v3__fillcap_16
X_3795_ VDD VDD VSS VSS _3795_/B _3795_/A _4868_/D gf180mcu_as_sc_mcu7t3v3__and2_2
XFILLER_117_244 VDD VDD VSS VSS gf180mcu_as_sc_mcu7t3v3__fillcap_16
X_2746_ VDD VDD VSS VSS _4626_/B _2746_/B _2838_/B gf180mcu_as_sc_mcu7t3v3__nor2_2
XTAP_TAPCELL_ROW_135_1233 VDD VSS gf180mcu_as_sc_mcu7t3v3__tap_2
XTAP_TAPCELL_ROW_135_1222 VDD VSS gf180mcu_as_sc_mcu7t3v3__tap_2
X_2677_ VDD VDD VSS VSS _2717_/S _5099_/Q _2677_/Y gf180mcu_as_sc_mcu7t3v3__and2_2
XFILLER_160_523 VDD VDD VSS VSS gf180mcu_as_sc_mcu7t3v3__fill_2
X_4416_ VDD VDD VSS VSS _5168_/Q _4548_/B _4416_/C _4416_/D _5168_/D gf180mcu_as_sc_mcu7t3v3__ao211_2
XTAP_TAPCELL_ROW_152_1591 VDD VSS gf180mcu_as_sc_mcu7t3v3__tap_2
XFILLER_132_247 VDD VDD VSS VSS gf180mcu_as_sc_mcu7t3v3__fillcap_4
X_4347_ VDD VDD VSS VSS _4347_/Y _4350_/C _4575_/B gf180mcu_as_sc_mcu7t3v3__nand2b_2
X_4278_ VDD VDD VSS VSS _4278_/S _5482_/A _5112_/Q _5112_/D gf180mcu_as_sc_mcu7t3v3__mux2_2
XFILLER_100_166 VDD VDD VSS VSS gf180mcu_as_sc_mcu7t3v3__fillcap_8
XFILLER_100_177 VDD VDD VSS VSS gf180mcu_as_sc_mcu7t3v3__fillcap_16
X_3229_ VDD VDD VSS VSS _3513_/A _3240_/B _3229_/C _3229_/D _3230_/A gf180mcu_as_sc_mcu7t3v3__ao22_2
XFILLER_100_199 VDD VDD VSS VSS gf180mcu_as_sc_mcu7t3v3__fill_1
XFILLER_167_1402 VDD VDD VSS VSS gf180mcu_as_sc_mcu7t3v3__fillcap_16
XTAP_TAPCELL_ROW_161_1805 VDD VSS gf180mcu_as_sc_mcu7t3v3__tap_2
XFILLER_36_69 VDD VDD VSS VSS gf180mcu_as_sc_mcu7t3v3__fillcap_16
XFILLER_167_1468 VDD VDD VSS VSS gf180mcu_as_sc_mcu7t3v3__fill_2
XFILLER_54_264 VDD VDD VSS VSS gf180mcu_as_sc_mcu7t3v3__fillcap_4
XFILLER_14_139 VDD VDD VSS VSS gf180mcu_as_sc_mcu7t3v3__fillcap_16
XFILLER_165_1192 VDD VDD VSS VSS gf180mcu_as_sc_mcu7t3v3__fillcap_16
XFILLER_168_634 VDD VDD VSS VSS gf180mcu_as_sc_mcu7t3v3__fillcap_16
XTAP_TAPCELL_ROW_159_1745 VDD VSS gf180mcu_as_sc_mcu7t3v3__tap_2
XFILLER_156_807 VDD VDD VSS VSS gf180mcu_as_sc_mcu7t3v3__fillcap_16
XFILLER_168_667 VDD VDD VSS VSS gf180mcu_as_sc_mcu7t3v3__fillcap_8
XTAP_TAPCELL_ROW_159_1756 VDD VSS gf180mcu_as_sc_mcu7t3v3__tap_2
XFILLER_149_892 VDD VDD VSS VSS gf180mcu_as_sc_mcu7t3v3__fill_2
XFILLER_164_884 VDD VDD VSS VSS gf180mcu_as_sc_mcu7t3v3__fillcap_8
XFILLER_174_1406 VDD VDD VSS VSS gf180mcu_as_sc_mcu7t3v3__fill_2
XFILLER_136_597 VDD VDD VSS VSS gf180mcu_as_sc_mcu7t3v3__fillcap_8
XFILLER_117_72 VDD VDD VSS VSS gf180mcu_as_sc_mcu7t3v3__fillcap_16
XFILLER_151_556 VDD VDD VSS VSS gf180mcu_as_sc_mcu7t3v3__fillcap_4
XFILLER_7_2 VDD VDD VSS VSS gf180mcu_as_sc_mcu7t3v3__fillcap_16
XTAP_TAPCELL_ROW_133_3_2549 VDD VSS gf180mcu_as_sc_mcu7t3v3__tap_2
XFILLER_150_1461 VDD VDD VSS VSS gf180mcu_as_sc_mcu7t3v3__fill_1
XFILLER_133_60 VDD VDD VSS VSS gf180mcu_as_sc_mcu7t3v3__fillcap_8
XFILLER_24_1486 VDD VDD VSS VSS gf180mcu_as_sc_mcu7t3v3__fillcap_16
XTAP_TAPCELL_ROW_39_1_792 VDD VSS gf180mcu_as_sc_mcu7t3v3__tap_2
XFILLER_111_1467 VDD VDD VSS VSS gf180mcu_as_sc_mcu7t3v3__fillcap_16
XFILLER_93_64 VDD VDD VSS VSS gf180mcu_as_sc_mcu7t3v3__fill_2
XFILLER_60_201 VDD VDD VSS VSS gf180mcu_as_sc_mcu7t3v3__fill_2
XFILLER_158_155 VDD VDD VSS VSS gf180mcu_as_sc_mcu7t3v3__fillcap_16
XFILLER_159_678 VDD VDD VSS VSS gf180mcu_as_sc_mcu7t3v3__fill_2
XFILLER_158_177 VDD VDD VSS VSS gf180mcu_as_sc_mcu7t3v3__fillcap_16
XFILLER_174_637 VDD VDD VSS VSS gf180mcu_as_sc_mcu7t3v3__fill_1
XFILLER_70_1451 VDD VDD VSS VSS gf180mcu_as_sc_mcu7t3v3__fillcap_16
XFILLER_173_136 VDD VDD VSS VSS gf180mcu_as_sc_mcu7t3v3__fillcap_4
X_3580_ VDD VDD VSS VSS _3944_/A _3753_/B _3580_/C _4840_/D _3706_/D gf180mcu_as_sc_mcu7t3v3__aoi211_2
X_2600_ VDD VDD VSS VSS _4765_/Q _4764_/Q _2601_/C gf180mcu_as_sc_mcu7t3v3__xnor2_2
XFILLER_142_501 VDD VDD VSS VSS gf180mcu_as_sc_mcu7t3v3__fill_1
XFILLER_173_158 VDD VDD VSS VSS gf180mcu_as_sc_mcu7t3v3__fillcap_16
XFILLER_177_1052 VDD VDD VSS VSS gf180mcu_as_sc_mcu7t3v3__fillcap_4
X_2531_ VDD VDD VSS VSS _4371_/B _2802_/A _2747_/A gf180mcu_as_sc_mcu7t3v3__nand2_2
XFILLER_142_545 VDD VDD VSS VSS gf180mcu_as_sc_mcu7t3v3__fill_1
XFILLER_154_372 VDD VDD VSS VSS gf180mcu_as_sc_mcu7t3v3__fillcap_4
XFILLER_54_4 VDD VDD VSS VSS gf180mcu_as_sc_mcu7t3v3__fill_1
X_5250_ VDD VDD VSS VSS clkload7/A _5250_/D _5250_/Q gf180mcu_as_sc_mcu7t3v3__dfxtp_2
XFILLER_114_247 VDD VDD VSS VSS gf180mcu_as_sc_mcu7t3v3__fillcap_4
X_4201_ VDD VDD VSS VSS _4230_/B _4218_/B _4228_/C _5037_/Q _5037_/D gf180mcu_as_sc_mcu7t3v3__ao22_2
X_2462_ VDD VDD VSS VSS _4448_/A _2462_/B _2462_/A _4350_/D gf180mcu_as_sc_mcu7t3v3__mux2_2
XPHY_EDGE_ROW_65_3_Right_384 VDD VSS gf180mcu_as_sc_mcu7t3v3__tap_2
X_5181_ VDD VDD VSS VSS _5186_/CLK _5181_/D _5181_/Q gf180mcu_as_sc_mcu7t3v3__dfxtp_2
X_2393_ VDD VDD VSS VSS _2882_/A _4763_/Q gf180mcu_as_sc_mcu7t3v3__inv_2
X_4132_ VDD VDD VSS VSS _4132_/A _4141_/B _4132_/C _4132_/D _4133_/B gf180mcu_as_sc_mcu7t3v3__ao22_2
XFILLER_28_209 VDD VDD VSS VSS gf180mcu_as_sc_mcu7t3v3__fillcap_16
XFILLER_95_142 VDD VDD VSS VSS gf180mcu_as_sc_mcu7t3v3__fill_2
X_4063_ VDD VDD VSS VSS _4063_/A _4103_/B _4063_/C _4063_/D _4065_/C gf180mcu_as_sc_mcu7t3v3__ao211_2
XTAP_TAPCELL_ROW_182_2263 VDD VSS gf180mcu_as_sc_mcu7t3v3__tap_2
XTAP_TAPCELL_ROW_182_2252 VDD VSS gf180mcu_as_sc_mcu7t3v3__tap_2
XFILLER_42_1564 VDD VDD VSS VSS gf180mcu_as_sc_mcu7t3v3__fillcap_4
X_3014_ VDD VDD VSS VSS _3194_/S _3014_/B _3994_/A _3015_/B gf180mcu_as_sc_mcu7t3v3__mux2_2
XFILLER_184_1034 VDD VDD VSS VSS gf180mcu_as_sc_mcu7t3v3__fill_1
X_4965_ VDD VDD VSS VSS _5146_/CLK _4965_/D _4965_/Q gf180mcu_as_sc_mcu7t3v3__dfxtp_2
XFILLER_162_1321 VDD VDD VSS VSS gf180mcu_as_sc_mcu7t3v3__fill_2
X_3916_ VDD VDD VSS VSS _3924_/C _3931_/B gf180mcu_as_sc_mcu7t3v3__inv_2
XFILLER_138_807 VDD VDD VSS VSS gf180mcu_as_sc_mcu7t3v3__fill_1
X_4896_ VDD VDD VSS VSS _4904_/CLK _4896_/D _4896_/Q gf180mcu_as_sc_mcu7t3v3__dfxtp_2
XTAP_TAPCELL_ROW_48_1_827 VDD VSS gf180mcu_as_sc_mcu7t3v3__tap_2
XFILLER_149_166 VDD VDD VSS VSS gf180mcu_as_sc_mcu7t3v3__fillcap_4
X_3847_ VDD VDD VSS VSS _3847_/S _3847_/B _3847_/A _3848_/B gf180mcu_as_sc_mcu7t3v3__mux2_2
X_3778_ VDD VDD VSS VSS _3778_/B _4159_/D _3779_/D gf180mcu_as_sc_mcu7t3v3__and2_2
XTAP_TAPCELL_ROW_154_1642 VDD VSS gf180mcu_as_sc_mcu7t3v3__tap_2
X_2729_ VDD VDD VSS VSS _2730_/D _2730_/A _2729_/B _2729_/A gf180mcu_as_sc_mcu7t3v3__aoi21b_2
XTAP_TAPCELL_ROW_154_1653 VDD VSS gf180mcu_as_sc_mcu7t3v3__tap_2
XFILLER_156_1103 VDD VDD VSS VSS gf180mcu_as_sc_mcu7t3v3__fillcap_4
XFILLER_154_37 VDD VDD VSS VSS gf180mcu_as_sc_mcu7t3v3__fill_1
XFILLER_161_854 VDD VDD VSS VSS gf180mcu_as_sc_mcu7t3v3__fill_2
Xoutput440 VDD VDD VSS VSS _4894_/Q west_out[21] gf180mcu_as_sc_mcu7t3v3__buff_2
Xoutput451 VDD VDD VSS VSS _4904_/Q west_out[31] gf180mcu_as_sc_mcu7t3v3__buff_2
XFILLER_134_1412 VDD VDD VSS VSS gf180mcu_as_sc_mcu7t3v3__fillcap_16
XFILLER_160_364 VDD VDD VSS VSS gf180mcu_as_sc_mcu7t3v3__fillcap_16
XFILLER_173_1472 VDD VDD VSS VSS gf180mcu_as_sc_mcu7t3v3__fillcap_16
XFILLER_47_24 VDD VDD VSS VSS gf180mcu_as_sc_mcu7t3v3__fillcap_16
XFILLER_86_186 VDD VDD VSS VSS gf180mcu_as_sc_mcu7t3v3__fillcap_16
XFILLER_170_69 VDD VDD VSS VSS gf180mcu_as_sc_mcu7t3v3__fillcap_16
XFILLER_179_34 VDD VDD VSS VSS gf180mcu_as_sc_mcu7t3v3__fillcap_16
XFILLER_93_1451 VDD VDD VSS VSS gf180mcu_as_sc_mcu7t3v3__fillcap_16
XFILLER_144_2 VDD VDD VSS VSS gf180mcu_as_sc_mcu7t3v3__fillcap_16
XFILLER_180_1443 VDD VDD VSS VSS gf180mcu_as_sc_mcu7t3v3__fill_2
XFILLER_184_913 VDD VDD VSS VSS gf180mcu_as_sc_mcu7t3v3__fillcap_4
XFILLER_8_18 VDD VDD VSS VSS gf180mcu_as_sc_mcu7t3v3__fillcap_16
XFILLER_156_637 VDD VDD VSS VSS gf180mcu_as_sc_mcu7t3v3__fill_1
XFILLER_168_486 VDD VDD VSS VSS gf180mcu_as_sc_mcu7t3v3__fillcap_8
XFILLER_184_946 VDD VDD VSS VSS gf180mcu_as_sc_mcu7t3v3__fillcap_4
Xwire512 VDD VDD VSS VSS _2832_/Y wire512/Y gf180mcu_as_sc_mcu7t3v3__buff_8
XPHY_EDGE_ROW_92_1_Left_544 VDD VSS gf180mcu_as_sc_mcu7t3v3__tap_2
XFILLER_155_136 VDD VDD VSS VSS gf180mcu_as_sc_mcu7t3v3__fillcap_4
XFILLER_137_884 VDD VDD VSS VSS gf180mcu_as_sc_mcu7t3v3__fillcap_8
XFILLER_155_158 VDD VDD VSS VSS gf180mcu_as_sc_mcu7t3v3__fill_2
XFILLER_170_139 VDD VDD VSS VSS gf180mcu_as_sc_mcu7t3v3__fillcap_16
XFILLER_152_865 VDD VDD VSS VSS gf180mcu_as_sc_mcu7t3v3__fillcap_8
XFILLER_174_1269 VDD VDD VSS VSS gf180mcu_as_sc_mcu7t3v3__fill_1
XFILLER_65_1553 VDD VDD VSS VSS gf180mcu_as_sc_mcu7t3v3__fillcap_16
XFILLER_144_81 VDD VDD VSS VSS gf180mcu_as_sc_mcu7t3v3__fillcap_16
XFILLER_77_142 VDD VDD VSS VSS gf180mcu_as_sc_mcu7t3v3__fill_2
XFILLER_18_275 VDD VDD VSS VSS gf180mcu_as_sc_mcu7t3v3__fill_2
XFILLER_33_212 VDD VDD VSS VSS gf180mcu_as_sc_mcu7t3v3__fillcap_16
XTAP_TAPCELL_ROW_88_1_987 VDD VSS gf180mcu_as_sc_mcu7t3v3__tap_2
XFILLER_72_1502 VDD VDD VSS VSS gf180mcu_as_sc_mcu7t3v3__fillcap_16
XFILLER_144_1062 VDD VDD VSS VSS gf180mcu_as_sc_mcu7t3v3__fillcap_16
XFILLER_72_1568 VDD VDD VSS VSS gf180mcu_as_sc_mcu7t3v3__fill_1
X_4750_ VDD VDD VSS VSS _5278_/D _4750_/A _4750_/B _4750_/C _4750_/D gf180mcu_as_sc_mcu7t3v3__aoi22_2
XFILLER_144_1084 VDD VDD VSS VSS gf180mcu_as_sc_mcu7t3v3__fill_1
XFILLER_175_935 VDD VDD VSS VSS gf180mcu_as_sc_mcu7t3v3__fillcap_8
X_4681_ VDD VDD VSS VSS _5248_/Q _4685_/C _4681_/C _5249_/Q _4682_/C gf180mcu_as_sc_mcu7t3v3__ao22_2
X_3701_ VDD VDD VSS VSS _3702_/C _4077_/D _3751_/B _3701_/C gf180mcu_as_sc_mcu7t3v3__ao21_2
X_3632_ VDD VDD VSS VSS _4006_/D _3741_/B _3740_/C _4005_/A _3633_/C gf180mcu_as_sc_mcu7t3v3__ao22_2
XTAP_TAPCELL_ROW_44_1_811 VDD VSS gf180mcu_as_sc_mcu7t3v3__tap_2
XFILLER_174_489 VDD VDD VSS VSS gf180mcu_as_sc_mcu7t3v3__fill_2
XFILLER_179_1158 VDD VDD VSS VSS gf180mcu_as_sc_mcu7t3v3__fillcap_4
XFILLER_155_681 VDD VDD VSS VSS gf180mcu_as_sc_mcu7t3v3__fillcap_16
X_3563_ VDD VDD VSS VSS _3563_/Y _3563_/B _3563_/A gf180mcu_as_sc_mcu7t3v3__nor2_2
XFILLER_170_662 VDD VDD VSS VSS gf180mcu_as_sc_mcu7t3v3__fill_2
XFILLER_5_190 VDD VDD VSS VSS gf180mcu_as_sc_mcu7t3v3__fillcap_16
X_3494_ VDD VDD VSS VSS _4153_/A _3501_/C _3503_/B _4151_/D _3495_/D gf180mcu_as_sc_mcu7t3v3__ao22_2
X_2514_ VDD VDD VSS VSS _4663_/A _5240_/Q _4703_/D gf180mcu_as_sc_mcu7t3v3__and2_2
X_5233_ VDD VDD VSS VSS clkload7/A _5233_/D _5233_/Q gf180mcu_as_sc_mcu7t3v3__dfxtp_2
X_2445_ VDD VDD VSS VSS _4124_/A _2445_/A gf180mcu_as_sc_mcu7t3v3__inv_2
XTAP_TAPCELL_ROW_184_2314 VDD VSS gf180mcu_as_sc_mcu7t3v3__tap_2
XTAP_TAPCELL_ROW_184_2303 VDD VSS gf180mcu_as_sc_mcu7t3v3__tap_2
X_5164_ VDD VDD VSS VSS _5164_/CLK _5164_/D _5164_/Q gf180mcu_as_sc_mcu7t3v3__dfxtp_2
XTAP_TAPCELL_ROW_184_2336 VDD VSS gf180mcu_as_sc_mcu7t3v3__tap_2
XTAP_TAPCELL_ROW_184_2325 VDD VSS gf180mcu_as_sc_mcu7t3v3__tap_2
XPHY_EDGE_ROW_66_3_Right_385 VDD VSS gf180mcu_as_sc_mcu7t3v3__tap_2
X_4115_ VDD VDD VSS VSS _4115_/A _4115_/B _4115_/C _4115_/D _4116_/B gf180mcu_as_sc_mcu7t3v3__ao22_2
X_5095_ VDD VDD VSS VSS _5185_/CLK _5095_/D _5095_/Q gf180mcu_as_sc_mcu7t3v3__dfxtp_2
XFILLER_83_134 VDD VDD VSS VSS gf180mcu_as_sc_mcu7t3v3__fillcap_4
X_4046_ VDD VDD VSS VSS _4046_/A _4126_/C _4130_/B _4046_/D _4047_/D gf180mcu_as_sc_mcu7t3v3__ao22_2
XTAP_TAPCELL_ROW_147_1490 VDD VSS gf180mcu_as_sc_mcu7t3v3__tap_2
XFILLER_168_1552 VDD VDD VSS VSS gf180mcu_as_sc_mcu7t3v3__fillcap_8
XFILLER_169_206 VDD VDD VSS VSS gf180mcu_as_sc_mcu7t3v3__fillcap_4
XFILLER_169_228 VDD VDD VSS VSS gf180mcu_as_sc_mcu7t3v3__fillcap_16
XTAP_TAPCELL_ROW_143_1398 VDD VSS gf180mcu_as_sc_mcu7t3v3__tap_2
X_4948_ VDD VDD VSS VSS _5164_/CLK _4948_/D _4948_/Q gf180mcu_as_sc_mcu7t3v3__dfxtp_2
XFILLER_162_1173 VDD VDD VSS VSS gf180mcu_as_sc_mcu7t3v3__fillcap_8
X_4879_ VDD VDD VSS VSS _4928_/CLK _4879_/D _4879_/Q gf180mcu_as_sc_mcu7t3v3__dfxtp_2
XFILLER_153_629 VDD VDD VSS VSS gf180mcu_as_sc_mcu7t3v3__fill_1
XFILLER_165_467 VDD VDD VSS VSS gf180mcu_as_sc_mcu7t3v3__fill_1
XFILLER_152_139 VDD VDD VSS VSS gf180mcu_as_sc_mcu7t3v3__fillcap_16
XFILLER_49_1515 VDD VDD VSS VSS gf180mcu_as_sc_mcu7t3v3__fillcap_4
XFILLER_88_1564 VDD VDD VSS VSS gf180mcu_as_sc_mcu7t3v3__fillcap_4
XFILLER_101_1499 VDD VDD VSS VSS gf180mcu_as_sc_mcu7t3v3__fillcap_16
XFILLER_136_1507 VDD VDD VSS VSS gf180mcu_as_sc_mcu7t3v3__fillcap_16
XFILLER_161_662 VDD VDD VSS VSS gf180mcu_as_sc_mcu7t3v3__fill_2
XFILLER_49_1537 VDD VDD VSS VSS gf180mcu_as_sc_mcu7t3v3__fillcap_16
XFILLER_134_898 VDD VDD VSS VSS gf180mcu_as_sc_mcu7t3v3__fill_2
XFILLER_58_23 VDD VDD VSS VSS gf180mcu_as_sc_mcu7t3v3__fillcap_8
XFILLER_173_1291 VDD VDD VSS VSS gf180mcu_as_sc_mcu7t3v3__fillcap_16
XFILLER_59_142 VDD VDD VSS VSS gf180mcu_as_sc_mcu7t3v3__fillcap_4
XFILLER_74_123 VDD VDD VSS VSS gf180mcu_as_sc_mcu7t3v3__fillcap_16
XFILLER_60_1483 VDD VDD VSS VSS gf180mcu_as_sc_mcu7t3v3__fill_1
XFILLER_21_1467 VDD VDD VSS VSS gf180mcu_as_sc_mcu7t3v3__fillcap_16
XFILLER_15_212 VDD VDD VSS VSS gf180mcu_as_sc_mcu7t3v3__fillcap_16
XFILLER_182_1527 VDD VDD VSS VSS gf180mcu_as_sc_mcu7t3v3__fillcap_16
XFILLER_74_99 VDD VDD VSS VSS gf180mcu_as_sc_mcu7t3v3__fillcap_4
XFILLER_95_1568 VDD VDD VSS VSS gf180mcu_as_sc_mcu7t3v3__fill_1
XFILLER_167_1084 VDD VDD VSS VSS gf180mcu_as_sc_mcu7t3v3__fillcap_16
XFILLER_90_10 VDD VDD VSS VSS gf180mcu_as_sc_mcu7t3v3__fillcap_4
XFILLER_90_43 VDD VDD VSS VSS gf180mcu_as_sc_mcu7t3v3__fill_1
XTAP_TAPCELL_ROW_33_3_2399 VDD VSS gf180mcu_as_sc_mcu7t3v3__tap_2
XTAP_TAPCELL_ROW_84_1_971 VDD VSS gf180mcu_as_sc_mcu7t3v3__tap_2
XFILLER_157_979 VDD VDD VSS VSS gf180mcu_as_sc_mcu7t3v3__fill_1
XFILLER_172_938 VDD VDD VSS VSS gf180mcu_as_sc_mcu7t3v3__fillcap_4
XFILLER_176_1309 VDD VDD VSS VSS gf180mcu_as_sc_mcu7t3v3__fillcap_8
XFILLER_137_670 VDD VDD VSS VSS gf180mcu_as_sc_mcu7t3v3__fillcap_16
XFILLER_99_41 VDD VDD VSS VSS gf180mcu_as_sc_mcu7t3v3__fill_1
XFILLER_99_63 VDD VDD VSS VSS gf180mcu_as_sc_mcu7t3v3__fill_2
XPHY_EDGE_ROW_85_3_Left_219 VDD VSS gf180mcu_as_sc_mcu7t3v3__tap_2
XFILLER_174_1033 VDD VDD VSS VSS gf180mcu_as_sc_mcu7t3v3__fill_1
XFILLER_2_160 VDD VDD VSS VSS gf180mcu_as_sc_mcu7t3v3__fillcap_4
XFILLER_97_226 VDD VDD VSS VSS gf180mcu_as_sc_mcu7t3v3__fill_1
XFILLER_97_237 VDD VDD VSS VSS gf180mcu_as_sc_mcu7t3v3__fillcap_16
XFILLER_117_1451 VDD VDD VSS VSS gf180mcu_as_sc_mcu7t3v3__fillcap_16
XFILLER_152_1364 VDD VDD VSS VSS gf180mcu_as_sc_mcu7t3v3__fill_1
XFILLER_2_193 VDD VDD VSS VSS gf180mcu_as_sc_mcu7t3v3__fillcap_8
XFILLER_152_1375 VDD VDD VSS VSS gf180mcu_as_sc_mcu7t3v3__fill_2
XFILLER_0_52 VDD VDD VSS VSS gf180mcu_as_sc_mcu7t3v3__fillcap_16
XFILLER_179_548 VDD VDD VSS VSS gf180mcu_as_sc_mcu7t3v3__fillcap_8
XFILLER_80_159 VDD VDD VSS VSS gf180mcu_as_sc_mcu7t3v3__fill_2
XFILLER_146_1157 VDD VDD VSS VSS gf180mcu_as_sc_mcu7t3v3__fillcap_16
X_4802_ VDD VDD VSS VSS _4869_/CLK _4802_/D _4802_/Q gf180mcu_as_sc_mcu7t3v3__dfxtp_2
X_2994_ VDD VDD VSS VSS _3120_/A _2994_/B _2994_/C _3120_/D _2996_/C gf180mcu_as_sc_mcu7t3v3__ao211_2
XTAP_TAPCELL_ROW_177_2151 VDD VSS gf180mcu_as_sc_mcu7t3v3__tap_2
XTAP_TAPCELL_ROW_177_2140 VDD VSS gf180mcu_as_sc_mcu7t3v3__tap_2
XFILLER_166_209 VDD VDD VSS VSS gf180mcu_as_sc_mcu7t3v3__fillcap_4
XFILLER_9_50 VDD VDD VSS VSS gf180mcu_as_sc_mcu7t3v3__fillcap_16
XFILLER_9_72 VDD VDD VSS VSS gf180mcu_as_sc_mcu7t3v3__fillcap_16
X_4733_ VDD VDD VSS VSS _4733_/A _4733_/B _4733_/C _5268_/D _4742_/C gf180mcu_as_sc_mcu7t3v3__aoi211_2
XFILLER_119_18 VDD VDD VSS VSS gf180mcu_as_sc_mcu7t3v3__fillcap_16
XFILLER_147_434 VDD VDD VSS VSS gf180mcu_as_sc_mcu7t3v3__fill_2
XTAP_TAPCELL_ROW_173_2059 VDD VSS gf180mcu_as_sc_mcu7t3v3__tap_2
X_4664_ VDD VDD VSS VSS _4677_/B _4666_/B _4731_/B gf180mcu_as_sc_mcu7t3v3__nor2_2
XTAP_TAPCELL_ROW_125_1_1136 VDD VSS gf180mcu_as_sc_mcu7t3v3__tap_2
XFILLER_147_489 VDD VDD VSS VSS gf180mcu_as_sc_mcu7t3v3__fill_1
XFILLER_162_415 VDD VDD VSS VSS gf180mcu_as_sc_mcu7t3v3__fillcap_16
X_4595_ VDD VDD VSS VSS _5189_/Q _4750_/D _4600_/C _5190_/Q _5189_/D gf180mcu_as_sc_mcu7t3v3__ao22_2
X_3615_ VDD VDD VSS VSS _3699_/D _3794_/S _3615_/B _3615_/C _3616_/C gf180mcu_as_sc_mcu7t3v3__ao31_2
XTAP_TAPCELL_ROW_26_1_740 VDD VSS gf180mcu_as_sc_mcu7t3v3__tap_2
XFILLER_157_1242 VDD VDD VSS VSS gf180mcu_as_sc_mcu7t3v3__fillcap_8
XFILLER_171_960 VDD VDD VSS VSS gf180mcu_as_sc_mcu7t3v3__fillcap_16
X_3546_ VDD VDD VSS VSS _3797_/C _3563_/A _3786_/A gf180mcu_as_sc_mcu7t3v3__and2_2
XFILLER_142_150 VDD VDD VSS VSS gf180mcu_as_sc_mcu7t3v3__fill_1
XFILLER_143_662 VDD VDD VSS VSS gf180mcu_as_sc_mcu7t3v3__fillcap_16
XFILLER_171_982 VDD VDD VSS VSS gf180mcu_as_sc_mcu7t3v3__fill_2
XFILLER_142_172 VDD VDD VSS VSS gf180mcu_as_sc_mcu7t3v3__fill_2
X_5216_ VDD VDD VSS VSS clkload0/A _5216_/D _5216_/Q gf180mcu_as_sc_mcu7t3v3__dfxtp_2
X_3477_ VDD VDD VSS VSS _4132_/A _3477_/B _3477_/C _4829_/D _3753_/D gf180mcu_as_sc_mcu7t3v3__aoi211_2
XTAP_TAPCELL_ROW_105_1_1056 VDD VSS gf180mcu_as_sc_mcu7t3v3__tap_2
XFILLER_170_1453 VDD VDD VSS VSS gf180mcu_as_sc_mcu7t3v3__fill_2
XFILLER_83_1483 VDD VDD VSS VSS gf180mcu_as_sc_mcu7t3v3__fillcap_16
X_2428_ VDD VDD VSS VSS _3608_/A _3978_/A gf180mcu_as_sc_mcu7t3v3__inv_2
XTAP_TAPCELL_ROW_149_1541 VDD VSS gf180mcu_as_sc_mcu7t3v3__tap_2
XTAP_TAPCELL_ROW_149_1530 VDD VSS gf180mcu_as_sc_mcu7t3v3__tap_2
XPHY_EDGE_ROW_67_3_Right_386 VDD VSS gf180mcu_as_sc_mcu7t3v3__tap_2
XFILLER_151_16 VDD VDD VSS VSS gf180mcu_as_sc_mcu7t3v3__fillcap_16
XFILLER_28_37 VDD VDD VSS VSS gf180mcu_as_sc_mcu7t3v3__fillcap_16
XFILLER_44_1467 VDD VDD VSS VSS gf180mcu_as_sc_mcu7t3v3__fillcap_16
X_5147_ VDD VDD VSS VSS clkload9/A _5147_/D _5147_/Q gf180mcu_as_sc_mcu7t3v3__dfxtp_2
X_5078_ VDD VDD VSS VSS _5085_/CLK _5078_/D _5078_/Q gf180mcu_as_sc_mcu7t3v3__dfxtp_2
XTAP_TAPCELL_ROW_145_1449 VDD VSS gf180mcu_as_sc_mcu7t3v3__tap_2
XTAP_TAPCELL_ROW_145_1438 VDD VSS gf180mcu_as_sc_mcu7t3v3__tap_2
X_4029_ VDD VDD VSS VSS _4029_/A _4120_/B _4120_/C _4927_/Q _4031_/C gf180mcu_as_sc_mcu7t3v3__ao22_2
XFILLER_12_215 VDD VDD VSS VSS gf180mcu_as_sc_mcu7t3v3__fillcap_16
XFILLER_142_1511 VDD VDD VSS VSS gf180mcu_as_sc_mcu7t3v3__fill_2
XFILLER_181_1560 VDD VDD VSS VSS gf180mcu_as_sc_mcu7t3v3__fill_1
XFILLER_138_412 VDD VDD VSS VSS gf180mcu_as_sc_mcu7t3v3__fill_1
XFILLER_139_946 VDD VDD VSS VSS gf180mcu_as_sc_mcu7t3v3__fill_2
XFILLER_178_581 VDD VDD VSS VSS gf180mcu_as_sc_mcu7t3v3__fillcap_8
XFILLER_138_478 VDD VDD VSS VSS gf180mcu_as_sc_mcu7t3v3__fill_2
XFILLER_166_776 VDD VDD VSS VSS gf180mcu_as_sc_mcu7t3v3__fillcap_16
XFILLER_181_702 VDD VDD VSS VSS gf180mcu_as_sc_mcu7t3v3__fill_1
XFILLER_153_426 VDD VDD VSS VSS gf180mcu_as_sc_mcu7t3v3__fill_2
XFILLER_154_938 VDD VDD VSS VSS gf180mcu_as_sc_mcu7t3v3__fillcap_4
XFILLER_158_1017 VDD VDD VSS VSS gf180mcu_as_sc_mcu7t3v3__fill_2
XFILLER_181_735 VDD VDD VSS VSS gf180mcu_as_sc_mcu7t3v3__fill_2
XFILLER_107_2 VDD VDD VSS VSS gf180mcu_as_sc_mcu7t3v3__fillcap_16
XFILLER_69_22 VDD VDD VSS VSS gf180mcu_as_sc_mcu7t3v3__fillcap_16
XFILLER_161_492 VDD VDD VSS VSS gf180mcu_as_sc_mcu7t3v3__fillcap_16
XFILLER_69_88 VDD VDD VSS VSS gf180mcu_as_sc_mcu7t3v3__fillcap_4
XFILLER_62_1534 VDD VDD VSS VSS gf180mcu_as_sc_mcu7t3v3__fillcap_16
XFILLER_85_10 VDD VDD VSS VSS gf180mcu_as_sc_mcu7t3v3__fill_2
XFILLER_62_1556 VDD VDD VSS VSS gf180mcu_as_sc_mcu7t3v3__fillcap_8
XFILLER_169_1113 VDD VDD VSS VSS gf180mcu_as_sc_mcu7t3v3__fill_1
XFILLER_47_134 VDD VDD VSS VSS gf180mcu_as_sc_mcu7t3v3__fillcap_4
XFILLER_85_65 VDD VDD VSS VSS gf180mcu_as_sc_mcu7t3v3__fillcap_4
XFILLER_5_1483 VDD VDD VSS VSS gf180mcu_as_sc_mcu7t3v3__fillcap_16
XFILLER_62_115 VDD VDD VSS VSS gf180mcu_as_sc_mcu7t3v3__fill_1
XFILLER_182_1313 VDD VDD VSS VSS gf180mcu_as_sc_mcu7t3v3__fillcap_8
XFILLER_147_1488 VDD VDD VSS VSS gf180mcu_as_sc_mcu7t3v3__fillcap_4
XFILLER_148_209 VDD VDD VSS VSS gf180mcu_as_sc_mcu7t3v3__fillcap_16
XFILLER_34_91 VDD VDD VSS VSS gf180mcu_as_sc_mcu7t3v3__fill_1
XFILLER_180_1081 VDD VDD VSS VSS gf180mcu_as_sc_mcu7t3v3__fillcap_4
XFILLER_184_562 VDD VDD VSS VSS gf180mcu_as_sc_mcu7t3v3__fillcap_16
XFILLER_141_1098 VDD VDD VSS VSS gf180mcu_as_sc_mcu7t3v3__fillcap_8
XFILLER_171_212 VDD VDD VSS VSS gf180mcu_as_sc_mcu7t3v3__fillcap_16
XFILLER_153_960 VDD VDD VSS VSS gf180mcu_as_sc_mcu7t3v3__fillcap_16
XPHY_EDGE_ROW_55_1_Left_507 VDD VSS gf180mcu_as_sc_mcu7t3v3__tap_2
X_4380_ VDD VDD VSS VSS _4380_/B _4380_/A _5164_/D gf180mcu_as_sc_mcu7t3v3__and2_2
X_3400_ VDD VDD VSS VSS _3400_/B _3768_/A _4819_/D gf180mcu_as_sc_mcu7t3v3__and2_2
XFILLER_153_982 VDD VDD VSS VSS gf180mcu_as_sc_mcu7t3v3__fillcap_16
XFILLER_154_1415 VDD VDD VSS VSS gf180mcu_as_sc_mcu7t3v3__fillcap_16
XFILLER_67_1467 VDD VDD VSS VSS gf180mcu_as_sc_mcu7t3v3__fillcap_16
Xclkbuf_leaf_11_clk_regs VDD VDD VSS VSS clkbuf_3_2_0_clk_regs/Y _5146_/CLK gf180mcu_as_sc_mcu7t3v3__clkbuff_12
X_3331_ VDD VDD VSS VSS _3981_/A _3451_/B _3331_/C _3331_/D _3332_/A gf180mcu_as_sc_mcu7t3v3__ao22_2
XFILLER_124_172 VDD VDD VSS VSS gf180mcu_as_sc_mcu7t3v3__fill_2
XFILLER_152_481 VDD VDD VSS VSS gf180mcu_as_sc_mcu7t3v3__fill_1
XFILLER_154_1459 VDD VDD VSS VSS gf180mcu_as_sc_mcu7t3v3__fill_1
XFILLER_85_207 VDD VDD VSS VSS gf180mcu_as_sc_mcu7t3v3__fill_2
X_3262_ VDD VDD VSS VSS _3520_/B _3776_/A _3262_/Y gf180mcu_as_sc_mcu7t3v3__and2_2
XFILLER_152_1161 VDD VDD VSS VSS gf180mcu_as_sc_mcu7t3v3__fill_2
XFILLER_22_2 VDD VDD VSS VSS gf180mcu_as_sc_mcu7t3v3__fillcap_16
XFILLER_38_101 VDD VDD VSS VSS gf180mcu_as_sc_mcu7t3v3__fillcap_4
X_5001_ VDD VDD VSS VSS _5088_/CLK _5001_/D _5001_/Q gf180mcu_as_sc_mcu7t3v3__dfxtp_2
X_3193_ VDD VDD VSS VSS _4163_/A _3230_/S _3193_/C _3193_/D _3194_/B gf180mcu_as_sc_mcu7t3v3__ao22_2
XFILLER_38_123 VDD VDD VSS VSS gf180mcu_as_sc_mcu7t3v3__fillcap_16
XTAP_TAPCELL_ROW_179_2202 VDD VSS gf180mcu_as_sc_mcu7t3v3__tap_2
XTAP_TAPCELL_ROW_140_1335 VDD VSS gf180mcu_as_sc_mcu7t3v3__tap_2
XPHY_EDGE_ROW_79_1_Right_78 VDD VSS gf180mcu_as_sc_mcu7t3v3__tap_2
XFILLER_165_1566 VDD VDD VSS VSS gf180mcu_as_sc_mcu7t3v3__fill_2
XTAP_TAPCELL_ROW_140_1346 VDD VSS gf180mcu_as_sc_mcu7t3v3__tap_2
X_2977_ VDD VDD VSS VSS _3145_/A _2977_/B _2977_/C _3145_/D _2979_/C gf180mcu_as_sc_mcu7t3v3__ao211_2
XFILLER_163_702 VDD VDD VSS VSS gf180mcu_as_sc_mcu7t3v3__fillcap_4
XFILLER_175_562 VDD VDD VSS VSS gf180mcu_as_sc_mcu7t3v3__fillcap_8
X_4716_ VDD VDD VSS VSS _4721_/A _4716_/B _5107_/Q _5260_/D gf180mcu_as_sc_mcu7t3v3__mux2_2
XFILLER_102_1550 VDD VDD VSS VSS gf180mcu_as_sc_mcu7t3v3__fillcap_4
XFILLER_107_106 VDD VDD VSS VSS gf180mcu_as_sc_mcu7t3v3__fillcap_4
XFILLER_136_938 VDD VDD VSS VSS gf180mcu_as_sc_mcu7t3v3__fillcap_4
XFILLER_163_746 VDD VDD VSS VSS gf180mcu_as_sc_mcu7t3v3__fillcap_8
X_4647_ VDD VDD VSS VSS _5234_/D _4647_/A _4660_/A _4647_/C gf180mcu_as_sc_mcu7t3v3__ao21_2
XTAP_TAPCELL_ROW_138_1297 VDD VSS gf180mcu_as_sc_mcu7t3v3__tap_2
XTAP_TAPCELL_ROW_138_1286 VDD VSS gf180mcu_as_sc_mcu7t3v3__tap_2
XFILLER_107_139 VDD VDD VSS VSS gf180mcu_as_sc_mcu7t3v3__fill_1
XFILLER_159_1348 VDD VDD VSS VSS gf180mcu_as_sc_mcu7t3v3__fillcap_16
XFILLER_11_1499 VDD VDD VSS VSS gf180mcu_as_sc_mcu7t3v3__fillcap_16
XFILLER_150_429 VDD VDD VSS VSS gf180mcu_as_sc_mcu7t3v3__fill_1
XFILLER_162_267 VDD VDD VSS VSS gf180mcu_as_sc_mcu7t3v3__fill_1
X_4578_ VDD VDD VSS VSS _4581_/C _5000_/Q _4579_/S gf180mcu_as_sc_mcu7t3v3__nand2b_2
XFILLER_157_1083 VDD VDD VSS VSS gf180mcu_as_sc_mcu7t3v3__fillcap_4
XFILLER_46_1518 VDD VDD VSS VSS gf180mcu_as_sc_mcu7t3v3__fillcap_16
X_3529_ VDD VDD VSS VSS _3557_/B _3922_/B _3559_/A gf180mcu_as_sc_mcu7t3v3__nand2_2
XFILLER_130_142 VDD VDD VSS VSS gf180mcu_as_sc_mcu7t3v3__fill_2
XFILLER_76_207 VDD VDD VSS VSS gf180mcu_as_sc_mcu7t3v3__fillcap_4
XTAP_TAPCELL_ROW_75_1_935 VDD VSS gf180mcu_as_sc_mcu7t3v3__tap_2
XFILLER_162_37 VDD VDD VSS VSS gf180mcu_as_sc_mcu7t3v3__fillcap_16
XFILLER_39_69 VDD VDD VSS VSS gf180mcu_as_sc_mcu7t3v3__fill_1
XTAP_TAPCELL_ROW_168_1961 VDD VSS gf180mcu_as_sc_mcu7t3v3__tap_2
XTAP_TAPCELL_ROW_168_1950 VDD VSS gf180mcu_as_sc_mcu7t3v3__tap_2
XPHY_EDGE_ROW_68_3_Right_387 VDD VSS gf180mcu_as_sc_mcu7t3v3__tap_2
XFILLER_44_104 VDD VDD VSS VSS gf180mcu_as_sc_mcu7t3v3__fill_1
XFILLER_84_251 VDD VDD VSS VSS gf180mcu_as_sc_mcu7t3v3__fill_2
XTAP_TAPCELL_ROW_164_1869 VDD VSS gf180mcu_as_sc_mcu7t3v3__tap_2
XTAP_TAPCELL_ROW_164_1858 VDD VSS gf180mcu_as_sc_mcu7t3v3__tap_2
XFILLER_55_57 VDD VDD VSS VSS gf180mcu_as_sc_mcu7t3v3__fill_1
XFILLER_92_1527 VDD VDD VSS VSS gf180mcu_as_sc_mcu7t3v3__fillcap_16
XFILLER_164_1087 VDD VDD VSS VSS gf180mcu_as_sc_mcu7t3v3__fillcap_16
XFILLER_138_220 VDD VDD VSS VSS gf180mcu_as_sc_mcu7t3v3__fillcap_4
XFILLER_107_1483 VDD VDD VSS VSS gf180mcu_as_sc_mcu7t3v3__fillcap_16
XFILLER_138_242 VDD VDD VSS VSS gf180mcu_as_sc_mcu7t3v3__fill_2
XFILLER_138_286 VDD VDD VSS VSS gf180mcu_as_sc_mcu7t3v3__fillcap_16
XFILLER_153_212 VDD VDD VSS VSS gf180mcu_as_sc_mcu7t3v3__fillcap_16
XFILLER_166_573 VDD VDD VSS VSS gf180mcu_as_sc_mcu7t3v3__fill_1
XFILLER_181_521 VDD VDD VSS VSS gf180mcu_as_sc_mcu7t3v3__fillcap_4
XFILLER_135_982 VDD VDD VSS VSS gf180mcu_as_sc_mcu7t3v3__fill_2
XFILLER_153_256 VDD VDD VSS VSS gf180mcu_as_sc_mcu7t3v3__fill_1
XFILLER_153_278 VDD VDD VSS VSS gf180mcu_as_sc_mcu7t3v3__fill_2
XFILLER_4_244 VDD VDD VSS VSS gf180mcu_as_sc_mcu7t3v3__fill_1
XFILLER_106_172 VDD VDD VSS VSS gf180mcu_as_sc_mcu7t3v3__fill_2
XFILLER_175_1150 VDD VDD VSS VSS gf180mcu_as_sc_mcu7t3v3__fillcap_8
XFILLER_4_299 VDD VDD VSS VSS gf180mcu_as_sc_mcu7t3v3__fill_2
XFILLER_121_142 VDD VDD VSS VSS gf180mcu_as_sc_mcu7t3v3__fill_2
XFILLER_175_1194 VDD VDD VSS VSS gf180mcu_as_sc_mcu7t3v3__fill_1
XFILLER_121_175 VDD VDD VSS VSS gf180mcu_as_sc_mcu7t3v3__fillcap_16
XFILLER_27_1451 VDD VDD VSS VSS gf180mcu_as_sc_mcu7t3v3__fillcap_16
XFILLER_96_64 VDD VDD VSS VSS gf180mcu_as_sc_mcu7t3v3__fillcap_4
XFILLER_153_1492 VDD VDD VSS VSS gf180mcu_as_sc_mcu7t3v3__fill_2
XFILLER_35_104 VDD VDD VSS VSS gf180mcu_as_sc_mcu7t3v3__fillcap_16
XFILLER_75_251 VDD VDD VSS VSS gf180mcu_as_sc_mcu7t3v3__fill_1
XTAP_TAPCELL_ROW_17_1_704 VDD VSS gf180mcu_as_sc_mcu7t3v3__tap_2
XFILLER_149_1539 VDD VDD VSS VSS gf180mcu_as_sc_mcu7t3v3__fill_1
XFILLER_50_107 VDD VDD VSS VSS gf180mcu_as_sc_mcu7t3v3__fillcap_16
X_2900_ VDD VDD VSS VSS _3247_/B _4946_/Q _4944_/Q gf180mcu_as_sc_mcu7t3v3__nand2_2
XFILLER_182_1154 VDD VDD VSS VSS gf180mcu_as_sc_mcu7t3v3__fill_1
X_3880_ VDD VDD VSS VSS _3897_/B _5170_/Q _4920_/D gf180mcu_as_sc_mcu7t3v3__and2_2
XPHY_EDGE_ROW_29_3_Left_163 VDD VSS gf180mcu_as_sc_mcu7t3v3__tap_2
X_2831_ VDD VDD VSS VSS _4952_/D _2831_/B _2831_/A _2832_/A gf180mcu_as_sc_mcu7t3v3__mux2_2
XFILLER_145_702 VDD VDD VSS VSS gf180mcu_as_sc_mcu7t3v3__fill_2
XFILLER_157_562 VDD VDD VSS VSS gf180mcu_as_sc_mcu7t3v3__fillcap_8
X_2762_ VDD VDD VSS VSS _2764_/B _2810_/C _2810_/B gf180mcu_as_sc_mcu7t3v3__nand2_2
XTAP_TAPCELL_ROW_170_2007 VDD VSS gf180mcu_as_sc_mcu7t3v3__tap_2
XFILLER_160_1485 VDD VDD VSS VSS gf180mcu_as_sc_mcu7t3v3__fillcap_16
XPHY_EDGE_ROW_140_Right_274 VDD VSS gf180mcu_as_sc_mcu7t3v3__tap_2
X_5481_ VDD VDD VSS VSS _5481_/A _5481_/Y gf180mcu_as_sc_mcu7t3v3__buff_2
X_4501_ VDD VDD VSS VSS _4502_/D _4501_/B _4588_/A gf180mcu_as_sc_mcu7t3v3__nor2_2
XFILLER_184_392 VDD VDD VSS VSS gf180mcu_as_sc_mcu7t3v3__fillcap_16
X_4432_ VDD VDD VSS VSS _4433_/D _4432_/B _4589_/A gf180mcu_as_sc_mcu7t3v3__nor2_2
X_2693_ VDD VDD VSS VSS _2832_/S _2693_/B _2693_/A _2693_/Y gf180mcu_as_sc_mcu7t3v3__mux2_2
XFILLER_160_749 VDD VDD VSS VSS gf180mcu_as_sc_mcu7t3v3__fill_1
XPHY_EDGE_ROW_136_Left_588 VDD VSS gf180mcu_as_sc_mcu7t3v3__tap_2
X_4363_ VDD VDD VSS VSS _4379_/B _4363_/B _5160_/Q _5160_/D gf180mcu_as_sc_mcu7t3v3__mux2_2
XFILLER_112_142 VDD VDD VSS VSS gf180mcu_as_sc_mcu7t3v3__fillcap_4
XFILLER_140_440 VDD VDD VSS VSS gf180mcu_as_sc_mcu7t3v3__fillcap_8
Xfanout507 VDD VDD VSS VSS _3477_/B _3424_/B gf180mcu_as_sc_mcu7t3v3__buff_2
Xfanout518 VDD VDD VSS VSS _4334_/Y _4506_/A gf180mcu_as_sc_mcu7t3v3__buff_2
X_4294_ VDD VDD VSS VSS _4294_/B _4294_/A _4295_/B gf180mcu_as_sc_mcu7t3v3__xnor2_2
X_3314_ VDD VDD VSS VSS _3442_/B _3968_/A _3315_/D gf180mcu_as_sc_mcu7t3v3__or2_2
Xmesh_tile_911 VDD VDD VSS VSS nw_out[18] gf180mcu_as_sc_mcu7t3v3__tiel_4
Xmesh_tile_900 VDD VDD VSS VSS nw_out[7] gf180mcu_as_sc_mcu7t3v3__tiel_4
X_3245_ VDD VDD VSS VSS _3534_/A _3932_/A _3245_/C _3268_/A gf180mcu_as_sc_mcu7t3v3__nand3_2
XFILLER_132_18 VDD VDD VSS VSS gf180mcu_as_sc_mcu7t3v3__fillcap_16
XFILLER_80_1486 VDD VDD VSS VSS gf180mcu_as_sc_mcu7t3v3__fillcap_16
Xmesh_tile_944 VDD VDD VSS VSS sw_out[17] gf180mcu_as_sc_mcu7t3v3__tiel_4
Xmesh_tile_933 VDD VDD VSS VSS sw_out[6] gf180mcu_as_sc_mcu7t3v3__tiel_4
Xmesh_tile_922 VDD VDD VSS VSS nw_out[29] gf180mcu_as_sc_mcu7t3v3__tiel_4
XFILLER_66_251 VDD VDD VSS VSS gf180mcu_as_sc_mcu7t3v3__fill_1
Xmesh_tile_955 VDD VDD VSS VSS sw_out[28] gf180mcu_as_sc_mcu7t3v3__tiel_4
X_3176_ VDD VDD VSS VSS _3176_/S _4151_/A _4153_/A _3178_/B gf180mcu_as_sc_mcu7t3v3__mux2_2
XPHY_EDGE_ROW_145_Left_597 VDD VSS gf180mcu_as_sc_mcu7t3v3__tap_2
XFILLER_179_120 VDD VDD VSS VSS gf180mcu_as_sc_mcu7t3v3__fillcap_16
XFILLER_81_298 VDD VDD VSS VSS gf180mcu_as_sc_mcu7t3v3__fill_2
XFILLER_161_1216 VDD VDD VSS VSS gf180mcu_as_sc_mcu7t3v3__fill_1
XFILLER_179_142 VDD VDD VSS VSS gf180mcu_as_sc_mcu7t3v3__fillcap_4
XFILLER_165_1396 VDD VDD VSS VSS gf180mcu_as_sc_mcu7t3v3__fillcap_4
XFILLER_176_1481 VDD VDD VSS VSS gf180mcu_as_sc_mcu7t3v3__fill_2
XFILLER_1_225 VDD VDD VSS VSS gf180mcu_as_sc_mcu7t3v3__fillcap_4
XFILLER_103_142 VDD VDD VSS VSS gf180mcu_as_sc_mcu7t3v3__fillcap_16
XFILLER_172_1323 VDD VDD VSS VSS gf180mcu_as_sc_mcu7t3v3__fill_1
XFILLER_172_1367 VDD VDD VSS VSS gf180mcu_as_sc_mcu7t3v3__fillcap_8
XTAP_TAPCELL_ROW_166_1909 VDD VSS gf180mcu_as_sc_mcu7t3v3__tap_2
XFILLER_106_96 VDD VDD VSS VSS gf180mcu_as_sc_mcu7t3v3__fillcap_8
XTAP_TAPCELL_ROW_57_1_864 VDD VSS gf180mcu_as_sc_mcu7t3v3__tap_2
XPHY_EDGE_ROW_69_3_Right_388 VDD VSS gf180mcu_as_sc_mcu7t3v3__tap_2
XFILLER_174_2 VDD VDD VSS VSS gf180mcu_as_sc_mcu7t3v3__fillcap_16
XFILLER_17_104 VDD VDD VSS VSS gf180mcu_as_sc_mcu7t3v3__fillcap_16
XFILLER_72_221 VDD VDD VSS VSS gf180mcu_as_sc_mcu7t3v3__fillcap_16
XFILLER_122_51 VDD VDD VSS VSS gf180mcu_as_sc_mcu7t3v3__fill_2
XFILLER_2_1475 VDD VDD VSS VSS gf180mcu_as_sc_mcu7t3v3__fillcap_8
XPHY_EDGE_ROW_94_3_Left_228 VDD VSS gf180mcu_as_sc_mcu7t3v3__tap_2
XFILLER_183_1430 VDD VDD VSS VSS gf180mcu_as_sc_mcu7t3v3__fill_1
XFILLER_2_1486 VDD VDD VSS VSS gf180mcu_as_sc_mcu7t3v3__fillcap_16
XFILLER_32_107 VDD VDD VSS VSS gf180mcu_as_sc_mcu7t3v3__fillcap_16
XFILLER_159_827 VDD VDD VSS VSS gf180mcu_as_sc_mcu7t3v3__fillcap_8
XFILLER_57_1499 VDD VDD VSS VSS gf180mcu_as_sc_mcu7t3v3__fillcap_16
XFILLER_139_551 VDD VDD VSS VSS gf180mcu_as_sc_mcu7t3v3__fillcap_8
XFILLER_158_348 VDD VDD VSS VSS gf180mcu_as_sc_mcu7t3v3__fillcap_16
XFILLER_139_562 VDD VDD VSS VSS gf180mcu_as_sc_mcu7t3v3__fillcap_8
XTAP_TAPCELL_ROW_126_1_1141 VDD VSS gf180mcu_as_sc_mcu7t3v3__tap_2
XFILLER_166_381 VDD VDD VSS VSS gf180mcu_as_sc_mcu7t3v3__fillcap_4
XFILLER_56_8 VDD VDD VSS VSS gf180mcu_as_sc_mcu7t3v3__fillcap_4
XFILLER_181_384 VDD VDD VSS VSS gf180mcu_as_sc_mcu7t3v3__fillcap_16
XTAP_TAPCELL_ROW_106_1_1061 VDD VSS gf180mcu_as_sc_mcu7t3v3__tap_2
Xinput170 VDD VDD VSS VSS nw_in[31] _3513_/A gf180mcu_as_sc_mcu7t3v3__buff_2
Xinput181 VDD VDD VSS VSS se_in[0] _3934_/A gf180mcu_as_sc_mcu7t3v3__buff_2
X_3030_ VDD VDD VSS VSS _3031_/C _3030_/C _3125_/C _4008_/D gf180mcu_as_sc_mcu7t3v3__aoi21_2
XFILLER_149_1314 VDD VDD VSS VSS gf180mcu_as_sc_mcu7t3v3__fillcap_16
XFILLER_48_295 VDD VDD VSS VSS gf180mcu_as_sc_mcu7t3v3__fillcap_4
Xinput192 VDD VDD VSS VSS se_in[1] _3943_/A gf180mcu_as_sc_mcu7t3v3__buff_2
XFILLER_184_1216 VDD VDD VSS VSS gf180mcu_as_sc_mcu7t3v3__fill_1
XFILLER_63_298 VDD VDD VSS VSS gf180mcu_as_sc_mcu7t3v3__fill_2
X_4981_ VDD VDD VSS VSS _5183_/CLK _4981_/D _4981_/Q gf180mcu_as_sc_mcu7t3v3__dfxtp_2
XFILLER_177_602 VDD VDD VSS VSS gf180mcu_as_sc_mcu7t3v3__fill_2
X_3932_ VDD VDD VSS VSS _3932_/A _3932_/B _3932_/C _3932_/Y _3932_/D gf180mcu_as_sc_mcu7t3v3__aoi211_2
XFILLER_147_1082 VDD VDD VSS VSS gf180mcu_as_sc_mcu7t3v3__fill_2
XFILLER_176_101 VDD VDD VSS VSS gf180mcu_as_sc_mcu7t3v3__fillcap_4
XFILLER_176_123 VDD VDD VSS VSS gf180mcu_as_sc_mcu7t3v3__fillcap_16
X_3863_ VDD VDD VSS VSS _5140_/Q _5139_/Q _3864_/C gf180mcu_as_sc_mcu7t3v3__or2_2
XFILLER_149_348 VDD VDD VSS VSS gf180mcu_as_sc_mcu7t3v3__fill_2
X_2814_ VDD VDD VSS VSS _4974_/D _2825_/B _4756_/Q _4755_/D gf180mcu_as_sc_mcu7t3v3__mux2_2
XFILLER_158_893 VDD VDD VSS VSS gf180mcu_as_sc_mcu7t3v3__fill_2
X_3794_ VDD VDD VSS VSS _3794_/S _3794_/B _3794_/A _3795_/B gf180mcu_as_sc_mcu7t3v3__mux2_2
XFILLER_117_212 VDD VDD VSS VSS gf180mcu_as_sc_mcu7t3v3__fillcap_16
XFILLER_11_18 VDD VDD VSS VSS gf180mcu_as_sc_mcu7t3v3__fillcap_16
XFILLER_12_1550 VDD VDD VSS VSS gf180mcu_as_sc_mcu7t3v3__fillcap_4
XFILLER_160_1293 VDD VDD VSS VSS gf180mcu_as_sc_mcu7t3v3__fill_2
XFILLER_173_830 VDD VDD VSS VSS gf180mcu_as_sc_mcu7t3v3__fillcap_8
X_2745_ VDD VDD VSS VSS _2745_/B _2745_/A _2746_/B gf180mcu_as_sc_mcu7t3v3__xnor2_2
XTAP_TAPCELL_ROW_135_1234 VDD VSS gf180mcu_as_sc_mcu7t3v3__tap_2
XTAP_TAPCELL_ROW_135_1223 VDD VSS gf180mcu_as_sc_mcu7t3v3__tap_2
XFILLER_127_18 VDD VDD VSS VSS gf180mcu_as_sc_mcu7t3v3__fillcap_16
X_2676_ VDD VDD VSS VSS _2709_/A _2676_/B _2676_/C _2676_/D _2676_/Y gf180mcu_as_sc_mcu7t3v3__ao22_2
XFILLER_156_1329 VDD VDD VSS VSS gf180mcu_as_sc_mcu7t3v3__fillcap_8
X_4415_ VDD VDD VSS VSS _4416_/D _4415_/B _4589_/A gf180mcu_as_sc_mcu7t3v3__nor2_2
X_4346_ VDD VDD VSS VSS _4379_/B _4346_/B _5157_/Q _5157_/D gf180mcu_as_sc_mcu7t3v3__mux2_2
XTAP_TAPCELL_ROW_152_1592 VDD VSS gf180mcu_as_sc_mcu7t3v3__tap_2
XFILLER_100_123 VDD VDD VSS VSS gf180mcu_as_sc_mcu7t3v3__fillcap_16
X_4277_ VDD VDD VSS VSS _4281_/S _5481_/A _5111_/Q _5111_/D gf180mcu_as_sc_mcu7t3v3__mux2_2
X_3228_ VDD VDD VSS VSS _3228_/B _3228_/A _3229_/D gf180mcu_as_sc_mcu7t3v3__or2_2
XFILLER_36_37 VDD VDD VSS VSS gf180mcu_as_sc_mcu7t3v3__fillcap_16
XPHY_EDGE_ROW_153_Left_605 VDD VSS gf180mcu_as_sc_mcu7t3v3__tap_2
X_3159_ VDD VDD VSS VSS _3176_/S _4135_/D _4138_/A _3161_/B gf180mcu_as_sc_mcu7t3v3__mux2_2
XTAP_TAPCELL_ROW_161_1806 VDD VSS gf180mcu_as_sc_mcu7t3v3__tap_2
XFILLER_54_243 VDD VDD VSS VSS gf180mcu_as_sc_mcu7t3v3__fill_2
XTAP_TAPCELL_ROW_132_1_1162 VDD VSS gf180mcu_as_sc_mcu7t3v3__tap_2
XFILLER_14_107 VDD VDD VSS VSS gf180mcu_as_sc_mcu7t3v3__fillcap_16
XFILLER_165_1160 VDD VDD VSS VSS gf180mcu_as_sc_mcu7t3v3__fill_2
XFILLER_161_1002 VDD VDD VSS VSS gf180mcu_as_sc_mcu7t3v3__fill_2
XFILLER_168_624 VDD VDD VSS VSS gf180mcu_as_sc_mcu7t3v3__fill_2
XTAP_TAPCELL_ROW_159_1746 VDD VSS gf180mcu_as_sc_mcu7t3v3__tap_2
XFILLER_168_679 VDD VDD VSS VSS gf180mcu_as_sc_mcu7t3v3__fill_2
XFILLER_183_605 VDD VDD VSS VSS gf180mcu_as_sc_mcu7t3v3__fillcap_4
XTAP_TAPCELL_ROW_159_1757 VDD VSS gf180mcu_as_sc_mcu7t3v3__tap_2
XFILLER_143_1480 VDD VDD VSS VSS gf180mcu_as_sc_mcu7t3v3__fillcap_4
XFILLER_148_370 VDD VDD VSS VSS gf180mcu_as_sc_mcu7t3v3__fillcap_4
XFILLER_155_318 VDD VDD VSS VSS gf180mcu_as_sc_mcu7t3v3__fill_2
XFILLER_168_69 VDD VDD VSS VSS gf180mcu_as_sc_mcu7t3v3__fillcap_16
XFILLER_17_1483 VDD VDD VSS VSS gf180mcu_as_sc_mcu7t3v3__fillcap_16
XFILLER_183_616 VDD VDD VSS VSS gf180mcu_as_sc_mcu7t3v3__fillcap_8
XTAP_TAPCELL_ROW_112_1_1082 VDD VSS gf180mcu_as_sc_mcu7t3v3__tap_2
XFILLER_104_1486 VDD VDD VSS VSS gf180mcu_as_sc_mcu7t3v3__fillcap_16
XPHY_EDGE_ROW_162_Left_614 VDD VSS gf180mcu_as_sc_mcu7t3v3__tap_2
XFILLER_139_1527 VDD VDD VSS VSS gf180mcu_as_sc_mcu7t3v3__fillcap_8
XFILLER_184_24 VDD VDD VSS VSS gf180mcu_as_sc_mcu7t3v3__fillcap_8
XFILLER_163_373 VDD VDD VSS VSS gf180mcu_as_sc_mcu7t3v3__fill_2
XTAP_TAPCELL_ROW_91_1_1000 VDD VSS gf180mcu_as_sc_mcu7t3v3__tap_2
XFILLER_137_1251 VDD VDD VSS VSS gf180mcu_as_sc_mcu7t3v3__fill_1
XFILLER_137_1262 VDD VDD VSS VSS gf180mcu_as_sc_mcu7t3v3__fillcap_8
XFILLER_77_88 VDD VDD VSS VSS gf180mcu_as_sc_mcu7t3v3__fillcap_4
XPHY_EDGE_ROW_171_Left_623 VDD VSS gf180mcu_as_sc_mcu7t3v3__tap_2
XFILLER_133_72 VDD VDD VSS VSS gf180mcu_as_sc_mcu7t3v3__fill_2
XFILLER_150_1473 VDD VDD VSS VSS gf180mcu_as_sc_mcu7t3v3__fillcap_8
XPHY_EDGE_ROW_127_1_Left_579 VDD VSS gf180mcu_as_sc_mcu7t3v3__tap_2
XTAP_TAPCELL_ROW_39_1_793 VDD VSS gf180mcu_as_sc_mcu7t3v3__tap_2
XFILLER_45_276 VDD VDD VSS VSS gf180mcu_as_sc_mcu7t3v3__fillcap_4
XFILLER_93_87 VDD VDD VSS VSS gf180mcu_as_sc_mcu7t3v3__fillcap_4
XFILLER_45_298 VDD VDD VSS VSS gf180mcu_as_sc_mcu7t3v3__fill_2
XPHY_EDGE_ROW_64_1_Left_516 VDD VSS gf180mcu_as_sc_mcu7t3v3__tap_2
XFILLER_159_624 VDD VDD VSS VSS gf180mcu_as_sc_mcu7t3v3__fillcap_4
XFILLER_183_1282 VDD VDD VSS VSS gf180mcu_as_sc_mcu7t3v3__fill_1
XFILLER_140_1108 VDD VDD VSS VSS gf180mcu_as_sc_mcu7t3v3__fill_1
XFILLER_158_123 VDD VDD VSS VSS gf180mcu_as_sc_mcu7t3v3__fillcap_16
XPHY_EDGE_ROW_180_Left_632 VDD VSS gf180mcu_as_sc_mcu7t3v3__tap_2
XFILLER_146_329 VDD VDD VSS VSS gf180mcu_as_sc_mcu7t3v3__fillcap_16
XFILLER_173_104 VDD VDD VSS VSS gf180mcu_as_sc_mcu7t3v3__fillcap_16
XFILLER_42_80 VDD VDD VSS VSS gf180mcu_as_sc_mcu7t3v3__fillcap_8
XFILLER_139_392 VDD VDD VSS VSS gf180mcu_as_sc_mcu7t3v3__fill_2
XFILLER_155_830 VDD VDD VSS VSS gf180mcu_as_sc_mcu7t3v3__fillcap_8
XFILLER_174_649 VDD VDD VSS VSS gf180mcu_as_sc_mcu7t3v3__fill_1
XFILLER_155_885 VDD VDD VSS VSS gf180mcu_as_sc_mcu7t3v3__fillcap_8
X_2530_ VDD VDD VSS VSS _2541_/B _2530_/B _2534_/B gf180mcu_as_sc_mcu7t3v3__nor2b_2
X_2461_ VDD VDD VSS VSS _4447_/S _5032_/Q _5061_/Q _2462_/A gf180mcu_as_sc_mcu7t3v3__mux2_2
XFILLER_170_877 VDD VDD VSS VSS gf180mcu_as_sc_mcu7t3v3__fillcap_16
XFILLER_47_4 VDD VDD VSS VSS gf180mcu_as_sc_mcu7t3v3__fill_1
X_4200_ VDD VDD VSS VSS _4229_/B _4228_/B _4228_/C _5036_/Q _5036_/D gf180mcu_as_sc_mcu7t3v3__ao22_2
X_5180_ VDD VDD VSS VSS _5185_/CLK _5180_/D _5180_/Q gf180mcu_as_sc_mcu7t3v3__dfxtp_2
X_2392_ VDD VDD VSS VSS _3847_/A _4913_/Q gf180mcu_as_sc_mcu7t3v3__inv_2
XPHY_EDGE_ROW_88_1_Right_87 VDD VSS gf180mcu_as_sc_mcu7t3v3__tap_2
X_4131_ VDD VDD VSS VSS _4132_/D _4131_/C _4131_/B _4131_/A gf180mcu_as_sc_mcu7t3v3__aoi21_2
XFILLER_151_1259 VDD VDD VSS VSS gf180mcu_as_sc_mcu7t3v3__fill_1
X_4062_ VDD VDD VSS VSS _4101_/C _4062_/A _4063_/D gf180mcu_as_sc_mcu7t3v3__and2_2
XTAP_TAPCELL_ROW_182_2264 VDD VSS gf180mcu_as_sc_mcu7t3v3__tap_2
XTAP_TAPCELL_ROW_182_2253 VDD VSS gf180mcu_as_sc_mcu7t3v3__tap_2
XFILLER_95_187 VDD VDD VSS VSS gf180mcu_as_sc_mcu7t3v3__fillcap_16
X_3013_ VDD VDD VSS VSS _3992_/D _3239_/A _3013_/C _3013_/D _3014_/B gf180mcu_as_sc_mcu7t3v3__ao211_2
XFILLER_149_1122 VDD VDD VSS VSS gf180mcu_as_sc_mcu7t3v3__fillcap_8
XFILLER_149_1188 VDD VDD VSS VSS gf180mcu_as_sc_mcu7t3v3__fill_2
XFILLER_51_224 VDD VDD VSS VSS gf180mcu_as_sc_mcu7t3v3__fillcap_4
X_4964_ VDD VDD VSS VSS _5146_/CLK _4964_/D _4964_/Q gf180mcu_as_sc_mcu7t3v3__dfxtp_2
XFILLER_178_922 VDD VDD VSS VSS gf180mcu_as_sc_mcu7t3v3__fill_2
XFILLER_178_944 VDD VDD VSS VSS gf180mcu_as_sc_mcu7t3v3__fill_1
XFILLER_51_279 VDD VDD VSS VSS gf180mcu_as_sc_mcu7t3v3__fill_1
X_3915_ VDD VDD VSS VSS _3931_/B _3932_/D _3915_/A gf180mcu_as_sc_mcu7t3v3__nor2_2
XFILLER_177_454 VDD VDD VSS VSS gf180mcu_as_sc_mcu7t3v3__fillcap_16
XFILLER_178_966 VDD VDD VSS VSS gf180mcu_as_sc_mcu7t3v3__fill_2
X_4895_ VDD VDD VSS VSS _4928_/CLK _4895_/D _4895_/Q gf180mcu_as_sc_mcu7t3v3__dfxtp_2
XTAP_TAPCELL_ROW_48_1_828 VDD VSS gf180mcu_as_sc_mcu7t3v3__tap_2
XFILLER_137_318 VDD VDD VSS VSS gf180mcu_as_sc_mcu7t3v3__fill_1
XFILLER_165_616 VDD VDD VSS VSS gf180mcu_as_sc_mcu7t3v3__fillcap_8
XFILLER_178_999 VDD VDD VSS VSS gf180mcu_as_sc_mcu7t3v3__fill_2
X_3846_ VDD VDD VSS VSS _3847_/B _3847_/A _3846_/B _4914_/Q gf180mcu_as_sc_mcu7t3v3__aoi21_2
X_3777_ VDD VDD VSS VSS _3792_/D _4160_/D _3777_/B _3799_/D _3779_/C gf180mcu_as_sc_mcu7t3v3__ao31_2
XFILLER_146_852 VDD VDD VSS VSS gf180mcu_as_sc_mcu7t3v3__fill_2
XFILLER_146_874 VDD VDD VSS VSS gf180mcu_as_sc_mcu7t3v3__fill_1
X_2728_ VDD VDD VSS VSS _2735_/A _2728_/B _2728_/C _2735_/D _2730_/C gf180mcu_as_sc_mcu7t3v3__ao211_2
XTAP_TAPCELL_ROW_154_1654 VDD VSS gf180mcu_as_sc_mcu7t3v3__tap_2
XTAP_TAPCELL_ROW_154_1643 VDD VSS gf180mcu_as_sc_mcu7t3v3__tap_2
XFILLER_156_1148 VDD VDD VSS VSS gf180mcu_as_sc_mcu7t3v3__fillcap_4
XFILLER_161_877 VDD VDD VSS VSS gf180mcu_as_sc_mcu7t3v3__fill_1
Xoutput430 VDD VDD VSS VSS _4885_/Q west_out[12] gf180mcu_as_sc_mcu7t3v3__buff_2
Xoutput441 VDD VDD VSS VSS _4895_/Q west_out[22] gf180mcu_as_sc_mcu7t3v3__buff_2
Xoutput452 VDD VDD VSS VSS _4905_/Q west_out[32] gf180mcu_as_sc_mcu7t3v3__buff_2
X_2659_ VDD VDD VSS VSS _2831_/A _2659_/B _5266_/Q _2662_/C gf180mcu_as_sc_mcu7t3v3__mux2_2
XFILLER_160_387 VDD VDD VSS VSS gf180mcu_as_sc_mcu7t3v3__fill_2
XFILLER_134_1446 VDD VDD VSS VSS gf180mcu_as_sc_mcu7t3v3__fillcap_16
X_4329_ VDD VDD VSS VSS _4331_/D _4371_/B _4371_/A _4329_/A gf180mcu_as_sc_mcu7t3v3__aoi21b_2
XFILLER_86_154 VDD VDD VSS VSS gf180mcu_as_sc_mcu7t3v3__fill_1
XFILLER_170_37 VDD VDD VSS VSS gf180mcu_as_sc_mcu7t3v3__fillcap_16
XFILLER_47_58 VDD VDD VSS VSS gf180mcu_as_sc_mcu7t3v3__fill_1
XPHY_EDGE_ROW_106_3_Left_240 VDD VSS gf180mcu_as_sc_mcu7t3v3__tap_2
XTAP_TAPCELL_ROW_27_1_742 VDD VSS gf180mcu_as_sc_mcu7t3v3__tap_2
XFILLER_167_1255 VDD VDD VSS VSS gf180mcu_as_sc_mcu7t3v3__fillcap_4
XFILLER_27_276 VDD VDD VSS VSS gf180mcu_as_sc_mcu7t3v3__fillcap_4
XFILLER_63_24 VDD VDD VSS VSS gf180mcu_as_sc_mcu7t3v3__fillcap_8
XFILLER_163_1108 VDD VDD VSS VSS gf180mcu_as_sc_mcu7t3v3__fill_1
XFILLER_27_298 VDD VDD VSS VSS gf180mcu_as_sc_mcu7t3v3__fill_2
XFILLER_58_1550 VDD VDD VSS VSS gf180mcu_as_sc_mcu7t3v3__fillcap_4
XFILLER_145_1542 VDD VDD VSS VSS gf180mcu_as_sc_mcu7t3v3__fill_2
XFILLER_42_279 VDD VDD VSS VSS gf180mcu_as_sc_mcu7t3v3__fillcap_16
XFILLER_169_955 VDD VDD VSS VSS gf180mcu_as_sc_mcu7t3v3__fillcap_8
XFILLER_137_2 VDD VDD VSS VSS gf180mcu_as_sc_mcu7t3v3__fillcap_16
XFILLER_155_104 VDD VDD VSS VSS gf180mcu_as_sc_mcu7t3v3__fillcap_16
XFILLER_168_465 VDD VDD VSS VSS gf180mcu_as_sc_mcu7t3v3__fillcap_4
XFILLER_169_999 VDD VDD VSS VSS gf180mcu_as_sc_mcu7t3v3__fill_2
XFILLER_137_830 VDD VDD VSS VSS gf180mcu_as_sc_mcu7t3v3__fillcap_8
XFILLER_156_649 VDD VDD VSS VSS gf180mcu_as_sc_mcu7t3v3__fill_2
XFILLER_170_107 VDD VDD VSS VSS gf180mcu_as_sc_mcu7t3v3__fillcap_16
XFILLER_136_384 VDD VDD VSS VSS gf180mcu_as_sc_mcu7t3v3__fill_1
XFILLER_178_1362 VDD VDD VSS VSS gf180mcu_as_sc_mcu7t3v3__fill_2
XFILLER_152_877 VDD VDD VSS VSS gf180mcu_as_sc_mcu7t3v3__fillcap_16
XFILLER_65_1521 VDD VDD VSS VSS gf180mcu_as_sc_mcu7t3v3__fillcap_16
XFILLER_174_1259 VDD VDD VSS VSS gf180mcu_as_sc_mcu7t3v3__fillcap_8
XFILLER_137_1070 VDD VDD VSS VSS gf180mcu_as_sc_mcu7t3v3__fill_1
XFILLER_152_1535 VDD VDD VSS VSS gf180mcu_as_sc_mcu7t3v3__fill_2
XFILLER_77_121 VDD VDD VSS VSS gf180mcu_as_sc_mcu7t3v3__fill_1
XFILLER_77_176 VDD VDD VSS VSS gf180mcu_as_sc_mcu7t3v3__fill_2
XFILLER_92_102 VDD VDD VSS VSS gf180mcu_as_sc_mcu7t3v3__fill_2
XPHY_EDGE_ROW_38_3_Left_172 VDD VSS gf180mcu_as_sc_mcu7t3v3__tap_2
Xfanout690 VDD VDD VSS VSS _3145_/A _3120_/A gf180mcu_as_sc_mcu7t3v3__buff_2
XFILLER_92_146 VDD VDD VSS VSS gf180mcu_as_sc_mcu7t3v3__fillcap_16
Xclkbuf_leaf_36_clk_regs VDD VDD VSS VSS clkbuf_3_5_0_clk_regs/Y _5088_/CLK gf180mcu_as_sc_mcu7t3v3__clkbuff_12
XTAP_TAPCELL_ROW_88_1_988 VDD VSS gf180mcu_as_sc_mcu7t3v3__tap_2
XFILLER_159_410 VDD VDD VSS VSS gf180mcu_as_sc_mcu7t3v3__fill_2
XFILLER_175_903 VDD VDD VSS VSS gf180mcu_as_sc_mcu7t3v3__fill_1
X_3700_ VDD VDD VSS VSS _4080_/A _3749_/B _3748_/C _4079_/A _3701_/C gf180mcu_as_sc_mcu7t3v3__ao22_2
XFILLER_159_487 VDD VDD VSS VSS gf180mcu_as_sc_mcu7t3v3__fill_2
X_4680_ VDD VDD VSS VSS _5247_/D _5101_/Q _4680_/B _4680_/C gf180mcu_as_sc_mcu7t3v3__ao21_2
XFILLER_174_435 VDD VDD VSS VSS gf180mcu_as_sc_mcu7t3v3__fillcap_16
XFILLER_175_947 VDD VDD VSS VSS gf180mcu_as_sc_mcu7t3v3__fill_2
XFILLER_179_1115 VDD VDD VSS VSS gf180mcu_as_sc_mcu7t3v3__fill_1
X_3631_ VDD VDD VSS VSS _4003_/A _3746_/B _3631_/C _4847_/D _3746_/D gf180mcu_as_sc_mcu7t3v3__aoi211_2
XTAP_TAPCELL_ROW_44_1_812 VDD VSS gf180mcu_as_sc_mcu7t3v3__tap_2
XFILLER_143_800 VDD VDD VSS VSS gf180mcu_as_sc_mcu7t3v3__fill_2
XFILLER_174_457 VDD VDD VSS VSS gf180mcu_as_sc_mcu7t3v3__fillcap_16
X_3562_ VDD VDD VSS VSS _3562_/Y _3562_/B _3562_/A gf180mcu_as_sc_mcu7t3v3__nor2b_2
XFILLER_157_1402 VDD VDD VSS VSS gf180mcu_as_sc_mcu7t3v3__fillcap_16
X_2513_ VDD VDD VSS VSS _4684_/A _2747_/A _2847_/A _4663_/A gf180mcu_as_sc_mcu7t3v3__nand3_2
X_3493_ VDD VDD VSS VSS _4942_/Q _3493_/B _3501_/B _4152_/A _3495_/C gf180mcu_as_sc_mcu7t3v3__ao22_2
XFILLER_157_1468 VDD VDD VSS VSS gf180mcu_as_sc_mcu7t3v3__fill_2
X_5232_ VDD VDD VSS VSS _5266_/CLK _5232_/D _5232_/Q gf180mcu_as_sc_mcu7t3v3__dfxtp_2
X_2444_ VDD VDD VSS VSS _4115_/A _2444_/A gf180mcu_as_sc_mcu7t3v3__inv_2
XTAP_TAPCELL_ROW_184_2315 VDD VSS gf180mcu_as_sc_mcu7t3v3__tap_2
XTAP_TAPCELL_ROW_184_2304 VDD VSS gf180mcu_as_sc_mcu7t3v3__tap_2
XFILLER_142_398 VDD VDD VSS VSS gf180mcu_as_sc_mcu7t3v3__fillcap_8
XFILLER_155_1170 VDD VDD VSS VSS gf180mcu_as_sc_mcu7t3v3__fillcap_16
XFILLER_68_121 VDD VDD VSS VSS gf180mcu_as_sc_mcu7t3v3__fillcap_16
X_5163_ VDD VDD VSS VSS _5164_/CLK _5163_/D _5163_/Q gf180mcu_as_sc_mcu7t3v3__dfxtp_2
XTAP_TAPCELL_ROW_184_2337 VDD VSS gf180mcu_as_sc_mcu7t3v3__tap_2
XTAP_TAPCELL_ROW_184_2326 VDD VSS gf180mcu_as_sc_mcu7t3v3__tap_2
XFILLER_155_1192 VDD VDD VSS VSS gf180mcu_as_sc_mcu7t3v3__fillcap_16
X_4114_ VDD VDD VSS VSS _4115_/D _4114_/C _4131_/B _4114_/A gf180mcu_as_sc_mcu7t3v3__aoi21_2
XFILLER_68_165 VDD VDD VSS VSS gf180mcu_as_sc_mcu7t3v3__fill_2
XFILLER_68_198 VDD VDD VSS VSS gf180mcu_as_sc_mcu7t3v3__fill_1
X_5094_ VDD VDD VSS VSS _5094_/CLK _5094_/D _5094_/Q gf180mcu_as_sc_mcu7t3v3__dfxtp_2
X_4045_ VDD VDD VSS VSS _4045_/A _4129_/B _4152_/C _4929_/Q _4047_/C gf180mcu_as_sc_mcu7t3v3__ao22_2
XTAP_TAPCELL_ROW_147_1480 VDD VSS gf180mcu_as_sc_mcu7t3v3__tap_2
XTAP_TAPCELL_ROW_147_1491 VDD VSS gf180mcu_as_sc_mcu7t3v3__tap_2
XFILLER_129_1515 VDD VDD VSS VSS gf180mcu_as_sc_mcu7t3v3__fillcap_4
XFILLER_129_1537 VDD VDD VSS VSS gf180mcu_as_sc_mcu7t3v3__fillcap_4
XFILLER_164_1428 VDD VDD VSS VSS gf180mcu_as_sc_mcu7t3v3__fillcap_4
XTAP_TAPCELL_ROW_143_1399 VDD VSS gf180mcu_as_sc_mcu7t3v3__tap_2
X_4947_ VDD VDD VSS VSS clkload3/A _4947_/D _4947_/Q gf180mcu_as_sc_mcu7t3v3__dfxtp_2
XFILLER_137_104 VDD VDD VSS VSS gf180mcu_as_sc_mcu7t3v3__fillcap_16
XFILLER_178_785 VDD VDD VSS VSS gf180mcu_as_sc_mcu7t3v3__fillcap_4
X_4878_ VDD VDD VSS VSS _4938_/CLK _4878_/D _4878_/Q gf180mcu_as_sc_mcu7t3v3__dfxtp_2
XFILLER_137_126 VDD VDD VSS VSS gf180mcu_as_sc_mcu7t3v3__fillcap_8
XFILLER_166_947 VDD VDD VSS VSS gf180mcu_as_sc_mcu7t3v3__fillcap_8
X_3829_ VDD VDD VSS VSS _4752_/B _3835_/B _4909_/Q gf180mcu_as_sc_mcu7t3v3__nor2_2
XFILLER_101_1467 VDD VDD VSS VSS gf180mcu_as_sc_mcu7t3v3__fillcap_16
XFILLER_140_1483 VDD VDD VSS VSS gf180mcu_as_sc_mcu7t3v3__fill_1
XFILLER_14_1486 VDD VDD VSS VSS gf180mcu_as_sc_mcu7t3v3__fillcap_16
XFILLER_152_107 VDD VDD VSS VSS gf180mcu_as_sc_mcu7t3v3__fillcap_16
XFILLER_174_991 VDD VDD VSS VSS gf180mcu_as_sc_mcu7t3v3__fillcap_8
XFILLER_175_1535 VDD VDD VSS VSS gf180mcu_as_sc_mcu7t3v3__fillcap_4
XFILLER_173_1270 VDD VDD VSS VSS gf180mcu_as_sc_mcu7t3v3__fill_2
XFILLER_101_240 VDD VDD VSS VSS gf180mcu_as_sc_mcu7t3v3__fillcap_16
XFILLER_134_1254 VDD VDD VSS VSS gf180mcu_as_sc_mcu7t3v3__fillcap_4
XFILLER_134_1276 VDD VDD VSS VSS gf180mcu_as_sc_mcu7t3v3__fillcap_16
XFILLER_181_69 VDD VDD VSS VSS gf180mcu_as_sc_mcu7t3v3__fill_1
XFILLER_59_176 VDD VDD VSS VSS gf180mcu_as_sc_mcu7t3v3__fillcap_16
XFILLER_60_1451 VDD VDD VSS VSS gf180mcu_as_sc_mcu7t3v3__fillcap_16
XFILLER_167_1052 VDD VDD VSS VSS gf180mcu_as_sc_mcu7t3v3__fillcap_16
XFILLER_74_89 VDD VDD VSS VSS gf180mcu_as_sc_mcu7t3v3__fill_2
XFILLER_90_88 VDD VDD VSS VSS gf180mcu_as_sc_mcu7t3v3__fillcap_4
XTAP_TAPCELL_ROW_84_1_972 VDD VSS gf180mcu_as_sc_mcu7t3v3__tap_2
XFILLER_168_295 VDD VDD VSS VSS gf180mcu_as_sc_mcu7t3v3__fillcap_16
XFILLER_128_148 VDD VDD VSS VSS gf180mcu_as_sc_mcu7t3v3__fill_2
XFILLER_156_457 VDD VDD VSS VSS gf180mcu_as_sc_mcu7t3v3__fillcap_8
XFILLER_184_777 VDD VDD VSS VSS gf180mcu_as_sc_mcu7t3v3__fillcap_4
XFILLER_32_1564 VDD VDD VSS VSS gf180mcu_as_sc_mcu7t3v3__fillcap_4
XFILLER_171_416 VDD VDD VSS VSS gf180mcu_as_sc_mcu7t3v3__fillcap_4
XFILLER_171_438 VDD VDD VSS VSS gf180mcu_as_sc_mcu7t3v3__fillcap_16
XFILLER_183_298 VDD VDD VSS VSS gf180mcu_as_sc_mcu7t3v3__fillcap_16
XFILLER_136_181 VDD VDD VSS VSS gf180mcu_as_sc_mcu7t3v3__fill_1
XFILLER_174_1001 VDD VDD VSS VSS gf180mcu_as_sc_mcu7t3v3__fill_1
XFILLER_174_1045 VDD VDD VSS VSS gf180mcu_as_sc_mcu7t3v3__fillcap_8
XFILLER_135_1029 VDD VDD VSS VSS gf180mcu_as_sc_mcu7t3v3__fillcap_8
XFILLER_152_1321 VDD VDD VSS VSS gf180mcu_as_sc_mcu7t3v3__fill_2
XFILLER_48_90 VDD VDD VSS VSS gf180mcu_as_sc_mcu7t3v3__fill_2
XFILLER_0_86 VDD VDD VSS VSS gf180mcu_as_sc_mcu7t3v3__fillcap_16
XFILLER_146_1114 VDD VDD VSS VSS gf180mcu_as_sc_mcu7t3v3__fillcap_16
XFILLER_181_1049 VDD VDD VSS VSS gf180mcu_as_sc_mcu7t3v3__fill_1
X_4801_ VDD VDD VSS VSS _4869_/CLK _4801_/D _4801_/Q gf180mcu_as_sc_mcu7t3v3__dfxtp_2
X_2993_ VDD VDD VSS VSS _3974_/A _3127_/B _3127_/C _3973_/D _2994_/C gf180mcu_as_sc_mcu7t3v3__ao22_2
XTAP_TAPCELL_ROW_177_2152 VDD VSS gf180mcu_as_sc_mcu7t3v3__tap_2
XTAP_TAPCELL_ROW_177_2141 VDD VSS gf180mcu_as_sc_mcu7t3v3__tap_2
XFILLER_147_402 VDD VDD VSS VSS gf180mcu_as_sc_mcu7t3v3__fillcap_16
XFILLER_163_1472 VDD VDD VSS VSS gf180mcu_as_sc_mcu7t3v3__fillcap_16
X_4732_ VDD VDD VSS VSS _5267_/D _5267_/Q _4732_/B _4732_/C gf180mcu_as_sc_mcu7t3v3__ao21_2
XFILLER_124_1467 VDD VDD VSS VSS gf180mcu_as_sc_mcu7t3v3__fillcap_16
XFILLER_148_947 VDD VDD VSS VSS gf180mcu_as_sc_mcu7t3v3__fill_2
XFILLER_159_295 VDD VDD VSS VSS gf180mcu_as_sc_mcu7t3v3__fillcap_8
X_4663_ VDD VDD VSS VSS _4666_/B _4708_/C _4663_/B _4663_/A gf180mcu_as_sc_mcu7t3v3__aoi21_2
XFILLER_175_788 VDD VDD VSS VSS gf180mcu_as_sc_mcu7t3v3__fillcap_4
X_3614_ VDD VDD VSS VSS _3615_/C _3614_/C _3729_/B _3985_/A gf180mcu_as_sc_mcu7t3v3__aoi21_2
XTAP_TAPCELL_ROW_18_1_706 VDD VSS gf180mcu_as_sc_mcu7t3v3__tap_2
XTAP_TAPCELL_ROW_125_1_1137 VDD VSS gf180mcu_as_sc_mcu7t3v3__tap_2
XFILLER_156_991 VDD VDD VSS VSS gf180mcu_as_sc_mcu7t3v3__fillcap_8
X_4594_ VDD VDD VSS VSS _4594_/Y _4742_/C _4594_/A gf180mcu_as_sc_mcu7t3v3__nor2_2
XTAP_TAPCELL_ROW_26_1_741 VDD VSS gf180mcu_as_sc_mcu7t3v3__tap_2
X_3545_ VDD VDD VSS VSS _3563_/B _3797_/C _3798_/A gf180mcu_as_sc_mcu7t3v3__nand2_2
X_3476_ VDD VDD VSS VSS _4131_/A _3476_/B _3476_/C _3477_/C _3477_/B gf180mcu_as_sc_mcu7t3v3__aoi211_2
XFILLER_153_1118 VDD VDD VSS VSS gf180mcu_as_sc_mcu7t3v3__fill_2
XFILLER_170_1410 VDD VDD VSS VSS gf180mcu_as_sc_mcu7t3v3__fillcap_16
XFILLER_170_493 VDD VDD VSS VSS gf180mcu_as_sc_mcu7t3v3__fill_1
XFILLER_83_1451 VDD VDD VSS VSS gf180mcu_as_sc_mcu7t3v3__fillcap_16
X_5215_ VDD VDD VSS VSS clkload0/A _5215_/D _5215_/Q gf180mcu_as_sc_mcu7t3v3__dfxtp_2
X_2427_ VDD VDD VSS VSS _3971_/A _2427_/A gf180mcu_as_sc_mcu7t3v3__inv_2
XTAP_TAPCELL_ROW_105_1_1057 VDD VSS gf180mcu_as_sc_mcu7t3v3__tap_2
XTAP_TAPCELL_ROW_149_1531 VDD VSS gf180mcu_as_sc_mcu7t3v3__tap_2
X_5146_ VDD VDD VSS VSS _5146_/CLK _5146_/D _5146_/Q gf180mcu_as_sc_mcu7t3v3__dfxtp_2
XTAP_TAPCELL_ROW_149_1542 VDD VSS gf180mcu_as_sc_mcu7t3v3__tap_2
X_5077_ VDD VDD VSS VSS _5080_/CLK _5077_/D _5077_/Q gf180mcu_as_sc_mcu7t3v3__dfxtp_2
XTAP_TAPCELL_ROW_145_1439 VDD VSS gf180mcu_as_sc_mcu7t3v3__tap_2
X_4028_ VDD VDD VSS VSS _4989_/Q _4117_/B _4240_/B _4108_/D _4989_/D gf180mcu_as_sc_mcu7t3v3__ao22_2
XFILLER_71_138 VDD VDD VSS VSS gf180mcu_as_sc_mcu7t3v3__fill_2
XFILLER_44_37 VDD VDD VSS VSS gf180mcu_as_sc_mcu7t3v3__fill_1
XPHY_EDGE_ROW_154_Right_288 VDD VSS gf180mcu_as_sc_mcu7t3v3__tap_2
XFILLER_100_10 VDD VDD VSS VSS gf180mcu_as_sc_mcu7t3v3__fillcap_4
XFILLER_164_1269 VDD VDD VSS VSS gf180mcu_as_sc_mcu7t3v3__fill_1
XPHY_EDGE_ROW_40_1_Right_39 VDD VSS gf180mcu_as_sc_mcu7t3v3__tap_2
XFILLER_55_1553 VDD VDD VSS VSS gf180mcu_as_sc_mcu7t3v3__fillcap_16
XFILLER_8_209 VDD VDD VSS VSS gf180mcu_as_sc_mcu7t3v3__fillcap_16
XFILLER_178_593 VDD VDD VSS VSS gf180mcu_as_sc_mcu7t3v3__fill_2
XFILLER_138_457 VDD VDD VSS VSS gf180mcu_as_sc_mcu7t3v3__fillcap_8
XFILLER_154_906 VDD VDD VSS VSS gf180mcu_as_sc_mcu7t3v3__fillcap_16
XFILLER_20_271 VDD VDD VSS VSS gf180mcu_as_sc_mcu7t3v3__fillcap_4
XFILLER_176_69 VDD VDD VSS VSS gf180mcu_as_sc_mcu7t3v3__fillcap_16
XFILLER_118_181 VDD VDD VSS VSS gf180mcu_as_sc_mcu7t3v3__fill_2
XFILLER_134_630 VDD VDD VSS VSS gf180mcu_as_sc_mcu7t3v3__fill_1
XFILLER_165_298 VDD VDD VSS VSS gf180mcu_as_sc_mcu7t3v3__fillcap_8
XFILLER_175_1321 VDD VDD VSS VSS gf180mcu_as_sc_mcu7t3v3__fill_2
XFILLER_175_1332 VDD VDD VSS VSS gf180mcu_as_sc_mcu7t3v3__fill_2
XFILLER_175_1354 VDD VDD VSS VSS gf180mcu_as_sc_mcu7t3v3__fillcap_4
XFILLER_175_1365 VDD VDD VSS VSS gf180mcu_as_sc_mcu7t3v3__fillcap_8
XFILLER_180_279 VDD VDD VSS VSS gf180mcu_as_sc_mcu7t3v3__fillcap_16
XFILLER_175_1398 VDD VDD VSS VSS gf180mcu_as_sc_mcu7t3v3__fill_2
XFILLER_62_1502 VDD VDD VSS VSS gf180mcu_as_sc_mcu7t3v3__fillcap_16
XPHY_EDGE_ROW_73_1_Left_525 VDD VSS gf180mcu_as_sc_mcu7t3v3__tap_2
XFILLER_125_95 VDD VDD VSS VSS gf180mcu_as_sc_mcu7t3v3__fillcap_8
XFILLER_62_1568 VDD VDD VSS VSS gf180mcu_as_sc_mcu7t3v3__fill_1
XFILLER_5_1451 VDD VDD VSS VSS gf180mcu_as_sc_mcu7t3v3__fillcap_16
XFILLER_87_282 VDD VDD VSS VSS gf180mcu_as_sc_mcu7t3v3__fillcap_16
XFILLER_47_157 VDD VDD VSS VSS gf180mcu_as_sc_mcu7t3v3__fillcap_4
XFILLER_85_88 VDD VDD VSS VSS gf180mcu_as_sc_mcu7t3v3__fillcap_4
XFILLER_141_50 VDD VDD VSS VSS gf180mcu_as_sc_mcu7t3v3__fillcap_16
XFILLER_141_72 VDD VDD VSS VSS gf180mcu_as_sc_mcu7t3v3__fillcap_16
XFILLER_147_1445 VDD VDD VSS VSS gf180mcu_as_sc_mcu7t3v3__fillcap_8
XTAP_TAPCELL_ROW_131_1_1158 VDD VSS gf180mcu_as_sc_mcu7t3v3__tap_2
XPHY_EDGE_ROW_97_1_Right_96 VDD VSS gf180mcu_as_sc_mcu7t3v3__tap_2
XFILLER_141_1033 VDD VDD VSS VSS gf180mcu_as_sc_mcu7t3v3__fill_2
XTAP_TAPCELL_ROW_58_1_866 VDD VSS gf180mcu_as_sc_mcu7t3v3__tap_2
XFILLER_11_260 VDD VDD VSS VSS gf180mcu_as_sc_mcu7t3v3__fillcap_16
XFILLER_11_282 VDD VDD VSS VSS gf180mcu_as_sc_mcu7t3v3__fillcap_16
XFILLER_145_906 VDD VDD VSS VSS gf180mcu_as_sc_mcu7t3v3__fillcap_4
XFILLER_156_243 VDD VDD VSS VSS gf180mcu_as_sc_mcu7t3v3__fill_2
XFILLER_180_1093 VDD VDD VSS VSS gf180mcu_as_sc_mcu7t3v3__fillcap_16
XTAP_TAPCELL_ROW_111_1_1078 VDD VSS gf180mcu_as_sc_mcu7t3v3__tap_2
XFILLER_144_416 VDD VDD VSS VSS gf180mcu_as_sc_mcu7t3v3__fillcap_8
XFILLER_145_939 VDD VDD VSS VSS gf180mcu_as_sc_mcu7t3v3__fillcap_8
XFILLER_157_788 VDD VDD VSS VSS gf180mcu_as_sc_mcu7t3v3__fillcap_8
X_3330_ VDD VDD VSS VSS _3442_/B _3983_/A _3331_/D gf180mcu_as_sc_mcu7t3v3__or2_2
X_5000_ VDD VDD VSS VSS _5188_/CLK _5000_/D _5000_/Q gf180mcu_as_sc_mcu7t3v3__dfxtp_2
X_3261_ VDD VDD VSS VSS _3263_/B _3261_/B _3776_/A gf180mcu_as_sc_mcu7t3v3__nand2_2
X_3192_ VDD VDD VSS VSS _3193_/D _3192_/A _3240_/B _3239_/A _3192_/D gf180mcu_as_sc_mcu7t3v3__aoi22_2
XFILLER_15_2 VDD VDD VSS VSS gf180mcu_as_sc_mcu7t3v3__fillcap_16
XFILLER_93_230 VDD VDD VSS VSS gf180mcu_as_sc_mcu7t3v3__fillcap_16
XFILLER_53_138 VDD VDD VSS VSS gf180mcu_as_sc_mcu7t3v3__fill_2
XTAP_TAPCELL_ROW_179_2203 VDD VSS gf180mcu_as_sc_mcu7t3v3__tap_2
XFILLER_39_1515 VDD VDD VSS VSS gf180mcu_as_sc_mcu7t3v3__fillcap_4
XFILLER_39_1537 VDD VDD VSS VSS gf180mcu_as_sc_mcu7t3v3__fillcap_16
XFILLER_78_1564 VDD VDD VSS VSS gf180mcu_as_sc_mcu7t3v3__fillcap_4
XTAP_TAPCELL_ROW_140_1336 VDD VSS gf180mcu_as_sc_mcu7t3v3__tap_2
XFILLER_126_1518 VDD VDD VSS VSS gf180mcu_as_sc_mcu7t3v3__fillcap_16
XFILLER_14_18 VDD VDD VSS VSS gf180mcu_as_sc_mcu7t3v3__fillcap_16
XFILLER_179_346 VDD VDD VSS VSS gf180mcu_as_sc_mcu7t3v3__fillcap_4
XTAP_TAPCELL_ROW_140_1347 VDD VSS gf180mcu_as_sc_mcu7t3v3__tap_2
XFILLER_179_368 VDD VDD VSS VSS gf180mcu_as_sc_mcu7t3v3__fillcap_16
XFILLER_148_733 VDD VDD VSS VSS gf180mcu_as_sc_mcu7t3v3__fill_2
X_2976_ VDD VDD VSS VSS _3959_/A _3152_/B _3152_/C _3958_/A _2977_/C gf180mcu_as_sc_mcu7t3v3__ao22_2
XFILLER_148_766 VDD VDD VSS VSS gf180mcu_as_sc_mcu7t3v3__fillcap_16
XFILLER_175_552 VDD VDD VSS VSS gf180mcu_as_sc_mcu7t3v3__fill_1
X_4715_ VDD VDD VSS VSS _4717_/S _5260_/Q _5261_/Q _4716_/B gf180mcu_as_sc_mcu7t3v3__mux2_2
XFILLER_148_799 VDD VDD VSS VSS gf180mcu_as_sc_mcu7t3v3__fillcap_4
X_4646_ VDD VDD VSS VSS _4646_/D _4733_/A _5235_/Q _4646_/C _4647_/C gf180mcu_as_sc_mcu7t3v3__ao31_2
XTAP_TAPCELL_ROW_138_1287 VDD VSS gf180mcu_as_sc_mcu7t3v3__tap_2
XFILLER_107_129 VDD VDD VSS VSS gf180mcu_as_sc_mcu7t3v3__fillcap_8
XFILLER_11_1467 VDD VDD VSS VSS gf180mcu_as_sc_mcu7t3v3__fillcap_16
XFILLER_147_298 VDD VDD VSS VSS gf180mcu_as_sc_mcu7t3v3__fillcap_8
XFILLER_50_1483 VDD VDD VSS VSS gf180mcu_as_sc_mcu7t3v3__fill_1
X_4577_ VDD VDD VSS VSS _4581_/B _5087_/Q _4579_/S gf180mcu_as_sc_mcu7t3v3__nand2_2
XTAP_TAPCELL_ROW_138_1298 VDD VSS gf180mcu_as_sc_mcu7t3v3__tap_2
XPHY_EDGE_ROW_3_1_Right_2 VDD VSS gf180mcu_as_sc_mcu7t3v3__tap_2
X_3528_ VDD VDD VSS VSS _3922_/B _3528_/B _3528_/A gf180mcu_as_sc_mcu7t3v3__nor2b_2
XFILLER_162_16 VDD VDD VSS VSS gf180mcu_as_sc_mcu7t3v3__fillcap_16
XFILLER_39_37 VDD VDD VSS VSS gf180mcu_as_sc_mcu7t3v3__fill_1
X_3459_ VDD VDD VSS VSS _3460_/A _4109_/D _3475_/B _3459_/C gf180mcu_as_sc_mcu7t3v3__ao21_2
XTAP_TAPCELL_ROW_75_1_936 VDD VSS gf180mcu_as_sc_mcu7t3v3__tap_2
XFILLER_130_187 VDD VDD VSS VSS gf180mcu_as_sc_mcu7t3v3__fillcap_8
XFILLER_76_219 VDD VDD VSS VSS gf180mcu_as_sc_mcu7t3v3__fillcap_16
XTAP_TAPCELL_ROW_168_1962 VDD VSS gf180mcu_as_sc_mcu7t3v3__tap_2
XTAP_TAPCELL_ROW_168_1951 VDD VSS gf180mcu_as_sc_mcu7t3v3__tap_2
XFILLER_69_282 VDD VDD VSS VSS gf180mcu_as_sc_mcu7t3v3__fillcap_16
X_5129_ VDD VDD VSS VSS _5199_/CLK _5129_/D _5129_/Q gf180mcu_as_sc_mcu7t3v3__dfxtp_2
XFILLER_29_146 VDD VDD VSS VSS gf180mcu_as_sc_mcu7t3v3__fill_2
XFILLER_84_241 VDD VDD VSS VSS gf180mcu_as_sc_mcu7t3v3__fillcap_4
XTAP_TAPCELL_ROW_164_1859 VDD VSS gf180mcu_as_sc_mcu7t3v3__tap_2
XFILLER_37_190 VDD VDD VSS VSS gf180mcu_as_sc_mcu7t3v3__fillcap_16
XFILLER_44_149 VDD VDD VSS VSS gf180mcu_as_sc_mcu7t3v3__fill_1
XFILLER_168_1191 VDD VDD VSS VSS gf180mcu_as_sc_mcu7t3v3__fillcap_8
XFILLER_111_86 VDD VDD VSS VSS gf180mcu_as_sc_mcu7t3v3__fillcap_4
XFILLER_71_35 VDD VDD VSS VSS gf180mcu_as_sc_mcu7t3v3__fill_2
XFILLER_107_1451 VDD VDD VSS VSS gf180mcu_as_sc_mcu7t3v3__fillcap_16
XFILLER_139_766 VDD VDD VSS VSS gf180mcu_as_sc_mcu7t3v3__fillcap_4
XFILLER_142_1364 VDD VDD VSS VSS gf180mcu_as_sc_mcu7t3v3__fill_1
XFILLER_142_1375 VDD VDD VSS VSS gf180mcu_as_sc_mcu7t3v3__fill_2
XFILLER_139_788 VDD VDD VSS VSS gf180mcu_as_sc_mcu7t3v3__fillcap_8
XFILLER_153_202 VDD VDD VSS VSS gf180mcu_as_sc_mcu7t3v3__fillcap_8
XPHY_EDGE_ROW_47_3_Left_181 VDD VSS gf180mcu_as_sc_mcu7t3v3__tap_2
XTAP_TAPCELL_ROW_54_1_850 VDD VSS gf180mcu_as_sc_mcu7t3v3__tap_2
XFILLER_177_1427 VDD VDD VSS VSS gf180mcu_as_sc_mcu7t3v3__fillcap_4
XFILLER_134_460 VDD VDD VSS VSS gf180mcu_as_sc_mcu7t3v3__fillcap_16
XFILLER_150_942 VDD VDD VSS VSS gf180mcu_as_sc_mcu7t3v3__fill_2
XFILLER_175_1162 VDD VDD VSS VSS gf180mcu_as_sc_mcu7t3v3__fill_1
XFILLER_96_10 VDD VDD VSS VSS gf180mcu_as_sc_mcu7t3v3__fillcap_4
XFILLER_136_1157 VDD VDD VSS VSS gf180mcu_as_sc_mcu7t3v3__fillcap_4
XFILLER_171_1037 VDD VDD VSS VSS gf180mcu_as_sc_mcu7t3v3__fill_2
XFILLER_121_165 VDD VDD VSS VSS gf180mcu_as_sc_mcu7t3v3__fillcap_4
XTAP_TAPCELL_ROW_17_1_705 VDD VSS gf180mcu_as_sc_mcu7t3v3__tap_2
XFILLER_147_1220 VDD VDD VSS VSS gf180mcu_as_sc_mcu7t3v3__fill_1
XFILLER_90_233 VDD VDD VSS VSS gf180mcu_as_sc_mcu7t3v3__fillcap_8
XFILLER_90_255 VDD VDD VSS VSS gf180mcu_as_sc_mcu7t3v3__fill_1
XFILLER_31_300 VDD VDD VSS VSS gf180mcu_as_sc_mcu7t3v3__fill_1
XFILLER_90_277 VDD VDD VSS VSS gf180mcu_as_sc_mcu7t3v3__fillcap_16
XFILLER_147_1297 VDD VDD VSS VSS gf180mcu_as_sc_mcu7t3v3__fillcap_16
XFILLER_149_508 VDD VDD VSS VSS gf180mcu_as_sc_mcu7t3v3__fillcap_16
X_2830_ VDD VDD VSS VSS _4751_/A _2830_/B _5285_/Q _5284_/D gf180mcu_as_sc_mcu7t3v3__mux2_2
XFILLER_177_839 VDD VDD VSS VSS gf180mcu_as_sc_mcu7t3v3__fill_1
XFILLER_73_1483 VDD VDD VSS VSS gf180mcu_as_sc_mcu7t3v3__fillcap_16
XFILLER_160_1453 VDD VDD VSS VSS gf180mcu_as_sc_mcu7t3v3__fillcap_16
XFILLER_176_349 VDD VDD VSS VSS gf180mcu_as_sc_mcu7t3v3__fillcap_16
XFILLER_34_1467 VDD VDD VSS VSS gf180mcu_as_sc_mcu7t3v3__fillcap_16
X_2761_ VDD VDD VSS VSS _4691_/A _2766_/B _2766_/C _2761_/D _2810_/C gf180mcu_as_sc_mcu7t3v3__ao211_2
X_4976__999 VDD VDD VSS VSS _4976_/D gf180mcu_as_sc_mcu7t3v3__tiel_4
X_5480_ VDD VDD VSS VSS _5480_/A _5480_/Y gf180mcu_as_sc_mcu7t3v3__buff_2
X_4500_ VDD VDD VSS VSS _4586_/S _5020_/Q _5049_/Q _4501_/B gf180mcu_as_sc_mcu7t3v3__mux2_2
X_2692_ VDD VDD VSS VSS _2692_/S _2692_/B _2692_/A _2693_/A gf180mcu_as_sc_mcu7t3v3__mux2_2
XANTENNA_1 VDD VDD VSS VSS _4921_/D gf180mcu_as_sc_mcu7t3v3__diode_2
XFILLER_145_769 VDD VDD VSS VSS gf180mcu_as_sc_mcu7t3v3__fill_1
X_4431_ VDD VDD VSS VSS _4431_/D _4553_/A _4431_/B _4431_/C _4432_/B gf180mcu_as_sc_mcu7t3v3__ao31_2
XFILLER_6_85 VDD VDD VSS VSS gf180mcu_as_sc_mcu7t3v3__fillcap_16
XFILLER_98_300 VDD VDD VSS VSS gf180mcu_as_sc_mcu7t3v3__fill_1
X_4362_ VDD VDD VSS VSS _4363_/B _4362_/C _4362_/B _4562_/A gf180mcu_as_sc_mcu7t3v3__ao21b_2
Xfanout508 VDD VDD VSS VSS _3284_/Y _3477_/B gf180mcu_as_sc_mcu7t3v3__buff_2
Xfanout519 VDD VDD VSS VSS _4334_/Y _4576_/A gf180mcu_as_sc_mcu7t3v3__buff_2
X_4293_ VDD VDD VSS VSS _4297_/S _5125_/Q _5126_/Q _5125_/D gf180mcu_as_sc_mcu7t3v3__mux2_2
X_3313_ VDD VDD VSS VSS _3968_/D _3473_/B _3313_/C _3501_/C _3315_/C gf180mcu_as_sc_mcu7t3v3__ao211_2
XFILLER_112_165 VDD VDD VSS VSS gf180mcu_as_sc_mcu7t3v3__fillcap_8
Xmesh_tile_901 VDD VDD VSS VSS nw_out[8] gf180mcu_as_sc_mcu7t3v3__tiel_4
X_3244_ VDD VDD VSS VSS _3932_/A _3534_/A _3818_/B gf180mcu_as_sc_mcu7t3v3__and2_2
Xmesh_tile_945 VDD VDD VSS VSS sw_out[18] gf180mcu_as_sc_mcu7t3v3__tiel_4
Xmesh_tile_934 VDD VDD VSS VSS sw_out[7] gf180mcu_as_sc_mcu7t3v3__tiel_4
Xmesh_tile_923 VDD VDD VSS VSS nw_out[30] gf180mcu_as_sc_mcu7t3v3__tiel_4
Xmesh_tile_912 VDD VDD VSS VSS nw_out[19] gf180mcu_as_sc_mcu7t3v3__tiel_4
XTAP_TAPCELL_ROW_71_1_920 VDD VSS gf180mcu_as_sc_mcu7t3v3__tap_2
XTAP_TAPCELL_ROW_54_3_2430 VDD VSS gf180mcu_as_sc_mcu7t3v3__tap_2
XFILLER_66_241 VDD VDD VSS VSS gf180mcu_as_sc_mcu7t3v3__fillcap_4
Xmesh_tile_956 VDD VDD VSS VSS sw_out[29] gf180mcu_as_sc_mcu7t3v3__tiel_4
X_3175_ VDD VDD VSS VSS _4154_/A _3240_/B _3239_/A _4154_/D _3181_/B gf180mcu_as_sc_mcu7t3v3__ao22_2
XFILLER_148_1017 VDD VDD VSS VSS gf180mcu_as_sc_mcu7t3v3__fillcap_8
XFILLER_19_190 VDD VDD VSS VSS gf180mcu_as_sc_mcu7t3v3__fillcap_16
XFILLER_165_1364 VDD VDD VSS VSS gf180mcu_as_sc_mcu7t3v3__fillcap_16
XFILLER_34_171 VDD VDD VSS VSS gf180mcu_as_sc_mcu7t3v3__fillcap_4
XFILLER_34_193 VDD VDD VSS VSS gf180mcu_as_sc_mcu7t3v3__fillcap_16
XFILLER_161_1228 VDD VDD VSS VSS gf180mcu_as_sc_mcu7t3v3__fillcap_16
XFILLER_168_839 VDD VDD VSS VSS gf180mcu_as_sc_mcu7t3v3__fillcap_8
XFILLER_91_1561 VDD VDD VSS VSS gf180mcu_as_sc_mcu7t3v3__fillcap_4
XFILLER_52_1534 VDD VDD VSS VSS gf180mcu_as_sc_mcu7t3v3__fillcap_16
XFILLER_52_1556 VDD VDD VSS VSS gf180mcu_as_sc_mcu7t3v3__fillcap_8
X_2959_ VDD VDD VSS VSS _3179_/B _4916_/Q _2962_/C gf180mcu_as_sc_mcu7t3v3__or2_2
XFILLER_148_574 VDD VDD VSS VSS gf180mcu_as_sc_mcu7t3v3__fillcap_4
XFILLER_176_883 VDD VDD VSS VSS gf180mcu_as_sc_mcu7t3v3__fillcap_8
XFILLER_135_279 VDD VDD VSS VSS gf180mcu_as_sc_mcu7t3v3__fill_1
X_4629_ VDD VDD VSS VSS _5220_/Q _4629_/B _4629_/C _4629_/D _5220_/D gf180mcu_as_sc_mcu7t3v3__ao22_2
XFILLER_172_1313 VDD VDD VSS VSS gf180mcu_as_sc_mcu7t3v3__fillcap_8
XFILLER_89_300 VDD VDD VSS VSS gf180mcu_as_sc_mcu7t3v3__fill_1
XFILLER_173_48 VDD VDD VSS VSS gf180mcu_as_sc_mcu7t3v3__fillcap_16
XFILLER_137_1488 VDD VDD VSS VSS gf180mcu_as_sc_mcu7t3v3__fillcap_16
XFILLER_49_208 VDD VDD VSS VSS gf180mcu_as_sc_mcu7t3v3__fill_2
XTAP_TAPCELL_ROW_57_1_865 VDD VSS gf180mcu_as_sc_mcu7t3v3__tap_2
XFILLER_57_230 VDD VDD VSS VSS gf180mcu_as_sc_mcu7t3v3__fillcap_4
XFILLER_57_241 VDD VDD VSS VSS gf180mcu_as_sc_mcu7t3v3__fillcap_8
XFILLER_167_2 VDD VDD VSS VSS gf180mcu_as_sc_mcu7t3v3__fillcap_16
XFILLER_82_12 VDD VDD VSS VSS gf180mcu_as_sc_mcu7t3v3__fill_1
XFILLER_13_300 VDD VDD VSS VSS gf180mcu_as_sc_mcu7t3v3__fill_1
XFILLER_183_1420 VDD VDD VSS VSS gf180mcu_as_sc_mcu7t3v3__fillcap_8
XFILLER_82_45 VDD VDD VSS VSS gf180mcu_as_sc_mcu7t3v3__fillcap_8
XFILLER_96_1483 VDD VDD VSS VSS gf180mcu_as_sc_mcu7t3v3__fill_1
XFILLER_15_50 VDD VDD VSS VSS gf180mcu_as_sc_mcu7t3v3__fillcap_16
XFILLER_57_1467 VDD VDD VSS VSS gf180mcu_as_sc_mcu7t3v3__fillcap_16
XFILLER_144_1437 VDD VDD VSS VSS gf180mcu_as_sc_mcu7t3v3__fill_2
XFILLER_159_839 VDD VDD VSS VSS gf180mcu_as_sc_mcu7t3v3__fill_1
XFILLER_15_72 VDD VDD VSS VSS gf180mcu_as_sc_mcu7t3v3__fillcap_16
XFILLER_40_163 VDD VDD VSS VSS gf180mcu_as_sc_mcu7t3v3__fill_1
XFILLER_126_224 VDD VDD VSS VSS gf180mcu_as_sc_mcu7t3v3__fill_1
XFILLER_177_1202 VDD VDD VSS VSS gf180mcu_as_sc_mcu7t3v3__fillcap_8
XFILLER_181_330 VDD VDD VSS VSS gf180mcu_as_sc_mcu7t3v3__fillcap_16
XTAP_TAPCELL_ROW_60_3_2440 VDD VSS gf180mcu_as_sc_mcu7t3v3__tap_2
XFILLER_181_352 VDD VDD VSS VSS gf180mcu_as_sc_mcu7t3v3__fillcap_16
XFILLER_141_216 VDD VDD VSS VSS gf180mcu_as_sc_mcu7t3v3__fill_2
XFILLER_155_1522 VDD VDD VSS VSS gf180mcu_as_sc_mcu7t3v3__fill_1
XFILLER_49_8 VDD VDD VSS VSS gf180mcu_as_sc_mcu7t3v3__fill_2
XFILLER_141_249 VDD VDD VSS VSS gf180mcu_as_sc_mcu7t3v3__fill_2
Xinput160 VDD VDD VSS VSS nw_in[22] _4110_/A gf180mcu_as_sc_mcu7t3v3__buff_2
Xinput171 VDD VDD VSS VSS nw_in[32] _3522_/A gf180mcu_as_sc_mcu7t3v3__buff_2
XFILLER_48_263 VDD VDD VSS VSS gf180mcu_as_sc_mcu7t3v3__fillcap_16
Xinput182 VDD VDD VSS VSS se_in[10] _4017_/A gf180mcu_as_sc_mcu7t3v3__buff_2
Xinput193 VDD VDD VSS VSS se_in[20] _4097_/A gf180mcu_as_sc_mcu7t3v3__buff_2
XFILLER_149_1348 VDD VDD VSS VSS gf180mcu_as_sc_mcu7t3v3__fillcap_4
XFILLER_63_255 VDD VDD VSS VSS gf180mcu_as_sc_mcu7t3v3__fillcap_16
X_4980_ VDD VDD VSS VSS _5172_/CLK _4980_/D _4980_/Q gf180mcu_as_sc_mcu7t3v3__dfxtp_2
XFILLER_162_1504 VDD VDD VSS VSS gf180mcu_as_sc_mcu7t3v3__fill_1
XFILLER_16_171 VDD VDD VSS VSS gf180mcu_as_sc_mcu7t3v3__fillcap_4
XFILLER_16_193 VDD VDD VSS VSS gf180mcu_as_sc_mcu7t3v3__fillcap_16
XFILLER_36_1518 VDD VDD VSS VSS gf180mcu_as_sc_mcu7t3v3__fillcap_16
X_3931_ VDD VDD VSS VSS _3931_/B _3931_/A _3931_/Y gf180mcu_as_sc_mcu7t3v3__and2_2
XFILLER_177_614 VDD VDD VSS VSS gf180mcu_as_sc_mcu7t3v3__fillcap_16
XFILLER_177_636 VDD VDD VSS VSS gf180mcu_as_sc_mcu7t3v3__fill_1
X_3862_ VDD VDD VSS VSS _3868_/C _3862_/A _3871_/B _3862_/C _3869_/C gf180mcu_as_sc_mcu7t3v3__ao31_2
XFILLER_31_174 VDD VDD VSS VSS gf180mcu_as_sc_mcu7t3v3__fillcap_16
XFILLER_82_2 VDD VDD VSS VSS gf180mcu_as_sc_mcu7t3v3__fillcap_8
X_2813_ VDD VDD VSS VSS _5479_/A _2833_/A _2825_/B gf180mcu_as_sc_mcu7t3v3__and2_2
XFILLER_164_308 VDD VDD VSS VSS gf180mcu_as_sc_mcu7t3v3__fillcap_4
X_3793_ VDD VDD VSS VSS _3794_/B _3793_/A _3802_/B _3793_/C gf180mcu_as_sc_mcu7t3v3__ao21_2
X_2744_ VDD VDD VSS VSS _4947_/Q _2744_/B _2744_/A _2744_/Y gf180mcu_as_sc_mcu7t3v3__mux2_2
XTAP_TAPCELL_ROW_135_1235 VDD VSS gf180mcu_as_sc_mcu7t3v3__tap_2
XTAP_TAPCELL_ROW_135_1224 VDD VSS gf180mcu_as_sc_mcu7t3v3__tap_2
XFILLER_160_503 VDD VDD VSS VSS gf180mcu_as_sc_mcu7t3v3__fillcap_16
X_2675_ VDD VDD VSS VSS _2676_/D _2737_/A _2736_/B _2675_/A gf180mcu_as_sc_mcu7t3v3__aoi21b_2
X_4414_ VDD VDD VSS VSS _4414_/D _4581_/A _4414_/B _4414_/C _4415_/B gf180mcu_as_sc_mcu7t3v3__ao31_2
X_4345_ VDD VDD VSS VSS _4346_/B _4345_/C _4345_/B _4575_/B gf180mcu_as_sc_mcu7t3v3__aoi21_2
XTAP_TAPCELL_ROW_152_1593 VDD VSS gf180mcu_as_sc_mcu7t3v3__tap_2
XFILLER_141_772 VDD VDD VSS VSS gf180mcu_as_sc_mcu7t3v3__fillcap_16
XFILLER_98_141 VDD VDD VSS VSS gf180mcu_as_sc_mcu7t3v3__fillcap_4
X_4276_ VDD VDD VSS VSS _4281_/S _5480_/A _5110_/Q _5110_/D gf180mcu_as_sc_mcu7t3v3__mux2_2
X_3227_ VDD VDD VSS VSS _3227_/S _3512_/A _3511_/A _3228_/B gf180mcu_as_sc_mcu7t3v3__mux2_2
XTAP_TAPCELL_ROW_45_1_814 VDD VSS gf180mcu_as_sc_mcu7t3v3__tap_2
X_3158_ VDD VDD VSS VSS _4136_/A _3240_/B _3239_/A _4135_/A _3164_/B gf180mcu_as_sc_mcu7t3v3__ao22_2
XTAP_TAPCELL_ROW_161_1807 VDD VSS gf180mcu_as_sc_mcu7t3v3__tap_2
X_3089_ VDD VDD VSS VSS _4067_/A _3132_/B _3089_/C _4787_/D _3699_/D gf180mcu_as_sc_mcu7t3v3__aoi211_2
XTAP_TAPCELL_ROW_132_1_1163 VDD VSS gf180mcu_as_sc_mcu7t3v3__tap_2
XFILLER_161_1014 VDD VDD VSS VSS gf180mcu_as_sc_mcu7t3v3__fillcap_4
XFILLER_52_37 VDD VDD VSS VSS gf180mcu_as_sc_mcu7t3v3__fillcap_4
XFILLER_161_1047 VDD VDD VSS VSS gf180mcu_as_sc_mcu7t3v3__fill_2
XFILLER_168_37 VDD VDD VSS VSS gf180mcu_as_sc_mcu7t3v3__fillcap_16
XFILLER_17_1451 VDD VDD VSS VSS gf180mcu_as_sc_mcu7t3v3__fillcap_16
XTAP_TAPCELL_ROW_159_1758 VDD VSS gf180mcu_as_sc_mcu7t3v3__tap_2
XTAP_TAPCELL_ROW_159_1747 VDD VSS gf180mcu_as_sc_mcu7t3v3__tap_2
XPHY_EDGE_ROW_82_1_Left_534 VDD VSS gf180mcu_as_sc_mcu7t3v3__tap_2
XFILLER_149_872 VDD VDD VSS VSS gf180mcu_as_sc_mcu7t3v3__fill_1
XFILLER_183_628 VDD VDD VSS VSS gf180mcu_as_sc_mcu7t3v3__fill_2
XTAP_TAPCELL_ROW_112_1_1083 VDD VSS gf180mcu_as_sc_mcu7t3v3__tap_2
XFILLER_149_894 VDD VDD VSS VSS gf180mcu_as_sc_mcu7t3v3__fill_1
XFILLER_163_352 VDD VDD VSS VSS gf180mcu_as_sc_mcu7t3v3__fillcap_4
XFILLER_175_190 VDD VDD VSS VSS gf180mcu_as_sc_mcu7t3v3__fillcap_16
XFILLER_178_1555 VDD VDD VSS VSS gf180mcu_as_sc_mcu7t3v3__fill_2
XFILLER_184_36 VDD VDD VSS VSS gf180mcu_as_sc_mcu7t3v3__fillcap_16
XFILLER_123_205 VDD VDD VSS VSS gf180mcu_as_sc_mcu7t3v3__fillcap_4
XFILLER_139_1539 VDD VDD VSS VSS gf180mcu_as_sc_mcu7t3v3__fill_1
XFILLER_151_525 VDD VDD VSS VSS gf180mcu_as_sc_mcu7t3v3__fillcap_4
XFILLER_174_1408 VDD VDD VSS VSS gf180mcu_as_sc_mcu7t3v3__fill_1
XTAP_TAPCELL_ROW_91_1_1001 VDD VSS gf180mcu_as_sc_mcu7t3v3__tap_2
XFILLER_123_249 VDD VDD VSS VSS gf180mcu_as_sc_mcu7t3v3__fill_2
XFILLER_172_1154 VDD VDD VSS VSS gf180mcu_as_sc_mcu7t3v3__fill_1
XFILLER_77_34 VDD VDD VSS VSS gf180mcu_as_sc_mcu7t3v3__fillcap_4
XFILLER_131_282 VDD VDD VSS VSS gf180mcu_as_sc_mcu7t3v3__fill_2
XFILLER_77_56 VDD VDD VSS VSS gf180mcu_as_sc_mcu7t3v3__fillcap_4
XFILLER_98_1534 VDD VDD VSS VSS gf180mcu_as_sc_mcu7t3v3__fillcap_16
XFILLER_45_244 VDD VDD VSS VSS gf180mcu_as_sc_mcu7t3v3__fillcap_16
XFILLER_98_1556 VDD VDD VSS VSS gf180mcu_as_sc_mcu7t3v3__fillcap_8
XFILLER_144_1201 VDD VDD VSS VSS gf180mcu_as_sc_mcu7t3v3__fillcap_16
XFILLER_60_247 VDD VDD VSS VSS gf180mcu_as_sc_mcu7t3v3__fillcap_8
XFILLER_13_174 VDD VDD VSS VSS gf180mcu_as_sc_mcu7t3v3__fillcap_16
XFILLER_144_1245 VDD VDD VSS VSS gf180mcu_as_sc_mcu7t3v3__fillcap_16
XFILLER_179_1319 VDD VDD VSS VSS gf180mcu_as_sc_mcu7t3v3__fillcap_4
XFILLER_158_81 VDD VDD VSS VSS gf180mcu_as_sc_mcu7t3v3__fillcap_16
XFILLER_167_680 VDD VDD VSS VSS gf180mcu_as_sc_mcu7t3v3__fill_1
XFILLER_42_92 VDD VDD VSS VSS gf180mcu_as_sc_mcu7t3v3__fill_2
XFILLER_70_1486 VDD VDD VSS VSS gf180mcu_as_sc_mcu7t3v3__fillcap_16
XFILLER_155_897 VDD VDD VSS VSS gf180mcu_as_sc_mcu7t3v3__fill_2
X_2460_ VDD VDD VSS VSS _4447_/S _5090_/Q _5003_/Q _2462_/B gf180mcu_as_sc_mcu7t3v3__mux2_2
XFILLER_177_1098 VDD VDD VSS VSS gf180mcu_as_sc_mcu7t3v3__fillcap_8
X_4130_ VDD VDD VSS VSS _4130_/A _4130_/B _4130_/C _4130_/D _4131_/C gf180mcu_as_sc_mcu7t3v3__ao211_2
X_2391_ VDD VDD VSS VSS _2699_/A _5099_/Q gf180mcu_as_sc_mcu7t3v3__inv_2
XTAP_TAPCELL_ROW_85_1_974 VDD VSS gf180mcu_as_sc_mcu7t3v3__tap_2
XFILLER_150_591 VDD VDD VSS VSS gf180mcu_as_sc_mcu7t3v3__fillcap_4
XFILLER_155_1396 VDD VDD VSS VSS gf180mcu_as_sc_mcu7t3v3__fillcap_4
XFILLER_95_144 VDD VDD VSS VSS gf180mcu_as_sc_mcu7t3v3__fill_1
X_4061_ VDD VDD VSS VSS _4061_/A _4102_/B _4102_/C _4931_/Q _4063_/C gf180mcu_as_sc_mcu7t3v3__ao22_2
XTAP_TAPCELL_ROW_182_2254 VDD VSS gf180mcu_as_sc_mcu7t3v3__tap_2
X_3012_ VDD VDD VSS VSS _3992_/A _3240_/B _3012_/C _3012_/D _3013_/D gf180mcu_as_sc_mcu7t3v3__ao22_2
XTAP_TAPCELL_ROW_182_2265 VDD VSS gf180mcu_as_sc_mcu7t3v3__tap_2
XFILLER_36_299 VDD VDD VSS VSS gf180mcu_as_sc_mcu7t3v3__fill_2
X_4963_ VDD VDD VSS VSS _5146_/CLK _4963_/D _4963_/Q gf180mcu_as_sc_mcu7t3v3__dfxtp_2
XFILLER_162_1301 VDD VDD VSS VSS gf180mcu_as_sc_mcu7t3v3__fill_1
XFILLER_162_1323 VDD VDD VSS VSS gf180mcu_as_sc_mcu7t3v3__fill_1
XFILLER_177_400 VDD VDD VSS VSS gf180mcu_as_sc_mcu7t3v3__fillcap_16
X_3914_ VDD VDD VSS VSS _3932_/D _3914_/A _3914_/B _3929_/A gf180mcu_as_sc_mcu7t3v3__ao21_2
XFILLER_162_1367 VDD VDD VSS VSS gf180mcu_as_sc_mcu7t3v3__fillcap_8
XFILLER_177_422 VDD VDD VSS VSS gf180mcu_as_sc_mcu7t3v3__fillcap_16
X_4894_ VDD VDD VSS VSS _5081_/CLK _4894_/D _4894_/Q gf180mcu_as_sc_mcu7t3v3__dfxtp_2
XTAP_TAPCELL_ROW_48_1_829 VDD VSS gf180mcu_as_sc_mcu7t3v3__tap_2
XFILLER_165_628 VDD VDD VSS VSS gf180mcu_as_sc_mcu7t3v3__fill_2
XFILLER_22_18 VDD VDD VSS VSS gf180mcu_as_sc_mcu7t3v3__fillcap_16
X_3845_ VDD VDD VSS VSS _3845_/B _3845_/A _3847_/S gf180mcu_as_sc_mcu7t3v3__or2_2
XFILLER_138_18 VDD VDD VSS VSS gf180mcu_as_sc_mcu7t3v3__fillcap_16
XFILLER_146_820 VDD VDD VSS VSS gf180mcu_as_sc_mcu7t3v3__fillcap_16
X_3776_ VDD VDD VSS VSS _3780_/C _3776_/A _3776_/B _4161_/A gf180mcu_as_sc_mcu7t3v3__ao21_2
XFILLER_145_352 VDD VDD VSS VSS gf180mcu_as_sc_mcu7t3v3__fillcap_4
XFILLER_157_190 VDD VDD VSS VSS gf180mcu_as_sc_mcu7t3v3__fillcap_8
X_2727_ VDD VDD VSS VSS _2727_/S _2727_/B _2727_/A _2728_/C gf180mcu_as_sc_mcu7t3v3__mux2_2
XTAP_TAPCELL_ROW_154_1655 VDD VSS gf180mcu_as_sc_mcu7t3v3__tap_2
XTAP_TAPCELL_ROW_154_1644 VDD VSS gf180mcu_as_sc_mcu7t3v3__tap_2
XFILLER_156_1116 VDD VDD VSS VSS gf180mcu_as_sc_mcu7t3v3__fillcap_16
XFILLER_172_171 VDD VDD VSS VSS gf180mcu_as_sc_mcu7t3v3__fillcap_4
Xoutput420 VDD VDD VSS VSS _4808_/Q south_out[3] gf180mcu_as_sc_mcu7t3v3__buff_2
XTAP_TAPCELL_ROW_42_3_2412 VDD VSS gf180mcu_as_sc_mcu7t3v3__tap_2
XFILLER_161_867 VDD VDD VSS VSS gf180mcu_as_sc_mcu7t3v3__fillcap_8
XFILLER_172_193 VDD VDD VSS VSS gf180mcu_as_sc_mcu7t3v3__fillcap_16
XFILLER_173_1430 VDD VDD VSS VSS gf180mcu_as_sc_mcu7t3v3__fill_1
Xclkbuf_leaf_6_clk_regs VDD VDD VSS VSS clkbuf_3_0_0_clk_regs/Y _5266_/CLK gf180mcu_as_sc_mcu7t3v3__clkbuff_12
Xoutput431 VDD VDD VSS VSS _4886_/Q west_out[13] gf180mcu_as_sc_mcu7t3v3__buff_2
Xoutput442 VDD VDD VSS VSS _4896_/Q west_out[23] gf180mcu_as_sc_mcu7t3v3__buff_2
Xoutput453 VDD VDD VSS VSS _4906_/Q west_out[33] gf180mcu_as_sc_mcu7t3v3__buff_2
X_2658_ VDD VDD VSS VSS _2658_/S _5261_/Q _5249_/Q _2659_/B gf180mcu_as_sc_mcu7t3v3__mux2_2
X_2589_ VDD VDD VSS VSS _2589_/Y _2589_/C _4949_/Q _2589_/A gf180mcu_as_sc_mcu7t3v3__aoi21b_2
XFILLER_113_282 VDD VDD VSS VSS gf180mcu_as_sc_mcu7t3v3__fillcap_16
XFILLER_47_1499 VDD VDD VSS VSS gf180mcu_as_sc_mcu7t3v3__fillcap_16
X_4328_ VDD VDD VSS VSS _4328_/A _4328_/B _4328_/C _5156_/Q _5156_/D gf180mcu_as_sc_mcu7t3v3__ao22_2
X_4259_ VDD VDD VSS VSS _4643_/B _4643_/A _4259_/B _4259_/C _4260_/B gf180mcu_as_sc_mcu7t3v3__ao31_2
XFILLER_86_177 VDD VDD VSS VSS gf180mcu_as_sc_mcu7t3v3__fill_2
XFILLER_103_10 VDD VDD VSS VSS gf180mcu_as_sc_mcu7t3v3__fillcap_4
XFILLER_27_244 VDD VDD VSS VSS gf180mcu_as_sc_mcu7t3v3__fillcap_16
XTAP_TAPCELL_ROW_27_1_743 VDD VSS gf180mcu_as_sc_mcu7t3v3__tap_2
XFILLER_103_65 VDD VDD VSS VSS gf180mcu_as_sc_mcu7t3v3__fillcap_4
XPHY_EDGE_ROW_56_3_Left_190 VDD VSS gf180mcu_as_sc_mcu7t3v3__tap_2
XFILLER_145_1510 VDD VDD VSS VSS gf180mcu_as_sc_mcu7t3v3__fill_1
XFILLER_167_1278 VDD VDD VSS VSS gf180mcu_as_sc_mcu7t3v3__fillcap_16
XFILLER_63_36 VDD VDD VSS VSS gf180mcu_as_sc_mcu7t3v3__fill_2
XFILLER_169_934 VDD VDD VSS VSS gf180mcu_as_sc_mcu7t3v3__fillcap_8
XFILLER_42_247 VDD VDD VSS VSS gf180mcu_as_sc_mcu7t3v3__fillcap_16
XFILLER_63_69 VDD VDD VSS VSS gf180mcu_as_sc_mcu7t3v3__fill_1
XFILLER_169_967 VDD VDD VSS VSS gf180mcu_as_sc_mcu7t3v3__fill_2
XFILLER_180_1445 VDD VDD VSS VSS gf180mcu_as_sc_mcu7t3v3__fill_1
XFILLER_141_1418 VDD VDD VSS VSS gf180mcu_as_sc_mcu7t3v3__fillcap_8
XFILLER_10_155 VDD VDD VSS VSS gf180mcu_as_sc_mcu7t3v3__fillcap_16
XFILLER_10_177 VDD VDD VSS VSS gf180mcu_as_sc_mcu7t3v3__fillcap_16
XFILLER_137_842 VDD VDD VSS VSS gf180mcu_as_sc_mcu7t3v3__fill_2
XPHY_EDGE_ROW_75_3_Left_209 VDD VSS gf180mcu_as_sc_mcu7t3v3__tap_2
XFILLER_178_1330 VDD VDD VSS VSS gf180mcu_as_sc_mcu7t3v3__fill_2
XFILLER_139_1314 VDD VDD VSS VSS gf180mcu_as_sc_mcu7t3v3__fillcap_16
XFILLER_152_834 VDD VDD VSS VSS gf180mcu_as_sc_mcu7t3v3__fillcap_16
XFILLER_174_1205 VDD VDD VSS VSS gf180mcu_as_sc_mcu7t3v3__fillcap_8
XFILLER_111_208 VDD VDD VSS VSS gf180mcu_as_sc_mcu7t3v3__fill_2
XFILLER_88_88 VDD VDD VSS VSS gf180mcu_as_sc_mcu7t3v3__fillcap_4
XPHY_EDGE_ROW_5_1_Left_457 VDD VSS gf180mcu_as_sc_mcu7t3v3__tap_2
XFILLER_77_144 VDD VDD VSS VSS gf180mcu_as_sc_mcu7t3v3__fill_1
XFILLER_77_188 VDD VDD VSS VSS gf180mcu_as_sc_mcu7t3v3__fillcap_16
XFILLER_92_114 VDD VDD VSS VSS gf180mcu_as_sc_mcu7t3v3__fill_2
Xfanout680 VDD VDD VSS VSS fanout684/Y _3501_/C gf180mcu_as_sc_mcu7t3v3__buff_2
Xfanout691 VDD VDD VSS VSS _3153_/A _3145_/A gf180mcu_as_sc_mcu7t3v3__buff_2
XFILLER_150_1293 VDD VDD VSS VSS gf180mcu_as_sc_mcu7t3v3__fill_2
XFILLER_168_1009 VDD VDD VSS VSS gf180mcu_as_sc_mcu7t3v3__fillcap_4
XFILLER_18_299 VDD VDD VSS VSS gf180mcu_as_sc_mcu7t3v3__fill_2
XTAP_TAPCELL_ROW_88_1_989 VDD VSS gf180mcu_as_sc_mcu7t3v3__tap_2
XFILLER_144_1053 VDD VDD VSS VSS gf180mcu_as_sc_mcu7t3v3__fill_2
XFILLER_53_80 VDD VDD VSS VSS gf180mcu_as_sc_mcu7t3v3__fillcap_8
XFILLER_159_455 VDD VDD VSS VSS gf180mcu_as_sc_mcu7t3v3__fillcap_16
XFILLER_174_403 VDD VDD VSS VSS gf180mcu_as_sc_mcu7t3v3__fillcap_16
X_3630_ VDD VDD VSS VSS _3631_/C _3630_/C _3729_/B _4001_/A gf180mcu_as_sc_mcu7t3v3__aoi21_2
XTAP_TAPCELL_ROW_44_1_813 VDD VSS gf180mcu_as_sc_mcu7t3v3__tap_2
X_3561_ VDD VDD VSS VSS _3561_/Y _3561_/B _3561_/A gf180mcu_as_sc_mcu7t3v3__nor2_2
X_2512_ VDD VDD VSS VSS _5262_/Q _4662_/C _4708_/B _2517_/C gf180mcu_as_sc_mcu7t3v3__nand3_2
XFILLER_142_333 VDD VDD VSS VSS gf180mcu_as_sc_mcu7t3v3__fill_2
XFILLER_154_171 VDD VDD VSS VSS gf180mcu_as_sc_mcu7t3v3__fillcap_4
XFILLER_154_193 VDD VDD VSS VSS gf180mcu_as_sc_mcu7t3v3__fillcap_16
X_3492_ VDD VDD VSS VSS _3492_/B _3768_/A _4831_/D gf180mcu_as_sc_mcu7t3v3__and2_2
XFILLER_142_366 VDD VDD VSS VSS gf180mcu_as_sc_mcu7t3v3__fillcap_4
XFILLER_170_664 VDD VDD VSS VSS gf180mcu_as_sc_mcu7t3v3__fill_1
XFILLER_170_675 VDD VDD VSS VSS gf180mcu_as_sc_mcu7t3v3__fillcap_4
X_5231_ VDD VDD VSS VSS _5266_/CLK _5231_/D _5231_/Q gf180mcu_as_sc_mcu7t3v3__dfxtp_2
X_2443_ VDD VDD VSS VSS _3731_/A _4106_/A gf180mcu_as_sc_mcu7t3v3__inv_2
XTAP_TAPCELL_ROW_184_2305 VDD VSS gf180mcu_as_sc_mcu7t3v3__tap_2
X_5162_ VDD VDD VSS VSS _5164_/CLK _5162_/D _5162_/Q gf180mcu_as_sc_mcu7t3v3__dfxtp_2
XTAP_TAPCELL_ROW_184_2338 VDD VSS gf180mcu_as_sc_mcu7t3v3__tap_2
XTAP_TAPCELL_ROW_184_2327 VDD VSS gf180mcu_as_sc_mcu7t3v3__tap_2
XTAP_TAPCELL_ROW_184_2316 VDD VSS gf180mcu_as_sc_mcu7t3v3__tap_2
XFILLER_151_1046 VDD VDD VSS VSS gf180mcu_as_sc_mcu7t3v3__fillcap_4
XPHY_EDGE_ROW_135_Right_269 VDD VSS gf180mcu_as_sc_mcu7t3v3__tap_2
X_5093_ VDD VDD VSS VSS _5094_/CLK _5093_/D _5093_/Q gf180mcu_as_sc_mcu7t3v3__dfxtp_2
X_4113_ VDD VDD VSS VSS _4113_/A _4130_/B _4113_/C _4113_/D _4114_/C gf180mcu_as_sc_mcu7t3v3__ao211_2
XFILLER_151_1079 VDD VDD VSS VSS gf180mcu_as_sc_mcu7t3v3__fill_2
XFILLER_110_296 VDD VDD VSS VSS gf180mcu_as_sc_mcu7t3v3__fillcap_4
XFILLER_17_18 VDD VDD VSS VSS gf180mcu_as_sc_mcu7t3v3__fillcap_16
X_4044_ VDD VDD VSS VSS _4991_/Q _4092_/B _4242_/B _4092_/D _4991_/D gf180mcu_as_sc_mcu7t3v3__ao22_2
XTAP_TAPCELL_ROW_147_1481 VDD VSS gf180mcu_as_sc_mcu7t3v3__tap_2
XFILLER_83_158 VDD VDD VSS VSS gf180mcu_as_sc_mcu7t3v3__fillcap_8
XTAP_TAPCELL_ROW_147_1492 VDD VSS gf180mcu_as_sc_mcu7t3v3__tap_2
XFILLER_24_225 VDD VDD VSS VSS gf180mcu_as_sc_mcu7t3v3__fillcap_16
XFILLER_24_247 VDD VDD VSS VSS gf180mcu_as_sc_mcu7t3v3__fillcap_16
XPHY_EDGE_ROW_181_Right_315 VDD VSS gf180mcu_as_sc_mcu7t3v3__tap_2
XFILLER_178_731 VDD VDD VSS VSS gf180mcu_as_sc_mcu7t3v3__fillcap_4
X_4946_ VDD VDD VSS VSS _5074_/CLK _4946_/D _4946_/Q gf180mcu_as_sc_mcu7t3v3__dfxtp_2
XFILLER_162_1153 VDD VDD VSS VSS gf180mcu_as_sc_mcu7t3v3__fill_2
X_4877_ VDD VDD VSS VSS _4928_/CLK _4877_/D _4877_/Q gf180mcu_as_sc_mcu7t3v3__dfxtp_2
XFILLER_138_639 VDD VDD VSS VSS gf180mcu_as_sc_mcu7t3v3__fillcap_4
X_3828_ VDD VDD VSS VSS _3869_/A _4914_/Q _3835_/B gf180mcu_as_sc_mcu7t3v3__and2_2
XFILLER_137_138 VDD VDD VSS VSS gf180mcu_as_sc_mcu7t3v3__fill_2
XFILLER_140_1451 VDD VDD VSS VSS gf180mcu_as_sc_mcu7t3v3__fillcap_16
XFILLER_133_300 VDD VDD VSS VSS gf180mcu_as_sc_mcu7t3v3__fill_1
X_3759_ VDD VDD VSS VSS _3760_/C _3759_/C _3802_/B _4139_/A gf180mcu_as_sc_mcu7t3v3__aoi21_2
XFILLER_134_856 VDD VDD VSS VSS gf180mcu_as_sc_mcu7t3v3__fill_2
XFILLER_161_686 VDD VDD VSS VSS gf180mcu_as_sc_mcu7t3v3__fillcap_8
XFILLER_175_1558 VDD VDD VSS VSS gf180mcu_as_sc_mcu7t3v3__fill_2
XFILLER_134_1222 VDD VDD VSS VSS gf180mcu_as_sc_mcu7t3v3__fill_2
XFILLER_138_1391 VDD VDD VSS VSS gf180mcu_as_sc_mcu7t3v3__fill_2
XFILLER_59_100 VDD VDD VSS VSS gf180mcu_as_sc_mcu7t3v3__fill_2
XFILLER_74_103 VDD VDD VSS VSS gf180mcu_as_sc_mcu7t3v3__fill_2
XFILLER_169_1329 VDD VDD VSS VSS gf180mcu_as_sc_mcu7t3v3__fill_1
XFILLER_112_1564 VDD VDD VSS VSS gf180mcu_as_sc_mcu7t3v3__fillcap_4
XFILLER_95_1515 VDD VDD VSS VSS gf180mcu_as_sc_mcu7t3v3__fillcap_4
XFILLER_167_1042 VDD VDD VSS VSS gf180mcu_as_sc_mcu7t3v3__fillcap_8
XFILLER_95_1537 VDD VDD VSS VSS gf180mcu_as_sc_mcu7t3v3__fillcap_4
XPHY_EDGE_ROW_81_3_Right_400 VDD VSS gf180mcu_as_sc_mcu7t3v3__tap_2
XTAP_TAPCELL_ROW_76_1_938 VDD VSS gf180mcu_as_sc_mcu7t3v3__tap_2
XFILLER_169_731 VDD VDD VSS VSS gf180mcu_as_sc_mcu7t3v3__fill_2
XFILLER_180_1231 VDD VDD VSS VSS gf180mcu_as_sc_mcu7t3v3__fill_1
XFILLER_168_241 VDD VDD VSS VSS gf180mcu_as_sc_mcu7t3v3__fillcap_4
XFILLER_168_263 VDD VDD VSS VSS gf180mcu_as_sc_mcu7t3v3__fillcap_16
XTAP_TAPCELL_ROW_84_1_973 VDD VSS gf180mcu_as_sc_mcu7t3v3__tap_2
XFILLER_184_723 VDD VDD VSS VSS gf180mcu_as_sc_mcu7t3v3__fillcap_8
XFILLER_23_50 VDD VDD VSS VSS gf180mcu_as_sc_mcu7t3v3__fillcap_16
XFILLER_23_72 VDD VDD VSS VSS gf180mcu_as_sc_mcu7t3v3__fillcap_16
XFILLER_139_50 VDD VDD VSS VSS gf180mcu_as_sc_mcu7t3v3__fillcap_16
XFILLER_139_72 VDD VDD VSS VSS gf180mcu_as_sc_mcu7t3v3__fillcap_16
XFILLER_156_447 VDD VDD VSS VSS gf180mcu_as_sc_mcu7t3v3__fillcap_8
XFILLER_156_469 VDD VDD VSS VSS gf180mcu_as_sc_mcu7t3v3__fill_1
XFILLER_183_244 VDD VDD VSS VSS gf180mcu_as_sc_mcu7t3v3__fillcap_8
XFILLER_99_10 VDD VDD VSS VSS gf180mcu_as_sc_mcu7t3v3__fillcap_4
XFILLER_99_65 VDD VDD VSS VSS gf180mcu_as_sc_mcu7t3v3__fill_1
XFILLER_137_694 VDD VDD VSS VSS gf180mcu_as_sc_mcu7t3v3__fillcap_4
XFILLER_152_642 VDD VDD VSS VSS gf180mcu_as_sc_mcu7t3v3__fill_2
XFILLER_152_675 VDD VDD VSS VSS gf180mcu_as_sc_mcu7t3v3__fillcap_4
XFILLER_151_174 VDD VDD VSS VSS gf180mcu_as_sc_mcu7t3v3__fillcap_16
XFILLER_65_158 VDD VDD VSS VSS gf180mcu_as_sc_mcu7t3v3__fillcap_16
XPHY_EDGE_ROW_69_1_Right_68 VDD VSS gf180mcu_as_sc_mcu7t3v3__tap_2
XFILLER_179_517 VDD VDD VSS VSS gf180mcu_as_sc_mcu7t3v3__fillcap_4
X_4800_ VDD VDD VSS VSS _4869_/CLK _4800_/D _4800_/Q gf180mcu_as_sc_mcu7t3v3__dfxtp_2
XFILLER_21_206 VDD VDD VSS VSS gf180mcu_as_sc_mcu7t3v3__fillcap_4
XFILLER_21_228 VDD VDD VSS VSS gf180mcu_as_sc_mcu7t3v3__fillcap_16
X_2992_ VDD VDD VSS VSS _3118_/S _3973_/A _3975_/A _2994_/B gf180mcu_as_sc_mcu7t3v3__mux2_2
XTAP_TAPCELL_ROW_177_2153 VDD VSS gf180mcu_as_sc_mcu7t3v3__tap_2
XTAP_TAPCELL_ROW_177_2142 VDD VSS gf180mcu_as_sc_mcu7t3v3__tap_2
XFILLER_159_230 VDD VDD VSS VSS gf180mcu_as_sc_mcu7t3v3__fillcap_4
XFILLER_159_241 VDD VDD VSS VSS gf180mcu_as_sc_mcu7t3v3__fillcap_8
XPHY_EDGE_ROW_110_1_Right_109 VDD VSS gf180mcu_as_sc_mcu7t3v3__tap_2
X_4731_ VDD VDD VSS VSS _5266_/D _5111_/Q _4731_/B _4731_/C gf180mcu_as_sc_mcu7t3v3__ao21_2
XFILLER_147_436 VDD VDD VSS VSS gf180mcu_as_sc_mcu7t3v3__fill_1
XFILLER_159_263 VDD VDD VSS VSS gf180mcu_as_sc_mcu7t3v3__fillcap_16
XFILLER_175_723 VDD VDD VSS VSS gf180mcu_as_sc_mcu7t3v3__fillcap_8
X_4662_ VDD VDD VSS VSS _4663_/B _4703_/A _4746_/A _4662_/C gf180mcu_as_sc_mcu7t3v3__ao21_2
X_3613_ VDD VDD VSS VSS _3613_/D _3984_/D _3736_/B _3728_/C _3614_/C gf180mcu_as_sc_mcu7t3v3__ao31_2
XTAP_TAPCELL_ROW_18_1_707 VDD VSS gf180mcu_as_sc_mcu7t3v3__tap_2
XFILLER_115_300 VDD VDD VSS VSS gf180mcu_as_sc_mcu7t3v3__fill_1
X_4593_ VDD VDD VSS VSS _4745_/B _4594_/A _4593_/Y gf180mcu_as_sc_mcu7t3v3__and2_2
X_3544_ VDD VDD VSS VSS _3787_/A _3818_/D _3544_/C _3797_/C gf180mcu_as_sc_mcu7t3v3__nand3_2
X_3475_ VDD VDD VSS VSS _4126_/D _3475_/B _3475_/C _3475_/D _3476_/C gf180mcu_as_sc_mcu7t3v3__ao211_2
XFILLER_142_174 VDD VDD VSS VSS gf180mcu_as_sc_mcu7t3v3__fill_1
XFILLER_143_686 VDD VDD VSS VSS gf180mcu_as_sc_mcu7t3v3__fill_2
XFILLER_48_1550 VDD VDD VSS VSS gf180mcu_as_sc_mcu7t3v3__fillcap_4
XFILLER_88_217 VDD VDD VSS VSS gf180mcu_as_sc_mcu7t3v3__fillcap_16
X_5214_ VDD VDD VSS VSS clkload0/A _5214_/D _5214_/Q gf180mcu_as_sc_mcu7t3v3__dfxtp_2
X_2426_ VDD VDD VSS VSS _3962_/A _2426_/A gf180mcu_as_sc_mcu7t3v3__inv_2
XTAP_TAPCELL_ROW_149_1532 VDD VSS gf180mcu_as_sc_mcu7t3v3__tap_2
X_5145_ VDD VDD VSS VSS _5146_/CLK _5145_/D _5145_/Q gf180mcu_as_sc_mcu7t3v3__dfxtp_2
XTAP_TAPCELL_ROW_149_1543 VDD VSS gf180mcu_as_sc_mcu7t3v3__tap_2
XPHY_EDGE_ROW_91_1_Left_543 VDD VSS gf180mcu_as_sc_mcu7t3v3__tap_2
X_5076_ VDD VDD VSS VSS _5188_/CLK _5076_/D _5076_/Q gf180mcu_as_sc_mcu7t3v3__dfxtp_2
XFILLER_71_106 VDD VDD VSS VSS gf180mcu_as_sc_mcu7t3v3__fill_1
X_4027_ VDD VDD VSS VSS _4027_/A _4124_/B _4027_/C _4240_/B _4091_/D gf180mcu_as_sc_mcu7t3v3__aoi211_2
XFILLER_44_49 VDD VDD VSS VSS gf180mcu_as_sc_mcu7t3v3__fillcap_4
XFILLER_164_1237 VDD VDD VSS VSS gf180mcu_as_sc_mcu7t3v3__fill_1
XFILLER_164_1259 VDD VDD VSS VSS gf180mcu_as_sc_mcu7t3v3__fillcap_8
XFILLER_55_1521 VDD VDD VSS VSS gf180mcu_as_sc_mcu7t3v3__fillcap_16
XFILLER_100_33 VDD VDD VSS VSS gf180mcu_as_sc_mcu7t3v3__fill_2
XFILLER_12_239 VDD VDD VSS VSS gf180mcu_as_sc_mcu7t3v3__fillcap_4
XFILLER_139_926 VDD VDD VSS VSS gf180mcu_as_sc_mcu7t3v3__fill_1
XFILLER_142_1502 VDD VDD VSS VSS gf180mcu_as_sc_mcu7t3v3__fill_2
X_4929_ VDD VDD VSS VSS _5053_/CLK _4929_/D _4929_/Q gf180mcu_as_sc_mcu7t3v3__dfxtp_2
XFILLER_139_948 VDD VDD VSS VSS gf180mcu_as_sc_mcu7t3v3__fill_1
XFILLER_142_1535 VDD VDD VSS VSS gf180mcu_as_sc_mcu7t3v3__fillcap_4
XFILLER_166_723 VDD VDD VSS VSS gf180mcu_as_sc_mcu7t3v3__fillcap_8
XFILLER_166_745 VDD VDD VSS VSS gf180mcu_as_sc_mcu7t3v3__fill_2
XFILLER_60_37 VDD VDD VSS VSS gf180mcu_as_sc_mcu7t3v3__fillcap_4
XFILLER_90_1467 VDD VDD VSS VSS gf180mcu_as_sc_mcu7t3v3__fillcap_16
XTAP_TAPCELL_ROW_72_1_922 VDD VSS gf180mcu_as_sc_mcu7t3v3__tap_2
XFILLER_165_255 VDD VDD VSS VSS gf180mcu_as_sc_mcu7t3v3__fillcap_16
XFILLER_166_767 VDD VDD VSS VSS gf180mcu_as_sc_mcu7t3v3__fill_2
XFILLER_176_37 VDD VDD VSS VSS gf180mcu_as_sc_mcu7t3v3__fillcap_16
XPHY_EDGE_ROW_120_3_Right_439 VDD VSS gf180mcu_as_sc_mcu7t3v3__tap_2
XFILLER_109_31 VDD VDD VSS VSS gf180mcu_as_sc_mcu7t3v3__fillcap_4
XFILLER_181_737 VDD VDD VSS VSS gf180mcu_as_sc_mcu7t3v3__fill_1
XFILLER_140_1292 VDD VDD VSS VSS gf180mcu_as_sc_mcu7t3v3__fill_2
XFILLER_179_1480 VDD VDD VSS VSS gf180mcu_as_sc_mcu7t3v3__fillcap_4
XFILLER_180_225 VDD VDD VSS VSS gf180mcu_as_sc_mcu7t3v3__fillcap_16
XFILLER_180_247 VDD VDD VSS VSS gf180mcu_as_sc_mcu7t3v3__fillcap_16
XFILLER_181_759 VDD VDD VSS VSS gf180mcu_as_sc_mcu7t3v3__fill_1
XFILLER_133_130 VDD VDD VSS VSS gf180mcu_as_sc_mcu7t3v3__fillcap_8
XFILLER_161_461 VDD VDD VSS VSS gf180mcu_as_sc_mcu7t3v3__fillcap_4
XFILLER_47_103 VDD VDD VSS VSS gf180mcu_as_sc_mcu7t3v3__fillcap_4
XFILLER_85_12 VDD VDD VSS VSS gf180mcu_as_sc_mcu7t3v3__fill_1
XFILLER_147_1402 VDD VDD VSS VSS gf180mcu_as_sc_mcu7t3v3__fillcap_16
XTAP_TAPCELL_ROW_131_1_1159 VDD VSS gf180mcu_as_sc_mcu7t3v3__tap_2
XFILLER_147_1457 VDD VDD VSS VSS gf180mcu_as_sc_mcu7t3v3__fill_2
XFILLER_70_172 VDD VDD VSS VSS gf180mcu_as_sc_mcu7t3v3__fill_2
XPHY_EDGE_ROW_82_3_Right_401 VDD VSS gf180mcu_as_sc_mcu7t3v3__tap_2
XFILLER_176_509 VDD VDD VSS VSS gf180mcu_as_sc_mcu7t3v3__fillcap_16
XPHY_EDGE_ROW_19_3_Left_153 VDD VSS gf180mcu_as_sc_mcu7t3v3__tap_2
XFILLER_145_1181 VDD VDD VSS VSS gf180mcu_as_sc_mcu7t3v3__fillcap_8
XFILLER_145_1192 VDD VDD VSS VSS gf180mcu_as_sc_mcu7t3v3__fillcap_16
XFILLER_157_723 VDD VDD VSS VSS gf180mcu_as_sc_mcu7t3v3__fillcap_8
XTAP_TAPCELL_ROW_58_1_867 VDD VSS gf180mcu_as_sc_mcu7t3v3__tap_2
XFILLER_141_1045 VDD VDD VSS VSS gf180mcu_as_sc_mcu7t3v3__fillcap_4
XTAP_TAPCELL_ROW_172_2050 VDD VSS gf180mcu_as_sc_mcu7t3v3__tap_2
XTAP_TAPCELL_ROW_111_1_1079 VDD VSS gf180mcu_as_sc_mcu7t3v3__tap_2
XFILLER_156_255 VDD VDD VSS VSS gf180mcu_as_sc_mcu7t3v3__fill_2
XFILLER_109_160 VDD VDD VSS VSS gf180mcu_as_sc_mcu7t3v3__fill_1
XFILLER_144_439 VDD VDD VSS VSS gf180mcu_as_sc_mcu7t3v3__fillcap_16
XFILLER_119_1515 VDD VDD VSS VSS gf180mcu_as_sc_mcu7t3v3__fillcap_4
XFILLER_119_1537 VDD VDD VSS VSS gf180mcu_as_sc_mcu7t3v3__fillcap_16
XFILLER_124_174 VDD VDD VSS VSS gf180mcu_as_sc_mcu7t3v3__fill_1
XFILLER_140_667 VDD VDD VSS VSS gf180mcu_as_sc_mcu7t3v3__fillcap_16
X_3260_ VDD VDD VSS VSS _3261_/B _3263_/A _3520_/B gf180mcu_as_sc_mcu7t3v3__and2_2
XFILLER_152_1163 VDD VDD VSS VSS gf180mcu_as_sc_mcu7t3v3__fill_1
XFILLER_182_80 VDD VDD VSS VSS gf180mcu_as_sc_mcu7t3v3__fillcap_8
XFILLER_85_209 VDD VDD VSS VSS gf180mcu_as_sc_mcu7t3v3__fill_1
X_3191_ VDD VDD VSS VSS _4161_/A _3237_/B _3238_/C _3191_/D _3193_/C gf180mcu_as_sc_mcu7t3v3__ao211_2
XFILLER_93_220 VDD VDD VSS VSS gf180mcu_as_sc_mcu7t3v3__fill_2
XFILLER_130_1483 VDD VDD VSS VSS gf180mcu_as_sc_mcu7t3v3__fill_1
XFILLER_130_1494 VDD VDD VSS VSS gf180mcu_as_sc_mcu7t3v3__fillcap_4
XTAP_TAPCELL_ROW_179_2204 VDD VSS gf180mcu_as_sc_mcu7t3v3__tap_2
XFILLER_179_314 VDD VDD VSS VSS gf180mcu_as_sc_mcu7t3v3__fillcap_16
Xclkbuf_leaf_20_clk_regs VDD VDD VSS VSS clkbuf_3_6_0_clk_regs/Y _5074_/CLK gf180mcu_as_sc_mcu7t3v3__clkbuff_12
XTAP_TAPCELL_ROW_140_1326 VDD VSS gf180mcu_as_sc_mcu7t3v3__tap_2
XFILLER_165_1568 VDD VDD VSS VSS gf180mcu_as_sc_mcu7t3v3__fill_1
XFILLER_61_150 VDD VDD VSS VSS gf180mcu_as_sc_mcu7t3v3__fillcap_4
XTAP_TAPCELL_ROW_140_1337 VDD VSS gf180mcu_as_sc_mcu7t3v3__tap_2
XFILLER_167_509 VDD VDD VSS VSS gf180mcu_as_sc_mcu7t3v3__fillcap_16
X_4714_ VDD VDD VSS VSS _4749_/B _4714_/B _5106_/Q _5259_/D gf180mcu_as_sc_mcu7t3v3__mux2_2
X_2975_ VDD VDD VSS VSS _3143_/S _3956_/D _3960_/A _2977_/B gf180mcu_as_sc_mcu7t3v3__mux2_2
XFILLER_50_1451 VDD VDD VSS VSS gf180mcu_as_sc_mcu7t3v3__fillcap_16
X_4645_ VDD VDD VSS VSS _4645_/B _5234_/Q _4646_/D gf180mcu_as_sc_mcu7t3v3__and2_2
XTAP_TAPCELL_ROW_138_1288 VDD VSS gf180mcu_as_sc_mcu7t3v3__tap_2
XFILLER_162_236 VDD VDD VSS VSS gf180mcu_as_sc_mcu7t3v3__fillcap_8
XFILLER_162_247 VDD VDD VSS VSS gf180mcu_as_sc_mcu7t3v3__fillcap_16
X_4576_ VDD VDD VSS VSS _4576_/B _4576_/A _4583_/C gf180mcu_as_sc_mcu7t3v3__and2_2
XTAP_TAPCELL_ROW_138_1299 VDD VSS gf180mcu_as_sc_mcu7t3v3__tap_2
X_3527_ VDD VDD VSS VSS _3527_/B _3768_/A _4838_/D gf180mcu_as_sc_mcu7t3v3__and2_2
XFILLER_115_152 VDD VDD VSS VSS gf180mcu_as_sc_mcu7t3v3__fillcap_8
XFILLER_157_1052 VDD VDD VSS VSS gf180mcu_as_sc_mcu7t3v3__fillcap_16
XFILLER_115_196 VDD VDD VSS VSS gf180mcu_as_sc_mcu7t3v3__fill_2
XFILLER_130_144 VDD VDD VSS VSS gf180mcu_as_sc_mcu7t3v3__fill_1
XFILLER_172_1539 VDD VDD VSS VSS gf180mcu_as_sc_mcu7t3v3__fillcap_16
XFILLER_39_27 VDD VDD VSS VSS gf180mcu_as_sc_mcu7t3v3__fillcap_8
X_3458_ VDD VDD VSS VSS _4111_/A _3473_/B _3458_/C _3458_/D _3459_/C gf180mcu_as_sc_mcu7t3v3__ao211_2
XTAP_TAPCELL_ROW_75_1_937 VDD VSS gf180mcu_as_sc_mcu7t3v3__tap_2
XFILLER_170_1241 VDD VDD VSS VSS gf180mcu_as_sc_mcu7t3v3__fill_1
XFILLER_39_49 VDD VDD VSS VSS gf180mcu_as_sc_mcu7t3v3__fillcap_16
X_3389_ VDD VDD VSS VSS _3467_/B _4037_/A _3389_/A _3391_/B gf180mcu_as_sc_mcu7t3v3__mux2_2
X_2409_ VDD VDD VSS VSS _4337_/B _5158_/Q gf180mcu_as_sc_mcu7t3v3__inv_2
XTAP_TAPCELL_ROW_168_1963 VDD VSS gf180mcu_as_sc_mcu7t3v3__tap_2
XTAP_TAPCELL_ROW_168_1952 VDD VSS gf180mcu_as_sc_mcu7t3v3__tap_2
XFILLER_130_199 VDD VDD VSS VSS gf180mcu_as_sc_mcu7t3v3__fill_2
X_5128_ VDD VDD VSS VSS _5199_/CLK _5128_/D _5128_/Q gf180mcu_as_sc_mcu7t3v3__dfxtp_2
XFILLER_22_1564 VDD VDD VSS VSS gf180mcu_as_sc_mcu7t3v3__fillcap_4
X_5059_ VDD VDD VSS VSS _5088_/CLK _5059_/D _5059_/Q gf180mcu_as_sc_mcu7t3v3__dfxtp_2
XPHY_EDGE_ROW_84_3_Left_218 VDD VSS gf180mcu_as_sc_mcu7t3v3__tap_2
XFILLER_44_139 VDD VDD VSS VSS gf180mcu_as_sc_mcu7t3v3__fillcap_8
XFILLER_111_65 VDD VDD VSS VSS gf180mcu_as_sc_mcu7t3v3__fillcap_4
XTAP_TAPCELL_ROW_48_3_2421 VDD VSS gf180mcu_as_sc_mcu7t3v3__tap_2
XFILLER_52_172 VDD VDD VSS VSS gf180mcu_as_sc_mcu7t3v3__fill_2
XFILLER_52_194 VDD VDD VSS VSS gf180mcu_as_sc_mcu7t3v3__fillcap_4
XFILLER_139_723 VDD VDD VSS VSS gf180mcu_as_sc_mcu7t3v3__fillcap_16
XFILLER_179_892 VDD VDD VSS VSS gf180mcu_as_sc_mcu7t3v3__fill_2
XFILLER_71_69 VDD VDD VSS VSS gf180mcu_as_sc_mcu7t3v3__fill_1
XFILLER_138_244 VDD VDD VSS VSS gf180mcu_as_sc_mcu7t3v3__fill_1
XFILLER_142_1354 VDD VDD VSS VSS gf180mcu_as_sc_mcu7t3v3__fillcap_8
XFILLER_166_542 VDD VDD VSS VSS gf180mcu_as_sc_mcu7t3v3__fill_1
XFILLER_138_255 VDD VDD VSS VSS gf180mcu_as_sc_mcu7t3v3__fillcap_4
XTAP_TAPCELL_ROW_54_1_851 VDD VSS gf180mcu_as_sc_mcu7t3v3__tap_2
XFILLER_112_2 VDD VDD VSS VSS gf180mcu_as_sc_mcu7t3v3__fillcap_16
XFILLER_166_597 VDD VDD VSS VSS gf180mcu_as_sc_mcu7t3v3__fill_2
XFILLER_4_224 VDD VDD VSS VSS gf180mcu_as_sc_mcu7t3v3__fillcap_16
XFILLER_106_141 VDD VDD VSS VSS gf180mcu_as_sc_mcu7t3v3__fillcap_4
XFILLER_141_409 VDD VDD VSS VSS gf180mcu_as_sc_mcu7t3v3__fillcap_4
XFILLER_181_578 VDD VDD VSS VSS gf180mcu_as_sc_mcu7t3v3__fillcap_8
XFILLER_106_174 VDD VDD VSS VSS gf180mcu_as_sc_mcu7t3v3__fill_1
XFILLER_136_1136 VDD VDD VSS VSS gf180mcu_as_sc_mcu7t3v3__fillcap_4
XFILLER_121_144 VDD VDD VSS VSS gf180mcu_as_sc_mcu7t3v3__fill_1
XFILLER_171_1049 VDD VDD VSS VSS gf180mcu_as_sc_mcu7t3v3__fill_1
XFILLER_153_1472 VDD VDD VSS VSS gf180mcu_as_sc_mcu7t3v3__fillcap_16
XFILLER_114_1467 VDD VDD VSS VSS gf180mcu_as_sc_mcu7t3v3__fillcap_16
XFILLER_75_264 VDD VDD VSS VSS gf180mcu_as_sc_mcu7t3v3__fill_2
XFILLER_143_1118 VDD VDD VSS VSS gf180mcu_as_sc_mcu7t3v3__fill_2
XFILLER_177_829 VDD VDD VSS VSS gf180mcu_as_sc_mcu7t3v3__fillcap_8
XPHY_EDGE_ROW_83_3_Right_402 VDD VSS gf180mcu_as_sc_mcu7t3v3__tap_2
XFILLER_143_1129 VDD VDD VSS VSS gf180mcu_as_sc_mcu7t3v3__fillcap_16
XFILLER_176_317 VDD VDD VSS VSS gf180mcu_as_sc_mcu7t3v3__fillcap_16
XFILLER_73_1451 VDD VDD VSS VSS gf180mcu_as_sc_mcu7t3v3__fillcap_16
X_2760_ VDD VDD VSS VSS _4691_/A _2765_/B _2765_/C _2809_/B _2810_/B gf180mcu_as_sc_mcu7t3v3__ao211_2
X_2691_ VDD VDD VSS VSS _2692_/B _4262_/B _2691_/B _2691_/C gf180mcu_as_sc_mcu7t3v3__ao21_2
XANTENNA_2 VDD VDD VSS VSS _4928_/D gf180mcu_as_sc_mcu7t3v3__diode_2
XFILLER_129_299 VDD VDD VSS VSS gf180mcu_as_sc_mcu7t3v3__fill_2
XFILLER_145_737 VDD VDD VSS VSS gf180mcu_as_sc_mcu7t3v3__fillcap_4
XFILLER_172_523 VDD VDD VSS VSS gf180mcu_as_sc_mcu7t3v3__fill_2
X_4430_ VDD VDD VSS VSS _4431_/D _4430_/B _4553_/A gf180mcu_as_sc_mcu7t3v3__nor2_2
XFILLER_144_247 VDD VDD VSS VSS gf180mcu_as_sc_mcu7t3v3__fillcap_8
XFILLER_160_707 VDD VDD VSS VSS gf180mcu_as_sc_mcu7t3v3__fillcap_4
XFILLER_6_53 VDD VDD VSS VSS gf180mcu_as_sc_mcu7t3v3__fillcap_16
XFILLER_158_1361 VDD VDD VSS VSS gf180mcu_as_sc_mcu7t3v3__fillcap_4
XFILLER_158_1383 VDD VDD VSS VSS gf180mcu_as_sc_mcu7t3v3__fillcap_16
X_4361_ VDD VDD VSS VSS _5481_/A _4566_/C _4361_/C _4590_/B _4362_/C gf180mcu_as_sc_mcu7t3v3__ao22_2
XFILLER_141_976 VDD VDD VSS VSS gf180mcu_as_sc_mcu7t3v3__fillcap_4
Xfanout509 VDD VDD VSS VSS _3284_/Y _3470_/B gf180mcu_as_sc_mcu7t3v3__buff_2
X_4292_ VDD VDD VSS VSS _4329_/A _4327_/C _4627_/B _4297_/S gf180mcu_as_sc_mcu7t3v3__mux2_2
X_3312_ VDD VDD VSS VSS _4919_/Q _3465_/B _3472_/C _3967_/A _3313_/C gf180mcu_as_sc_mcu7t3v3__ao22_2
XFILLER_112_177 VDD VDD VSS VSS gf180mcu_as_sc_mcu7t3v3__fillcap_16
XFILLER_140_486 VDD VDD VSS VSS gf180mcu_as_sc_mcu7t3v3__fillcap_8
XFILLER_141_998 VDD VDD VSS VSS gf180mcu_as_sc_mcu7t3v3__fillcap_4
XFILLER_45_1553 VDD VDD VSS VSS gf180mcu_as_sc_mcu7t3v3__fillcap_16
Xmesh_tile_902 VDD VDD VSS VSS nw_out[9] gf180mcu_as_sc_mcu7t3v3__tiel_4
X_3243_ VDD VDD VSS VSS _4804_/D _3706_/D _3243_/B _3243_/A gf180mcu_as_sc_mcu7t3v3__aoi21_2
Xmesh_tile_935 VDD VDD VSS VSS sw_out[8] gf180mcu_as_sc_mcu7t3v3__tiel_4
Xmesh_tile_924 VDD VDD VSS VSS nw_out[31] gf180mcu_as_sc_mcu7t3v3__tiel_4
Xmesh_tile_913 VDD VDD VSS VSS nw_out[20] gf180mcu_as_sc_mcu7t3v3__tiel_4
XTAP_TAPCELL_ROW_71_1_921 VDD VSS gf180mcu_as_sc_mcu7t3v3__tap_2
XTAP_TAPCELL_ROW_54_3_2431 VDD VSS gf180mcu_as_sc_mcu7t3v3__tap_2
XFILLER_132_1556 VDD VDD VSS VSS gf180mcu_as_sc_mcu7t3v3__fill_1
Xmesh_tile_957 VDD VDD VSS VSS sw_out[30] gf180mcu_as_sc_mcu7t3v3__tiel_4
Xmesh_tile_946 VDD VDD VSS VSS sw_out[19] gf180mcu_as_sc_mcu7t3v3__tiel_4
X_3174_ VDD VDD VSS VSS _3174_/B _3768_/A _4797_/D gf180mcu_as_sc_mcu7t3v3__and2_2
XFILLER_148_1029 VDD VDD VSS VSS gf180mcu_as_sc_mcu7t3v3__fill_2
XFILLER_25_18 VDD VDD VSS VSS gf180mcu_as_sc_mcu7t3v3__fillcap_16
XFILLER_26_139 VDD VDD VSS VSS gf180mcu_as_sc_mcu7t3v3__fillcap_16
XFILLER_165_1332 VDD VDD VSS VSS gf180mcu_as_sc_mcu7t3v3__fillcap_16
XFILLER_168_807 VDD VDD VSS VSS gf180mcu_as_sc_mcu7t3v3__fillcap_16
XFILLER_52_1502 VDD VDD VSS VSS gf180mcu_as_sc_mcu7t3v3__fillcap_16
XFILLER_148_531 VDD VDD VSS VSS gf180mcu_as_sc_mcu7t3v3__fill_2
XFILLER_176_851 VDD VDD VSS VSS gf180mcu_as_sc_mcu7t3v3__fill_1
X_2958_ VDD VDD VSS VSS _3176_/S _3938_/D _3942_/A _2961_/B gf180mcu_as_sc_mcu7t3v3__mux2_2
XFILLER_52_1568 VDD VDD VSS VSS gf180mcu_as_sc_mcu7t3v3__fill_1
XFILLER_136_737 VDD VDD VSS VSS gf180mcu_as_sc_mcu7t3v3__fillcap_4
X_4628_ VDD VDD VSS VSS _4628_/S _4628_/B _4628_/A _4629_/D gf180mcu_as_sc_mcu7t3v3__mux2_2
X_2889_ VDD VDD VSS VSS _3548_/A _3776_/A _3776_/B _3227_/S gf180mcu_as_sc_mcu7t3v3__nand3_2
XFILLER_135_247 VDD VDD VSS VSS gf180mcu_as_sc_mcu7t3v3__fillcap_4
XFILLER_150_217 VDD VDD VSS VSS gf180mcu_as_sc_mcu7t3v3__fill_1
XFILLER_173_16 VDD VDD VSS VSS gf180mcu_as_sc_mcu7t3v3__fillcap_16
X_4559_ VDD VDD VSS VSS _4559_/S _5027_/Q _5056_/Q _4560_/B gf180mcu_as_sc_mcu7t3v3__mux2_2
XFILLER_137_1434 VDD VDD VSS VSS gf180mcu_as_sc_mcu7t3v3__fill_2
XFILLER_176_1483 VDD VDD VSS VSS gf180mcu_as_sc_mcu7t3v3__fill_1
XFILLER_1_249 VDD VDD VSS VSS gf180mcu_as_sc_mcu7t3v3__fillcap_4
XFILLER_137_1467 VDD VDD VSS VSS gf180mcu_as_sc_mcu7t3v3__fill_2
XFILLER_170_1093 VDD VDD VSS VSS gf180mcu_as_sc_mcu7t3v3__fillcap_16
XFILLER_57_253 VDD VDD VSS VSS gf180mcu_as_sc_mcu7t3v3__fill_2
XPHY_EDGE_ROW_117_1_Left_569 VDD VSS gf180mcu_as_sc_mcu7t3v3__tap_2
XFILLER_72_201 VDD VDD VSS VSS gf180mcu_as_sc_mcu7t3v3__fill_2
XFILLER_166_1107 VDD VDD VSS VSS gf180mcu_as_sc_mcu7t3v3__fill_2
XFILLER_96_1451 VDD VDD VSS VSS gf180mcu_as_sc_mcu7t3v3__fillcap_16
XPHY_EDGE_ROW_54_1_Left_506 VDD VSS gf180mcu_as_sc_mcu7t3v3__tap_2
XFILLER_158_306 VDD VDD VSS VSS gf180mcu_as_sc_mcu7t3v3__fill_2
XFILLER_142_1173 VDD VDD VSS VSS gf180mcu_as_sc_mcu7t3v3__fillcap_4
XFILLER_167_873 VDD VDD VSS VSS gf180mcu_as_sc_mcu7t3v3__fillcap_16
XFILLER_177_1214 VDD VDD VSS VSS gf180mcu_as_sc_mcu7t3v3__fill_2
XFILLER_31_50 VDD VDD VSS VSS gf180mcu_as_sc_mcu7t3v3__fillcap_16
XFILLER_126_247 VDD VDD VSS VSS gf180mcu_as_sc_mcu7t3v3__fillcap_8
XFILLER_31_72 VDD VDD VSS VSS gf180mcu_as_sc_mcu7t3v3__fillcap_16
XTAP_TAPCELL_ROW_36_1_780 VDD VSS gf180mcu_as_sc_mcu7t3v3__tap_2
XFILLER_147_72 VDD VDD VSS VSS gf180mcu_as_sc_mcu7t3v3__fillcap_16
XFILLER_29_1515 VDD VDD VSS VSS gf180mcu_as_sc_mcu7t3v3__fillcap_4
XFILLER_68_1564 VDD VDD VSS VSS gf180mcu_as_sc_mcu7t3v3__fillcap_4
XPHY_EDGE_ROW_78_1_Right_77 VDD VSS gf180mcu_as_sc_mcu7t3v3__tap_2
XFILLER_29_1537 VDD VDD VSS VSS gf180mcu_as_sc_mcu7t3v3__fillcap_16
XFILLER_116_1518 VDD VDD VSS VSS gf180mcu_as_sc_mcu7t3v3__fillcap_16
Xinput150 VDD VDD VSS VSS nw_in[13] _4038_/A gf180mcu_as_sc_mcu7t3v3__buff_2
Xinput161 VDD VDD VSS VSS nw_in[23] _4119_/A gf180mcu_as_sc_mcu7t3v3__buff_2
Xinput172 VDD VDD VSS VSS nw_in[33] _3553_/A gf180mcu_as_sc_mcu7t3v3__buff_2
XFILLER_63_212 VDD VDD VSS VSS gf180mcu_as_sc_mcu7t3v3__fillcap_4
Xinput183 VDD VDD VSS VSS se_in[11] _4025_/A gf180mcu_as_sc_mcu7t3v3__buff_2
Xinput194 VDD VDD VSS VSS se_in[21] _4105_/A gf180mcu_as_sc_mcu7t3v3__buff_2
XFILLER_40_1483 VDD VDD VSS VSS gf180mcu_as_sc_mcu7t3v3__fill_1
XFILLER_56_80 VDD VDD VSS VSS gf180mcu_as_sc_mcu7t3v3__fillcap_16
X_3930_ VDD VDD VSS VSS _3930_/A _4160_/C _4152_/C _4915_/Q _3934_/C gf180mcu_as_sc_mcu7t3v3__ao22_2
XFILLER_31_120 VDD VDD VSS VSS gf180mcu_as_sc_mcu7t3v3__fillcap_16
XFILLER_31_142 VDD VDD VSS VSS gf180mcu_as_sc_mcu7t3v3__fillcap_16
X_3861_ VDD VDD VSS VSS _5127_/Q _4691_/A _3862_/C gf180mcu_as_sc_mcu7t3v3__and2_2
X_3792_ VDD VDD VSS VSS _3792_/A _3792_/B _3792_/C _3792_/D _3793_/C gf180mcu_as_sc_mcu7t3v3__ao211_2
X_2812_ VDD VDD VSS VSS _4974_/D _2812_/B _4755_/Q _4754_/D gf180mcu_as_sc_mcu7t3v3__mux2_2
XPHY_EDGE_ROW_84_3_Right_403 VDD VSS gf180mcu_as_sc_mcu7t3v3__tap_2
XFILLER_75_2 VDD VDD VSS VSS gf180mcu_as_sc_mcu7t3v3__fillcap_8
X_2743_ VDD VDD VSS VSS _4947_/Q _2743_/B _2743_/A _2743_/Y gf180mcu_as_sc_mcu7t3v3__mux2_2
XFILLER_157_372 VDD VDD VSS VSS gf180mcu_as_sc_mcu7t3v3__fill_2
XFILLER_158_895 VDD VDD VSS VSS gf180mcu_as_sc_mcu7t3v3__fill_1
XTAP_TAPCELL_ROW_135_1225 VDD VSS gf180mcu_as_sc_mcu7t3v3__tap_2
X_2674_ VDD VDD VSS VSS _5198_/Q _2858_/B _2674_/C _2674_/D _2676_/C gf180mcu_as_sc_mcu7t3v3__ao211_2
XTAP_TAPCELL_ROW_135_1236 VDD VSS gf180mcu_as_sc_mcu7t3v3__tap_2
XFILLER_132_217 VDD VDD VSS VSS gf180mcu_as_sc_mcu7t3v3__fillcap_16
X_4413_ VDD VDD VSS VSS _4414_/D _4413_/B _4581_/A gf180mcu_as_sc_mcu7t3v3__nor2_2
X_4344_ VDD VDD VSS VSS _4350_/C _4344_/B _4344_/C _4345_/C _4575_/B gf180mcu_as_sc_mcu7t3v3__aoi211_2
XTAP_TAPCELL_ROW_152_1594 VDD VSS gf180mcu_as_sc_mcu7t3v3__tap_2
XFILLER_100_103 VDD VDD VSS VSS gf180mcu_as_sc_mcu7t3v3__fill_2
X_4275_ VDD VDD VSS VSS _4281_/S _5479_/A _5109_/Q _5109_/D gf180mcu_as_sc_mcu7t3v3__mux2_2
XFILLER_171_1380 VDD VDD VSS VSS gf180mcu_as_sc_mcu7t3v3__fillcap_4
X_3226_ VDD VDD VSS VSS _3914_/A _3247_/B _3228_/A _3229_/C _3226_/D gf180mcu_as_sc_mcu7t3v3__oai211_2
XTAP_TAPCELL_ROW_45_1_815 VDD VSS gf180mcu_as_sc_mcu7t3v3__tap_2
XFILLER_36_28 VDD VDD VSS VSS gf180mcu_as_sc_mcu7t3v3__fillcap_4
X_3157_ VDD VDD VSS VSS _4132_/A _3182_/B _3157_/C _4795_/D _3706_/D gf180mcu_as_sc_mcu7t3v3__aoi211_2
XTAP_TAPCELL_ROW_161_1808 VDD VSS gf180mcu_as_sc_mcu7t3v3__tap_2
X_3088_ VDD VDD VSS VSS _3132_/B _3088_/B _3088_/C _3089_/C gf180mcu_as_sc_mcu7t3v3__nor3_2
XTAP_TAPCELL_ROW_132_1_1164 VDD VSS gf180mcu_as_sc_mcu7t3v3__tap_2
XFILLER_165_1162 VDD VDD VSS VSS gf180mcu_as_sc_mcu7t3v3__fill_1
XFILLER_165_1173 VDD VDD VSS VSS gf180mcu_as_sc_mcu7t3v3__fillcap_4
XFILLER_168_626 VDD VDD VSS VSS gf180mcu_as_sc_mcu7t3v3__fill_1
XFILLER_52_27 VDD VDD VSS VSS gf180mcu_as_sc_mcu7t3v3__fillcap_8
XFILLER_167_136 VDD VDD VSS VSS gf180mcu_as_sc_mcu7t3v3__fillcap_4
XTAP_TAPCELL_ROW_159_1759 VDD VSS gf180mcu_as_sc_mcu7t3v3__tap_2
XTAP_TAPCELL_ROW_159_1748 VDD VSS gf180mcu_as_sc_mcu7t3v3__tap_2
XFILLER_149_884 VDD VDD VSS VSS gf180mcu_as_sc_mcu7t3v3__fillcap_8
XFILLER_167_158 VDD VDD VSS VSS gf180mcu_as_sc_mcu7t3v3__fillcap_16
XTAP_TAPCELL_ROW_112_1_1084 VDD VSS gf180mcu_as_sc_mcu7t3v3__tap_2
XFILLER_178_1523 VDD VDD VSS VSS gf180mcu_as_sc_mcu7t3v3__fillcap_16
XFILLER_108_247 VDD VDD VSS VSS gf180mcu_as_sc_mcu7t3v3__fillcap_16
XFILLER_136_556 VDD VDD VSS VSS gf180mcu_as_sc_mcu7t3v3__fillcap_16
XFILLER_136_589 VDD VDD VSS VSS gf180mcu_as_sc_mcu7t3v3__fillcap_4
XFILLER_137_1220 VDD VDD VSS VSS gf180mcu_as_sc_mcu7t3v3__fillcap_8
XFILLER_89_142 VDD VDD VSS VSS gf180mcu_as_sc_mcu7t3v3__fill_2
XPHY_EDGE_ROW_28_3_Left_162 VDD VSS gf180mcu_as_sc_mcu7t3v3__tap_2
XFILLER_63_1483 VDD VDD VSS VSS gf180mcu_as_sc_mcu7t3v3__fillcap_16
XFILLER_98_1502 VDD VDD VSS VSS gf180mcu_as_sc_mcu7t3v3__fillcap_16
XTAP_TAPCELL_ROW_36_3_2403 VDD VSS gf180mcu_as_sc_mcu7t3v3__tap_2
XFILLER_24_1467 VDD VDD VSS VSS gf180mcu_as_sc_mcu7t3v3__fillcap_16
XFILLER_133_96 VDD VDD VSS VSS gf180mcu_as_sc_mcu7t3v3__fill_1
XFILLER_45_212 VDD VDD VSS VSS gf180mcu_as_sc_mcu7t3v3__fillcap_16
XFILLER_98_1568 VDD VDD VSS VSS gf180mcu_as_sc_mcu7t3v3__fill_1
XFILLER_13_120 VDD VDD VSS VSS gf180mcu_as_sc_mcu7t3v3__fillcap_16
XFILLER_13_142 VDD VDD VSS VSS gf180mcu_as_sc_mcu7t3v3__fillcap_16
XFILLER_183_1262 VDD VDD VSS VSS gf180mcu_as_sc_mcu7t3v3__fillcap_8
XFILLER_60_259 VDD VDD VSS VSS gf180mcu_as_sc_mcu7t3v3__fill_1
XFILLER_167_670 VDD VDD VSS VSS gf180mcu_as_sc_mcu7t3v3__fillcap_8
XFILLER_177_1000 VDD VDD VSS VSS gf180mcu_as_sc_mcu7t3v3__fill_2
XFILLER_61_8 VDD VDD VSS VSS gf180mcu_as_sc_mcu7t3v3__fill_2
XFILLER_154_364 VDD VDD VSS VSS gf180mcu_as_sc_mcu7t3v3__fillcap_8
XFILLER_181_150 VDD VDD VSS VSS gf180mcu_as_sc_mcu7t3v3__fillcap_4
XFILLER_182_695 VDD VDD VSS VSS gf180mcu_as_sc_mcu7t3v3__fill_1
XFILLER_114_239 VDD VDD VSS VSS gf180mcu_as_sc_mcu7t3v3__fillcap_4
XFILLER_155_1364 VDD VDD VSS VSS gf180mcu_as_sc_mcu7t3v3__fillcap_16
X_2390_ VDD VDD VSS VSS _2534_/A _5277_/Q gf180mcu_as_sc_mcu7t3v3__inv_2
XTAP_TAPCELL_ROW_85_1_975 VDD VSS gf180mcu_as_sc_mcu7t3v3__tap_2
XFILLER_42_1534 VDD VDD VSS VSS gf180mcu_as_sc_mcu7t3v3__fillcap_16
X_4060_ VDD VDD VSS VSS _4993_/Q _4092_/B _4244_/B _4092_/D _4993_/D gf180mcu_as_sc_mcu7t3v3__ao22_2
XTAP_TAPCELL_ROW_182_2255 VDD VSS gf180mcu_as_sc_mcu7t3v3__tap_2
XFILLER_42_1556 VDD VDD VSS VSS gf180mcu_as_sc_mcu7t3v3__fillcap_8
XFILLER_67_90 VDD VDD VSS VSS gf180mcu_as_sc_mcu7t3v3__fill_2
X_3011_ VDD VDD VSS VSS _3179_/B _4922_/Q _3012_/D gf180mcu_as_sc_mcu7t3v3__or2_2
XTAP_TAPCELL_ROW_182_2266 VDD VSS gf180mcu_as_sc_mcu7t3v3__tap_2
XFILLER_149_1168 VDD VDD VSS VSS gf180mcu_as_sc_mcu7t3v3__fillcap_16
X_4962_ VDD VDD VSS VSS _5146_/CLK _4962_/D _4962_/Q gf180mcu_as_sc_mcu7t3v3__dfxtp_2
XFILLER_162_1313 VDD VDD VSS VSS gf180mcu_as_sc_mcu7t3v3__fillcap_8
X_4893_ VDD VDD VSS VSS _4943_/CLK _4893_/D _4893_/Q gf180mcu_as_sc_mcu7t3v3__dfxtp_2
X_3913_ VDD VDD VSS VSS _3913_/Y _4166_/D _4753_/A gf180mcu_as_sc_mcu7t3v3__nor2_2
XFILLER_149_136 VDD VDD VSS VSS gf180mcu_as_sc_mcu7t3v3__fillcap_4
XFILLER_162_1335 VDD VDD VSS VSS gf180mcu_as_sc_mcu7t3v3__fillcap_4
XFILLER_178_968 VDD VDD VSS VSS gf180mcu_as_sc_mcu7t3v3__fill_1
X_3844_ VDD VDD VSS VSS _4912_/D _4753_/A _3844_/B _3844_/A gf180mcu_as_sc_mcu7t3v3__aoi21_2
XFILLER_127_1499 VDD VDD VSS VSS gf180mcu_as_sc_mcu7t3v3__fillcap_16
XFILLER_149_158 VDD VDD VSS VSS gf180mcu_as_sc_mcu7t3v3__fillcap_8
XFILLER_165_607 VDD VDD VSS VSS gf180mcu_as_sc_mcu7t3v3__fill_2
XFILLER_177_478 VDD VDD VSS VSS gf180mcu_as_sc_mcu7t3v3__fillcap_4
XPHY_EDGE_ROW_85_3_Right_404 VDD VSS gf180mcu_as_sc_mcu7t3v3__tap_2
XFILLER_164_139 VDD VDD VSS VSS gf180mcu_as_sc_mcu7t3v3__fillcap_16
X_3775_ VDD VDD VSS VSS _3775_/A _3802_/C _3775_/C _4866_/D _3825_/C gf180mcu_as_sc_mcu7t3v3__aoi211_2
X_2726_ VDD VDD VSS VSS _5163_/Q _4269_/S _4278_/S _5187_/Q _2727_/B gf180mcu_as_sc_mcu7t3v3__ao22_2
XTAP_TAPCELL_ROW_154_1645 VDD VSS gf180mcu_as_sc_mcu7t3v3__tap_2
XTAP_TAPCELL_ROW_154_1634 VDD VSS gf180mcu_as_sc_mcu7t3v3__tap_2
XFILLER_145_386 VDD VDD VSS VSS gf180mcu_as_sc_mcu7t3v3__fillcap_4
XFILLER_161_824 VDD VDD VSS VSS gf180mcu_as_sc_mcu7t3v3__fillcap_16
XFILLER_173_662 VDD VDD VSS VSS gf180mcu_as_sc_mcu7t3v3__fillcap_16
Xoutput410 VDD VDD VSS VSS _4830_/Q south_out[25] gf180mcu_as_sc_mcu7t3v3__buff_2
X_2657_ VDD VDD VSS VSS _2657_/Y _2737_/A _2657_/B _2657_/C _2657_/D gf180mcu_as_sc_mcu7t3v3__aoi22_2
XTAP_TAPCELL_ROW_42_3_2413 VDD VSS gf180mcu_as_sc_mcu7t3v3__tap_2
XPHY_EDGE_ROW_93_3_Left_227 VDD VSS gf180mcu_as_sc_mcu7t3v3__tap_2
XFILLER_105_228 VDD VDD VSS VSS gf180mcu_as_sc_mcu7t3v3__fill_2
XFILLER_154_18 VDD VDD VSS VSS gf180mcu_as_sc_mcu7t3v3__fillcap_16
Xoutput421 VDD VDD VSS VSS _4809_/Q south_out[4] gf180mcu_as_sc_mcu7t3v3__buff_2
Xoutput432 VDD VDD VSS VSS _4887_/Q west_out[14] gf180mcu_as_sc_mcu7t3v3__buff_2
Xoutput443 VDD VDD VSS VSS _4897_/Q west_out[24] gf180mcu_as_sc_mcu7t3v3__buff_2
XFILLER_173_1442 VDD VDD VSS VSS gf180mcu_as_sc_mcu7t3v3__fillcap_16
XFILLER_86_1483 VDD VDD VSS VSS gf180mcu_as_sc_mcu7t3v3__fill_1
Xoutput454 VDD VDD VSS VSS _4876_/Q west_out[3] gf180mcu_as_sc_mcu7t3v3__buff_2
X_2588_ VDD VDD VSS VSS _2588_/Y _2588_/B _2588_/A gf180mcu_as_sc_mcu7t3v3__nand2b_2
XFILLER_141_570 VDD VDD VSS VSS gf180mcu_as_sc_mcu7t3v3__fillcap_4
XFILLER_160_389 VDD VDD VSS VSS gf180mcu_as_sc_mcu7t3v3__fill_1
XFILLER_47_1467 VDD VDD VSS VSS gf180mcu_as_sc_mcu7t3v3__fillcap_16
X_4327_ VDD VDD VSS VSS _4328_/C _5233_/Q _4329_/A _4327_/C gf180mcu_as_sc_mcu7t3v3__ao21_2
XFILLER_86_134 VDD VDD VSS VSS gf180mcu_as_sc_mcu7t3v3__fillcap_16
X_4258_ VDD VDD VSS VSS _4260_/A _4258_/C _4259_/B _4643_/A gf180mcu_as_sc_mcu7t3v3__aoi21_2
X_3209_ VDD VDD VSS VSS _3209_/B _3768_/A _4800_/D gf180mcu_as_sc_mcu7t3v3__and2_2
XFILLER_27_212 VDD VDD VSS VSS gf180mcu_as_sc_mcu7t3v3__fillcap_16
X_4189_ VDD VDD VSS VSS _4249_/B _4192_/B _4192_/C _5027_/Q _5027_/D gf180mcu_as_sc_mcu7t3v3__ao22_2
XTAP_TAPCELL_ROW_27_1_744 VDD VSS gf180mcu_as_sc_mcu7t3v3__tap_2
XFILLER_103_88 VDD VDD VSS VSS gf180mcu_as_sc_mcu7t3v3__fillcap_4
XFILLER_103_99 VDD VDD VSS VSS gf180mcu_as_sc_mcu7t3v3__fillcap_16
XFILLER_42_226 VDD VDD VSS VSS gf180mcu_as_sc_mcu7t3v3__fillcap_16
XFILLER_145_1522 VDD VDD VSS VSS gf180mcu_as_sc_mcu7t3v3__fill_1
XFILLER_10_101 VDD VDD VSS VSS gf180mcu_as_sc_mcu7t3v3__fillcap_4
XFILLER_145_1544 VDD VDD VSS VSS gf180mcu_as_sc_mcu7t3v3__fill_1
XFILLER_169_946 VDD VDD VSS VSS gf180mcu_as_sc_mcu7t3v3__fill_2
XFILLER_10_123 VDD VDD VSS VSS gf180mcu_as_sc_mcu7t3v3__fillcap_16
XFILLER_50_292 VDD VDD VSS VSS gf180mcu_as_sc_mcu7t3v3__fillcap_8
XFILLER_184_938 VDD VDD VSS VSS gf180mcu_as_sc_mcu7t3v3__fillcap_8
XFILLER_12_85 VDD VDD VSS VSS gf180mcu_as_sc_mcu7t3v3__fillcap_16
XFILLER_136_364 VDD VDD VSS VSS gf180mcu_as_sc_mcu7t3v3__fillcap_8
XFILLER_178_1364 VDD VDD VSS VSS gf180mcu_as_sc_mcu7t3v3__fill_1
XFILLER_178_1375 VDD VDD VSS VSS gf180mcu_as_sc_mcu7t3v3__fillcap_4
XFILLER_139_1348 VDD VDD VSS VSS gf180mcu_as_sc_mcu7t3v3__fillcap_16
XFILLER_5_2 VDD VDD VSS VSS gf180mcu_as_sc_mcu7t3v3__fillcap_16
XFILLER_152_1537 VDD VDD VSS VSS gf180mcu_as_sc_mcu7t3v3__fill_1
XFILLER_26_1518 VDD VDD VSS VSS gf180mcu_as_sc_mcu7t3v3__fillcap_16
XFILLER_77_134 VDD VDD VSS VSS gf180mcu_as_sc_mcu7t3v3__fillcap_4
XFILLER_8_1483 VDD VDD VSS VSS gf180mcu_as_sc_mcu7t3v3__fill_1
XFILLER_92_104 VDD VDD VSS VSS gf180mcu_as_sc_mcu7t3v3__fill_1
Xfanout670 VDD VDD VSS VSS _3929_/Y _4129_/C gf180mcu_as_sc_mcu7t3v3__buff_2
Xfanout681 VDD VDD VSS VSS fanout684/Y _3471_/B gf180mcu_as_sc_mcu7t3v3__buff_2
Xfanout692 VDD VDD VSS VSS _2948_/Y _3153_/A gf180mcu_as_sc_mcu7t3v3__buff_2
XFILLER_178_209 VDD VDD VSS VSS gf180mcu_as_sc_mcu7t3v3__fillcap_16
XFILLER_159_412 VDD VDD VSS VSS gf180mcu_as_sc_mcu7t3v3__fill_1
XFILLER_144_1087 VDD VDD VSS VSS gf180mcu_as_sc_mcu7t3v3__fillcap_16
XFILLER_147_629 VDD VDD VSS VSS gf180mcu_as_sc_mcu7t3v3__fill_1
XFILLER_159_489 VDD VDD VSS VSS gf180mcu_as_sc_mcu7t3v3__fill_1
XFILLER_168_990 VDD VDD VSS VSS gf180mcu_as_sc_mcu7t3v3__fillcap_8
XFILLER_155_640 VDD VDD VSS VSS gf180mcu_as_sc_mcu7t3v3__fill_2
X_3560_ VDD VDD VSS VSS _3805_/B _3805_/A _3560_/Y gf180mcu_as_sc_mcu7t3v3__or2_2
XFILLER_143_802 VDD VDD VSS VSS gf180mcu_as_sc_mcu7t3v3__fill_1
XPHY_EDGE_ROW_157_Right_291 VDD VSS gf180mcu_as_sc_mcu7t3v3__tap_2
X_2511_ VDD VDD VSS VSS _2517_/B _4662_/C _4708_/B _2511_/C gf180mcu_as_sc_mcu7t3v3__ao21_2
XFILLER_143_846 VDD VDD VSS VSS gf180mcu_as_sc_mcu7t3v3__fill_2
XFILLER_157_1426 VDD VDD VSS VSS gf180mcu_as_sc_mcu7t3v3__fillcap_4
X_5230_ VDD VDD VSS VSS _5266_/CLK _5230_/D _5230_/Q gf180mcu_as_sc_mcu7t3v3__dfxtp_2
X_3491_ VDD VDD VSS VSS _3505_/S _3491_/B _4148_/A _3492_/B gf180mcu_as_sc_mcu7t3v3__mux2_2
XFILLER_142_356 VDD VDD VSS VSS gf180mcu_as_sc_mcu7t3v3__fill_2
X_2442_ VDD VDD VSS VSS _4099_/A _2442_/A gf180mcu_as_sc_mcu7t3v3__inv_2
XTAP_TAPCELL_ROW_184_2306 VDD VSS gf180mcu_as_sc_mcu7t3v3__tap_2
X_5161_ VDD VDD VSS VSS _5164_/CLK _5161_/D _5161_/Q gf180mcu_as_sc_mcu7t3v3__dfxtp_2
XTAP_TAPCELL_ROW_184_2339 VDD VSS gf180mcu_as_sc_mcu7t3v3__tap_2
XTAP_TAPCELL_ROW_184_2328 VDD VSS gf180mcu_as_sc_mcu7t3v3__tap_2
XTAP_TAPCELL_ROW_184_2317 VDD VSS gf180mcu_as_sc_mcu7t3v3__tap_2
XFILLER_151_1014 VDD VDD VSS VSS gf180mcu_as_sc_mcu7t3v3__fillcap_16
XFILLER_68_145 VDD VDD VSS VSS gf180mcu_as_sc_mcu7t3v3__fillcap_4
X_5092_ VDD VDD VSS VSS _5159_/CLK _5092_/D _5092_/Q gf180mcu_as_sc_mcu7t3v3__dfxtp_2
X_4112_ VDD VDD VSS VSS _4112_/A _4129_/B _4129_/C _4937_/Q _4113_/D gf180mcu_as_sc_mcu7t3v3__ao22_2
XFILLER_68_167 VDD VDD VSS VSS gf180mcu_as_sc_mcu7t3v3__fill_1
X_4043_ VDD VDD VSS VSS _4043_/A _4124_/B _4043_/C _4242_/B _4091_/D gf180mcu_as_sc_mcu7t3v3__aoi211_2
XFILLER_83_126 VDD VDD VSS VSS gf180mcu_as_sc_mcu7t3v3__fill_1
XTAP_TAPCELL_ROW_147_1493 VDD VSS gf180mcu_as_sc_mcu7t3v3__tap_2
XTAP_TAPCELL_ROW_147_1482 VDD VSS gf180mcu_as_sc_mcu7t3v3__tap_2
XPHY_EDGE_ROW_30_1_Right_29 VDD VSS gf180mcu_as_sc_mcu7t3v3__tap_2
X_4945_ VDD VDD VSS VSS _5094_/CLK _4945_/D _4945_/Q gf180mcu_as_sc_mcu7t3v3__dfxtp_2
XFILLER_162_1121 VDD VDD VSS VSS gf180mcu_as_sc_mcu7t3v3__fillcap_16
XFILLER_33_18 VDD VDD VSS VSS gf180mcu_as_sc_mcu7t3v3__fillcap_16
XFILLER_149_18 VDD VDD VSS VSS gf180mcu_as_sc_mcu7t3v3__fillcap_16
X_4876_ VDD VDD VSS VSS _4904_/CLK _4876_/D _4876_/Q gf180mcu_as_sc_mcu7t3v3__dfxtp_2
XFILLER_165_426 VDD VDD VSS VSS gf180mcu_as_sc_mcu7t3v3__fill_2
XFILLER_166_938 VDD VDD VSS VSS gf180mcu_as_sc_mcu7t3v3__fillcap_4
X_3827_ VDD VDD VSS VSS _4908_/D _3827_/B _4257_/S gf180mcu_as_sc_mcu7t3v3__nor2_2
XFILLER_105_1561 VDD VDD VSS VSS gf180mcu_as_sc_mcu7t3v3__fillcap_4
XPHY_EDGE_ROW_126_1_Left_578 VDD VSS gf180mcu_as_sc_mcu7t3v3__tap_2
X_3758_ VDD VDD VSS VSS _4136_/A _3792_/B _3758_/C _3802_/C _3759_/C gf180mcu_as_sc_mcu7t3v3__ao211_2
XPHY_EDGE_ROW_86_3_Right_405 VDD VSS gf180mcu_as_sc_mcu7t3v3__tap_2
XFILLER_173_470 VDD VDD VSS VSS gf180mcu_as_sc_mcu7t3v3__fillcap_8
XFILLER_88_1534 VDD VDD VSS VSS gf180mcu_as_sc_mcu7t3v3__fillcap_16
XFILLER_88_1556 VDD VDD VSS VSS gf180mcu_as_sc_mcu7t3v3__fillcap_8
X_2709_ VDD VDD VSS VSS _2709_/A _2709_/B _2709_/C _2709_/D _2709_/Y gf180mcu_as_sc_mcu7t3v3__ao22_2
XFILLER_161_632 VDD VDD VSS VSS gf180mcu_as_sc_mcu7t3v3__fillcap_8
XFILLER_173_492 VDD VDD VSS VSS gf180mcu_as_sc_mcu7t3v3__fillcap_4
X_3689_ VDD VDD VSS VSS _3689_/D _4064_/D _3736_/B _3728_/C _3690_/C gf180mcu_as_sc_mcu7t3v3__ao31_2
XPHY_EDGE_ROW_63_1_Left_515 VDD VSS gf180mcu_as_sc_mcu7t3v3__tap_2
XFILLER_161_698 VDD VDD VSS VSS gf180mcu_as_sc_mcu7t3v3__fill_2
XFILLER_58_37 VDD VDD VSS VSS gf180mcu_as_sc_mcu7t3v3__fill_1
XFILLER_101_220 VDD VDD VSS VSS gf180mcu_as_sc_mcu7t3v3__fill_1
XFILLER_134_1234 VDD VDD VSS VSS gf180mcu_as_sc_mcu7t3v3__fill_2
XFILLER_173_1283 VDD VDD VSS VSS gf180mcu_as_sc_mcu7t3v3__fill_1
XFILLER_114_10 VDD VDD VSS VSS gf180mcu_as_sc_mcu7t3v3__fillcap_4
XFILLER_60_1486 VDD VDD VSS VSS gf180mcu_as_sc_mcu7t3v3__fillcap_16
XFILLER_74_159 VDD VDD VSS VSS gf180mcu_as_sc_mcu7t3v3__fill_2
XFILLER_169_710 VDD VDD VSS VSS gf180mcu_as_sc_mcu7t3v3__fill_2
XPHY_EDGE_ROW_159_Left_611 VDD VSS gf180mcu_as_sc_mcu7t3v3__tap_2
XFILLER_180_1210 VDD VDD VSS VSS gf180mcu_as_sc_mcu7t3v3__fillcap_4
XTAP_TAPCELL_ROW_76_1_939 VDD VSS gf180mcu_as_sc_mcu7t3v3__tap_2
XPHY_EDGE_ROW_87_1_Right_86 VDD VSS gf180mcu_as_sc_mcu7t3v3__tap_2
XFILLER_141_1205 VDD VDD VSS VSS gf180mcu_as_sc_mcu7t3v3__fillcap_16
XFILLER_142_2 VDD VDD VSS VSS gf180mcu_as_sc_mcu7t3v3__fillcap_8
XFILLER_145_1374 VDD VDD VSS VSS gf180mcu_as_sc_mcu7t3v3__fill_2
XFILLER_169_765 VDD VDD VSS VSS gf180mcu_as_sc_mcu7t3v3__fillcap_4
XFILLER_145_1396 VDD VDD VSS VSS gf180mcu_as_sc_mcu7t3v3__fillcap_4
XFILLER_157_938 VDD VDD VSS VSS gf180mcu_as_sc_mcu7t3v3__fillcap_16
XFILLER_183_212 VDD VDD VSS VSS gf180mcu_as_sc_mcu7t3v3__fillcap_16
XFILLER_184_735 VDD VDD VSS VSS gf180mcu_as_sc_mcu7t3v3__fill_1
XFILLER_183_256 VDD VDD VSS VSS gf180mcu_as_sc_mcu7t3v3__fillcap_16
XTAP_TAPCELL_ROW_95_3_2492 VDD VSS gf180mcu_as_sc_mcu7t3v3__tap_2
XFILLER_165_982 VDD VDD VSS VSS gf180mcu_as_sc_mcu7t3v3__fillcap_16
XFILLER_136_172 VDD VDD VSS VSS gf180mcu_as_sc_mcu7t3v3__fill_2
XFILLER_151_120 VDD VDD VSS VSS gf180mcu_as_sc_mcu7t3v3__fillcap_16
XFILLER_152_621 VDD VDD VSS VSS gf180mcu_as_sc_mcu7t3v3__fillcap_4
XFILLER_174_1014 VDD VDD VSS VSS gf180mcu_as_sc_mcu7t3v3__fill_1
XFILLER_178_1161 VDD VDD VSS VSS gf180mcu_as_sc_mcu7t3v3__fill_2
XFILLER_99_88 VDD VDD VSS VSS gf180mcu_as_sc_mcu7t3v3__fillcap_4
XFILLER_151_142 VDD VDD VSS VSS gf180mcu_as_sc_mcu7t3v3__fillcap_16
XPHY_EDGE_ROW_168_Left_620 VDD VSS gf180mcu_as_sc_mcu7t3v3__tap_2
XFILLER_139_1189 VDD VDD VSS VSS gf180mcu_as_sc_mcu7t3v3__fill_1
XFILLER_155_72 VDD VDD VSS VSS gf180mcu_as_sc_mcu7t3v3__fillcap_16
XFILLER_180_996 VDD VDD VSS VSS gf180mcu_as_sc_mcu7t3v3__fillcap_4
XFILLER_2_152 VDD VDD VSS VSS gf180mcu_as_sc_mcu7t3v3__fillcap_8
XFILLER_2_174 VDD VDD VSS VSS gf180mcu_as_sc_mcu7t3v3__fill_1
XFILLER_152_1323 VDD VDD VSS VSS gf180mcu_as_sc_mcu7t3v3__fill_1
XTAP_TAPCELL_ROW_100_3_2500 VDD VSS gf180mcu_as_sc_mcu7t3v3__tap_2
XFILLER_152_1367 VDD VDD VSS VSS gf180mcu_as_sc_mcu7t3v3__fillcap_8
XFILLER_48_70 VDD VDD VSS VSS gf180mcu_as_sc_mcu7t3v3__fillcap_16
XFILLER_65_137 VDD VDD VSS VSS gf180mcu_as_sc_mcu7t3v3__fill_2
XFILLER_80_107 VDD VDD VSS VSS gf180mcu_as_sc_mcu7t3v3__fillcap_8
XFILLER_64_80 VDD VDD VSS VSS gf180mcu_as_sc_mcu7t3v3__fillcap_8
X_2991_ VDD VDD VSS VSS _3976_/A _3125_/B _3125_/C _3976_/D _2997_/B gf180mcu_as_sc_mcu7t3v3__ao22_2
XTAP_TAPCELL_ROW_177_2154 VDD VSS gf180mcu_as_sc_mcu7t3v3__tap_2
XTAP_TAPCELL_ROW_177_2143 VDD VSS gf180mcu_as_sc_mcu7t3v3__tap_2
XTAP_TAPCELL_ROW_142_1390 VDD VSS gf180mcu_as_sc_mcu7t3v3__tap_2
XFILLER_159_253 VDD VDD VSS VSS gf180mcu_as_sc_mcu7t3v3__fill_2
X_4730_ VDD VDD VSS VSS _5251_/Q _4730_/B _4730_/C _5266_/Q _4731_/C gf180mcu_as_sc_mcu7t3v3__ao22_2
XFILLER_148_938 VDD VDD VSS VSS gf180mcu_as_sc_mcu7t3v3__fillcap_4
XFILLER_148_949 VDD VDD VSS VSS gf180mcu_as_sc_mcu7t3v3__fill_1
XFILLER_159_286 VDD VDD VSS VSS gf180mcu_as_sc_mcu7t3v3__fill_2
XFILLER_175_735 VDD VDD VSS VSS gf180mcu_as_sc_mcu7t3v3__fill_2
XFILLER_37_1499 VDD VDD VSS VSS gf180mcu_as_sc_mcu7t3v3__fillcap_16
X_4661_ VDD VDD VSS VSS _4731_/B _5485_/A _5240_/Q _5240_/D gf180mcu_as_sc_mcu7t3v3__mux2_2
XFILLER_175_768 VDD VDD VSS VSS gf180mcu_as_sc_mcu7t3v3__fill_2
X_3612_ VDD VDD VSS VSS _4921_/Q _3719_/B _3719_/C _3981_/D _3613_/D gf180mcu_as_sc_mcu7t3v3__ao22_2
XTAP_TAPCELL_ROW_18_1_708 VDD VSS gf180mcu_as_sc_mcu7t3v3__tap_2
X_4592_ VDD VDD VSS VSS _5188_/Q _4592_/B _4592_/C _4592_/D _5188_/D gf180mcu_as_sc_mcu7t3v3__ao211_2
XFILLER_155_470 VDD VDD VSS VSS gf180mcu_as_sc_mcu7t3v3__fillcap_8
X_3543_ VDD VDD VSS VSS _3798_/A _3799_/B _3777_/B gf180mcu_as_sc_mcu7t3v3__nor2_2
XFILLER_170_451 VDD VDD VSS VSS gf180mcu_as_sc_mcu7t3v3__fillcap_4
X_3474_ VDD VDD VSS VSS _4126_/A _3474_/B _3474_/C _4127_/A _3475_/D gf180mcu_as_sc_mcu7t3v3__ao22_2
XFILLER_170_473 VDD VDD VSS VSS gf180mcu_as_sc_mcu7t3v3__fill_1
X_5213_ VDD VDD VSS VSS clkload0/A _5213_/D _5213_/Q gf180mcu_as_sc_mcu7t3v3__dfxtp_2
X_2425_ VDD VDD VSS VSS _3953_/A _3302_/A gf180mcu_as_sc_mcu7t3v3__inv_2
XFILLER_170_1434 VDD VDD VSS VSS gf180mcu_as_sc_mcu7t3v3__fill_1
X_5144_ VDD VDD VSS VSS _5146_/CLK _5144_/D _5144_/Q gf180mcu_as_sc_mcu7t3v3__dfxtp_2
XFILLER_28_18 VDD VDD VSS VSS gf180mcu_as_sc_mcu7t3v3__fillcap_16
XFILLER_96_251 VDD VDD VSS VSS gf180mcu_as_sc_mcu7t3v3__fill_1
XTAP_TAPCELL_ROW_149_1544 VDD VSS gf180mcu_as_sc_mcu7t3v3__tap_2
XTAP_TAPCELL_ROW_149_1533 VDD VSS gf180mcu_as_sc_mcu7t3v3__tap_2
XFILLER_170_1489 VDD VDD VSS VSS gf180mcu_as_sc_mcu7t3v3__fillcap_16
XFILLER_96_295 VDD VDD VSS VSS gf180mcu_as_sc_mcu7t3v3__fillcap_4
X_5075_ VDD VDD VSS VSS _5084_/CLK _5075_/D _5075_/Q gf180mcu_as_sc_mcu7t3v3__dfxtp_2
X_4026_ VDD VDD VSS VSS _4027_/C _4026_/B _4026_/A gf180mcu_as_sc_mcu7t3v3__nor2_2
XFILLER_64_170 VDD VDD VSS VSS gf180mcu_as_sc_mcu7t3v3__fillcap_4
XFILLER_0_1553 VDD VDD VSS VSS gf180mcu_as_sc_mcu7t3v3__fillcap_16
XFILLER_164_1205 VDD VDD VSS VSS gf180mcu_as_sc_mcu7t3v3__fillcap_16
XFILLER_168_1363 VDD VDD VSS VSS gf180mcu_as_sc_mcu7t3v3__fill_2
XFILLER_94_1560 VDD VDD VSS VSS gf180mcu_as_sc_mcu7t3v3__fill_2
X_4928_ VDD VDD VSS VSS _4928_/CLK _4928_/D _4928_/Q gf180mcu_as_sc_mcu7t3v3__dfxtp_2
XFILLER_139_938 VDD VDD VSS VSS gf180mcu_as_sc_mcu7t3v3__fillcap_8
XFILLER_165_212 VDD VDD VSS VSS gf180mcu_as_sc_mcu7t3v3__fill_2
XFILLER_178_573 VDD VDD VSS VSS gf180mcu_as_sc_mcu7t3v3__fill_1
XTAP_TAPCELL_ROW_72_1_923 VDD VSS gf180mcu_as_sc_mcu7t3v3__tap_2
XPHY_EDGE_ROW_37_3_Left_171 VDD VSS gf180mcu_as_sc_mcu7t3v3__tap_2
X_4859_ VDD VDD VSS VSS _4904_/CLK _4859_/D _4859_/Q gf180mcu_as_sc_mcu7t3v3__dfxtp_2
XFILLER_109_10 VDD VDD VSS VSS gf180mcu_as_sc_mcu7t3v3__fill_1
XFILLER_118_150 VDD VDD VSS VSS gf180mcu_as_sc_mcu7t3v3__fill_2
XFILLER_147_960 VDD VDD VSS VSS gf180mcu_as_sc_mcu7t3v3__fillcap_8
XFILLER_147_982 VDD VDD VSS VSS gf180mcu_as_sc_mcu7t3v3__fillcap_16
XFILLER_20_295 VDD VDD VSS VSS gf180mcu_as_sc_mcu7t3v3__fillcap_4
XPHY_EDGE_ROW_87_3_Right_406 VDD VSS gf180mcu_as_sc_mcu7t3v3__tap_2
XFILLER_109_65 VDD VDD VSS VSS gf180mcu_as_sc_mcu7t3v3__fillcap_4
XFILLER_162_930 VDD VDD VSS VSS gf180mcu_as_sc_mcu7t3v3__fillcap_8
XFILLER_174_790 VDD VDD VSS VSS gf180mcu_as_sc_mcu7t3v3__fill_1
XFILLER_175_1301 VDD VDD VSS VSS gf180mcu_as_sc_mcu7t3v3__fill_1
XFILLER_175_1323 VDD VDD VSS VSS gf180mcu_as_sc_mcu7t3v3__fill_1
XFILLER_133_142 VDD VDD VSS VSS gf180mcu_as_sc_mcu7t3v3__fillcap_4
XFILLER_162_985 VDD VDD VSS VSS gf180mcu_as_sc_mcu7t3v3__fillcap_16
XFILLER_134_698 VDD VDD VSS VSS gf180mcu_as_sc_mcu7t3v3__fillcap_4
XFILLER_136_1329 VDD VDD VSS VSS gf180mcu_as_sc_mcu7t3v3__fillcap_16
XFILLER_69_69 VDD VDD VSS VSS gf180mcu_as_sc_mcu7t3v3__fill_1
XFILLER_125_42 VDD VDD VSS VSS gf180mcu_as_sc_mcu7t3v3__fill_1
XFILLER_85_35 VDD VDD VSS VSS gf180mcu_as_sc_mcu7t3v3__fill_2
XFILLER_134_1086 VDD VDD VSS VSS gf180mcu_as_sc_mcu7t3v3__fill_2
XFILLER_62_107 VDD VDD VSS VSS gf180mcu_as_sc_mcu7t3v3__fillcap_8
XFILLER_70_184 VDD VDD VSS VSS gf180mcu_as_sc_mcu7t3v3__fillcap_16
XFILLER_157_735 VDD VDD VSS VSS gf180mcu_as_sc_mcu7t3v3__fill_2
XFILLER_169_562 VDD VDD VSS VSS gf180mcu_as_sc_mcu7t3v3__fillcap_16
XTAP_TAPCELL_ROW_97_1_1022 VDD VSS gf180mcu_as_sc_mcu7t3v3__tap_2
XTAP_TAPCELL_ROW_58_1_868 VDD VSS gf180mcu_as_sc_mcu7t3v3__tap_2
XFILLER_157_768 VDD VDD VSS VSS gf180mcu_as_sc_mcu7t3v3__fill_2
XTAP_TAPCELL_ROW_172_2040 VDD VSS gf180mcu_as_sc_mcu7t3v3__tap_2
XFILLER_176_1109 VDD VDD VSS VSS gf180mcu_as_sc_mcu7t3v3__fillcap_4
XFILLER_7_244 VDD VDD VSS VSS gf180mcu_as_sc_mcu7t3v3__fillcap_16
XTAP_TAPCELL_ROW_172_2051 VDD VSS gf180mcu_as_sc_mcu7t3v3__tap_2
XFILLER_137_492 VDD VDD VSS VSS gf180mcu_as_sc_mcu7t3v3__fillcap_16
XFILLER_50_71 VDD VDD VSS VSS gf180mcu_as_sc_mcu7t3v3__fillcap_16
XFILLER_7_299 VDD VDD VSS VSS gf180mcu_as_sc_mcu7t3v3__fill_2
XFILLER_140_624 VDD VDD VSS VSS gf180mcu_as_sc_mcu7t3v3__fillcap_4
XFILLER_152_473 VDD VDD VSS VSS gf180mcu_as_sc_mcu7t3v3__fillcap_8
XFILLER_78_251 VDD VDD VSS VSS gf180mcu_as_sc_mcu7t3v3__fill_2
X_3190_ VDD VDD VSS VSS _3237_/B _3204_/C _3227_/S gf180mcu_as_sc_mcu7t3v3__nor2_2
XFILLER_182_92 VDD VDD VSS VSS gf180mcu_as_sc_mcu7t3v3__fill_1
XFILLER_78_295 VDD VDD VSS VSS gf180mcu_as_sc_mcu7t3v3__fillcap_4
XFILLER_130_1451 VDD VDD VSS VSS gf180mcu_as_sc_mcu7t3v3__fillcap_16
XFILLER_93_276 VDD VDD VSS VSS gf180mcu_as_sc_mcu7t3v3__fillcap_4
XFILLER_93_298 VDD VDD VSS VSS gf180mcu_as_sc_mcu7t3v3__fill_2
XTAP_TAPCELL_ROW_37_1_782 VDD VSS gf180mcu_as_sc_mcu7t3v3__tap_2
XTAP_TAPCELL_ROW_179_2205 VDD VSS gf180mcu_as_sc_mcu7t3v3__tap_2
XTAP_TAPCELL_ROW_144_1430 VDD VSS gf180mcu_as_sc_mcu7t3v3__tap_2
XTAP_TAPCELL_ROW_140_1327 VDD VSS gf180mcu_as_sc_mcu7t3v3__tap_2
XFILLER_165_1536 VDD VDD VSS VSS gf180mcu_as_sc_mcu7t3v3__fillcap_4
XFILLER_165_1558 VDD VDD VSS VSS gf180mcu_as_sc_mcu7t3v3__fillcap_8
XTAP_TAPCELL_ROW_140_1338 VDD VSS gf180mcu_as_sc_mcu7t3v3__tap_2
X_2974_ VDD VDD VSS VSS _3957_/A _3150_/B _3150_/C _3956_/A _2980_/B gf180mcu_as_sc_mcu7t3v3__ao22_2
XFILLER_148_713 VDD VDD VSS VSS gf180mcu_as_sc_mcu7t3v3__fillcap_16
XPHY_EDGE_ROW_10_1_Right_9 VDD VSS gf180mcu_as_sc_mcu7t3v3__tap_2
X_4713_ VDD VDD VSS VSS _4717_/S _5259_/Q _5260_/Q _4714_/B gf180mcu_as_sc_mcu7t3v3__mux2_2
X_4644_ VDD VDD VSS VSS _4646_/C _4647_/A _4649_/C _4645_/B gf180mcu_as_sc_mcu7t3v3__nor3_2
XFILLER_102_1564 VDD VDD VSS VSS gf180mcu_as_sc_mcu7t3v3__fillcap_4
XFILLER_144_930 VDD VDD VSS VSS gf180mcu_as_sc_mcu7t3v3__fill_1
XFILLER_146_19 VDD VDD VSS VSS gf180mcu_as_sc_mcu7t3v3__fillcap_16
XFILLER_159_1329 VDD VDD VSS VSS gf180mcu_as_sc_mcu7t3v3__fill_1
XFILLER_175_598 VDD VDD VSS VSS gf180mcu_as_sc_mcu7t3v3__fillcap_8
X_4575_ VDD VDD VSS VSS _5188_/Q _4575_/B _4590_/C _5106_/Q _4576_/B gf180mcu_as_sc_mcu7t3v3__ao22_2
XTAP_TAPCELL_ROW_138_1289 VDD VSS gf180mcu_as_sc_mcu7t3v3__tap_2
XFILLER_115_142 VDD VDD VSS VSS gf180mcu_as_sc_mcu7t3v3__fill_2
XFILLER_144_974 VDD VDD VSS VSS gf180mcu_as_sc_mcu7t3v3__fill_2
XFILLER_85_1515 VDD VDD VSS VSS gf180mcu_as_sc_mcu7t3v3__fillcap_4
XFILLER_85_1537 VDD VDD VSS VSS gf180mcu_as_sc_mcu7t3v3__fillcap_16
X_3526_ VDD VDD VSS VSS _3817_/B _3526_/B _3526_/C _3526_/D _3527_/B gf180mcu_as_sc_mcu7t3v3__ao211_2
XFILLER_172_1507 VDD VDD VSS VSS gf180mcu_as_sc_mcu7t3v3__fillcap_16
XFILLER_130_134 VDD VDD VSS VSS gf180mcu_as_sc_mcu7t3v3__fillcap_8
X_3457_ VDD VDD VSS VSS _3471_/B _4113_/A _3458_/D gf180mcu_as_sc_mcu7t3v3__and2_2
XFILLER_69_251 VDD VDD VSS VSS gf180mcu_as_sc_mcu7t3v3__fill_1
X_3388_ VDD VDD VSS VSS _4037_/D _3468_/B _3388_/C _3388_/D _3389_/A gf180mcu_as_sc_mcu7t3v3__ao22_2
X_2408_ VDD VDD VSS VSS _4364_/A _5160_/Q gf180mcu_as_sc_mcu7t3v3__inv_2
XTAP_TAPCELL_ROW_168_1953 VDD VSS gf180mcu_as_sc_mcu7t3v3__tap_2
XTAP_TAPCELL_ROW_168_1942 VDD VSS gf180mcu_as_sc_mcu7t3v3__tap_2
XFILLER_29_104 VDD VDD VSS VSS gf180mcu_as_sc_mcu7t3v3__fillcap_16
X_5127_ VDD VDD VSS VSS _5199_/CLK _5127_/D _5127_/Q gf180mcu_as_sc_mcu7t3v3__dfxtp_2
XFILLER_170_1297 VDD VDD VSS VSS gf180mcu_as_sc_mcu7t3v3__fillcap_16
X_5058_ VDD VDD VSS VSS _5173_/CLK _5058_/D _5058_/Q gf180mcu_as_sc_mcu7t3v3__dfxtp_2
XFILLER_44_107 VDD VDD VSS VSS gf180mcu_as_sc_mcu7t3v3__fillcap_16
X_4009_ VDD VDD VSS VSS _4009_/A _4131_/B _4009_/C _4009_/D _4010_/B gf180mcu_as_sc_mcu7t3v3__ao211_2
XFILLER_164_1013 VDD VDD VSS VSS gf180mcu_as_sc_mcu7t3v3__fill_2
XTAP_TAPCELL_ROW_48_3_2422 VDD VSS gf180mcu_as_sc_mcu7t3v3__tap_2
XFILLER_71_37 VDD VDD VSS VSS gf180mcu_as_sc_mcu7t3v3__fill_1
XPHY_EDGE_ROW_11_3_Right_330 VDD VSS gf180mcu_as_sc_mcu7t3v3__tap_2
XFILLER_139_702 VDD VDD VSS VSS gf180mcu_as_sc_mcu7t3v3__fillcap_8
XFILLER_142_1322 VDD VDD VSS VSS gf180mcu_as_sc_mcu7t3v3__fillcap_16
XFILLER_178_381 VDD VDD VSS VSS gf180mcu_as_sc_mcu7t3v3__fillcap_4
XFILLER_142_1388 VDD VDD VSS VSS gf180mcu_as_sc_mcu7t3v3__fillcap_4
XFILLER_142_1399 VDD VDD VSS VSS gf180mcu_as_sc_mcu7t3v3__fillcap_4
XFILLER_154_705 VDD VDD VSS VSS gf180mcu_as_sc_mcu7t3v3__fillcap_16
XTAP_TAPCELL_ROW_54_1_852 VDD VSS gf180mcu_as_sc_mcu7t3v3__tap_2
XFILLER_154_749 VDD VDD VSS VSS gf180mcu_as_sc_mcu7t3v3__fillcap_4
XFILLER_105_2 VDD VDD VSS VSS gf180mcu_as_sc_mcu7t3v3__fillcap_16
XFILLER_134_440 VDD VDD VSS VSS gf180mcu_as_sc_mcu7t3v3__fill_2
XFILLER_4_247 VDD VDD VSS VSS gf180mcu_as_sc_mcu7t3v3__fillcap_4
XPHY_EDGE_ROW_88_3_Right_407 VDD VSS gf180mcu_as_sc_mcu7t3v3__tap_2
XFILLER_106_153 VDD VDD VSS VSS gf180mcu_as_sc_mcu7t3v3__fill_1
XFILLER_150_922 VDD VDD VSS VSS gf180mcu_as_sc_mcu7t3v3__fillcap_4
XFILLER_162_793 VDD VDD VSS VSS gf180mcu_as_sc_mcu7t3v3__fillcap_8
XFILLER_20_85 VDD VDD VSS VSS gf180mcu_as_sc_mcu7t3v3__fillcap_16
XFILLER_121_134 VDD VDD VSS VSS gf180mcu_as_sc_mcu7t3v3__fillcap_4
XFILLER_136_85 VDD VDD VSS VSS gf180mcu_as_sc_mcu7t3v3__fillcap_16
XFILLER_150_944 VDD VDD VSS VSS gf180mcu_as_sc_mcu7t3v3__fill_1
XFILLER_150_999 VDD VDD VSS VSS gf180mcu_as_sc_mcu7t3v3__fill_2
XFILLER_7_1515 VDD VDD VSS VSS gf180mcu_as_sc_mcu7t3v3__fillcap_4
XFILLER_7_1537 VDD VDD VSS VSS gf180mcu_as_sc_mcu7t3v3__fillcap_16
Xinput310 VDD VDD VSS VSS west_in[3] _3956_/D gf180mcu_as_sc_mcu7t3v3__buff_2
XFILLER_29_50 VDD VDD VSS VSS gf180mcu_as_sc_mcu7t3v3__fillcap_16
XFILLER_29_72 VDD VDD VSS VSS gf180mcu_as_sc_mcu7t3v3__fillcap_16
XFILLER_75_298 VDD VDD VSS VSS gf180mcu_as_sc_mcu7t3v3__fill_2
XFILLER_90_224 VDD VDD VSS VSS gf180mcu_as_sc_mcu7t3v3__fill_2
XFILLER_45_60 VDD VDD VSS VSS gf180mcu_as_sc_mcu7t3v3__fillcap_8
XTAP_TAPCELL_ROW_83_3_2474 VDD VSS gf180mcu_as_sc_mcu7t3v3__tap_2
XFILLER_147_1255 VDD VDD VSS VSS gf180mcu_as_sc_mcu7t3v3__fillcap_4
XFILLER_177_808 VDD VDD VSS VSS gf180mcu_as_sc_mcu7t3v3__fill_2
XFILLER_182_1157 VDD VDD VSS VSS gf180mcu_as_sc_mcu7t3v3__fillcap_4
XFILLER_38_1550 VDD VDD VSS VSS gf180mcu_as_sc_mcu7t3v3__fillcap_4
XFILLER_129_212 VDD VDD VSS VSS gf180mcu_as_sc_mcu7t3v3__fillcap_8
XFILLER_160_1433 VDD VDD VSS VSS gf180mcu_as_sc_mcu7t3v3__fill_2
X_2690_ VDD VDD VSS VSS _2735_/A _2690_/B _2690_/C _2727_/S _2691_/C gf180mcu_as_sc_mcu7t3v3__ao22_2
XANTENNA_3 VDD VDD VSS VSS VSS gf180mcu_as_sc_mcu7t3v3__diode_2
XFILLER_129_278 VDD VDD VSS VSS gf180mcu_as_sc_mcu7t3v3__fill_2
XFILLER_144_226 VDD VDD VSS VSS gf180mcu_as_sc_mcu7t3v3__fillcap_16
XFILLER_144_259 VDD VDD VSS VSS gf180mcu_as_sc_mcu7t3v3__fill_1
X_4360_ VDD VDD VSS VSS _4366_/S _5161_/Q _4360_/A _4361_/C gf180mcu_as_sc_mcu7t3v3__mux2_2
X_3311_ VDD VDD VSS VSS _3962_/A _3462_/A _3311_/C _4808_/D _3753_/D gf180mcu_as_sc_mcu7t3v3__aoi211_2
XFILLER_112_123 VDD VDD VSS VSS gf180mcu_as_sc_mcu7t3v3__fillcap_4
XFILLER_112_134 VDD VDD VSS VSS gf180mcu_as_sc_mcu7t3v3__fillcap_8
XFILLER_140_410 VDD VDD VSS VSS gf180mcu_as_sc_mcu7t3v3__fill_2
XFILLER_141_944 VDD VDD VSS VSS gf180mcu_as_sc_mcu7t3v3__fillcap_4
XFILLER_45_1521 VDD VDD VSS VSS gf180mcu_as_sc_mcu7t3v3__fillcap_16
X_4291_ VDD VDD VSS VSS _4627_/B _4649_/A _4291_/A gf180mcu_as_sc_mcu7t3v3__nand2_2
XFILLER_140_465 VDD VDD VSS VSS gf180mcu_as_sc_mcu7t3v3__fill_2
XFILLER_154_1259 VDD VDD VSS VSS gf180mcu_as_sc_mcu7t3v3__fillcap_16
X_3242_ VDD VDD VSS VSS _4803_/D _3825_/C _3242_/B _3242_/A gf180mcu_as_sc_mcu7t3v3__aoi21_2
XFILLER_132_1535 VDD VDD VSS VSS gf180mcu_as_sc_mcu7t3v3__fillcap_4
XFILLER_171_1562 VDD VDD VSS VSS gf180mcu_as_sc_mcu7t3v3__fill_2
XFILLER_20_2 VDD VDD VSS VSS gf180mcu_as_sc_mcu7t3v3__fillcap_16
XFILLER_80_1467 VDD VDD VSS VSS gf180mcu_as_sc_mcu7t3v3__fillcap_16
Xmesh_tile_936 VDD VDD VSS VSS sw_out[9] gf180mcu_as_sc_mcu7t3v3__tiel_4
Xmesh_tile_925 VDD VDD VSS VSS nw_out[32] gf180mcu_as_sc_mcu7t3v3__tiel_4
Xmesh_tile_914 VDD VDD VSS VSS nw_out[21] gf180mcu_as_sc_mcu7t3v3__tiel_4
Xmesh_tile_903 VDD VDD VSS VSS nw_out[10] gf180mcu_as_sc_mcu7t3v3__tiel_4
X_3173_ VDD VDD VSS VSS _3194_/S _3173_/B _4148_/A _3174_/B gf180mcu_as_sc_mcu7t3v3__mux2_2
XFILLER_66_221 VDD VDD VSS VSS gf180mcu_as_sc_mcu7t3v3__fill_1
XPHY_EDGE_ROW_50_3_Right_369 VDD VSS gf180mcu_as_sc_mcu7t3v3__tap_2
Xmesh_tile_958 VDD VDD VSS VSS sw_out[31] gf180mcu_as_sc_mcu7t3v3__tiel_4
Xmesh_tile_947 VDD VDD VSS VSS sw_out[20] gf180mcu_as_sc_mcu7t3v3__tiel_4
XFILLER_26_107 VDD VDD VSS VSS gf180mcu_as_sc_mcu7t3v3__fillcap_16
XTAP_TAPCELL_ROW_163_1850 VDD VSS gf180mcu_as_sc_mcu7t3v3__tap_2
XFILLER_81_224 VDD VDD VSS VSS gf180mcu_as_sc_mcu7t3v3__fillcap_16
XFILLER_161_1208 VDD VDD VSS VSS gf180mcu_as_sc_mcu7t3v3__fillcap_8
XPHY_EDGE_ROW_72_1_Left_524 VDD VSS gf180mcu_as_sc_mcu7t3v3__tap_2
XFILLER_176_841 VDD VDD VSS VSS gf180mcu_as_sc_mcu7t3v3__fill_1
X_2957_ VDD VDD VSS VSS _2964_/B _3241_/B _3943_/A gf180mcu_as_sc_mcu7t3v3__nand2_2
X_2888_ VDD VDD VSS VSS _3788_/A _3796_/A _3776_/B gf180mcu_as_sc_mcu7t3v3__or2_2
XFILLER_135_204 VDD VDD VSS VSS gf180mcu_as_sc_mcu7t3v3__fillcap_4
XFILLER_163_524 VDD VDD VSS VSS gf180mcu_as_sc_mcu7t3v3__fillcap_4
XFILLER_175_384 VDD VDD VSS VSS gf180mcu_as_sc_mcu7t3v3__fillcap_16
X_4627_ VDD VDD VSS VSS _4627_/B _4627_/A _4628_/A gf180mcu_as_sc_mcu7t3v3__and2_2
XFILLER_163_557 VDD VDD VSS VSS gf180mcu_as_sc_mcu7t3v3__fill_2
XFILLER_137_1402 VDD VDD VSS VSS gf180mcu_as_sc_mcu7t3v3__fillcap_16
XFILLER_176_1473 VDD VDD VSS VSS gf180mcu_as_sc_mcu7t3v3__fillcap_8
X_4558_ VDD VDD VSS VSS _4561_/C _4998_/Q _4559_/S gf180mcu_as_sc_mcu7t3v3__nand2b_2
XFILLER_144_793 VDD VDD VSS VSS gf180mcu_as_sc_mcu7t3v3__fill_1
XFILLER_176_1495 VDD VDD VSS VSS gf180mcu_as_sc_mcu7t3v3__fillcap_8
X_4489_ VDD VDD VSS VSS _4518_/S _5019_/Q _5048_/Q _4490_/B gf180mcu_as_sc_mcu7t3v3__mux2_2
X_3509_ VDD VDD VSS VSS _3511_/C _3518_/C _3509_/B _3509_/A gf180mcu_as_sc_mcu7t3v3__aoi21_2
XFILLER_172_1359 VDD VDD VSS VSS gf180mcu_as_sc_mcu7t3v3__fillcap_4
XPHY_EDGE_ROW_96_1_Right_95 VDD VSS gf180mcu_as_sc_mcu7t3v3__tap_2
XFILLER_135_1170 VDD VDD VSS VSS gf180mcu_as_sc_mcu7t3v3__fillcap_16
XFILLER_66_37 VDD VDD VSS VSS gf180mcu_as_sc_mcu7t3v3__fill_1
XFILLER_57_298 VDD VDD VSS VSS gf180mcu_as_sc_mcu7t3v3__fill_2
XFILLER_72_268 VDD VDD VSS VSS gf180mcu_as_sc_mcu7t3v3__fill_1
XFILLER_109_1515 VDD VDD VSS VSS gf180mcu_as_sc_mcu7t3v3__fillcap_4
XFILLER_109_1537 VDD VDD VSS VSS gf180mcu_as_sc_mcu7t3v3__fillcap_16
XFILLER_144_1428 VDD VDD VSS VSS gf180mcu_as_sc_mcu7t3v3__fillcap_4
XFILLER_144_1439 VDD VDD VSS VSS gf180mcu_as_sc_mcu7t3v3__fill_1
XFILLER_158_329 VDD VDD VSS VSS gf180mcu_as_sc_mcu7t3v3__fill_1
XFILLER_139_521 VDD VDD VSS VSS gf180mcu_as_sc_mcu7t3v3__fill_2
XFILLER_167_830 VDD VDD VSS VSS gf180mcu_as_sc_mcu7t3v3__fillcap_8
XPHY_EDGE_ROW_12_3_Right_331 VDD VSS gf180mcu_as_sc_mcu7t3v3__tap_2
XFILLER_142_1152 VDD VDD VSS VSS gf180mcu_as_sc_mcu7t3v3__fill_2
XFILLER_154_524 VDD VDD VSS VSS gf180mcu_as_sc_mcu7t3v3__fill_1
XTAP_TAPCELL_ROW_28_1_746 VDD VSS gf180mcu_as_sc_mcu7t3v3__tap_2
XFILLER_126_237 VDD VDD VSS VSS gf180mcu_as_sc_mcu7t3v3__fillcap_8
XFILLER_177_1259 VDD VDD VSS VSS gf180mcu_as_sc_mcu7t3v3__fill_1
XTAP_TAPCELL_ROW_36_1_781 VDD VSS gf180mcu_as_sc_mcu7t3v3__tap_2
XFILLER_120_1483 VDD VDD VSS VSS gf180mcu_as_sc_mcu7t3v3__fill_1
XFILLER_141_207 VDD VDD VSS VSS gf180mcu_as_sc_mcu7t3v3__fill_2
XPHY_EDGE_ROW_89_3_Right_408 VDD VSS gf180mcu_as_sc_mcu7t3v3__tap_2
XFILLER_134_270 VDD VDD VSS VSS gf180mcu_as_sc_mcu7t3v3__fill_2
XFILLER_155_1535 VDD VDD VSS VSS gf180mcu_as_sc_mcu7t3v3__fillcap_4
XPHY_EDGE_ROW_141_Left_593 VDD VSS gf180mcu_as_sc_mcu7t3v3__tap_2
XFILLER_150_785 VDD VDD VSS VSS gf180mcu_as_sc_mcu7t3v3__fill_2
XFILLER_153_1270 VDD VDD VSS VSS gf180mcu_as_sc_mcu7t3v3__fillcap_4
XFILLER_163_50 VDD VDD VSS VSS gf180mcu_as_sc_mcu7t3v3__fillcap_16
XFILLER_163_72 VDD VDD VSS VSS gf180mcu_as_sc_mcu7t3v3__fillcap_16
Xinput140 VDD VDD VSS VSS north_in[4] _3967_/A gf180mcu_as_sc_mcu7t3v3__buff_2
Xinput151 VDD VDD VSS VSS nw_in[14] _4048_/A gf180mcu_as_sc_mcu7t3v3__buff_2
Xinput162 VDD VDD VSS VSS nw_in[24] _4127_/A gf180mcu_as_sc_mcu7t3v3__buff_2
XFILLER_40_1451 VDD VDD VSS VSS gf180mcu_as_sc_mcu7t3v3__fillcap_16
Xinput173 VDD VDD VSS VSS nw_in[3] _3957_/A gf180mcu_as_sc_mcu7t3v3__buff_2
Xinput184 VDD VDD VSS VSS se_in[12] _4033_/A gf180mcu_as_sc_mcu7t3v3__buff_2
Xinput195 VDD VDD VSS VSS se_in[22] _4114_/A gf180mcu_as_sc_mcu7t3v3__buff_2
XFILLER_63_279 VDD VDD VSS VSS gf180mcu_as_sc_mcu7t3v3__fill_1
XFILLER_147_1052 VDD VDD VSS VSS gf180mcu_as_sc_mcu7t3v3__fillcap_4
XFILLER_162_1539 VDD VDD VSS VSS gf180mcu_as_sc_mcu7t3v3__fillcap_16
XFILLER_72_80 VDD VDD VSS VSS gf180mcu_as_sc_mcu7t3v3__fillcap_16
X_3860_ VDD VDD VSS VSS _5128_/Q _5129_/Q _5130_/Q _3871_/B gf180mcu_as_sc_mcu7t3v3__nor3_2
XFILLER_158_830 VDD VDD VSS VSS gf180mcu_as_sc_mcu7t3v3__fillcap_16
XFILLER_177_649 VDD VDD VSS VSS gf180mcu_as_sc_mcu7t3v3__fill_2
X_3791_ VDD VDD VSS VSS _3791_/A _3791_/B _3791_/C _3799_/D _3792_/C gf180mcu_as_sc_mcu7t3v3__ao22_2
X_2811_ VDD VDD VSS VSS _4953_/D _2811_/C _2841_/A _4719_/A gf180mcu_as_sc_mcu7t3v3__aoi21_2
XFILLER_158_874 VDD VDD VSS VSS gf180mcu_as_sc_mcu7t3v3__fill_1
X_2742_ VDD VDD VSS VSS _4947_/Q _2742_/B _2742_/A _5483_/A gf180mcu_as_sc_mcu7t3v3__mux2_2
XFILLER_117_204 VDD VDD VSS VSS gf180mcu_as_sc_mcu7t3v3__fillcap_4
XFILLER_173_811 VDD VDD VSS VSS gf180mcu_as_sc_mcu7t3v3__fillcap_8
XTAP_TAPCELL_ROW_135_1226 VDD VSS gf180mcu_as_sc_mcu7t3v3__tap_2
XFILLER_12_1564 VDD VDD VSS VSS gf180mcu_as_sc_mcu7t3v3__fillcap_4
X_4412_ VDD VDD VSS VSS _4579_/S _5010_/Q _5039_/Q _4413_/B gf180mcu_as_sc_mcu7t3v3__mux2_2
X_2673_ VDD VDD VSS VSS _2673_/B _5134_/Q _2674_/D gf180mcu_as_sc_mcu7t3v3__and2_2
XTAP_TAPCELL_ROW_135_1237 VDD VSS gf180mcu_as_sc_mcu7t3v3__tap_2
XFILLER_172_365 VDD VDD VSS VSS gf180mcu_as_sc_mcu7t3v3__fillcap_16
XFILLER_172_387 VDD VDD VSS VSS gf180mcu_as_sc_mcu7t3v3__fillcap_16
XFILLER_82_1518 VDD VDD VSS VSS gf180mcu_as_sc_mcu7t3v3__fillcap_16
XFILLER_98_121 VDD VDD VSS VSS gf180mcu_as_sc_mcu7t3v3__fill_1
X_4343_ VDD VDD VSS VSS _4350_/A _5478_/A _4344_/C gf180mcu_as_sc_mcu7t3v3__and2_2
XTAP_TAPCELL_ROW_152_1595 VDD VSS gf180mcu_as_sc_mcu7t3v3__tap_2
X_4274_ VDD VDD VSS VSS _4278_/S _5478_/A _5108_/Q _5108_/D gf180mcu_as_sc_mcu7t3v3__mux2_2
XFILLER_141_796 VDD VDD VSS VSS gf180mcu_as_sc_mcu7t3v3__fill_1
X_3225_ VDD VDD VSS VSS _3226_/D _3225_/B _3225_/A gf180mcu_as_sc_mcu7t3v3__nand2_2
XFILLER_140_295 VDD VDD VSS VSS gf180mcu_as_sc_mcu7t3v3__fillcap_8
XTAP_TAPCELL_ROW_45_1_816 VDD VSS gf180mcu_as_sc_mcu7t3v3__tap_2
XFILLER_39_276 VDD VDD VSS VSS gf180mcu_as_sc_mcu7t3v3__fillcap_4
XPHY_EDGE_ROW_46_3_Left_180 VDD VSS gf180mcu_as_sc_mcu7t3v3__tap_2
X_3156_ VDD VDD VSS VSS _3156_/A _3156_/B _3156_/C _3157_/C gf180mcu_as_sc_mcu7t3v3__nor3_2
XTAP_TAPCELL_ROW_161_1809 VDD VSS gf180mcu_as_sc_mcu7t3v3__tap_2
XFILLER_39_298 VDD VDD VSS VSS gf180mcu_as_sc_mcu7t3v3__fill_2
X_3087_ VDD VDD VSS VSS _4066_/A _3130_/B _3087_/C _3087_/D _3088_/C gf180mcu_as_sc_mcu7t3v3__ao22_2
XTAP_TAPCELL_ROW_132_1_1165 VDD VSS gf180mcu_as_sc_mcu7t3v3__tap_2
XFILLER_165_1152 VDD VDD VSS VSS gf180mcu_as_sc_mcu7t3v3__fillcap_8
XFILLER_167_104 VDD VDD VSS VSS gf180mcu_as_sc_mcu7t3v3__fillcap_16
XFILLER_168_605 VDD VDD VSS VSS gf180mcu_as_sc_mcu7t3v3__fill_1
XFILLER_168_616 VDD VDD VSS VSS gf180mcu_as_sc_mcu7t3v3__fillcap_8
XFILLER_149_830 VDD VDD VSS VSS gf180mcu_as_sc_mcu7t3v3__fillcap_8
XFILLER_161_1049 VDD VDD VSS VSS gf180mcu_as_sc_mcu7t3v3__fill_1
XTAP_TAPCELL_ROW_159_1749 VDD VSS gf180mcu_as_sc_mcu7t3v3__tap_2
XFILLER_143_1450 VDD VDD VSS VSS gf180mcu_as_sc_mcu7t3v3__fillcap_16
XFILLER_143_1472 VDD VDD VSS VSS gf180mcu_as_sc_mcu7t3v3__fillcap_8
X_3989_ VDD VDD VSS VSS _3989_/A _4161_/B _4159_/C _3989_/D _3991_/C gf180mcu_as_sc_mcu7t3v3__ao22_2
XTAP_TAPCELL_ROW_112_1_1085 VDD VSS gf180mcu_as_sc_mcu7t3v3__tap_2
XFILLER_104_1467 VDD VDD VSS VSS gf180mcu_as_sc_mcu7t3v3__fillcap_16
XFILLER_143_1494 VDD VDD VSS VSS gf180mcu_as_sc_mcu7t3v3__fillcap_16
XFILLER_178_1502 VDD VDD VSS VSS gf180mcu_as_sc_mcu7t3v3__fill_2
XFILLER_108_226 VDD VDD VSS VSS gf180mcu_as_sc_mcu7t3v3__fill_2
XFILLER_163_365 VDD VDD VSS VSS gf180mcu_as_sc_mcu7t3v3__fillcap_8
XTAP_TAPCELL_ROW_24_1_730 VDD VSS gf180mcu_as_sc_mcu7t3v3__tap_2
XFILLER_117_65 VDD VDD VSS VSS gf180mcu_as_sc_mcu7t3v3__fillcap_4
XFILLER_131_251 VDD VDD VSS VSS gf180mcu_as_sc_mcu7t3v3__fill_1
XFILLER_176_1292 VDD VDD VSS VSS gf180mcu_as_sc_mcu7t3v3__fill_2
XFILLER_63_1451 VDD VDD VSS VSS gf180mcu_as_sc_mcu7t3v3__fillcap_16
XFILLER_89_187 VDD VDD VSS VSS gf180mcu_as_sc_mcu7t3v3__fillcap_16
Xdelaybuf_0_clk VDD VDD VSS VSS clk delaybuf_1_clk/A gf180mcu_as_sc_mcu7t3v3__clkbuff_12
XFILLER_131_295 VDD VDD VSS VSS gf180mcu_as_sc_mcu7t3v3__fillcap_4
XFILLER_4_1518 VDD VDD VSS VSS gf180mcu_as_sc_mcu7t3v3__fillcap_16
XTAP_TAPCELL_ROW_36_3_2404 VDD VSS gf180mcu_as_sc_mcu7t3v3__tap_2
XFILLER_133_42 VDD VDD VSS VSS gf180mcu_as_sc_mcu7t3v3__fillcap_4
Xhold1050 VDD VDD VSS VSS _4961_/Q hold1050/Y gf180mcu_as_sc_mcu7t3v3__buff_2
XFILLER_172_2 VDD VDD VSS VSS gf180mcu_as_sc_mcu7t3v3__fillcap_16
XFILLER_93_35 VDD VDD VSS VSS gf180mcu_as_sc_mcu7t3v3__fill_2
XFILLER_93_79 VDD VDD VSS VSS gf180mcu_as_sc_mcu7t3v3__fillcap_8
XFILLER_60_227 VDD VDD VSS VSS gf180mcu_as_sc_mcu7t3v3__fillcap_16
XFILLER_148_1383 VDD VDD VSS VSS gf180mcu_as_sc_mcu7t3v3__fillcap_16
XFILLER_159_616 VDD VDD VSS VSS gf180mcu_as_sc_mcu7t3v3__fillcap_8
XFILLER_144_1269 VDD VDD VSS VSS gf180mcu_as_sc_mcu7t3v3__fillcap_4
XPHY_EDGE_ROW_138_Right_272 VDD VSS gf180mcu_as_sc_mcu7t3v3__tap_2
XFILLER_35_1553 VDD VDD VSS VSS gf180mcu_as_sc_mcu7t3v3__fillcap_16
XFILLER_9_136 VDD VDD VSS VSS gf180mcu_as_sc_mcu7t3v3__fillcap_4
XFILLER_9_158 VDD VDD VSS VSS gf180mcu_as_sc_mcu7t3v3__fillcap_16
XPHY_EDGE_ROW_13_3_Right_332 VDD VSS gf180mcu_as_sc_mcu7t3v3__tap_2
XFILLER_122_1534 VDD VDD VSS VSS gf180mcu_as_sc_mcu7t3v3__fillcap_16
XFILLER_122_1556 VDD VDD VSS VSS gf180mcu_as_sc_mcu7t3v3__fill_1
XFILLER_139_384 VDD VDD VSS VSS gf180mcu_as_sc_mcu7t3v3__fillcap_8
XFILLER_142_527 VDD VDD VSS VSS gf180mcu_as_sc_mcu7t3v3__fillcap_16
XFILLER_154_376 VDD VDD VSS VSS gf180mcu_as_sc_mcu7t3v3__fill_2
XFILLER_170_836 VDD VDD VSS VSS gf180mcu_as_sc_mcu7t3v3__fillcap_4
XFILLER_154_387 VDD VDD VSS VSS gf180mcu_as_sc_mcu7t3v3__fill_1
XFILLER_181_184 VDD VDD VSS VSS gf180mcu_as_sc_mcu7t3v3__fillcap_16
XFILLER_107_292 VDD VDD VSS VSS gf180mcu_as_sc_mcu7t3v3__fillcap_8
XFILLER_155_1332 VDD VDD VSS VSS gf180mcu_as_sc_mcu7t3v3__fillcap_16
XFILLER_150_560 VDD VDD VSS VSS gf180mcu_as_sc_mcu7t3v3__fillcap_16
XFILLER_42_1502 VDD VDD VSS VSS gf180mcu_as_sc_mcu7t3v3__fillcap_16
XFILLER_95_113 VDD VDD VSS VSS gf180mcu_as_sc_mcu7t3v3__fillcap_4
XTAP_TAPCELL_ROW_85_1_976 VDD VSS gf180mcu_as_sc_mcu7t3v3__tap_2
XFILLER_122_295 VDD VDD VSS VSS gf180mcu_as_sc_mcu7t3v3__fillcap_4
XFILLER_3_66 VDD VDD VSS VSS gf180mcu_as_sc_mcu7t3v3__fillcap_4
XFILLER_3_88 VDD VDD VSS VSS gf180mcu_as_sc_mcu7t3v3__fillcap_16
XTAP_TAPCELL_ROW_71_3_2456 VDD VSS gf180mcu_as_sc_mcu7t3v3__tap_2
XFILLER_42_1568 VDD VDD VSS VSS gf180mcu_as_sc_mcu7t3v3__fill_1
XFILLER_95_168 VDD VDD VSS VSS gf180mcu_as_sc_mcu7t3v3__fill_1
XFILLER_95_179 VDD VDD VSS VSS gf180mcu_as_sc_mcu7t3v3__fillcap_4
X_3010_ VDD VDD VSS VSS _3178_/A _3010_/B _3010_/C _3178_/D _3012_/C gf180mcu_as_sc_mcu7t3v3__ao211_2
XTAP_TAPCELL_ROW_182_2267 VDD VSS gf180mcu_as_sc_mcu7t3v3__tap_2
XTAP_TAPCELL_ROW_182_2256 VDD VSS gf180mcu_as_sc_mcu7t3v3__tap_2
XTAP_TAPCELL_ROW_41_1_800 VDD VSS gf180mcu_as_sc_mcu7t3v3__tap_2
XFILLER_184_1049 VDD VDD VSS VSS gf180mcu_as_sc_mcu7t3v3__fillcap_4
XFILLER_36_279 VDD VDD VSS VSS gf180mcu_as_sc_mcu7t3v3__fillcap_16
X_4961_ VDD VDD VSS VSS _5146_/CLK _4961_/D _4961_/Q gf180mcu_as_sc_mcu7t3v3__dfxtp_2
XFILLER_166_1483 VDD VDD VSS VSS gf180mcu_as_sc_mcu7t3v3__fillcap_16
XFILLER_51_249 VDD VDD VSS VSS gf180mcu_as_sc_mcu7t3v3__fill_2
X_4892_ VDD VDD VSS VSS _4914_/CLK _4892_/D _4892_/Q gf180mcu_as_sc_mcu7t3v3__dfxtp_2
X_3912_ VDD VDD VSS VSS _4198_/A _4908_/Q _3912_/Y gf180mcu_as_sc_mcu7t3v3__and2_2
XFILLER_127_1467 VDD VDD VSS VSS gf180mcu_as_sc_mcu7t3v3__fillcap_16
XFILLER_149_104 VDD VDD VSS VSS gf180mcu_as_sc_mcu7t3v3__fillcap_16
XFILLER_178_947 VDD VDD VSS VSS gf180mcu_as_sc_mcu7t3v3__fill_2
X_3843_ VDD VDD VSS VSS _3843_/S _3843_/B _3845_/A _3844_/B gf180mcu_as_sc_mcu7t3v3__mux2_2
XTAP_TAPCELL_ROW_96_1_1018 VDD VSS gf180mcu_as_sc_mcu7t3v3__tap_2
XFILLER_158_693 VDD VDD VSS VSS gf180mcu_as_sc_mcu7t3v3__fill_2
XFILLER_164_107 VDD VDD VSS VSS gf180mcu_as_sc_mcu7t3v3__fillcap_16
X_3774_ VDD VDD VSS VSS _4155_/A _3802_/B _3802_/C _3775_/C _3774_/D gf180mcu_as_sc_mcu7t3v3__aoi211_2
X_2725_ VDD VDD VSS VSS _4975_/Q _4963_/Q _4972_/Q _2727_/A gf180mcu_as_sc_mcu7t3v3__mux2_2
XTAP_TAPCELL_ROW_64_1_890 VDD VSS gf180mcu_as_sc_mcu7t3v3__tap_2
XTAP_TAPCELL_ROW_154_1646 VDD VSS gf180mcu_as_sc_mcu7t3v3__tap_2
XTAP_TAPCELL_ROW_154_1635 VDD VSS gf180mcu_as_sc_mcu7t3v3__tap_2
XFILLER_146_877 VDD VDD VSS VSS gf180mcu_as_sc_mcu7t3v3__fillcap_16
XFILLER_156_1107 VDD VDD VSS VSS gf180mcu_as_sc_mcu7t3v3__fill_2
Xoutput400 VDD VDD VSS VSS _4821_/Q south_out[16] gf180mcu_as_sc_mcu7t3v3__buff_2
Xoutput411 VDD VDD VSS VSS _4831_/Q south_out[26] gf180mcu_as_sc_mcu7t3v3__buff_2
X_2656_ VDD VDD VSS VSS _2666_/B _2656_/B _2656_/C _2729_/B _2657_/D gf180mcu_as_sc_mcu7t3v3__ao211_2
XFILLER_86_1451 VDD VDD VSS VSS gf180mcu_as_sc_mcu7t3v3__fillcap_16
Xoutput422 VDD VDD VSS VSS _4810_/Q south_out[5] gf180mcu_as_sc_mcu7t3v3__buff_2
Xoutput433 VDD VDD VSS VSS _4888_/Q west_out[15] gf180mcu_as_sc_mcu7t3v3__buff_2
Xoutput444 VDD VDD VSS VSS _4898_/Q west_out[25] gf180mcu_as_sc_mcu7t3v3__buff_2
Xoutput455 VDD VDD VSS VSS _4877_/Q west_out[4] gf180mcu_as_sc_mcu7t3v3__buff_2
X_2587_ VDD VDD VSS VSS _2587_/Y _2588_/B _2587_/A gf180mcu_as_sc_mcu7t3v3__nand2_2
XFILLER_86_102 VDD VDD VSS VSS gf180mcu_as_sc_mcu7t3v3__fill_2
X_4326_ VDD VDD VSS VSS _4328_/A _5156_/Q _5155_/Q _5155_/D gf180mcu_as_sc_mcu7t3v3__mux2_2
X_4257_ VDD VDD VSS VSS _4257_/S _4257_/B _5093_/Q _5093_/D gf180mcu_as_sc_mcu7t3v3__mux2_2
XFILLER_170_18 VDD VDD VSS VSS gf180mcu_as_sc_mcu7t3v3__fillcap_16
X_4188_ VDD VDD VSS VSS _4248_/B _4188_/B _4188_/C _5026_/Q _5026_/D gf180mcu_as_sc_mcu7t3v3__ao22_2
X_3208_ VDD VDD VSS VSS _3209_/B _3794_/A _3218_/B _3208_/C gf180mcu_as_sc_mcu7t3v3__ao21_2
X_3139_ VDD VDD VSS VSS _3140_/C _3139_/C _3150_/C _4109_/A gf180mcu_as_sc_mcu7t3v3__aoi21_2
XTAP_TAPCELL_ROW_27_1_745 VDD VSS gf180mcu_as_sc_mcu7t3v3__tap_2
XFILLER_167_1247 VDD VDD VSS VSS gf180mcu_as_sc_mcu7t3v3__fillcap_8
XFILLER_63_49 VDD VDD VSS VSS gf180mcu_as_sc_mcu7t3v3__fillcap_16
XFILLER_19_1515 VDD VDD VSS VSS gf180mcu_as_sc_mcu7t3v3__fillcap_4
XFILLER_19_1537 VDD VDD VSS VSS gf180mcu_as_sc_mcu7t3v3__fillcap_16
XFILLER_58_1564 VDD VDD VSS VSS gf180mcu_as_sc_mcu7t3v3__fillcap_4
XFILLER_106_1518 VDD VDD VSS VSS gf180mcu_as_sc_mcu7t3v3__fillcap_16
XFILLER_168_435 VDD VDD VSS VSS gf180mcu_as_sc_mcu7t3v3__fillcap_16
XFILLER_93_1499 VDD VDD VSS VSS gf180mcu_as_sc_mcu7t3v3__fillcap_16
XFILLER_156_619 VDD VDD VSS VSS gf180mcu_as_sc_mcu7t3v3__fillcap_16
XFILLER_168_457 VDD VDD VSS VSS gf180mcu_as_sc_mcu7t3v3__fillcap_8
XFILLER_184_917 VDD VDD VSS VSS gf180mcu_as_sc_mcu7t3v3__fill_1
XFILLER_183_416 VDD VDD VSS VSS gf180mcu_as_sc_mcu7t3v3__fillcap_4
XFILLER_183_438 VDD VDD VSS VSS gf180mcu_as_sc_mcu7t3v3__fillcap_16
XFILLER_12_53 VDD VDD VSS VSS gf180mcu_as_sc_mcu7t3v3__fillcap_16
XFILLER_137_844 VDD VDD VSS VSS gf180mcu_as_sc_mcu7t3v3__fill_1
XFILLER_178_1332 VDD VDD VSS VSS gf180mcu_as_sc_mcu7t3v3__fill_1
XFILLER_6_139 VDD VDD VSS VSS gf180mcu_as_sc_mcu7t3v3__fillcap_16
XFILLER_152_803 VDD VDD VSS VSS gf180mcu_as_sc_mcu7t3v3__fill_2
XFILLER_30_1483 VDD VDD VSS VSS gf180mcu_as_sc_mcu7t3v3__fill_1
XFILLER_104_240 VDD VDD VSS VSS gf180mcu_as_sc_mcu7t3v3__fillcap_4
XFILLER_151_368 VDD VDD VSS VSS gf180mcu_as_sc_mcu7t3v3__fillcap_4
XFILLER_104_251 VDD VDD VSS VSS gf180mcu_as_sc_mcu7t3v3__fill_1
XFILLER_152_1527 VDD VDD VSS VSS gf180mcu_as_sc_mcu7t3v3__fillcap_8
XFILLER_104_295 VDD VDD VSS VSS gf180mcu_as_sc_mcu7t3v3__fillcap_4
XFILLER_8_1451 VDD VDD VSS VSS gf180mcu_as_sc_mcu7t3v3__fillcap_16
Xfanout660 VDD VDD VSS VSS _3272_/Y fanout660/Y gf180mcu_as_sc_mcu7t3v3__buff_2
Xfanout671 VDD VDD VSS VSS fanout675/Y _4160_/C gf180mcu_as_sc_mcu7t3v3__buff_2
Xfanout682 VDD VDD VSS VSS fanout684/Y _3450_/B gf180mcu_as_sc_mcu7t3v3__buff_2
Xfanout693 VDD VDD VSS VSS _3542_/Y _3799_/B gf180mcu_as_sc_mcu7t3v3__buff_2
XTAP_TAPCELL_ROW_81_1_960 VDD VSS gf180mcu_as_sc_mcu7t3v3__tap_2
XPHY_EDGE_ROW_59_1_Right_58 VDD VSS gf180mcu_as_sc_mcu7t3v3__tap_2
XFILLER_37_72 VDD VDD VSS VSS gf180mcu_as_sc_mcu7t3v3__fillcap_16
XFILLER_159_402 VDD VDD VSS VSS gf180mcu_as_sc_mcu7t3v3__fillcap_8
XFILLER_144_1033 VDD VDD VSS VSS gf180mcu_as_sc_mcu7t3v3__fillcap_16
XFILLER_41_260 VDD VDD VSS VSS gf180mcu_as_sc_mcu7t3v3__fillcap_16
XFILLER_144_1055 VDD VDD VSS VSS gf180mcu_as_sc_mcu7t3v3__fill_1
XFILLER_41_282 VDD VDD VSS VSS gf180mcu_as_sc_mcu7t3v3__fillcap_16
XFILLER_146_107 VDD VDD VSS VSS gf180mcu_as_sc_mcu7t3v3__fillcap_4
XPHY_EDGE_ROW_14_3_Right_333 VDD VSS gf180mcu_as_sc_mcu7t3v3__tap_2
X_3490_ VDD VDD VSS VSS _4146_/A _3504_/B _3490_/C _3490_/D _3491_/B gf180mcu_as_sc_mcu7t3v3__ao211_2
X_2510_ VDD VDD VSS VSS _4708_/B _4703_/B _4652_/B gf180mcu_as_sc_mcu7t3v3__nor2b_2
XFILLER_142_335 VDD VDD VSS VSS gf180mcu_as_sc_mcu7t3v3__fill_1
X_2441_ VDD VDD VSS VSS _4091_/A _2441_/A gf180mcu_as_sc_mcu7t3v3__inv_2
X_5160_ VDD VDD VSS VSS _5185_/CLK _5160_/D _5160_/Q gf180mcu_as_sc_mcu7t3v3__dfxtp_2
Xclkbuf_leaf_14_clk_regs VDD VDD VSS VSS clkbuf_3_3_0_clk_regs/Y _5185_/CLK gf180mcu_as_sc_mcu7t3v3__clkbuff_12
XTAP_TAPCELL_ROW_89_3_2483 VDD VSS gf180mcu_as_sc_mcu7t3v3__tap_2
XTAP_TAPCELL_ROW_184_2329 VDD VSS gf180mcu_as_sc_mcu7t3v3__tap_2
XTAP_TAPCELL_ROW_184_2318 VDD VSS gf180mcu_as_sc_mcu7t3v3__tap_2
XTAP_TAPCELL_ROW_184_2307 VDD VSS gf180mcu_as_sc_mcu7t3v3__tap_2
X_5091_ VDD VDD VSS VSS _5185_/CLK _5091_/D _5091_/Q gf180mcu_as_sc_mcu7t3v3__dfxtp_2
X_4111_ VDD VDD VSS VSS _4128_/B _4111_/A _4113_/C gf180mcu_as_sc_mcu7t3v3__and2_2
XPHY_EDGE_ROW_81_1_Left_533 VDD VSS gf180mcu_as_sc_mcu7t3v3__tap_2
X_4042_ VDD VDD VSS VSS _4043_/C _4042_/B _4042_/A gf180mcu_as_sc_mcu7t3v3__nor2_2
XFILLER_83_138 VDD VDD VSS VSS gf180mcu_as_sc_mcu7t3v3__fill_2
XFILLER_168_1523 VDD VDD VSS VSS gf180mcu_as_sc_mcu7t3v3__fillcap_16
XTAP_TAPCELL_ROW_147_1494 VDD VSS gf180mcu_as_sc_mcu7t3v3__tap_2
XTAP_TAPCELL_ROW_147_1483 VDD VSS gf180mcu_as_sc_mcu7t3v3__tap_2
X_4944_ VDD VDD VSS VSS _5094_/CLK _4944_/D _4944_/Q gf180mcu_as_sc_mcu7t3v3__dfxtp_2
XFILLER_166_1280 VDD VDD VSS VSS gf180mcu_as_sc_mcu7t3v3__fillcap_8
XFILLER_138_608 VDD VDD VSS VSS gf180mcu_as_sc_mcu7t3v3__fillcap_16
XFILLER_178_777 VDD VDD VSS VSS gf180mcu_as_sc_mcu7t3v3__fillcap_8
XPHY_EDGE_ROW_131_1_Right_130 VDD VSS gf180mcu_as_sc_mcu7t3v3__tap_2
X_4875_ VDD VDD VSS VSS _4943_/CLK _4875_/D _4875_/Q gf180mcu_as_sc_mcu7t3v3__dfxtp_2
XFILLER_165_416 VDD VDD VSS VSS gf180mcu_as_sc_mcu7t3v3__fillcap_4
XFILLER_177_276 VDD VDD VSS VSS gf180mcu_as_sc_mcu7t3v3__fillcap_4
XFILLER_53_1483 VDD VDD VSS VSS gf180mcu_as_sc_mcu7t3v3__fillcap_16
X_3826_ VDD VDD VSS VSS _3827_/B _3826_/B _4908_/Q gf180mcu_as_sc_mcu7t3v3__nor2_2
XFILLER_14_1467 VDD VDD VSS VSS gf180mcu_as_sc_mcu7t3v3__fillcap_16
XFILLER_177_298 VDD VDD VSS VSS gf180mcu_as_sc_mcu7t3v3__fillcap_16
XFILLER_88_1502 VDD VDD VSS VSS gf180mcu_as_sc_mcu7t3v3__fillcap_16
X_3757_ VDD VDD VSS VSS _3758_/C _4135_/A _3791_/B _3757_/C gf180mcu_as_sc_mcu7t3v3__ao21_2
XFILLER_165_18 VDD VDD VSS VSS gf180mcu_as_sc_mcu7t3v3__fillcap_16
XFILLER_180_419 VDD VDD VSS VSS gf180mcu_as_sc_mcu7t3v3__fillcap_16
X_2708_ VDD VDD VSS VSS _2709_/D _2709_/A _2736_/B _2708_/A gf180mcu_as_sc_mcu7t3v3__aoi21b_2
XFILLER_134_836 VDD VDD VSS VSS gf180mcu_as_sc_mcu7t3v3__fillcap_4
XFILLER_134_858 VDD VDD VSS VSS gf180mcu_as_sc_mcu7t3v3__fill_1
XFILLER_173_482 VDD VDD VSS VSS gf180mcu_as_sc_mcu7t3v3__fill_1
XFILLER_175_1527 VDD VDD VSS VSS gf180mcu_as_sc_mcu7t3v3__fillcap_8
XFILLER_88_1568 VDD VDD VSS VSS gf180mcu_as_sc_mcu7t3v3__fill_1
X_3688_ VDD VDD VSS VSS _4931_/Q _3740_/B _3741_/C _4062_/A _3689_/D gf180mcu_as_sc_mcu7t3v3__ao22_2
X_2639_ VDD VDD VSS VSS _4264_/B _2639_/B _2639_/A _2640_/B gf180mcu_as_sc_mcu7t3v3__mux2_2
XFILLER_134_1202 VDD VDD VSS VSS gf180mcu_as_sc_mcu7t3v3__fillcap_16
XFILLER_173_1262 VDD VDD VSS VSS gf180mcu_as_sc_mcu7t3v3__fillcap_8
XTAP_TAPCELL_ROW_120_1_1114 VDD VSS gf180mcu_as_sc_mcu7t3v3__tap_2
XFILLER_101_232 VDD VDD VSS VSS gf180mcu_as_sc_mcu7t3v3__fill_2
XFILLER_59_146 VDD VDD VSS VSS gf180mcu_as_sc_mcu7t3v3__fill_2
XFILLER_99_282 VDD VDD VSS VSS gf180mcu_as_sc_mcu7t3v3__fillcap_16
X_4309_ VDD VDD VSS VSS _4321_/S _5139_/Q _5138_/Q _5138_/D gf180mcu_as_sc_mcu7t3v3__mux2_2
XFILLER_101_298 VDD VDD VSS VSS gf180mcu_as_sc_mcu7t3v3__fill_2
XFILLER_114_88 VDD VDD VSS VSS gf180mcu_as_sc_mcu7t3v3__fillcap_4
XFILLER_74_37 VDD VDD VSS VSS gf180mcu_as_sc_mcu7t3v3__fill_1
XTAP_TAPCELL_ROW_100_1_1034 VDD VSS gf180mcu_as_sc_mcu7t3v3__tap_2
XFILLER_169_733 VDD VDD VSS VSS gf180mcu_as_sc_mcu7t3v3__fill_1
XFILLER_90_14 VDD VDD VSS VSS gf180mcu_as_sc_mcu7t3v3__fill_2
XFILLER_157_906 VDD VDD VSS VSS gf180mcu_as_sc_mcu7t3v3__fillcap_4
XFILLER_169_755 VDD VDD VSS VSS gf180mcu_as_sc_mcu7t3v3__fill_2
XFILLER_23_260 VDD VDD VSS VSS gf180mcu_as_sc_mcu7t3v3__fillcap_16
XFILLER_23_282 VDD VDD VSS VSS gf180mcu_as_sc_mcu7t3v3__fillcap_16
XFILLER_90_58 VDD VDD VSS VSS gf180mcu_as_sc_mcu7t3v3__fillcap_4
XFILLER_156_416 VDD VDD VSS VSS gf180mcu_as_sc_mcu7t3v3__fillcap_16
XFILLER_32_1534 VDD VDD VSS VSS gf180mcu_as_sc_mcu7t3v3__fillcap_16
XFILLER_32_1556 VDD VDD VSS VSS gf180mcu_as_sc_mcu7t3v3__fillcap_8
XFILLER_180_942 VDD VDD VSS VSS gf180mcu_as_sc_mcu7t3v3__fill_2
XFILLER_140_828 VDD VDD VSS VSS gf180mcu_as_sc_mcu7t3v3__fillcap_16
XFILLER_156_1460 VDD VDD VSS VSS gf180mcu_as_sc_mcu7t3v3__fill_2
XFILLER_2_142 VDD VDD VSS VSS gf180mcu_as_sc_mcu7t3v3__fillcap_4
XFILLER_152_1313 VDD VDD VSS VSS gf180mcu_as_sc_mcu7t3v3__fillcap_8
XFILLER_156_1493 VDD VDD VSS VSS gf180mcu_as_sc_mcu7t3v3__fill_2
XFILLER_117_1499 VDD VDD VSS VSS gf180mcu_as_sc_mcu7t3v3__fillcap_16
XFILLER_171_50 VDD VDD VSS VSS gf180mcu_as_sc_mcu7t3v3__fillcap_16
XFILLER_171_72 VDD VDD VSS VSS gf180mcu_as_sc_mcu7t3v3__fillcap_16
Xfanout490 VDD VDD VSS VSS _4108_/D _4166_/D gf180mcu_as_sc_mcu7t3v3__buff_2
XTAP_TAPCELL_ROW_55_1_854 VDD VSS gf180mcu_as_sc_mcu7t3v3__tap_2
XFILLER_61_300 VDD VDD VSS VSS gf180mcu_as_sc_mcu7t3v3__fill_1
XFILLER_73_160 VDD VDD VSS VSS gf180mcu_as_sc_mcu7t3v3__fill_1
XFILLER_64_92 VDD VDD VSS VSS gf180mcu_as_sc_mcu7t3v3__fill_1
XFILLER_76_1483 VDD VDD VSS VSS gf180mcu_as_sc_mcu7t3v3__fill_1
X_2990_ VDD VDD VSS VSS _4775_/D _2990_/C _3156_/A _3971_/A gf180mcu_as_sc_mcu7t3v3__aoi21_2
XTAP_TAPCELL_ROW_177_2144 VDD VSS gf180mcu_as_sc_mcu7t3v3__tap_2
XTAP_TAPCELL_ROW_142_1391 VDD VSS gf180mcu_as_sc_mcu7t3v3__tap_2
XTAP_TAPCELL_ROW_142_1380 VDD VSS gf180mcu_as_sc_mcu7t3v3__tap_2
XFILLER_148_906 VDD VDD VSS VSS gf180mcu_as_sc_mcu7t3v3__fillcap_16
XFILLER_37_1467 VDD VDD VSS VSS gf180mcu_as_sc_mcu7t3v3__fillcap_16
XTAP_TAPCELL_ROW_177_2155 VDD VSS gf180mcu_as_sc_mcu7t3v3__tap_2
X_4660_ VDD VDD VSS VSS _5239_/D _4660_/C _4660_/B _4660_/A gf180mcu_as_sc_mcu7t3v3__aoi21b_2
XFILLER_80_80 VDD VDD VSS VSS gf180mcu_as_sc_mcu7t3v3__fillcap_8
X_3611_ VDD VDD VSS VSS _3615_/B _3611_/C _3726_/B _3984_/A gf180mcu_as_sc_mcu7t3v3__aoi21_2
XTAP_TAPCELL_ROW_18_1_709 VDD VSS gf180mcu_as_sc_mcu7t3v3__tap_2
XFILLER_127_151 VDD VDD VSS VSS gf180mcu_as_sc_mcu7t3v3__fillcap_8
XFILLER_156_961 VDD VDD VSS VSS gf180mcu_as_sc_mcu7t3v3__fill_2
XFILLER_174_279 VDD VDD VSS VSS gf180mcu_as_sc_mcu7t3v3__fillcap_16
XPHY_EDGE_ROW_15_3_Right_334 VDD VSS gf180mcu_as_sc_mcu7t3v3__tap_2
X_4591_ VDD VDD VSS VSS _4591_/B _4591_/A _4592_/D gf180mcu_as_sc_mcu7t3v3__and2_2
X_3542_ VDD VDD VSS VSS _3914_/B _3542_/A _3542_/Y gf180mcu_as_sc_mcu7t3v3__and2_2
XFILLER_127_195 VDD VDD VSS VSS gf180mcu_as_sc_mcu7t3v3__fillcap_4
X_3473_ VDD VDD VSS VSS _4128_/A _3473_/B _3473_/C _3473_/D _3475_/C gf180mcu_as_sc_mcu7t3v3__ao211_2
X_5212_ VDD VDD VSS VSS clkload0/A _5212_/D _5212_/Q gf180mcu_as_sc_mcu7t3v3__dfxtp_2
X_2424_ VDD VDD VSS VSS _3944_/A _2424_/A gf180mcu_as_sc_mcu7t3v3__inv_2
XFILLER_135_1533 VDD VDD VSS VSS gf180mcu_as_sc_mcu7t3v3__fillcap_4
X_5143_ VDD VDD VSS VSS _5146_/CLK _5143_/D _5143_/Q gf180mcu_as_sc_mcu7t3v3__dfxtp_2
XFILLER_96_241 VDD VDD VSS VSS gf180mcu_as_sc_mcu7t3v3__fillcap_4
XTAP_TAPCELL_ROW_149_1545 VDD VSS gf180mcu_as_sc_mcu7t3v3__tap_2
XTAP_TAPCELL_ROW_149_1534 VDD VSS gf180mcu_as_sc_mcu7t3v3__tap_2
X_5074_ VDD VDD VSS VSS _5074_/CLK _5074_/D _5074_/Q gf180mcu_as_sc_mcu7t3v3__dfxtp_2
XPHY_EDGE_ROW_74_3_Left_208 VDD VSS gf180mcu_as_sc_mcu7t3v3__tap_2
X_4025_ VDD VDD VSS VSS _4025_/A _4105_/B _4025_/C _4025_/D _4026_/B gf180mcu_as_sc_mcu7t3v3__ao211_2
XFILLER_0_1510 VDD VDD VSS VSS gf180mcu_as_sc_mcu7t3v3__fillcap_4
XFILLER_168_1375 VDD VDD VSS VSS gf180mcu_as_sc_mcu7t3v3__fill_2
XFILLER_142_1504 VDD VDD VSS VSS gf180mcu_as_sc_mcu7t3v3__fill_1
XFILLER_16_1518 VDD VDD VSS VSS gf180mcu_as_sc_mcu7t3v3__fillcap_16
XFILLER_178_541 VDD VDD VSS VSS gf180mcu_as_sc_mcu7t3v3__fill_1
XFILLER_181_1542 VDD VDD VSS VSS gf180mcu_as_sc_mcu7t3v3__fillcap_16
XPHY_EDGE_ROW_4_1_Left_456 VDD VSS gf180mcu_as_sc_mcu7t3v3__tap_2
X_4927_ VDD VDD VSS VSS _5085_/CLK _4927_/D _4927_/Q gf180mcu_as_sc_mcu7t3v3__dfxtp_2
XFILLER_100_79 VDD VDD VSS VSS gf180mcu_as_sc_mcu7t3v3__fillcap_16
XFILLER_20_241 VDD VDD VSS VSS gf180mcu_as_sc_mcu7t3v3__fillcap_4
XPHY_EDGE_ROW_132_1_Right_131 VDD VSS gf180mcu_as_sc_mcu7t3v3__tap_2
X_4858_ VDD VDD VSS VSS _4858_/CLK _4858_/D _4858_/Q gf180mcu_as_sc_mcu7t3v3__dfxtp_2
XTAP_TAPCELL_ROW_72_1_924 VDD VSS gf180mcu_as_sc_mcu7t3v3__tap_2
XFILLER_20_263 VDD VDD VSS VSS gf180mcu_as_sc_mcu7t3v3__fillcap_8
X_3809_ VDD VDD VSS VSS _3932_/C _3818_/C _3818_/D gf180mcu_as_sc_mcu7t3v3__nand2_2
XFILLER_153_419 VDD VDD VSS VSS gf180mcu_as_sc_mcu7t3v3__fill_1
XFILLER_165_279 VDD VDD VSS VSS gf180mcu_as_sc_mcu7t3v3__fill_1
X_4789_ VDD VDD VSS VSS _5053_/CLK _4789_/D _4789_/Q gf180mcu_as_sc_mcu7t3v3__dfxtp_2
XFILLER_134_611 VDD VDD VSS VSS gf180mcu_as_sc_mcu7t3v3__fill_1
XFILLER_140_1294 VDD VDD VSS VSS gf180mcu_as_sc_mcu7t3v3__fill_1
XFILLER_162_942 VDD VDD VSS VSS gf180mcu_as_sc_mcu7t3v3__fill_2
XFILLER_175_1313 VDD VDD VSS VSS gf180mcu_as_sc_mcu7t3v3__fillcap_8
XFILLER_109_88 VDD VDD VSS VSS gf180mcu_as_sc_mcu7t3v3__fillcap_4
XFILLER_118_195 VDD VDD VSS VSS gf180mcu_as_sc_mcu7t3v3__fillcap_4
XFILLER_161_430 VDD VDD VSS VSS gf180mcu_as_sc_mcu7t3v3__fillcap_4
XFILLER_87_241 VDD VDD VSS VSS gf180mcu_as_sc_mcu7t3v3__fillcap_8
XFILLER_47_138 VDD VDD VSS VSS gf180mcu_as_sc_mcu7t3v3__fill_2
XFILLER_85_69 VDD VDD VSS VSS gf180mcu_as_sc_mcu7t3v3__fill_1
XFILLER_18_85 VDD VDD VSS VSS gf180mcu_as_sc_mcu7t3v3__fillcap_16
XFILLER_43_300 VDD VDD VSS VSS gf180mcu_as_sc_mcu7t3v3__fill_1
XFILLER_99_1483 VDD VDD VSS VSS gf180mcu_as_sc_mcu7t3v3__fillcap_16
XFILLER_55_171 VDD VDD VSS VSS gf180mcu_as_sc_mcu7t3v3__fillcap_16
XFILLER_147_1459 VDD VDD VSS VSS gf180mcu_as_sc_mcu7t3v3__fill_1
XFILLER_70_174 VDD VDD VSS VSS gf180mcu_as_sc_mcu7t3v3__fill_1
XTAP_TAPCELL_ROW_97_1_1023 VDD VSS gf180mcu_as_sc_mcu7t3v3__tap_2
XTAP_TAPCELL_ROW_58_1_869 VDD VSS gf180mcu_as_sc_mcu7t3v3__tap_2
XFILLER_156_235 VDD VDD VSS VSS gf180mcu_as_sc_mcu7t3v3__fillcap_8
XFILLER_7_212 VDD VDD VSS VSS gf180mcu_as_sc_mcu7t3v3__fillcap_16
XTAP_TAPCELL_ROW_172_2041 VDD VSS gf180mcu_as_sc_mcu7t3v3__tap_2
XTAP_TAPCELL_ROW_172_2030 VDD VSS gf180mcu_as_sc_mcu7t3v3__tap_2
XFILLER_138_983 VDD VDD VSS VSS gf180mcu_as_sc_mcu7t3v3__fillcap_16
XFILLER_153_920 VDD VDD VSS VSS gf180mcu_as_sc_mcu7t3v3__fillcap_4
XFILLER_158_1511 VDD VDD VSS VSS gf180mcu_as_sc_mcu7t3v3__fill_1
XFILLER_78_241 VDD VDD VSS VSS gf180mcu_as_sc_mcu7t3v3__fillcap_4
XFILLER_93_222 VDD VDD VSS VSS gf180mcu_as_sc_mcu7t3v3__fill_1
XTAP_TAPCELL_ROW_144_1420 VDD VSS gf180mcu_as_sc_mcu7t3v3__tap_2
XFILLER_78_1534 VDD VDD VSS VSS gf180mcu_as_sc_mcu7t3v3__fillcap_16
XTAP_TAPCELL_ROW_37_1_783 VDD VSS gf180mcu_as_sc_mcu7t3v3__tap_2
XTAP_TAPCELL_ROW_144_1431 VDD VSS gf180mcu_as_sc_mcu7t3v3__tap_2
XFILLER_165_1504 VDD VDD VSS VSS gf180mcu_as_sc_mcu7t3v3__fillcap_16
XFILLER_78_1556 VDD VDD VSS VSS gf180mcu_as_sc_mcu7t3v3__fillcap_8
XTAP_TAPCELL_ROW_140_1339 VDD VSS gf180mcu_as_sc_mcu7t3v3__tap_2
XTAP_TAPCELL_ROW_140_1328 VDD VSS gf180mcu_as_sc_mcu7t3v3__tap_2
XFILLER_98_2 VDD VDD VSS VSS gf180mcu_as_sc_mcu7t3v3__fillcap_8
X_2973_ VDD VDD VSS VSS _3953_/A _3182_/B _2973_/C _4773_/D _3825_/C gf180mcu_as_sc_mcu7t3v3__aoi211_2
X_4712_ VDD VDD VSS VSS _4749_/B _4712_/B _5105_/Q _5258_/D gf180mcu_as_sc_mcu7t3v3__mux2_2
XFILLER_175_533 VDD VDD VSS VSS gf180mcu_as_sc_mcu7t3v3__fillcap_4
X_4643_ VDD VDD VSS VSS _4643_/B _4643_/A _4649_/C gf180mcu_as_sc_mcu7t3v3__and2_2
XTAP_TAPCELL_ROW_77_3_2465 VDD VSS gf180mcu_as_sc_mcu7t3v3__tap_2
XFILLER_147_279 VDD VDD VSS VSS gf180mcu_as_sc_mcu7t3v3__fill_1
XFILLER_50_1486 VDD VDD VSS VSS gf180mcu_as_sc_mcu7t3v3__fillcap_16
X_4574_ VDD VDD VSS VSS _5186_/Q _4574_/B _4574_/C _4574_/D _5186_/D gf180mcu_as_sc_mcu7t3v3__ao211_2
XFILLER_144_942 VDD VDD VSS VSS gf180mcu_as_sc_mcu7t3v3__fill_2
XPHY_EDGE_ROW_16_3_Right_335 VDD VSS gf180mcu_as_sc_mcu7t3v3__tap_2
X_3525_ VDD VDD VSS VSS _3525_/B _3768_/A _4837_/D gf180mcu_as_sc_mcu7t3v3__and2_2
XFILLER_143_463 VDD VDD VSS VSS gf180mcu_as_sc_mcu7t3v3__fillcap_4
XFILLER_157_1043 VDD VDD VSS VSS gf180mcu_as_sc_mcu7t3v3__fillcap_4
XFILLER_171_772 VDD VDD VSS VSS gf180mcu_as_sc_mcu7t3v3__fill_1
XFILLER_115_198 VDD VDD VSS VSS gf180mcu_as_sc_mcu7t3v3__fill_1
XFILLER_157_1098 VDD VDD VSS VSS gf180mcu_as_sc_mcu7t3v3__fillcap_8
X_3456_ VDD VDD VSS VSS _4937_/Q _3486_/B _3472_/C _4112_/A _3458_/C gf180mcu_as_sc_mcu7t3v3__ao22_2
XPHY_EDGE_ROW_107_1_Left_559 VDD VSS gf180mcu_as_sc_mcu7t3v3__tap_2
X_3387_ VDD VDD VSS VSS _3442_/B _4040_/A _3388_/D gf180mcu_as_sc_mcu7t3v3__or2_2
X_2407_ VDD VDD VSS VSS _2539_/B _5163_/Q gf180mcu_as_sc_mcu7t3v3__inv_2
XTAP_TAPCELL_ROW_168_1954 VDD VSS gf180mcu_as_sc_mcu7t3v3__tap_2
XTAP_TAPCELL_ROW_168_1943 VDD VSS gf180mcu_as_sc_mcu7t3v3__tap_2
XFILLER_135_1396 VDD VDD VSS VSS gf180mcu_as_sc_mcu7t3v3__fillcap_4
X_5126_ VDD VDD VSS VSS clkload8/A _5126_/D _5126_/Q gf180mcu_as_sc_mcu7t3v3__dfxtp_2
X_5057_ VDD VDD VSS VSS _5173_/CLK _5057_/D _5057_/Q gf180mcu_as_sc_mcu7t3v3__dfxtp_2
XFILLER_25_300 VDD VDD VSS VSS gf180mcu_as_sc_mcu7t3v3__fill_1
XFILLER_55_39 VDD VDD VSS VSS gf180mcu_as_sc_mcu7t3v3__fillcap_16
X_4008_ VDD VDD VSS VSS _4008_/A _4127_/B _4104_/C _4008_/D _4009_/D gf180mcu_as_sc_mcu7t3v3__ao22_2
XFILLER_168_1161 VDD VDD VSS VSS gf180mcu_as_sc_mcu7t3v3__fill_2
XFILLER_111_34 VDD VDD VSS VSS gf180mcu_as_sc_mcu7t3v3__fillcap_4
XFILLER_111_78 VDD VDD VSS VSS gf180mcu_as_sc_mcu7t3v3__fillcap_8
XFILLER_52_174 VDD VDD VSS VSS gf180mcu_as_sc_mcu7t3v3__fill_1
XFILLER_71_27 VDD VDD VSS VSS gf180mcu_as_sc_mcu7t3v3__fillcap_8
XFILLER_166_500 VDD VDD VSS VSS gf180mcu_as_sc_mcu7t3v3__fill_1
XFILLER_179_894 VDD VDD VSS VSS gf180mcu_as_sc_mcu7t3v3__fill_1
XFILLER_138_224 VDD VDD VSS VSS gf180mcu_as_sc_mcu7t3v3__fill_2
XFILLER_139_747 VDD VDD VSS VSS gf180mcu_as_sc_mcu7t3v3__fill_1
XFILLER_142_1367 VDD VDD VSS VSS gf180mcu_as_sc_mcu7t3v3__fillcap_8
XTAP_TAPCELL_ROW_46_1_818 VDD VSS gf180mcu_as_sc_mcu7t3v3__tap_2
XPHY_EDGE_ROW_133_1_Right_132 VDD VSS gf180mcu_as_sc_mcu7t3v3__tap_2
XTAP_TAPCELL_ROW_54_1_853 VDD VSS gf180mcu_as_sc_mcu7t3v3__tap_2
XFILLER_135_920 VDD VDD VSS VSS gf180mcu_as_sc_mcu7t3v3__fillcap_4
XFILLER_166_588 VDD VDD VSS VSS gf180mcu_as_sc_mcu7t3v3__fillcap_4
XFILLER_177_1419 VDD VDD VSS VSS gf180mcu_as_sc_mcu7t3v3__fillcap_8
XFILLER_181_525 VDD VDD VSS VSS gf180mcu_as_sc_mcu7t3v3__fill_2
XPHY_EDGE_ROW_68_1_Right_67 VDD VSS gf180mcu_as_sc_mcu7t3v3__tap_2
XFILLER_136_53 VDD VDD VSS VSS gf180mcu_as_sc_mcu7t3v3__fillcap_16
XFILLER_162_761 VDD VDD VSS VSS gf180mcu_as_sc_mcu7t3v3__fill_2
XFILLER_20_53 VDD VDD VSS VSS gf180mcu_as_sc_mcu7t3v3__fillcap_16
XFILLER_161_271 VDD VDD VSS VSS gf180mcu_as_sc_mcu7t3v3__fillcap_8
XFILLER_161_282 VDD VDD VSS VSS gf180mcu_as_sc_mcu7t3v3__fill_2
XFILLER_171_1029 VDD VDD VSS VSS gf180mcu_as_sc_mcu7t3v3__fillcap_8
XFILLER_175_1176 VDD VDD VSS VSS gf180mcu_as_sc_mcu7t3v3__fill_2
XFILLER_118_1550 VDD VDD VSS VSS gf180mcu_as_sc_mcu7t3v3__fillcap_4
XFILLER_121_157 VDD VDD VSS VSS gf180mcu_as_sc_mcu7t3v3__fillcap_8
XFILLER_153_1452 VDD VDD VSS VSS gf180mcu_as_sc_mcu7t3v3__fillcap_4
XFILLER_96_68 VDD VDD VSS VSS gf180mcu_as_sc_mcu7t3v3__fill_1
Xinput300 VDD VDD VSS VSS west_in[25] _4135_/D gf180mcu_as_sc_mcu7t3v3__buff_2
Xinput311 VDD VDD VSS VSS west_in[4] _3965_/D gf180mcu_as_sc_mcu7t3v3__buff_2
XFILLER_27_1499 VDD VDD VSS VSS gf180mcu_as_sc_mcu7t3v3__fillcap_16
XFILLER_152_85 VDD VDD VSS VSS gf180mcu_as_sc_mcu7t3v3__fillcap_16
XFILLER_28_171 VDD VDD VSS VSS gf180mcu_as_sc_mcu7t3v3__fillcap_4
XFILLER_28_193 VDD VDD VSS VSS gf180mcu_as_sc_mcu7t3v3__fillcap_16
XFILLER_90_247 VDD VDD VSS VSS gf180mcu_as_sc_mcu7t3v3__fillcap_8
XFILLER_45_72 VDD VDD VSS VSS gf180mcu_as_sc_mcu7t3v3__fillcap_16
XFILLER_43_174 VDD VDD VSS VSS gf180mcu_as_sc_mcu7t3v3__fill_2
XFILLER_125_1521 VDD VDD VSS VSS gf180mcu_as_sc_mcu7t3v3__fillcap_16
XFILLER_157_544 VDD VDD VSS VSS gf180mcu_as_sc_mcu7t3v3__fillcap_16
XPHY_EDGE_ROW_90_1_Left_542 VDD VSS gf180mcu_as_sc_mcu7t3v3__tap_2
XANTENNA_4 VDD VDD VSS VSS _4935_/D gf180mcu_as_sc_mcu7t3v3__diode_2
XFILLER_141_912 VDD VDD VSS VSS gf180mcu_as_sc_mcu7t3v3__fillcap_16
XFILLER_153_772 VDD VDD VSS VSS gf180mcu_as_sc_mcu7t3v3__fillcap_16
XFILLER_154_1205 VDD VDD VSS VSS gf180mcu_as_sc_mcu7t3v3__fillcap_16
X_3310_ VDD VDD VSS VSS _3462_/A _3310_/B _3310_/C _3311_/C gf180mcu_as_sc_mcu7t3v3__nor3_2
XFILLER_152_293 VDD VDD VSS VSS gf180mcu_as_sc_mcu7t3v3__fillcap_8
XFILLER_154_1227 VDD VDD VSS VSS gf180mcu_as_sc_mcu7t3v3__fillcap_4
X_4290_ VDD VDD VSS VSS _4719_/A _4290_/B _5124_/Q _5124_/D gf180mcu_as_sc_mcu7t3v3__mux2_2
XFILLER_112_157 VDD VDD VSS VSS gf180mcu_as_sc_mcu7t3v3__fill_2
X_3241_ VDD VDD VSS VSS _3242_/B _3523_/A _3241_/B _3241_/C _3524_/A gf180mcu_as_sc_mcu7t3v3__aoi22_2
Xmesh_tile_926 VDD VDD VSS VSS nw_out[33] gf180mcu_as_sc_mcu7t3v3__tiel_4
Xmesh_tile_915 VDD VDD VSS VSS nw_out[22] gf180mcu_as_sc_mcu7t3v3__tiel_4
Xmesh_tile_904 VDD VDD VSS VSS nw_out[11] gf180mcu_as_sc_mcu7t3v3__tiel_4
X_3172_ VDD VDD VSS VSS _4146_/D _3239_/A _3172_/C _3172_/D _3173_/B gf180mcu_as_sc_mcu7t3v3__ao211_2
XFILLER_13_2 VDD VDD VSS VSS gf180mcu_as_sc_mcu7t3v3__fillcap_16
XFILLER_66_233 VDD VDD VSS VSS gf180mcu_as_sc_mcu7t3v3__fillcap_8
Xmesh_tile_959 VDD VDD VSS VSS sw_out[32] gf180mcu_as_sc_mcu7t3v3__tiel_4
Xmesh_tile_948 VDD VDD VSS VSS sw_out[21] gf180mcu_as_sc_mcu7t3v3__tiel_4
Xmesh_tile_937 VDD VDD VSS VSS sw_out[10] gf180mcu_as_sc_mcu7t3v3__tiel_4
XTAP_TAPCELL_ROW_163_1851 VDD VSS gf180mcu_as_sc_mcu7t3v3__tap_2
XTAP_TAPCELL_ROW_163_1840 VDD VSS gf180mcu_as_sc_mcu7t3v3__tap_2
XFILLER_66_299 VDD VDD VSS VSS gf180mcu_as_sc_mcu7t3v3__fill_2
XFILLER_165_1312 VDD VDD VSS VSS gf180mcu_as_sc_mcu7t3v3__fillcap_16
XFILLER_179_146 VDD VDD VSS VSS gf180mcu_as_sc_mcu7t3v3__fill_2
XTAP_TAPCELL_ROW_86_1_978 VDD VSS gf180mcu_as_sc_mcu7t3v3__tap_2
XFILLER_91_1553 VDD VDD VSS VSS gf180mcu_as_sc_mcu7t3v3__fillcap_8
XFILLER_148_533 VDD VDD VSS VSS gf180mcu_as_sc_mcu7t3v3__fill_1
X_2956_ VDD VDD VSS VSS _2956_/B _3624_/A _4771_/D gf180mcu_as_sc_mcu7t3v3__and2_2
XFILLER_175_330 VDD VDD VSS VSS gf180mcu_as_sc_mcu7t3v3__fillcap_16
XFILLER_175_352 VDD VDD VSS VSS gf180mcu_as_sc_mcu7t3v3__fillcap_16
X_2887_ VDD VDD VSS VSS _3811_/A _3788_/A _3796_/A gf180mcu_as_sc_mcu7t3v3__nor2_2
X_4626_ VDD VDD VSS VSS _5276_/Q _4626_/B _4626_/A _4628_/B gf180mcu_as_sc_mcu7t3v3__mux2_2
XTAP_TAPCELL_ROW_42_1_802 VDD VSS gf180mcu_as_sc_mcu7t3v3__tap_2
XFILLER_176_1430 VDD VDD VSS VSS gf180mcu_as_sc_mcu7t3v3__fill_1
XPHY_EDGE_ROW_17_3_Right_336 VDD VSS gf180mcu_as_sc_mcu7t3v3__tap_2
X_4557_ VDD VDD VSS VSS _4561_/B _5085_/Q _4559_/S gf180mcu_as_sc_mcu7t3v3__nand2_2
XFILLER_143_282 VDD VDD VSS VSS gf180mcu_as_sc_mcu7t3v3__fillcap_16
X_4488_ VDD VDD VSS VSS _4491_/C _4990_/Q _4518_/S gf180mcu_as_sc_mcu7t3v3__nand2b_2
X_3508_ VDD VDD VSS VSS _3508_/A _3533_/A _3812_/A _3517_/D _3509_/B gf180mcu_as_sc_mcu7t3v3__nand4_2
XFILLER_106_34 VDD VDD VSS VSS gf180mcu_as_sc_mcu7t3v3__fill_1
XFILLER_137_1469 VDD VDD VSS VSS gf180mcu_as_sc_mcu7t3v3__fill_1
XPHY_EDGE_ROW_18_3_Left_152 VDD VSS gf180mcu_as_sc_mcu7t3v3__tap_2
X_3439_ VDD VDD VSS VSS _4091_/A _3455_/B _3439_/C _4824_/D _3730_/D gf180mcu_as_sc_mcu7t3v3__aoi211_2
XFILLER_103_179 VDD VDD VSS VSS gf180mcu_as_sc_mcu7t3v3__fillcap_16
XFILLER_135_1160 VDD VDD VSS VSS gf180mcu_as_sc_mcu7t3v3__fill_2
XFILLER_66_27 VDD VDD VSS VSS gf180mcu_as_sc_mcu7t3v3__fillcap_8
XFILLER_170_1084 VDD VDD VSS VSS gf180mcu_as_sc_mcu7t3v3__fill_1
XFILLER_57_222 VDD VDD VSS VSS gf180mcu_as_sc_mcu7t3v3__fillcap_8
X_5109_ VDD VDD VSS VSS _5186_/CLK _5109_/D _5109_/Q gf180mcu_as_sc_mcu7t3v3__dfxtp_2
XFILLER_122_88 VDD VDD VSS VSS gf180mcu_as_sc_mcu7t3v3__fillcap_4
XFILLER_72_247 VDD VDD VSS VSS gf180mcu_as_sc_mcu7t3v3__fillcap_4
XFILLER_82_37 VDD VDD VSS VSS gf180mcu_as_sc_mcu7t3v3__fill_1
XFILLER_25_174 VDD VDD VSS VSS gf180mcu_as_sc_mcu7t3v3__fillcap_16
XFILLER_96_1486 VDD VDD VSS VSS gf180mcu_as_sc_mcu7t3v3__fillcap_16
XFILLER_158_308 VDD VDD VSS VSS gf180mcu_as_sc_mcu7t3v3__fill_1
XFILLER_167_842 VDD VDD VSS VSS gf180mcu_as_sc_mcu7t3v3__fillcap_4
XFILLER_40_155 VDD VDD VSS VSS gf180mcu_as_sc_mcu7t3v3__fillcap_8
XFILLER_40_177 VDD VDD VSS VSS gf180mcu_as_sc_mcu7t3v3__fillcap_16
XFILLER_126_216 VDD VDD VSS VSS gf180mcu_as_sc_mcu7t3v3__fillcap_8
XFILLER_177_1216 VDD VDD VSS VSS gf180mcu_as_sc_mcu7t3v3__fill_1
XTAP_TAPCELL_ROW_28_1_747 VDD VSS gf180mcu_as_sc_mcu7t3v3__tap_2
XFILLER_120_1451 VDD VDD VSS VSS gf180mcu_as_sc_mcu7t3v3__fillcap_16
XFILLER_135_772 VDD VDD VSS VSS gf180mcu_as_sc_mcu7t3v3__fillcap_16
XFILLER_150_731 VDD VDD VSS VSS gf180mcu_as_sc_mcu7t3v3__fillcap_4
XFILLER_150_753 VDD VDD VSS VSS gf180mcu_as_sc_mcu7t3v3__fill_2
XFILLER_0_240 VDD VDD VSS VSS gf180mcu_as_sc_mcu7t3v3__fillcap_8
XFILLER_0_295 VDD VDD VSS VSS gf180mcu_as_sc_mcu7t3v3__fillcap_4
Xinput130 VDD VDD VSS VSS north_in[26] _4144_/A gf180mcu_as_sc_mcu7t3v3__buff_2
Xinput141 VDD VDD VSS VSS north_in[5] _3974_/A gf180mcu_as_sc_mcu7t3v3__buff_2
Xinput152 VDD VDD VSS VSS nw_in[15] _4056_/A gf180mcu_as_sc_mcu7t3v3__buff_2
Xinput163 VDD VDD VSS VSS nw_in[25] _4136_/A gf180mcu_as_sc_mcu7t3v3__buff_2
XFILLER_48_255 VDD VDD VSS VSS gf180mcu_as_sc_mcu7t3v3__fill_1
Xinput174 VDD VDD VSS VSS nw_in[4] _3966_/A gf180mcu_as_sc_mcu7t3v3__buff_2
Xinput185 VDD VDD VSS VSS se_in[13] _4041_/A gf180mcu_as_sc_mcu7t3v3__buff_2
Xinput196 VDD VDD VSS VSS se_in[23] _4122_/A gf180mcu_as_sc_mcu7t3v3__buff_2
XFILLER_48_299 VDD VDD VSS VSS gf180mcu_as_sc_mcu7t3v3__fill_2
XFILLER_75_1515 VDD VDD VSS VSS gf180mcu_as_sc_mcu7t3v3__fillcap_4
XFILLER_147_1042 VDD VDD VSS VSS gf180mcu_as_sc_mcu7t3v3__fillcap_8
XFILLER_162_1507 VDD VDD VSS VSS gf180mcu_as_sc_mcu7t3v3__fillcap_16
XFILLER_75_1537 VDD VDD VSS VSS gf180mcu_as_sc_mcu7t3v3__fillcap_16
Xclkbuf_leaf_39_clk_regs VDD VDD VSS VSS clkbuf_3_0_0_clk_regs/Y clkload3/A gf180mcu_as_sc_mcu7t3v3__clkbuff_12
X_3790_ VDD VDD VSS VSS _3790_/A _3932_/B _3790_/C _3790_/D _3791_/C gf180mcu_as_sc_mcu7t3v3__ao22_2
X_2810_ VDD VDD VSS VSS _2810_/A _2810_/B _2810_/C _2841_/A _2810_/D gf180mcu_as_sc_mcu7t3v3__aoi31_2
XFILLER_157_352 VDD VDD VSS VSS gf180mcu_as_sc_mcu7t3v3__fillcap_16
XFILLER_169_190 VDD VDD VSS VSS gf180mcu_as_sc_mcu7t3v3__fillcap_16
X_2741_ VDD VDD VSS VSS _4947_/Q _2741_/B _2741_/A _5482_/A gf180mcu_as_sc_mcu7t3v3__mux2_2
XTAP_TAPCELL_ROW_82_1_962 VDD VSS gf180mcu_as_sc_mcu7t3v3__tap_2
XFILLER_157_374 VDD VDD VSS VSS gf180mcu_as_sc_mcu7t3v3__fill_1
XFILLER_160_1297 VDD VDD VSS VSS gf180mcu_as_sc_mcu7t3v3__fillcap_4
XFILLER_172_311 VDD VDD VSS VSS gf180mcu_as_sc_mcu7t3v3__fillcap_4
XTAP_TAPCELL_ROW_135_1216 VDD VSS gf180mcu_as_sc_mcu7t3v3__tap_2
XFILLER_172_333 VDD VDD VSS VSS gf180mcu_as_sc_mcu7t3v3__fillcap_16
XFILLER_173_878 VDD VDD VSS VSS gf180mcu_as_sc_mcu7t3v3__fillcap_16
X_4411_ VDD VDD VSS VSS _4414_/C _4981_/Q _4579_/S gf180mcu_as_sc_mcu7t3v3__nand2b_2
X_2672_ VDD VDD VSS VSS _2709_/A _2672_/B _2672_/C _2672_/D _2672_/Y gf180mcu_as_sc_mcu7t3v3__ao22_2
XTAP_TAPCELL_ROW_135_1227 VDD VSS gf180mcu_as_sc_mcu7t3v3__tap_2
XPHY_EDGE_ROW_83_3_Left_217 VDD VSS gf180mcu_as_sc_mcu7t3v3__tap_2
X_4342_ VDD VDD VSS VSS _4448_/A _4342_/B _4342_/A _4344_/B gf180mcu_as_sc_mcu7t3v3__mux2_2
XTAP_TAPCELL_ROW_152_1596 VDD VSS gf180mcu_as_sc_mcu7t3v3__tap_2
XFILLER_141_742 VDD VDD VSS VSS gf180mcu_as_sc_mcu7t3v3__fill_1
XFILLER_154_1024 VDD VDD VSS VSS gf180mcu_as_sc_mcu7t3v3__fillcap_16
XFILLER_98_133 VDD VDD VSS VSS gf180mcu_as_sc_mcu7t3v3__fillcap_8
X_4273_ VDD VDD VSS VSS _4273_/S _5485_/A _5107_/Q _5107_/D gf180mcu_as_sc_mcu7t3v3__mux2_2
XFILLER_140_263 VDD VDD VSS VSS gf180mcu_as_sc_mcu7t3v3__fillcap_4
XFILLER_98_177 VDD VDD VSS VSS gf180mcu_as_sc_mcu7t3v3__fill_1
XFILLER_98_188 VDD VDD VSS VSS gf180mcu_as_sc_mcu7t3v3__fillcap_16
X_3224_ VDD VDD VSS VSS _3225_/B _3542_/A _3249_/B _3233_/B _3224_/D gf180mcu_as_sc_mcu7t3v3__aoi22_2
.ends
