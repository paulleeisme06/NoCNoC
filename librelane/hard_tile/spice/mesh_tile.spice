* NGSPICE file created from mesh_tile.ext - technology: gf180mcuD

* Black-box entry subcircuit for gf180mcu_as_sc_mcu7t3v3__ao22_2 abstract view
.subckt gf180mcu_as_sc_mcu7t3v3__ao22_2 VDD VNW VPW VSS A B C D Y
.ends

* Black-box entry subcircuit for gf180mcu_as_sc_mcu7t3v3__or2_2 abstract view
.subckt gf180mcu_as_sc_mcu7t3v3__or2_2 VDD VNW VPW VSS B A Y
.ends

* Black-box entry subcircuit for gf180mcu_as_sc_mcu7t3v3__fill_1 abstract view
.subckt gf180mcu_as_sc_mcu7t3v3__fill_1 VDD VNW VPW VSS
.ends

* Black-box entry subcircuit for gf180mcu_as_sc_mcu7t3v3__tap_2 abstract view
.subckt gf180mcu_as_sc_mcu7t3v3__tap_2 VDD VSS
.ends

* Black-box entry subcircuit for gf180mcu_as_sc_mcu7t3v3__fillcap_16 abstract view
.subckt gf180mcu_as_sc_mcu7t3v3__fillcap_16 VDD VNW VPW VSS
.ends

* Black-box entry subcircuit for gf180mcu_as_sc_mcu7t3v3__fillcap_4 abstract view
.subckt gf180mcu_as_sc_mcu7t3v3__fillcap_4 VDD VNW VPW VSS
.ends

* Black-box entry subcircuit for gf180mcu_as_sc_mcu7t3v3__fill_2 abstract view
.subckt gf180mcu_as_sc_mcu7t3v3__fill_2 VDD VNW VPW VSS
.ends

* Black-box entry subcircuit for gf180mcu_as_sc_mcu7t3v3__nor2_2 abstract view
.subckt gf180mcu_as_sc_mcu7t3v3__nor2_2 VDD VNW VPW VSS Y B A
.ends

* Black-box entry subcircuit for gf180mcu_as_sc_mcu7t3v3__buff_12 abstract view
.subckt gf180mcu_as_sc_mcu7t3v3__buff_12 VDD VNW VPW VSS A Y
.ends

* Black-box entry subcircuit for gf180mcu_as_sc_mcu7t3v3__fillcap_8 abstract view
.subckt gf180mcu_as_sc_mcu7t3v3__fillcap_8 VDD VNW VPW VSS
.ends

* Black-box entry subcircuit for gf180mcu_as_sc_mcu7t3v3__clkbuff_12 abstract view
.subckt gf180mcu_as_sc_mcu7t3v3__clkbuff_12 VDD VNW VPW VSS A Y
.ends

* Black-box entry subcircuit for gf180mcu_as_sc_mcu7t3v3__dfxtp_2 abstract view
.subckt gf180mcu_as_sc_mcu7t3v3__dfxtp_2 VDD VNW VPW VSS CLK D Q
.ends

* Black-box entry subcircuit for gf180mcu_as_sc_mcu7t3v3__nand2b_2 abstract view
.subckt gf180mcu_as_sc_mcu7t3v3__nand2b_2 VDD VNW VPW VSS Y B A
.ends

* Black-box entry subcircuit for gf180mcu_as_sc_mcu7t3v3__ao211_2 abstract view
.subckt gf180mcu_as_sc_mcu7t3v3__ao211_2 VDD VNW VPW VSS A B C D Y
.ends

* Black-box entry subcircuit for gf180mcu_as_sc_mcu7t3v3__mux2_2 abstract view
.subckt gf180mcu_as_sc_mcu7t3v3__mux2_2 VDD VNW VPW VSS S B A Y
.ends

* Black-box entry subcircuit for gf180mcu_as_sc_mcu7t3v3__inv_2 abstract view
.subckt gf180mcu_as_sc_mcu7t3v3__inv_2 VDD VNW VPW VSS Y A
.ends

* Black-box entry subcircuit for gf180mcu_as_sc_mcu7t3v3__aoi211_2 abstract view
.subckt gf180mcu_as_sc_mcu7t3v3__aoi211_2 VDD VNW VPW VSS A B C Y D
.ends

* Black-box entry subcircuit for gf180mcu_as_sc_mcu7t3v3__tiel_4 abstract view
.subckt gf180mcu_as_sc_mcu7t3v3__tiel_4 VDD VNW VPW VSS ZERO
.ends

* Black-box entry subcircuit for gf180mcu_as_sc_mcu7t3v3__ao21_2 abstract view
.subckt gf180mcu_as_sc_mcu7t3v3__ao21_2 VDD VNW VPW VSS Y A B C
.ends

* Black-box entry subcircuit for gf180mcu_as_sc_mcu7t3v3__aoi21_2 abstract view
.subckt gf180mcu_as_sc_mcu7t3v3__aoi21_2 VDD VNW VPW VSS Y C B A
.ends

* Black-box entry subcircuit for gf180mcu_as_sc_mcu7t3v3__nand2_2 abstract view
.subckt gf180mcu_as_sc_mcu7t3v3__nand2_2 VDD VNW VPW VSS Y B A
.ends

* Black-box entry subcircuit for gf180mcu_as_sc_mcu7t3v3__nor3_2 abstract view
.subckt gf180mcu_as_sc_mcu7t3v3__nor3_2 VDD VNW VPW VSS A B C Y
.ends

* Black-box entry subcircuit for gf180mcu_as_sc_mcu7t3v3__ao31_2 abstract view
.subckt gf180mcu_as_sc_mcu7t3v3__ao31_2 VDD VNW VPW VSS D A B C Y
.ends

* Black-box entry subcircuit for gf180mcu_as_sc_mcu7t3v3__diode_2 abstract view
.subckt gf180mcu_as_sc_mcu7t3v3__diode_2 VDD VNW VPW VSS DIODE
.ends

* Black-box entry subcircuit for gf180mcu_as_sc_mcu7t3v3__and2_2 abstract view
.subckt gf180mcu_as_sc_mcu7t3v3__and2_2 VDD VNW VPW VSS B A Y
.ends

* Black-box entry subcircuit for gf180mcu_as_sc_mcu7t3v3__aoi21b_2 abstract view
.subckt gf180mcu_as_sc_mcu7t3v3__aoi21b_2 VDD VNW VPW VSS Y C B A
.ends

* Black-box entry subcircuit for gf180mcu_as_sc_mcu7t3v3__nor2b_2 abstract view
.subckt gf180mcu_as_sc_mcu7t3v3__nor2b_2 VDD VNW VPW VSS Y B A
.ends

* Black-box entry subcircuit for gf180mcu_as_sc_mcu7t3v3__xnor2_2 abstract view
.subckt gf180mcu_as_sc_mcu7t3v3__xnor2_2 VDD VNW VPW VSS B A Y
.ends

* Black-box entry subcircuit for gf180mcu_as_sc_mcu7t3v3__nand3_2 abstract view
.subckt gf180mcu_as_sc_mcu7t3v3__nand3_2 VDD VNW VPW VSS A B C Y
.ends

* Black-box entry subcircuit for gf180mcu_as_sc_mcu7t3v3__oai211_2 abstract view
.subckt gf180mcu_as_sc_mcu7t3v3__oai211_2 VDD VNW VPW VSS A B C Y D
.ends

* Black-box entry subcircuit for gf180mcu_as_sc_mcu7t3v3__aoi22_2 abstract view
.subckt gf180mcu_as_sc_mcu7t3v3__aoi22_2 VDD VNW VPW VSS Y A B C D
.ends

* Black-box entry subcircuit for gf180mcu_as_sc_mcu7t3v3__clkbuff_4 abstract view
.subckt gf180mcu_as_sc_mcu7t3v3__clkbuff_4 VDD VNW VPW VSS A Y
.ends

* Black-box entry subcircuit for gf180mcu_as_sc_mcu7t3v3__maj3_2 abstract view
.subckt gf180mcu_as_sc_mcu7t3v3__maj3_2 VDD VNW VPW VSS Y A B C
.ends

* Black-box entry subcircuit for gf180mcu_as_sc_mcu7t3v3__nand4_2 abstract view
.subckt gf180mcu_as_sc_mcu7t3v3__nand4_2 VDD VNW VPW VSS A B C D Y
.ends

* Black-box entry subcircuit for gf180mcu_as_sc_mcu7t3v3__aoi31_2 abstract view
.subckt gf180mcu_as_sc_mcu7t3v3__aoi31_2 VDD VNW VPW VSS A B C Y D
.ends

* Black-box entry subcircuit for gf180mcu_as_sc_mcu7t3v3__buff_2 abstract view
.subckt gf180mcu_as_sc_mcu7t3v3__buff_2 VDD VNW VPW VSS A Y
.ends

* Black-box entry subcircuit for gf180mcu_as_sc_mcu7t3v3__inv_6 abstract view
.subckt gf180mcu_as_sc_mcu7t3v3__inv_6 VDD VNW VPW VSS Y A
.ends

* Black-box entry subcircuit for gf180mcu_as_sc_mcu7t3v3__inv_4 abstract view
.subckt gf180mcu_as_sc_mcu7t3v3__inv_4 VDD VNW VPW VSS Y A
.ends

* Black-box entry subcircuit for gf180mcu_as_sc_mcu7t3v3__dfsrtp_2 abstract view
.subckt gf180mcu_as_sc_mcu7t3v3__dfsrtp_2 VDD VNW VPW VSS CLK Q RN SN D
.ends

* Black-box entry subcircuit for gf180mcu_ocd_ip_sram__sram1024x8m8wm1 abstract view
.subckt gf180mcu_ocd_ip_sram__sram1024x8m8wm1 A[8] A[7] A[6] A[5] A[4] A[3] A[2] A[1]
+ A[0] CEN CLK D[7] D[6] D[5] D[4] D[3] D[2] D[1] D[0] GWEN Q[7] Q[6] Q[5] Q[4] Q[3]
+ Q[2] Q[1] Q[0] VDD VSS WEN[7] WEN[6] WEN[5] WEN[4] WEN[3] WEN[2] WEN[1] WEN[0] A[9]
.ends

* Black-box entry subcircuit for gf180mcu_as_sc_mcu7t3v3__ao21b_2 abstract view
.subckt gf180mcu_as_sc_mcu7t3v3__ao21b_2 VDD VNW VPW VSS Y C B A
.ends

* Black-box entry subcircuit for gf180mcu_as_sc_mcu7t3v3__tieh_4 abstract view
.subckt gf180mcu_as_sc_mcu7t3v3__tieh_4 VDD VNW VPW VSS ONE
.ends

.subckt mesh_tile VDD VSS boot_addr[0] boot_addr[10] boot_addr[1] boot_addr[2] boot_addr[3]
+ boot_addr[4] boot_addr[5] boot_addr[6] boot_addr[7] boot_addr[8] boot_addr[9] boot_data[0]
+ boot_data[1] boot_data[2] boot_data[3] boot_data[4] boot_data[5] boot_data[6] boot_data[7]
+ boot_mode boot_wen clk dft_addr[0] dft_addr[10] dft_addr[1] dft_addr[2] dft_addr[3]
+ dft_addr[4] dft_addr[5] dft_addr[6] dft_addr[7] dft_addr[8] dft_addr[9] dft_ce dft_mode
+ dft_rdata[0] dft_rdata[1] dft_rdata[2] dft_rdata[3] dft_rdata[4] dft_rdata[5] dft_rdata[6]
+ dft_rdata[7] dft_wdata[0] dft_wdata[1] dft_wdata[2] dft_wdata[3] dft_wdata[4] dft_wdata[5]
+ dft_wdata[6] dft_wdata[7] dft_we east_in[0] east_in[10] east_in[11] east_in[12]
+ east_in[13] east_in[14] east_in[15] east_in[16] east_in[17] east_in[18] east_in[19]
+ east_in[1] east_in[20] east_in[21] east_in[22] east_in[23] east_in[24] east_in[25]
+ east_in[26] east_in[27] east_in[28] east_in[29] east_in[2] east_in[30] east_in[31]
+ east_in[32] east_in[33] east_in[3] east_in[4] east_in[5] east_in[6] east_in[7] east_in[8]
+ east_in[9] east_out[0] east_out[10] east_out[11] east_out[12] east_out[13] east_out[14]
+ east_out[15] east_out[16] east_out[17] east_out[18] east_out[19] east_out[1] east_out[20]
+ east_out[21] east_out[22] east_out[23] east_out[24] east_out[25] east_out[26] east_out[27]
+ east_out[28] east_out[29] east_out[2] east_out[30] east_out[31] east_out[32] east_out[33]
+ east_out[3] east_out[4] east_out[5] east_out[6] east_out[7] east_out[8] east_out[9]
+ ne_in[0] ne_in[10] ne_in[11] ne_in[12] ne_in[13] ne_in[14] ne_in[15] ne_in[16] ne_in[17]
+ ne_in[18] ne_in[19] ne_in[1] ne_in[20] ne_in[21] ne_in[22] ne_in[23] ne_in[24] ne_in[25]
+ ne_in[26] ne_in[27] ne_in[28] ne_in[29] ne_in[2] ne_in[30] ne_in[31] ne_in[32] ne_in[33]
+ ne_in[3] ne_in[4] ne_in[5] ne_in[6] ne_in[7] ne_in[8] ne_in[9] ne_out[0] ne_out[10]
+ ne_out[11] ne_out[12] ne_out[13] ne_out[14] ne_out[15] ne_out[16] ne_out[17] ne_out[18]
+ ne_out[19] ne_out[1] ne_out[20] ne_out[21] ne_out[22] ne_out[23] ne_out[24] ne_out[25]
+ ne_out[26] ne_out[27] ne_out[28] ne_out[29] ne_out[2] ne_out[30] ne_out[31] ne_out[32]
+ ne_out[33] ne_out[3] ne_out[4] ne_out[5] ne_out[6] ne_out[7] ne_out[8] ne_out[9]
+ north_in[0] north_in[10] north_in[11] north_in[12] north_in[13] north_in[14] north_in[15]
+ north_in[16] north_in[17] north_in[18] north_in[19] north_in[1] north_in[20] north_in[21]
+ north_in[22] north_in[23] north_in[24] north_in[25] north_in[26] north_in[27] north_in[28]
+ north_in[29] north_in[2] north_in[30] north_in[31] north_in[32] north_in[33] north_in[3]
+ north_in[4] north_in[5] north_in[6] north_in[7] north_in[8] north_in[9] north_out[0]
+ north_out[10] north_out[11] north_out[12] north_out[13] north_out[14] north_out[15]
+ north_out[16] north_out[17] north_out[18] north_out[19] north_out[1] north_out[20]
+ north_out[21] north_out[22] north_out[23] north_out[24] north_out[25] north_out[26]
+ north_out[27] north_out[28] north_out[29] north_out[2] north_out[30] north_out[31]
+ north_out[32] north_out[33] north_out[3] north_out[4] north_out[5] north_out[6]
+ north_out[7] north_out[8] north_out[9] nw_in[0] nw_in[10] nw_in[11] nw_in[12] nw_in[13]
+ nw_in[14] nw_in[15] nw_in[16] nw_in[17] nw_in[18] nw_in[19] nw_in[1] nw_in[20] nw_in[21]
+ nw_in[22] nw_in[23] nw_in[24] nw_in[25] nw_in[26] nw_in[27] nw_in[28] nw_in[29]
+ nw_in[2] nw_in[30] nw_in[31] nw_in[32] nw_in[33] nw_in[3] nw_in[4] nw_in[5] nw_in[6]
+ nw_in[7] nw_in[8] nw_in[9] nw_out[0] nw_out[10] nw_out[11] nw_out[12] nw_out[13]
+ nw_out[14] nw_out[15] nw_out[16] nw_out[17] nw_out[18] nw_out[19] nw_out[1] nw_out[20]
+ nw_out[21] nw_out[22] nw_out[23] nw_out[24] nw_out[25] nw_out[26] nw_out[27] nw_out[28]
+ nw_out[29] nw_out[2] nw_out[30] nw_out[31] nw_out[32] nw_out[33] nw_out[3] nw_out[4]
+ nw_out[5] nw_out[6] nw_out[7] nw_out[8] nw_out[9] rst se_in[0] se_in[10] se_in[11]
+ se_in[12] se_in[13] se_in[14] se_in[15] se_in[16] se_in[17] se_in[18] se_in[19]
+ se_in[1] se_in[20] se_in[21] se_in[22] se_in[23] se_in[24] se_in[25] se_in[26] se_in[27]
+ se_in[28] se_in[29] se_in[2] se_in[30] se_in[31] se_in[32] se_in[33] se_in[3] se_in[4]
+ se_in[5] se_in[6] se_in[7] se_in[8] se_in[9] se_out[0] se_out[10] se_out[11] se_out[12]
+ se_out[13] se_out[14] se_out[15] se_out[16] se_out[17] se_out[18] se_out[19] se_out[1]
+ se_out[20] se_out[21] se_out[22] se_out[23] se_out[24] se_out[25] se_out[26] se_out[27]
+ se_out[28] se_out[29] se_out[2] se_out[30] se_out[31] se_out[32] se_out[33] se_out[3]
+ se_out[4] se_out[5] se_out[6] se_out[7] se_out[8] se_out[9] south_in[0] south_in[10]
+ south_in[11] south_in[12] south_in[13] south_in[14] south_in[15] south_in[16] south_in[17]
+ south_in[18] south_in[19] south_in[1] south_in[20] south_in[21] south_in[22] south_in[23]
+ south_in[24] south_in[25] south_in[26] south_in[27] south_in[28] south_in[29] south_in[2]
+ south_in[30] south_in[31] south_in[32] south_in[33] south_in[3] south_in[4] south_in[5]
+ south_in[6] south_in[7] south_in[8] south_in[9] south_out[0] south_out[10] south_out[11]
+ south_out[12] south_out[13] south_out[14] south_out[15] south_out[16] south_out[17]
+ south_out[18] south_out[19] south_out[1] south_out[20] south_out[21] south_out[22]
+ south_out[23] south_out[24] south_out[25] south_out[26] south_out[27] south_out[28]
+ south_out[29] south_out[2] south_out[30] south_out[31] south_out[32] south_out[33]
+ south_out[3] south_out[4] south_out[5] south_out[6] south_out[7] south_out[8] south_out[9]
+ sw_in[0] sw_in[10] sw_in[11] sw_in[12] sw_in[13] sw_in[14] sw_in[15] sw_in[16] sw_in[17]
+ sw_in[18] sw_in[19] sw_in[1] sw_in[20] sw_in[21] sw_in[22] sw_in[23] sw_in[24] sw_in[25]
+ sw_in[26] sw_in[27] sw_in[28] sw_in[29] sw_in[2] sw_in[30] sw_in[31] sw_in[32] sw_in[33]
+ sw_in[3] sw_in[4] sw_in[5] sw_in[6] sw_in[7] sw_in[8] sw_in[9] sw_out[0] sw_out[10]
+ sw_out[11] sw_out[12] sw_out[13] sw_out[14] sw_out[15] sw_out[16] sw_out[17] sw_out[18]
+ sw_out[19] sw_out[1] sw_out[20] sw_out[21] sw_out[22] sw_out[23] sw_out[24] sw_out[25]
+ sw_out[26] sw_out[27] sw_out[28] sw_out[29] sw_out[2] sw_out[30] sw_out[31] sw_out[32]
+ sw_out[33] sw_out[3] sw_out[4] sw_out[5] sw_out[6] sw_out[7] sw_out[8] sw_out[9]
+ west_in[0] west_in[10] west_in[11] west_in[12] west_in[13] west_in[14] west_in[15]
+ west_in[16] west_in[17] west_in[18] west_in[19] west_in[1] west_in[20] west_in[21]
+ west_in[22] west_in[23] west_in[24] west_in[25] west_in[26] west_in[27] west_in[28]
+ west_in[29] west_in[2] west_in[30] west_in[31] west_in[32] west_in[33] west_in[3]
+ west_in[4] west_in[5] west_in[6] west_in[7] west_in[8] west_in[9] west_out[0] west_out[10]
+ west_out[11] west_out[12] west_out[13] west_out[14] west_out[15] west_out[16] west_out[17]
+ west_out[18] west_out[19] west_out[1] west_out[20] west_out[21] west_out[22] west_out[23]
+ west_out[24] west_out[25] west_out[26] west_out[27] west_out[28] west_out[29] west_out[2]
+ west_out[30] west_out[31] west_out[32] west_out[33] west_out[3] west_out[4] west_out[5]
+ west_out[6] west_out[7] west_out[8] west_out[9]
X_3155_ VDD VDD VSS VSS _4131_/A _3241_/B _3155_/C _3155_/D _3156_/C gf180mcu_as_sc_mcu7t3v3__ao22_2
X_3086_ VDD VDD VSS VSS _3121_/B _4931_/Q _3087_/D gf180mcu_as_sc_mcu7t3v3__or2_2
XFILLER_36_951 VDD VDD VSS VSS gf180mcu_as_sc_mcu7t3v3__fill_1
XTAP_TAPCELL_ROW_206_2699 VDD VSS gf180mcu_as_sc_mcu7t3v3__tap_2
XFILLER_208_1415 VDD VDD VSS VSS gf180mcu_as_sc_mcu7t3v3__fillcap_16
XFILLER_35_483 VDD VDD VSS VSS gf180mcu_as_sc_mcu7t3v3__fillcap_4
XFILLER_17_1410 VDD VDD VSS VSS gf180mcu_as_sc_mcu7t3v3__fill_1
XFILLER_208_1437 VDD VDD VSS VSS gf180mcu_as_sc_mcu7t3v3__fillcap_16
XFILLER_210_212 VDD VDD VSS VSS gf180mcu_as_sc_mcu7t3v3__fill_1
XFILLER_10_317 VDD VDD VSS VSS gf180mcu_as_sc_mcu7t3v3__fillcap_4
XFILLER_167_127 VDD VDD VSS VSS gf180mcu_as_sc_mcu7t3v3__fill_2
XFILLER_168_18 VDD VDD VSS VSS gf180mcu_as_sc_mcu7t3v3__fillcap_16
XPHY_EDGE_ROW_43_3_Left_428 VDD VSS gf180mcu_as_sc_mcu7t3v3__tap_2
X_3988_ VDD VDD VSS VSS _4984_/Q _4166_/B _4235_/B _4166_/D _4984_/D gf180mcu_as_sc_mcu7t3v3__ao22_2
XFILLER_176_650 VDD VDD VSS VSS gf180mcu_as_sc_mcu7t3v3__fill_2
XFILLER_210_278 VDD VDD VSS VSS gf180mcu_as_sc_mcu7t3v3__fill_2
XFILLER_22_177 VDD VDD VSS VSS gf180mcu_as_sc_mcu7t3v3__fill_1
X_2939_ VDD VDD VSS VSS _3817_/B _3794_/A _3803_/A gf180mcu_as_sc_mcu7t3v3__nor2_2
XTAP_TAPCELL_ROW_96_1_1734 VDD VSS gf180mcu_as_sc_mcu7t3v3__tap_2
XPHY_EDGE_ROW_168_3_Left_553 VDD VSS gf180mcu_as_sc_mcu7t3v3__tap_2
XFILLER_11_1064 VDD VDD VSS VSS gf180mcu_as_sc_mcu7t3v3__fill_1
XFILLER_191_664 VDD VDD VSS VSS gf180mcu_as_sc_mcu7t3v3__fillcap_16
X_4609_ VDD VDD VSS VSS _5203_/Q _4622_/B _4622_/C _5204_/Q _5203_/D gf180mcu_as_sc_mcu7t3v3__ao22_2
XFILLER_190_174 VDD VDD VSS VSS gf180mcu_as_sc_mcu7t3v3__fill_1
XFILLER_2_516 VDD VDD VSS VSS gf180mcu_as_sc_mcu7t3v3__fill_1
XFILLER_117_99 VDD VDD VSS VSS gf180mcu_as_sc_mcu7t3v3__fillcap_16
XFILLER_24_1403 VDD VDD VSS VSS gf180mcu_as_sc_mcu7t3v3__fill_1
XFILLER_115_1553 VDD VDD VSS VSS gf180mcu_as_sc_mcu7t3v3__fill_2
XTAP_TAPCELL_ROW_12_1003 VDD VSS gf180mcu_as_sc_mcu7t3v3__tap_2
XTAP_TAPCELL_ROW_6_866 VDD VSS gf180mcu_as_sc_mcu7t3v3__tap_2
XTAP_TAPCELL_ROW_6_855 VDD VSS gf180mcu_as_sc_mcu7t3v3__tap_2
XFILLER_133_43 VDD VDD VSS VSS gf180mcu_as_sc_mcu7t3v3__fillcap_16
XFILLER_63_1496 VDD VDD VSS VSS gf180mcu_as_sc_mcu7t3v3__fill_1
XFILLER_98_1515 VDD VDD VSS VSS gf180mcu_as_sc_mcu7t3v3__fillcap_4
Xfanout886 VDD VDD VSS VSS _3608_/D _3594_/D gf180mcu_as_sc_mcu7t3v3__buff_12
Xfanout897 VDD VDD VSS VSS _3844_/C _3760_/D gf180mcu_as_sc_mcu7t3v3__buff_12
XFILLER_26_74 VDD VDD VSS VSS gf180mcu_as_sc_mcu7t3v3__fillcap_16
XFILLER_148_1373 VDD VDD VSS VSS gf180mcu_as_sc_mcu7t3v3__fill_1
XFILLER_14_645 VDD VDD VSS VSS gf180mcu_as_sc_mcu7t3v3__fillcap_16
XFILLER_18_1218 VDD VDD VSS VSS gf180mcu_as_sc_mcu7t3v3__fillcap_4
XFILLER_198_241 VDD VDD VSS VSS gf180mcu_as_sc_mcu7t3v3__fillcap_4
XFILLER_198_263 VDD VDD VSS VSS gf180mcu_as_sc_mcu7t3v3__fillcap_8
XFILLER_14_667 VDD VDD VSS VSS gf180mcu_as_sc_mcu7t3v3__fillcap_16
XFILLER_201_212 VDD VDD VSS VSS gf180mcu_as_sc_mcu7t3v3__fillcap_16
XFILLER_9_104 VDD VDD VSS VSS gf180mcu_as_sc_mcu7t3v3__fillcap_16
XFILLER_70_1445 VDD VDD VSS VSS gf180mcu_as_sc_mcu7t3v3__fillcap_4
Xclkbuf_3_6__f_clk_regs VDD VDD VSS VSS clkbuf_2_3_0_clk_regs/Y clkbuf_leaf_9_clk_regs/A
+ gf180mcu_as_sc_mcu7t3v3__clkbuff_12
XFILLER_210_790 VDD VDD VSS VSS gf180mcu_as_sc_mcu7t3v3__fill_1
XFILLER_31_1418 VDD VDD VSS VSS gf180mcu_as_sc_mcu7t3v3__fill_2
XTAP_TAPCELL_ROW_143_1_1873 VDD VSS gf180mcu_as_sc_mcu7t3v3__tap_2
XTAP_TAPCELL_ROW_155_3_3185 VDD VSS gf180mcu_as_sc_mcu7t3v3__tap_2
XFILLER_122_1568 VDD VDD VSS VSS gf180mcu_as_sc_mcu7t3v3__fill_1
XFILLER_177_1046 VDD VDD VSS VSS gf180mcu_as_sc_mcu7t3v3__fillcap_4
XFILLER_6_866 VDD VDD VSS VSS gf180mcu_as_sc_mcu7t3v3__fillcap_8
XFILLER_6_877 VDD VDD VSS VSS gf180mcu_as_sc_mcu7t3v3__fillcap_16
XFILLER_177_1068 VDD VDD VSS VSS gf180mcu_as_sc_mcu7t3v3__fillcap_16
XFILLER_181_174 VDD VDD VSS VSS gf180mcu_as_sc_mcu7t3v3__fillcap_16
XFILLER_155_1355 VDD VDD VSS VSS gf180mcu_as_sc_mcu7t3v3__fillcap_16
XFILLER_29_1336 VDD VDD VSS VSS gf180mcu_as_sc_mcu7t3v3__fill_2
XTAP_TAPCELL_ROW_36_1548 VDD VSS gf180mcu_as_sc_mcu7t3v3__tap_2
XTAP_TAPCELL_ROW_36_1537 VDD VSS gf180mcu_as_sc_mcu7t3v3__tap_2
XTAP_TAPCELL_ROW_36_1526 VDD VSS gf180mcu_as_sc_mcu7t3v3__tap_2
XTAP_TAPCELL_ROW_36_1515 VDD VSS gf180mcu_as_sc_mcu7t3v3__tap_2
XFILLER_7_1110 VDD VDD VSS VSS gf180mcu_as_sc_mcu7t3v3__fill_1
XFILLER_95_114 VDD VDD VSS VSS gf180mcu_as_sc_mcu7t3v3__fillcap_16
XFILLER_27_1060 VDD VDD VSS VSS gf180mcu_as_sc_mcu7t3v3__fillcap_4
XFILLER_3_1018 VDD VDD VSS VSS gf180mcu_as_sc_mcu7t3v3__fillcap_16
XFILLER_7_1176 VDD VDD VSS VSS gf180mcu_as_sc_mcu7t3v3__fillcap_8
XFILLER_95_169 VDD VDD VSS VSS gf180mcu_as_sc_mcu7t3v3__fillcap_16
XFILLER_184_1017 VDD VDD VSS VSS gf180mcu_as_sc_mcu7t3v3__fillcap_16
XFILLER_18_962 VDD VDD VSS VSS gf180mcu_as_sc_mcu7t3v3__fill_2
XFILLER_36_236 VDD VDD VSS VSS gf180mcu_as_sc_mcu7t3v3__fill_2
XFILLER_36_269 VDD VDD VSS VSS gf180mcu_as_sc_mcu7t3v3__fill_2
XFILLER_205_540 VDD VDD VSS VSS gf180mcu_as_sc_mcu7t3v3__fillcap_16
XFILLER_79_1470 VDD VDD VSS VSS gf180mcu_as_sc_mcu7t3v3__fillcap_4
X_4960_ VDD VDD VSS VSS _5111_/CLK _4960_/D _4960_/Q gf180mcu_as_sc_mcu7t3v3__dfxtp_2
XFILLER_127_1413 VDD VDD VSS VSS gf180mcu_as_sc_mcu7t3v3__fill_2
XFILLER_189_263 VDD VDD VSS VSS gf180mcu_as_sc_mcu7t3v3__fillcap_16
XFILLER_205_562 VDD VDD VSS VSS gf180mcu_as_sc_mcu7t3v3__fillcap_16
XFILLER_33_965 VDD VDD VSS VSS gf180mcu_as_sc_mcu7t3v3__fill_2
X_4891_ VDD VDD VSS VSS _4904_/CLK _4891_/D _4891_/Q gf180mcu_as_sc_mcu7t3v3__dfxtp_2
X_3911_ VDD VDD VSS VSS _4198_/A _4124_/D _4907_/Q gf180mcu_as_sc_mcu7t3v3__nor2_2
XTAP_TAPCELL_ROW_201_2585 VDD VSS gf180mcu_as_sc_mcu7t3v3__tap_2
XFILLER_127_1457 VDD VDD VSS VSS gf180mcu_as_sc_mcu7t3v3__fillcap_16
XFILLER_162_1348 VDD VDD VSS VSS gf180mcu_as_sc_mcu7t3v3__fillcap_16
X_3842_ VDD VDD VSS VSS _3843_/S _3845_/B _3846_/B gf180mcu_as_sc_mcu7t3v3__nand2b_2
XTAP_TAPCELL_ROW_201_2596 VDD VSS gf180mcu_as_sc_mcu7t3v3__tap_2
XTAP_TAPCELL_ROW_176_2039 VDD VSS gf180mcu_as_sc_mcu7t3v3__tap_2
XFILLER_149_138 VDD VDD VSS VSS gf180mcu_as_sc_mcu7t3v3__fill_2
XFILLER_80_2 VDD VDD VSS VSS gf180mcu_as_sc_mcu7t3v3__fill_2
XPHY_EDGE_ROW_116_3_Right_153 VDD VSS gf180mcu_as_sc_mcu7t3v3__tap_2
X_3773_ VDD VDD VSS VSS _4151_/A _3781_/S _3773_/C _3773_/D _3774_/D gf180mcu_as_sc_mcu7t3v3__ao211_2
X_2724_ VDD VDD VSS VSS _2731_/S _5179_/Q _5171_/Q _2728_/B gf180mcu_as_sc_mcu7t3v3__mux2_2
XFILLER_12_1373 VDD VDD VSS VSS gf180mcu_as_sc_mcu7t3v3__fill_1
Xoutput401 VDD VDD VSS VSS _4822_/Q south_out[17] gf180mcu_as_sc_mcu7t3v3__buff_12
X_2655_ VDD VDD VSS VSS _2656_/C _2655_/B _4262_/B gf180mcu_as_sc_mcu7t3v3__nor2_2
XFILLER_12_1395 VDD VDD VSS VSS gf180mcu_as_sc_mcu7t3v3__fillcap_4
XFILLER_173_1400 VDD VDD VSS VSS gf180mcu_as_sc_mcu7t3v3__fillcap_16
Xoutput434 VDD VDD VSS VSS _4889_/Q west_out[16] gf180mcu_as_sc_mcu7t3v3__buff_12
Xoutput423 VDD VDD VSS VSS _4811_/Q south_out[6] gf180mcu_as_sc_mcu7t3v3__buff_12
Xoutput412 VDD VDD VSS VSS _4832_/Q south_out[27] gf180mcu_as_sc_mcu7t3v3__buff_12
XFILLER_86_1485 VDD VDD VSS VSS gf180mcu_as_sc_mcu7t3v3__fillcap_16
Xoutput456 VDD VDD VSS VSS _4878_/Q west_out[5] gf180mcu_as_sc_mcu7t3v3__buff_12
Xoutput445 VDD VDD VSS VSS _4899_/Q west_out[26] gf180mcu_as_sc_mcu7t3v3__buff_12
X_4325_ VDD VDD VSS VSS _4326_/S _5155_/Q _5154_/Q _5154_/D gf180mcu_as_sc_mcu7t3v3__mux2_2
X_2586_ VDD VDD VSS VSS _2668_/B _2586_/B _2586_/A _3906_/S gf180mcu_as_sc_mcu7t3v3__mux2_2
XFILLER_134_1439 VDD VDD VSS VSS gf180mcu_as_sc_mcu7t3v3__fillcap_4
XFILLER_173_1488 VDD VDD VSS VSS gf180mcu_as_sc_mcu7t3v3__fillcap_16
X_4256_ VDD VDD VSS VSS _4256_/S _4256_/B _5092_/Q _5092_/D gf180mcu_as_sc_mcu7t3v3__mux2_2
XTAP_TAPCELL_ROW_3_803 VDD VSS gf180mcu_as_sc_mcu7t3v3__tap_2
XTAP_TAPCELL_ROW_208_2739 VDD VSS gf180mcu_as_sc_mcu7t3v3__tap_2
XFILLER_210_1305 VDD VDD VSS VSS gf180mcu_as_sc_mcu7t3v3__fillcap_4
XFILLER_28_715 VDD VDD VSS VSS gf180mcu_as_sc_mcu7t3v3__fillcap_16
X_4187_ VDD VDD VSS VSS _4247_/B _4193_/B _4193_/C _5025_/Q _5025_/D gf180mcu_as_sc_mcu7t3v3__ao22_2
X_3207_ VDD VDD VSS VSS _3241_/B _3793_/A _3207_/A _3208_/C gf180mcu_as_sc_mcu7t3v3__mux2_2
XFILLER_210_1349 VDD VDD VSS VSS gf180mcu_as_sc_mcu7t3v3__fill_2
XFILLER_27_203 VDD VDD VSS VSS gf180mcu_as_sc_mcu7t3v3__fillcap_4
XFILLER_28_737 VDD VDD VSS VSS gf180mcu_as_sc_mcu7t3v3__fill_1
X_3138_ VDD VDD VSS VSS _4110_/A _3240_/B _3138_/C _3138_/D _3139_/C gf180mcu_as_sc_mcu7t3v3__ao22_2
XFILLER_103_68 VDD VDD VSS VSS gf180mcu_as_sc_mcu7t3v3__fill_2
XFILLER_24_921 VDD VDD VSS VSS gf180mcu_as_sc_mcu7t3v3__fillcap_4
XFILLER_36_781 VDD VDD VSS VSS gf180mcu_as_sc_mcu7t3v3__fill_1
XFILLER_58_1543 VDD VDD VSS VSS gf180mcu_as_sc_mcu7t3v3__fill_1
XFILLER_93_1401 VDD VDD VSS VSS gf180mcu_as_sc_mcu7t3v3__fillcap_8
XTAP_TAPCELL_ROW_148_1_1888 VDD VSS gf180mcu_as_sc_mcu7t3v3__tap_2
X_3069_ VDD VDD VSS VSS _3128_/A _3069_/B _3069_/C _3128_/D _3071_/C gf180mcu_as_sc_mcu7t3v3__ao211_2
XFILLER_93_1467 VDD VDD VSS VSS gf180mcu_as_sc_mcu7t3v3__fill_1
XFILLER_145_1568 VDD VDD VSS VSS gf180mcu_as_sc_mcu7t3v3__fill_1
XFILLER_180_1437 VDD VDD VSS VSS gf180mcu_as_sc_mcu7t3v3__fillcap_16
XFILLER_23_442 VDD VDD VSS VSS gf180mcu_as_sc_mcu7t3v3__fill_2
XFILLER_23_475 VDD VDD VSS VSS gf180mcu_as_sc_mcu7t3v3__fill_1
Xwire506 VDD VDD VSS VSS wire507/Y _4774_/D gf180mcu_as_sc_mcu7t3v3__clkbuff_12
XFILLER_13_1126 VDD VDD VSS VSS gf180mcu_as_sc_mcu7t3v3__fill_2
XFILLER_17_1262 VDD VDD VSS VSS gf180mcu_as_sc_mcu7t3v3__fillcap_4
XFILLER_6_107 VDD VDD VSS VSS gf180mcu_as_sc_mcu7t3v3__fillcap_16
XFILLER_178_1311 VDD VDD VSS VSS gf180mcu_as_sc_mcu7t3v3__fillcap_16
XFILLER_17_1295 VDD VDD VSS VSS gf180mcu_as_sc_mcu7t3v3__fillcap_8
XFILLER_195_38 VDD VDD VSS VSS gf180mcu_as_sc_mcu7t3v3__fillcap_16
XFILLER_163_174 VDD VDD VSS VSS gf180mcu_as_sc_mcu7t3v3__fillcap_16
XFILLER_174_1208 VDD VDD VSS VSS gf180mcu_as_sc_mcu7t3v3__fillcap_16
XFILLER_192_995 VDD VDD VSS VSS gf180mcu_as_sc_mcu7t3v3__fillcap_16
XFILLER_65_1558 VDD VDD VSS VSS gf180mcu_as_sc_mcu7t3v3__fillcap_8
XTAP_TAPCELL_ROW_119_1_1802 VDD VSS gf180mcu_as_sc_mcu7t3v3__tap_2
XFILLER_144_53 VDD VDD VSS VSS gf180mcu_as_sc_mcu7t3v3__fillcap_16
XFILLER_152_1539 VDD VDD VSS VSS gf180mcu_as_sc_mcu7t3v3__fill_2
Xfanout650 VDD VDD VSS VSS _3262_/Y _3468_/B gf180mcu_as_sc_mcu7t3v3__buff_12
XFILLER_24_1222 VDD VDD VSS VSS gf180mcu_as_sc_mcu7t3v3__fill_2
XFILLER_4_1316 VDD VDD VSS VSS gf180mcu_as_sc_mcu7t3v3__fill_2
XFILLER_77_158 VDD VDD VSS VSS gf180mcu_as_sc_mcu7t3v3__fill_1
Xfanout661 VDD VDD VSS VSS _2930_/Y _3239_/A gf180mcu_as_sc_mcu7t3v3__buff_12
Xfanout672 VDD VDD VSS VSS _4624_/B _4622_/B gf180mcu_as_sc_mcu7t3v3__buff_12
Xfanout683 VDD VDD VSS VSS _3564_/Y _3778_/B gf180mcu_as_sc_mcu7t3v3__buff_12
Xfanout694 VDD VDD VSS VSS _4102_/C _4023_/C gf180mcu_as_sc_mcu7t3v3__buff_12
XTAP_TAPCELL_ROW_31_1423 VDD VSS gf180mcu_as_sc_mcu7t3v3__tap_2
XTAP_TAPCELL_ROW_31_1412 VDD VSS gf180mcu_as_sc_mcu7t3v3__tap_2
XFILLER_18_225 VDD VDD VSS VSS gf180mcu_as_sc_mcu7t3v3__fillcap_16
XFILLER_160_30 VDD VDD VSS VSS gf180mcu_as_sc_mcu7t3v3__fillcap_4
XFILLER_185_1326 VDD VDD VSS VSS gf180mcu_as_sc_mcu7t3v3__fillcap_4
XFILLER_18_247 VDD VDD VSS VSS gf180mcu_as_sc_mcu7t3v3__fillcap_16
XFILLER_185_1348 VDD VDD VSS VSS gf180mcu_as_sc_mcu7t3v3__fillcap_16
XFILLER_33_206 VDD VDD VSS VSS gf180mcu_as_sc_mcu7t3v3__fillcap_4
XFILLER_34_729 VDD VDD VSS VSS gf180mcu_as_sc_mcu7t3v3__fillcap_4
XFILLER_2_1084 VDD VDD VSS VSS gf180mcu_as_sc_mcu7t3v3__fill_1
XFILLER_33_228 VDD VDD VSS VSS gf180mcu_as_sc_mcu7t3v3__fillcap_16
XFILLER_15_976 VDD VDD VSS VSS gf180mcu_as_sc_mcu7t3v3__fillcap_4
XFILLER_15_998 VDD VDD VSS VSS gf180mcu_as_sc_mcu7t3v3__fillcap_16
XFILLER_187_734 VDD VDD VSS VSS gf180mcu_as_sc_mcu7t3v3__fillcap_16
XFILLER_199_594 VDD VDD VSS VSS gf180mcu_as_sc_mcu7t3v3__fillcap_16
XFILLER_202_521 VDD VDD VSS VSS gf180mcu_as_sc_mcu7t3v3__fillcap_4
XFILLER_202_543 VDD VDD VSS VSS gf180mcu_as_sc_mcu7t3v3__fillcap_16
XFILLER_53_72 VDD VDD VSS VSS gf180mcu_as_sc_mcu7t3v3__fillcap_16
XTAP_TAPCELL_ROW_29_1374 VDD VSS gf180mcu_as_sc_mcu7t3v3__tap_2
XTAP_TAPCELL_ROW_29_1363 VDD VSS gf180mcu_as_sc_mcu7t3v3__tap_2
XFILLER_169_72 VDD VDD VSS VSS gf180mcu_as_sc_mcu7t3v3__fillcap_16
XFILLER_30_968 VDD VDD VSS VSS gf180mcu_as_sc_mcu7t3v3__fill_1
XFILLER_200_1507 VDD VDD VSS VSS gf180mcu_as_sc_mcu7t3v3__fillcap_16
XFILLER_31_1248 VDD VDD VSS VSS gf180mcu_as_sc_mcu7t3v3__fill_2
XFILLER_31_1259 VDD VDD VSS VSS gf180mcu_as_sc_mcu7t3v3__fill_1
Xmax_cap817 VDD VDD VSS VSS _3477_/A _4132_/A gf180mcu_as_sc_mcu7t3v3__clkbuff_12
XFILLER_154_163 VDD VDD VSS VSS gf180mcu_as_sc_mcu7t3v3__fill_1
X_2440_ VDD VDD VSS VSS _4083_/A _2440_/A gf180mcu_as_sc_mcu7t3v3__inv_2
XFILLER_29_1122 VDD VDD VSS VSS gf180mcu_as_sc_mcu7t3v3__fill_2
XPHY_EDGE_ROW_109_1_Left_319 VDD VSS gf180mcu_as_sc_mcu7t3v3__tap_2
XFILLER_190_1065 VDD VDD VSS VSS gf180mcu_as_sc_mcu7t3v3__fillcap_16
XFILLER_190_1087 VDD VDD VSS VSS gf180mcu_as_sc_mcu7t3v3__fillcap_16
X_5090_ VDD VDD VSS VSS _5090_/CLK _5090_/D _5090_/Q gf180mcu_as_sc_mcu7t3v3__dfxtp_2
X_4110_ VDD VDD VSS VSS _4110_/A _4119_/B _4115_/B _4115_/C _4110_/D gf180mcu_as_sc_mcu7t3v3__aoi211_2
XFILLER_133_1461 VDD VDD VSS VSS gf180mcu_as_sc_mcu7t3v3__fillcap_16
XFILLER_204_34 VDD VDD VSS VSS gf180mcu_as_sc_mcu7t3v3__fill_1
XPHY_EDGE_ROW_16_Left_227 VDD VSS gf180mcu_as_sc_mcu7t3v3__tap_2
X_4041_ VDD VDD VSS VSS _4041_/A _4122_/B _4041_/C _4041_/D _4042_/B gf180mcu_as_sc_mcu7t3v3__ao211_2
XFILLER_209_142 VDD VDD VSS VSS gf180mcu_as_sc_mcu7t3v3__fillcap_8
XFILLER_83_128 VDD VDD VSS VSS gf180mcu_as_sc_mcu7t3v3__fillcap_4
XFILLER_77_1418 VDD VDD VSS VSS gf180mcu_as_sc_mcu7t3v3__fill_2
Xmesh_tile_1060 VDD VDD VSS VSS sw_out[33] gf180mcu_as_sc_mcu7t3v3__tiel_4
XTAP_TAPCELL_ROW_203_2636 VDD VSS gf180mcu_as_sc_mcu7t3v3__tap_2
XFILLER_168_1568 VDD VDD VSS VSS gf180mcu_as_sc_mcu7t3v3__fill_1
XTAP_TAPCELL_ROW_203_2647 VDD VSS gf180mcu_as_sc_mcu7t3v3__tap_2
XTAP_TAPCELL_ROW_199_2551 VDD VSS gf180mcu_as_sc_mcu7t3v3__tap_2
XTAP_TAPCELL_ROW_199_2540 VDD VSS gf180mcu_as_sc_mcu7t3v3__tap_2
XFILLER_206_871 VDD VDD VSS VSS gf180mcu_as_sc_mcu7t3v3__fillcap_4
XFILLER_206_893 VDD VDD VSS VSS gf180mcu_as_sc_mcu7t3v3__fillcap_16
X_4943_ VDD VDD VSS VSS _4977_/CLK _4943_/D _4943_/Q gf180mcu_as_sc_mcu7t3v3__dfxtp_2
XFILLER_205_1418 VDD VDD VSS VSS gf180mcu_as_sc_mcu7t3v3__fillcap_16
XTAP_TAPCELL_ROW_195_2459 VDD VSS gf180mcu_as_sc_mcu7t3v3__tap_2
XFILLER_177_233 VDD VDD VSS VSS gf180mcu_as_sc_mcu7t3v3__fill_2
XPHY_EDGE_ROW_25_Left_236 VDD VSS gf180mcu_as_sc_mcu7t3v3__tap_2
X_4874_ VDD VDD VSS VSS _4916_/CLK _4874_/D _4874_/Q gf180mcu_as_sc_mcu7t3v3__dfxtp_2
XFILLER_140_1410 VDD VDD VSS VSS gf180mcu_as_sc_mcu7t3v3__fillcap_8
XFILLER_197_1208 VDD VDD VSS VSS gf180mcu_as_sc_mcu7t3v3__fillcap_16
XFILLER_53_1462 VDD VDD VSS VSS gf180mcu_as_sc_mcu7t3v3__fill_2
X_3825_ VDD VDD VSS VSS _3825_/Y _4908_/Q _3826_/B _4199_/A gf180mcu_as_sc_mcu7t3v3__ao21_2
XPHY_EDGE_ROW_117_3_Right_154 VDD VSS gf180mcu_as_sc_mcu7t3v3__tap_2
X_3756_ VDD VDD VSS VSS _4135_/D _3781_/S _3756_/C _3756_/D _3757_/C gf180mcu_as_sc_mcu7t3v3__ao211_2
XFILLER_101_1438 VDD VDD VSS VSS gf180mcu_as_sc_mcu7t3v3__fill_1
XFILLER_14_1468 VDD VDD VSS VSS gf180mcu_as_sc_mcu7t3v3__fill_2
XFILLER_192_258 VDD VDD VSS VSS gf180mcu_as_sc_mcu7t3v3__fillcap_16
XFILLER_203_1186 VDD VDD VSS VSS gf180mcu_as_sc_mcu7t3v3__fillcap_4
X_2707_ VDD VDD VSS VSS _2735_/A _2707_/B _2707_/C _2736_/B _2709_/C gf180mcu_as_sc_mcu7t3v3__ao211_2
XFILLER_12_1170 VDD VDD VSS VSS gf180mcu_as_sc_mcu7t3v3__fill_1
XFILLER_145_174 VDD VDD VSS VSS gf180mcu_as_sc_mcu7t3v3__fillcap_8
XFILLER_160_100 VDD VDD VSS VSS gf180mcu_as_sc_mcu7t3v3__fillcap_4
X_3687_ VDD VDD VSS VSS _3691_/B _3687_/C _3758_/B _4064_/A gf180mcu_as_sc_mcu7t3v3__aoi21_2
X_2638_ VDD VDD VSS VSS _2852_/B _5128_/Q _5192_/Q _2639_/B gf180mcu_as_sc_mcu7t3v3__mux2_2
XTAP_TAPCELL_ROW_8_917 VDD VSS gf180mcu_as_sc_mcu7t3v3__tap_2
XTAP_TAPCELL_ROW_8_906 VDD VSS gf180mcu_as_sc_mcu7t3v3__tap_2
XFILLER_160_166 VDD VDD VSS VSS gf180mcu_as_sc_mcu7t3v3__fillcap_8
XFILLER_160_177 VDD VDD VSS VSS gf180mcu_as_sc_mcu7t3v3__fillcap_8
X_2569_ VDD VDD VSS VSS _2875_/B _4703_/A _4683_/B gf180mcu_as_sc_mcu7t3v3__nor2_2
XFILLER_138_1383 VDD VDD VSS VSS gf180mcu_as_sc_mcu7t3v3__fillcap_4
XFILLER_138_1394 VDD VDD VSS VSS gf180mcu_as_sc_mcu7t3v3__fillcap_16
XFILLER_181_18 VDD VDD VSS VSS gf180mcu_as_sc_mcu7t3v3__fillcap_16
XPHY_EDGE_ROW_34_Left_245 VDD VSS gf180mcu_as_sc_mcu7t3v3__tap_2
X_4308_ VDD VDD VSS VSS _4308_/S _5138_/Q _5137_/Q _5137_/D gf180mcu_as_sc_mcu7t3v3__mux2_2
XFILLER_25_1542 VDD VDD VSS VSS gf180mcu_as_sc_mcu7t3v3__fill_2
X_4239_ VDD VDD VSS VSS _4256_/S _4239_/B _5075_/Q _5075_/D gf180mcu_as_sc_mcu7t3v3__mux2_2
XFILLER_112_1523 VDD VDD VSS VSS gf180mcu_as_sc_mcu7t3v3__fill_1
XFILLER_60_1444 VDD VDD VSS VSS gf180mcu_as_sc_mcu7t3v3__fillcap_4
XFILLER_16_707 VDD VDD VSS VSS gf180mcu_as_sc_mcu7t3v3__fill_2
XFILLER_210_1179 VDD VDD VSS VSS gf180mcu_as_sc_mcu7t3v3__fill_2
XPHY_EDGE_ROW_155_1_Left_365 VDD VSS gf180mcu_as_sc_mcu7t3v3__tap_2
XFILLER_12_924 VDD VDD VSS VSS gf180mcu_as_sc_mcu7t3v3__fillcap_16
XFILLER_184_715 VDD VDD VSS VSS gf180mcu_as_sc_mcu7t3v3__fillcap_16
XFILLER_184_737 VDD VDD VSS VSS gf180mcu_as_sc_mcu7t3v3__fillcap_16
XFILLER_196_575 VDD VDD VSS VSS gf180mcu_as_sc_mcu7t3v3__fillcap_16
XFILLER_32_1513 VDD VDD VSS VSS gf180mcu_as_sc_mcu7t3v3__fill_1
XFILLER_8_917 VDD VDD VSS VSS gf180mcu_as_sc_mcu7t3v3__fillcap_16
XPHY_EDGE_ROW_92_1_Left_302 VDD VSS gf180mcu_as_sc_mcu7t3v3__tap_2
XTAP_TAPCELL_ROW_64_1_1636 VDD VSS gf180mcu_as_sc_mcu7t3v3__tap_2
XFILLER_128_2 VDD VDD VSS VSS gf180mcu_as_sc_mcu7t3v3__fillcap_16
XFILLER_196_597 VDD VDD VSS VSS gf180mcu_as_sc_mcu7t3v3__fillcap_16
XTAP_TAPCELL_ROW_24_1260 VDD VSS gf180mcu_as_sc_mcu7t3v3__tap_2
XPHY_EDGE_ROW_180_Right_43 VDD VSS gf180mcu_as_sc_mcu7t3v3__tap_2
XTAP_TAPCELL_ROW_20_1179 VDD VSS gf180mcu_as_sc_mcu7t3v3__tap_2
XTAP_TAPCELL_ROW_20_1168 VDD VSS gf180mcu_as_sc_mcu7t3v3__tap_2
XFILLER_178_1185 VDD VDD VSS VSS gf180mcu_as_sc_mcu7t3v3__fillcap_16
XTAP_TAPCELL_ROW_44_1_1578 VDD VSS gf180mcu_as_sc_mcu7t3v3__tap_2
XFILLER_117_1434 VDD VDD VSS VSS gf180mcu_as_sc_mcu7t3v3__fillcap_4
XFILLER_117_1456 VDD VDD VSS VSS gf180mcu_as_sc_mcu7t3v3__fillcap_8
XFILLER_3_699 VDD VDD VSS VSS gf180mcu_as_sc_mcu7t3v3__fill_1
XFILLER_19_512 VDD VDD VSS VSS gf180mcu_as_sc_mcu7t3v3__fill_1
XPHY_EDGE_ROW_120_3_Left_505 VDD VSS gf180mcu_as_sc_mcu7t3v3__tap_2
Xfanout480 VDD VDD VSS VSS _4228_/C _4222_/C gf180mcu_as_sc_mcu7t3v3__buff_12
XFILLER_206_101 VDD VDD VSS VSS gf180mcu_as_sc_mcu7t3v3__fillcap_4
XFILLER_4_1157 VDD VDD VSS VSS gf180mcu_as_sc_mcu7t3v3__fillcap_4
XFILLER_206_123 VDD VDD VSS VSS gf180mcu_as_sc_mcu7t3v3__fillcap_16
XPHY_EDGE_ROW_42_3_Right_79 VDD VSS gf180mcu_as_sc_mcu7t3v3__tap_2
XPHY_EDGE_ROW_87_1_Left_297 VDD VSS gf180mcu_as_sc_mcu7t3v3__tap_2
XFILLER_37_1413 VDD VDD VSS VSS gf180mcu_as_sc_mcu7t3v3__fill_2
XFILLER_37_1424 VDD VDD VSS VSS gf180mcu_as_sc_mcu7t3v3__fill_1
XFILLER_187_553 VDD VDD VSS VSS gf180mcu_as_sc_mcu7t3v3__fillcap_4
XFILLER_203_874 VDD VDD VSS VSS gf180mcu_as_sc_mcu7t3v3__fillcap_16
XFILLER_30_732 VDD VDD VSS VSS gf180mcu_as_sc_mcu7t3v3__fill_2
XFILLER_72_1348 VDD VDD VSS VSS gf180mcu_as_sc_mcu7t3v3__fillcap_4
XFILLER_174_203 VDD VDD VSS VSS gf180mcu_as_sc_mcu7t3v3__fill_1
XFILLER_30_765 VDD VDD VSS VSS gf180mcu_as_sc_mcu7t3v3__fillcap_16
XFILLER_9_88 VDD VDD VSS VSS gf180mcu_as_sc_mcu7t3v3__fillcap_16
XFILLER_198_1539 VDD VDD VSS VSS gf180mcu_as_sc_mcu7t3v3__fillcap_4
XFILLER_30_798 VDD VDD VSS VSS gf180mcu_as_sc_mcu7t3v3__fillcap_4
XFILLER_35_1192 VDD VDD VSS VSS gf180mcu_as_sc_mcu7t3v3__fillcap_16
XFILLER_80_81 VDD VDD VSS VSS gf180mcu_as_sc_mcu7t3v3__fill_1
X_4590_ VDD VDD VSS VSS _4590_/A _4590_/B _4590_/C _5107_/Q _4591_/B gf180mcu_as_sc_mcu7t3v3__ao22_2
X_3610_ VDD VDD VSS VSS _3611_/C _3981_/A _3650_/B _3610_/C gf180mcu_as_sc_mcu7t3v3__ao21_2
XTAP_TAPCELL_ROW_190_2356 VDD VSS gf180mcu_as_sc_mcu7t3v3__tap_2
XTAP_TAPCELL_ROW_190_2345 VDD VSS gf180mcu_as_sc_mcu7t3v3__tap_2
XFILLER_31_1034 VDD VDD VSS VSS gf180mcu_as_sc_mcu7t3v3__fill_1
Xwire870 VDD VDD VSS VSS wire870/A _3969_/A gf180mcu_as_sc_mcu7t3v3__clkbuff_12
X_3541_ VDD VDD VSS VSS _3799_/D _3914_/B _4943_/Q gf180mcu_as_sc_mcu7t3v3__nand2_2
XFILLER_7_972 VDD VDD VSS VSS gf180mcu_as_sc_mcu7t3v3__fill_1
Xwire881 VDD VDD VSS VSS wire881/A _4025_/A gf180mcu_as_sc_mcu7t3v3__clkbuff_12
XFILLER_100_1460 VDD VDD VSS VSS gf180mcu_as_sc_mcu7t3v3__fillcap_16
X_3472_ VDD VDD VSS VSS _4939_/Q _3493_/B _3501_/B _4129_/A _3473_/D gf180mcu_as_sc_mcu7t3v3__ao22_2
XFILLER_142_177 VDD VDD VSS VSS gf180mcu_as_sc_mcu7t3v3__fillcap_16
XFILLER_88_209 VDD VDD VSS VSS gf180mcu_as_sc_mcu7t3v3__fillcap_8
X_5211_ VDD VDD VSS VSS _5214_/CLK _5211_/D _5211_/Q gf180mcu_as_sc_mcu7t3v3__dfxtp_2
X_2423_ VDD VDD VSS VSS _3936_/A _2955_/A gf180mcu_as_sc_mcu7t3v3__inv_2
XTAP_TAPCELL_ROW_90_1_1715 VDD VSS gf180mcu_as_sc_mcu7t3v3__tap_2
XFILLER_83_1466 VDD VDD VSS VSS gf180mcu_as_sc_mcu7t3v3__fillcap_16
X_5142_ VDD VDD VSS VSS _5142_/CLK _5142_/D _5142_/Q gf180mcu_as_sc_mcu7t3v3__dfxtp_2
XFILLER_9_1079 VDD VDD VSS VSS gf180mcu_as_sc_mcu7t3v3__fillcap_8
XPHY_EDGE_ROW_52_3_Left_437 VDD VSS gf180mcu_as_sc_mcu7t3v3__tap_2
X_5073_ VDD VDD VSS VSS _5073_/CLK _5073_/D _5073_/Q gf180mcu_as_sc_mcu7t3v3__dfxtp_2
XFILLER_56_139 VDD VDD VSS VSS gf180mcu_as_sc_mcu7t3v3__fillcap_16
X_4024_ VDD VDD VSS VSS _4024_/A _4030_/C _4031_/B _4024_/D _4025_/D gf180mcu_as_sc_mcu7t3v3__ao22_2
XFILLER_198_807 VDD VDD VSS VSS gf180mcu_as_sc_mcu7t3v3__fillcap_16
XFILLER_0_1566 VDD VDD VSS VSS gf180mcu_as_sc_mcu7t3v3__fill_2
Xsram2048.u_bank1_919 VDD VDD VSS VSS sram2048.u_bank1/WEN[1] gf180mcu_as_sc_mcu7t3v3__tiel_4
XFILLER_55_1568 VDD VDD VSS VSS gf180mcu_as_sc_mcu7t3v3__fill_1
X_4926_ VDD VDD VSS VSS _5090_/CLK _4926_/D _4926_/Q gf180mcu_as_sc_mcu7t3v3__dfxtp_2
XFILLER_100_69 VDD VDD VSS VSS gf180mcu_as_sc_mcu7t3v3__fill_2
X_4857_ VDD VDD VSS VSS _5192_/CLK _4857_/D _4857_/Q gf180mcu_as_sc_mcu7t3v3__dfxtp_2
XFILLER_178_597 VDD VDD VSS VSS gf180mcu_as_sc_mcu7t3v3__fillcap_4
XTAP_TAPCELL_ROW_156_3_3190 VDD VSS gf180mcu_as_sc_mcu7t3v3__tap_2
X_3808_ VDD VDD VSS VSS _3923_/A _3918_/A gf180mcu_as_sc_mcu7t3v3__inv_2
XFILLER_105_1360 VDD VDD VSS VSS gf180mcu_as_sc_mcu7t3v3__fillcap_16
XFILLER_14_1276 VDD VDD VSS VSS gf180mcu_as_sc_mcu7t3v3__fillcap_16
XFILLER_193_556 VDD VDD VSS VSS gf180mcu_as_sc_mcu7t3v3__fillcap_4
XFILLER_193_578 VDD VDD VSS VSS gf180mcu_as_sc_mcu7t3v3__fillcap_16
XFILLER_5_909 VDD VDD VSS VSS gf180mcu_as_sc_mcu7t3v3__fill_1
X_4788_ VDD VDD VSS VSS _4869_/CLK _4788_/D _4788_/Q gf180mcu_as_sc_mcu7t3v3__dfxtp_2
XFILLER_118_174 VDD VDD VSS VSS gf180mcu_as_sc_mcu7t3v3__fill_1
XFILLER_179_1472 VDD VDD VSS VSS gf180mcu_as_sc_mcu7t3v3__fillcap_8
XPHY_EDGE_ROW_118_3_Right_155 VDD VSS gf180mcu_as_sc_mcu7t3v3__tap_2
X_3739_ VDD VDD VSS VSS _4861_/D _3739_/C _3758_/D _4115_/A gf180mcu_as_sc_mcu7t3v3__aoi21_2
XFILLER_88_1399 VDD VDD VSS VSS gf180mcu_as_sc_mcu7t3v3__fillcap_16
XFILLER_0_614 VDD VDD VSS VSS gf180mcu_as_sc_mcu7t3v3__fillcap_4
XFILLER_62_1517 VDD VDD VSS VSS gf180mcu_as_sc_mcu7t3v3__fillcap_4
XFILLER_87_220 VDD VDD VSS VSS gf180mcu_as_sc_mcu7t3v3__fill_2
XFILLER_5_1422 VDD VDD VSS VSS gf180mcu_as_sc_mcu7t3v3__fill_1
XFILLER_18_53 VDD VDD VSS VSS gf180mcu_as_sc_mcu7t3v3__fillcap_16
XFILLER_99_1451 VDD VDD VSS VSS gf180mcu_as_sc_mcu7t3v3__fillcap_16
XFILLER_112_1364 VDD VDD VSS VSS gf180mcu_as_sc_mcu7t3v3__fillcap_4
XFILLER_21_1247 VDD VDD VSS VSS gf180mcu_as_sc_mcu7t3v3__fillcap_8
XFILLER_112_1397 VDD VDD VSS VSS gf180mcu_as_sc_mcu7t3v3__fill_2
XFILLER_203_104 VDD VDD VSS VSS gf180mcu_as_sc_mcu7t3v3__fillcap_16
XFILLER_95_1348 VDD VDD VSS VSS gf180mcu_as_sc_mcu7t3v3__fillcap_4
XFILLER_182_1329 VDD VDD VSS VSS gf180mcu_as_sc_mcu7t3v3__fillcap_16
XFILLER_188_317 VDD VDD VSS VSS gf180mcu_as_sc_mcu7t3v3__fillcap_16
XTAP_TAPCELL_ROW_26_1300 VDD VSS gf180mcu_as_sc_mcu7t3v3__tap_2
XTAP_TAPCELL_ROW_26_1311 VDD VSS gf180mcu_as_sc_mcu7t3v3__tap_2
XFILLER_12_732 VDD VDD VSS VSS gf180mcu_as_sc_mcu7t3v3__fill_2
XFILLER_15_1018 VDD VDD VSS VSS gf180mcu_as_sc_mcu7t3v3__fill_1
XTAP_TAPCELL_ROW_22_1208 VDD VSS gf180mcu_as_sc_mcu7t3v3__tap_2
XFILLER_184_545 VDD VDD VSS VSS gf180mcu_as_sc_mcu7t3v3__fill_1
XFILLER_196_383 VDD VDD VSS VSS gf180mcu_as_sc_mcu7t3v3__fill_2
XFILLER_200_844 VDD VDD VSS VSS gf180mcu_as_sc_mcu7t3v3__fillcap_16
XFILLER_8_747 VDD VDD VSS VSS gf180mcu_as_sc_mcu7t3v3__fill_1
XTAP_TAPCELL_ROW_22_1219 VDD VSS gf180mcu_as_sc_mcu7t3v3__tap_2
XFILLER_123_1460 VDD VDD VSS VSS gf180mcu_as_sc_mcu7t3v3__fillcap_16
XFILLER_71_1392 VDD VDD VSS VSS gf180mcu_as_sc_mcu7t3v3__fillcap_16
XTAP_TAPCELL_ROW_10_944 VDD VSS gf180mcu_as_sc_mcu7t3v3__tap_2
XFILLER_4_920 VDD VDD VSS VSS gf180mcu_as_sc_mcu7t3v3__fillcap_16
XFILLER_50_73 VDD VDD VSS VSS gf180mcu_as_sc_mcu7t3v3__fillcap_4
XTAP_TAPCELL_ROW_10_955 VDD VSS gf180mcu_as_sc_mcu7t3v3__tap_2
XFILLER_119_1529 VDD VDD VSS VSS gf180mcu_as_sc_mcu7t3v3__fill_2
XFILLER_124_177 VDD VDD VSS VSS gf180mcu_as_sc_mcu7t3v3__fillcap_16
XFILLER_3_474 VDD VDD VSS VSS gf180mcu_as_sc_mcu7t3v3__fill_2
XTAP_TAPCELL_ROW_100_3_3022 VDD VSS gf180mcu_as_sc_mcu7t3v3__tap_2
XTAP_TAPCELL_ROW_169_1_1951 VDD VSS gf180mcu_as_sc_mcu7t3v3__tap_2
XFILLER_26_1147 VDD VDD VSS VSS gf180mcu_as_sc_mcu7t3v3__fillcap_8
XFILLER_93_201 VDD VDD VSS VSS gf180mcu_as_sc_mcu7t3v3__fillcap_8
XFILLER_93_212 VDD VDD VSS VSS gf180mcu_as_sc_mcu7t3v3__fillcap_8
XTAP_TAPCELL_ROW_183_2193 VDD VSS gf180mcu_as_sc_mcu7t3v3__tap_2
XFILLER_130_1453 VDD VDD VSS VSS gf180mcu_as_sc_mcu7t3v3__fillcap_16
XFILLER_35_813 VDD VDD VSS VSS gf180mcu_as_sc_mcu7t3v3__fillcap_4
XFILLER_207_454 VDD VDD VSS VSS gf180mcu_as_sc_mcu7t3v3__fillcap_16
XFILLER_208_988 VDD VDD VSS VSS gf180mcu_as_sc_mcu7t3v3__fill_2
XFILLER_34_312 VDD VDD VSS VSS gf180mcu_as_sc_mcu7t3v3__fill_2
XFILLER_78_1568 VDD VDD VSS VSS gf180mcu_as_sc_mcu7t3v3__fill_1
XTAP_TAPCELL_ROW_149_1_1893 VDD VSS gf180mcu_as_sc_mcu7t3v3__tap_2
XFILLER_61_142 VDD VDD VSS VSS gf180mcu_as_sc_mcu7t3v3__fillcap_16
X_2972_ VDD VDD VSS VSS _3005_/A _2972_/B _2972_/C _2973_/C gf180mcu_as_sc_mcu7t3v3__nor3_2
XTAP_TAPCELL_ROW_192_2407 VDD VSS gf180mcu_as_sc_mcu7t3v3__tap_2
X_4711_ VDD VDD VSS VSS _4717_/S _5258_/Q _5259_/Q _4712_/B gf180mcu_as_sc_mcu7t3v3__mux2_2
XFILLER_187_383 VDD VDD VSS VSS gf180mcu_as_sc_mcu7t3v3__fillcap_4
XFILLER_30_562 VDD VDD VSS VSS gf180mcu_as_sc_mcu7t3v3__fillcap_16
X_4642_ VDD VDD VSS VSS _4642_/S _5484_/A _5233_/Q _5233_/D gf180mcu_as_sc_mcu7t3v3__mux2_2
XFILLER_162_217 VDD VDD VSS VSS gf180mcu_as_sc_mcu7t3v3__fillcap_4
X_4573_ VDD VDD VSS VSS _4574_/D _4573_/B _4582_/A gf180mcu_as_sc_mcu7t3v3__nor2_2
XTAP_TAPCELL_ROW_44_3_2853 VDD VSS gf180mcu_as_sc_mcu7t3v3__tap_2
XFILLER_190_559 VDD VDD VSS VSS gf180mcu_as_sc_mcu7t3v3__fillcap_16
XFILLER_200_1189 VDD VDD VSS VSS gf180mcu_as_sc_mcu7t3v3__fillcap_16
XFILLER_85_1528 VDD VDD VSS VSS gf180mcu_as_sc_mcu7t3v3__fill_2
XPHY_EDGE_ROW_203_Left_413 VDD VSS gf180mcu_as_sc_mcu7t3v3__tap_2
X_3524_ VDD VDD VSS VSS _3524_/D _3524_/A _3817_/A _3524_/C _3525_/B gf180mcu_as_sc_mcu7t3v3__ao31_2
XFILLER_115_166 VDD VDD VSS VSS gf180mcu_as_sc_mcu7t3v3__fill_1
X_3455_ VDD VDD VSS VSS _3731_/A _3455_/B _3455_/C _4826_/D _3730_/D gf180mcu_as_sc_mcu7t3v3__aoi211_2
XFILLER_69_220 VDD VDD VSS VSS gf180mcu_as_sc_mcu7t3v3__fill_2
X_2406_ VDD VDD VSS VSS _2546_/A _4955_/Q gf180mcu_as_sc_mcu7t3v3__inv_2
XFILLER_130_169 VDD VDD VSS VSS gf180mcu_as_sc_mcu7t3v3__fillcap_4
XFILLER_48_1383 VDD VDD VSS VSS gf180mcu_as_sc_mcu7t3v3__fillcap_16
X_3386_ VDD VDD VSS VSS _4040_/D _3466_/B _3386_/C _3450_/B _3388_/C gf180mcu_as_sc_mcu7t3v3__ao211_2
XFILLER_135_1397 VDD VDD VSS VSS gf180mcu_as_sc_mcu7t3v3__fillcap_16
XFILLER_29_117 VDD VDD VSS VSS gf180mcu_as_sc_mcu7t3v3__fillcap_16
X_5125_ VDD VDD VSS VSS _5278_/CLK _5125_/D _5125_/Q gf180mcu_as_sc_mcu7t3v3__dfxtp_2
XFILLER_29_139 VDD VDD VSS VSS gf180mcu_as_sc_mcu7t3v3__fill_1
X_5056_ VDD VDD VSS VSS clkload3/A _5056_/D _5056_/Q gf180mcu_as_sc_mcu7t3v3__dfxtp_2
X_4007_ VDD VDD VSS VSS _4007_/A _4101_/C _4007_/C _4007_/D _4009_/C gf180mcu_as_sc_mcu7t3v3__ao211_2
XFILLER_197_136 VDD VDD VSS VSS gf180mcu_as_sc_mcu7t3v3__fillcap_4
XFILLER_107_1411 VDD VDD VSS VSS gf180mcu_as_sc_mcu7t3v3__fillcap_4
XFILLER_107_1422 VDD VDD VSS VSS gf180mcu_as_sc_mcu7t3v3__fill_2
XFILLER_16_1305 VDD VDD VSS VSS gf180mcu_as_sc_mcu7t3v3__fillcap_4
XFILLER_197_158 VDD VDD VSS VSS gf180mcu_as_sc_mcu7t3v3__fillcap_16
XFILLER_200_107 VDD VDD VSS VSS gf180mcu_as_sc_mcu7t3v3__fillcap_16
XFILLER_209_1192 VDD VDD VSS VSS gf180mcu_as_sc_mcu7t3v3__fillcap_16
X_4909_ VDD VDD VSS VSS _4946_/CLK _4909_/D _4909_/Q gf180mcu_as_sc_mcu7t3v3__dfxtp_2
XFILLER_181_1384 VDD VDD VSS VSS gf180mcu_as_sc_mcu7t3v3__fill_2
XFILLER_21_562 VDD VDD VSS VSS gf180mcu_as_sc_mcu7t3v3__fillcap_16
XFILLER_107_1488 VDD VDD VSS VSS gf180mcu_as_sc_mcu7t3v3__fillcap_8
XFILLER_194_887 VDD VDD VSS VSS gf180mcu_as_sc_mcu7t3v3__fill_1
XTAP_TAPCELL_ROW_105_3_3037 VDD VSS gf180mcu_as_sc_mcu7t3v3__tap_2
XFILLER_14_1073 VDD VDD VSS VSS gf180mcu_as_sc_mcu7t3v3__fill_1
XFILLER_153_206 VDD VDD VSS VSS gf180mcu_as_sc_mcu7t3v3__fillcap_4
XFILLER_5_706 VDD VDD VSS VSS gf180mcu_as_sc_mcu7t3v3__fill_1
XFILLER_175_1100 VDD VDD VSS VSS gf180mcu_as_sc_mcu7t3v3__fillcap_16
XFILLER_175_1122 VDD VDD VSS VSS gf180mcu_as_sc_mcu7t3v3__fillcap_16
XFILLER_181_559 VDD VDD VSS VSS gf180mcu_as_sc_mcu7t3v3__fill_1
XPHY_EDGE_ROW_119_3_Right_156 VDD VSS gf180mcu_as_sc_mcu7t3v3__tap_2
XFILLER_175_1144 VDD VDD VSS VSS gf180mcu_as_sc_mcu7t3v3__fill_1
XFILLER_1_912 VDD VDD VSS VSS gf180mcu_as_sc_mcu7t3v3__fillcap_16
XFILLER_106_177 VDD VDD VSS VSS gf180mcu_as_sc_mcu7t3v3__fillcap_8
XFILLER_175_1188 VDD VDD VSS VSS gf180mcu_as_sc_mcu7t3v3__fill_2
XFILLER_0_444 VDD VDD VSS VSS gf180mcu_as_sc_mcu7t3v3__fillcap_4
XFILLER_121_136 VDD VDD VSS VSS gf180mcu_as_sc_mcu7t3v3__fillcap_4
XFILLER_1_956 VDD VDD VSS VSS gf180mcu_as_sc_mcu7t3v3__fillcap_16
Xinput301 VDD VDD VSS VSS west_in[26] _4143_/A gf180mcu_as_sc_mcu7t3v3__buff_12
Xinput312 VDD VDD VSS VSS west_in[5] _3973_/A gf180mcu_as_sc_mcu7t3v3__buff_12
XFILLER_114_1437 VDD VDD VSS VSS gf180mcu_as_sc_mcu7t3v3__fillcap_8
XFILLER_75_212 VDD VDD VSS VSS gf180mcu_as_sc_mcu7t3v3__fillcap_8
XTAP_TAPCELL_ROW_15_1056 VDD VSS gf180mcu_as_sc_mcu7t3v3__tap_2
XTAP_TAPCELL_ROW_70_3_2932 VDD VSS gf180mcu_as_sc_mcu7t3v3__tap_2
XFILLER_29_640 VDD VDD VSS VSS gf180mcu_as_sc_mcu7t3v3__fill_2
XFILLER_29_85 VDD VDD VSS VSS gf180mcu_as_sc_mcu7t3v3__fillcap_16
XTAP_TAPCELL_ROW_15_1067 VDD VSS gf180mcu_as_sc_mcu7t3v3__tap_2
XFILLER_152_75 VDD VDD VSS VSS gf180mcu_as_sc_mcu7t3v3__fillcap_16
XFILLER_1_1116 VDD VDD VSS VSS gf180mcu_as_sc_mcu7t3v3__fillcap_4
XFILLER_5_1285 VDD VDD VSS VSS gf180mcu_as_sc_mcu7t3v3__fillcap_4
XTAP_TAPCELL_ROW_39_1_1562 VDD VSS gf180mcu_as_sc_mcu7t3v3__tap_2
XFILLER_16_301 VDD VDD VSS VSS gf180mcu_as_sc_mcu7t3v3__fill_2
XFILLER_28_161 VDD VDD VSS VSS gf180mcu_as_sc_mcu7t3v3__fill_2
XFILLER_189_626 VDD VDD VSS VSS gf180mcu_as_sc_mcu7t3v3__fillcap_4
XFILLER_204_435 VDD VDD VSS VSS gf180mcu_as_sc_mcu7t3v3__fillcap_16
XFILLER_43_142 VDD VDD VSS VSS gf180mcu_as_sc_mcu7t3v3__fill_2
XFILLER_189_648 VDD VDD VSS VSS gf180mcu_as_sc_mcu7t3v3__fillcap_16
XFILLER_204_457 VDD VDD VSS VSS gf180mcu_as_sc_mcu7t3v3__fillcap_16
XTAP_TAPCELL_ROW_49_3_2868 VDD VSS gf180mcu_as_sc_mcu7t3v3__tap_2
XFILLER_160_1402 VDD VDD VSS VSS gf180mcu_as_sc_mcu7t3v3__fill_2
XFILLER_176_309 VDD VDD VSS VSS gf180mcu_as_sc_mcu7t3v3__fillcap_4
XFILLER_125_1566 VDD VDD VSS VSS gf180mcu_as_sc_mcu7t3v3__fill_2
XFILLER_129_203 VDD VDD VSS VSS gf180mcu_as_sc_mcu7t3v3__fillcap_4
XFILLER_12_551 VDD VDD VSS VSS gf180mcu_as_sc_mcu7t3v3__fillcap_16
XFILLER_8_522 VDD VDD VSS VSS gf180mcu_as_sc_mcu7t3v3__fill_2
XPHY_EDGE_ROW_118_1_Left_328 VDD VSS gf180mcu_as_sc_mcu7t3v3__tap_2
XFILLER_160_1457 VDD VDD VSS VSS gf180mcu_as_sc_mcu7t3v3__fill_2
XFILLER_61_72 VDD VDD VSS VSS gf180mcu_as_sc_mcu7t3v3__fillcap_16
XFILLER_144_217 VDD VDD VSS VSS gf180mcu_as_sc_mcu7t3v3__fillcap_4
XFILLER_177_72 VDD VDD VSS VSS gf180mcu_as_sc_mcu7t3v3__fillcap_16
XFILLER_32_1173 VDD VDD VSS VSS gf180mcu_as_sc_mcu7t3v3__fillcap_16
XFILLER_6_34 VDD VDD VSS VSS gf180mcu_as_sc_mcu7t3v3__fill_1
XFILLER_8_577 VDD VDD VSS VSS gf180mcu_as_sc_mcu7t3v3__fill_2
XANTENNA_5 VDD VDD VSS VSS _4852_/D gf180mcu_as_sc_mcu7t3v3__diode_2
XFILLER_184_397 VDD VDD VSS VSS gf180mcu_as_sc_mcu7t3v3__fill_1
XFILLER_197_1380 VDD VDD VSS VSS gf180mcu_as_sc_mcu7t3v3__fillcap_16
XFILLER_8_599 VDD VDD VSS VSS gf180mcu_as_sc_mcu7t3v3__fill_1
XFILLER_158_1364 VDD VDD VSS VSS gf180mcu_as_sc_mcu7t3v3__fillcap_16
XFILLER_112_125 VDD VDD VSS VSS gf180mcu_as_sc_mcu7t3v3__fill_2
XFILLER_180_581 VDD VDD VSS VSS gf180mcu_as_sc_mcu7t3v3__fillcap_8
XFILLER_3_282 VDD VDD VSS VSS gf180mcu_as_sc_mcu7t3v3__fillcap_16
X_3240_ VDD VDD VSS VSS _3240_/A _3240_/B _3240_/C _3240_/D _3242_/A gf180mcu_as_sc_mcu7t3v3__ao211_2
XTAP_TAPCELL_ROW_210_2790 VDD VSS gf180mcu_as_sc_mcu7t3v3__tap_2
XTAP_TAPCELL_ROW_185_2244 VDD VSS gf180mcu_as_sc_mcu7t3v3__tap_2
XTAP_TAPCELL_ROW_185_2233 VDD VSS gf180mcu_as_sc_mcu7t3v3__tap_2
XFILLER_112_169 VDD VDD VSS VSS gf180mcu_as_sc_mcu7t3v3__fillcap_4
XFILLER_171_1553 VDD VDD VSS VSS gf180mcu_as_sc_mcu7t3v3__fill_2
Xmesh_tile_927 VDD VDD VSS VSS ne_out[2] gf180mcu_as_sc_mcu7t3v3__tiel_4
X_3171_ VDD VDD VSS VSS _4146_/A _3240_/B _3171_/C _3171_/D _3172_/D gf180mcu_as_sc_mcu7t3v3__ao22_2
XFILLER_132_1537 VDD VDD VSS VSS gf180mcu_as_sc_mcu7t3v3__fillcap_4
Xmesh_tile_949 VDD VDD VSS VSS ne_out[24] gf180mcu_as_sc_mcu7t3v3__tiel_4
Xmesh_tile_938 VDD VDD VSS VSS ne_out[13] gf180mcu_as_sc_mcu7t3v3__tiel_4
XFILLER_208_785 VDD VDD VSS VSS gf180mcu_as_sc_mcu7t3v3__fillcap_16
XFILLER_35_632 VDD VDD VSS VSS gf180mcu_as_sc_mcu7t3v3__fillcap_8
XTAP_TAPCELL_ROW_97_3_3011 VDD VSS gf180mcu_as_sc_mcu7t3v3__tap_2
XFILLER_34_120 VDD VDD VSS VSS gf180mcu_as_sc_mcu7t3v3__fill_1
XFILLER_34_131 VDD VDD VSS VSS gf180mcu_as_sc_mcu7t3v3__fillcap_16
XFILLER_179_136 VDD VDD VSS VSS gf180mcu_as_sc_mcu7t3v3__fillcap_4
XFILLER_22_304 VDD VDD VSS VSS gf180mcu_as_sc_mcu7t3v3__fillcap_8
X_4885__1082 VDD VDD VSS VSS _4885_/D gf180mcu_as_sc_mcu7t3v3__tiel_4
XFILLER_210_416 VDD VDD VSS VSS gf180mcu_as_sc_mcu7t3v3__fill_1
XFILLER_194_139 VDD VDD VSS VSS gf180mcu_as_sc_mcu7t3v3__fillcap_16
X_2955_ VDD VDD VSS VSS _3115_/A _2955_/B _2955_/A _2955_/Y gf180mcu_as_sc_mcu7t3v3__mux2_2
XTAP_TAPCELL_ROW_65_1_1641 VDD VSS gf180mcu_as_sc_mcu7t3v3__tap_2
X_2886_ VDD VDD VSS VSS _3511_/A _3520_/A _3776_/A gf180mcu_as_sc_mcu7t3v3__or2_2
X_4625_ VDD VDD VSS VSS _5219_/Q _4629_/B _4629_/C _5220_/Q _5219_/D gf180mcu_as_sc_mcu7t3v3__ao22_2
XTAP_TAPCELL_ROW_174_1970 VDD VSS gf180mcu_as_sc_mcu7t3v3__tap_2
XFILLER_11_1224 VDD VDD VSS VSS gf180mcu_as_sc_mcu7t3v3__fillcap_16
XFILLER_89_1450 VDD VDD VSS VSS gf180mcu_as_sc_mcu7t3v3__fillcap_16
X_4556_ VDD VDD VSS VSS _5184_/Q _4574_/B _4556_/C _4556_/D _5184_/D gf180mcu_as_sc_mcu7t3v3__ao211_2
XTAP_TAPCELL_ROW_75_3_2947 VDD VSS gf180mcu_as_sc_mcu7t3v3__tap_2
XTAP_TAPCELL_ROW_174_1992 VDD VSS gf180mcu_as_sc_mcu7t3v3__tap_2
XTAP_TAPCELL_ROW_174_1981 VDD VSS gf180mcu_as_sc_mcu7t3v3__tap_2
XFILLER_176_1453 VDD VDD VSS VSS gf180mcu_as_sc_mcu7t3v3__fillcap_4
X_3507_ VDD VDD VSS VSS _3533_/B _3533_/A _3812_/B gf180mcu_as_sc_mcu7t3v3__and2_2
XPHY_EDGE_ROW_164_1_Left_374 VDD VSS gf180mcu_as_sc_mcu7t3v3__tap_2
XPHY_EDGE_ROW_8_Left_219 VDD VSS gf180mcu_as_sc_mcu7t3v3__tap_2
X_4487_ VDD VDD VSS VSS _4491_/B _5077_/Q _4488_/A gf180mcu_as_sc_mcu7t3v3__nand2_2
XFILLER_103_136 VDD VDD VSS VSS gf180mcu_as_sc_mcu7t3v3__fillcap_4
Xclkbuf_leaf_9_clk_regs VDD VDD VSS VSS clkbuf_leaf_9_clk_regs/A _5142_/CLK gf180mcu_as_sc_mcu7t3v3__clkbuff_12
X_3438_ VDD VDD VSS VSS _4089_/A _3445_/C _3438_/C _3439_/C _3455_/B gf180mcu_as_sc_mcu7t3v3__aoi211_2
X_3369_ VDD VDD VSS VSS _4926_/Q _3448_/B _3448_/C _4023_/A _3370_/C gf180mcu_as_sc_mcu7t3v3__ao22_2
XFILLER_57_212 VDD VDD VSS VSS gf180mcu_as_sc_mcu7t3v3__fillcap_8
X_5108_ VDD VDD VSS VSS _5280_/CLK _5108_/D _5108_/Q gf180mcu_as_sc_mcu7t3v3__dfxtp_2
XFILLER_72_204 VDD VDD VSS VSS gf180mcu_as_sc_mcu7t3v3__fillcap_16
XFILLER_122_45 VDD VDD VSS VSS gf180mcu_as_sc_mcu7t3v3__fill_2
XFILLER_22_1364 VDD VDD VSS VSS gf180mcu_as_sc_mcu7t3v3__fill_1
X_5039_ VDD VDD VSS VSS _5068_/CLK _5039_/D _5039_/Q gf180mcu_as_sc_mcu7t3v3__dfxtp_2
XTAP_TAPCELL_ROW_1_753 VDD VSS gf180mcu_as_sc_mcu7t3v3__tap_2
XTAP_TAPCELL_ROW_1_742 VDD VSS gf180mcu_as_sc_mcu7t3v3__tap_2
XFILLER_167_6 VDD VDD VSS VSS gf180mcu_as_sc_mcu7t3v3__fillcap_16
XFILLER_183_1402 VDD VDD VSS VSS gf180mcu_as_sc_mcu7t3v3__fillcap_16
XFILLER_25_120 VDD VDD VSS VSS gf180mcu_as_sc_mcu7t3v3__fillcap_16
XFILLER_25_142 VDD VDD VSS VSS gf180mcu_as_sc_mcu7t3v3__fillcap_16
XFILLER_26_643 VDD VDD VSS VSS gf180mcu_as_sc_mcu7t3v3__fill_2
XFILLER_207_1118 VDD VDD VSS VSS gf180mcu_as_sc_mcu7t3v3__fill_2
XFILLER_13_348 VDD VDD VSS VSS gf180mcu_as_sc_mcu7t3v3__fill_2
XFILLER_15_43 VDD VDD VSS VSS gf180mcu_as_sc_mcu7t3v3__fillcap_16
XFILLER_186_629 VDD VDD VSS VSS gf180mcu_as_sc_mcu7t3v3__fillcap_4
XFILLER_198_489 VDD VDD VSS VSS gf180mcu_as_sc_mcu7t3v3__fillcap_16
XFILLER_201_405 VDD VDD VSS VSS gf180mcu_as_sc_mcu7t3v3__fill_1
XFILLER_40_123 VDD VDD VSS VSS gf180mcu_as_sc_mcu7t3v3__fillcap_16
XFILLER_16_1135 VDD VDD VSS VSS gf180mcu_as_sc_mcu7t3v3__fillcap_16
XFILLER_181_1170 VDD VDD VSS VSS gf180mcu_as_sc_mcu7t3v3__fillcap_16
XFILLER_185_128 VDD VDD VSS VSS gf180mcu_as_sc_mcu7t3v3__fillcap_4
XFILLER_22_871 VDD VDD VSS VSS gf180mcu_as_sc_mcu7t3v3__fillcap_4
XFILLER_40_145 VDD VDD VSS VSS gf180mcu_as_sc_mcu7t3v3__fill_1
Xclkbuf_3_5__f_clk_regs VDD VDD VSS VSS clkbuf_2_2_0_clk_regs/Y clkbuf_3_5__f_clk_regs/Y
+ gf180mcu_as_sc_mcu7t3v3__clkbuff_12
XFILLER_16_1157 VDD VDD VSS VSS gf180mcu_as_sc_mcu7t3v3__fillcap_16
XFILLER_181_1192 VDD VDD VSS VSS gf180mcu_as_sc_mcu7t3v3__fillcap_16
XFILLER_182_802 VDD VDD VSS VSS gf180mcu_as_sc_mcu7t3v3__fill_2
XFILLER_210_983 VDD VDD VSS VSS gf180mcu_as_sc_mcu7t3v3__fill_2
XTAP_TAPCELL_ROW_112_1_1780 VDD VSS gf180mcu_as_sc_mcu7t3v3__tap_2
XTAP_TAPCELL_ROW_124_3_3092 VDD VSS gf180mcu_as_sc_mcu7t3v3__tap_2
XFILLER_126_206 VDD VDD VSS VSS gf180mcu_as_sc_mcu7t3v3__fillcap_16
XFILLER_177_1206 VDD VDD VSS VSS gf180mcu_as_sc_mcu7t3v3__fill_1
XFILLER_182_813 VDD VDD VSS VSS gf180mcu_as_sc_mcu7t3v3__fill_1
XFILLER_5_514 VDD VDD VSS VSS gf180mcu_as_sc_mcu7t3v3__fill_1
XFILLER_181_323 VDD VDD VSS VSS gf180mcu_as_sc_mcu7t3v3__fillcap_4
XFILLER_182_857 VDD VDD VSS VSS gf180mcu_as_sc_mcu7t3v3__fill_2
XFILLER_120_1485 VDD VDD VSS VSS gf180mcu_as_sc_mcu7t3v3__fillcap_16
XFILLER_155_1504 VDD VDD VSS VSS gf180mcu_as_sc_mcu7t3v3__fill_2
XFILLER_208_2 VDD VDD VSS VSS gf180mcu_as_sc_mcu7t3v3__fillcap_16
XFILLER_5_558 VDD VDD VSS VSS gf180mcu_as_sc_mcu7t3v3__fill_2
XFILLER_68_1556 VDD VDD VSS VSS gf180mcu_as_sc_mcu7t3v3__fillcap_8
XFILLER_64_1409 VDD VDD VSS VSS gf180mcu_as_sc_mcu7t3v3__fillcap_16
XPHY_EDGE_ROW_51_3_Right_88 VDD VSS gf180mcu_as_sc_mcu7t3v3__tap_2
XTAP_TAPCELL_ROW_17_1107 VDD VSS gf180mcu_as_sc_mcu7t3v3__tap_2
XFILLER_7_1314 VDD VDD VSS VSS gf180mcu_as_sc_mcu7t3v3__fillcap_4
Xinput120 VDD VDD VSS VSS north_in[17] _4071_/A gf180mcu_as_sc_mcu7t3v3__buff_12
XFILLER_0_274 VDD VDD VSS VSS gf180mcu_as_sc_mcu7t3v3__fillcap_4
XFILLER_27_1286 VDD VDD VSS VSS gf180mcu_as_sc_mcu7t3v3__fill_2
Xinput131 VDD VDD VSS VSS north_in[27] _4152_/A gf180mcu_as_sc_mcu7t3v3__buff_12
Xinput142 VDD VDD VSS VSS north_in[6] _3982_/A gf180mcu_as_sc_mcu7t3v3__buff_12
Xinput153 VDD VDD VSS VSS nw_in[16] _4064_/A gf180mcu_as_sc_mcu7t3v3__buff_12
XTAP_TAPCELL_ROW_34_1487 VDD VSS gf180mcu_as_sc_mcu7t3v3__tap_2
XTAP_TAPCELL_ROW_34_1476 VDD VSS gf180mcu_as_sc_mcu7t3v3__tap_2
XFILLER_188_1313 VDD VDD VSS VSS gf180mcu_as_sc_mcu7t3v3__fillcap_16
Xinput164 VDD VDD VSS VSS nw_in[26] _4146_/A gf180mcu_as_sc_mcu7t3v3__buff_12
Xinput175 VDD VDD VSS VSS nw_in[5] _3976_/A gf180mcu_as_sc_mcu7t3v3__buff_12
Xinput186 VDD VDD VSS VSS se_in[14] wire879/A gf180mcu_as_sc_mcu7t3v3__buff_12
XTAP_TAPCELL_ROW_180_2141 VDD VSS gf180mcu_as_sc_mcu7t3v3__tap_2
XTAP_TAPCELL_ROW_180_2130 VDD VSS gf180mcu_as_sc_mcu7t3v3__tap_2
XFILLER_29_470 VDD VDD VSS VSS gf180mcu_as_sc_mcu7t3v3__fillcap_8
XFILLER_40_1453 VDD VDD VSS VSS gf180mcu_as_sc_mcu7t3v3__fillcap_16
Xinput197 VDD VDD VSS VSS se_in[24] _4131_/A gf180mcu_as_sc_mcu7t3v3__buff_12
XFILLER_17_698 VDD VDD VSS VSS gf180mcu_as_sc_mcu7t3v3__fill_2
XFILLER_186_1081 VDD VDD VSS VSS gf180mcu_as_sc_mcu7t3v3__fillcap_4
XFILLER_205_766 VDD VDD VSS VSS gf180mcu_as_sc_mcu7t3v3__fillcap_4
XFILLER_32_613 VDD VDD VSS VSS gf180mcu_as_sc_mcu7t3v3__fillcap_16
XFILLER_205_788 VDD VDD VSS VSS gf180mcu_as_sc_mcu7t3v3__fillcap_16
XFILLER_177_629 VDD VDD VSS VSS gf180mcu_as_sc_mcu7t3v3__fill_1
XFILLER_189_489 VDD VDD VSS VSS gf180mcu_as_sc_mcu7t3v3__fill_1
XFILLER_32_679 VDD VDD VSS VSS gf180mcu_as_sc_mcu7t3v3__fillcap_16
XTAP_TAPCELL_ROW_178_2092 VDD VSS gf180mcu_as_sc_mcu7t3v3__tap_2
XTAP_TAPCELL_ROW_178_2081 VDD VSS gf180mcu_as_sc_mcu7t3v3__tap_2
X_2740_ VDD VDD VSS VSS _4947_/Q _2740_/B _2740_/A _5481_/A gf180mcu_as_sc_mcu7t3v3__mux2_2
XFILLER_117_206 VDD VDD VSS VSS gf180mcu_as_sc_mcu7t3v3__fillcap_4
XFILLER_184_161 VDD VDD VSS VSS gf180mcu_as_sc_mcu7t3v3__fill_2
XFILLER_9_875 VDD VDD VSS VSS gf180mcu_as_sc_mcu7t3v3__fillcap_4
XPHY_EDGE_ROW_61_3_Left_446 VDD VSS gf180mcu_as_sc_mcu7t3v3__tap_2
X_2671_ VDD VDD VSS VSS _2672_/D _2729_/C _2722_/B _2671_/A gf180mcu_as_sc_mcu7t3v3__aoi21b_2
XFILLER_201_1240 VDD VDD VSS VSS gf180mcu_as_sc_mcu7t3v3__fillcap_16
XFILLER_201_1262 VDD VDD VSS VSS gf180mcu_as_sc_mcu7t3v3__fillcap_16
X_4410_ VDD VDD VSS VSS _4414_/B _5068_/Q _4456_/S gf180mcu_as_sc_mcu7t3v3__nand2_2
XFILLER_132_209 VDD VDD VSS VSS gf180mcu_as_sc_mcu7t3v3__fillcap_8
XFILLER_193_1030 VDD VDD VSS VSS gf180mcu_as_sc_mcu7t3v3__fillcap_16
XFILLER_193_1052 VDD VDD VSS VSS gf180mcu_as_sc_mcu7t3v3__fillcap_16
XFILLER_207_34 VDD VDD VSS VSS gf180mcu_as_sc_mcu7t3v3__fillcap_16
XFILLER_28_1017 VDD VDD VSS VSS gf180mcu_as_sc_mcu7t3v3__fill_2
XFILLER_98_101 VDD VDD VSS VSS gf180mcu_as_sc_mcu7t3v3__fillcap_4
X_4341_ VDD VDD VSS VSS _4536_/S _5031_/Q _5060_/Q _4342_/A gf180mcu_as_sc_mcu7t3v3__mux2_2
XFILLER_98_123 VDD VDD VSS VSS gf180mcu_as_sc_mcu7t3v3__fillcap_4
XTAP_TAPCELL_ROW_150_3_3171 VDD VSS gf180mcu_as_sc_mcu7t3v3__tap_2
X_4272_ VDD VDD VSS VSS _4272_/S _5484_/A _5106_/Q _5106_/D gf180mcu_as_sc_mcu7t3v3__mux2_2
X_3223_ VDD VDD VSS VSS _3223_/D _3508_/A _3223_/B _3223_/C _3225_/A gf180mcu_as_sc_mcu7t3v3__ao31_2
XFILLER_39_212 VDD VDD VSS VSS gf180mcu_as_sc_mcu7t3v3__fillcap_8
XFILLER_27_407 VDD VDD VSS VSS gf180mcu_as_sc_mcu7t3v3__fillcap_8
X_3154_ VDD VDD VSS VSS _3179_/B _4939_/Q _3155_/D gf180mcu_as_sc_mcu7t3v3__or2_2
XFILLER_36_930 VDD VDD VSS VSS gf180mcu_as_sc_mcu7t3v3__fill_1
X_3085_ VDD VDD VSS VSS _3145_/A _3085_/B _3085_/C _3145_/D _3087_/C gf180mcu_as_sc_mcu7t3v3__ao211_2
XTAP_TAPCELL_ROW_117_1_1795 VDD VSS gf180mcu_as_sc_mcu7t3v3__tap_2
XFILLER_143_1430 VDD VDD VSS VSS gf180mcu_as_sc_mcu7t3v3__fill_2
XFILLER_206_1151 VDD VDD VSS VSS gf180mcu_as_sc_mcu7t3v3__fillcap_4
X_3987_ VDD VDD VSS VSS _3987_/B _4107_/A _4235_/B gf180mcu_as_sc_mcu7t3v3__and2_2
XFILLER_13_1308 VDD VDD VSS VSS gf180mcu_as_sc_mcu7t3v3__fillcap_16
XFILLER_206_1173 VDD VDD VSS VSS gf180mcu_as_sc_mcu7t3v3__fillcap_16
XFILLER_210_246 VDD VDD VSS VSS gf180mcu_as_sc_mcu7t3v3__fill_1
XFILLER_22_189 VDD VDD VSS VSS gf180mcu_as_sc_mcu7t3v3__fillcap_16
XFILLER_56_1493 VDD VDD VSS VSS gf180mcu_as_sc_mcu7t3v3__fillcap_16
X_2938_ VDD VDD VSS VSS _3243_/A _2947_/A _2947_/B gf180mcu_as_sc_mcu7t3v3__nor2b_2
XFILLER_17_1488 VDD VDD VSS VSS gf180mcu_as_sc_mcu7t3v3__fillcap_16
XFILLER_191_610 VDD VDD VSS VSS gf180mcu_as_sc_mcu7t3v3__fillcap_16
XFILLER_184_18 VDD VDD VSS VSS gf180mcu_as_sc_mcu7t3v3__fillcap_16
XFILLER_191_632 VDD VDD VSS VSS gf180mcu_as_sc_mcu7t3v3__fillcap_16
X_2869_ VDD VDD VSS VSS _4742_/A _2871_/B _2869_/C _4765_/D gf180mcu_as_sc_mcu7t3v3__nor3_2
XFILLER_190_131 VDD VDD VSS VSS gf180mcu_as_sc_mcu7t3v3__fillcap_4
X_4608_ VDD VDD VSS VSS _5202_/Q _4622_/B _4622_/C _5203_/Q _5202_/D gf180mcu_as_sc_mcu7t3v3__ao22_2
XFILLER_11_1076 VDD VDD VSS VSS gf180mcu_as_sc_mcu7t3v3__fill_2
X_4539_ VDD VDD VSS VSS _5182_/Q _4539_/B _4539_/C _4539_/D _5182_/D gf180mcu_as_sc_mcu7t3v3__ao211_2
XFILLER_131_220 VDD VDD VSS VSS gf180mcu_as_sc_mcu7t3v3__fill_2
XFILLER_63_1442 VDD VDD VSS VSS gf180mcu_as_sc_mcu7t3v3__fill_1
XFILLER_63_1453 VDD VDD VSS VSS gf180mcu_as_sc_mcu7t3v3__fill_2
Xfanout810 VDD VDD VSS VSS _4975_/Q _2732_/S gf180mcu_as_sc_mcu7t3v3__buff_12
XFILLER_24_1437 VDD VDD VSS VSS gf180mcu_as_sc_mcu7t3v3__fillcap_16
XTAP_TAPCELL_ROW_12_1004 VDD VSS gf180mcu_as_sc_mcu7t3v3__tap_2
XTAP_TAPCELL_ROW_6_867 VDD VSS gf180mcu_as_sc_mcu7t3v3__tap_2
XTAP_TAPCELL_ROW_6_856 VDD VSS gf180mcu_as_sc_mcu7t3v3__tap_2
XFILLER_111_1418 VDD VDD VSS VSS gf180mcu_as_sc_mcu7t3v3__fillcap_4
Xfanout887 VDD VDD VSS VSS _3661_/D _3608_/D gf180mcu_as_sc_mcu7t3v3__buff_12
Xfanout898 VDD VDD VSS VSS wire902/A _2563_/A gf180mcu_as_sc_mcu7t3v3__buff_12
XFILLER_133_88 VDD VDD VSS VSS gf180mcu_as_sc_mcu7t3v3__fillcap_16
XFILLER_2_1222 VDD VDD VSS VSS gf180mcu_as_sc_mcu7t3v3__fill_2
XFILLER_26_440 VDD VDD VSS VSS gf180mcu_as_sc_mcu7t3v3__fillcap_8
XFILLER_14_613 VDD VDD VSS VSS gf180mcu_as_sc_mcu7t3v3__fillcap_16
XFILLER_26_473 VDD VDD VSS VSS gf180mcu_as_sc_mcu7t3v3__fillcap_16
XFILLER_26_53 VDD VDD VSS VSS gf180mcu_as_sc_mcu7t3v3__fillcap_8
XFILLER_158_2 VDD VDD VSS VSS gf180mcu_as_sc_mcu7t3v3__fillcap_16
XFILLER_198_275 VDD VDD VSS VSS gf180mcu_as_sc_mcu7t3v3__fill_1
XFILLER_198_297 VDD VDD VSS VSS gf180mcu_as_sc_mcu7t3v3__fillcap_16
XFILLER_202_769 VDD VDD VSS VSS gf180mcu_as_sc_mcu7t3v3__fillcap_16
XFILLER_35_1511 VDD VDD VSS VSS gf180mcu_as_sc_mcu7t3v3__fillcap_4
XFILLER_158_139 VDD VDD VSS VSS gf180mcu_as_sc_mcu7t3v3__fill_2
XFILLER_195_960 VDD VDD VSS VSS gf180mcu_as_sc_mcu7t3v3__fillcap_16
XFILLER_195_982 VDD VDD VSS VSS gf180mcu_as_sc_mcu7t3v3__fillcap_16
XTAP_TAPCELL_ROW_143_1_1874 VDD VSS gf180mcu_as_sc_mcu7t3v3__tap_2
XFILLER_10_874 VDD VDD VSS VSS gf180mcu_as_sc_mcu7t3v3__fill_1
XFILLER_177_1014 VDD VDD VSS VSS gf180mcu_as_sc_mcu7t3v3__fillcap_16
XFILLER_181_120 VDD VDD VSS VSS gf180mcu_as_sc_mcu7t3v3__fillcap_16
XTAP_TAPCELL_ROW_155_3_3186 VDD VSS gf180mcu_as_sc_mcu7t3v3__tap_2
XFILLER_114_209 VDD VDD VSS VSS gf180mcu_as_sc_mcu7t3v3__fillcap_8
XFILLER_181_142 VDD VDD VSS VSS gf180mcu_as_sc_mcu7t3v3__fillcap_16
XFILLER_194_1361 VDD VDD VSS VSS gf180mcu_as_sc_mcu7t3v3__fillcap_4
XFILLER_68_1364 VDD VDD VSS VSS gf180mcu_as_sc_mcu7t3v3__fillcap_16
XFILLER_194_1383 VDD VDD VSS VSS gf180mcu_as_sc_mcu7t3v3__fillcap_16
XFILLER_68_1397 VDD VDD VSS VSS gf180mcu_as_sc_mcu7t3v3__fill_2
XTAP_TAPCELL_ROW_36_1538 VDD VSS gf180mcu_as_sc_mcu7t3v3__tap_2
XTAP_TAPCELL_ROW_36_1527 VDD VSS gf180mcu_as_sc_mcu7t3v3__tap_2
XTAP_TAPCELL_ROW_36_1516 VDD VSS gf180mcu_as_sc_mcu7t3v3__tap_2
XTAP_TAPCELL_ROW_36_1549 VDD VSS gf180mcu_as_sc_mcu7t3v3__tap_2
XFILLER_7_1122 VDD VDD VSS VSS gf180mcu_as_sc_mcu7t3v3__fillcap_16
XPHY_EDGE_ROW_181_Left_391 VDD VSS gf180mcu_as_sc_mcu7t3v3__tap_2
XFILLER_209_368 VDD VDD VSS VSS gf180mcu_as_sc_mcu7t3v3__fill_2
XFILLER_7_1188 VDD VDD VSS VSS gf180mcu_as_sc_mcu7t3v3__fill_2
XFILLER_17_462 VDD VDD VSS VSS gf180mcu_as_sc_mcu7t3v3__fill_2
XTAP_TAPCELL_ROW_126_3_3100 VDD VSS gf180mcu_as_sc_mcu7t3v3__tap_2
XFILLER_127_1425 VDD VDD VSS VSS gf180mcu_as_sc_mcu7t3v3__fillcap_16
X_4890_ VDD VDD VSS VSS _4924_/CLK _4890_/D _4890_/Q gf180mcu_as_sc_mcu7t3v3__dfxtp_2
X_3910_ VDD VDD VSS VSS _4165_/A _4124_/D gf180mcu_as_sc_mcu7t3v3__inv_2
XFILLER_20_605 VDD VDD VSS VSS gf180mcu_as_sc_mcu7t3v3__fill_1
XFILLER_32_443 VDD VDD VSS VSS gf180mcu_as_sc_mcu7t3v3__fill_1
X_3841_ VDD VDD VSS VSS _3845_/B _4911_/Q _4912_/Q gf180mcu_as_sc_mcu7t3v3__nand2_2
XTAP_TAPCELL_ROW_201_2597 VDD VSS gf180mcu_as_sc_mcu7t3v3__tap_2
XTAP_TAPCELL_ROW_201_2586 VDD VSS gf180mcu_as_sc_mcu7t3v3__tap_2
XFILLER_34_1010 VDD VDD VSS VSS gf180mcu_as_sc_mcu7t3v3__fillcap_4
X_3772_ VDD VDD VSS VSS _4154_/A _3792_/B _3772_/C _4154_/D _3773_/D gf180mcu_as_sc_mcu7t3v3__ao22_2
XFILLER_34_1076 VDD VDD VSS VSS gf180mcu_as_sc_mcu7t3v3__fillcap_8
XFILLER_73_2 VDD VDD VSS VSS gf180mcu_as_sc_mcu7t3v3__fill_2
X_2723_ VDD VDD VSS VSS _2737_/A _2723_/B _2723_/C _2723_/D _2723_/Y gf180mcu_as_sc_mcu7t3v3__ao22_2
XFILLER_185_481 VDD VDD VSS VSS gf180mcu_as_sc_mcu7t3v3__fill_2
XFILLER_185_492 VDD VDD VSS VSS gf180mcu_as_sc_mcu7t3v3__fill_2
XFILLER_34_1098 VDD VDD VSS VSS gf180mcu_as_sc_mcu7t3v3__fillcap_8
XFILLER_12_1363 VDD VDD VSS VSS gf180mcu_as_sc_mcu7t3v3__fill_2
XFILLER_199_1294 VDD VDD VSS VSS gf180mcu_as_sc_mcu7t3v3__fillcap_16
Xoutput402 VDD VDD VSS VSS _4823_/Q south_out[18] gf180mcu_as_sc_mcu7t3v3__buff_12
X_2654_ VDD VDD VSS VSS _2852_/B _5130_/Q _5194_/Q _2655_/B gf180mcu_as_sc_mcu7t3v3__mux2_2
XFILLER_47_1415 VDD VDD VSS VSS gf180mcu_as_sc_mcu7t3v3__fill_1
XFILLER_86_1431 VDD VDD VSS VSS gf180mcu_as_sc_mcu7t3v3__fill_2
XFILLER_86_1453 VDD VDD VSS VSS gf180mcu_as_sc_mcu7t3v3__fillcap_16
Xoutput435 VDD VDD VSS VSS _4890_/Q west_out[17] gf180mcu_as_sc_mcu7t3v3__buff_12
Xoutput424 VDD VDD VSS VSS _4812_/Q south_out[7] gf180mcu_as_sc_mcu7t3v3__buff_12
Xoutput413 VDD VDD VSS VSS _4833_/Q south_out[28] gf180mcu_as_sc_mcu7t3v3__buff_12
X_2585_ VDD VDD VSS VSS _2585_/Y _2585_/B _2701_/A gf180mcu_as_sc_mcu7t3v3__nand2_2
XFILLER_113_220 VDD VDD VSS VSS gf180mcu_as_sc_mcu7t3v3__fill_2
XFILLER_173_1434 VDD VDD VSS VSS gf180mcu_as_sc_mcu7t3v3__fillcap_16
Xoutput457 VDD VDD VSS VSS _4879_/Q west_out[6] gf180mcu_as_sc_mcu7t3v3__buff_12
Xoutput446 VDD VDD VSS VSS _4900_/Q west_out[27] gf180mcu_as_sc_mcu7t3v3__buff_12
X_4324_ VDD VDD VSS VSS _4324_/S _5154_/Q _5153_/Q _5153_/D gf180mcu_as_sc_mcu7t3v3__mux2_2
X_4255_ VDD VDD VSS VSS _4255_/S _4255_/B _5091_/Q _5091_/D gf180mcu_as_sc_mcu7t3v3__mux2_2
XTAP_TAPCELL_ROW_3_804 VDD VSS gf180mcu_as_sc_mcu7t3v3__tap_2
X_4186_ VDD VDD VSS VSS _4246_/B _4193_/B _4193_/C _5024_/Q _5024_/D gf180mcu_as_sc_mcu7t3v3__ao22_2
X_3206_ VDD VDD VSS VSS _3792_/A _3240_/B _3206_/C _3206_/D _3207_/A gf180mcu_as_sc_mcu7t3v3__ao22_2
XFILLER_210_1328 VDD VDD VSS VSS gf180mcu_as_sc_mcu7t3v3__fill_2
XFILLER_210_1339 VDD VDD VSS VSS gf180mcu_as_sc_mcu7t3v3__fill_2
X_3137_ VDD VDD VSS VSS _3179_/B _4937_/Q _3138_/D gf180mcu_as_sc_mcu7t3v3__or2_2
XFILLER_103_47 VDD VDD VSS VSS gf180mcu_as_sc_mcu7t3v3__fillcap_4
XFILLER_94_181 VDD VDD VSS VSS gf180mcu_as_sc_mcu7t3v3__fill_1
XFILLER_42_218 VDD VDD VSS VSS gf180mcu_as_sc_mcu7t3v3__fillcap_4
XFILLER_93_1413 VDD VDD VSS VSS gf180mcu_as_sc_mcu7t3v3__fill_2
XTAP_TAPCELL_ROW_148_1_1889 VDD VSS gf180mcu_as_sc_mcu7t3v3__tap_2
X_3068_ VDD VDD VSS VSS _4045_/A _3127_/B _3127_/C _4047_/A _3069_/C gf180mcu_as_sc_mcu7t3v3__ao22_2
XFILLER_35_270 VDD VDD VSS VSS gf180mcu_as_sc_mcu7t3v3__fillcap_8
XFILLER_54_1408 VDD VDD VSS VSS gf180mcu_as_sc_mcu7t3v3__fillcap_4
XFILLER_145_1558 VDD VDD VSS VSS gf180mcu_as_sc_mcu7t3v3__fillcap_8
XFILLER_195_212 VDD VDD VSS VSS gf180mcu_as_sc_mcu7t3v3__fillcap_16
XFILLER_19_1539 VDD VDD VSS VSS gf180mcu_as_sc_mcu7t3v3__fill_1
XFILLER_24_977 VDD VDD VSS VSS gf180mcu_as_sc_mcu7t3v3__fill_1
XFILLER_93_1479 VDD VDD VSS VSS gf180mcu_as_sc_mcu7t3v3__fillcap_4
XFILLER_11_649 VDD VDD VSS VSS gf180mcu_as_sc_mcu7t3v3__fillcap_4
XFILLER_23_487 VDD VDD VSS VSS gf180mcu_as_sc_mcu7t3v3__fill_2
XFILLER_108_1380 VDD VDD VSS VSS gf180mcu_as_sc_mcu7t3v3__fill_1
XFILLER_13_1116 VDD VDD VSS VSS gf180mcu_as_sc_mcu7t3v3__fillcap_4
XFILLER_177_960 VDD VDD VSS VSS gf180mcu_as_sc_mcu7t3v3__fillcap_16
XFILLER_177_982 VDD VDD VSS VSS gf180mcu_as_sc_mcu7t3v3__fillcap_16
XFILLER_183_418 VDD VDD VSS VSS gf180mcu_as_sc_mcu7t3v3__fill_2
XPHY_EDGE_ROW_69_1_Right_590 VDD VSS gf180mcu_as_sc_mcu7t3v3__tap_2
Xwire507 VDD VDD VSS VSS _2981_/Y wire507/Y gf180mcu_as_sc_mcu7t3v3__clkbuff_12
XFILLER_178_1301 VDD VDD VSS VSS gf180mcu_as_sc_mcu7t3v3__fill_2
XFILLER_192_941 VDD VDD VSS VSS gf180mcu_as_sc_mcu7t3v3__fillcap_4
XFILLER_163_120 VDD VDD VSS VSS gf180mcu_as_sc_mcu7t3v3__fillcap_16
XFILLER_163_142 VDD VDD VSS VSS gf180mcu_as_sc_mcu7t3v3__fillcap_16
XFILLER_192_963 VDD VDD VSS VSS gf180mcu_as_sc_mcu7t3v3__fillcap_16
XTAP_TAPCELL_ROW_43_3_2849 VDD VSS gf180mcu_as_sc_mcu7t3v3__tap_2
XFILLER_128_77 VDD VDD VSS VSS gf180mcu_as_sc_mcu7t3v3__fillcap_16
XFILLER_178_1378 VDD VDD VSS VSS gf180mcu_as_sc_mcu7t3v3__fillcap_16
XFILLER_65_1504 VDD VDD VSS VSS gf180mcu_as_sc_mcu7t3v3__fill_2
XFILLER_88_37 VDD VDD VSS VSS gf180mcu_as_sc_mcu7t3v3__fillcap_16
XFILLER_77_104 VDD VDD VSS VSS gf180mcu_as_sc_mcu7t3v3__fillcap_16
XTAP_TAPCELL_ROW_119_1_1803 VDD VSS gf180mcu_as_sc_mcu7t3v3__tap_2
Xfanout640 VDD VDD VSS VSS _3562_/Y _3751_/B gf180mcu_as_sc_mcu7t3v3__buff_12
Xfanout651 VDD VDD VSS VSS _3262_/Y _3500_/B gf180mcu_as_sc_mcu7t3v3__buff_12
XTAP_TAPCELL_ROW_31_1402 VDD VSS gf180mcu_as_sc_mcu7t3v3__tap_2
XPHY_EDGE_ROW_127_1_Left_337 VDD VSS gf180mcu_as_sc_mcu7t3v3__tap_2
Xfanout662 VDD VDD VSS VSS _4326_/S _4324_/S gf180mcu_as_sc_mcu7t3v3__buff_12
Xfanout673 VDD VDD VSS VSS _4624_/B _4621_/B gf180mcu_as_sc_mcu7t3v3__buff_12
Xfanout684 VDD VDD VSS VSS _3449_/B _3403_/S gf180mcu_as_sc_mcu7t3v3__buff_12
XTAP_TAPCELL_ROW_31_1413 VDD VSS gf180mcu_as_sc_mcu7t3v3__tap_2
XFILLER_115_1373 VDD VDD VSS VSS gf180mcu_as_sc_mcu7t3v3__fillcap_16
XFILLER_189_1452 VDD VDD VSS VSS gf180mcu_as_sc_mcu7t3v3__fillcap_16
XFILLER_24_1278 VDD VDD VSS VSS gf180mcu_as_sc_mcu7t3v3__fillcap_4
Xfanout695 VDD VDD VSS VSS _4152_/C _4102_/C gf180mcu_as_sc_mcu7t3v3__buff_12
XFILLER_160_53 VDD VDD VSS VSS gf180mcu_as_sc_mcu7t3v3__fillcap_4
XFILLER_2_1041 VDD VDD VSS VSS gf180mcu_as_sc_mcu7t3v3__fillcap_4
XFILLER_206_349 VDD VDD VSS VSS gf180mcu_as_sc_mcu7t3v3__fillcap_16
XFILLER_37_96 VDD VDD VSS VSS gf180mcu_as_sc_mcu7t3v3__fillcap_4
XFILLER_14_432 VDD VDD VSS VSS gf180mcu_as_sc_mcu7t3v3__fillcap_16
XFILLER_15_944 VDD VDD VSS VSS gf180mcu_as_sc_mcu7t3v3__fillcap_4
XFILLER_187_702 VDD VDD VSS VSS gf180mcu_as_sc_mcu7t3v3__fillcap_16
XFILLER_199_540 VDD VDD VSS VSS gf180mcu_as_sc_mcu7t3v3__fillcap_16
XFILLER_199_562 VDD VDD VSS VSS gf180mcu_as_sc_mcu7t3v3__fillcap_16
XFILLER_14_454 VDD VDD VSS VSS gf180mcu_as_sc_mcu7t3v3__fill_1
XFILLER_183_1084 VDD VDD VSS VSS gf180mcu_as_sc_mcu7t3v3__fillcap_16
XFILLER_186_201 VDD VDD VSS VSS gf180mcu_as_sc_mcu7t3v3__fillcap_8
XFILLER_30_903 VDD VDD VSS VSS gf180mcu_as_sc_mcu7t3v3__fillcap_16
XFILLER_53_51 VDD VDD VSS VSS gf180mcu_as_sc_mcu7t3v3__fill_2
XFILLER_72_1519 VDD VDD VSS VSS gf180mcu_as_sc_mcu7t3v3__fill_2
XTAP_TAPCELL_ROW_29_1375 VDD VSS gf180mcu_as_sc_mcu7t3v3__tap_2
XTAP_TAPCELL_ROW_29_1364 VDD VSS gf180mcu_as_sc_mcu7t3v3__tap_2
XFILLER_18_1049 VDD VDD VSS VSS gf180mcu_as_sc_mcu7t3v3__fillcap_16
XFILLER_30_925 VDD VDD VSS VSS gf180mcu_as_sc_mcu7t3v3__fill_1
XFILLER_30_947 VDD VDD VSS VSS gf180mcu_as_sc_mcu7t3v3__fill_1
XFILLER_174_407 VDD VDD VSS VSS gf180mcu_as_sc_mcu7t3v3__fill_1
XFILLER_174_418 VDD VDD VSS VSS gf180mcu_as_sc_mcu7t3v3__fillcap_4
XFILLER_30_958 VDD VDD VSS VSS gf180mcu_as_sc_mcu7t3v3__fillcap_8
XFILLER_35_1352 VDD VDD VSS VSS gf180mcu_as_sc_mcu7t3v3__fill_2
XFILLER_10_671 VDD VDD VSS VSS gf180mcu_as_sc_mcu7t3v3__fill_1
XFILLER_161_1393 VDD VDD VSS VSS gf180mcu_as_sc_mcu7t3v3__fill_2
Xmax_cap818 VDD VDD VSS VSS _4124_/A _3746_/A gf180mcu_as_sc_mcu7t3v3__clkbuff_12
XFILLER_157_1418 VDD VDD VSS VSS gf180mcu_as_sc_mcu7t3v3__fillcap_4
XFILLER_182_473 VDD VDD VSS VSS gf180mcu_as_sc_mcu7t3v3__fillcap_16
XFILLER_185_72 VDD VDD VSS VSS gf180mcu_as_sc_mcu7t3v3__fillcap_16
XFILLER_190_1011 VDD VDD VSS VSS gf180mcu_as_sc_mcu7t3v3__fillcap_4
XFILLER_190_1033 VDD VDD VSS VSS gf180mcu_as_sc_mcu7t3v3__fillcap_16
XFILLER_68_104 VDD VDD VSS VSS gf180mcu_as_sc_mcu7t3v3__fill_1
XFILLER_25_1009 VDD VDD VSS VSS gf180mcu_as_sc_mcu7t3v3__fillcap_16
XFILLER_29_1189 VDD VDD VSS VSS gf180mcu_as_sc_mcu7t3v3__fill_1
XPHY_EDGE_ROW_59_1_Left_269 VDD VSS gf180mcu_as_sc_mcu7t3v3__tap_2
X_4040_ VDD VDD VSS VSS _4040_/A _4103_/B _4101_/C _4040_/D _4041_/D gf180mcu_as_sc_mcu7t3v3__ao22_2
XFILLER_42_1356 VDD VDD VSS VSS gf180mcu_as_sc_mcu7t3v3__fillcap_4
XFILLER_209_154 VDD VDD VSS VSS gf180mcu_as_sc_mcu7t3v3__fill_2
XFILLER_25_708 VDD VDD VSS VSS gf180mcu_as_sc_mcu7t3v3__fill_1
Xmesh_tile_1050 VDD VDD VSS VSS sw_out[23] gf180mcu_as_sc_mcu7t3v3__tiel_4
XTAP_TAPCELL_ROW_38_1_1558 VDD VSS gf180mcu_as_sc_mcu7t3v3__tap_2
XTAP_TAPCELL_ROW_203_2648 VDD VSS gf180mcu_as_sc_mcu7t3v3__tap_2
XTAP_TAPCELL_ROW_203_2637 VDD VSS gf180mcu_as_sc_mcu7t3v3__tap_2
XTAP_TAPCELL_ROW_199_2552 VDD VSS gf180mcu_as_sc_mcu7t3v3__tap_2
XTAP_TAPCELL_ROW_199_2541 VDD VSS gf180mcu_as_sc_mcu7t3v3__tap_2
XFILLER_17_270 VDD VDD VSS VSS gf180mcu_as_sc_mcu7t3v3__fillcap_8
XFILLER_18_782 VDD VDD VSS VSS gf180mcu_as_sc_mcu7t3v3__fillcap_16
Xclkbuf_leaf_23_clk_regs VDD VDD VSS VSS clkbuf_3_5__f_clk_regs/Y _5285_/CLK gf180mcu_as_sc_mcu7t3v3__clkbuff_12
X_4942_ VDD VDD VSS VSS _5198_/CLK _4942_/D _4942_/Q gf180mcu_as_sc_mcu7t3v3__dfxtp_2
XFILLER_177_212 VDD VDD VSS VSS gf180mcu_as_sc_mcu7t3v3__fill_2
XFILLER_209_1566 VDD VDD VSS VSS gf180mcu_as_sc_mcu7t3v3__fill_2
XFILLER_36_1116 VDD VDD VSS VSS gf180mcu_as_sc_mcu7t3v3__fillcap_4
XFILLER_20_424 VDD VDD VSS VSS gf180mcu_as_sc_mcu7t3v3__fillcap_4
XFILLER_53_1430 VDD VDD VSS VSS gf180mcu_as_sc_mcu7t3v3__fillcap_8
XPHY_EDGE_ROW_173_1_Left_383 VDD VSS gf180mcu_as_sc_mcu7t3v3__tap_2
X_4873_ VDD VDD VSS VSS _4916_/CLK _4873_/D _4873_/Q gf180mcu_as_sc_mcu7t3v3__dfxtp_2
XFILLER_20_457 VDD VDD VSS VSS gf180mcu_as_sc_mcu7t3v3__fillcap_16
X_3824_ VDD VDD VSS VSS _4907_/D _3824_/C _4168_/A _4907_/Q gf180mcu_as_sc_mcu7t3v3__aoi21b_2
XFILLER_203_1154 VDD VDD VSS VSS gf180mcu_as_sc_mcu7t3v3__fillcap_16
XFILLER_20_479 VDD VDD VSS VSS gf180mcu_as_sc_mcu7t3v3__fill_1
XFILLER_53_1485 VDD VDD VSS VSS gf180mcu_as_sc_mcu7t3v3__fill_1
X_3755_ VDD VDD VSS VSS _4138_/A _3779_/B _3778_/B _4138_/D _3756_/D gf180mcu_as_sc_mcu7t3v3__ao22_2
XFILLER_145_120 VDD VDD VSS VSS gf180mcu_as_sc_mcu7t3v3__fillcap_16
XFILLER_145_142 VDD VDD VSS VSS gf180mcu_as_sc_mcu7t3v3__fillcap_16
X_3686_ VDD VDD VSS VSS _3687_/C _4065_/A _3751_/B _3686_/C gf180mcu_as_sc_mcu7t3v3__ao21_2
X_2706_ VDD VDD VSS VSS _2734_/S _2706_/B _2706_/A _2707_/C gf180mcu_as_sc_mcu7t3v3__mux2_2
XFILLER_12_1182 VDD VDD VSS VSS gf180mcu_as_sc_mcu7t3v3__fill_2
XPHY_EDGE_ROW_12_Right_12 VDD VSS gf180mcu_as_sc_mcu7t3v3__tap_2
X_2637_ VDD VDD VSS VSS _2639_/A _2637_/A gf180mcu_as_sc_mcu7t3v3__inv_2
XFILLER_145_186 VDD VDD VSS VSS gf180mcu_as_sc_mcu7t3v3__fill_1
XFILLER_160_123 VDD VDD VSS VSS gf180mcu_as_sc_mcu7t3v3__fillcap_16
XTAP_TAPCELL_ROW_8_907 VDD VSS gf180mcu_as_sc_mcu7t3v3__tap_2
X_2568_ VDD VDD VSS VSS _5227_/Q _5126_/Q _2806_/D _5125_/Q _2855_/A gf180mcu_as_sc_mcu7t3v3__ao22_2
XFILLER_101_212 VDD VDD VSS VSS gf180mcu_as_sc_mcu7t3v3__fillcap_8
XFILLER_160_189 VDD VDD VSS VSS gf180mcu_as_sc_mcu7t3v3__fill_1
XFILLER_59_137 VDD VDD VSS VSS gf180mcu_as_sc_mcu7t3v3__fill_2
XPHY_EDGE_ROW_149_3_Left_534 VDD VSS gf180mcu_as_sc_mcu7t3v3__tap_2
X_4307_ VDD VDD VSS VSS _4308_/S _5137_/Q _5136_/Q _5136_/D gf180mcu_as_sc_mcu7t3v3__mux2_2
X_2499_ VDD VDD VSS VSS _4708_/A _4703_/A _4683_/B gf180mcu_as_sc_mcu7t3v3__nand2_2
XFILLER_112_1502 VDD VDD VSS VSS gf180mcu_as_sc_mcu7t3v3__fill_2
XFILLER_151_1551 VDD VDD VSS VSS gf180mcu_as_sc_mcu7t3v3__fillcap_4
XFILLER_59_148 VDD VDD VSS VSS gf180mcu_as_sc_mcu7t3v3__fill_1
XFILLER_60_1423 VDD VDD VSS VSS gf180mcu_as_sc_mcu7t3v3__fill_2
X_4238_ VDD VDD VSS VSS _4256_/S _4238_/B _5074_/Q _5074_/D gf180mcu_as_sc_mcu7t3v3__mux2_2
XFILLER_21_1418 VDD VDD VSS VSS gf180mcu_as_sc_mcu7t3v3__fillcap_16
XFILLER_28_524 VDD VDD VSS VSS gf180mcu_as_sc_mcu7t3v3__fill_1
XFILLER_74_107 VDD VDD VSS VSS gf180mcu_as_sc_mcu7t3v3__fillcap_16
XFILLER_210_1158 VDD VDD VSS VSS gf180mcu_as_sc_mcu7t3v3__fill_2
XFILLER_210_1169 VDD VDD VSS VSS gf180mcu_as_sc_mcu7t3v3__fill_2
XFILLER_60_1489 VDD VDD VSS VSS gf180mcu_as_sc_mcu7t3v3__fill_2
X_4169_ VDD VDD VSS VSS _4229_/B _4193_/B _4193_/C _5007_/Q _5007_/D gf180mcu_as_sc_mcu7t3v3__ao22_2
XPHY_EDGE_ROW_21_Right_21 VDD VSS gf180mcu_as_sc_mcu7t3v3__tap_2
XFILLER_3_1394 VDD VDD VSS VSS gf180mcu_as_sc_mcu7t3v3__fillcap_4
XFILLER_58_1352 VDD VDD VSS VSS gf180mcu_as_sc_mcu7t3v3__fill_2
XFILLER_82_173 VDD VDD VSS VSS gf180mcu_as_sc_mcu7t3v3__fill_2
XFILLER_90_27 VDD VDD VSS VSS gf180mcu_as_sc_mcu7t3v3__fillcap_8
XPHY_EDGE_ROW_60_3_Right_97 VDD VSS gf180mcu_as_sc_mcu7t3v3__tap_2
XFILLER_12_947 VDD VDD VSS VSS gf180mcu_as_sc_mcu7t3v3__fillcap_8
XFILLER_196_521 VDD VDD VSS VSS gf180mcu_as_sc_mcu7t3v3__fillcap_4
XFILLER_196_543 VDD VDD VSS VSS gf180mcu_as_sc_mcu7t3v3__fillcap_16
XFILLER_208_1076 VDD VDD VSS VSS gf180mcu_as_sc_mcu7t3v3__fillcap_8
XFILLER_208_1087 VDD VDD VSS VSS gf180mcu_as_sc_mcu7t3v3__fillcap_4
XFILLER_24_774 VDD VDD VSS VSS gf180mcu_as_sc_mcu7t3v3__fill_2
XFILLER_11_446 VDD VDD VSS VSS gf180mcu_as_sc_mcu7t3v3__fill_1
XFILLER_23_43 VDD VDD VSS VSS gf180mcu_as_sc_mcu7t3v3__fillcap_16
XFILLER_32_1503 VDD VDD VSS VSS gf180mcu_as_sc_mcu7t3v3__fill_2
XTAP_TAPCELL_ROW_24_1250 VDD VSS gf180mcu_as_sc_mcu7t3v3__tap_2
XFILLER_139_43 VDD VDD VSS VSS gf180mcu_as_sc_mcu7t3v3__fillcap_4
XTAP_TAPCELL_ROW_64_1_1637 VDD VSS gf180mcu_as_sc_mcu7t3v3__tap_2
XTAP_TAPCELL_ROW_24_1261 VDD VSS gf180mcu_as_sc_mcu7t3v3__tap_2
XFILLER_136_131 VDD VDD VSS VSS gf180mcu_as_sc_mcu7t3v3__fillcap_4
XFILLER_20_991 VDD VDD VSS VSS gf180mcu_as_sc_mcu7t3v3__fill_1
XFILLER_99_47 VDD VDD VSS VSS gf180mcu_as_sc_mcu7t3v3__fillcap_8
XPHY_EDGE_ROW_30_Right_30 VDD VSS gf180mcu_as_sc_mcu7t3v3__tap_2
XTAP_TAPCELL_ROW_20_1169 VDD VSS gf180mcu_as_sc_mcu7t3v3__tap_2
XFILLER_174_1017 VDD VDD VSS VSS gf180mcu_as_sc_mcu7t3v3__fill_2
XFILLER_69_1481 VDD VDD VSS VSS gf180mcu_as_sc_mcu7t3v3__fillcap_4
XFILLER_117_1413 VDD VDD VSS VSS gf180mcu_as_sc_mcu7t3v3__fill_2
XFILLER_3_2 VDD VDD VSS VSS gf180mcu_as_sc_mcu7t3v3__fillcap_16
XFILLER_156_1495 VDD VDD VSS VSS gf180mcu_as_sc_mcu7t3v3__fill_1
XFILLER_26_1329 VDD VDD VSS VSS gf180mcu_as_sc_mcu7t3v3__fillcap_16
XFILLER_2_177 VDD VDD VSS VSS gf180mcu_as_sc_mcu7t3v3__fill_2
XFILLER_152_1348 VDD VDD VSS VSS gf180mcu_as_sc_mcu7t3v3__fillcap_16
XFILLER_48_84 VDD VDD VSS VSS gf180mcu_as_sc_mcu7t3v3__fill_1
XFILLER_8_1294 VDD VDD VSS VSS gf180mcu_as_sc_mcu7t3v3__fill_1
Xfanout481 VDD VDD VSS VSS _4227_/C _4228_/C gf180mcu_as_sc_mcu7t3v3__buff_12
XPHY_EDGE_ROW_70_3_Left_455 VDD VSS gf180mcu_as_sc_mcu7t3v3__tap_2
XFILLER_0_36 VDD VDD VSS VSS gf180mcu_as_sc_mcu7t3v3__fillcap_4
XFILLER_34_527 VDD VDD VSS VSS gf180mcu_as_sc_mcu7t3v3__fillcap_16
XFILLER_64_61 VDD VDD VSS VSS gf180mcu_as_sc_mcu7t3v3__fill_2
XFILLER_76_1430 VDD VDD VSS VSS gf180mcu_as_sc_mcu7t3v3__fillcap_16
XFILLER_159_201 VDD VDD VSS VSS gf180mcu_as_sc_mcu7t3v3__fillcap_8
XFILLER_163_1411 VDD VDD VSS VSS gf180mcu_as_sc_mcu7t3v3__fillcap_4
XFILLER_203_820 VDD VDD VSS VSS gf180mcu_as_sc_mcu7t3v3__fillcap_16
XFILLER_203_842 VDD VDD VSS VSS gf180mcu_as_sc_mcu7t3v3__fillcap_16
XFILLER_124_1406 VDD VDD VSS VSS gf180mcu_as_sc_mcu7t3v3__fillcap_16
XFILLER_128_1564 VDD VDD VSS VSS gf180mcu_as_sc_mcu7t3v3__fillcap_4
XFILLER_159_212 VDD VDD VSS VSS gf180mcu_as_sc_mcu7t3v3__fillcap_8
XFILLER_163_1466 VDD VDD VSS VSS gf180mcu_as_sc_mcu7t3v3__fillcap_16
XFILLER_187_532 VDD VDD VSS VSS gf180mcu_as_sc_mcu7t3v3__fillcap_4
XFILLER_37_1469 VDD VDD VSS VSS gf180mcu_as_sc_mcu7t3v3__fill_1
XFILLER_76_1485 VDD VDD VSS VSS gf180mcu_as_sc_mcu7t3v3__fillcap_8
XFILLER_163_1488 VDD VDD VSS VSS gf180mcu_as_sc_mcu7t3v3__fillcap_16
XFILLER_175_727 VDD VDD VSS VSS gf180mcu_as_sc_mcu7t3v3__fillcap_4
XFILLER_198_1507 VDD VDD VSS VSS gf180mcu_as_sc_mcu7t3v3__fillcap_16
XFILLER_9_67 VDD VDD VSS VSS gf180mcu_as_sc_mcu7t3v3__fill_2
XFILLER_174_237 VDD VDD VSS VSS gf180mcu_as_sc_mcu7t3v3__fill_1
XFILLER_31_1002 VDD VDD VSS VSS gf180mcu_as_sc_mcu7t3v3__fillcap_16
XTAP_TAPCELL_ROW_190_2346 VDD VSS gf180mcu_as_sc_mcu7t3v3__tap_2
XFILLER_127_142 VDD VDD VSS VSS gf180mcu_as_sc_mcu7t3v3__fill_2
XFILLER_204_1485 VDD VDD VSS VSS gf180mcu_as_sc_mcu7t3v3__fillcap_16
XFILLER_31_1046 VDD VDD VSS VSS gf180mcu_as_sc_mcu7t3v3__fillcap_4
X_3540_ VDD VDD VSS VSS _3914_/B _4977_/Q _3792_/D gf180mcu_as_sc_mcu7t3v3__and2_2
XTAP_TAPCELL_ROW_190_2357 VDD VSS gf180mcu_as_sc_mcu7t3v3__tap_2
Xwire871 VDD VDD VSS VSS wire871/A _3961_/A gf180mcu_as_sc_mcu7t3v3__clkbuff_12
Xwire882 VDD VDD VSS VSS wire882/A _4017_/A gf180mcu_as_sc_mcu7t3v3__clkbuff_12
XFILLER_196_1275 VDD VDD VSS VSS gf180mcu_as_sc_mcu7t3v3__fillcap_16
XFILLER_196_1297 VDD VDD VSS VSS gf180mcu_as_sc_mcu7t3v3__fillcap_16
X_5210_ VDD VDD VSS VSS _5214_/CLK _5210_/D _5210_/Q gf180mcu_as_sc_mcu7t3v3__dfxtp_2
X_3471_ VDD VDD VSS VSS _3479_/C _4130_/A _3473_/C gf180mcu_as_sc_mcu7t3v3__and2_2
XFILLER_83_1434 VDD VDD VSS VSS gf180mcu_as_sc_mcu7t3v3__fillcap_16
X_2422_ VDD VDD VSS VSS _2663_/A input8/Y gf180mcu_as_sc_mcu7t3v3__inv_2
XFILLER_44_1407 VDD VDD VSS VSS gf180mcu_as_sc_mcu7t3v3__fill_1
XFILLER_96_221 VDD VDD VSS VSS gf180mcu_as_sc_mcu7t3v3__fill_1
X_5141_ VDD VDD VSS VSS _5142_/CLK _5141_/D _5141_/Q gf180mcu_as_sc_mcu7t3v3__dfxtp_2
XTAP_TAPCELL_ROW_90_1_1716 VDD VSS gf180mcu_as_sc_mcu7t3v3__tap_2
XFILLER_135_1568 VDD VDD VSS VSS gf180mcu_as_sc_mcu7t3v3__fill_1
X_5072_ VDD VDD VSS VSS clkload3/A _5072_/D _5072_/Q gf180mcu_as_sc_mcu7t3v3__dfxtp_2
XFILLER_56_107 VDD VDD VSS VSS gf180mcu_as_sc_mcu7t3v3__fillcap_16
X_4023_ VDD VDD VSS VSS _4023_/A _4023_/B _4023_/C _4926_/Q _4025_/C gf180mcu_as_sc_mcu7t3v3__ao22_2
XFILLER_168_1366 VDD VDD VSS VSS gf180mcu_as_sc_mcu7t3v3__fill_1
XFILLER_168_1399 VDD VDD VSS VSS gf180mcu_as_sc_mcu7t3v3__fillcap_16
XFILLER_181_1500 VDD VDD VSS VSS gf180mcu_as_sc_mcu7t3v3__fill_2
XFILLER_100_37 VDD VDD VSS VSS gf180mcu_as_sc_mcu7t3v3__fillcap_8
XFILLER_178_543 VDD VDD VSS VSS gf180mcu_as_sc_mcu7t3v3__fillcap_16
XFILLER_205_190 VDD VDD VSS VSS gf180mcu_as_sc_mcu7t3v3__fillcap_16
XFILLER_55_1558 VDD VDD VSS VSS gf180mcu_as_sc_mcu7t3v3__fillcap_8
X_4925_ VDD VDD VSS VSS clkload8/A _4925_/D _4925_/Q gf180mcu_as_sc_mcu7t3v3__dfxtp_2
XFILLER_142_1539 VDD VDD VSS VSS gf180mcu_as_sc_mcu7t3v3__fill_2
XFILLER_209_1396 VDD VDD VSS VSS gf180mcu_as_sc_mcu7t3v3__fillcap_4
XFILLER_90_1449 VDD VDD VSS VSS gf180mcu_as_sc_mcu7t3v3__fill_2
X_4856_ VDD VDD VSS VSS _5192_/CLK _4856_/D _4856_/Q gf180mcu_as_sc_mcu7t3v3__dfxtp_2
XFILLER_14_1211 VDD VDD VSS VSS gf180mcu_as_sc_mcu7t3v3__fillcap_8
XFILLER_178_587 VDD VDD VSS VSS gf180mcu_as_sc_mcu7t3v3__fillcap_8
XFILLER_193_524 VDD VDD VSS VSS gf180mcu_as_sc_mcu7t3v3__fillcap_16
XFILLER_21_788 VDD VDD VSS VSS gf180mcu_as_sc_mcu7t3v3__fillcap_16
X_4871__1095 VDD VDD VSS VSS _4871_/D gf180mcu_as_sc_mcu7t3v3__tiel_4
X_3807_ VDD VDD VSS VSS _3918_/A _3807_/B _3807_/A gf180mcu_as_sc_mcu7t3v3__nand2_2
XFILLER_20_287 VDD VDD VSS VSS gf180mcu_as_sc_mcu7t3v3__fillcap_4
X_4787_ VDD VDD VSS VSS _4869_/CLK _4787_/D _4787_/Q gf180mcu_as_sc_mcu7t3v3__dfxtp_2
XFILLER_180_218 VDD VDD VSS VSS gf180mcu_as_sc_mcu7t3v3__fillcap_16
X_3738_ VDD VDD VSS VSS _3746_/D _3794_/S _3738_/B _3738_/C _3739_/C gf180mcu_as_sc_mcu7t3v3__ao31_2
XFILLER_109_68 VDD VDD VSS VSS gf180mcu_as_sc_mcu7t3v3__fill_2
X_3669_ VDD VDD VSS VSS _4852_/D _3669_/C _3731_/B _4043_/A gf180mcu_as_sc_mcu7t3v3__aoi21_2
XFILLER_175_1359 VDD VDD VSS VSS gf180mcu_as_sc_mcu7t3v3__fillcap_16
XFILLER_0_648 VDD VDD VSS VSS gf180mcu_as_sc_mcu7t3v3__fillcap_4
XFILLER_197_6 VDD VDD VSS VSS gf180mcu_as_sc_mcu7t3v3__fillcap_16
XFILLER_25_1395 VDD VDD VSS VSS gf180mcu_as_sc_mcu7t3v3__fillcap_4
XFILLER_21_1259 VDD VDD VSS VSS gf180mcu_as_sc_mcu7t3v3__fill_1
XFILLER_99_1485 VDD VDD VSS VSS gf180mcu_as_sc_mcu7t3v3__fill_1
XFILLER_141_88 VDD VDD VSS VSS gf180mcu_as_sc_mcu7t3v3__fill_2
XFILLER_16_527 VDD VDD VSS VSS gf180mcu_as_sc_mcu7t3v3__fillcap_16
XFILLER_28_387 VDD VDD VSS VSS gf180mcu_as_sc_mcu7t3v3__fillcap_16
XFILLER_186_1499 VDD VDD VSS VSS gf180mcu_as_sc_mcu7t3v3__fillcap_4
XFILLER_31_508 VDD VDD VSS VSS gf180mcu_as_sc_mcu7t3v3__fillcap_8
XTAP_TAPCELL_ROW_26_1301 VDD VSS gf180mcu_as_sc_mcu7t3v3__tap_2
XFILLER_19_1122 VDD VDD VSS VSS gf180mcu_as_sc_mcu7t3v3__fillcap_8
XFILLER_70_187 VDD VDD VSS VSS gf180mcu_as_sc_mcu7t3v3__fillcap_4
XTAP_TAPCELL_ROW_26_1312 VDD VSS gf180mcu_as_sc_mcu7t3v3__tap_2
XFILLER_180_1065 VDD VDD VSS VSS gf180mcu_as_sc_mcu7t3v3__fillcap_16
XFILLER_184_502 VDD VDD VSS VSS gf180mcu_as_sc_mcu7t3v3__fillcap_16
XFILLER_196_351 VDD VDD VSS VSS gf180mcu_as_sc_mcu7t3v3__fill_1
XFILLER_197_874 VDD VDD VSS VSS gf180mcu_as_sc_mcu7t3v3__fillcap_16
XFILLER_19_1188 VDD VDD VSS VSS gf180mcu_as_sc_mcu7t3v3__fill_2
XFILLER_200_801 VDD VDD VSS VSS gf180mcu_as_sc_mcu7t3v3__fillcap_4
XFILLER_11_265 VDD VDD VSS VSS gf180mcu_as_sc_mcu7t3v3__fillcap_8
XFILLER_156_204 VDD VDD VSS VSS gf180mcu_as_sc_mcu7t3v3__fillcap_16
XFILLER_180_1087 VDD VDD VSS VSS gf180mcu_as_sc_mcu7t3v3__fillcap_16
XFILLER_184_524 VDD VDD VSS VSS gf180mcu_as_sc_mcu7t3v3__fill_1
XFILLER_36_1480 VDD VDD VSS VSS gf180mcu_as_sc_mcu7t3v3__fillcap_16
XFILLER_8_737 VDD VDD VSS VSS gf180mcu_as_sc_mcu7t3v3__fillcap_8
XTAP_TAPCELL_ROW_22_1209 VDD VSS gf180mcu_as_sc_mcu7t3v3__tap_2
XFILLER_109_120 VDD VDD VSS VSS gf180mcu_as_sc_mcu7t3v3__fillcap_16
XFILLER_8_759 VDD VDD VSS VSS gf180mcu_as_sc_mcu7t3v3__fill_2
XTAP_TAPCELL_ROW_10_945 VDD VSS gf180mcu_as_sc_mcu7t3v3__tap_2
XFILLER_109_142 VDD VDD VSS VSS gf180mcu_as_sc_mcu7t3v3__fillcap_8
XFILLER_166_30 VDD VDD VSS VSS gf180mcu_as_sc_mcu7t3v3__fillcap_4
XFILLER_171_207 VDD VDD VSS VSS gf180mcu_as_sc_mcu7t3v3__fill_2
XFILLER_32_1399 VDD VDD VSS VSS gf180mcu_as_sc_mcu7t3v3__fillcap_16
XTAP_TAPCELL_ROW_10_956 VDD VSS gf180mcu_as_sc_mcu7t3v3__tap_2
XFILLER_119_1508 VDD VDD VSS VSS gf180mcu_as_sc_mcu7t3v3__fill_2
XFILLER_67_1418 VDD VDD VSS VSS gf180mcu_as_sc_mcu7t3v3__fill_2
XFILLER_158_1568 VDD VDD VSS VSS gf180mcu_as_sc_mcu7t3v3__fill_1
XFILLER_4_976 VDD VDD VSS VSS gf180mcu_as_sc_mcu7t3v3__fillcap_8
XTAP_TAPCELL_ROW_169_1_1952 VDD VSS gf180mcu_as_sc_mcu7t3v3__tap_2
XFILLER_59_83 VDD VDD VSS VSS gf180mcu_as_sc_mcu7t3v3__fillcap_8
XFILLER_38_118 VDD VDD VSS VSS gf180mcu_as_sc_mcu7t3v3__fillcap_16
XFILLER_187_1208 VDD VDD VSS VSS gf180mcu_as_sc_mcu7t3v3__fillcap_16
XTAP_TAPCELL_ROW_183_2194 VDD VSS gf180mcu_as_sc_mcu7t3v3__tap_2
XFILLER_19_354 VDD VDD VSS VSS gf180mcu_as_sc_mcu7t3v3__fill_1
XFILLER_207_422 VDD VDD VSS VSS gf180mcu_as_sc_mcu7t3v3__fillcap_16
XTAP_TAPCELL_ROW_64_3_2912 VDD VSS gf180mcu_as_sc_mcu7t3v3__tap_2
X_2971_ VDD VDD VSS VSS _3952_/A _3079_/B _2971_/C _2971_/D _2972_/C gf180mcu_as_sc_mcu7t3v3__ao22_2
XFILLER_128_1383 VDD VDD VSS VSS gf180mcu_as_sc_mcu7t3v3__fillcap_16
X_4710_ VDD VDD VSS VSS _4721_/A _4710_/B _5104_/Q _5257_/D gf180mcu_as_sc_mcu7t3v3__mux2_2
XFILLER_147_204 VDD VDD VSS VSS gf180mcu_as_sc_mcu7t3v3__fillcap_4
XFILLER_202_171 VDD VDD VSS VSS gf180mcu_as_sc_mcu7t3v3__fillcap_4
XFILLER_202_193 VDD VDD VSS VSS gf180mcu_as_sc_mcu7t3v3__fillcap_16
XFILLER_33_1119 VDD VDD VSS VSS gf180mcu_as_sc_mcu7t3v3__fill_1
X_4641_ VDD VDD VSS VSS _4725_/B _5480_/A _5232_/Q _5232_/D gf180mcu_as_sc_mcu7t3v3__mux2_2
XFILLER_102_1501 VDD VDD VSS VSS gf180mcu_as_sc_mcu7t3v3__fill_1
XFILLER_102_1523 VDD VDD VSS VSS gf180mcu_as_sc_mcu7t3v3__fillcap_16
XFILLER_190_527 VDD VDD VSS VSS gf180mcu_as_sc_mcu7t3v3__fillcap_16
XFILLER_200_1135 VDD VDD VSS VSS gf180mcu_as_sc_mcu7t3v3__fillcap_16
X_4572_ VDD VDD VSS VSS _4572_/D _4572_/A _4572_/B _4572_/C _4573_/B gf180mcu_as_sc_mcu7t3v3__ao31_2
XTAP_TAPCELL_ROW_44_3_2854 VDD VSS gf180mcu_as_sc_mcu7t3v3__tap_2
XFILLER_200_1157 VDD VDD VSS VSS gf180mcu_as_sc_mcu7t3v3__fillcap_16
X_3523_ VDD VDD VSS VSS _3524_/D _3523_/C _3523_/B _3523_/A gf180mcu_as_sc_mcu7t3v3__aoi21b_2
X_3454_ VDD VDD VSS VSS _3455_/B _3454_/B _3454_/C _3455_/C gf180mcu_as_sc_mcu7t3v3__nor3_2
XFILLER_115_178 VDD VDD VSS VSS gf180mcu_as_sc_mcu7t3v3__fillcap_16
XFILLER_130_104 VDD VDD VSS VSS gf180mcu_as_sc_mcu7t3v3__fill_1
X_2405_ VDD VDD VSS VSS _4704_/A _5222_/Q gf180mcu_as_sc_mcu7t3v3__inv_2
X_3385_ VDD VDD VSS VSS _4928_/Q _3448_/B _3465_/C _4039_/A _3386_/C gf180mcu_as_sc_mcu7t3v3__ao22_2
X_5124_ VDD VDD VSS VSS _5277_/CLK _5124_/D _5124_/Q gf180mcu_as_sc_mcu7t3v3__dfxtp_2
X_5055_ VDD VDD VSS VSS _5085_/CLK _5055_/D _5055_/Q gf180mcu_as_sc_mcu7t3v3__dfxtp_2
X_4006_ VDD VDD VSS VSS _4006_/A _4101_/B _4103_/B _4006_/D _4007_/D gf180mcu_as_sc_mcu7t3v3__ao22_2
XFILLER_0_1353 VDD VDD VSS VSS gf180mcu_as_sc_mcu7t3v3__fillcap_4
XFILLER_197_104 VDD VDD VSS VSS gf180mcu_as_sc_mcu7t3v3__fillcap_16
XFILLER_20_1292 VDD VDD VSS VSS gf180mcu_as_sc_mcu7t3v3__fill_2
XFILLER_146_1450 VDD VDD VSS VSS gf180mcu_as_sc_mcu7t3v3__fill_1
XFILLER_146_1461 VDD VDD VSS VSS gf180mcu_as_sc_mcu7t3v3__fillcap_4
XFILLER_209_1171 VDD VDD VSS VSS gf180mcu_as_sc_mcu7t3v3__fillcap_16
Xclkbuf_3_4__f_clk_regs VDD VDD VSS VSS clkbuf_2_2_0_clk_regs/Y clkbuf_3_4__f_clk_regs/Y
+ gf180mcu_as_sc_mcu7t3v3__clkbuff_12
X_4908_ VDD VDD VSS VSS _5073_/CLK _4908_/D _4908_/Q gf180mcu_as_sc_mcu7t3v3__dfxtp_2
XFILLER_205_1046 VDD VDD VSS VSS gf180mcu_as_sc_mcu7t3v3__fillcap_4
XFILLER_205_1068 VDD VDD VSS VSS gf180mcu_as_sc_mcu7t3v3__fillcap_16
XFILLER_193_343 VDD VDD VSS VSS gf180mcu_as_sc_mcu7t3v3__fillcap_4
XFILLER_194_855 VDD VDD VSS VSS gf180mcu_as_sc_mcu7t3v3__fillcap_16
XFILLER_194_877 VDD VDD VSS VSS gf180mcu_as_sc_mcu7t3v3__fillcap_8
X_4839_ VDD VDD VSS VSS clkload6/A _4839_/D _4839_/Q gf180mcu_as_sc_mcu7t3v3__dfxtp_2
XPHY_EDGE_ROW_136_1_Left_346 VDD VSS gf180mcu_as_sc_mcu7t3v3__tap_2
XFILLER_121_104 VDD VDD VSS VSS gf180mcu_as_sc_mcu7t3v3__fillcap_16
XFILLER_136_66 VDD VDD VSS VSS gf180mcu_as_sc_mcu7t3v3__fill_2
XFILLER_27_1402 VDD VDD VSS VSS gf180mcu_as_sc_mcu7t3v3__fillcap_16
XTAP_TAPCELL_ROW_59_1_1621 VDD VSS gf180mcu_as_sc_mcu7t3v3__tap_2
Xinput302 VDD VDD VSS VSS west_in[27] _4151_/A gf180mcu_as_sc_mcu7t3v3__buff_12
XFILLER_27_1468 VDD VDD VSS VSS gf180mcu_as_sc_mcu7t3v3__fill_2
XFILLER_62_1348 VDD VDD VSS VSS gf180mcu_as_sc_mcu7t3v3__fillcap_16
Xinput313 VDD VDD VSS VSS west_in[6] _3981_/A gf180mcu_as_sc_mcu7t3v3__buff_12
XFILLER_114_1449 VDD VDD VSS VSS gf180mcu_as_sc_mcu7t3v3__fill_2
XFILLER_188_2 VDD VDD VSS VSS gf180mcu_as_sc_mcu7t3v3__fillcap_16
XTAP_TAPCELL_ROW_15_1057 VDD VSS gf180mcu_as_sc_mcu7t3v3__tap_2
XTAP_TAPCELL_ROW_15_1068 VDD VSS gf180mcu_as_sc_mcu7t3v3__tap_2
XTAP_TAPCELL_ROW_69_3_2927 VDD VSS gf180mcu_as_sc_mcu7t3v3__tap_2
XFILLER_25_1192 VDD VDD VSS VSS gf180mcu_as_sc_mcu7t3v3__fillcap_16
XTAP_TAPCELL_ROW_39_1_1563 VDD VSS gf180mcu_as_sc_mcu7t3v3__tap_2
XFILLER_1_1128 VDD VDD VSS VSS gf180mcu_as_sc_mcu7t3v3__fill_1
XFILLER_17_858 VDD VDD VSS VSS gf180mcu_as_sc_mcu7t3v3__fill_2
XFILLER_204_403 VDD VDD VSS VSS gf180mcu_as_sc_mcu7t3v3__fillcap_16
XFILLER_16_379 VDD VDD VSS VSS gf180mcu_as_sc_mcu7t3v3__fillcap_4
XFILLER_73_1422 VDD VDD VSS VSS gf180mcu_as_sc_mcu7t3v3__fill_2
XTAP_TAPCELL_ROW_49_3_2869 VDD VSS gf180mcu_as_sc_mcu7t3v3__tap_2
XFILLER_31_349 VDD VDD VSS VSS gf180mcu_as_sc_mcu7t3v3__fill_1
XFILLER_34_1417 VDD VDD VSS VSS gf180mcu_as_sc_mcu7t3v3__fill_1
XFILLER_160_1447 VDD VDD VSS VSS gf180mcu_as_sc_mcu7t3v3__fillcap_4
XFILLER_61_51 VDD VDD VSS VSS gf180mcu_as_sc_mcu7t3v3__fillcap_16
XFILLER_73_1488 VDD VDD VSS VSS gf180mcu_as_sc_mcu7t3v3__fillcap_16
XPHY_EDGE_ROW_68_1_Left_278 VDD VSS gf180mcu_as_sc_mcu7t3v3__tap_2
XFILLER_184_387 VDD VDD VSS VSS gf180mcu_as_sc_mcu7t3v3__fillcap_8
XANTENNA_6 VDD VDD VSS VSS _4854_/D gf180mcu_as_sc_mcu7t3v3__diode_2
XFILLER_201_1466 VDD VDD VSS VSS gf180mcu_as_sc_mcu7t3v3__fillcap_4
XFILLER_201_1488 VDD VDD VSS VSS gf180mcu_as_sc_mcu7t3v3__fillcap_16
XFILLER_112_104 VDD VDD VSS VSS gf180mcu_as_sc_mcu7t3v3__fill_1
XFILLER_180_593 VDD VDD VSS VSS gf180mcu_as_sc_mcu7t3v3__fill_2
XFILLER_193_1256 VDD VDD VSS VSS gf180mcu_as_sc_mcu7t3v3__fillcap_4
XFILLER_193_1278 VDD VDD VSS VSS gf180mcu_as_sc_mcu7t3v3__fillcap_16
XFILLER_193_72 VDD VDD VSS VSS gf180mcu_as_sc_mcu7t3v3__fillcap_16
XFILLER_112_137 VDD VDD VSS VSS gf180mcu_as_sc_mcu7t3v3__fillcap_16
XFILLER_80_1426 VDD VDD VSS VSS gf180mcu_as_sc_mcu7t3v3__fill_1
XTAP_TAPCELL_ROW_210_2791 VDD VSS gf180mcu_as_sc_mcu7t3v3__tap_2
XTAP_TAPCELL_ROW_185_2245 VDD VSS gf180mcu_as_sc_mcu7t3v3__tap_2
XTAP_TAPCELL_ROW_185_2234 VDD VSS gf180mcu_as_sc_mcu7t3v3__tap_2
XFILLER_132_1505 VDD VDD VSS VSS gf180mcu_as_sc_mcu7t3v3__fillcap_16
XFILLER_45_1568 VDD VDD VSS VSS gf180mcu_as_sc_mcu7t3v3__fill_1
XFILLER_80_1437 VDD VDD VSS VSS gf180mcu_as_sc_mcu7t3v3__fill_1
X_3170_ VDD VDD VSS VSS _3178_/A _3170_/B _3170_/C _3178_/D _3171_/D gf180mcu_as_sc_mcu7t3v3__ao211_2
Xmesh_tile_939 VDD VDD VSS VSS ne_out[14] gf180mcu_as_sc_mcu7t3v3__tiel_4
Xmesh_tile_928 VDD VDD VSS VSS ne_out[3] gf180mcu_as_sc_mcu7t3v3__tiel_4
XFILLER_208_731 VDD VDD VSS VSS gf180mcu_as_sc_mcu7t3v3__fillcap_4
XFILLER_169_1450 VDD VDD VSS VSS gf180mcu_as_sc_mcu7t3v3__fillcap_8
XFILLER_208_753 VDD VDD VSS VSS gf180mcu_as_sc_mcu7t3v3__fillcap_16
XTAP_TAPCELL_ROW_97_3_3012 VDD VSS gf180mcu_as_sc_mcu7t3v3__tap_2
XTAP_TAPCELL_ROW_85_1_1700 VDD VSS gf180mcu_as_sc_mcu7t3v3__tap_2
XFILLER_179_104 VDD VDD VSS VSS gf180mcu_as_sc_mcu7t3v3__fillcap_16
XFILLER_35_655 VDD VDD VSS VSS gf180mcu_as_sc_mcu7t3v3__fillcap_16
XFILLER_23_817 VDD VDD VSS VSS gf180mcu_as_sc_mcu7t3v3__fillcap_16
XFILLER_23_839 VDD VDD VSS VSS gf180mcu_as_sc_mcu7t3v3__fill_1
XFILLER_179_148 VDD VDD VSS VSS gf180mcu_as_sc_mcu7t3v3__fill_1
XFILLER_22_327 VDD VDD VSS VSS gf180mcu_as_sc_mcu7t3v3__fill_1
XFILLER_176_811 VDD VDD VSS VSS gf180mcu_as_sc_mcu7t3v3__fill_2
XFILLER_194_107 VDD VDD VSS VSS gf180mcu_as_sc_mcu7t3v3__fillcap_16
XFILLER_31_850 VDD VDD VSS VSS gf180mcu_as_sc_mcu7t3v3__fill_2
XFILLER_91_1566 VDD VDD VSS VSS gf180mcu_as_sc_mcu7t3v3__fill_2
XPHY_EDGE_ROW_158_3_Left_543 VDD VSS gf180mcu_as_sc_mcu7t3v3__tap_2
X_2954_ VDD VDD VSS VSS _3934_/A _3079_/B _2954_/C _2954_/D _2955_/B gf180mcu_as_sc_mcu7t3v3__ao211_2
XFILLER_175_321 VDD VDD VSS VSS gf180mcu_as_sc_mcu7t3v3__fill_1
XFILLER_176_877 VDD VDD VSS VSS gf180mcu_as_sc_mcu7t3v3__fillcap_16
XFILLER_206_1399 VDD VDD VSS VSS gf180mcu_as_sc_mcu7t3v3__fillcap_16
XFILLER_30_371 VDD VDD VSS VSS gf180mcu_as_sc_mcu7t3v3__fillcap_8
X_2885_ VDD VDD VSS VSS _3780_/A _3511_/A _3520_/A gf180mcu_as_sc_mcu7t3v3__nor2_2
XFILLER_15_1372 VDD VDD VSS VSS gf180mcu_as_sc_mcu7t3v3__fill_2
XFILLER_191_836 VDD VDD VSS VSS gf180mcu_as_sc_mcu7t3v3__fillcap_4
XPHY_EDGE_ROW_6_Right_6 VDD VSS gf180mcu_as_sc_mcu7t3v3__tap_2
X_4624_ VDD VDD VSS VSS _5218_/Q _4624_/B _4629_/C _5219_/Q _5218_/D gf180mcu_as_sc_mcu7t3v3__ao22_2
XTAP_TAPCELL_ROW_174_1971 VDD VSS gf180mcu_as_sc_mcu7t3v3__tap_2
XFILLER_191_858 VDD VDD VSS VSS gf180mcu_as_sc_mcu7t3v3__fillcap_16
XFILLER_198_1189 VDD VDD VSS VSS gf180mcu_as_sc_mcu7t3v3__fillcap_16
X_4555_ VDD VDD VSS VSS _4555_/B _4591_/A _4556_/D gf180mcu_as_sc_mcu7t3v3__and2_2
XTAP_TAPCELL_ROW_174_1993 VDD VSS gf180mcu_as_sc_mcu7t3v3__tap_2
XTAP_TAPCELL_ROW_174_1982 VDD VSS gf180mcu_as_sc_mcu7t3v3__tap_2
X_3506_ VDD VDD VSS VSS _3506_/B _3525_/A _4833_/D gf180mcu_as_sc_mcu7t3v3__and2_2
XFILLER_103_104 VDD VDD VSS VSS gf180mcu_as_sc_mcu7t3v3__fillcap_16
XFILLER_137_1427 VDD VDD VSS VSS gf180mcu_as_sc_mcu7t3v3__fill_1
XFILLER_1_209 VDD VDD VSS VSS gf180mcu_as_sc_mcu7t3v3__fill_1
XFILLER_85_1348 VDD VDD VSS VSS gf180mcu_as_sc_mcu7t3v3__fillcap_8
X_4486_ VDD VDD VSS VSS _5176_/Q _4574_/B _4486_/C _4486_/D _5176_/D gf180mcu_as_sc_mcu7t3v3__ao211_2
X_3437_ VDD VDD VSS VSS _4085_/D _3468_/B _3437_/C _3437_/D _3438_/C gf180mcu_as_sc_mcu7t3v3__ao211_2
X_3368_ VDD VDD VSS VSS _3647_/A _3463_/B _3368_/C _4815_/D _3416_/D gf180mcu_as_sc_mcu7t3v3__aoi211_2
X_5107_ VDD VDD VSS VSS _5260_/CLK _5107_/D _5107_/Q gf180mcu_as_sc_mcu7t3v3__dfxtp_2
X_3299_ VDD VDD VSS VSS _3949_/A _3403_/S _3299_/C _3299_/D _3301_/C gf180mcu_as_sc_mcu7t3v3__ao211_2
XFILLER_22_1354 VDD VDD VSS VSS gf180mcu_as_sc_mcu7t3v3__fillcap_8
X_5038_ VDD VDD VSS VSS clkload5/A _5038_/D _5038_/Q gf180mcu_as_sc_mcu7t3v3__dfxtp_2
XTAP_TAPCELL_ROW_1_743 VDD VSS gf180mcu_as_sc_mcu7t3v3__tap_2
XFILLER_82_39 VDD VDD VSS VSS gf180mcu_as_sc_mcu7t3v3__fill_1
XTAP_TAPCELL_ROW_1_754 VDD VSS gf180mcu_as_sc_mcu7t3v3__tap_2
XFILLER_183_1447 VDD VDD VSS VSS gf180mcu_as_sc_mcu7t3v3__fillcap_16
XFILLER_198_413 VDD VDD VSS VSS gf180mcu_as_sc_mcu7t3v3__fillcap_8
XFILLER_26_677 VDD VDD VSS VSS gf180mcu_as_sc_mcu7t3v3__fillcap_16
XFILLER_0_1183 VDD VDD VSS VSS gf180mcu_as_sc_mcu7t3v3__fillcap_4
XFILLER_183_1469 VDD VDD VSS VSS gf180mcu_as_sc_mcu7t3v3__fill_1
XFILLER_198_457 VDD VDD VSS VSS gf180mcu_as_sc_mcu7t3v3__fillcap_16
XFILLER_201_417 VDD VDD VSS VSS gf180mcu_as_sc_mcu7t3v3__fill_2
XFILLER_15_88 VDD VDD VSS VSS gf180mcu_as_sc_mcu7t3v3__fillcap_16
XFILLER_16_1103 VDD VDD VSS VSS gf180mcu_as_sc_mcu7t3v3__fillcap_16
XFILLER_210_951 VDD VDD VSS VSS gf180mcu_as_sc_mcu7t3v3__fill_1
XFILLER_21_382 VDD VDD VSS VSS gf180mcu_as_sc_mcu7t3v3__fill_2
XFILLER_40_179 VDD VDD VSS VSS gf180mcu_as_sc_mcu7t3v3__fill_1
XTAP_TAPCELL_ROW_112_1_1781 VDD VSS gf180mcu_as_sc_mcu7t3v3__tap_2
XTAP_TAPCELL_ROW_124_3_3093 VDD VSS gf180mcu_as_sc_mcu7t3v3__tap_2
XFILLER_33_1450 VDD VDD VSS VSS gf180mcu_as_sc_mcu7t3v3__fillcap_16
XFILLER_33_1472 VDD VDD VSS VSS gf180mcu_as_sc_mcu7t3v3__fillcap_16
XFILLER_120_1453 VDD VDD VSS VSS gf180mcu_as_sc_mcu7t3v3__fillcap_16
XFILLER_147_43 VDD VDD VSS VSS gf180mcu_as_sc_mcu7t3v3__fillcap_4
XFILLER_193_195 VDD VDD VSS VSS gf180mcu_as_sc_mcu7t3v3__fill_2
XFILLER_194_1543 VDD VDD VSS VSS gf180mcu_as_sc_mcu7t3v3__fill_1
XFILLER_68_1568 VDD VDD VSS VSS gf180mcu_as_sc_mcu7t3v3__fill_1
XTAP_TAPCELL_ROW_17_1108 VDD VSS gf180mcu_as_sc_mcu7t3v3__tap_2
Xinput110 VDD VDD VSS VSS ne_in[8] _3997_/A gf180mcu_as_sc_mcu7t3v3__buff_12
XFILLER_7_1348 VDD VDD VSS VSS gf180mcu_as_sc_mcu7t3v3__fillcap_16
Xinput121 VDD VDD VSS VSS north_in[18] _4079_/A gf180mcu_as_sc_mcu7t3v3__buff_12
Xinput132 VDD VDD VSS VSS north_in[28] _4160_/D gf180mcu_as_sc_mcu7t3v3__buff_12
Xinput143 VDD VDD VSS VSS north_in[7] _3990_/A gf180mcu_as_sc_mcu7t3v3__buff_12
Xinput154 VDD VDD VSS VSS nw_in[17] _4070_/A gf180mcu_as_sc_mcu7t3v3__buff_12
XTAP_TAPCELL_ROW_34_1488 VDD VSS gf180mcu_as_sc_mcu7t3v3__tap_2
XTAP_TAPCELL_ROW_34_1477 VDD VSS gf180mcu_as_sc_mcu7t3v3__tap_2
Xinput165 VDD VDD VSS VSS nw_in[27] _4154_/A gf180mcu_as_sc_mcu7t3v3__buff_12
Xinput176 VDD VDD VSS VSS nw_in[6] _3984_/A gf180mcu_as_sc_mcu7t3v3__buff_12
Xinput187 VDD VDD VSS VSS se_in[15] wire878/A gf180mcu_as_sc_mcu7t3v3__buff_12
XTAP_TAPCELL_ROW_180_2142 VDD VSS gf180mcu_as_sc_mcu7t3v3__tap_2
XTAP_TAPCELL_ROW_180_2131 VDD VSS gf180mcu_as_sc_mcu7t3v3__tap_2
Xinput198 VDD VDD VSS VSS se_in[25] _4139_/A gf180mcu_as_sc_mcu7t3v3__buff_12
XFILLER_17_644 VDD VDD VSS VSS gf180mcu_as_sc_mcu7t3v3__fill_2
XFILLER_205_734 VDD VDD VSS VSS gf180mcu_as_sc_mcu7t3v3__fillcap_16
XFILLER_164_1380 VDD VDD VSS VSS gf180mcu_as_sc_mcu7t3v3__fill_1
XFILLER_176_107 VDD VDD VSS VSS gf180mcu_as_sc_mcu7t3v3__fillcap_8
XFILLER_38_1372 VDD VDD VSS VSS gf180mcu_as_sc_mcu7t3v3__fillcap_8
XFILLER_38_1383 VDD VDD VSS VSS gf180mcu_as_sc_mcu7t3v3__fillcap_8
XTAP_TAPCELL_ROW_178_2093 VDD VSS gf180mcu_as_sc_mcu7t3v3__tap_2
XTAP_TAPCELL_ROW_178_2082 VDD VSS gf180mcu_as_sc_mcu7t3v3__tap_2
XFILLER_125_1364 VDD VDD VSS VSS gf180mcu_as_sc_mcu7t3v3__fillcap_8
XFILLER_12_371 VDD VDD VSS VSS gf180mcu_as_sc_mcu7t3v3__fillcap_8
X_2670_ VDD VDD VSS VSS _5197_/Q _2858_/B _2674_/C _2670_/D _2672_/C gf180mcu_as_sc_mcu7t3v3__ao211_2
XTAP_TAPCELL_ROW_170_3_3230 VDD VSS gf180mcu_as_sc_mcu7t3v3__tap_2
XFILLER_12_1523 VDD VDD VSS VSS gf180mcu_as_sc_mcu7t3v3__fill_1
XFILLER_184_173 VDD VDD VSS VSS gf180mcu_as_sc_mcu7t3v3__fill_2
X_4340_ VDD VDD VSS VSS _4536_/S _5089_/Q _5002_/Q _4342_/B gf180mcu_as_sc_mcu7t3v3__mux2_2
XFILLER_140_221 VDD VDD VSS VSS gf180mcu_as_sc_mcu7t3v3__fill_1
X_4271_ VDD VDD VSS VSS _4272_/S _5483_/A _5105_/Q _5105_/D gf180mcu_as_sc_mcu7t3v3__mux2_2
XFILLER_45_1354 VDD VDD VSS VSS gf180mcu_as_sc_mcu7t3v3__fill_1
XTAP_TAPCELL_ROW_150_3_3172 VDD VSS gf180mcu_as_sc_mcu7t3v3__tap_2
X_3222_ VDD VDD VSS VSS _3222_/D _3253_/A _3787_/A _3544_/C _3223_/D gf180mcu_as_sc_mcu7t3v3__ao31_2
XFILLER_100_118 VDD VDD VSS VSS gf180mcu_as_sc_mcu7t3v3__fillcap_4
X_3153_ VDD VDD VSS VSS _3178_/A _3153_/B _3153_/C _3178_/D _3155_/C gf180mcu_as_sc_mcu7t3v3__ao211_2
XFILLER_45_1398 VDD VDD VSS VSS gf180mcu_as_sc_mcu7t3v3__fillcap_16
XFILLER_27_419 VDD VDD VSS VSS gf180mcu_as_sc_mcu7t3v3__fill_1
XFILLER_36_920 VDD VDD VSS VSS gf180mcu_as_sc_mcu7t3v3__fillcap_8
X_3084_ VDD VDD VSS VSS _4061_/A _3233_/B _3169_/C _4062_/A _3085_/C gf180mcu_as_sc_mcu7t3v3__ao22_2
XTAP_TAPCELL_ROW_117_1_1796 VDD VSS gf180mcu_as_sc_mcu7t3v3__tap_2
XFILLER_23_614 VDD VDD VSS VSS gf180mcu_as_sc_mcu7t3v3__fillcap_16
XFILLER_35_463 VDD VDD VSS VSS gf180mcu_as_sc_mcu7t3v3__fillcap_8
XFILLER_22_102 VDD VDD VSS VSS gf180mcu_as_sc_mcu7t3v3__fill_2
XFILLER_23_636 VDD VDD VSS VSS gf180mcu_as_sc_mcu7t3v3__fill_2
XFILLER_195_438 VDD VDD VSS VSS gf180mcu_as_sc_mcu7t3v3__fillcap_16
X_3986_ VDD VDD VSS VSS _4106_/S _3986_/B _3986_/A _3987_/B gf180mcu_as_sc_mcu7t3v3__mux2_2
XFILLER_104_1415 VDD VDD VSS VSS gf180mcu_as_sc_mcu7t3v3__fillcap_16
XFILLER_143_1453 VDD VDD VSS VSS gf180mcu_as_sc_mcu7t3v3__fillcap_4
XFILLER_17_1467 VDD VDD VSS VSS gf180mcu_as_sc_mcu7t3v3__fill_2
X_2937_ VDD VDD VSS VSS _2947_/B _3281_/B _3559_/A gf180mcu_as_sc_mcu7t3v3__nand2_2
XFILLER_176_652 VDD VDD VSS VSS gf180mcu_as_sc_mcu7t3v3__fill_1
XFILLER_202_1049 VDD VDD VSS VSS gf180mcu_as_sc_mcu7t3v3__fillcap_16
X_4607_ VDD VDD VSS VSS _5201_/Q _4622_/B _4622_/C _5202_/Q _5201_/D gf180mcu_as_sc_mcu7t3v3__ao22_2
X_2868_ VDD VDD VSS VSS _2868_/B _4765_/Q _2869_/C gf180mcu_as_sc_mcu7t3v3__xnor2_2
XFILLER_11_1033 VDD VDD VSS VSS gf180mcu_as_sc_mcu7t3v3__fillcap_4
XFILLER_11_1044 VDD VDD VSS VSS gf180mcu_as_sc_mcu7t3v3__fillcap_4
X_2799_ VDD VDD VSS VSS _4683_/B _4626_/B _2799_/C _4655_/B _2800_/B gf180mcu_as_sc_mcu7t3v3__ao211_2
XFILLER_176_1251 VDD VDD VSS VSS gf180mcu_as_sc_mcu7t3v3__fill_1
X_4538_ VDD VDD VSS VSS _4538_/A _4538_/B _4538_/C _4539_/D _4538_/D gf180mcu_as_sc_mcu7t3v3__aoi211_2
Xfanout800 VDD VDD VSS VSS _5094_/Q _4585_/A gf180mcu_as_sc_mcu7t3v3__buff_12
X_4469_ VDD VDD VSS VSS _5174_/Q _4504_/B _4469_/C _4469_/D _5174_/D gf180mcu_as_sc_mcu7t3v3__ao211_2
Xfanout811 VDD VDD VSS VSS _2826_/S _4975_/D gf180mcu_as_sc_mcu7t3v3__buff_12
Xfanout822 VDD VDD VSS VSS _3624_/A _3525_/A gf180mcu_as_sc_mcu7t3v3__buff_12
XFILLER_150_1402 VDD VDD VSS VSS gf180mcu_as_sc_mcu7t3v3__fill_1
XTAP_TAPCELL_ROW_6_868 VDD VSS gf180mcu_as_sc_mcu7t3v3__tap_2
XTAP_TAPCELL_ROW_6_857 VDD VSS gf180mcu_as_sc_mcu7t3v3__tap_2
XFILLER_115_1555 VDD VDD VSS VSS gf180mcu_as_sc_mcu7t3v3__fill_1
XFILLER_115_1566 VDD VDD VSS VSS gf180mcu_as_sc_mcu7t3v3__fill_2
XFILLER_150_1446 VDD VDD VSS VSS gf180mcu_as_sc_mcu7t3v3__fillcap_4
XFILLER_19_909 VDD VDD VSS VSS gf180mcu_as_sc_mcu7t3v3__fill_1
XTAP_TAPCELL_ROW_12_1005 VDD VSS gf180mcu_as_sc_mcu7t3v3__tap_2
Xfanout888 VDD VDD VSS VSS _3661_/D _3615_/D gf180mcu_as_sc_mcu7t3v3__buff_12
XFILLER_133_67 VDD VDD VSS VSS gf180mcu_as_sc_mcu7t3v3__fill_2
XFILLER_6_1381 VDD VDD VSS VSS gf180mcu_as_sc_mcu7t3v3__fill_1
XFILLER_98_1539 VDD VDD VSS VSS gf180mcu_as_sc_mcu7t3v3__fillcap_4
XTAP_TAPCELL_ROW_163_1_1933 VDD VSS gf180mcu_as_sc_mcu7t3v3__tap_2
XFILLER_26_452 VDD VDD VSS VSS gf180mcu_as_sc_mcu7t3v3__fill_2
XFILLER_60_219 VDD VDD VSS VSS gf180mcu_as_sc_mcu7t3v3__fill_2
XFILLER_187_906 VDD VDD VSS VSS gf180mcu_as_sc_mcu7t3v3__fillcap_4
XFILLER_199_766 VDD VDD VSS VSS gf180mcu_as_sc_mcu7t3v3__fillcap_4
XFILLER_202_715 VDD VDD VSS VSS gf180mcu_as_sc_mcu7t3v3__fillcap_16
XFILLER_26_98 VDD VDD VSS VSS gf180mcu_as_sc_mcu7t3v3__fillcap_4
XFILLER_158_107 VDD VDD VSS VSS gf180mcu_as_sc_mcu7t3v3__fillcap_16
XFILLER_187_928 VDD VDD VSS VSS gf180mcu_as_sc_mcu7t3v3__fillcap_16
XFILLER_199_788 VDD VDD VSS VSS gf180mcu_as_sc_mcu7t3v3__fillcap_16
XFILLER_202_737 VDD VDD VSS VSS gf180mcu_as_sc_mcu7t3v3__fillcap_16
XFILLER_74_1550 VDD VDD VSS VSS gf180mcu_as_sc_mcu7t3v3__fillcap_16
XFILLER_158_53 VDD VDD VSS VSS gf180mcu_as_sc_mcu7t3v3__fillcap_8
XFILLER_6_802 VDD VDD VSS VSS gf180mcu_as_sc_mcu7t3v3__fill_2
XTAP_TAPCELL_ROW_143_1_1875 VDD VSS gf180mcu_as_sc_mcu7t3v3__tap_2
XTAP_TAPCELL_ROW_155_3_3187 VDD VSS gf180mcu_as_sc_mcu7t3v3__tap_2
XFILLER_5_367 VDD VDD VSS VSS gf180mcu_as_sc_mcu7t3v3__fill_2
XFILLER_122_210 VDD VDD VSS VSS gf180mcu_as_sc_mcu7t3v3__fillcap_8
XFILLER_174_52 VDD VDD VSS VSS gf180mcu_as_sc_mcu7t3v3__fillcap_16
XFILLER_29_1349 VDD VDD VSS VSS gf180mcu_as_sc_mcu7t3v3__fill_2
XTAP_TAPCELL_ROW_36_1539 VDD VSS gf180mcu_as_sc_mcu7t3v3__tap_2
XTAP_TAPCELL_ROW_36_1528 VDD VSS gf180mcu_as_sc_mcu7t3v3__tap_2
XTAP_TAPCELL_ROW_36_1517 VDD VSS gf180mcu_as_sc_mcu7t3v3__tap_2
XFILLER_155_1379 VDD VDD VSS VSS gf180mcu_as_sc_mcu7t3v3__fillcap_4
XFILLER_190_1259 VDD VDD VSS VSS gf180mcu_as_sc_mcu7t3v3__fillcap_16
XFILLER_1_562 VDD VDD VSS VSS gf180mcu_as_sc_mcu7t3v3__fillcap_16
XFILLER_107_90 VDD VDD VSS VSS gf180mcu_as_sc_mcu7t3v3__fill_1
XFILLER_42_1516 VDD VDD VSS VSS gf180mcu_as_sc_mcu7t3v3__fillcap_4
XFILLER_95_138 VDD VDD VSS VSS gf180mcu_as_sc_mcu7t3v3__fill_2
XFILLER_67_72 VDD VDD VSS VSS gf180mcu_as_sc_mcu7t3v3__fillcap_16
XFILLER_131_1390 VDD VDD VSS VSS gf180mcu_as_sc_mcu7t3v3__fillcap_16
XFILLER_17_430 VDD VDD VSS VSS gf180mcu_as_sc_mcu7t3v3__fill_1
XFILLER_18_975 VDD VDD VSS VSS gf180mcu_as_sc_mcu7t3v3__fillcap_8
XFILLER_33_912 VDD VDD VSS VSS gf180mcu_as_sc_mcu7t3v3__fillcap_16
XFILLER_51_208 VDD VDD VSS VSS gf180mcu_as_sc_mcu7t3v3__fill_2
XFILLER_79_1483 VDD VDD VSS VSS gf180mcu_as_sc_mcu7t3v3__fill_2
XFILLER_83_60 VDD VDD VSS VSS gf180mcu_as_sc_mcu7t3v3__fillcap_8
XTAP_TAPCELL_ROW_205_2690 VDD VSS gf180mcu_as_sc_mcu7t3v3__tap_2
XFILLER_127_1415 VDD VDD VSS VSS gf180mcu_as_sc_mcu7t3v3__fill_1
XFILLER_36_1309 VDD VDD VSS VSS gf180mcu_as_sc_mcu7t3v3__fillcap_16
XFILLER_166_1497 VDD VDD VSS VSS gf180mcu_as_sc_mcu7t3v3__fillcap_8
XFILLER_207_1450 VDD VDD VSS VSS gf180mcu_as_sc_mcu7t3v3__fillcap_16
XFILLER_33_967 VDD VDD VSS VSS gf180mcu_as_sc_mcu7t3v3__fill_1
X_3840_ VDD VDD VSS VSS _4912_/Q _3845_/A _3843_/B _3844_/A gf180mcu_as_sc_mcu7t3v3__nand3_2
XTAP_TAPCELL_ROW_201_2598 VDD VSS gf180mcu_as_sc_mcu7t3v3__tap_2
XTAP_TAPCELL_ROW_201_2587 VDD VSS gf180mcu_as_sc_mcu7t3v3__tap_2
XFILLER_13_680 VDD VDD VSS VSS gf180mcu_as_sc_mcu7t3v3__fillcap_16
XFILLER_207_1472 VDD VDD VSS VSS gf180mcu_as_sc_mcu7t3v3__fillcap_16
XFILLER_80_4 VDD VDD VSS VSS gf180mcu_as_sc_mcu7t3v3__fill_1
X_3771_ VDD VDD VSS VSS _4153_/A _3779_/B _3771_/C _3771_/D _3773_/C gf180mcu_as_sc_mcu7t3v3__ao211_2
XFILLER_199_1240 VDD VDD VSS VSS gf180mcu_as_sc_mcu7t3v3__fillcap_16
XFILLER_34_1044 VDD VDD VSS VSS gf180mcu_as_sc_mcu7t3v3__fillcap_16
X_2722_ VDD VDD VSS VSS _2723_/D _2729_/C _2722_/B _2722_/A gf180mcu_as_sc_mcu7t3v3__aoi21b_2
XFILLER_12_1331 VDD VDD VSS VSS gf180mcu_as_sc_mcu7t3v3__fill_1
XFILLER_199_1262 VDD VDD VSS VSS gf180mcu_as_sc_mcu7t3v3__fillcap_16
X_2653_ VDD VDD VSS VSS _2831_/A _2653_/B _5265_/Q _2656_/B gf180mcu_as_sc_mcu7t3v3__mux2_2
Xoutput425 VDD VDD VSS VSS _4813_/Q south_out[8] gf180mcu_as_sc_mcu7t3v3__buff_12
Xoutput414 VDD VDD VSS VSS _4834_/Q south_out[29] gf180mcu_as_sc_mcu7t3v3__buff_12
Xoutput403 VDD VDD VSS VSS _4824_/Q south_out[19] gf180mcu_as_sc_mcu7t3v3__buff_12
X_2584_ VDD VDD VSS VSS _2584_/B _4952_/D _2584_/Y gf180mcu_as_sc_mcu7t3v3__or2_2
XFILLER_138_1555 VDD VDD VSS VSS gf180mcu_as_sc_mcu7t3v3__fillcap_8
Xoutput458 VDD VDD VSS VSS _4880_/Q west_out[7] gf180mcu_as_sc_mcu7t3v3__buff_12
Xoutput447 VDD VDD VSS VSS _4901_/Q west_out[28] gf180mcu_as_sc_mcu7t3v3__buff_12
Xoutput436 VDD VDD VSS VSS _4891_/Q west_out[18] gf180mcu_as_sc_mcu7t3v3__buff_12
X_4323_ VDD VDD VSS VSS _4324_/S _5153_/Q _5152_/Q _5152_/D gf180mcu_as_sc_mcu7t3v3__mux2_2
X_4254_ VDD VDD VSS VSS _4255_/S _4254_/B _5090_/Q _5090_/D gf180mcu_as_sc_mcu7t3v3__mux2_2
XTAP_TAPCELL_ROW_168_1_1948 VDD VSS gf180mcu_as_sc_mcu7t3v3__tap_2
X_4185_ VDD VDD VSS VSS _4245_/B _4197_/B _4197_/C _5023_/Q _5023_/D gf180mcu_as_sc_mcu7t3v3__ao22_2
X_3205_ VDD VDD VSS VSS _3213_/A _3205_/B _3228_/A _3206_/D gf180mcu_as_sc_mcu7t3v3__nand3_2
XTAP_TAPCELL_ROW_3_805 VDD VSS gf180mcu_as_sc_mcu7t3v3__tap_2
XFILLER_94_171 VDD VDD VSS VSS gf180mcu_as_sc_mcu7t3v3__fillcap_4
X_3136_ VDD VDD VSS VSS _3145_/A _3136_/B _3136_/C _3145_/D _3138_/C gf180mcu_as_sc_mcu7t3v3__ao211_2
XFILLER_209_892 VDD VDD VSS VSS gf180mcu_as_sc_mcu7t3v3__fillcap_16
XFILLER_27_238 VDD VDD VSS VSS gf180mcu_as_sc_mcu7t3v3__fillcap_16
XPHY_EDGE_ROW_145_1_Left_355 VDD VSS gf180mcu_as_sc_mcu7t3v3__tap_2
X_3067_ VDD VDD VSS VSS _3126_/S _4046_/A _4046_/D _3069_/B gf180mcu_as_sc_mcu7t3v3__mux2_2
XFILLER_110_1474 VDD VDD VSS VSS gf180mcu_as_sc_mcu7t3v3__fillcap_16
XFILLER_36_750 VDD VDD VSS VSS gf180mcu_as_sc_mcu7t3v3__fillcap_4
XFILLER_58_1523 VDD VDD VSS VSS gf180mcu_as_sc_mcu7t3v3__fillcap_16
XPHY_EDGE_ROW_209_Right_72 VDD VSS gf180mcu_as_sc_mcu7t3v3__tap_2
XFILLER_145_1504 VDD VDD VSS VSS gf180mcu_as_sc_mcu7t3v3__fill_2
XFILLER_19_1518 VDD VDD VSS VSS gf180mcu_as_sc_mcu7t3v3__fillcap_4
XFILLER_23_400 VDD VDD VSS VSS gf180mcu_as_sc_mcu7t3v3__fillcap_16
XFILLER_23_422 VDD VDD VSS VSS gf180mcu_as_sc_mcu7t3v3__fillcap_16
XFILLER_35_282 VDD VDD VSS VSS gf180mcu_as_sc_mcu7t3v3__fillcap_16
XFILLER_24_967 VDD VDD VSS VSS gf180mcu_as_sc_mcu7t3v3__fill_2
XFILLER_184_909 VDD VDD VSS VSS gf180mcu_as_sc_mcu7t3v3__fillcap_16
XFILLER_196_769 VDD VDD VSS VSS gf180mcu_as_sc_mcu7t3v3__fillcap_16
XFILLER_195_268 VDD VDD VSS VSS gf180mcu_as_sc_mcu7t3v3__fillcap_8
Xwire508 VDD VDD VSS VSS wire509/Y _4773_/D gf180mcu_as_sc_mcu7t3v3__clkbuff_12
X_3969_ VDD VDD VSS VSS _3969_/A _4033_/B _3969_/C _3969_/D _3970_/B gf180mcu_as_sc_mcu7t3v3__ao211_2
XFILLER_13_1128 VDD VDD VSS VSS gf180mcu_as_sc_mcu7t3v3__fill_1
XFILLER_30_1420 VDD VDD VSS VSS gf180mcu_as_sc_mcu7t3v3__fillcap_4
XFILLER_128_34 VDD VDD VSS VSS gf180mcu_as_sc_mcu7t3v3__fill_1
XFILLER_191_430 VDD VDD VSS VSS gf180mcu_as_sc_mcu7t3v3__fillcap_4
XFILLER_176_1081 VDD VDD VSS VSS gf180mcu_as_sc_mcu7t3v3__fillcap_4
XFILLER_191_1524 VDD VDD VSS VSS gf180mcu_as_sc_mcu7t3v3__fillcap_16
XFILLER_28_1360 VDD VDD VSS VSS gf180mcu_as_sc_mcu7t3v3__fillcap_4
XFILLER_8_1432 VDD VDD VSS VSS gf180mcu_as_sc_mcu7t3v3__fill_2
Xfanout630 VDD VDD VSS VSS _3923_/Y _4104_/C gf180mcu_as_sc_mcu7t3v3__buff_12
Xfanout641 VDD VDD VSS VSS _3562_/Y _3781_/S gf180mcu_as_sc_mcu7t3v3__buff_12
XFILLER_19_706 VDD VDD VSS VSS gf180mcu_as_sc_mcu7t3v3__fill_2
XFILLER_24_1224 VDD VDD VSS VSS gf180mcu_as_sc_mcu7t3v3__fill_1
Xfanout652 VDD VDD VSS VSS _3130_/B _3079_/B gf180mcu_as_sc_mcu7t3v3__buff_12
Xfanout663 VDD VDD VSS VSS _4314_/S _4326_/S gf180mcu_as_sc_mcu7t3v3__buff_12
Xfanout674 VDD VDD VSS VSS _4629_/B _4624_/B gf180mcu_as_sc_mcu7t3v3__buff_12
Xfanout685 VDD VDD VSS VSS _3272_/Y _3449_/B gf180mcu_as_sc_mcu7t3v3__buff_12
XTAP_TAPCELL_ROW_31_1414 VDD VSS gf180mcu_as_sc_mcu7t3v3__tap_2
XTAP_TAPCELL_ROW_31_1403 VDD VSS gf180mcu_as_sc_mcu7t3v3__tap_2
XPHY_EDGE_ROW_77_1_Left_287 VDD VSS gf180mcu_as_sc_mcu7t3v3__tap_2
Xfanout696 VDD VDD VSS VSS _4152_/C _4129_/C gf180mcu_as_sc_mcu7t3v3__buff_12
XFILLER_206_317 VDD VDD VSS VSS gf180mcu_as_sc_mcu7t3v3__fillcap_16
XPHY_EDGE_ROW_37_1_Right_695 VDD VSS gf180mcu_as_sc_mcu7t3v3__tap_2
XFILLER_15_912 VDD VDD VSS VSS gf180mcu_as_sc_mcu7t3v3__fillcap_16
XFILLER_27_772 VDD VDD VSS VSS gf180mcu_as_sc_mcu7t3v3__fillcap_16
XFILLER_26_271 VDD VDD VSS VSS gf180mcu_as_sc_mcu7t3v3__fillcap_4
XFILLER_183_1052 VDD VDD VSS VSS gf180mcu_as_sc_mcu7t3v3__fillcap_16
XFILLER_18_1017 VDD VDD VSS VSS gf180mcu_as_sc_mcu7t3v3__fillcap_16
XTAP_TAPCELL_ROW_29_1376 VDD VSS gf180mcu_as_sc_mcu7t3v3__tap_2
XTAP_TAPCELL_ROW_29_1365 VDD VSS gf180mcu_as_sc_mcu7t3v3__tap_2
XFILLER_175_909 VDD VDD VSS VSS gf180mcu_as_sc_mcu7t3v3__fill_1
XFILLER_30_937 VDD VDD VSS VSS gf180mcu_as_sc_mcu7t3v3__fillcap_8
XFILLER_74_1380 VDD VDD VSS VSS gf180mcu_as_sc_mcu7t3v3__fill_1
XTAP_TAPCELL_ROW_175_2030 VDD VSS gf180mcu_as_sc_mcu7t3v3__tap_2
XFILLER_5_120 VDD VDD VSS VSS gf180mcu_as_sc_mcu7t3v3__fill_2
Xmax_cap819 VDD VDD VSS VSS _4099_/A _3723_/A gf180mcu_as_sc_mcu7t3v3__clkbuff_12
XFILLER_5_142 VDD VDD VSS VSS gf180mcu_as_sc_mcu7t3v3__fillcap_8
XPHY_EDGE_ROW_37_1_Left_421 VDD VSS gf180mcu_as_sc_mcu7t3v3__tap_2
XFILLER_29_1124 VDD VDD VSS VSS gf180mcu_as_sc_mcu7t3v3__fill_1
XFILLER_78_93 VDD VDD VSS VSS gf180mcu_as_sc_mcu7t3v3__fillcap_8
XPHY_EDGE_ROW_42_3_Left_427 VDD VSS gf180mcu_as_sc_mcu7t3v3__tap_2
XPHY_EDGE_ROW_167_3_Left_552 VDD VSS gf180mcu_as_sc_mcu7t3v3__tap_2
XTAP_TAPCELL_ROW_207_2730 VDD VSS gf180mcu_as_sc_mcu7t3v3__tap_2
XFILLER_133_1496 VDD VDD VSS VSS gf180mcu_as_sc_mcu7t3v3__fill_2
XFILLER_204_69 VDD VDD VSS VSS gf180mcu_as_sc_mcu7t3v3__fillcap_16
XFILLER_76_171 VDD VDD VSS VSS gf180mcu_as_sc_mcu7t3v3__fillcap_4
XFILLER_76_193 VDD VDD VSS VSS gf180mcu_as_sc_mcu7t3v3__fillcap_16
XFILLER_94_81 VDD VDD VSS VSS gf180mcu_as_sc_mcu7t3v3__fill_2
Xmesh_tile_1051 VDD VDD VSS VSS sw_out[24] gf180mcu_as_sc_mcu7t3v3__tiel_4
Xmesh_tile_1040 VDD VDD VSS VSS sw_out[13] gf180mcu_as_sc_mcu7t3v3__tiel_4
XTAP_TAPCELL_ROW_38_1_1559 VDD VSS gf180mcu_as_sc_mcu7t3v3__tap_2
XTAP_TAPCELL_ROW_203_2649 VDD VSS gf180mcu_as_sc_mcu7t3v3__tap_2
XTAP_TAPCELL_ROW_203_2638 VDD VSS gf180mcu_as_sc_mcu7t3v3__tap_2
XTAP_TAPCELL_ROW_199_2542 VDD VSS gf180mcu_as_sc_mcu7t3v3__tap_2
XFILLER_17_282 VDD VDD VSS VSS gf180mcu_as_sc_mcu7t3v3__fillcap_16
X_4941_ VDD VDD VSS VSS _5278_/CLK _4941_/D _4941_/Q gf180mcu_as_sc_mcu7t3v3__dfxtp_2
XTAP_TAPCELL_ROW_199_2553 VDD VSS gf180mcu_as_sc_mcu7t3v3__tap_2
XFILLER_21_904 VDD VDD VSS VSS gf180mcu_as_sc_mcu7t3v3__fillcap_4
XFILLER_36_1106 VDD VDD VSS VSS gf180mcu_as_sc_mcu7t3v3__fill_1
X_4872_ VDD VDD VSS VSS _5220_/CLK _4872_/D _4872_/Q gf180mcu_as_sc_mcu7t3v3__dfxtp_2
XFILLER_177_235 VDD VDD VSS VSS gf180mcu_as_sc_mcu7t3v3__fill_1
XFILLER_32_274 VDD VDD VSS VSS gf180mcu_as_sc_mcu7t3v3__fillcap_16
X_3823_ VDD VDD VSS VSS _3826_/B _4199_/A _3824_/C gf180mcu_as_sc_mcu7t3v3__or2_2
XFILLER_203_1100 VDD VDD VSS VSS gf180mcu_as_sc_mcu7t3v3__fillcap_16
XFILLER_203_1122 VDD VDD VSS VSS gf180mcu_as_sc_mcu7t3v3__fillcap_16
XFILLER_53_1464 VDD VDD VSS VSS gf180mcu_as_sc_mcu7t3v3__fill_1
XFILLER_14_1437 VDD VDD VSS VSS gf180mcu_as_sc_mcu7t3v3__fill_2
XFILLER_174_920 VDD VDD VSS VSS gf180mcu_as_sc_mcu7t3v3__fillcap_16
XFILLER_9_470 VDD VDD VSS VSS gf180mcu_as_sc_mcu7t3v3__fillcap_16
XPHY_EDGE_ROW_170_3_Right_207 VDD VSS gf180mcu_as_sc_mcu7t3v3__tap_2
X_3754_ VDD VDD VSS VSS _4940_/Q _3799_/B _3770_/C _4137_/A _3756_/C gf180mcu_as_sc_mcu7t3v3__ao22_2
XFILLER_101_1418 VDD VDD VSS VSS gf180mcu_as_sc_mcu7t3v3__fillcap_16
XFILLER_9_492 VDD VDD VSS VSS gf180mcu_as_sc_mcu7t3v3__fillcap_16
X_3685_ VDD VDD VSS VSS _4063_/A _3749_/B _3740_/C _4061_/A _3686_/C gf180mcu_as_sc_mcu7t3v3__ao22_2
X_2705_ VDD VDD VSS VSS _5160_/Q _4267_/S _4279_/S _5184_/Q _2706_/B gf180mcu_as_sc_mcu7t3v3__ao22_2
X_2636_ VDD VDD VSS VSS _2831_/A _2636_/B _2636_/A _2637_/A gf180mcu_as_sc_mcu7t3v3__mux2_2
XFILLER_145_198 VDD VDD VSS VSS gf180mcu_as_sc_mcu7t3v3__fillcap_8
XTAP_TAPCELL_ROW_8_908 VDD VSS gf180mcu_as_sc_mcu7t3v3__tap_2
X_2567_ VDD VDD VSS VSS _2673_/B _4748_/A _5278_/Q gf180mcu_as_sc_mcu7t3v3__nand2_2
X_4306_ VDD VDD VSS VSS _4308_/S _5136_/Q _5135_/Q _5135_/D gf180mcu_as_sc_mcu7t3v3__mux2_2
X_2498_ VDD VDD VSS VSS _2747_/A _2795_/A _2525_/A gf180mcu_as_sc_mcu7t3v3__and2_2
XPHY_EDGE_ROW_99_3_Left_484 VDD VSS gf180mcu_as_sc_mcu7t3v3__tap_2
X_4237_ VDD VDD VSS VSS _4253_/S _4237_/B _5073_/Q _5073_/D gf180mcu_as_sc_mcu7t3v3__mux2_2
XFILLER_210_1115 VDD VDD VSS VSS gf180mcu_as_sc_mcu7t3v3__fill_2
XFILLER_95_1509 VDD VDD VSS VSS gf180mcu_as_sc_mcu7t3v3__fill_1
X_4168_ VDD VDD VSS VSS _4168_/Y _4199_/A _4193_/B _4168_/A gf180mcu_as_sc_mcu7t3v3__aoi21b_2
XFILLER_16_709 VDD VDD VSS VSS gf180mcu_as_sc_mcu7t3v3__fill_1
X_4099_ VDD VDD VSS VSS _4099_/A _4141_/B _4099_/C _4249_/B _4124_/D gf180mcu_as_sc_mcu7t3v3__aoi211_2
X_3119_ VDD VDD VSS VSS _4095_/A _3233_/B _3169_/C _4096_/D _3120_/C gf180mcu_as_sc_mcu7t3v3__ao22_2
XTAP_TAPCELL_ROW_96_3_3008 VDD VSS gf180mcu_as_sc_mcu7t3v3__tap_2
XFILLER_36_580 VDD VDD VSS VSS gf180mcu_as_sc_mcu7t3v3__fillcap_16
XFILLER_184_1361 VDD VDD VSS VSS gf180mcu_as_sc_mcu7t3v3__fillcap_4
XFILLER_184_1383 VDD VDD VSS VSS gf180mcu_as_sc_mcu7t3v3__fill_2
XFILLER_19_1326 VDD VDD VSS VSS gf180mcu_as_sc_mcu7t3v3__fillcap_4
XFILLER_24_742 VDD VDD VSS VSS gf180mcu_as_sc_mcu7t3v3__fill_1
XFILLER_19_1348 VDD VDD VSS VSS gf180mcu_as_sc_mcu7t3v3__fill_2
XFILLER_71_1520 VDD VDD VSS VSS gf180mcu_as_sc_mcu7t3v3__fillcap_8
XTAP_TAPCELL_ROW_64_1_1638 VDD VSS gf180mcu_as_sc_mcu7t3v3__tap_2
XTAP_TAPCELL_ROW_24_1262 VDD VSS gf180mcu_as_sc_mcu7t3v3__tap_2
XTAP_TAPCELL_ROW_24_1251 VDD VSS gf180mcu_as_sc_mcu7t3v3__tap_2
XFILLER_139_66 VDD VDD VSS VSS gf180mcu_as_sc_mcu7t3v3__fillcap_4
XFILLER_139_88 VDD VDD VSS VSS gf180mcu_as_sc_mcu7t3v3__fillcap_16
XFILLER_99_59 VDD VDD VSS VSS gf180mcu_as_sc_mcu7t3v3__fill_1
XFILLER_191_1310 VDD VDD VSS VSS gf180mcu_as_sc_mcu7t3v3__fillcap_16
XFILLER_191_282 VDD VDD VSS VSS gf180mcu_as_sc_mcu7t3v3__fillcap_8
XFILLER_30_1294 VDD VDD VSS VSS gf180mcu_as_sc_mcu7t3v3__fill_1
XFILLER_155_54 VDD VDD VSS VSS gf180mcu_as_sc_mcu7t3v3__fillcap_16
XFILLER_191_1332 VDD VDD VSS VSS gf180mcu_as_sc_mcu7t3v3__fillcap_8
XFILLER_156_1485 VDD VDD VSS VSS gf180mcu_as_sc_mcu7t3v3__fillcap_8
XFILLER_191_1387 VDD VDD VSS VSS gf180mcu_as_sc_mcu7t3v3__fill_2
XFILLER_48_41 VDD VDD VSS VSS gf180mcu_as_sc_mcu7t3v3__fill_1
Xfanout482 VDD VDD VSS VSS _4199_/Y _4227_/C gf180mcu_as_sc_mcu7t3v3__buff_12
XFILLER_207_626 VDD VDD VSS VSS gf180mcu_as_sc_mcu7t3v3__fillcap_4
XFILLER_24_1087 VDD VDD VSS VSS gf180mcu_as_sc_mcu7t3v3__fillcap_16
XFILLER_48_96 VDD VDD VSS VSS gf180mcu_as_sc_mcu7t3v3__fillcap_8
XFILLER_58_193 VDD VDD VSS VSS gf180mcu_as_sc_mcu7t3v3__fillcap_4
XFILLER_189_1294 VDD VDD VSS VSS gf180mcu_as_sc_mcu7t3v3__fillcap_16
XFILLER_19_569 VDD VDD VSS VSS gf180mcu_as_sc_mcu7t3v3__fillcap_16
XFILLER_207_648 VDD VDD VSS VSS gf180mcu_as_sc_mcu7t3v3__fillcap_16
XFILLER_73_174 VDD VDD VSS VSS gf180mcu_as_sc_mcu7t3v3__fillcap_4
XFILLER_15_742 VDD VDD VSS VSS gf180mcu_as_sc_mcu7t3v3__fill_1
XFILLER_37_1415 VDD VDD VSS VSS gf180mcu_as_sc_mcu7t3v3__fill_1
XFILLER_76_1453 VDD VDD VSS VSS gf180mcu_as_sc_mcu7t3v3__fillcap_16
XFILLER_14_263 VDD VDD VSS VSS gf180mcu_as_sc_mcu7t3v3__fill_2
XFILLER_163_1434 VDD VDD VSS VSS gf180mcu_as_sc_mcu7t3v3__fillcap_16
XFILLER_76_1497 VDD VDD VSS VSS gf180mcu_as_sc_mcu7t3v3__fill_2
XFILLER_204_1431 VDD VDD VSS VSS gf180mcu_as_sc_mcu7t3v3__fillcap_4
XFILLER_30_734 VDD VDD VSS VSS gf180mcu_as_sc_mcu7t3v3__fill_1
XTAP_TAPCELL_ROW_194_2450 VDD VSS gf180mcu_as_sc_mcu7t3v3__tap_2
XFILLER_11_970 VDD VDD VSS VSS gf180mcu_as_sc_mcu7t3v3__fillcap_8
XFILLER_204_1453 VDD VDD VSS VSS gf180mcu_as_sc_mcu7t3v3__fillcap_16
XFILLER_35_1172 VDD VDD VSS VSS gf180mcu_as_sc_mcu7t3v3__fillcap_16
XTAP_TAPCELL_ROW_111_1_1777 VDD VSS gf180mcu_as_sc_mcu7t3v3__tap_2
XTAP_TAPCELL_ROW_190_2347 VDD VSS gf180mcu_as_sc_mcu7t3v3__tap_2
XFILLER_196_1221 VDD VDD VSS VSS gf180mcu_as_sc_mcu7t3v3__fillcap_4
XTAP_TAPCELL_ROW_123_3_3089 VDD VSS gf180mcu_as_sc_mcu7t3v3__tap_2
Xwire850 VDD VDD VSS VSS wire850/A _4096_/A gf180mcu_as_sc_mcu7t3v3__clkbuff_12
XTAP_TAPCELL_ROW_190_2358 VDD VSS gf180mcu_as_sc_mcu7t3v3__tap_2
XFILLER_183_772 VDD VDD VSS VSS gf180mcu_as_sc_mcu7t3v3__fillcap_16
XFILLER_196_1243 VDD VDD VSS VSS gf180mcu_as_sc_mcu7t3v3__fillcap_16
Xwire872 VDD VDD VSS VSS wire872/A _3952_/A gf180mcu_as_sc_mcu7t3v3__clkbuff_12
Xwire883 VDD VDD VSS VSS wire883/A _3934_/A gf180mcu_as_sc_mcu7t3v3__clkbuff_12
XFILLER_127_187 VDD VDD VSS VSS gf180mcu_as_sc_mcu7t3v3__fill_2
XFILLER_182_282 VDD VDD VSS VSS gf180mcu_as_sc_mcu7t3v3__fillcap_8
X_3470_ VDD VDD VSS VSS _4124_/A _3477_/B _3470_/C _4828_/D _3661_/D gf180mcu_as_sc_mcu7t3v3__aoi211_2
XFILLER_9_1004 VDD VDD VSS VSS gf180mcu_as_sc_mcu7t3v3__fillcap_16
X_2421_ VDD VDD VSS VSS _2657_/B _2421_/A gf180mcu_as_sc_mcu7t3v3__inv_2
X_5140_ VDD VDD VSS VSS _5142_/CLK _5140_/D _5140_/Q gf180mcu_as_sc_mcu7t3v3__dfxtp_2
XTAP_TAPCELL_ROW_188_2298 VDD VSS gf180mcu_as_sc_mcu7t3v3__tap_2
XFILLER_135_1558 VDD VDD VSS VSS gf180mcu_as_sc_mcu7t3v3__fillcap_8
XFILLER_170_1438 VDD VDD VSS VSS gf180mcu_as_sc_mcu7t3v3__fillcap_8
X_5071_ VDD VDD VSS VSS clkload5/A _5071_/D _5071_/Q gf180mcu_as_sc_mcu7t3v3__dfxtp_2
X_4022_ VDD VDD VSS VSS _4022_/A _4032_/B _4027_/B _4022_/D _4026_/A gf180mcu_as_sc_mcu7t3v3__ao211_2
XFILLER_49_182 VDD VDD VSS VSS gf180mcu_as_sc_mcu7t3v3__fill_2
XFILLER_20_1441 VDD VDD VSS VSS gf180mcu_as_sc_mcu7t3v3__fill_2
XFILLER_64_141 VDD VDD VSS VSS gf180mcu_as_sc_mcu7t3v3__fillcap_8
XFILLER_0_1524 VDD VDD VSS VSS gf180mcu_as_sc_mcu7t3v3__fillcap_4
XFILLER_64_174 VDD VDD VSS VSS gf180mcu_as_sc_mcu7t3v3__fill_1
XFILLER_0_1557 VDD VDD VSS VSS gf180mcu_as_sc_mcu7t3v3__fillcap_4
XFILLER_0_1568 VDD VDD VSS VSS gf180mcu_as_sc_mcu7t3v3__fill_1
XFILLER_197_308 VDD VDD VSS VSS gf180mcu_as_sc_mcu7t3v3__fillcap_16
XFILLER_55_1504 VDD VDD VSS VSS gf180mcu_as_sc_mcu7t3v3__fill_2
Xclkbuf_3_3__f_clk_regs VDD VDD VSS VSS clkbuf_2_1_0_clk_regs/Y clkbuf_3_3__f_clk_regs/Y
+ gf180mcu_as_sc_mcu7t3v3__clkbuff_12
X_4924_ VDD VDD VSS VSS _4924_/CLK _4924_/D _4924_/Q gf180mcu_as_sc_mcu7t3v3__dfxtp_2
XFILLER_178_522 VDD VDD VSS VSS gf180mcu_as_sc_mcu7t3v3__fill_2
XFILLER_181_1534 VDD VDD VSS VSS gf180mcu_as_sc_mcu7t3v3__fillcap_4
XFILLER_209_1364 VDD VDD VSS VSS gf180mcu_as_sc_mcu7t3v3__fillcap_16
XFILLER_90_1417 VDD VDD VSS VSS gf180mcu_as_sc_mcu7t3v3__fillcap_16
XFILLER_20_233 VDD VDD VSS VSS gf180mcu_as_sc_mcu7t3v3__fill_1
XFILLER_33_583 VDD VDD VSS VSS gf180mcu_as_sc_mcu7t3v3__fillcap_16
X_4855_ VDD VDD VSS VSS _5276_/CLK _4855_/D _4855_/Q gf180mcu_as_sc_mcu7t3v3__dfxtp_2
XFILLER_14_1223 VDD VDD VSS VSS gf180mcu_as_sc_mcu7t3v3__fill_2
X_4786_ VDD VDD VSS VSS _4869_/CLK _4786_/D _4786_/Q gf180mcu_as_sc_mcu7t3v3__dfxtp_2
X_3806_ VDD VDD VSS VSS _3846_/B _4913_/Q _3929_/A gf180mcu_as_sc_mcu7t3v3__and2_2
XFILLER_174_750 VDD VDD VSS VSS gf180mcu_as_sc_mcu7t3v3__fill_2
XFILLER_179_1430 VDD VDD VSS VSS gf180mcu_as_sc_mcu7t3v3__fill_2
X_3737_ VDD VDD VSS VSS _3738_/C _3737_/C _3766_/B _4114_/A gf180mcu_as_sc_mcu7t3v3__aoi21_2
XFILLER_118_143 VDD VDD VSS VSS gf180mcu_as_sc_mcu7t3v3__fill_2
XPHY_EDGE_ROW_171_3_Right_208 VDD VSS gf180mcu_as_sc_mcu7t3v3__tap_2
X_3668_ VDD VDD VSS VSS _3691_/D _3730_/A _3668_/B _3668_/C _3669_/C gf180mcu_as_sc_mcu7t3v3__ao31_2
X_3599_ VDD VDD VSS VSS _3966_/A _3652_/B _3599_/C _3608_/B _3600_/C gf180mcu_as_sc_mcu7t3v3__ao211_2
X_2619_ VDD VDD VSS VSS _2620_/D _5257_/Q _2634_/B _2619_/C gf180mcu_as_sc_mcu7t3v3__ao21_2
XFILLER_125_35 VDD VDD VSS VSS gf180mcu_as_sc_mcu7t3v3__fillcap_4
XFILLER_125_68 VDD VDD VSS VSS gf180mcu_as_sc_mcu7t3v3__fill_2
XFILLER_5_1402 VDD VDD VSS VSS gf180mcu_as_sc_mcu7t3v3__fillcap_4
X_5269_ VDD VDD VSS VSS _5276_/CLK _5269_/D _5269_/Q gf180mcu_as_sc_mcu7t3v3__dfxtp_2
XTAP_TAPCELL_ROW_38_3_2834 VDD VSS gf180mcu_as_sc_mcu7t3v3__tap_2
XFILLER_99_1420 VDD VDD VSS VSS gf180mcu_as_sc_mcu7t3v3__fill_1
XFILLER_141_34 VDD VDD VSS VSS gf180mcu_as_sc_mcu7t3v3__fillcap_4
XFILLER_18_77 VDD VDD VSS VSS gf180mcu_as_sc_mcu7t3v3__fillcap_4
XFILLER_112_1399 VDD VDD VSS VSS gf180mcu_as_sc_mcu7t3v3__fill_1
XFILLER_147_1418 VDD VDD VSS VSS gf180mcu_as_sc_mcu7t3v3__fillcap_16
XFILLER_19_1112 VDD VDD VSS VSS gf180mcu_as_sc_mcu7t3v3__fillcap_8
XFILLER_204_629 VDD VDD VSS VSS gf180mcu_as_sc_mcu7t3v3__fillcap_16
XFILLER_3_1192 VDD VDD VSS VSS gf180mcu_as_sc_mcu7t3v3__fillcap_8
XFILLER_180_1011 VDD VDD VSS VSS gf180mcu_as_sc_mcu7t3v3__fillcap_4
XFILLER_197_820 VDD VDD VSS VSS gf180mcu_as_sc_mcu7t3v3__fillcap_16
XFILLER_197_842 VDD VDD VSS VSS gf180mcu_as_sc_mcu7t3v3__fillcap_16
XFILLER_70_155 VDD VDD VSS VSS gf180mcu_as_sc_mcu7t3v3__fillcap_4
XPHY_EDGE_ROW_108_1_Left_318 VDD VSS gf180mcu_as_sc_mcu7t3v3__tap_2
XTAP_TAPCELL_ROW_26_1313 VDD VSS gf180mcu_as_sc_mcu7t3v3__tap_2
XTAP_TAPCELL_ROW_26_1302 VDD VSS gf180mcu_as_sc_mcu7t3v3__tap_2
XFILLER_12_734 VDD VDD VSS VSS gf180mcu_as_sc_mcu7t3v3__fill_1
XFILLER_180_1033 VDD VDD VSS VSS gf180mcu_as_sc_mcu7t3v3__fillcap_16
XFILLER_34_87 VDD VDD VSS VSS gf180mcu_as_sc_mcu7t3v3__fillcap_16
Xsram2048.u_bank0_910 VDD VDD VSS VSS sram2048.u_bank0/WEN[0] gf180mcu_as_sc_mcu7t3v3__tiel_4
XFILLER_11_233 VDD VDD VSS VSS gf180mcu_as_sc_mcu7t3v3__fillcap_16
XTAP_TAPCELL_ROW_83_1_1693 VDD VSS gf180mcu_as_sc_mcu7t3v3__tap_2
XFILLER_11_277 VDD VDD VSS VSS gf180mcu_as_sc_mcu7t3v3__fill_2
XFILLER_184_558 VDD VDD VSS VSS gf180mcu_as_sc_mcu7t3v3__fillcap_16
XFILLER_200_868 VDD VDD VSS VSS gf180mcu_as_sc_mcu7t3v3__fillcap_4
XFILLER_32_1345 VDD VDD VSS VSS gf180mcu_as_sc_mcu7t3v3__fillcap_16
XFILLER_7_226 VDD VDD VSS VSS gf180mcu_as_sc_mcu7t3v3__fillcap_4
XFILLER_109_165 VDD VDD VSS VSS gf180mcu_as_sc_mcu7t3v3__fillcap_8
XFILLER_32_1367 VDD VDD VSS VSS gf180mcu_as_sc_mcu7t3v3__fillcap_16
XTAP_TAPCELL_ROW_10_946 VDD VSS gf180mcu_as_sc_mcu7t3v3__tap_2
XTAP_TAPCELL_ROW_10_957 VDD VSS gf180mcu_as_sc_mcu7t3v3__tap_2
XFILLER_166_53 VDD VDD VSS VSS gf180mcu_as_sc_mcu7t3v3__fillcap_16
XFILLER_192_591 VDD VDD VSS VSS gf180mcu_as_sc_mcu7t3v3__fillcap_4
XFILLER_4_944 VDD VDD VSS VSS gf180mcu_as_sc_mcu7t3v3__fill_1
XTAP_TAPCELL_ROW_93_3_2999 VDD VSS gf180mcu_as_sc_mcu7t3v3__tap_2
XFILLER_124_157 VDD VDD VSS VSS gf180mcu_as_sc_mcu7t3v3__fillcap_16
XFILLER_180_786 VDD VDD VSS VSS gf180mcu_as_sc_mcu7t3v3__fillcap_16
XFILLER_182_30 VDD VDD VSS VSS gf180mcu_as_sc_mcu7t3v3__fillcap_4
XTAP_TAPCELL_ROW_169_1_1953 VDD VSS gf180mcu_as_sc_mcu7t3v3__tap_2
XFILLER_59_95 VDD VDD VSS VSS gf180mcu_as_sc_mcu7t3v3__fill_1
XFILLER_182_85 VDD VDD VSS VSS gf180mcu_as_sc_mcu7t3v3__fillcap_16
XTAP_TAPCELL_ROW_183_2195 VDD VSS gf180mcu_as_sc_mcu7t3v3__tap_2
XFILLER_19_366 VDD VDD VSS VSS gf180mcu_as_sc_mcu7t3v3__fillcap_8
XFILLER_207_412 VDD VDD VSS VSS gf180mcu_as_sc_mcu7t3v3__fillcap_8
XFILLER_43_1496 VDD VDD VSS VSS gf180mcu_as_sc_mcu7t3v3__fillcap_4
XFILLER_75_72 VDD VDD VSS VSS gf180mcu_as_sc_mcu7t3v3__fill_2
XFILLER_34_314 VDD VDD VSS VSS gf180mcu_as_sc_mcu7t3v3__fill_1
XFILLER_46_174 VDD VDD VSS VSS gf180mcu_as_sc_mcu7t3v3__fill_1
X_2970_ VDD VDD VSS VSS _3078_/B _4917_/Q _2971_/D gf180mcu_as_sc_mcu7t3v3__or2_2
XTAP_TAPCELL_ROW_64_3_2913 VDD VSS gf180mcu_as_sc_mcu7t3v3__tap_2
XFILLER_199_190 VDD VDD VSS VSS gf180mcu_as_sc_mcu7t3v3__fillcap_16
X_4640_ VDD VDD VSS VSS _4640_/S _5106_/Q _5231_/Q _5231_/D gf180mcu_as_sc_mcu7t3v3__mux2_2
XFILLER_175_547 VDD VDD VSS VSS gf180mcu_as_sc_mcu7t3v3__fillcap_8
XFILLER_200_1103 VDD VDD VSS VSS gf180mcu_as_sc_mcu7t3v3__fillcap_16
XFILLER_7_760 VDD VDD VSS VSS gf180mcu_as_sc_mcu7t3v3__fillcap_8
X_4571_ VDD VDD VSS VSS _4572_/D _4571_/B _4572_/A gf180mcu_as_sc_mcu7t3v3__nor2_2
XFILLER_102_1568 VDD VDD VSS VSS gf180mcu_as_sc_mcu7t3v3__fill_1
X_3522_ VDD VDD VSS VSS _3522_/A _3522_/B _3522_/C _3523_/C _3522_/D gf180mcu_as_sc_mcu7t3v3__aoi211_2
XPHY_EDGE_ROW_154_1_Left_364 VDD VSS gf180mcu_as_sc_mcu7t3v3__tap_2
X_3453_ VDD VDD VSS VSS _4104_/A _3453_/B _3453_/C _4105_/A _3454_/C gf180mcu_as_sc_mcu7t3v3__ao22_2
X_2404_ VDD VDD VSS VSS _4746_/A _4703_/B gf180mcu_as_sc_mcu7t3v3__inv_2
X_5123_ VDD VDD VSS VSS clkload7/A _5123_/D _5123_/Q gf180mcu_as_sc_mcu7t3v3__dfxtp_2
X_3384_ VDD VDD VSS VSS _3661_/A _3477_/B _3384_/C _4817_/D _3608_/D gf180mcu_as_sc_mcu7t3v3__aoi211_2
XPHY_EDGE_ROW_91_1_Left_301 VDD VSS gf180mcu_as_sc_mcu7t3v3__tap_2
XFILLER_22_1503 VDD VDD VSS VSS gf180mcu_as_sc_mcu7t3v3__fill_2
X_5054_ VDD VDD VSS VSS _5073_/CLK _5054_/D _5054_/Q gf180mcu_as_sc_mcu7t3v3__dfxtp_2
XFILLER_37_130 VDD VDD VSS VSS gf180mcu_as_sc_mcu7t3v3__fillcap_8
X_4889__1078 VDD VDD VSS VSS _4889_/D gf180mcu_as_sc_mcu7t3v3__tiel_4
X_4005_ VDD VDD VSS VSS _4005_/A _4102_/B _4102_/C _4924_/Q _4007_/C gf180mcu_as_sc_mcu7t3v3__ao22_2
XFILLER_25_325 VDD VDD VSS VSS gf180mcu_as_sc_mcu7t3v3__fillcap_8
XFILLER_37_174 VDD VDD VSS VSS gf180mcu_as_sc_mcu7t3v3__fillcap_16
XFILLER_26_859 VDD VDD VSS VSS gf180mcu_as_sc_mcu7t3v3__fillcap_16
XFILLER_0_1387 VDD VDD VSS VSS gf180mcu_as_sc_mcu7t3v3__fillcap_4
XFILLER_179_842 VDD VDD VSS VSS gf180mcu_as_sc_mcu7t3v3__fillcap_8
XFILLER_52_155 VDD VDD VSS VSS gf180mcu_as_sc_mcu7t3v3__fillcap_16
XFILLER_179_875 VDD VDD VSS VSS gf180mcu_as_sc_mcu7t3v3__fillcap_16
XFILLER_181_1364 VDD VDD VSS VSS gf180mcu_as_sc_mcu7t3v3__fillcap_16
XFILLER_194_801 VDD VDD VSS VSS gf180mcu_as_sc_mcu7t3v3__fillcap_4
XFILLER_205_1014 VDD VDD VSS VSS gf180mcu_as_sc_mcu7t3v3__fillcap_16
XFILLER_52_188 VDD VDD VSS VSS gf180mcu_as_sc_mcu7t3v3__fillcap_8
XFILLER_94_1383 VDD VDD VSS VSS gf180mcu_as_sc_mcu7t3v3__fillcap_16
X_4907_ VDD VDD VSS VSS _5090_/CLK _4907_/D _4907_/Q gf180mcu_as_sc_mcu7t3v3__dfxtp_2
XFILLER_142_1348 VDD VDD VSS VSS gf180mcu_as_sc_mcu7t3v3__fillcap_16
XFILLER_146_1495 VDD VDD VSS VSS gf180mcu_as_sc_mcu7t3v3__fill_1
XFILLER_181_1397 VDD VDD VSS VSS gf180mcu_as_sc_mcu7t3v3__fill_2
XFILLER_194_823 VDD VDD VSS VSS gf180mcu_as_sc_mcu7t3v3__fillcap_16
X_4838_ VDD VDD VSS VSS _5073_/CLK _4838_/D _4838_/Q gf180mcu_as_sc_mcu7t3v3__dfxtp_2
X_4769_ VDD VDD VSS VSS _5241_/CLK _4769_/D _4769_/Q gf180mcu_as_sc_mcu7t3v3__dfxtp_2
XFILLER_174_580 VDD VDD VSS VSS gf180mcu_as_sc_mcu7t3v3__fillcap_16
XPHY_EDGE_ROW_172_3_Right_209 VDD VSS gf180mcu_as_sc_mcu7t3v3__tap_2
XPHY_EDGE_ROW_41_3_Right_78 VDD VSS gf180mcu_as_sc_mcu7t3v3__tap_2
XPHY_EDGE_ROW_86_1_Left_296 VDD VSS gf180mcu_as_sc_mcu7t3v3__tap_2
XFILLER_136_45 VDD VDD VSS VSS gf180mcu_as_sc_mcu7t3v3__fill_2
XTAP_TAPCELL_ROW_59_1_1622 VDD VSS gf180mcu_as_sc_mcu7t3v3__tap_2
XFILLER_0_424 VDD VDD VSS VSS gf180mcu_as_sc_mcu7t3v3__fillcap_16
XFILLER_66_1485 VDD VDD VSS VSS gf180mcu_as_sc_mcu7t3v3__fillcap_16
Xinput303 VDD VDD VSS VSS west_in[28] _4161_/A gf180mcu_as_sc_mcu7t3v3__buff_12
XTAP_TAPCELL_ROW_19_1150 VDD VSS gf180mcu_as_sc_mcu7t3v3__tap_2
XFILLER_153_1466 VDD VDD VSS VSS gf180mcu_as_sc_mcu7t3v3__fillcap_16
XFILLER_29_43 VDD VDD VSS VSS gf180mcu_as_sc_mcu7t3v3__fillcap_8
Xinput314 VDD VDD VSS VSS west_in[7] _3989_/A gf180mcu_as_sc_mcu7t3v3__buff_12
XFILLER_153_1488 VDD VDD VSS VSS gf180mcu_as_sc_mcu7t3v3__fill_2
XFILLER_188_1507 VDD VDD VSS VSS gf180mcu_as_sc_mcu7t3v3__fillcap_8
XFILLER_29_76 VDD VDD VSS VSS gf180mcu_as_sc_mcu7t3v3__fill_2
XTAP_TAPCELL_ROW_15_1058 VDD VSS gf180mcu_as_sc_mcu7t3v3__tap_2
XTAP_TAPCELL_ROW_15_1069 VDD VSS gf180mcu_as_sc_mcu7t3v3__tap_2
XTAP_TAPCELL_ROW_69_3_2928 VDD VSS gf180mcu_as_sc_mcu7t3v3__tap_2
XFILLER_17_804 VDD VDD VSS VSS gf180mcu_as_sc_mcu7t3v3__fill_2
XFILLER_28_141 VDD VDD VSS VSS gf180mcu_as_sc_mcu7t3v3__fill_1
XFILLER_29_642 VDD VDD VSS VSS gf180mcu_as_sc_mcu7t3v3__fill_1
XFILLER_152_99 VDD VDD VSS VSS gf180mcu_as_sc_mcu7t3v3__fillcap_4
XFILLER_16_303 VDD VDD VSS VSS gf180mcu_as_sc_mcu7t3v3__fill_1
XFILLER_17_837 VDD VDD VSS VSS gf180mcu_as_sc_mcu7t3v3__fill_2
XFILLER_21_1068 VDD VDD VSS VSS gf180mcu_as_sc_mcu7t3v3__fillcap_16
XFILLER_28_163 VDD VDD VSS VSS gf180mcu_as_sc_mcu7t3v3__fill_1
XFILLER_90_217 VDD VDD VSS VSS gf180mcu_as_sc_mcu7t3v3__fillcap_4
XFILLER_186_1275 VDD VDD VSS VSS gf180mcu_as_sc_mcu7t3v3__fillcap_16
XPHY_EDGE_ROW_114_3_Left_499 VDD VSS gf180mcu_as_sc_mcu7t3v3__tap_2
XFILLER_186_1297 VDD VDD VSS VSS gf180mcu_as_sc_mcu7t3v3__fillcap_16
XFILLER_43_144 VDD VDD VSS VSS gf180mcu_as_sc_mcu7t3v3__fill_1
XFILLER_196_171 VDD VDD VSS VSS gf180mcu_as_sc_mcu7t3v3__fillcap_4
XFILLER_34_1429 VDD VDD VSS VSS gf180mcu_as_sc_mcu7t3v3__fillcap_4
XPHY_EDGE_ROW_177_Right_40 VDD VSS gf180mcu_as_sc_mcu7t3v3__tap_2
XPHY_EDGE_ROW_51_3_Left_436 VDD VSS gf180mcu_as_sc_mcu7t3v3__tap_2
XFILLER_125_1568 VDD VDD VSS VSS gf180mcu_as_sc_mcu7t3v3__fill_1
XFILLER_184_333 VDD VDD VSS VSS gf180mcu_as_sc_mcu7t3v3__fillcap_16
XFILLER_196_193 VDD VDD VSS VSS gf180mcu_as_sc_mcu7t3v3__fillcap_16
XFILLER_8_524 VDD VDD VSS VSS gf180mcu_as_sc_mcu7t3v3__fill_1
XFILLER_201_1434 VDD VDD VSS VSS gf180mcu_as_sc_mcu7t3v3__fillcap_16
XFILLER_61_96 VDD VDD VSS VSS gf180mcu_as_sc_mcu7t3v3__fill_2
XFILLER_8_579 VDD VDD VSS VSS gf180mcu_as_sc_mcu7t3v3__fill_1
XANTENNA_7 VDD VDD VSS VSS _4855_/D gf180mcu_as_sc_mcu7t3v3__diode_2
XFILLER_193_1224 VDD VDD VSS VSS gf180mcu_as_sc_mcu7t3v3__fillcap_16
XFILLER_6_69 VDD VDD VSS VSS gf180mcu_as_sc_mcu7t3v3__fillcap_16
XFILLER_10_1473 VDD VDD VSS VSS gf180mcu_as_sc_mcu7t3v3__fill_2
XFILLER_10_1484 VDD VDD VSS VSS gf180mcu_as_sc_mcu7t3v3__fillcap_4
XFILLER_171_1533 VDD VDD VSS VSS gf180mcu_as_sc_mcu7t3v3__fillcap_16
XTAP_TAPCELL_ROW_210_2792 VDD VSS gf180mcu_as_sc_mcu7t3v3__tap_2
XTAP_TAPCELL_ROW_185_2246 VDD VSS gf180mcu_as_sc_mcu7t3v3__tap_2
XTAP_TAPCELL_ROW_185_2235 VDD VSS gf180mcu_as_sc_mcu7t3v3__tap_2
XFILLER_171_1555 VDD VDD VSS VSS gf180mcu_as_sc_mcu7t3v3__fill_1
XFILLER_171_1566 VDD VDD VSS VSS gf180mcu_as_sc_mcu7t3v3__fill_2
XFILLER_45_1558 VDD VDD VSS VSS gf180mcu_as_sc_mcu7t3v3__fillcap_8
XFILLER_80_1449 VDD VDD VSS VSS gf180mcu_as_sc_mcu7t3v3__fill_2
Xmesh_tile_929 VDD VDD VSS VSS ne_out[4] gf180mcu_as_sc_mcu7t3v3__tiel_4
XFILLER_120_193 VDD VDD VSS VSS gf180mcu_as_sc_mcu7t3v3__fillcap_16
XFILLER_19_174 VDD VDD VSS VSS gf180mcu_as_sc_mcu7t3v3__fillcap_16
XFILLER_35_623 VDD VDD VSS VSS gf180mcu_as_sc_mcu7t3v3__fillcap_4
XTAP_TAPCELL_ROW_97_3_3013 VDD VSS gf180mcu_as_sc_mcu7t3v3__tap_2
XTAP_TAPCELL_ROW_85_1_1701 VDD VSS gf180mcu_as_sc_mcu7t3v3__tap_2
XFILLER_169_1462 VDD VDD VSS VSS gf180mcu_as_sc_mcu7t3v3__fill_2
XFILLER_169_1484 VDD VDD VSS VSS gf180mcu_as_sc_mcu7t3v3__fill_2
XFILLER_207_253 VDD VDD VSS VSS gf180mcu_as_sc_mcu7t3v3__fillcap_16
XFILLER_165_1348 VDD VDD VSS VSS gf180mcu_as_sc_mcu7t3v3__fillcap_16
XFILLER_22_317 VDD VDD VSS VSS gf180mcu_as_sc_mcu7t3v3__fillcap_8
XFILLER_22_339 VDD VDD VSS VSS gf180mcu_as_sc_mcu7t3v3__fillcap_4
XFILLER_34_177 VDD VDD VSS VSS gf180mcu_as_sc_mcu7t3v3__fillcap_16
X_2953_ VDD VDD VSS VSS _4915_/Q _3045_/D _3042_/B _3926_/A _2954_/D gf180mcu_as_sc_mcu7t3v3__ao22_2
XFILLER_176_823 VDD VDD VSS VSS gf180mcu_as_sc_mcu7t3v3__fillcap_16
XFILLER_188_661 VDD VDD VSS VSS gf180mcu_as_sc_mcu7t3v3__fillcap_4
XFILLER_188_683 VDD VDD VSS VSS gf180mcu_as_sc_mcu7t3v3__fillcap_16
XFILLER_203_470 VDD VDD VSS VSS gf180mcu_as_sc_mcu7t3v3__fillcap_16
XFILLER_203_492 VDD VDD VSS VSS gf180mcu_as_sc_mcu7t3v3__fillcap_16
XFILLER_206_1345 VDD VDD VSS VSS gf180mcu_as_sc_mcu7t3v3__fillcap_16
XFILLER_206_1367 VDD VDD VSS VSS gf180mcu_as_sc_mcu7t3v3__fillcap_16
XFILLER_52_1518 VDD VDD VSS VSS gf180mcu_as_sc_mcu7t3v3__fill_2
XFILLER_175_311 VDD VDD VSS VSS gf180mcu_as_sc_mcu7t3v3__fillcap_8
XFILLER_30_383 VDD VDD VSS VSS gf180mcu_as_sc_mcu7t3v3__fill_2
X_2884_ VDD VDD VSS VSS _4763_/Q _2884_/B _4770_/Q _4770_/D gf180mcu_as_sc_mcu7t3v3__mux2_2
XFILLER_135_208 VDD VDD VSS VSS gf180mcu_as_sc_mcu7t3v3__fill_2
XFILLER_191_804 VDD VDD VSS VSS gf180mcu_as_sc_mcu7t3v3__fillcap_16
XFILLER_198_1135 VDD VDD VSS VSS gf180mcu_as_sc_mcu7t3v3__fillcap_16
XFILLER_198_1157 VDD VDD VSS VSS gf180mcu_as_sc_mcu7t3v3__fillcap_16
X_4623_ VDD VDD VSS VSS _5217_/Q _4624_/B _4629_/C _5218_/Q _5217_/D gf180mcu_as_sc_mcu7t3v3__ao22_2
X_4554_ VDD VDD VSS VSS _5185_/Q _4554_/B _4575_/C _5103_/Q _4555_/B gf180mcu_as_sc_mcu7t3v3__ao22_2
XTAP_TAPCELL_ROW_174_1994 VDD VSS gf180mcu_as_sc_mcu7t3v3__tap_2
XTAP_TAPCELL_ROW_174_1983 VDD VSS gf180mcu_as_sc_mcu7t3v3__tap_2
XTAP_TAPCELL_ROW_174_1972 VDD VSS gf180mcu_as_sc_mcu7t3v3__tap_2
XFILLER_89_1496 VDD VDD VSS VSS gf180mcu_as_sc_mcu7t3v3__fill_2
X_3505_ VDD VDD VSS VSS _3505_/S _3505_/B _4164_/A _3506_/B gf180mcu_as_sc_mcu7t3v3__mux2_2
X_4485_ VDD VDD VSS VSS _4510_/A _4485_/B _4485_/C _4486_/D _4521_/A gf180mcu_as_sc_mcu7t3v3__aoi211_2
X_3436_ VDD VDD VSS VSS _4085_/A _3467_/B _3467_/C _4086_/A _3437_/D gf180mcu_as_sc_mcu7t3v3__ao22_2
XFILLER_106_37 VDD VDD VSS VSS gf180mcu_as_sc_mcu7t3v3__fillcap_8
X_3367_ VDD VDD VSS VSS _3367_/A _3367_/B _3367_/C _3368_/C gf180mcu_as_sc_mcu7t3v3__nor3_2
XFILLER_57_203 VDD VDD VSS VSS gf180mcu_as_sc_mcu7t3v3__fillcap_4
XPHY_EDGE_ROW_120_1_Right_641 VDD VSS gf180mcu_as_sc_mcu7t3v3__tap_2
X_5106_ VDD VDD VSS VSS _5260_/CLK _5106_/D _5106_/Q gf180mcu_as_sc_mcu7t3v3__dfxtp_2
XFILLER_61_1371 VDD VDD VSS VSS gf180mcu_as_sc_mcu7t3v3__fillcap_16
X_5037_ VDD VDD VSS VSS clkload5/A _5037_/D _5037_/Q gf180mcu_as_sc_mcu7t3v3__dfxtp_2
X_3298_ VDD VDD VSS VSS _3947_/D _3404_/B _3401_/B _3951_/A _3299_/D gf180mcu_as_sc_mcu7t3v3__ao22_2
XFILLER_113_1461 VDD VDD VSS VSS gf180mcu_as_sc_mcu7t3v3__fill_1
XTAP_TAPCELL_ROW_132_1_1840 VDD VSS gf180mcu_as_sc_mcu7t3v3__tap_2
XTAP_TAPCELL_ROW_1_744 VDD VSS gf180mcu_as_sc_mcu7t3v3__tap_2
XFILLER_26_645 VDD VDD VSS VSS gf180mcu_as_sc_mcu7t3v3__fill_1
XFILLER_57_1418 VDD VDD VSS VSS gf180mcu_as_sc_mcu7t3v3__fillcap_8
XTAP_TAPCELL_ROW_144_3_3152 VDD VSS gf180mcu_as_sc_mcu7t3v3__tap_2
XTAP_TAPCELL_ROW_1_755 VDD VSS gf180mcu_as_sc_mcu7t3v3__tap_2
XFILLER_148_1568 VDD VDD VSS VSS gf180mcu_as_sc_mcu7t3v3__fill_1
XFILLER_14_807 VDD VDD VSS VSS gf180mcu_as_sc_mcu7t3v3__fillcap_16
XFILLER_198_18 VDD VDD VSS VSS gf180mcu_as_sc_mcu7t3v3__fillcap_16
XFILLER_198_425 VDD VDD VSS VSS gf180mcu_as_sc_mcu7t3v3__fill_1
XFILLER_198_447 VDD VDD VSS VSS gf180mcu_as_sc_mcu7t3v3__fillcap_8
XFILLER_15_67 VDD VDD VSS VSS gf180mcu_as_sc_mcu7t3v3__fill_2
XTAP_TAPCELL_ROW_112_1_1782 VDD VSS gf180mcu_as_sc_mcu7t3v3__tap_2
XFILLER_120_1421 VDD VDD VSS VSS gf180mcu_as_sc_mcu7t3v3__fillcap_16
XFILLER_182_804 VDD VDD VSS VSS gf180mcu_as_sc_mcu7t3v3__fill_1
XFILLER_210_985 VDD VDD VSS VSS gf180mcu_as_sc_mcu7t3v3__fill_1
XTAP_TAPCELL_ROW_124_3_3094 VDD VSS gf180mcu_as_sc_mcu7t3v3__tap_2
XFILLER_182_837 VDD VDD VSS VSS gf180mcu_as_sc_mcu7t3v3__fillcap_16
XFILLER_182_859 VDD VDD VSS VSS gf180mcu_as_sc_mcu7t3v3__fill_1
XFILLER_193_174 VDD VDD VSS VSS gf180mcu_as_sc_mcu7t3v3__fillcap_8
XFILLER_31_66 VDD VDD VSS VSS gf180mcu_as_sc_mcu7t3v3__fillcap_4
XFILLER_147_88 VDD VDD VSS VSS gf180mcu_as_sc_mcu7t3v3__fillcap_16
XFILLER_0_210 VDD VDD VSS VSS gf180mcu_as_sc_mcu7t3v3__fill_2
XTAP_TAPCELL_ROW_17_1109 VDD VSS gf180mcu_as_sc_mcu7t3v3__tap_2
XFILLER_163_54 VDD VDD VSS VSS gf180mcu_as_sc_mcu7t3v3__fill_2
Xinput100 VDD VDD VSS VSS ne_in[2] wire909/A gf180mcu_as_sc_mcu7t3v3__buff_12
Xinput111 VDD VDD VSS VSS ne_in[9] wire903/A gf180mcu_as_sc_mcu7t3v3__buff_12
XFILLER_118_1383 VDD VDD VSS VSS gf180mcu_as_sc_mcu7t3v3__fillcap_4
XFILLER_23_1119 VDD VDD VSS VSS gf180mcu_as_sc_mcu7t3v3__fill_1
XFILLER_48_214 VDD VDD VSS VSS gf180mcu_as_sc_mcu7t3v3__fillcap_8
Xinput122 VDD VDD VSS VSS north_in[19] _4087_/A gf180mcu_as_sc_mcu7t3v3__buff_12
Xinput133 VDD VDD VSS VSS north_in[29] _3790_/A gf180mcu_as_sc_mcu7t3v3__buff_12
Xinput144 VDD VDD VSS VSS north_in[8] _3999_/A gf180mcu_as_sc_mcu7t3v3__buff_12
XTAP_TAPCELL_ROW_34_1478 VDD VSS gf180mcu_as_sc_mcu7t3v3__tap_2
Xinput155 VDD VDD VSS VSS nw_in[18] _4078_/A gf180mcu_as_sc_mcu7t3v3__buff_12
Xinput166 VDD VDD VSS VSS nw_in[28] _4162_/A gf180mcu_as_sc_mcu7t3v3__buff_12
Xinput177 VDD VDD VSS VSS nw_in[7] _3992_/A gf180mcu_as_sc_mcu7t3v3__buff_12
XTAP_TAPCELL_ROW_34_1489 VDD VSS gf180mcu_as_sc_mcu7t3v3__tap_2
XTAP_TAPCELL_ROW_180_2143 VDD VSS gf180mcu_as_sc_mcu7t3v3__tap_2
XTAP_TAPCELL_ROW_180_2132 VDD VSS gf180mcu_as_sc_mcu7t3v3__tap_2
XFILLER_17_601 VDD VDD VSS VSS gf180mcu_as_sc_mcu7t3v3__fill_2
Xinput188 VDD VDD VSS VSS se_in[16] wire877/A gf180mcu_as_sc_mcu7t3v3__buff_12
Xinput199 VDD VDD VSS VSS se_in[26] _4147_/A gf180mcu_as_sc_mcu7t3v3__buff_12
XFILLER_205_702 VDD VDD VSS VSS gf180mcu_as_sc_mcu7t3v3__fillcap_16
XFILLER_40_1477 VDD VDD VSS VSS gf180mcu_as_sc_mcu7t3v3__fillcap_4
XFILLER_56_85 VDD VDD VSS VSS gf180mcu_as_sc_mcu7t3v3__fillcap_16
XFILLER_5_1095 VDD VDD VSS VSS gf180mcu_as_sc_mcu7t3v3__fillcap_16
XFILLER_16_177 VDD VDD VSS VSS gf180mcu_as_sc_mcu7t3v3__fill_2
XFILLER_176_119 VDD VDD VSS VSS gf180mcu_as_sc_mcu7t3v3__fill_2
XFILLER_31_158 VDD VDD VSS VSS gf180mcu_as_sc_mcu7t3v3__fillcap_16
XTAP_TAPCELL_ROW_178_2094 VDD VSS gf180mcu_as_sc_mcu7t3v3__tap_2
XTAP_TAPCELL_ROW_178_2083 VDD VSS gf180mcu_as_sc_mcu7t3v3__tap_2
XFILLER_12_350 VDD VDD VSS VSS gf180mcu_as_sc_mcu7t3v3__fillcap_4
XFILLER_9_822 VDD VDD VSS VSS gf180mcu_as_sc_mcu7t3v3__fillcap_8
XFILLER_12_383 VDD VDD VSS VSS gf180mcu_as_sc_mcu7t3v3__fill_2
XFILLER_200_473 VDD VDD VSS VSS gf180mcu_as_sc_mcu7t3v3__fillcap_16
XFILLER_51_1551 VDD VDD VSS VSS gf180mcu_as_sc_mcu7t3v3__fillcap_4
XTAP_TAPCELL_ROW_170_3_3231 VDD VSS gf180mcu_as_sc_mcu7t3v3__tap_2
XFILLER_185_697 VDD VDD VSS VSS gf180mcu_as_sc_mcu7t3v3__fill_2
XFILLER_199_1466 VDD VDD VSS VSS gf180mcu_as_sc_mcu7t3v3__fillcap_4
XFILLER_199_1488 VDD VDD VSS VSS gf180mcu_as_sc_mcu7t3v3__fillcap_16
X_4270_ VDD VDD VSS VSS _4272_/S _5482_/A _5104_/Q _5104_/D gf180mcu_as_sc_mcu7t3v3__mux2_2
XTAP_TAPCELL_ROW_137_1_1855 VDD VSS gf180mcu_as_sc_mcu7t3v3__tap_2
XTAP_TAPCELL_ROW_149_3_3167 VDD VSS gf180mcu_as_sc_mcu7t3v3__tap_2
X_3221_ VDD VDD VSS VSS _3558_/B _3243_/A _3241_/C gf180mcu_as_sc_mcu7t3v3__and2_2
Xclkbuf_leaf_17_clk_regs VDD VDD VSS VSS clkbuf_3_4__f_clk_regs/Y _5256_/CLK gf180mcu_as_sc_mcu7t3v3__clkbuff_12
X_3152_ VDD VDD VSS VSS _4129_/A _3222_/D _3169_/C _4128_/A _3153_/C gf180mcu_as_sc_mcu7t3v3__ao22_2
XFILLER_11_2 VDD VDD VSS VSS gf180mcu_as_sc_mcu7t3v3__fillcap_16
X_3083_ VDD VDD VSS VSS _3143_/S _4065_/A _4063_/A _3085_/B gf180mcu_as_sc_mcu7t3v3__mux2_2
XFILLER_36_954 VDD VDD VSS VSS gf180mcu_as_sc_mcu7t3v3__fillcap_16
XTAP_TAPCELL_ROW_117_1_1797 VDD VSS gf180mcu_as_sc_mcu7t3v3__tap_2
XFILLER_17_1402 VDD VDD VSS VSS gf180mcu_as_sc_mcu7t3v3__fillcap_8
X_3985_ VDD VDD VSS VSS _3985_/A _4105_/B _3985_/C _3985_/D _3986_/B gf180mcu_as_sc_mcu7t3v3__ao211_2
XFILLER_143_1432 VDD VDD VSS VSS gf180mcu_as_sc_mcu7t3v3__fill_1
XFILLER_52_1348 VDD VDD VSS VSS gf180mcu_as_sc_mcu7t3v3__fillcap_16
XFILLER_91_1397 VDD VDD VSS VSS gf180mcu_as_sc_mcu7t3v3__fill_2
X_2936_ VDD VDD VSS VSS _3528_/B _3528_/A _3281_/B gf180mcu_as_sc_mcu7t3v3__and2_2
XFILLER_202_1017 VDD VDD VSS VSS gf180mcu_as_sc_mcu7t3v3__fillcap_16
X_2867_ VDD VDD VSS VSS _2868_/B _4765_/Q _2870_/B gf180mcu_as_sc_mcu7t3v3__and2_2
XFILLER_15_1181 VDD VDD VSS VSS gf180mcu_as_sc_mcu7t3v3__fillcap_8
XFILLER_15_1192 VDD VDD VSS VSS gf180mcu_as_sc_mcu7t3v3__fillcap_4
X_4606_ VDD VDD VSS VSS _5200_/Q _4622_/B _4622_/C _5201_/Q _5200_/D gf180mcu_as_sc_mcu7t3v3__ao22_2
XFILLER_175_196 VDD VDD VSS VSS gf180mcu_as_sc_mcu7t3v3__fillcap_8
X_2798_ VDD VDD VSS VSS _2799_/C _2798_/B _4684_/A gf180mcu_as_sc_mcu7t3v3__nor2_2
XFILLER_11_1078 VDD VDD VSS VSS gf180mcu_as_sc_mcu7t3v3__fill_1
XFILLER_190_166 VDD VDD VSS VSS gf180mcu_as_sc_mcu7t3v3__fillcap_8
XFILLER_190_177 VDD VDD VSS VSS gf180mcu_as_sc_mcu7t3v3__fillcap_16
X_4537_ VDD VDD VSS VSS _4538_/B _4537_/A gf180mcu_as_sc_mcu7t3v3__inv_2
XFILLER_117_47 VDD VDD VSS VSS gf180mcu_as_sc_mcu7t3v3__fill_1
X_4468_ VDD VDD VSS VSS _4468_/B _4497_/A _4469_/D gf180mcu_as_sc_mcu7t3v3__and2_2
XFILLER_28_1531 VDD VDD VSS VSS gf180mcu_as_sc_mcu7t3v3__fill_1
XFILLER_63_1422 VDD VDD VSS VSS gf180mcu_as_sc_mcu7t3v3__fill_1
Xfanout801 VDD VDD VSS VSS _4488_/A _4500_/S gf180mcu_as_sc_mcu7t3v3__buff_12
Xfanout812 VDD VDD VSS VSS _4974_/Q _2826_/S gf180mcu_as_sc_mcu7t3v3__buff_12
Xfanout823 VDD VDD VSS VSS fanout825/A _3624_/A gf180mcu_as_sc_mcu7t3v3__buff_12
X_3419_ VDD VDD VSS VSS _3442_/B _4072_/A _3420_/D gf180mcu_as_sc_mcu7t3v3__or2_2
XPHY_EDGE_ROW_117_1_Left_327 VDD VSS gf180mcu_as_sc_mcu7t3v3__tap_2
X_4399_ VDD VDD VSS VSS _5168_/Q _4470_/B _4479_/C _5118_/Q _4400_/B gf180mcu_as_sc_mcu7t3v3__ao22_2
XTAP_TAPCELL_ROW_6_869 VDD VSS gf180mcu_as_sc_mcu7t3v3__tap_2
XTAP_TAPCELL_ROW_6_858 VDD VSS gf180mcu_as_sc_mcu7t3v3__tap_2
XFILLER_63_1488 VDD VDD VSS VSS gf180mcu_as_sc_mcu7t3v3__fillcap_8
XFILLER_98_1507 VDD VDD VSS VSS gf180mcu_as_sc_mcu7t3v3__fill_1
XPHY_EDGE_ROW_121_1_Right_642 VDD VSS gf180mcu_as_sc_mcu7t3v3__tap_2
Xfanout889 VDD VDD VSS VSS _3661_/D _3730_/D gf180mcu_as_sc_mcu7t3v3__buff_12
XFILLER_150_1469 VDD VDD VSS VSS gf180mcu_as_sc_mcu7t3v3__fillcap_16
XFILLER_45_206 VDD VDD VSS VSS gf180mcu_as_sc_mcu7t3v3__fillcap_4
XFILLER_172_6 VDD VDD VSS VSS gf180mcu_as_sc_mcu7t3v3__fillcap_16
XFILLER_2_1224 VDD VDD VSS VSS gf180mcu_as_sc_mcu7t3v3__fill_1
XFILLER_183_1212 VDD VDD VSS VSS gf180mcu_as_sc_mcu7t3v3__fill_1
XFILLER_199_734 VDD VDD VSS VSS gf180mcu_as_sc_mcu7t3v3__fillcap_16
XFILLER_27_976 VDD VDD VSS VSS gf180mcu_as_sc_mcu7t3v3__fillcap_4
XFILLER_27_998 VDD VDD VSS VSS gf180mcu_as_sc_mcu7t3v3__fillcap_16
XTAP_TAPCELL_ROW_163_1_1934 VDD VSS gf180mcu_as_sc_mcu7t3v3__tap_2
XFILLER_183_1256 VDD VDD VSS VSS gf180mcu_as_sc_mcu7t3v3__fillcap_4
XFILLER_13_136 VDD VDD VSS VSS gf180mcu_as_sc_mcu7t3v3__fillcap_4
XFILLER_13_158 VDD VDD VSS VSS gf180mcu_as_sc_mcu7t3v3__fillcap_16
XFILLER_166_196 VDD VDD VSS VSS gf180mcu_as_sc_mcu7t3v3__fill_1
XFILLER_182_645 VDD VDD VSS VSS gf180mcu_as_sc_mcu7t3v3__fillcap_4
XFILLER_182_667 VDD VDD VSS VSS gf180mcu_as_sc_mcu7t3v3__fill_1
XFILLER_159_1450 VDD VDD VSS VSS gf180mcu_as_sc_mcu7t3v3__fillcap_8
XFILLER_159_1472 VDD VDD VSS VSS gf180mcu_as_sc_mcu7t3v3__fill_2
XFILLER_190_1205 VDD VDD VSS VSS gf180mcu_as_sc_mcu7t3v3__fillcap_16
XFILLER_190_1227 VDD VDD VSS VSS gf180mcu_as_sc_mcu7t3v3__fillcap_16
XFILLER_29_1328 VDD VDD VSS VSS gf180mcu_as_sc_mcu7t3v3__fill_2
X_4884__1083 VDD VDD VSS VSS _4884_/D gf180mcu_as_sc_mcu7t3v3__tiel_4
XTAP_TAPCELL_ROW_36_1529 VDD VSS gf180mcu_as_sc_mcu7t3v3__tap_2
XTAP_TAPCELL_ROW_36_1518 VDD VSS gf180mcu_as_sc_mcu7t3v3__tap_2
XFILLER_174_86 VDD VDD VSS VSS gf180mcu_as_sc_mcu7t3v3__fillcap_16
XFILLER_1_541 VDD VDD VSS VSS gf180mcu_as_sc_mcu7t3v3__fillcap_16
XFILLER_27_1030 VDD VDD VSS VSS gf180mcu_as_sc_mcu7t3v3__fill_2
XFILLER_68_1399 VDD VDD VSS VSS gf180mcu_as_sc_mcu7t3v3__fill_1
XFILLER_7_1102 VDD VDD VSS VSS gf180mcu_as_sc_mcu7t3v3__fillcap_8
XPHY_EDGE_ROW_49_1_Left_259 VDD VSS gf180mcu_as_sc_mcu7t3v3__tap_2
XFILLER_27_1052 VDD VDD VSS VSS gf180mcu_as_sc_mcu7t3v3__fillcap_8
XFILLER_81_1555 VDD VDD VSS VSS gf180mcu_as_sc_mcu7t3v3__fill_1
XFILLER_81_1566 VDD VDD VSS VSS gf180mcu_as_sc_mcu7t3v3__fill_2
XFILLER_190_30 VDD VDD VSS VSS gf180mcu_as_sc_mcu7t3v3__fillcap_4
XFILLER_7_1146 VDD VDD VSS VSS gf180mcu_as_sc_mcu7t3v3__fillcap_4
XFILLER_190_85 VDD VDD VSS VSS gf180mcu_as_sc_mcu7t3v3__fillcap_16
XFILLER_36_206 VDD VDD VSS VSS gf180mcu_as_sc_mcu7t3v3__fillcap_4
XFILLER_18_932 VDD VDD VSS VSS gf180mcu_as_sc_mcu7t3v3__fill_1
XFILLER_17_464 VDD VDD VSS VSS gf180mcu_as_sc_mcu7t3v3__fill_1
XFILLER_188_1189 VDD VDD VSS VSS gf180mcu_as_sc_mcu7t3v3__fillcap_16
XFILLER_18_987 VDD VDD VSS VSS gf180mcu_as_sc_mcu7t3v3__fill_1
XTAP_TAPCELL_ROW_205_2691 VDD VSS gf180mcu_as_sc_mcu7t3v3__tap_2
XTAP_TAPCELL_ROW_205_2680 VDD VSS gf180mcu_as_sc_mcu7t3v3__tap_2
XFILLER_127_1405 VDD VDD VSS VSS gf180mcu_as_sc_mcu7t3v3__fillcap_8
XFILLER_166_1465 VDD VDD VSS VSS gf180mcu_as_sc_mcu7t3v3__fillcap_16
XFILLER_199_72 VDD VDD VSS VSS gf180mcu_as_sc_mcu7t3v3__fillcap_16
XFILLER_32_401 VDD VDD VSS VSS gf180mcu_as_sc_mcu7t3v3__fill_1
XFILLER_83_72 VDD VDD VSS VSS gf180mcu_as_sc_mcu7t3v3__fillcap_16
XPHY_EDGE_ROW_163_1_Left_373 VDD VSS gf180mcu_as_sc_mcu7t3v3__tap_2
XFILLER_33_957 VDD VDD VSS VSS gf180mcu_as_sc_mcu7t3v3__fillcap_8
XTAP_TAPCELL_ROW_201_2599 VDD VSS gf180mcu_as_sc_mcu7t3v3__tap_2
XTAP_TAPCELL_ROW_201_2588 VDD VSS gf180mcu_as_sc_mcu7t3v3__tap_2
XFILLER_32_489 VDD VDD VSS VSS gf180mcu_as_sc_mcu7t3v3__fillcap_16
X_3770_ VDD VDD VSS VSS _4942_/Q _3799_/B _3770_/C _4152_/A _3771_/D gf180mcu_as_sc_mcu7t3v3__ao22_2
XFILLER_192_409 VDD VDD VSS VSS gf180mcu_as_sc_mcu7t3v3__fillcap_16
XFILLER_203_1326 VDD VDD VSS VSS gf180mcu_as_sc_mcu7t3v3__fillcap_4
XFILLER_203_1348 VDD VDD VSS VSS gf180mcu_as_sc_mcu7t3v3__fillcap_16
XFILLER_9_652 VDD VDD VSS VSS gf180mcu_as_sc_mcu7t3v3__fill_2
X_2721_ VDD VDD VSS VSS _2735_/A _2721_/B _2721_/C _2736_/B _2723_/C gf180mcu_as_sc_mcu7t3v3__ao211_2
XFILLER_186_995 VDD VDD VSS VSS gf180mcu_as_sc_mcu7t3v3__fillcap_16
XFILLER_73_4 VDD VDD VSS VSS gf180mcu_as_sc_mcu7t3v3__fill_1
XFILLER_12_1343 VDD VDD VSS VSS gf180mcu_as_sc_mcu7t3v3__fillcap_16
XFILLER_195_1116 VDD VDD VSS VSS gf180mcu_as_sc_mcu7t3v3__fillcap_4
XFILLER_195_1138 VDD VDD VSS VSS gf180mcu_as_sc_mcu7t3v3__fillcap_16
XFILLER_8_173 VDD VDD VSS VSS gf180mcu_as_sc_mcu7t3v3__fill_2
X_2652_ VDD VDD VSS VSS _2658_/S _5260_/Q _5248_/Q _2653_/B gf180mcu_as_sc_mcu7t3v3__mux2_2
XFILLER_172_177 VDD VDD VSS VSS gf180mcu_as_sc_mcu7t3v3__fillcap_4
XFILLER_86_1444 VDD VDD VSS VSS gf180mcu_as_sc_mcu7t3v3__fillcap_4
Xoutput426 VDD VDD VSS VSS _4814_/Q south_out[9] gf180mcu_as_sc_mcu7t3v3__buff_12
Xoutput415 VDD VDD VSS VSS _4807_/Q south_out[2] gf180mcu_as_sc_mcu7t3v3__buff_12
Xoutput404 VDD VDD VSS VSS _4806_/Q south_out[1] gf180mcu_as_sc_mcu7t3v3__buff_12
X_2583_ VDD VDD VSS VSS _2668_/B _2583_/B _2583_/C _2583_/D _3906_/B gf180mcu_as_sc_mcu7t3v3__ao22_2
XFILLER_138_1523 VDD VDD VSS VSS gf180mcu_as_sc_mcu7t3v3__fillcap_4
XPHY_EDGE_ROW_139_3_Left_524 VDD VSS gf180mcu_as_sc_mcu7t3v3__tap_2
Xoutput459 VDD VDD VSS VSS _4881_/Q west_out[8] gf180mcu_as_sc_mcu7t3v3__buff_12
Xoutput448 VDD VDD VSS VSS _4902_/Q west_out[29] gf180mcu_as_sc_mcu7t3v3__buff_12
Xoutput437 VDD VDD VSS VSS _4892_/Q west_out[19] gf180mcu_as_sc_mcu7t3v3__buff_12
X_4322_ VDD VDD VSS VSS _4324_/S _5152_/Q _5151_/Q _5151_/D gf180mcu_as_sc_mcu7t3v3__mux2_2
XFILLER_138_1567 VDD VDD VSS VSS gf180mcu_as_sc_mcu7t3v3__fill_2
X_4253_ VDD VDD VSS VSS _4253_/S _4253_/B _5089_/Q _5089_/D gf180mcu_as_sc_mcu7t3v3__mux2_2
X_3204_ VDD VDD VSS VSS _3228_/A _3227_/S _3216_/B _3204_/C gf180mcu_as_sc_mcu7t3v3__ao21_2
XTAP_TAPCELL_ROW_168_1_1949 VDD VSS gf180mcu_as_sc_mcu7t3v3__tap_2
XFILLER_86_139 VDD VDD VSS VSS gf180mcu_as_sc_mcu7t3v3__fillcap_4
X_4184_ VDD VDD VSS VSS _4244_/B _4197_/B _4197_/C _5022_/Q _5022_/D gf180mcu_as_sc_mcu7t3v3__ao22_2
XTAP_TAPCELL_ROW_3_806 VDD VSS gf180mcu_as_sc_mcu7t3v3__tap_2
XFILLER_210_1319 VDD VDD VSS VSS gf180mcu_as_sc_mcu7t3v3__fill_2
X_3135_ VDD VDD VSS VSS _4112_/A _3222_/D _3169_/C _4111_/A _3136_/C gf180mcu_as_sc_mcu7t3v3__ao22_2
XFILLER_23_1472 VDD VDD VSS VSS gf180mcu_as_sc_mcu7t3v3__fillcap_4
X_3066_ VDD VDD VSS VSS _4048_/A _3125_/B _3125_/C _4048_/D _3072_/B gf180mcu_as_sc_mcu7t3v3__ao22_2
XTAP_TAPCELL_ROW_53_1_1603 VDD VSS gf180mcu_as_sc_mcu7t3v3__tap_2
XFILLER_110_1453 VDD VDD VSS VSS gf180mcu_as_sc_mcu7t3v3__fill_2
XFILLER_93_1415 VDD VDD VSS VSS gf180mcu_as_sc_mcu7t3v3__fill_1
XFILLER_36_784 VDD VDD VSS VSS gf180mcu_as_sc_mcu7t3v3__fillcap_4
XFILLER_93_1437 VDD VDD VSS VSS gf180mcu_as_sc_mcu7t3v3__fillcap_8
XPHY_EDGE_ROW_50_3_Right_87 VDD VSS gf180mcu_as_sc_mcu7t3v3__tap_2
XFILLER_196_715 VDD VDD VSS VSS gf180mcu_as_sc_mcu7t3v3__fillcap_16
XFILLER_208_1259 VDD VDD VSS VSS gf180mcu_as_sc_mcu7t3v3__fillcap_16
XFILLER_93_1459 VDD VDD VSS VSS gf180mcu_as_sc_mcu7t3v3__fillcap_8
XTAP_TAPCELL_ROW_63_3_2909 VDD VSS gf180mcu_as_sc_mcu7t3v3__tap_2
XFILLER_11_607 VDD VDD VSS VSS gf180mcu_as_sc_mcu7t3v3__fill_1
XFILLER_196_737 VDD VDD VSS VSS gf180mcu_as_sc_mcu7t3v3__fillcap_16
XFILLER_23_489 VDD VDD VSS VSS gf180mcu_as_sc_mcu7t3v3__fill_1
X_3968_ VDD VDD VSS VSS _3968_/A _4030_/C _4031_/B _3968_/D _3969_/D gf180mcu_as_sc_mcu7t3v3__ao22_2
Xwire509 VDD VDD VSS VSS _2973_/Y wire509/Y gf180mcu_as_sc_mcu7t3v3__clkbuff_12
X_2919_ VDD VDD VSS VSS _3792_/A _3801_/A _3554_/A gf180mcu_as_sc_mcu7t3v3__or2_2
XFILLER_148_174 VDD VDD VSS VSS gf180mcu_as_sc_mcu7t3v3__fill_1
XFILLER_176_461 VDD VDD VSS VSS gf180mcu_as_sc_mcu7t3v3__fill_2
XFILLER_178_1303 VDD VDD VSS VSS gf180mcu_as_sc_mcu7t3v3__fill_1
X_3899_ VDD VDD VSS VSS _3903_/B _4590_/A _4939_/D gf180mcu_as_sc_mcu7t3v3__and2_2
XFILLER_191_475 VDD VDD VSS VSS gf180mcu_as_sc_mcu7t3v3__fillcap_4
XFILLER_30_1465 VDD VDD VSS VSS gf180mcu_as_sc_mcu7t3v3__fillcap_4
XFILLER_30_1498 VDD VDD VSS VSS gf180mcu_as_sc_mcu7t3v3__fillcap_4
XFILLER_144_34 VDD VDD VSS VSS gf180mcu_as_sc_mcu7t3v3__fill_1
XFILLER_8_1422 VDD VDD VSS VSS gf180mcu_as_sc_mcu7t3v3__fill_1
Xfanout620 VDD VDD VSS VSS _4377_/B _4590_/B gf180mcu_as_sc_mcu7t3v3__buff_12
Xfanout631 VDD VDD VSS VSS _3923_/Y _4118_/B gf180mcu_as_sc_mcu7t3v3__buff_12
Xfanout642 VDD VDD VSS VSS _3550_/Y _3728_/C gf180mcu_as_sc_mcu7t3v3__buff_12
XFILLER_24_1214 VDD VDD VSS VSS gf180mcu_as_sc_mcu7t3v3__fillcap_8
XFILLER_77_139 VDD VDD VSS VSS gf180mcu_as_sc_mcu7t3v3__fill_1
Xfanout653 VDD VDD VSS VSS _3071_/B _3130_/B gf180mcu_as_sc_mcu7t3v3__buff_12
Xfanout664 VDD VDD VSS VSS _4308_/S _4314_/S gf180mcu_as_sc_mcu7t3v3__buff_12
Xfanout675 VDD VDD VSS VSS _4593_/Y _4629_/B gf180mcu_as_sc_mcu7t3v3__buff_12
XTAP_TAPCELL_ROW_31_1415 VDD VSS gf180mcu_as_sc_mcu7t3v3__tap_2
XTAP_TAPCELL_ROW_31_1404 VDD VSS gf180mcu_as_sc_mcu7t3v3__tap_2
XFILLER_24_1247 VDD VDD VSS VSS gf180mcu_as_sc_mcu7t3v3__fillcap_4
XFILLER_8_1488 VDD VDD VSS VSS gf180mcu_as_sc_mcu7t3v3__fillcap_4
XPHY_EDGE_ROW_60_3_Left_445 VDD VSS gf180mcu_as_sc_mcu7t3v3__tap_2
Xfanout686 VDD VDD VSS VSS _3272_/Y _3466_/B gf180mcu_as_sc_mcu7t3v3__buff_12
Xfanout697 VDD VDD VSS VSS _3929_/Y _4152_/C gf180mcu_as_sc_mcu7t3v3__buff_12
XFILLER_160_22 VDD VDD VSS VSS gf180mcu_as_sc_mcu7t3v3__fillcap_8
XFILLER_37_43 VDD VDD VSS VSS gf180mcu_as_sc_mcu7t3v3__fillcap_16
XPHY_EDGE_ROW_122_1_Right_643 VDD VSS gf180mcu_as_sc_mcu7t3v3__tap_2
XFILLER_15_902 VDD VDD VSS VSS gf180mcu_as_sc_mcu7t3v3__fillcap_8
XFILLER_2_1087 VDD VDD VSS VSS gf180mcu_as_sc_mcu7t3v3__fill_2
XFILLER_41_220 VDD VDD VSS VSS gf180mcu_as_sc_mcu7t3v3__fill_2
XTAP_TAPCELL_ROW_29_1377 VDD VSS gf180mcu_as_sc_mcu7t3v3__tap_2
XTAP_TAPCELL_ROW_29_1366 VDD VSS gf180mcu_as_sc_mcu7t3v3__tap_2
XFILLER_14_489 VDD VDD VSS VSS gf180mcu_as_sc_mcu7t3v3__fillcap_16
XFILLER_35_1332 VDD VDD VSS VSS gf180mcu_as_sc_mcu7t3v3__fillcap_16
XFILLER_53_64 VDD VDD VSS VSS gf180mcu_as_sc_mcu7t3v3__fillcap_4
XTAP_TAPCELL_ROW_175_2031 VDD VSS gf180mcu_as_sc_mcu7t3v3__tap_2
XTAP_TAPCELL_ROW_175_2020 VDD VSS gf180mcu_as_sc_mcu7t3v3__tap_2
XFILLER_186_247 VDD VDD VSS VSS gf180mcu_as_sc_mcu7t3v3__fillcap_4
XFILLER_23_990 VDD VDD VSS VSS gf180mcu_as_sc_mcu7t3v3__fill_2
XFILLER_35_1354 VDD VDD VSS VSS gf180mcu_as_sc_mcu7t3v3__fill_1
XFILLER_139_174 VDD VDD VSS VSS gf180mcu_as_sc_mcu7t3v3__fillcap_16
XFILLER_35_1398 VDD VDD VSS VSS gf180mcu_as_sc_mcu7t3v3__fill_2
XFILLER_122_1368 VDD VDD VSS VSS gf180mcu_as_sc_mcu7t3v3__fill_2
XFILLER_154_111 VDD VDD VSS VSS gf180mcu_as_sc_mcu7t3v3__fill_2
XFILLER_183_976 VDD VDD VSS VSS gf180mcu_as_sc_mcu7t3v3__fillcap_4
XFILLER_6_622 VDD VDD VSS VSS gf180mcu_as_sc_mcu7t3v3__fill_2
XFILLER_154_177 VDD VDD VSS VSS gf180mcu_as_sc_mcu7t3v3__fillcap_4
XFILLER_196_1469 VDD VDD VSS VSS gf180mcu_as_sc_mcu7t3v3__fillcap_16
XFILLER_5_154 VDD VDD VSS VSS gf180mcu_as_sc_mcu7t3v3__fill_2
XFILLER_182_497 VDD VDD VSS VSS gf180mcu_as_sc_mcu7t3v3__fill_2
XFILLER_9_1208 VDD VDD VSS VSS gf180mcu_as_sc_mcu7t3v3__fill_2
XTAP_TAPCELL_ROW_58_1_1618 VDD VSS gf180mcu_as_sc_mcu7t3v3__tap_2
XFILLER_2_872 VDD VDD VSS VSS gf180mcu_as_sc_mcu7t3v3__fill_2
XFILLER_78_61 VDD VDD VSS VSS gf180mcu_as_sc_mcu7t3v3__fillcap_16
XFILLER_204_37 VDD VDD VSS VSS gf180mcu_as_sc_mcu7t3v3__fillcap_16
XFILLER_209_112 VDD VDD VSS VSS gf180mcu_as_sc_mcu7t3v3__fill_2
XTAP_TAPCELL_ROW_207_2731 VDD VSS gf180mcu_as_sc_mcu7t3v3__tap_2
XTAP_TAPCELL_ROW_207_2720 VDD VSS gf180mcu_as_sc_mcu7t3v3__tap_2
Xmesh_tile_1052 VDD VDD VSS VSS sw_out[25] gf180mcu_as_sc_mcu7t3v3__tiel_4
Xmesh_tile_1041 VDD VDD VSS VSS sw_out[14] gf180mcu_as_sc_mcu7t3v3__tiel_4
Xmesh_tile_1030 VDD VDD VSS VSS sw_out[3] gf180mcu_as_sc_mcu7t3v3__tiel_4
XFILLER_24_209 VDD VDD VSS VSS gf180mcu_as_sc_mcu7t3v3__fillcap_16
XFILLER_91_142 VDD VDD VSS VSS gf180mcu_as_sc_mcu7t3v3__fill_2
XTAP_TAPCELL_ROW_203_2639 VDD VSS gf180mcu_as_sc_mcu7t3v3__tap_2
XTAP_TAPCELL_ROW_203_2628 VDD VSS gf180mcu_as_sc_mcu7t3v3__tap_2
XTAP_TAPCELL_ROW_199_2543 VDD VSS gf180mcu_as_sc_mcu7t3v3__tap_2
Xclkbuf_3_2__f_clk_regs VDD VDD VSS VSS clkbuf_2_1_0_clk_regs/Y clkbuf_leaf_2_clk_regs/A
+ gf180mcu_as_sc_mcu7t3v3__clkbuff_12
X_4940_ VDD VDD VSS VSS _4977_/CLK _4940_/D _4940_/Q gf180mcu_as_sc_mcu7t3v3__dfxtp_2
XTAP_TAPCELL_ROW_199_2554 VDD VSS gf180mcu_as_sc_mcu7t3v3__tap_2
XFILLER_205_384 VDD VDD VSS VSS gf180mcu_as_sc_mcu7t3v3__fillcap_16
XFILLER_209_1568 VDD VDD VSS VSS gf180mcu_as_sc_mcu7t3v3__fill_1
XFILLER_32_220 VDD VDD VSS VSS gf180mcu_as_sc_mcu7t3v3__fillcap_8
X_4871_ VDD VDD VSS VSS _5277_/CLK _4871_/D _4871_/Q gf180mcu_as_sc_mcu7t3v3__dfxtp_2
XFILLER_177_214 VDD VDD VSS VSS gf180mcu_as_sc_mcu7t3v3__fill_1
XFILLER_178_737 VDD VDD VSS VSS gf180mcu_as_sc_mcu7t3v3__fill_2
X_3822_ VDD VDD VSS VSS _3826_/B _4168_/A _4907_/Q gf180mcu_as_sc_mcu7t3v3__nor2b_2
XFILLER_193_718 VDD VDD VSS VSS gf180mcu_as_sc_mcu7t3v3__fillcap_16
XFILLER_105_1566 VDD VDD VSS VSS gf180mcu_as_sc_mcu7t3v3__fill_2
XFILLER_140_1446 VDD VDD VSS VSS gf180mcu_as_sc_mcu7t3v3__fillcap_4
XFILLER_14_1427 VDD VDD VSS VSS gf180mcu_as_sc_mcu7t3v3__fillcap_8
X_3753_ VDD VDD VSS VSS _4132_/A _3775_/B _3753_/C _4863_/D _3831_/A gf180mcu_as_sc_mcu7t3v3__aoi211_2
XFILLER_174_954 VDD VDD VSS VSS gf180mcu_as_sc_mcu7t3v3__fillcap_16
XFILLER_88_1517 VDD VDD VSS VSS gf180mcu_as_sc_mcu7t3v3__fillcap_4
X_3684_ VDD VDD VSS VSS _4854_/D _3684_/C _3731_/B _3684_/A gf180mcu_as_sc_mcu7t3v3__aoi21_2
X_2704_ VDD VDD VSS VSS _2732_/S _4960_/Q _4969_/Q _2706_/A gf180mcu_as_sc_mcu7t3v3__mux2_2
X_2635_ VDD VDD VSS VSS _2658_/S _2635_/B _5246_/Q _2636_/B gf180mcu_as_sc_mcu7t3v3__mux2_2
XFILLER_12_1184 VDD VDD VSS VSS gf180mcu_as_sc_mcu7t3v3__fill_1
XFILLER_99_220 VDD VDD VSS VSS gf180mcu_as_sc_mcu7t3v3__fill_2
Xclkbuf_leaf_32_clk_regs VDD VDD VSS VSS clkbuf_3_3__f_clk_regs/Y _5095_/CLK gf180mcu_as_sc_mcu7t3v3__clkbuff_12
XTAP_TAPCELL_ROW_8_909 VDD VSS gf180mcu_as_sc_mcu7t3v3__tap_2
XFILLER_138_1364 VDD VDD VSS VSS gf180mcu_as_sc_mcu7t3v3__fillcap_4
X_4305_ VDD VDD VSS VSS _4308_/S _5135_/Q _5134_/Q _5134_/D gf180mcu_as_sc_mcu7t3v3__mux2_2
X_2566_ VDD VDD VSS VSS _4748_/A _5278_/Q _2858_/B gf180mcu_as_sc_mcu7t3v3__and2_2
X_5285_ VDD VDD VSS VSS _5285_/CLK _5285_/D _5285_/Q gf180mcu_as_sc_mcu7t3v3__dfxtp_2
X_2497_ VDD VDD VSS VSS _4662_/C _5222_/Q _4703_/A gf180mcu_as_sc_mcu7t3v3__nor2_2
XFILLER_25_1512 VDD VDD VSS VSS gf180mcu_as_sc_mcu7t3v3__fillcap_4
XFILLER_59_139 VDD VDD VSS VSS gf180mcu_as_sc_mcu7t3v3__fill_1
XFILLER_60_1425 VDD VDD VSS VSS gf180mcu_as_sc_mcu7t3v3__fill_1
X_4236_ VDD VDD VSS VSS _4256_/S _4236_/B _5072_/Q _5072_/D gf180mcu_as_sc_mcu7t3v3__mux2_2
XFILLER_112_1504 VDD VDD VSS VSS gf180mcu_as_sc_mcu7t3v3__fill_1
XFILLER_114_37 VDD VDD VSS VSS gf180mcu_as_sc_mcu7t3v3__fill_1
X_4167_ VDD VDD VSS VSS _4167_/Y _4908_/Q _4907_/Q gf180mcu_as_sc_mcu7t3v3__nor2b_2
XFILLER_60_1469 VDD VDD VSS VSS gf180mcu_as_sc_mcu7t3v3__fillcap_16
X_3118_ VDD VDD VSS VSS _3143_/S _4093_/D _4096_/A _3120_/B gf180mcu_as_sc_mcu7t3v3__mux2_2
XFILLER_28_559 VDD VDD VSS VSS gf180mcu_as_sc_mcu7t3v3__fill_2
X_4098_ VDD VDD VSS VSS _4099_/C _4098_/B _4098_/A gf180mcu_as_sc_mcu7t3v3__nor2_2
X_3049_ VDD VDD VSS VSS _4027_/A _3057_/B _3049_/C _3049_/Y _3608_/D gf180mcu_as_sc_mcu7t3v3__aoi211_2
XTAP_TAPCELL_ROW_96_3_3009 VDD VSS gf180mcu_as_sc_mcu7t3v3__tap_2
XFILLER_23_220 VDD VDD VSS VSS gf180mcu_as_sc_mcu7t3v3__fill_2
XFILLER_24_732 VDD VDD VSS VSS gf180mcu_as_sc_mcu7t3v3__fill_2
XFILLER_24_776 VDD VDD VSS VSS gf180mcu_as_sc_mcu7t3v3__fill_1
XFILLER_180_1259 VDD VDD VSS VSS gf180mcu_as_sc_mcu7t3v3__fillcap_16
XFILLER_23_275 VDD VDD VSS VSS gf180mcu_as_sc_mcu7t3v3__fillcap_4
XFILLER_17_1084 VDD VDD VSS VSS gf180mcu_as_sc_mcu7t3v3__fillcap_16
XFILLER_23_67 VDD VDD VSS VSS gf180mcu_as_sc_mcu7t3v3__fill_2
XPHY_EDGE_ROW_12_Left_223 VDD VSS gf180mcu_as_sc_mcu7t3v3__tap_2
XTAP_TAPCELL_ROW_24_1263 VDD VSS gf180mcu_as_sc_mcu7t3v3__tap_2
XTAP_TAPCELL_ROW_24_1252 VDD VSS gf180mcu_as_sc_mcu7t3v3__tap_2
XFILLER_30_1262 VDD VDD VSS VSS gf180mcu_as_sc_mcu7t3v3__fillcap_8
XFILLER_136_177 VDD VDD VSS VSS gf180mcu_as_sc_mcu7t3v3__fillcap_4
XFILLER_155_22 VDD VDD VSS VSS gf180mcu_as_sc_mcu7t3v3__fillcap_16
XFILLER_174_1019 VDD VDD VSS VSS gf180mcu_as_sc_mcu7t3v3__fill_1
XFILLER_191_294 VDD VDD VSS VSS gf180mcu_as_sc_mcu7t3v3__fill_2
XFILLER_151_136 VDD VDD VSS VSS gf180mcu_as_sc_mcu7t3v3__fillcap_4
XFILLER_151_158 VDD VDD VSS VSS gf180mcu_as_sc_mcu7t3v3__fillcap_16
XFILLER_156_1453 VDD VDD VSS VSS gf180mcu_as_sc_mcu7t3v3__fillcap_16
XFILLER_180_979 VDD VDD VSS VSS gf180mcu_as_sc_mcu7t3v3__fillcap_16
XTAP_TAPCELL_ROW_138_1_1860 VDD VSS gf180mcu_as_sc_mcu7t3v3__tap_2
XFILLER_117_1415 VDD VDD VSS VSS gf180mcu_as_sc_mcu7t3v3__fill_1
XFILLER_155_88 VDD VDD VSS VSS gf180mcu_as_sc_mcu7t3v3__fillcap_16
XFILLER_191_1344 VDD VDD VSS VSS gf180mcu_as_sc_mcu7t3v3__fill_1
XFILLER_24_1044 VDD VDD VSS VSS gf180mcu_as_sc_mcu7t3v3__fillcap_16
XPHY_EDGE_ROW_21_Left_232 VDD VSS gf180mcu_as_sc_mcu7t3v3__tap_2
Xfanout483 VDD VDD VSS VSS _4150_/B _4142_/B gf180mcu_as_sc_mcu7t3v3__buff_12
XFILLER_189_1240 VDD VDD VSS VSS gf180mcu_as_sc_mcu7t3v3__fillcap_16
XFILLER_4_1149 VDD VDD VSS VSS gf180mcu_as_sc_mcu7t3v3__fillcap_4
XFILLER_189_1262 VDD VDD VSS VSS gf180mcu_as_sc_mcu7t3v3__fillcap_16
XFILLER_41_1391 VDD VDD VSS VSS gf180mcu_as_sc_mcu7t3v3__fillcap_8
XFILLER_73_120 VDD VDD VSS VSS gf180mcu_as_sc_mcu7t3v3__fillcap_8
XFILLER_73_142 VDD VDD VSS VSS gf180mcu_as_sc_mcu7t3v3__fillcap_16
XPHY_EDGE_ROW_123_1_Right_644 VDD VSS gf180mcu_as_sc_mcu7t3v3__tap_2
XFILLER_15_710 VDD VDD VSS VSS gf180mcu_as_sc_mcu7t3v3__fillcap_4
XFILLER_64_63 VDD VDD VSS VSS gf180mcu_as_sc_mcu7t3v3__fill_1
XFILLER_37_1405 VDD VDD VSS VSS gf180mcu_as_sc_mcu7t3v3__fillcap_8
XFILLER_30_713 VDD VDD VSS VSS gf180mcu_as_sc_mcu7t3v3__fillcap_4
XFILLER_37_1449 VDD VDD VSS VSS gf180mcu_as_sc_mcu7t3v3__fillcap_16
XTAP_TAPCELL_ROW_194_2440 VDD VSS gf180mcu_as_sc_mcu7t3v3__tap_2
XFILLER_187_545 VDD VDD VSS VSS gf180mcu_as_sc_mcu7t3v3__fillcap_8
XFILLER_187_578 VDD VDD VSS VSS gf180mcu_as_sc_mcu7t3v3__fillcap_16
XFILLER_202_365 VDD VDD VSS VSS gf180mcu_as_sc_mcu7t3v3__fillcap_16
XFILLER_30_724 VDD VDD VSS VSS gf180mcu_as_sc_mcu7t3v3__fillcap_8
XFILLER_9_69 VDD VDD VSS VSS gf180mcu_as_sc_mcu7t3v3__fill_1
XPHY_EDGE_ROW_30_Left_241 VDD VSS gf180mcu_as_sc_mcu7t3v3__tap_2
XTAP_TAPCELL_ROW_194_2451 VDD VSS gf180mcu_as_sc_mcu7t3v3__tap_2
XFILLER_202_387 VDD VDD VSS VSS gf180mcu_as_sc_mcu7t3v3__fillcap_16
XFILLER_200_1329 VDD VDD VSS VSS gf180mcu_as_sc_mcu7t3v3__fillcap_16
XTAP_TAPCELL_ROW_111_1_1778 VDD VSS gf180mcu_as_sc_mcu7t3v3__tap_2
Xwire840 VDD VDD VSS VSS wire840/A _3797_/A gf180mcu_as_sc_mcu7t3v3__clkbuff_12
Xwire851 VDD VDD VSS VSS wire851/A _4088_/A gf180mcu_as_sc_mcu7t3v3__clkbuff_12
XTAP_TAPCELL_ROW_190_2359 VDD VSS gf180mcu_as_sc_mcu7t3v3__tap_2
XTAP_TAPCELL_ROW_190_2348 VDD VSS gf180mcu_as_sc_mcu7t3v3__tap_2
XFILLER_127_155 VDD VDD VSS VSS gf180mcu_as_sc_mcu7t3v3__fillcap_16
XFILLER_31_1059 VDD VDD VSS VSS gf180mcu_as_sc_mcu7t3v3__fillcap_16
XFILLER_182_294 VDD VDD VSS VSS gf180mcu_as_sc_mcu7t3v3__fill_2
XFILLER_192_1119 VDD VDD VSS VSS gf180mcu_as_sc_mcu7t3v3__fillcap_16
X_2420_ VDD VDD VSS VSS _2650_/B _2420_/A gf180mcu_as_sc_mcu7t3v3__inv_2
XFILLER_48_1523 VDD VDD VSS VSS gf180mcu_as_sc_mcu7t3v3__fill_2
XFILLER_83_1414 VDD VDD VSS VSS gf180mcu_as_sc_mcu7t3v3__fill_2
XFILLER_135_1504 VDD VDD VSS VSS gf180mcu_as_sc_mcu7t3v3__fillcap_8
XTAP_TAPCELL_ROW_188_2299 VDD VSS gf180mcu_as_sc_mcu7t3v3__tap_2
X_5070_ VDD VDD VSS VSS clkload1/A _5070_/D _5070_/Q gf180mcu_as_sc_mcu7t3v3__dfxtp_2
X_4021_ VDD VDD VSS VSS _4021_/A _4032_/C _4030_/B _4021_/D _4022_/D gf180mcu_as_sc_mcu7t3v3__ao22_2
XFILLER_18_570 VDD VDD VSS VSS gf180mcu_as_sc_mcu7t3v3__fillcap_16
XFILLER_209_1310 VDD VDD VSS VSS gf180mcu_as_sc_mcu7t3v3__fillcap_16
XFILLER_64_153 VDD VDD VSS VSS gf180mcu_as_sc_mcu7t3v3__fill_2
XFILLER_168_1379 VDD VDD VSS VSS gf180mcu_as_sc_mcu7t3v3__fill_2
XFILLER_209_1332 VDD VDD VSS VSS gf180mcu_as_sc_mcu7t3v3__fillcap_16
XFILLER_20_1497 VDD VDD VSS VSS gf180mcu_as_sc_mcu7t3v3__fillcap_8
X_4923_ VDD VDD VSS VSS _5277_/CLK _4923_/D _4923_/Q gf180mcu_as_sc_mcu7t3v3__dfxtp_2
XFILLER_21_702 VDD VDD VSS VSS gf180mcu_as_sc_mcu7t3v3__fill_1
XFILLER_142_1519 VDD VDD VSS VSS gf180mcu_as_sc_mcu7t3v3__fill_2
XFILLER_21_746 VDD VDD VSS VSS gf180mcu_as_sc_mcu7t3v3__fillcap_16
X_4854_ VDD VDD VSS VSS _5256_/CLK _4854_/D _4854_/Q gf180mcu_as_sc_mcu7t3v3__dfxtp_2
XPHY_EDGE_ROW_126_1_Left_336 VDD VSS gf180mcu_as_sc_mcu7t3v3__tap_2
X_4785_ VDD VDD VSS VSS _4869_/CLK _4785_/D _4785_/Q gf180mcu_as_sc_mcu7t3v3__dfxtp_2
X_3805_ VDD VDD VSS VSS _4872_/D _3831_/A _3805_/B _3805_/A gf180mcu_as_sc_mcu7t3v3__aoi21b_2
XFILLER_118_100 VDD VDD VSS VSS gf180mcu_as_sc_mcu7t3v3__fillcap_4
X_3736_ VDD VDD VSS VSS _3736_/D _4109_/A _3736_/B _3800_/C _3737_/C gf180mcu_as_sc_mcu7t3v3__ao31_2
XFILLER_174_784 VDD VDD VSS VSS gf180mcu_as_sc_mcu7t3v3__fillcap_16
XFILLER_180_209 VDD VDD VSS VSS gf180mcu_as_sc_mcu7t3v3__fill_2
XFILLER_109_48 VDD VDD VSS VSS gf180mcu_as_sc_mcu7t3v3__fillcap_16
XFILLER_118_177 VDD VDD VSS VSS gf180mcu_as_sc_mcu7t3v3__fill_2
X_3667_ VDD VDD VSS VSS _3668_/C _3667_/C _3729_/B _4041_/A gf180mcu_as_sc_mcu7t3v3__aoi21_2
XFILLER_133_136 VDD VDD VSS VSS gf180mcu_as_sc_mcu7t3v3__fillcap_4
XFILLER_133_158 VDD VDD VSS VSS gf180mcu_as_sc_mcu7t3v3__fillcap_16
X_3598_ VDD VDD VSS VSS _3599_/C _3965_/A _3658_/B _3598_/C gf180mcu_as_sc_mcu7t3v3__ao21_2
X_2618_ VDD VDD VSS VSS _2621_/B _2883_/B _4655_/B _2619_/C _2658_/S gf180mcu_as_sc_mcu7t3v3__oai211_2
XFILLER_87_201 VDD VDD VSS VSS gf180mcu_as_sc_mcu7t3v3__fillcap_8
XFILLER_87_212 VDD VDD VSS VSS gf180mcu_as_sc_mcu7t3v3__fillcap_8
X_2549_ VDD VDD VSS VSS _4705_/A _4746_/A _4683_/B gf180mcu_as_sc_mcu7t3v3__nand2_2
X_5268_ VDD VDD VSS VSS _5276_/CLK _5268_/D _5268_/Q gf180mcu_as_sc_mcu7t3v3__dfxtp_2
XFILLER_64_1380 VDD VDD VSS VSS gf180mcu_as_sc_mcu7t3v3__fill_1
X_4219_ VDD VDD VSS VSS _4248_/B _4222_/B _4222_/C _5055_/Q _5055_/D gf180mcu_as_sc_mcu7t3v3__ao22_2
XTAP_TAPCELL_ROW_38_3_2835 VDD VSS gf180mcu_as_sc_mcu7t3v3__tap_2
XFILLER_18_34 VDD VDD VSS VSS gf180mcu_as_sc_mcu7t3v3__fill_1
X_5199_ VDD VDD VSS VSS _5216_/CLK _5199_/D _5199_/Q gf180mcu_as_sc_mcu7t3v3__dfxtp_2
XFILLER_55_142 VDD VDD VSS VSS gf180mcu_as_sc_mcu7t3v3__fillcap_16
XFILLER_28_378 VDD VDD VSS VSS gf180mcu_as_sc_mcu7t3v3__fillcap_4
XFILLER_55_186 VDD VDD VSS VSS gf180mcu_as_sc_mcu7t3v3__fillcap_8
XFILLER_70_123 VDD VDD VSS VSS gf180mcu_as_sc_mcu7t3v3__fillcap_16
XTAP_TAPCELL_ROW_26_1303 VDD VSS gf180mcu_as_sc_mcu7t3v3__tap_2
XPHY_EDGE_ROW_58_1_Left_268 VDD VSS gf180mcu_as_sc_mcu7t3v3__tap_2
Xsram2048.u_bank0_911 VDD VDD VSS VSS sram2048.u_bank0/WEN[1] gf180mcu_as_sc_mcu7t3v3__tiel_4
XFILLER_196_375 VDD VDD VSS VSS gf180mcu_as_sc_mcu7t3v3__fillcap_8
XFILLER_32_1313 VDD VDD VSS VSS gf180mcu_as_sc_mcu7t3v3__fillcap_16
XTAP_TAPCELL_ROW_83_1_1694 VDD VSS gf180mcu_as_sc_mcu7t3v3__tap_2
XFILLER_197_1520 VDD VDD VSS VSS gf180mcu_as_sc_mcu7t3v3__fillcap_16
XFILLER_171_209 VDD VDD VSS VSS gf180mcu_as_sc_mcu7t3v3__fill_1
XFILLER_197_1542 VDD VDD VSS VSS gf180mcu_as_sc_mcu7t3v3__fill_2
XTAP_TAPCELL_ROW_10_947 VDD VSS gf180mcu_as_sc_mcu7t3v3__tap_2
XTAP_TAPCELL_ROW_10_958 VDD VSS gf180mcu_as_sc_mcu7t3v3__tap_2
XFILLER_109_177 VDD VDD VSS VSS gf180mcu_as_sc_mcu7t3v3__fill_2
XFILLER_124_114 VDD VDD VSS VSS gf180mcu_as_sc_mcu7t3v3__fillcap_16
XFILLER_50_98 VDD VDD VSS VSS gf180mcu_as_sc_mcu7t3v3__fillcap_4
XFILLER_180_754 VDD VDD VSS VSS gf180mcu_as_sc_mcu7t3v3__fillcap_16
XFILLER_30_1081 VDD VDD VSS VSS gf180mcu_as_sc_mcu7t3v3__fillcap_4
XFILLER_3_422 VDD VDD VSS VSS gf180mcu_as_sc_mcu7t3v3__fill_2
XFILLER_59_52 VDD VDD VSS VSS gf180mcu_as_sc_mcu7t3v3__fillcap_16
XFILLER_182_53 VDD VDD VSS VSS gf180mcu_as_sc_mcu7t3v3__fillcap_16
XPHY_EDGE_ROW_172_1_Left_382 VDD VSS gf180mcu_as_sc_mcu7t3v3__tap_2
XFILLER_130_1401 VDD VDD VSS VSS gf180mcu_as_sc_mcu7t3v3__fill_2
XFILLER_208_914 VDD VDD VSS VSS gf180mcu_as_sc_mcu7t3v3__fillcap_4
XFILLER_130_1445 VDD VDD VSS VSS gf180mcu_as_sc_mcu7t3v3__fillcap_4
XFILLER_208_947 VDD VDD VSS VSS gf180mcu_as_sc_mcu7t3v3__fillcap_4
XTAP_TAPCELL_ROW_183_2196 VDD VSS gf180mcu_as_sc_mcu7t3v3__tap_2
XFILLER_210_1480 VDD VDD VSS VSS gf180mcu_as_sc_mcu7t3v3__fillcap_16
XFILLER_34_337 VDD VDD VSS VSS gf180mcu_as_sc_mcu7t3v3__fill_2
XFILLER_61_134 VDD VDD VSS VSS gf180mcu_as_sc_mcu7t3v3__fillcap_4
XPHY_EDGE_ROW_124_1_Right_645 VDD VSS gf180mcu_as_sc_mcu7t3v3__tap_2
XTAP_TAPCELL_ROW_64_3_2914 VDD VSS gf180mcu_as_sc_mcu7t3v3__tap_2
XFILLER_15_595 VDD VDD VSS VSS gf180mcu_as_sc_mcu7t3v3__fillcap_16
XFILLER_91_72 VDD VDD VSS VSS gf180mcu_as_sc_mcu7t3v3__fillcap_16
XFILLER_98_6 VDD VDD VSS VSS gf180mcu_as_sc_mcu7t3v3__fill_1
XPHY_EDGE_ROW_148_3_Left_533 VDD VSS gf180mcu_as_sc_mcu7t3v3__tap_2
XFILLER_187_375 VDD VDD VSS VSS gf180mcu_as_sc_mcu7t3v3__fillcap_8
XFILLER_203_696 VDD VDD VSS VSS gf180mcu_as_sc_mcu7t3v3__fillcap_4
XFILLER_102_1514 VDD VDD VSS VSS gf180mcu_as_sc_mcu7t3v3__fillcap_4
XFILLER_175_559 VDD VDD VSS VSS gf180mcu_as_sc_mcu7t3v3__fill_1
X_4570_ VDD VDD VSS VSS _4570_/S _5028_/Q _5057_/Q _4571_/B gf180mcu_as_sc_mcu7t3v3__mux2_2
XFILLER_162_209 VDD VDD VSS VSS gf180mcu_as_sc_mcu7t3v3__fillcap_8
X_3521_ VDD VDD VSS VSS _3522_/D _3521_/A _3521_/B _3521_/C gf180mcu_as_sc_mcu7t3v3__ao21_2
XFILLER_7_772 VDD VDD VSS VSS gf180mcu_as_sc_mcu7t3v3__fillcap_16
XPHY_EDGE_ROW_100_3_Right_137 VDD VSS gf180mcu_as_sc_mcu7t3v3__tap_2
XFILLER_115_136 VDD VDD VSS VSS gf180mcu_as_sc_mcu7t3v3__fillcap_4
XFILLER_115_158 VDD VDD VSS VSS gf180mcu_as_sc_mcu7t3v3__fillcap_8
X_3452_ VDD VDD VSS VSS _3452_/S _4104_/D _3452_/A _3454_/B gf180mcu_as_sc_mcu7t3v3__mux2_2
XFILLER_41_2 VDD VDD VSS VSS gf180mcu_as_sc_mcu7t3v3__fillcap_16
XFILLER_87_1380 VDD VDD VSS VSS gf180mcu_as_sc_mcu7t3v3__fillcap_16
X_3383_ VDD VDD VSS VSS _3477_/B _3383_/B _3383_/C _3384_/C gf180mcu_as_sc_mcu7t3v3__nor3_2
X_2403_ VDD VDD VSS VSS _4691_/A _4633_/A gf180mcu_as_sc_mcu7t3v3__inv_2
XFILLER_130_139 VDD VDD VSS VSS gf180mcu_as_sc_mcu7t3v3__fill_2
XFILLER_69_212 VDD VDD VSS VSS gf180mcu_as_sc_mcu7t3v3__fillcap_8
X_5122_ VDD VDD VSS VSS clkload7/A _5122_/D _5122_/Q gf180mcu_as_sc_mcu7t3v3__dfxtp_2
XFILLER_123_191 VDD VDD VSS VSS gf180mcu_as_sc_mcu7t3v3__fill_1
XFILLER_135_1356 VDD VDD VSS VSS gf180mcu_as_sc_mcu7t3v3__fillcap_4
X_5053_ VDD VDD VSS VSS _5082_/CLK _5053_/D _5053_/Q gf180mcu_as_sc_mcu7t3v3__dfxtp_2
XFILLER_37_142 VDD VDD VSS VSS gf180mcu_as_sc_mcu7t3v3__fillcap_16
X_4004_ VDD VDD VSS VSS _4986_/Q _4142_/B _4237_/B _4142_/D _4986_/D gf180mcu_as_sc_mcu7t3v3__ao22_2
X_4897__1070 VDD VDD VSS VSS _4897_/D gf180mcu_as_sc_mcu7t3v3__tiel_4
XFILLER_111_27 VDD VDD VSS VSS gf180mcu_as_sc_mcu7t3v3__fill_2
XFILLER_198_629 VDD VDD VSS VSS gf180mcu_as_sc_mcu7t3v3__fillcap_16
XFILLER_25_348 VDD VDD VSS VSS gf180mcu_as_sc_mcu7t3v3__fill_2
XFILLER_52_123 VDD VDD VSS VSS gf180mcu_as_sc_mcu7t3v3__fillcap_16
XFILLER_20_1294 VDD VDD VSS VSS gf180mcu_as_sc_mcu7t3v3__fill_1
XFILLER_107_1403 VDD VDD VSS VSS gf180mcu_as_sc_mcu7t3v3__fillcap_8
XFILLER_179_854 VDD VDD VSS VSS gf180mcu_as_sc_mcu7t3v3__fill_2
XFILLER_181_1332 VDD VDD VSS VSS gf180mcu_as_sc_mcu7t3v3__fillcap_16
X_4906_ VDD VDD VSS VSS _4933_/CLK _4906_/D _4906_/Q gf180mcu_as_sc_mcu7t3v3__dfxtp_2
XFILLER_21_554 VDD VDD VSS VSS gf180mcu_as_sc_mcu7t3v3__fillcap_4
X_4837_ VDD VDD VSS VSS _5073_/CLK _4837_/D _4837_/Q gf180mcu_as_sc_mcu7t3v3__dfxtp_2
XFILLER_14_1010 VDD VDD VSS VSS gf180mcu_as_sc_mcu7t3v3__fillcap_4
XFILLER_193_312 VDD VDD VSS VSS gf180mcu_as_sc_mcu7t3v3__fillcap_16
XTAP_TAPCELL_ROW_21_1200 VDD VSS gf180mcu_as_sc_mcu7t3v3__tap_2
XFILLER_14_1065 VDD VDD VSS VSS gf180mcu_as_sc_mcu7t3v3__fillcap_8
X_4768_ VDD VDD VSS VSS _5192_/CLK _4768_/D _4768_/Q gf180mcu_as_sc_mcu7t3v3__dfxtp_2
XFILLER_106_114 VDD VDD VSS VSS gf180mcu_as_sc_mcu7t3v3__fill_1
XFILLER_14_1087 VDD VDD VSS VSS gf180mcu_as_sc_mcu7t3v3__fillcap_16
X_4699_ VDD VDD VSS VSS _4707_/S _5254_/Q _4699_/A _5254_/D gf180mcu_as_sc_mcu7t3v3__mux2_2
X_3719_ VDD VDD VSS VSS _4935_/Q _3740_/B _3741_/C _4096_/D _3720_/D gf180mcu_as_sc_mcu7t3v3__ao22_2
XFILLER_106_125 VDD VDD VSS VSS gf180mcu_as_sc_mcu7t3v3__fill_2
XFILLER_161_220 VDD VDD VSS VSS gf180mcu_as_sc_mcu7t3v3__fill_2
XFILLER_179_1294 VDD VDD VSS VSS gf180mcu_as_sc_mcu7t3v3__fillcap_16
XFILLER_136_68 VDD VDD VSS VSS gf180mcu_as_sc_mcu7t3v3__fill_1
XFILLER_66_1453 VDD VDD VSS VSS gf180mcu_as_sc_mcu7t3v3__fillcap_16
XTAP_TAPCELL_ROW_59_1_1623 VDD VSS gf180mcu_as_sc_mcu7t3v3__tap_2
XTAP_TAPCELL_ROW_19_1140 VDD VSS gf180mcu_as_sc_mcu7t3v3__tap_2
XFILLER_153_1412 VDD VDD VSS VSS gf180mcu_as_sc_mcu7t3v3__fillcap_4
XFILLER_153_1434 VDD VDD VSS VSS gf180mcu_as_sc_mcu7t3v3__fillcap_4
XTAP_TAPCELL_ROW_19_1151 VDD VSS gf180mcu_as_sc_mcu7t3v3__tap_2
XFILLER_114_1407 VDD VDD VSS VSS gf180mcu_as_sc_mcu7t3v3__fill_2
Xinput304 VDD VDD VSS VSS west_in[29] _3788_/A gf180mcu_as_sc_mcu7t3v3__buff_12
Xinput315 VDD VDD VSS VSS west_in[8] _3997_/D gf180mcu_as_sc_mcu7t3v3__buff_12
XFILLER_29_66 VDD VDD VSS VSS gf180mcu_as_sc_mcu7t3v3__fillcap_4
XFILLER_5_1200 VDD VDD VSS VSS gf180mcu_as_sc_mcu7t3v3__fill_1
XTAP_TAPCELL_ROW_15_1059 VDD VSS gf180mcu_as_sc_mcu7t3v3__tap_2
XTAP_TAPCELL_ROW_69_3_2929 VDD VSS gf180mcu_as_sc_mcu7t3v3__tap_2
XFILLER_21_1014 VDD VDD VSS VSS gf180mcu_as_sc_mcu7t3v3__fillcap_16
XFILLER_25_1183 VDD VDD VSS VSS gf180mcu_as_sc_mcu7t3v3__fillcap_4
XFILLER_29_632 VDD VDD VSS VSS gf180mcu_as_sc_mcu7t3v3__fillcap_8
XFILLER_29_654 VDD VDD VSS VSS gf180mcu_as_sc_mcu7t3v3__fillcap_16
XFILLER_186_1221 VDD VDD VSS VSS gf180mcu_as_sc_mcu7t3v3__fillcap_4
XFILLER_205_906 VDD VDD VSS VSS gf180mcu_as_sc_mcu7t3v3__fillcap_4
XFILLER_5_1277 VDD VDD VSS VSS gf180mcu_as_sc_mcu7t3v3__fillcap_8
XFILLER_186_1243 VDD VDD VSS VSS gf180mcu_as_sc_mcu7t3v3__fillcap_16
XFILLER_205_928 VDD VDD VSS VSS gf180mcu_as_sc_mcu7t3v3__fillcap_16
XFILLER_38_1500 VDD VDD VSS VSS gf180mcu_as_sc_mcu7t3v3__fillcap_8
XFILLER_45_43 VDD VDD VSS VSS gf180mcu_as_sc_mcu7t3v3__fillcap_16
XFILLER_25_871 VDD VDD VSS VSS gf180mcu_as_sc_mcu7t3v3__fill_1
XFILLER_43_156 VDD VDD VSS VSS gf180mcu_as_sc_mcu7t3v3__fillcap_16
XFILLER_73_1413 VDD VDD VSS VSS gf180mcu_as_sc_mcu7t3v3__fill_2
XFILLER_188_139 VDD VDD VSS VSS gf180mcu_as_sc_mcu7t3v3__fillcap_16
XFILLER_24_381 VDD VDD VSS VSS gf180mcu_as_sc_mcu7t3v3__fillcap_4
XFILLER_31_329 VDD VDD VSS VSS gf180mcu_as_sc_mcu7t3v3__fillcap_16
XFILLER_73_1424 VDD VDD VSS VSS gf180mcu_as_sc_mcu7t3v3__fill_1
XFILLER_125_1558 VDD VDD VSS VSS gf180mcu_as_sc_mcu7t3v3__fillcap_8
XFILLER_12_576 VDD VDD VSS VSS gf180mcu_as_sc_mcu7t3v3__fill_2
XFILLER_201_1402 VDD VDD VSS VSS gf180mcu_as_sc_mcu7t3v3__fillcap_16
XFILLER_32_1110 VDD VDD VSS VSS gf180mcu_as_sc_mcu7t3v3__fillcap_16
XFILLER_8_514 VDD VDD VSS VSS gf180mcu_as_sc_mcu7t3v3__fillcap_8
XFILLER_144_209 VDD VDD VSS VSS gf180mcu_as_sc_mcu7t3v3__fillcap_8
XFILLER_200_699 VDD VDD VSS VSS gf180mcu_as_sc_mcu7t3v3__fillcap_16
XANTENNA_8 VDD VDD VSS VSS _4855_/D gf180mcu_as_sc_mcu7t3v3__diode_2
XFILLER_193_890 VDD VDD VSS VSS gf180mcu_as_sc_mcu7t3v3__fillcap_16
XFILLER_6_37 VDD VDD VSS VSS gf180mcu_as_sc_mcu7t3v3__fillcap_16
XFILLER_10_1496 VDD VDD VSS VSS gf180mcu_as_sc_mcu7t3v3__fillcap_8
XFILLER_84_1520 VDD VDD VSS VSS gf180mcu_as_sc_mcu7t3v3__fill_1
XTAP_TAPCELL_ROW_106_1_1762 VDD VSS gf180mcu_as_sc_mcu7t3v3__tap_2
XTAP_TAPCELL_ROW_118_3_3074 VDD VSS gf180mcu_as_sc_mcu7t3v3__tap_2
XTAP_TAPCELL_ROW_210_2793 VDD VSS gf180mcu_as_sc_mcu7t3v3__tap_2
XTAP_TAPCELL_ROW_210_2782 VDD VSS gf180mcu_as_sc_mcu7t3v3__tap_2
XTAP_TAPCELL_ROW_185_2236 VDD VSS gf180mcu_as_sc_mcu7t3v3__tap_2
XTAP_TAPCELL_ROW_185_2247 VDD VSS gf180mcu_as_sc_mcu7t3v3__tap_2
XFILLER_0_981 VDD VDD VSS VSS gf180mcu_as_sc_mcu7t3v3__fill_1
XFILLER_0_992 VDD VDD VSS VSS gf180mcu_as_sc_mcu7t3v3__fill_1
XFILLER_120_172 VDD VDD VSS VSS gf180mcu_as_sc_mcu7t3v3__fill_2
X_4870__1096 VDD VDD VSS VSS _4870_/D gf180mcu_as_sc_mcu7t3v3__tiel_4
XFILLER_19_142 VDD VDD VSS VSS gf180mcu_as_sc_mcu7t3v3__fillcap_16
XFILLER_91_1502 VDD VDD VSS VSS gf180mcu_as_sc_mcu7t3v3__fillcap_16
XPHY_EDGE_ROW_125_1_Right_646 VDD VSS gf180mcu_as_sc_mcu7t3v3__tap_2
XFILLER_206_1313 VDD VDD VSS VSS gf180mcu_as_sc_mcu7t3v3__fillcap_16
X_2952_ VDD VDD VSS VSS _3925_/A _3042_/C _2952_/C _3078_/B _2954_/C gf180mcu_as_sc_mcu7t3v3__ao22_2
XFILLER_91_1568 VDD VDD VSS VSS gf180mcu_as_sc_mcu7t3v3__fill_1
XFILLER_198_1103 VDD VDD VSS VSS gf180mcu_as_sc_mcu7t3v3__fillcap_16
XFILLER_30_351 VDD VDD VSS VSS gf180mcu_as_sc_mcu7t3v3__fill_1
XFILLER_89_2 VDD VDD VSS VSS gf180mcu_as_sc_mcu7t3v3__fillcap_8
X_2883_ VDD VDD VSS VSS _2884_/B _4708_/C _2883_/B _4655_/B gf180mcu_as_sc_mcu7t3v3__aoi21_2
XFILLER_141_1360 VDD VDD VSS VSS gf180mcu_as_sc_mcu7t3v3__fill_2
XFILLER_15_1374 VDD VDD VSS VSS gf180mcu_as_sc_mcu7t3v3__fill_1
XFILLER_175_345 VDD VDD VSS VSS gf180mcu_as_sc_mcu7t3v3__fillcap_4
XFILLER_204_1081 VDD VDD VSS VSS gf180mcu_as_sc_mcu7t3v3__fillcap_4
X_4622_ VDD VDD VSS VSS _5216_/Q _4622_/B _4622_/C _5217_/Q _5216_/D gf180mcu_as_sc_mcu7t3v3__ao22_2
XFILLER_141_1393 VDD VDD VSS VSS gf180mcu_as_sc_mcu7t3v3__fillcap_16
XFILLER_15_1396 VDD VDD VSS VSS gf180mcu_as_sc_mcu7t3v3__fillcap_4
X_4553_ VDD VDD VSS VSS _4561_/A _4553_/B _4553_/C _4556_/C _4582_/A gf180mcu_as_sc_mcu7t3v3__aoi211_2
XTAP_TAPCELL_ROW_174_1995 VDD VSS gf180mcu_as_sc_mcu7t3v3__tap_2
XTAP_TAPCELL_ROW_174_1984 VDD VSS gf180mcu_as_sc_mcu7t3v3__tap_2
XTAP_TAPCELL_ROW_174_1973 VDD VSS gf180mcu_as_sc_mcu7t3v3__tap_2
XFILLER_143_220 VDD VDD VSS VSS gf180mcu_as_sc_mcu7t3v3__fill_2
X_4484_ VDD VDD VSS VSS _4485_/B _4484_/A gf180mcu_as_sc_mcu7t3v3__inv_2
X_3504_ VDD VDD VSS VSS _4162_/A _3504_/B _3504_/C _3504_/D _3505_/B gf180mcu_as_sc_mcu7t3v3__ao211_2
XPHY_EDGE_ROW_101_3_Right_138 VDD VSS gf180mcu_as_sc_mcu7t3v3__tap_2
X_3435_ VDD VDD VSS VSS _4088_/D _3466_/B _3435_/C _3435_/D _3437_/C gf180mcu_as_sc_mcu7t3v3__ao211_2
XFILLER_106_27 VDD VDD VSS VSS gf180mcu_as_sc_mcu7t3v3__fillcap_8
X_3366_ VDD VDD VSS VSS _4016_/A _3453_/B _3453_/C _4017_/A _3367_/C gf180mcu_as_sc_mcu7t3v3__ao22_2
X_5105_ VDD VDD VSS VSS _5260_/CLK _5105_/D _5105_/Q gf180mcu_as_sc_mcu7t3v3__dfxtp_2
X_3297_ VDD VDD VSS VSS _4917_/Q _3402_/B _3402_/C _3950_/A _3299_/C gf180mcu_as_sc_mcu7t3v3__ao22_2
XFILLER_111_194 VDD VDD VSS VSS gf180mcu_as_sc_mcu7t3v3__fill_2
XFILLER_22_1312 VDD VDD VSS VSS gf180mcu_as_sc_mcu7t3v3__fill_2
XFILLER_26_1481 VDD VDD VSS VSS gf180mcu_as_sc_mcu7t3v3__fill_1
XFILLER_6_1542 VDD VDD VSS VSS gf180mcu_as_sc_mcu7t3v3__fill_2
X_5036_ VDD VDD VSS VSS _5090_/CLK _5036_/D _5036_/Q gf180mcu_as_sc_mcu7t3v3__dfxtp_2
XFILLER_122_37 VDD VDD VSS VSS gf180mcu_as_sc_mcu7t3v3__fillcap_8
XFILLER_22_1367 VDD VDD VSS VSS gf180mcu_as_sc_mcu7t3v3__fillcap_8
XFILLER_26_613 VDD VDD VSS VSS gf180mcu_as_sc_mcu7t3v3__fill_2
XFILLER_2_1417 VDD VDD VSS VSS gf180mcu_as_sc_mcu7t3v3__fillcap_16
XFILLER_26_657 VDD VDD VSS VSS gf180mcu_as_sc_mcu7t3v3__fillcap_8
XFILLER_96_1446 VDD VDD VSS VSS gf180mcu_as_sc_mcu7t3v3__fillcap_4
XTAP_TAPCELL_ROW_132_1_1841 VDD VSS gf180mcu_as_sc_mcu7t3v3__tap_2
XTAP_TAPCELL_ROW_144_3_3153 VDD VSS gf180mcu_as_sc_mcu7t3v3__tap_2
XTAP_TAPCELL_ROW_1_756 VDD VSS gf180mcu_as_sc_mcu7t3v3__tap_2
XTAP_TAPCELL_ROW_1_745 VDD VSS gf180mcu_as_sc_mcu7t3v3__tap_2
XFILLER_179_640 VDD VDD VSS VSS gf180mcu_as_sc_mcu7t3v3__fill_2
XFILLER_202_909 VDD VDD VSS VSS gf180mcu_as_sc_mcu7t3v3__fillcap_16
XFILLER_40_104 VDD VDD VSS VSS gf180mcu_as_sc_mcu7t3v3__fill_1
XFILLER_201_419 VDD VDD VSS VSS gf180mcu_as_sc_mcu7t3v3__fill_1
XFILLER_178_172 VDD VDD VSS VSS gf180mcu_as_sc_mcu7t3v3__fill_2
XFILLER_193_120 VDD VDD VSS VSS gf180mcu_as_sc_mcu7t3v3__fillcap_16
XFILLER_193_142 VDD VDD VSS VSS gf180mcu_as_sc_mcu7t3v3__fillcap_16
XFILLER_31_34 VDD VDD VSS VSS gf180mcu_as_sc_mcu7t3v3__fillcap_16
XPHY_EDGE_ROW_63_3_Right_100 VDD VSS gf180mcu_as_sc_mcu7t3v3__tap_2
XFILLER_193_186 VDD VDD VSS VSS gf180mcu_as_sc_mcu7t3v3__fill_2
XFILLER_194_1501 VDD VDD VSS VSS gf180mcu_as_sc_mcu7t3v3__fillcap_4
XFILLER_68_1504 VDD VDD VSS VSS gf180mcu_as_sc_mcu7t3v3__fill_2
XFILLER_134_220 VDD VDD VSS VSS gf180mcu_as_sc_mcu7t3v3__fill_2
XFILLER_193_197 VDD VDD VSS VSS gf180mcu_as_sc_mcu7t3v3__fill_1
XFILLER_194_1523 VDD VDD VSS VSS gf180mcu_as_sc_mcu7t3v3__fillcap_16
XFILLER_190_871 VDD VDD VSS VSS gf180mcu_as_sc_mcu7t3v3__fillcap_4
XFILLER_190_893 VDD VDD VSS VSS gf180mcu_as_sc_mcu7t3v3__fillcap_16
XFILLER_163_22 VDD VDD VSS VSS gf180mcu_as_sc_mcu7t3v3__fillcap_16
XFILLER_0_244 VDD VDD VSS VSS gf180mcu_as_sc_mcu7t3v3__fill_2
XFILLER_192_1291 VDD VDD VSS VSS gf180mcu_as_sc_mcu7t3v3__fillcap_4
XFILLER_27_1223 VDD VDD VSS VSS gf180mcu_as_sc_mcu7t3v3__fillcap_4
XFILLER_7_1306 VDD VDD VSS VSS gf180mcu_as_sc_mcu7t3v3__fillcap_8
Xinput101 VDD VDD VSS VSS ne_in[30] _3800_/A gf180mcu_as_sc_mcu7t3v3__buff_12
XFILLER_118_1373 VDD VDD VSS VSS gf180mcu_as_sc_mcu7t3v3__fillcap_8
XFILLER_163_88 VDD VDD VSS VSS gf180mcu_as_sc_mcu7t3v3__fillcap_16
XFILLER_209_508 VDD VDD VSS VSS gf180mcu_as_sc_mcu7t3v3__fillcap_16
XFILLER_27_1278 VDD VDD VSS VSS gf180mcu_as_sc_mcu7t3v3__fillcap_8
Xinput112 VDD VDD VSS VSS north_in[0] _3930_/A gf180mcu_as_sc_mcu7t3v3__buff_12
Xinput123 VDD VDD VSS VSS north_in[1] _3940_/A gf180mcu_as_sc_mcu7t3v3__buff_12
Xinput134 VDD VDD VSS VSS north_in[2] _3950_/A gf180mcu_as_sc_mcu7t3v3__buff_12
Xinput145 VDD VDD VSS VSS north_in[9] _4005_/A gf180mcu_as_sc_mcu7t3v3__buff_12
XTAP_TAPCELL_ROW_88_3_2984 VDD VSS gf180mcu_as_sc_mcu7t3v3__tap_2
XTAP_TAPCELL_ROW_34_1479 VDD VSS gf180mcu_as_sc_mcu7t3v3__tap_2
XTAP_TAPCELL_ROW_34_1468 VDD VSS gf180mcu_as_sc_mcu7t3v3__tap_2
Xinput156 VDD VDD VSS VSS nw_in[19] _4086_/A gf180mcu_as_sc_mcu7t3v3__buff_12
Xinput167 VDD VDD VSS VSS nw_in[29] _3792_/A gf180mcu_as_sc_mcu7t3v3__buff_12
Xinput178 VDD VDD VSS VSS nw_in[8] _3998_/A gf180mcu_as_sc_mcu7t3v3__buff_12
XTAP_TAPCELL_ROW_180_2133 VDD VSS gf180mcu_as_sc_mcu7t3v3__tap_2
XTAP_TAPCELL_ROW_180_2122 VDD VSS gf180mcu_as_sc_mcu7t3v3__tap_2
XFILLER_56_53 VDD VDD VSS VSS gf180mcu_as_sc_mcu7t3v3__fillcap_16
XFILLER_63_207 VDD VDD VSS VSS gf180mcu_as_sc_mcu7t3v3__fill_2
Xinput189 VDD VDD VSS VSS se_in[17] _4073_/A gf180mcu_as_sc_mcu7t3v3__buff_12
XFILLER_16_123 VDD VDD VSS VSS gf180mcu_as_sc_mcu7t3v3__fill_1
XFILLER_17_646 VDD VDD VSS VSS gf180mcu_as_sc_mcu7t3v3__fill_1
XFILLER_189_415 VDD VDD VSS VSS gf180mcu_as_sc_mcu7t3v3__fillcap_4
XFILLER_204_279 VDD VDD VSS VSS gf180mcu_as_sc_mcu7t3v3__fillcap_16
XFILLER_31_126 VDD VDD VSS VSS gf180mcu_as_sc_mcu7t3v3__fill_2
XPHY_EDGE_ROW_4_Left_215 VDD VSS gf180mcu_as_sc_mcu7t3v3__tap_2
XTAP_TAPCELL_ROW_178_2084 VDD VSS gf180mcu_as_sc_mcu7t3v3__tap_2
XFILLER_185_610 VDD VDD VSS VSS gf180mcu_as_sc_mcu7t3v3__fill_2
XFILLER_185_632 VDD VDD VSS VSS gf180mcu_as_sc_mcu7t3v3__fillcap_8
XFILLER_188_85 VDD VDD VSS VSS gf180mcu_as_sc_mcu7t3v3__fillcap_16
XFILLER_197_470 VDD VDD VSS VSS gf180mcu_as_sc_mcu7t3v3__fillcap_16
XFILLER_197_492 VDD VDD VSS VSS gf180mcu_as_sc_mcu7t3v3__fillcap_16
XFILLER_200_441 VDD VDD VSS VSS gf180mcu_as_sc_mcu7t3v3__fillcap_8
XFILLER_72_96 VDD VDD VSS VSS gf180mcu_as_sc_mcu7t3v3__fillcap_8
XFILLER_9_834 VDD VDD VSS VSS gf180mcu_as_sc_mcu7t3v3__fill_2
XTAP_TAPCELL_ROW_178_2095 VDD VSS gf180mcu_as_sc_mcu7t3v3__tap_2
XFILLER_125_1399 VDD VDD VSS VSS gf180mcu_as_sc_mcu7t3v3__fillcap_16
XFILLER_12_1503 VDD VDD VSS VSS gf180mcu_as_sc_mcu7t3v3__fill_2
XFILLER_185_665 VDD VDD VSS VSS gf180mcu_as_sc_mcu7t3v3__fillcap_16
XFILLER_199_1434 VDD VDD VSS VSS gf180mcu_as_sc_mcu7t3v3__fillcap_16
XFILLER_9_867 VDD VDD VSS VSS gf180mcu_as_sc_mcu7t3v3__fillcap_8
XTAP_TAPCELL_ROW_170_3_3232 VDD VSS gf180mcu_as_sc_mcu7t3v3__tap_2
XFILLER_8_377 VDD VDD VSS VSS gf180mcu_as_sc_mcu7t3v3__fillcap_8
XFILLER_125_220 VDD VDD VSS VSS gf180mcu_as_sc_mcu7t3v3__fill_2
XFILLER_8_399 VDD VDD VSS VSS gf180mcu_as_sc_mcu7t3v3__fillcap_8
XFILLER_181_882 VDD VDD VSS VSS gf180mcu_as_sc_mcu7t3v3__fillcap_16
XFILLER_4_583 VDD VDD VSS VSS gf180mcu_as_sc_mcu7t3v3__fill_1
XFILLER_49_1481 VDD VDD VSS VSS gf180mcu_as_sc_mcu7t3v3__fillcap_4
XFILLER_84_1383 VDD VDD VSS VSS gf180mcu_as_sc_mcu7t3v3__fillcap_4
XTAP_TAPCELL_ROW_137_1_1856 VDD VSS gf180mcu_as_sc_mcu7t3v3__tap_2
XTAP_TAPCELL_ROW_149_3_3168 VDD VSS gf180mcu_as_sc_mcu7t3v3__tap_2
X_3220_ VDD VDD VSS VSS _3283_/A _3817_/A _3558_/B gf180mcu_as_sc_mcu7t3v3__and2_2
X_3151_ VDD VDD VSS VSS _3176_/S _4126_/D _4130_/A _3153_/B gf180mcu_as_sc_mcu7t3v3__mux2_2
XFILLER_132_1348 VDD VDD VSS VSS gf180mcu_as_sc_mcu7t3v3__fillcap_16
XPHY_EDGE_ROW_135_1_Left_345 VDD VSS gf180mcu_as_sc_mcu7t3v3__tap_2
X_3082_ VDD VDD VSS VSS _4064_/A _3229_/B _3150_/C _4064_/D _3088_/B gf180mcu_as_sc_mcu7t3v3__ao22_2
XFILLER_36_988 VDD VDD VSS VSS gf180mcu_as_sc_mcu7t3v3__fillcap_16
XFILLER_22_104 VDD VDD VSS VSS gf180mcu_as_sc_mcu7t3v3__fill_1
XFILLER_22_115 VDD VDD VSS VSS gf180mcu_as_sc_mcu7t3v3__fillcap_4
XFILLER_35_487 VDD VDD VSS VSS gf180mcu_as_sc_mcu7t3v3__fill_2
XFILLER_56_1430 VDD VDD VSS VSS gf180mcu_as_sc_mcu7t3v3__fill_1
XFILLER_56_1441 VDD VDD VSS VSS gf180mcu_as_sc_mcu7t3v3__fillcap_8
XPHY_EDGE_ROW_126_1_Right_647 VDD VSS gf180mcu_as_sc_mcu7t3v3__tap_2
XFILLER_189_960 VDD VDD VSS VSS gf180mcu_as_sc_mcu7t3v3__fillcap_16
XFILLER_189_982 VDD VDD VSS VSS gf180mcu_as_sc_mcu7t3v3__fillcap_16
XFILLER_195_418 VDD VDD VSS VSS gf180mcu_as_sc_mcu7t3v3__fill_2
X_3984_ VDD VDD VSS VSS _3984_/A _4104_/B _4104_/C _3984_/D _3985_/D gf180mcu_as_sc_mcu7t3v3__ao22_2
X_2935_ VDD VDD VSS VSS _3514_/A _3523_/A _3528_/B gf180mcu_as_sc_mcu7t3v3__or2_2
XFILLER_143_1488 VDD VDD VSS VSS gf180mcu_as_sc_mcu7t3v3__fillcap_4
XFILLER_175_120 VDD VDD VSS VSS gf180mcu_as_sc_mcu7t3v3__fillcap_4
XFILLER_175_142 VDD VDD VSS VSS gf180mcu_as_sc_mcu7t3v3__fill_2
XFILLER_17_1469 VDD VDD VSS VSS gf180mcu_as_sc_mcu7t3v3__fill_1
X_2866_ VDD VDD VSS VSS _4742_/A _2871_/B _2866_/C _4764_/D gf180mcu_as_sc_mcu7t3v3__nor3_2
XFILLER_178_1507 VDD VDD VSS VSS gf180mcu_as_sc_mcu7t3v3__fillcap_8
XFILLER_190_101 VDD VDD VSS VSS gf180mcu_as_sc_mcu7t3v3__fillcap_4
X_4605_ VDD VDD VSS VSS _5199_/Q _4622_/B _4629_/C _5200_/Q _5199_/D gf180mcu_as_sc_mcu7t3v3__ao22_2
XFILLER_190_123 VDD VDD VSS VSS gf180mcu_as_sc_mcu7t3v3__fillcap_8
XPHY_EDGE_ROW_196_Right_59 VDD VSS gf180mcu_as_sc_mcu7t3v3__tap_2
X_2797_ VDD VDD VSS VSS _2797_/A _4626_/B _2806_/A _2797_/D _2800_/A gf180mcu_as_sc_mcu7t3v3__ao211_2
XFILLER_89_104 VDD VDD VSS VSS gf180mcu_as_sc_mcu7t3v3__fill_1
X_4536_ VDD VDD VSS VSS _4536_/S _5082_/Q _4995_/Q _4537_/A gf180mcu_as_sc_mcu7t3v3__mux2_2
XFILLER_131_212 VDD VDD VSS VSS gf180mcu_as_sc_mcu7t3v3__fillcap_8
XFILLER_176_1297 VDD VDD VSS VSS gf180mcu_as_sc_mcu7t3v3__fill_2
XPHY_EDGE_ROW_102_3_Right_139 VDD VSS gf180mcu_as_sc_mcu7t3v3__tap_2
X_4467_ VDD VDD VSS VSS _5175_/Q _4470_/B _4540_/C _5109_/Q _4468_/B gf180mcu_as_sc_mcu7t3v3__ao22_2
Xfanout802 VDD VDD VSS VSS _4488_/A _4527_/S gf180mcu_as_sc_mcu7t3v3__buff_12
Xfanout813 VDD VDD VSS VSS _2666_/A _2701_/A gf180mcu_as_sc_mcu7t3v3__buff_12
Xfanout824 VDD VDD VSS VSS _3795_/A _3907_/A gf180mcu_as_sc_mcu7t3v3__buff_12
X_4398_ VDD VDD VSS VSS _5166_/Q _4504_/B _4398_/C _4398_/D _5166_/D gf180mcu_as_sc_mcu7t3v3__ao211_2
X_3418_ VDD VDD VSS VSS _4072_/D _3466_/B _3418_/C _3479_/C _3420_/C gf180mcu_as_sc_mcu7t3v3__ao211_2
X_3349_ VDD VDD VSS VSS _3467_/B _3997_/A _3349_/A _3351_/B gf180mcu_as_sc_mcu7t3v3__mux2_2
XTAP_TAPCELL_ROW_6_859 VDD VSS gf180mcu_as_sc_mcu7t3v3__tap_2
XFILLER_115_1568 VDD VDD VSS VSS gf180mcu_as_sc_mcu7t3v3__fill_1
XFILLER_63_1478 VDD VDD VSS VSS gf180mcu_as_sc_mcu7t3v3__fill_1
XFILLER_98_1519 VDD VDD VSS VSS gf180mcu_as_sc_mcu7t3v3__fill_2
XPHY_EDGE_ROW_67_1_Left_277 VDD VSS gf180mcu_as_sc_mcu7t3v3__tap_2
XFILLER_133_69 VDD VDD VSS VSS gf180mcu_as_sc_mcu7t3v3__fill_1
XFILLER_22_1131 VDD VDD VSS VSS gf180mcu_as_sc_mcu7t3v3__fill_1
XFILLER_199_702 VDD VDD VSS VSS gf180mcu_as_sc_mcu7t3v3__fillcap_16
XFILLER_27_944 VDD VDD VSS VSS gf180mcu_as_sc_mcu7t3v3__fillcap_16
XFILLER_6_1394 VDD VDD VSS VSS gf180mcu_as_sc_mcu7t3v3__fillcap_4
X_5019_ VDD VDD VSS VSS clkload5/A _5019_/D _5019_/Q gf180mcu_as_sc_mcu7t3v3__dfxtp_2
XFILLER_165_6 VDD VDD VSS VSS gf180mcu_as_sc_mcu7t3v3__fillcap_16
XFILLER_26_454 VDD VDD VSS VSS gf180mcu_as_sc_mcu7t3v3__fill_1
XTAP_TAPCELL_ROW_163_1_1935 VDD VSS gf180mcu_as_sc_mcu7t3v3__tap_2
XFILLER_13_104 VDD VDD VSS VSS gf180mcu_as_sc_mcu7t3v3__fillcap_16
XFILLER_186_418 VDD VDD VSS VSS gf180mcu_as_sc_mcu7t3v3__fillcap_16
XFILLER_35_1503 VDD VDD VSS VSS gf180mcu_as_sc_mcu7t3v3__fillcap_8
XFILLER_179_492 VDD VDD VSS VSS gf180mcu_as_sc_mcu7t3v3__fill_2
XFILLER_122_1517 VDD VDD VSS VSS gf180mcu_as_sc_mcu7t3v3__fillcap_4
XFILLER_161_1566 VDD VDD VSS VSS gf180mcu_as_sc_mcu7t3v3__fill_2
XFILLER_210_750 VDD VDD VSS VSS gf180mcu_as_sc_mcu7t3v3__fill_1
XFILLER_21_170 VDD VDD VSS VSS gf180mcu_as_sc_mcu7t3v3__fill_2
XFILLER_70_1449 VDD VDD VSS VSS gf180mcu_as_sc_mcu7t3v3__fill_2
XFILLER_10_855 VDD VDD VSS VSS gf180mcu_as_sc_mcu7t3v3__fillcap_4
XFILLER_10_877 VDD VDD VSS VSS gf180mcu_as_sc_mcu7t3v3__fillcap_16
XFILLER_182_613 VDD VDD VSS VSS gf180mcu_as_sc_mcu7t3v3__fillcap_16
XFILLER_194_473 VDD VDD VSS VSS gf180mcu_as_sc_mcu7t3v3__fillcap_16
XFILLER_42_88 VDD VDD VSS VSS gf180mcu_as_sc_mcu7t3v3__fillcap_16
XFILLER_6_804 VDD VDD VSS VSS gf180mcu_as_sc_mcu7t3v3__fill_1
XPHY_EDGE_ROW_64_3_Right_101 VDD VSS gf180mcu_as_sc_mcu7t3v3__tap_2
XFILLER_107_220 VDD VDD VSS VSS gf180mcu_as_sc_mcu7t3v3__fill_2
XFILLER_158_99 VDD VDD VSS VSS gf180mcu_as_sc_mcu7t3v3__fillcap_4
XFILLER_206_2 VDD VDD VSS VSS gf180mcu_as_sc_mcu7t3v3__fillcap_16
XFILLER_5_369 VDD VDD VSS VSS gf180mcu_as_sc_mcu7t3v3__fill_1
XTAP_TAPCELL_ROW_36_1519 VDD VSS gf180mcu_as_sc_mcu7t3v3__tap_2
XFILLER_27_1064 VDD VDD VSS VSS gf180mcu_as_sc_mcu7t3v3__fill_1
XPHY_EDGE_ROW_157_3_Left_542 VDD VSS gf180mcu_as_sc_mcu7t3v3__tap_2
XFILLER_88_170 VDD VDD VSS VSS gf180mcu_as_sc_mcu7t3v3__fillcap_4
XFILLER_188_1135 VDD VDD VSS VSS gf180mcu_as_sc_mcu7t3v3__fillcap_16
XFILLER_190_53 VDD VDD VSS VSS gf180mcu_as_sc_mcu7t3v3__fillcap_16
XFILLER_188_1157 VDD VDD VSS VSS gf180mcu_as_sc_mcu7t3v3__fillcap_16
XFILLER_17_454 VDD VDD VSS VSS gf180mcu_as_sc_mcu7t3v3__fillcap_8
XFILLER_79_1474 VDD VDD VSS VSS gf180mcu_as_sc_mcu7t3v3__fill_2
XFILLER_79_1485 VDD VDD VSS VSS gf180mcu_as_sc_mcu7t3v3__fill_1
Xclkbuf_3_1__f_clk_regs VDD VDD VSS VSS clkbuf_2_0_0_clk_regs/Y clkload0/A gf180mcu_as_sc_mcu7t3v3__clkbuff_12
XTAP_TAPCELL_ROW_205_2692 VDD VSS gf180mcu_as_sc_mcu7t3v3__tap_2
XTAP_TAPCELL_ROW_205_2681 VDD VSS gf180mcu_as_sc_mcu7t3v3__tap_2
XFILLER_32_413 VDD VDD VSS VSS gf180mcu_as_sc_mcu7t3v3__fillcap_16
XFILLER_177_418 VDD VDD VSS VSS gf180mcu_as_sc_mcu7t3v3__fill_2
XFILLER_32_457 VDD VDD VSS VSS gf180mcu_as_sc_mcu7t3v3__fillcap_16
XTAP_TAPCELL_ROW_201_2589 VDD VSS gf180mcu_as_sc_mcu7t3v3__tap_2
XFILLER_186_941 VDD VDD VSS VSS gf180mcu_as_sc_mcu7t3v3__fillcap_4
XFILLER_34_1002 VDD VDD VSS VSS gf180mcu_as_sc_mcu7t3v3__fillcap_8
XFILLER_157_120 VDD VDD VSS VSS gf180mcu_as_sc_mcu7t3v3__fillcap_16
XFILLER_157_142 VDD VDD VSS VSS gf180mcu_as_sc_mcu7t3v3__fill_1
XFILLER_186_963 VDD VDD VSS VSS gf180mcu_as_sc_mcu7t3v3__fillcap_16
XFILLER_201_750 VDD VDD VSS VSS gf180mcu_as_sc_mcu7t3v3__fillcap_16
XFILLER_201_772 VDD VDD VSS VSS gf180mcu_as_sc_mcu7t3v3__fillcap_16
XPHY_EDGE_ROW_50_1_Right_571 VDD VSS gf180mcu_as_sc_mcu7t3v3__tap_2
X_2720_ VDD VDD VSS VSS _2734_/S _2720_/B _2720_/A _2721_/C gf180mcu_as_sc_mcu7t3v3__mux2_2
XFILLER_12_192 VDD VDD VSS VSS gf180mcu_as_sc_mcu7t3v3__fillcap_16
XFILLER_172_101 VDD VDD VSS VSS gf180mcu_as_sc_mcu7t3v3__fillcap_4
XFILLER_8_141 VDD VDD VSS VSS gf180mcu_as_sc_mcu7t3v3__fill_1
X_2651_ VDD VDD VSS VSS _2657_/C _2737_/A _2736_/B input7/Y gf180mcu_as_sc_mcu7t3v3__aoi21_2
XFILLER_103_1450 VDD VDD VSS VSS gf180mcu_as_sc_mcu7t3v3__fillcap_16
XFILLER_157_186 VDD VDD VSS VSS gf180mcu_as_sc_mcu7t3v3__fillcap_4
XFILLER_172_123 VDD VDD VSS VSS gf180mcu_as_sc_mcu7t3v3__fillcap_4
XFILLER_201_1084 VDD VDD VSS VSS gf180mcu_as_sc_mcu7t3v3__fillcap_16
Xoutput416 VDD VDD VSS VSS _4835_/Q south_out[30] gf180mcu_as_sc_mcu7t3v3__buff_12
Xoutput405 VDD VDD VSS VSS _4825_/Q south_out[20] gf180mcu_as_sc_mcu7t3v3__buff_12
X_2582_ VDD VDD VSS VSS _2583_/D _2729_/C _2722_/B input2/Y gf180mcu_as_sc_mcu7t3v3__aoi21b_2
XFILLER_113_201 VDD VDD VSS VSS gf180mcu_as_sc_mcu7t3v3__fillcap_8
XFILLER_113_212 VDD VDD VSS VSS gf180mcu_as_sc_mcu7t3v3__fillcap_8
XFILLER_12_1399 VDD VDD VSS VSS gf180mcu_as_sc_mcu7t3v3__fill_2
XFILLER_47_1418 VDD VDD VSS VSS gf180mcu_as_sc_mcu7t3v3__fillcap_16
Xoutput449 VDD VDD VSS VSS _4875_/Q west_out[2] gf180mcu_as_sc_mcu7t3v3__buff_12
Xoutput438 VDD VDD VSS VSS _4874_/Q west_out[1] gf180mcu_as_sc_mcu7t3v3__buff_12
Xoutput427 VDD VDD VSS VSS _4873_/Q west_out[0] gf180mcu_as_sc_mcu7t3v3__buff_12
X_4321_ VDD VDD VSS VSS _4324_/S _5151_/Q _5150_/Q _5150_/D gf180mcu_as_sc_mcu7t3v3__mux2_2
XPHY_EDGE_ROW_89_3_Left_474 VDD VSS gf180mcu_as_sc_mcu7t3v3__tap_2
X_4252_ VDD VDD VSS VSS _4255_/S _4252_/B _5088_/Q _5088_/D gf180mcu_as_sc_mcu7t3v3__mux2_2
XFILLER_86_107 VDD VDD VSS VSS gf180mcu_as_sc_mcu7t3v3__fillcap_16
X_3203_ VDD VDD VSS VSS _3213_/D _3203_/A _3203_/B _3210_/B _3205_/B gf180mcu_as_sc_mcu7t3v3__ao31_2
XFILLER_210_1309 VDD VDD VSS VSS gf180mcu_as_sc_mcu7t3v3__fill_2
X_4183_ VDD VDD VSS VSS _4243_/B _4191_/B _4191_/C _5021_/Q _5021_/D gf180mcu_as_sc_mcu7t3v3__ao22_2
XTAP_TAPCELL_ROW_3_807 VDD VSS gf180mcu_as_sc_mcu7t3v3__tap_2
XFILLER_27_207 VDD VDD VSS VSS gf180mcu_as_sc_mcu7t3v3__fill_2
X_3134_ VDD VDD VSS VSS _3143_/S _4109_/D _4113_/A _3136_/B gf180mcu_as_sc_mcu7t3v3__mux2_2
X_3065_ VDD VDD VSS VSS _4043_/A _3141_/B _3065_/C _3065_/Y _3691_/D gf180mcu_as_sc_mcu7t3v3__aoi211_2
XTAP_TAPCELL_ROW_53_1_1604 VDD VSS gf180mcu_as_sc_mcu7t3v3__tap_2
XFILLER_184_1511 VDD VDD VSS VSS gf180mcu_as_sc_mcu7t3v3__fill_1
XFILLER_36_741 VDD VDD VSS VSS gf180mcu_as_sc_mcu7t3v3__fillcap_4
XFILLER_3_1567 VDD VDD VSS VSS gf180mcu_as_sc_mcu7t3v3__fill_2
XFILLER_58_1514 VDD VDD VSS VSS gf180mcu_as_sc_mcu7t3v3__fillcap_4
XFILLER_208_1205 VDD VDD VSS VSS gf180mcu_as_sc_mcu7t3v3__fillcap_16
XFILLER_208_1227 VDD VDD VSS VSS gf180mcu_as_sc_mcu7t3v3__fillcap_16
XFILLER_24_925 VDD VDD VSS VSS gf180mcu_as_sc_mcu7t3v3__fill_1
XFILLER_24_947 VDD VDD VSS VSS gf180mcu_as_sc_mcu7t3v3__fillcap_16
XFILLER_24_969 VDD VDD VSS VSS gf180mcu_as_sc_mcu7t3v3__fill_1
XFILLER_10_107 VDD VDD VSS VSS gf180mcu_as_sc_mcu7t3v3__fillcap_16
XFILLER_17_1233 VDD VDD VSS VSS gf180mcu_as_sc_mcu7t3v3__fillcap_16
XPHY_EDGE_ROW_127_1_Right_648 VDD VSS gf180mcu_as_sc_mcu7t3v3__tap_2
X_3967_ VDD VDD VSS VSS _3967_/A _4023_/B _4023_/C _4919_/Q _3969_/C gf180mcu_as_sc_mcu7t3v3__ao22_2
XFILLER_108_1383 VDD VDD VSS VSS gf180mcu_as_sc_mcu7t3v3__fillcap_4
XFILLER_17_1266 VDD VDD VSS VSS gf180mcu_as_sc_mcu7t3v3__fill_2
X_2918_ VDD VDD VSS VSS _3280_/B _3792_/A _3801_/A gf180mcu_as_sc_mcu7t3v3__nor2_2
X_3898_ VDD VDD VSS VSS _3903_/B _5188_/Q _4938_/D gf180mcu_as_sc_mcu7t3v3__and2_2
XFILLER_12_69 VDD VDD VSS VSS gf180mcu_as_sc_mcu7t3v3__fillcap_16
X_2849_ VDD VDD VSS VSS _2851_/B _3868_/C _4338_/A _2849_/A gf180mcu_as_sc_mcu7t3v3__aoi21_2
XFILLER_178_1359 VDD VDD VSS VSS gf180mcu_as_sc_mcu7t3v3__fillcap_4
XFILLER_2_317 VDD VDD VSS VSS gf180mcu_as_sc_mcu7t3v3__fillcap_16
X_4519_ VDD VDD VSS VSS _4520_/D _4519_/B _4572_/A gf180mcu_as_sc_mcu7t3v3__nor2_2
XFILLER_8_1434 VDD VDD VSS VSS gf180mcu_as_sc_mcu7t3v3__fill_1
Xfanout610 VDD VDD VSS VSS _3791_/B _3772_/C gf180mcu_as_sc_mcu7t3v3__buff_12
Xfanout621 VDD VDD VSS VSS _2659_/S _2831_/A gf180mcu_as_sc_mcu7t3v3__buff_12
Xfanout632 VDD VDD VSS VSS _3923_/Y _4160_/B gf180mcu_as_sc_mcu7t3v3__buff_12
XFILLER_8_1445 VDD VDD VSS VSS gf180mcu_as_sc_mcu7t3v3__fill_2
Xfanout643 VDD VDD VSS VSS _3550_/Y _3800_/C gf180mcu_as_sc_mcu7t3v3__buff_12
Xfanout654 VDD VDD VSS VSS _3241_/B _3163_/B gf180mcu_as_sc_mcu7t3v3__buff_12
Xfanout665 VDD VDD VSS VSS _4328_/A _4308_/S gf180mcu_as_sc_mcu7t3v3__buff_12
Xfanout676 VDD VDD VSS VSS _4103_/B _4030_/C gf180mcu_as_sc_mcu7t3v3__buff_12
XTAP_TAPCELL_ROW_31_1416 VDD VSS gf180mcu_as_sc_mcu7t3v3__tap_2
XTAP_TAPCELL_ROW_31_1405 VDD VSS gf180mcu_as_sc_mcu7t3v3__tap_2
Xfanout687 VDD VDD VSS VSS _3272_/Y _3503_/B gf180mcu_as_sc_mcu7t3v3__buff_12
Xfanout698 VDD VDD VSS VSS _4102_/B _4023_/B gf180mcu_as_sc_mcu7t3v3__buff_12
XFILLER_160_34 VDD VDD VSS VSS gf180mcu_as_sc_mcu7t3v3__fill_1
XFILLER_2_1033 VDD VDD VSS VSS gf180mcu_as_sc_mcu7t3v3__fillcap_8
XFILLER_37_88 VDD VDD VSS VSS gf180mcu_as_sc_mcu7t3v3__fillcap_8
XPHY_EDGE_ROW_89_1_Right_610 VDD VSS gf180mcu_as_sc_mcu7t3v3__tap_2
XFILLER_53_43 VDD VDD VSS VSS gf180mcu_as_sc_mcu7t3v3__fillcap_8
Xclkbuf_leaf_2_clk_regs VDD VDD VSS VSS clkbuf_leaf_2_clk_regs/A _4933_/CLK gf180mcu_as_sc_mcu7t3v3__clkbuff_12
XTAP_TAPCELL_ROW_29_1378 VDD VSS gf180mcu_as_sc_mcu7t3v3__tap_2
XTAP_TAPCELL_ROW_29_1367 VDD VSS gf180mcu_as_sc_mcu7t3v3__tap_2
XFILLER_14_457 VDD VDD VSS VSS gf180mcu_as_sc_mcu7t3v3__fillcap_16
XFILLER_169_54 VDD VDD VSS VSS gf180mcu_as_sc_mcu7t3v3__fillcap_16
XFILLER_186_226 VDD VDD VSS VSS gf180mcu_as_sc_mcu7t3v3__fillcap_4
XTAP_TAPCELL_ROW_175_2032 VDD VSS gf180mcu_as_sc_mcu7t3v3__tap_2
XTAP_TAPCELL_ROW_175_2021 VDD VSS gf180mcu_as_sc_mcu7t3v3__tap_2
XFILLER_126_1461 VDD VDD VSS VSS gf180mcu_as_sc_mcu7t3v3__fill_2
XFILLER_139_120 VDD VDD VSS VSS gf180mcu_as_sc_mcu7t3v3__fillcap_16
XFILLER_35_1366 VDD VDD VSS VSS gf180mcu_as_sc_mcu7t3v3__fillcap_16
XFILLER_139_142 VDD VDD VSS VSS gf180mcu_as_sc_mcu7t3v3__fillcap_16
XFILLER_161_1385 VDD VDD VSS VSS gf180mcu_as_sc_mcu7t3v3__fillcap_8
XFILLER_210_580 VDD VDD VSS VSS gf180mcu_as_sc_mcu7t3v3__fill_1
XFILLER_154_123 VDD VDD VSS VSS gf180mcu_as_sc_mcu7t3v3__fillcap_16
XFILLER_183_944 VDD VDD VSS VSS gf180mcu_as_sc_mcu7t3v3__fillcap_16
XFILLER_194_281 VDD VDD VSS VSS gf180mcu_as_sc_mcu7t3v3__fillcap_4
XFILLER_196_1415 VDD VDD VSS VSS gf180mcu_as_sc_mcu7t3v3__fillcap_16
XFILLER_196_1437 VDD VDD VSS VSS gf180mcu_as_sc_mcu7t3v3__fillcap_16
XFILLER_5_122 VDD VDD VSS VSS gf180mcu_as_sc_mcu7t3v3__fill_1
XTAP_TAPCELL_ROW_192_2390 VDD VSS gf180mcu_as_sc_mcu7t3v3__tap_2
XFILLER_6_678 VDD VDD VSS VSS gf180mcu_as_sc_mcu7t3v3__fillcap_4
XPHY_EDGE_ROW_65_3_Right_102 VDD VSS gf180mcu_as_sc_mcu7t3v3__tap_2
XFILLER_29_1115 VDD VDD VSS VSS gf180mcu_as_sc_mcu7t3v3__fillcap_4
XTAP_TAPCELL_ROW_58_1_1619 VDD VSS gf180mcu_as_sc_mcu7t3v3__tap_2
XFILLER_68_107 VDD VDD VSS VSS gf180mcu_as_sc_mcu7t3v3__fill_2
XFILLER_1_372 VDD VDD VSS VSS gf180mcu_as_sc_mcu7t3v3__fill_1
XFILLER_42_1348 VDD VDD VSS VSS gf180mcu_as_sc_mcu7t3v3__fillcap_8
Xmesh_tile_1020 VDD VDD VSS VSS nw_out[27] gf180mcu_as_sc_mcu7t3v3__tiel_4
XTAP_TAPCELL_ROW_207_2732 VDD VSS gf180mcu_as_sc_mcu7t3v3__tap_2
XTAP_TAPCELL_ROW_207_2721 VDD VSS gf180mcu_as_sc_mcu7t3v3__tap_2
XFILLER_133_1498 VDD VDD VSS VSS gf180mcu_as_sc_mcu7t3v3__fill_1
Xmesh_tile_1053 VDD VDD VSS VSS sw_out[26] gf180mcu_as_sc_mcu7t3v3__tiel_4
Xmesh_tile_1042 VDD VDD VSS VSS sw_out[15] gf180mcu_as_sc_mcu7t3v3__tiel_4
Xmesh_tile_1031 VDD VDD VSS VSS sw_out[4] gf180mcu_as_sc_mcu7t3v3__tiel_4
XFILLER_168_1539 VDD VDD VSS VSS gf180mcu_as_sc_mcu7t3v3__fill_2
XFILLER_91_154 VDD VDD VSS VSS gf180mcu_as_sc_mcu7t3v3__fillcap_16
XFILLER_94_83 VDD VDD VSS VSS gf180mcu_as_sc_mcu7t3v3__fill_1
XTAP_TAPCELL_ROW_203_2629 VDD VSS gf180mcu_as_sc_mcu7t3v3__tap_2
XFILLER_205_330 VDD VDD VSS VSS gf180mcu_as_sc_mcu7t3v3__fillcap_16
XTAP_TAPCELL_ROW_199_2555 VDD VSS gf180mcu_as_sc_mcu7t3v3__tap_2
XTAP_TAPCELL_ROW_199_2544 VDD VSS gf180mcu_as_sc_mcu7t3v3__tap_2
XFILLER_205_352 VDD VDD VSS VSS gf180mcu_as_sc_mcu7t3v3__fillcap_16
XFILLER_209_1536 VDD VDD VSS VSS gf180mcu_as_sc_mcu7t3v3__fillcap_4
XFILLER_209_1558 VDD VDD VSS VSS gf180mcu_as_sc_mcu7t3v3__fillcap_8
XFILLER_32_232 VDD VDD VSS VSS gf180mcu_as_sc_mcu7t3v3__fill_2
X_4870_ VDD VDD VSS VSS _5277_/CLK _4870_/D _4870_/Q gf180mcu_as_sc_mcu7t3v3__dfxtp_2
XFILLER_21_928 VDD VDD VSS VSS gf180mcu_as_sc_mcu7t3v3__fillcap_16
X_3821_ VDD VDD VSS VSS _3929_/A _3918_/A _3917_/A _3821_/C _3821_/Y gf180mcu_as_sc_mcu7t3v3__ao31_2
XFILLER_20_416 VDD VDD VSS VSS gf180mcu_as_sc_mcu7t3v3__fillcap_8
XFILLER_20_449 VDD VDD VSS VSS gf180mcu_as_sc_mcu7t3v3__fillcap_4
XFILLER_32_298 VDD VDD VSS VSS gf180mcu_as_sc_mcu7t3v3__fillcap_4
XFILLER_92_1493 VDD VDD VSS VSS gf180mcu_as_sc_mcu7t3v3__fillcap_16
XFILLER_192_207 VDD VDD VSS VSS gf180mcu_as_sc_mcu7t3v3__fillcap_16
XFILLER_53_1477 VDD VDD VSS VSS gf180mcu_as_sc_mcu7t3v3__fillcap_8
XFILLER_53_1488 VDD VDD VSS VSS gf180mcu_as_sc_mcu7t3v3__fillcap_16
X_3752_ VDD VDD VSS VSS _4131_/A _3802_/B _3802_/C _3753_/C _3752_/D gf180mcu_as_sc_mcu7t3v3__aoi211_2
XFILLER_140_1469 VDD VDD VSS VSS gf180mcu_as_sc_mcu7t3v3__fillcap_16
XFILLER_185_292 VDD VDD VSS VSS gf180mcu_as_sc_mcu7t3v3__fillcap_4
XPHY_EDGE_ROW_51_1_Right_572 VDD VSS gf180mcu_as_sc_mcu7t3v3__tap_2
X_3683_ VDD VDD VSS VSS _3730_/D _3730_/A _3683_/B _3683_/C _3684_/C gf180mcu_as_sc_mcu7t3v3__ao31_2
X_2703_ VDD VDD VSS VSS _2731_/S _5176_/Q _5168_/Q _2707_/B gf180mcu_as_sc_mcu7t3v3__mux2_2
XFILLER_12_1152 VDD VDD VSS VSS gf180mcu_as_sc_mcu7t3v3__fill_2
X_2634_ VDD VDD VSS VSS _2635_/B _5258_/Q _2634_/B _2634_/C gf180mcu_as_sc_mcu7t3v3__ao21_2
XFILLER_160_104 VDD VDD VSS VSS gf180mcu_as_sc_mcu7t3v3__fill_1
X_2565_ VDD VDD VSS VSS _2565_/B _2736_/C _4742_/C gf180mcu_as_sc_mcu7t3v3__or2_2
XFILLER_177_1392 VDD VDD VSS VSS gf180mcu_as_sc_mcu7t3v3__fillcap_8
X_4304_ VDD VDD VSS VSS _4326_/S _5134_/Q _5133_/Q _5133_/D gf180mcu_as_sc_mcu7t3v3__mux2_2
XFILLER_64_1540 VDD VDD VSS VSS gf180mcu_as_sc_mcu7t3v3__fill_1
X_5284_ VDD VDD VSS VSS _5285_/CLK _5284_/D _5284_/Q gf180mcu_as_sc_mcu7t3v3__dfxtp_2
X_2496_ VDD VDD VSS VSS _2876_/B _4703_/B _2747_/A gf180mcu_as_sc_mcu7t3v3__nor2_2
XFILLER_25_1535 VDD VDD VSS VSS gf180mcu_as_sc_mcu7t3v3__fillcap_4
XFILLER_60_1415 VDD VDD VSS VSS gf180mcu_as_sc_mcu7t3v3__fillcap_8
X_4235_ VDD VDD VSS VSS _4257_/S _4235_/B _5071_/Q _5071_/D gf180mcu_as_sc_mcu7t3v3__mux2_2
XFILLER_114_27 VDD VDD VSS VSS gf180mcu_as_sc_mcu7t3v3__fillcap_8
XFILLER_151_1543 VDD VDD VSS VSS gf180mcu_as_sc_mcu7t3v3__fillcap_8
XFILLER_210_1117 VDD VDD VSS VSS gf180mcu_as_sc_mcu7t3v3__fill_1
XFILLER_60_1448 VDD VDD VSS VSS gf180mcu_as_sc_mcu7t3v3__fill_2
X_4166_ VDD VDD VSS VSS _5006_/Q _4166_/B _4257_/B _4166_/D _5006_/D gf180mcu_as_sc_mcu7t3v3__ao22_2
XFILLER_28_527 VDD VDD VSS VSS gf180mcu_as_sc_mcu7t3v3__fillcap_16
X_3117_ VDD VDD VSS VSS _4094_/A _3229_/B _3150_/C _4093_/A _3123_/B gf180mcu_as_sc_mcu7t3v3__ao22_2
XFILLER_209_680 VDD VDD VSS VSS gf180mcu_as_sc_mcu7t3v3__fillcap_16
X_4097_ VDD VDD VSS VSS _4097_/A _4122_/B _4097_/C _4097_/D _4098_/B gf180mcu_as_sc_mcu7t3v3__ao211_2
XFILLER_82_165 VDD VDD VSS VSS gf180mcu_as_sc_mcu7t3v3__fillcap_8
X_3048_ VDD VDD VSS VSS _3057_/B _3048_/B _3048_/C _3049_/C gf180mcu_as_sc_mcu7t3v3__nor3_2
XFILLER_130_37 VDD VDD VSS VSS gf180mcu_as_sc_mcu7t3v3__fillcap_4
XFILLER_149_1461 VDD VDD VSS VSS gf180mcu_as_sc_mcu7t3v3__fill_2
XFILLER_149_1483 VDD VDD VSS VSS gf180mcu_as_sc_mcu7t3v3__fill_2
XFILLER_180_1205 VDD VDD VSS VSS gf180mcu_as_sc_mcu7t3v3__fillcap_16
XFILLER_180_1227 VDD VDD VSS VSS gf180mcu_as_sc_mcu7t3v3__fillcap_16
XFILLER_208_1046 VDD VDD VSS VSS gf180mcu_as_sc_mcu7t3v3__fillcap_4
XFILLER_23_243 VDD VDD VSS VSS gf180mcu_as_sc_mcu7t3v3__fillcap_16
XFILLER_24_766 VDD VDD VSS VSS gf180mcu_as_sc_mcu7t3v3__fillcap_8
XFILLER_58_1399 VDD VDD VSS VSS gf180mcu_as_sc_mcu7t3v3__fillcap_16
XFILLER_11_438 VDD VDD VSS VSS gf180mcu_as_sc_mcu7t3v3__fillcap_8
XFILLER_210_70 VDD VDD VSS VSS gf180mcu_as_sc_mcu7t3v3__fillcap_16
XPHY_EDGE_ROW_128_1_Right_649 VDD VSS gf180mcu_as_sc_mcu7t3v3__tap_2
X_4999_ VDD VDD VSS VSS _5095_/CLK _4999_/D _4999_/Q gf180mcu_as_sc_mcu7t3v3__dfxtp_2
XFILLER_17_1052 VDD VDD VSS VSS gf180mcu_as_sc_mcu7t3v3__fillcap_16
XFILLER_71_1566 VDD VDD VSS VSS gf180mcu_as_sc_mcu7t3v3__fill_2
XTAP_TAPCELL_ROW_24_1264 VDD VSS gf180mcu_as_sc_mcu7t3v3__tap_2
XTAP_TAPCELL_ROW_24_1253 VDD VSS gf180mcu_as_sc_mcu7t3v3__tap_2
XFILLER_136_123 VDD VDD VSS VSS gf180mcu_as_sc_mcu7t3v3__fillcap_8
XFILLER_180_925 VDD VDD VSS VSS gf180mcu_as_sc_mcu7t3v3__fillcap_16
XFILLER_192_785 VDD VDD VSS VSS gf180mcu_as_sc_mcu7t3v3__fillcap_16
XFILLER_121_1391 VDD VDD VSS VSS gf180mcu_as_sc_mcu7t3v3__fillcap_16
XFILLER_151_104 VDD VDD VSS VSS gf180mcu_as_sc_mcu7t3v3__fillcap_16
XFILLER_180_947 VDD VDD VSS VSS gf180mcu_as_sc_mcu7t3v3__fillcap_16
XFILLER_30_1274 VDD VDD VSS VSS gf180mcu_as_sc_mcu7t3v3__fill_1
XFILLER_117_1405 VDD VDD VSS VSS gf180mcu_as_sc_mcu7t3v3__fillcap_8
XFILLER_156_1443 VDD VDD VSS VSS gf180mcu_as_sc_mcu7t3v3__fillcap_8
XFILLER_69_1473 VDD VDD VSS VSS gf180mcu_as_sc_mcu7t3v3__fillcap_8
XFILLER_117_1438 VDD VDD VSS VSS gf180mcu_as_sc_mcu7t3v3__fill_1
Xfanout484 VDD VDD VSS VSS _4150_/B _4166_/B gf180mcu_as_sc_mcu7t3v3__buff_12
XFILLER_171_66 VDD VDD VSS VSS gf180mcu_as_sc_mcu7t3v3__fillcap_4
XFILLER_19_527 VDD VDD VSS VSS gf180mcu_as_sc_mcu7t3v3__fillcap_4
XFILLER_24_1078 VDD VDD VSS VSS gf180mcu_as_sc_mcu7t3v3__fillcap_4
XFILLER_8_1286 VDD VDD VSS VSS gf180mcu_as_sc_mcu7t3v3__fillcap_8
XFILLER_8_1297 VDD VDD VSS VSS gf180mcu_as_sc_mcu7t3v3__fillcap_4
XFILLER_171_88 VDD VDD VSS VSS gf180mcu_as_sc_mcu7t3v3__fillcap_16
XFILLER_185_1116 VDD VDD VSS VSS gf180mcu_as_sc_mcu7t3v3__fillcap_4
XFILLER_185_1138 VDD VDD VSS VSS gf180mcu_as_sc_mcu7t3v3__fillcap_16
XFILLER_64_31 VDD VDD VSS VSS gf180mcu_as_sc_mcu7t3v3__fillcap_4
XFILLER_64_53 VDD VDD VSS VSS gf180mcu_as_sc_mcu7t3v3__fillcap_8
XTAP_TAPCELL_ROW_131_1_1837 VDD VSS gf180mcu_as_sc_mcu7t3v3__tap_2
XTAP_TAPCELL_ROW_143_3_3149 VDD VSS gf180mcu_as_sc_mcu7t3v3__tap_2
XFILLER_128_1523 VDD VDD VSS VSS gf180mcu_as_sc_mcu7t3v3__fillcap_8
XFILLER_163_1403 VDD VDD VSS VSS gf180mcu_as_sc_mcu7t3v3__fillcap_8
XFILLER_167_1550 VDD VDD VSS VSS gf180mcu_as_sc_mcu7t3v3__fillcap_4
XFILLER_128_1556 VDD VDD VSS VSS gf180mcu_as_sc_mcu7t3v3__fillcap_8
XFILLER_14_243 VDD VDD VSS VSS gf180mcu_as_sc_mcu7t3v3__fill_2
XFILLER_15_788 VDD VDD VSS VSS gf180mcu_as_sc_mcu7t3v3__fillcap_16
XFILLER_187_524 VDD VDD VSS VSS gf180mcu_as_sc_mcu7t3v3__fillcap_8
XFILLER_199_384 VDD VDD VSS VSS gf180mcu_as_sc_mcu7t3v3__fill_2
XFILLER_202_311 VDD VDD VSS VSS gf180mcu_as_sc_mcu7t3v3__fillcap_4
XFILLER_202_333 VDD VDD VSS VSS gf180mcu_as_sc_mcu7t3v3__fillcap_16
XFILLER_76_1499 VDD VDD VSS VSS gf180mcu_as_sc_mcu7t3v3__fill_1
XTAP_TAPCELL_ROW_194_2430 VDD VSS gf180mcu_as_sc_mcu7t3v3__tap_2
XFILLER_187_557 VDD VDD VSS VSS gf180mcu_as_sc_mcu7t3v3__fill_2
XFILLER_9_59 VDD VDD VSS VSS gf180mcu_as_sc_mcu7t3v3__fillcap_8
XTAP_TAPCELL_ROW_194_2441 VDD VSS gf180mcu_as_sc_mcu7t3v3__tap_2
XFILLER_196_30 VDD VDD VSS VSS gf180mcu_as_sc_mcu7t3v3__fillcap_4
XFILLER_127_112 VDD VDD VSS VSS gf180mcu_as_sc_mcu7t3v3__fill_2
XFILLER_183_741 VDD VDD VSS VSS gf180mcu_as_sc_mcu7t3v3__fillcap_16
XFILLER_196_85 VDD VDD VSS VSS gf180mcu_as_sc_mcu7t3v3__fillcap_16
XTAP_TAPCELL_ROW_111_1_1779 VDD VSS gf180mcu_as_sc_mcu7t3v3__tap_2
Xwire830 VDD VDD VSS VSS wire830/A _4048_/D gf180mcu_as_sc_mcu7t3v3__clkbuff_12
Xwire841 VDD VDD VSS VSS wire841/A _3789_/A gf180mcu_as_sc_mcu7t3v3__clkbuff_12
Xwire852 VDD VDD VSS VSS wire852/A _4080_/A gf180mcu_as_sc_mcu7t3v3__clkbuff_12
XTAP_TAPCELL_ROW_190_2349 VDD VSS gf180mcu_as_sc_mcu7t3v3__tap_2
XFILLER_100_1420 VDD VDD VSS VSS gf180mcu_as_sc_mcu7t3v3__fill_1
XFILLER_13_1450 VDD VDD VSS VSS gf180mcu_as_sc_mcu7t3v3__fillcap_4
XPHY_EDGE_ROW_144_1_Left_354 VDD VSS gf180mcu_as_sc_mcu7t3v3__tap_2
Xwire874 VDD VDD VSS VSS wire874/A _4114_/A gf180mcu_as_sc_mcu7t3v3__clkbuff_12
XFILLER_127_189 VDD VDD VSS VSS gf180mcu_as_sc_mcu7t3v3__fill_1
XFILLER_142_115 VDD VDD VSS VSS gf180mcu_as_sc_mcu7t3v3__fillcap_4
XFILLER_48_1513 VDD VDD VSS VSS gf180mcu_as_sc_mcu7t3v3__fillcap_8
XPHY_EDGE_ROW_66_3_Right_103 VDD VSS gf180mcu_as_sc_mcu7t3v3__tap_2
XFILLER_174_1532 VDD VDD VSS VSS gf180mcu_as_sc_mcu7t3v3__fillcap_4
XFILLER_89_72 VDD VDD VSS VSS gf180mcu_as_sc_mcu7t3v3__fillcap_16
XFILLER_135_1527 VDD VDD VSS VSS gf180mcu_as_sc_mcu7t3v3__fillcap_4
XFILLER_170_1407 VDD VDD VSS VSS gf180mcu_as_sc_mcu7t3v3__fillcap_4
XFILLER_48_1568 VDD VDD VSS VSS gf180mcu_as_sc_mcu7t3v3__fill_1
XFILLER_9_1028 VDD VDD VSS VSS gf180mcu_as_sc_mcu7t3v3__fillcap_4
XFILLER_150_181 VDD VDD VSS VSS gf180mcu_as_sc_mcu7t3v3__fill_1
X_4020_ VDD VDD VSS VSS _4988_/Q _4158_/B _4239_/B _4117_/D _4988_/D gf180mcu_as_sc_mcu7t3v3__ao22_2
XFILLER_20_1432 VDD VDD VSS VSS gf180mcu_as_sc_mcu7t3v3__fill_2
XFILLER_49_195 VDD VDD VSS VSS gf180mcu_as_sc_mcu7t3v3__fill_1
XFILLER_20_1443 VDD VDD VSS VSS gf180mcu_as_sc_mcu7t3v3__fill_1
XFILLER_206_661 VDD VDD VSS VSS gf180mcu_as_sc_mcu7t3v3__fillcap_4
XFILLER_206_683 VDD VDD VSS VSS gf180mcu_as_sc_mcu7t3v3__fillcap_16
X_4922_ VDD VDD VSS VSS _5090_/CLK _4922_/D _4922_/Q gf180mcu_as_sc_mcu7t3v3__dfxtp_2
XFILLER_178_524 VDD VDD VSS VSS gf180mcu_as_sc_mcu7t3v3__fill_1
XFILLER_205_1208 VDD VDD VSS VSS gf180mcu_as_sc_mcu7t3v3__fillcap_16
XFILLER_33_574 VDD VDD VSS VSS gf180mcu_as_sc_mcu7t3v3__fill_2
X_4853_ VDD VDD VSS VSS _5256_/CLK _4853_/D _4853_/Q gf180mcu_as_sc_mcu7t3v3__dfxtp_2
XFILLER_18_1361 VDD VDD VSS VSS gf180mcu_as_sc_mcu7t3v3__fillcap_4
X_4784_ VDD VDD VSS VSS _4869_/CLK _4784_/D _4784_/Q gf180mcu_as_sc_mcu7t3v3__dfxtp_2
X_3804_ VDD VDD VSS VSS _3804_/B _3804_/A _4869_/D gf180mcu_as_sc_mcu7t3v3__and2_2
XFILLER_118_123 VDD VDD VSS VSS gf180mcu_as_sc_mcu7t3v3__fillcap_16
XFILLER_20_279 VDD VDD VSS VSS gf180mcu_as_sc_mcu7t3v3__fillcap_8
XPHY_EDGE_ROW_76_1_Left_286 VDD VSS gf180mcu_as_sc_mcu7t3v3__tap_2
X_3735_ VDD VDD VSS VSS _4937_/Q _3740_/B _3741_/C _4111_/A _3736_/D gf180mcu_as_sc_mcu7t3v3__ao22_2
XFILLER_118_156 VDD VDD VSS VSS gf180mcu_as_sc_mcu7t3v3__fillcap_16
XFILLER_174_752 VDD VDD VSS VSS gf180mcu_as_sc_mcu7t3v3__fill_1
XFILLER_88_1348 VDD VDD VSS VSS gf180mcu_as_sc_mcu7t3v3__fillcap_16
XPHY_EDGE_ROW_52_1_Right_573 VDD VSS gf180mcu_as_sc_mcu7t3v3__tap_2
XFILLER_133_104 VDD VDD VSS VSS gf180mcu_as_sc_mcu7t3v3__fillcap_16
X_3666_ VDD VDD VSS VSS _3666_/D _4037_/A _3728_/B _3728_/C _3667_/C gf180mcu_as_sc_mcu7t3v3__ao31_2
X_3597_ VDD VDD VSS VSS _3965_/D _3650_/B _3597_/C _3597_/D _3598_/C gf180mcu_as_sc_mcu7t3v3__ao211_2
X_2617_ VDD VDD VSS VSS _2643_/C _2634_/B gf180mcu_as_sc_mcu7t3v3__inv_2
XFILLER_0_618 VDD VDD VSS VSS gf180mcu_as_sc_mcu7t3v3__fill_2
X_2548_ VDD VDD VSS VSS _2556_/B _5222_/Q _2795_/A gf180mcu_as_sc_mcu7t3v3__nand2_2
XFILLER_141_170 VDD VDD VSS VSS gf180mcu_as_sc_mcu7t3v3__fillcap_4
XFILLER_25_1310 VDD VDD VSS VSS gf180mcu_as_sc_mcu7t3v3__fillcap_16
X_5267_ VDD VDD VSS VSS _5277_/CLK _5267_/D _5267_/Q gf180mcu_as_sc_mcu7t3v3__dfxtp_2
XFILLER_25_1332 VDD VDD VSS VSS gf180mcu_as_sc_mcu7t3v3__fillcap_4
X_4218_ VDD VDD VSS VSS _4247_/B _4224_/B _4224_/C _5054_/Q _5054_/D gf180mcu_as_sc_mcu7t3v3__ao22_2
X_2479_ VDD VDD VSS VSS _5272_/Q _5273_/Q _4291_/A gf180mcu_as_sc_mcu7t3v3__or2_2
XTAP_TAPCELL_ROW_38_3_2836 VDD VSS gf180mcu_as_sc_mcu7t3v3__tap_2
XFILLER_151_1373 VDD VDD VSS VSS gf180mcu_as_sc_mcu7t3v3__fillcap_16
XFILLER_25_1387 VDD VDD VSS VSS gf180mcu_as_sc_mcu7t3v3__fillcap_8
XFILLER_29_836 VDD VDD VSS VSS gf180mcu_as_sc_mcu7t3v3__fillcap_4
XFILLER_5_1448 VDD VDD VSS VSS gf180mcu_as_sc_mcu7t3v3__fill_2
XFILLER_99_1411 VDD VDD VSS VSS gf180mcu_as_sc_mcu7t3v3__fill_1
X_5198_ VDD VDD VSS VSS _5198_/CLK _5198_/D _5198_/Q gf180mcu_as_sc_mcu7t3v3__dfxtp_2
XFILLER_112_1368 VDD VDD VSS VSS gf180mcu_as_sc_mcu7t3v3__fill_2
XFILLER_29_869 VDD VDD VSS VSS gf180mcu_as_sc_mcu7t3v3__fillcap_16
X_4149_ VDD VDD VSS VSS _4149_/B _4165_/A _4255_/B gf180mcu_as_sc_mcu7t3v3__and2_2
XFILLER_99_1488 VDD VDD VSS VSS gf180mcu_as_sc_mcu7t3v3__fillcap_16
XPHY_EDGE_ROW_104_3_Left_489 VDD VSS gf180mcu_as_sc_mcu7t3v3__tap_2
XFILLER_34_34 VDD VDD VSS VSS gf180mcu_as_sc_mcu7t3v3__fill_1
XTAP_TAPCELL_ROW_26_1304 VDD VSS gf180mcu_as_sc_mcu7t3v3__tap_2
XFILLER_200_815 VDD VDD VSS VSS gf180mcu_as_sc_mcu7t3v3__fillcap_4
XPHY_EDGE_ROW_41_3_Left_426 VDD VSS gf180mcu_as_sc_mcu7t3v3__tap_2
Xsram2048.u_bank0_912 VDD VDD VSS VSS sram2048.u_bank0/WEN[2] gf180mcu_as_sc_mcu7t3v3__tiel_4
XFILLER_12_769 VDD VDD VSS VSS gf180mcu_as_sc_mcu7t3v3__fillcap_16
XFILLER_184_527 VDD VDD VSS VSS gf180mcu_as_sc_mcu7t3v3__fillcap_16
XFILLER_196_387 VDD VDD VSS VSS gf180mcu_as_sc_mcu7t3v3__fillcap_16
XFILLER_71_1352 VDD VDD VSS VSS gf180mcu_as_sc_mcu7t3v3__fill_2
XTAP_TAPCELL_ROW_83_1_1695 VDD VSS gf180mcu_as_sc_mcu7t3v3__tap_2
XFILLER_11_279 VDD VDD VSS VSS gf180mcu_as_sc_mcu7t3v3__fill_1
XFILLER_123_1442 VDD VDD VSS VSS gf180mcu_as_sc_mcu7t3v3__fill_1
XPHY_EDGE_ROW_166_3_Left_551 VDD VSS gf180mcu_as_sc_mcu7t3v3__tap_2
Xclkload0 VDD VDD VSS VSS clkload0/A clkload0/Y gf180mcu_as_sc_mcu7t3v3__clkbuff_12
XFILLER_166_22 VDD VDD VSS VSS gf180mcu_as_sc_mcu7t3v3__fillcap_8
XTAP_TAPCELL_ROW_10_948 VDD VSS gf180mcu_as_sc_mcu7t3v3__tap_2
XTAP_TAPCELL_ROW_10_959 VDD VSS gf180mcu_as_sc_mcu7t3v3__tap_2
XFILLER_180_711 VDD VDD VSS VSS gf180mcu_as_sc_mcu7t3v3__fill_2
XFILLER_193_1418 VDD VDD VSS VSS gf180mcu_as_sc_mcu7t3v3__fillcap_16
XFILLER_50_77 VDD VDD VSS VSS gf180mcu_as_sc_mcu7t3v3__fill_2
XFILLER_1_2 VDD VDD VSS VSS gf180mcu_as_sc_mcu7t3v3__fillcap_16
XFILLER_132_170 VDD VDD VSS VSS gf180mcu_as_sc_mcu7t3v3__fillcap_4
XFILLER_26_1118 VDD VDD VSS VSS gf180mcu_as_sc_mcu7t3v3__fill_2
XFILLER_191_1186 VDD VDD VSS VSS gf180mcu_as_sc_mcu7t3v3__fillcap_4
XFILLER_8_1083 VDD VDD VSS VSS gf180mcu_as_sc_mcu7t3v3__fill_2
XFILLER_19_346 VDD VDD VSS VSS gf180mcu_as_sc_mcu7t3v3__fillcap_4
XTAP_TAPCELL_ROW_183_2197 VDD VSS gf180mcu_as_sc_mcu7t3v3__tap_2
XFILLER_35_817 VDD VDD VSS VSS gf180mcu_as_sc_mcu7t3v3__fill_2
XFILLER_75_96 VDD VDD VSS VSS gf180mcu_as_sc_mcu7t3v3__fillcap_8
XFILLER_128_1364 VDD VDD VSS VSS gf180mcu_as_sc_mcu7t3v3__fillcap_16
XFILLER_187_332 VDD VDD VSS VSS gf180mcu_as_sc_mcu7t3v3__fillcap_8
XFILLER_188_855 VDD VDD VSS VSS gf180mcu_as_sc_mcu7t3v3__fillcap_16
XFILLER_203_664 VDD VDD VSS VSS gf180mcu_as_sc_mcu7t3v3__fillcap_16
XFILLER_206_1539 VDD VDD VSS VSS gf180mcu_as_sc_mcu7t3v3__fillcap_16
XFILLER_30_522 VDD VDD VSS VSS gf180mcu_as_sc_mcu7t3v3__fill_2
XFILLER_188_877 VDD VDD VSS VSS gf180mcu_as_sc_mcu7t3v3__fillcap_16
XPHY_EDGE_ROW_98_3_Left_483 VDD VSS gf180mcu_as_sc_mcu7t3v3__tap_2
XFILLER_198_1329 VDD VDD VSS VSS gf180mcu_as_sc_mcu7t3v3__fillcap_16
XFILLER_50_1425 VDD VDD VSS VSS gf180mcu_as_sc_mcu7t3v3__fillcap_16
XFILLER_15_1567 VDD VDD VSS VSS gf180mcu_as_sc_mcu7t3v3__fill_2
XFILLER_50_1469 VDD VDD VSS VSS gf180mcu_as_sc_mcu7t3v3__fill_2
X_3520_ VDD VDD VSS VSS _3520_/A _3520_/B _3520_/C _3520_/D _3521_/C gf180mcu_as_sc_mcu7t3v3__ao211_2
XFILLER_115_104 VDD VDD VSS VSS gf180mcu_as_sc_mcu7t3v3__fillcap_16
X_3451_ VDD VDD VSS VSS _4101_/A _3451_/B _3451_/C _3451_/D _3452_/A gf180mcu_as_sc_mcu7t3v3__ao211_2
XFILLER_130_107 VDD VDD VSS VSS gf180mcu_as_sc_mcu7t3v3__fillcap_16
XPHY_EDGE_ROW_67_3_Right_104 VDD VSS gf180mcu_as_sc_mcu7t3v3__tap_2
X_3382_ VDD VDD VSS VSS _4032_/A _3382_/B _3382_/C _4033_/A _3383_/C gf180mcu_as_sc_mcu7t3v3__ao22_2
X_2402_ VDD VDD VSS VSS _2815_/A _4976_/Q gf180mcu_as_sc_mcu7t3v3__inv_2
XFILLER_174_1362 VDD VDD VSS VSS gf180mcu_as_sc_mcu7t3v3__fillcap_4
XFILLER_34_2 VDD VDD VSS VSS gf180mcu_as_sc_mcu7t3v3__fillcap_16
X_5121_ VDD VDD VSS VSS clkload7/A _5121_/D _5121_/Q gf180mcu_as_sc_mcu7t3v3__dfxtp_2
X_5052_ VDD VDD VSS VSS clkload4/A _5052_/D _5052_/Q gf180mcu_as_sc_mcu7t3v3__dfxtp_2
XPHY_EDGE_ROW_179_Left_389 VDD VSS gf180mcu_as_sc_mcu7t3v3__tap_2
X_4003_ VDD VDD VSS VSS _4003_/A _4027_/B _4003_/C _4237_/B _4116_/A gf180mcu_as_sc_mcu7t3v3__aoi211_2
XTAP_TAPCELL_ROW_113_3_3060 VDD VSS gf180mcu_as_sc_mcu7t3v3__tap_2
XFILLER_0_1323 VDD VDD VSS VSS gf180mcu_as_sc_mcu7t3v3__fill_2
XFILLER_19_880 VDD VDD VSS VSS gf180mcu_as_sc_mcu7t3v3__fill_2
XFILLER_37_198 VDD VDD VSS VSS gf180mcu_as_sc_mcu7t3v3__fill_1
XFILLER_111_39 VDD VDD VSS VSS gf180mcu_as_sc_mcu7t3v3__fill_2
XFILLER_34_872 VDD VDD VSS VSS gf180mcu_as_sc_mcu7t3v3__fill_2
XFILLER_59_1472 VDD VDD VSS VSS gf180mcu_as_sc_mcu7t3v3__fillcap_4
XFILLER_59_1483 VDD VDD VSS VSS gf180mcu_as_sc_mcu7t3v3__fill_2
XFILLER_107_1415 VDD VDD VSS VSS gf180mcu_as_sc_mcu7t3v3__fill_1
XFILLER_146_1453 VDD VDD VSS VSS gf180mcu_as_sc_mcu7t3v3__fillcap_8
XFILLER_16_1309 VDD VDD VSS VSS gf180mcu_as_sc_mcu7t3v3__fill_2
XFILLER_178_321 VDD VDD VSS VSS gf180mcu_as_sc_mcu7t3v3__fill_2
X_4905_ VDD VDD VSS VSS _4933_/CLK _4905_/D _4905_/Q gf180mcu_as_sc_mcu7t3v3__dfxtp_2
X_4836_ VDD VDD VSS VSS _5073_/CLK _4836_/D _4836_/Q gf180mcu_as_sc_mcu7t3v3__dfxtp_2
XFILLER_14_1033 VDD VDD VSS VSS gf180mcu_as_sc_mcu7t3v3__fillcap_16
XFILLER_178_387 VDD VDD VSS VSS gf180mcu_as_sc_mcu7t3v3__fill_2
XFILLER_181_1399 VDD VDD VSS VSS gf180mcu_as_sc_mcu7t3v3__fill_1
XPHY_EDGE_ROW_188_Left_398 VDD VSS gf180mcu_as_sc_mcu7t3v3__tap_2
XTAP_TAPCELL_ROW_21_1201 VDD VSS gf180mcu_as_sc_mcu7t3v3__tap_2
XFILLER_181_508 VDD VDD VSS VSS gf180mcu_as_sc_mcu7t3v3__fillcap_16
XFILLER_193_368 VDD VDD VSS VSS gf180mcu_as_sc_mcu7t3v3__fill_2
X_4767_ VDD VDD VSS VSS _5241_/CLK _4767_/D _4767_/Q gf180mcu_as_sc_mcu7t3v3__dfxtp_2
XFILLER_179_1240 VDD VDD VSS VSS gf180mcu_as_sc_mcu7t3v3__fillcap_16
XFILLER_179_1262 VDD VDD VSS VSS gf180mcu_as_sc_mcu7t3v3__fillcap_16
X_4698_ VDD VDD VSS VSS _4733_/C _5482_/A _5255_/Q _4699_/A gf180mcu_as_sc_mcu7t3v3__mux2_2
X_3718_ VDD VDD VSS VSS _3722_/B _3718_/C _3758_/B _4094_/A gf180mcu_as_sc_mcu7t3v3__aoi21_2
XPHY_EDGE_ROW_53_1_Right_574 VDD VSS gf180mcu_as_sc_mcu7t3v3__tap_2
X_3649_ VDD VDD VSS VSS _4024_/A _3649_/B _3656_/C _4024_/D _3650_/D gf180mcu_as_sc_mcu7t3v3__ao22_2
XFILLER_136_58 VDD VDD VSS VSS gf180mcu_as_sc_mcu7t3v3__fillcap_8
XFILLER_20_69 VDD VDD VSS VSS gf180mcu_as_sc_mcu7t3v3__fillcap_16
XFILLER_118_1533 VDD VDD VSS VSS gf180mcu_as_sc_mcu7t3v3__fillcap_8
XTAP_TAPCELL_ROW_19_1152 VDD VSS gf180mcu_as_sc_mcu7t3v3__tap_2
XTAP_TAPCELL_ROW_19_1141 VDD VSS gf180mcu_as_sc_mcu7t3v3__tap_2
XFILLER_0_448 VDD VDD VSS VSS gf180mcu_as_sc_mcu7t3v3__fill_2
Xinput305 VDD VDD VSS VSS west_in[2] _3947_/D gf180mcu_as_sc_mcu7t3v3__buff_12
Xinput316 VDD VDD VSS VSS west_in[9] _4006_/A gf180mcu_as_sc_mcu7t3v3__buff_12
XTAP_TAPCELL_ROW_57_3_2891 VDD VSS gf180mcu_as_sc_mcu7t3v3__tap_2
XFILLER_195_6 VDD VDD VSS VSS gf180mcu_as_sc_mcu7t3v3__fillcap_16
XFILLER_5_1234 VDD VDD VSS VSS gf180mcu_as_sc_mcu7t3v3__fill_2
XFILLER_17_839 VDD VDD VSS VSS gf180mcu_as_sc_mcu7t3v3__fill_1
XFILLER_182_1119 VDD VDD VSS VSS gf180mcu_as_sc_mcu7t3v3__fillcap_16
XFILLER_188_107 VDD VDD VSS VSS gf180mcu_as_sc_mcu7t3v3__fillcap_16
XFILLER_38_1523 VDD VDD VSS VSS gf180mcu_as_sc_mcu7t3v3__fillcap_4
XFILLER_45_88 VDD VDD VSS VSS gf180mcu_as_sc_mcu7t3v3__fillcap_16
XFILLER_101_61 VDD VDD VSS VSS gf180mcu_as_sc_mcu7t3v3__fillcap_8
XFILLER_125_1504 VDD VDD VSS VSS gf180mcu_as_sc_mcu7t3v3__fill_2
XFILLER_101_72 VDD VDD VSS VSS gf180mcu_as_sc_mcu7t3v3__fillcap_16
XFILLER_125_1526 VDD VDD VSS VSS gf180mcu_as_sc_mcu7t3v3__fillcap_4
XFILLER_129_207 VDD VDD VSS VSS gf180mcu_as_sc_mcu7t3v3__fill_2
XFILLER_73_1469 VDD VDD VSS VSS gf180mcu_as_sc_mcu7t3v3__fillcap_4
XFILLER_185_858 VDD VDD VSS VSS gf180mcu_as_sc_mcu7t3v3__fillcap_16
XFILLER_197_696 VDD VDD VSS VSS gf180mcu_as_sc_mcu7t3v3__fillcap_4
XFILLER_200_645 VDD VDD VSS VSS gf180mcu_as_sc_mcu7t3v3__fillcap_16
XFILLER_200_667 VDD VDD VSS VSS gf180mcu_as_sc_mcu7t3v3__fillcap_16
XFILLER_36_1291 VDD VDD VSS VSS gf180mcu_as_sc_mcu7t3v3__fill_1
XFILLER_177_54 VDD VDD VSS VSS gf180mcu_as_sc_mcu7t3v3__fillcap_16
XANTENNA_9 VDD VDD VSS VSS _4858_/D gf180mcu_as_sc_mcu7t3v3__diode_2
XFILLER_10_1453 VDD VDD VSS VSS gf180mcu_as_sc_mcu7t3v3__fillcap_16
XFILLER_152_221 VDD VDD VSS VSS gf180mcu_as_sc_mcu7t3v3__fill_1
XFILLER_180_541 VDD VDD VSS VSS gf180mcu_as_sc_mcu7t3v3__fillcap_16
XTAP_TAPCELL_ROW_189_2340 VDD VSS gf180mcu_as_sc_mcu7t3v3__tap_2
XTAP_TAPCELL_ROW_106_1_1763 VDD VSS gf180mcu_as_sc_mcu7t3v3__tap_2
XTAP_TAPCELL_ROW_118_3_3075 VDD VSS gf180mcu_as_sc_mcu7t3v3__tap_2
XTAP_TAPCELL_ROW_210_2783 VDD VSS gf180mcu_as_sc_mcu7t3v3__tap_2
XTAP_TAPCELL_ROW_185_2237 VDD VSS gf180mcu_as_sc_mcu7t3v3__tap_2
XTAP_TAPCELL_ROW_210_2794 VDD VSS gf180mcu_as_sc_mcu7t3v3__tap_2
XTAP_TAPCELL_ROW_185_2248 VDD VSS gf180mcu_as_sc_mcu7t3v3__tap_2
XFILLER_0_960 VDD VDD VSS VSS gf180mcu_as_sc_mcu7t3v3__fill_1
XFILLER_171_1568 VDD VDD VSS VSS gf180mcu_as_sc_mcu7t3v3__fill_1
XFILLER_86_62 VDD VDD VSS VSS gf180mcu_as_sc_mcu7t3v3__fillcap_16
XFILLER_169_1464 VDD VDD VSS VSS gf180mcu_as_sc_mcu7t3v3__fill_1
XFILLER_207_277 VDD VDD VSS VSS gf180mcu_as_sc_mcu7t3v3__fill_2
XFILLER_16_850 VDD VDD VSS VSS gf180mcu_as_sc_mcu7t3v3__fillcap_16
XTAP_TAPCELL_ROW_83_3_2970 VDD VSS gf180mcu_as_sc_mcu7t3v3__tap_2
X_2951_ VDD VDD VSS VSS _2952_/C _3045_/A _2951_/B _2951_/C gf180mcu_as_sc_mcu7t3v3__ao21_2
XFILLER_176_803 VDD VDD VSS VSS gf180mcu_as_sc_mcu7t3v3__fill_2
XFILLER_204_995 VDD VDD VSS VSS gf180mcu_as_sc_mcu7t3v3__fillcap_16
XFILLER_31_842 VDD VDD VSS VSS gf180mcu_as_sc_mcu7t3v3__fillcap_8
XFILLER_91_1558 VDD VDD VSS VSS gf180mcu_as_sc_mcu7t3v3__fillcap_8
XFILLER_176_847 VDD VDD VSS VSS gf180mcu_as_sc_mcu7t3v3__fill_1
X_4621_ VDD VDD VSS VSS _5215_/Q _4621_/B _4622_/C _5216_/Q _5215_/D gf180mcu_as_sc_mcu7t3v3__ao22_2
X_2882_ VDD VDD VSS VSS _2882_/A _2882_/B _2882_/C _2882_/D _4769_/D gf180mcu_as_sc_mcu7t3v3__ao22_2
XFILLER_15_1364 VDD VDD VSS VSS gf180mcu_as_sc_mcu7t3v3__fillcap_8
X_4552_ VDD VDD VSS VSS _4553_/C _4552_/C _5055_/Q _4559_/S gf180mcu_as_sc_mcu7t3v3__aoi21b_2
XTAP_TAPCELL_ROW_174_1985 VDD VSS gf180mcu_as_sc_mcu7t3v3__tap_2
XTAP_TAPCELL_ROW_174_1974 VDD VSS gf180mcu_as_sc_mcu7t3v3__tap_2
XFILLER_190_349 VDD VDD VSS VSS gf180mcu_as_sc_mcu7t3v3__fillcap_16
XFILLER_89_1498 VDD VDD VSS VSS gf180mcu_as_sc_mcu7t3v3__fill_1
Xwire490 VDD VDD VSS VSS _3157_/Y _4795_/D gf180mcu_as_sc_mcu7t3v3__clkbuff_12
X_4483_ VDD VDD VSS VSS _4483_/S _5076_/Q _4989_/Q _4484_/A gf180mcu_as_sc_mcu7t3v3__mux2_2
X_3503_ VDD VDD VSS VSS _4159_/D _3503_/B _3522_/C _4163_/A _3504_/D gf180mcu_as_sc_mcu7t3v3__ao22_2
XTAP_TAPCELL_ROW_174_1996 VDD VSS gf180mcu_as_sc_mcu7t3v3__tap_2
XFILLER_176_1457 VDD VDD VSS VSS gf180mcu_as_sc_mcu7t3v3__fill_2
X_3434_ VDD VDD VSS VSS _4934_/Q _3486_/B _3465_/C _4087_/A _3435_/D gf180mcu_as_sc_mcu7t3v3__ao22_2
XPHY_EDGE_ROW_107_1_Left_317 VDD VSS gf180mcu_as_sc_mcu7t3v3__tap_2
XPHY_EDGE_ROW_68_3_Right_105 VDD VSS gf180mcu_as_sc_mcu7t3v3__tap_2
XTAP_TAPCELL_ROW_152_1_1900 VDD VSS gf180mcu_as_sc_mcu7t3v3__tap_2
XTAP_TAPCELL_ROW_164_3_3212 VDD VSS gf180mcu_as_sc_mcu7t3v3__tap_2
XFILLER_174_1192 VDD VDD VSS VSS gf180mcu_as_sc_mcu7t3v3__fillcap_16
X_3365_ VDD VDD VSS VSS _3452_/S _4016_/D _3365_/A _3367_/B gf180mcu_as_sc_mcu7t3v3__mux2_2
X_5104_ VDD VDD VSS VSS _5260_/CLK _5104_/D _5104_/Q gf180mcu_as_sc_mcu7t3v3__dfxtp_2
X_3296_ VDD VDD VSS VSS _3944_/A _3416_/B _3296_/C _4806_/D _3416_/D gf180mcu_as_sc_mcu7t3v3__aoi211_2
X_5035_ VDD VDD VSS VSS _5095_/CLK _5035_/D _5035_/Q gf180mcu_as_sc_mcu7t3v3__dfxtp_2
XFILLER_113_1485 VDD VDD VSS VSS gf180mcu_as_sc_mcu7t3v3__fill_1
XFILLER_122_27 VDD VDD VSS VSS gf180mcu_as_sc_mcu7t3v3__fillcap_8
XFILLER_61_1395 VDD VDD VSS VSS gf180mcu_as_sc_mcu7t3v3__fillcap_4
XFILLER_96_1414 VDD VDD VSS VSS gf180mcu_as_sc_mcu7t3v3__fillcap_16
XFILLER_199_906 VDD VDD VSS VSS gf180mcu_as_sc_mcu7t3v3__fillcap_4
XTAP_TAPCELL_ROW_132_1_1842 VDD VSS gf180mcu_as_sc_mcu7t3v3__tap_2
XTAP_TAPCELL_ROW_144_3_3154 VDD VSS gf180mcu_as_sc_mcu7t3v3__tap_2
XTAP_TAPCELL_ROW_1_757 VDD VSS gf180mcu_as_sc_mcu7t3v3__tap_2
XTAP_TAPCELL_ROW_1_746 VDD VSS gf180mcu_as_sc_mcu7t3v3__tap_2
XFILLER_0_1153 VDD VDD VSS VSS gf180mcu_as_sc_mcu7t3v3__fill_2
XFILLER_199_928 VDD VDD VSS VSS gf180mcu_as_sc_mcu7t3v3__fillcap_16
XFILLER_15_69 VDD VDD VSS VSS gf180mcu_as_sc_mcu7t3v3__fill_1
XFILLER_33_190 VDD VDD VSS VSS gf180mcu_as_sc_mcu7t3v3__fillcap_16
XPHY_EDGE_ROW_196_Left_406 VDD VSS gf180mcu_as_sc_mcu7t3v3__tap_2
XFILLER_21_352 VDD VDD VSS VSS gf180mcu_as_sc_mcu7t3v3__fillcap_4
XFILLER_178_195 VDD VDD VSS VSS gf180mcu_as_sc_mcu7t3v3__fill_1
X_4819_ VDD VDD VSS VSS _5082_/CLK _4819_/D _4819_/Q gf180mcu_as_sc_mcu7t3v3__dfxtp_2
XFILLER_120_1445 VDD VDD VSS VSS gf180mcu_as_sc_mcu7t3v3__fillcap_4
XFILLER_194_699 VDD VDD VSS VSS gf180mcu_as_sc_mcu7t3v3__fillcap_16
XFILLER_147_68 VDD VDD VSS VSS gf180mcu_as_sc_mcu7t3v3__fill_2
XFILLER_181_349 VDD VDD VSS VSS gf180mcu_as_sc_mcu7t3v3__fill_1
XPHY_EDGE_ROW_39_1_Left_249 VDD VSS gf180mcu_as_sc_mcu7t3v3__tap_2
XPHY_EDGE_ROW_54_1_Right_575 VDD VSS gf180mcu_as_sc_mcu7t3v3__tap_2
XFILLER_0_212 VDD VDD VSS VSS gf180mcu_as_sc_mcu7t3v3__fill_1
XFILLER_7_1318 VDD VDD VSS VSS gf180mcu_as_sc_mcu7t3v3__fill_2
Xinput102 VDD VDD VSS VSS ne_in[31] _3512_/A gf180mcu_as_sc_mcu7t3v3__buff_12
XFILLER_0_278 VDD VDD VSS VSS gf180mcu_as_sc_mcu7t3v3__fill_2
XFILLER_163_67 VDD VDD VSS VSS gf180mcu_as_sc_mcu7t3v3__fill_2
Xinput113 VDD VDD VSS VSS north_in[10] _4014_/A gf180mcu_as_sc_mcu7t3v3__buff_12
Xinput124 VDD VDD VSS VSS north_in[20] _4095_/A gf180mcu_as_sc_mcu7t3v3__buff_12
Xinput135 VDD VDD VSS VSS north_in[30] _3535_/A gf180mcu_as_sc_mcu7t3v3__buff_12
XTAP_TAPCELL_ROW_88_3_2985 VDD VSS gf180mcu_as_sc_mcu7t3v3__tap_2
XTAP_TAPCELL_ROW_34_1469 VDD VSS gf180mcu_as_sc_mcu7t3v3__tap_2
XFILLER_40_1424 VDD VDD VSS VSS gf180mcu_as_sc_mcu7t3v3__fillcap_16
XFILLER_56_32 VDD VDD VSS VSS gf180mcu_as_sc_mcu7t3v3__fill_2
Xinput146 VDD VDD VSS VSS nw_in[0] _3926_/A gf180mcu_as_sc_mcu7t3v3__buff_12
Xinput157 VDD VDD VSS VSS nw_in[1] _3939_/A gf180mcu_as_sc_mcu7t3v3__buff_12
Xinput168 VDD VDD VSS VSS nw_in[2] _3948_/A gf180mcu_as_sc_mcu7t3v3__buff_12
XTAP_TAPCELL_ROW_180_2134 VDD VSS gf180mcu_as_sc_mcu7t3v3__tap_2
XTAP_TAPCELL_ROW_180_2123 VDD VSS gf180mcu_as_sc_mcu7t3v3__tap_2
Xclkbuf_3_0__f_clk_regs VDD VDD VSS VSS clkbuf_2_0_0_clk_regs/Y clkbuf_3_0__f_clk_regs/Y
+ gf180mcu_as_sc_mcu7t3v3__clkbuff_12
Xinput179 VDD VDD VSS VSS nw_in[9] _4008_/A gf180mcu_as_sc_mcu7t3v3__buff_12
XFILLER_204_225 VDD VDD VSS VSS gf180mcu_as_sc_mcu7t3v3__fillcap_16
XPHY_EDGE_ROW_153_1_Left_363 VDD VSS gf180mcu_as_sc_mcu7t3v3__tap_2
XPHY_EDGE_ROW_19_Right_19 VDD VSS gf180mcu_as_sc_mcu7t3v3__tap_2
XFILLER_189_438 VDD VDD VSS VSS gf180mcu_as_sc_mcu7t3v3__fillcap_16
XFILLER_204_247 VDD VDD VSS VSS gf180mcu_as_sc_mcu7t3v3__fillcap_16
XFILLER_129_1470 VDD VDD VSS VSS gf180mcu_as_sc_mcu7t3v3__fillcap_4
XFILLER_13_842 VDD VDD VSS VSS gf180mcu_as_sc_mcu7t3v3__fill_2
XFILLER_188_53 VDD VDD VSS VSS gf180mcu_as_sc_mcu7t3v3__fillcap_16
XFILLER_72_64 VDD VDD VSS VSS gf180mcu_as_sc_mcu7t3v3__fillcap_16
XTAP_TAPCELL_ROW_178_2085 VDD VSS gf180mcu_as_sc_mcu7t3v3__tap_2
XFILLER_164_1383 VDD VDD VSS VSS gf180mcu_as_sc_mcu7t3v3__fillcap_16
XFILLER_199_1402 VDD VDD VSS VSS gf180mcu_as_sc_mcu7t3v3__fillcap_16
XFILLER_34_1217 VDD VDD VSS VSS gf180mcu_as_sc_mcu7t3v3__fillcap_8
XPHY_EDGE_ROW_90_1_Left_300 VDD VSS gf180mcu_as_sc_mcu7t3v3__tap_2
XTAP_TAPCELL_ROW_51_1_1597 VDD VSS gf180mcu_as_sc_mcu7t3v3__tap_2
XTAP_TAPCELL_ROW_178_2096 VDD VSS gf180mcu_as_sc_mcu7t3v3__tap_2
XFILLER_13_897 VDD VDD VSS VSS gf180mcu_as_sc_mcu7t3v3__fill_2
XFILLER_200_453 VDD VDD VSS VSS gf180mcu_as_sc_mcu7t3v3__fill_2
XFILLER_201_976 VDD VDD VSS VSS gf180mcu_as_sc_mcu7t3v3__fillcap_4
XFILLER_201_998 VDD VDD VSS VSS gf180mcu_as_sc_mcu7t3v3__fillcap_16
XFILLER_205_1380 VDD VDD VSS VSS gf180mcu_as_sc_mcu7t3v3__fillcap_16
XFILLER_8_345 VDD VDD VSS VSS gf180mcu_as_sc_mcu7t3v3__fillcap_16
XTAP_TAPCELL_ROW_157_1_1915 VDD VSS gf180mcu_as_sc_mcu7t3v3__tap_2
XFILLER_185_699 VDD VDD VSS VSS gf180mcu_as_sc_mcu7t3v3__fill_1
XTAP_TAPCELL_ROW_169_3_3227 VDD VSS gf180mcu_as_sc_mcu7t3v3__tap_2
XFILLER_197_1170 VDD VDD VSS VSS gf180mcu_as_sc_mcu7t3v3__fillcap_16
X_4888__1079 VDD VDD VSS VSS _4888_/D gf180mcu_as_sc_mcu7t3v3__tiel_4
XFILLER_181_850 VDD VDD VSS VSS gf180mcu_as_sc_mcu7t3v3__fillcap_4
XFILLER_197_1192 VDD VDD VSS VSS gf180mcu_as_sc_mcu7t3v3__fillcap_16
XFILLER_21_90 VDD VDD VSS VSS gf180mcu_as_sc_mcu7t3v3__fillcap_16
XPHY_EDGE_ROW_129_3_Left_514 VDD VSS gf180mcu_as_sc_mcu7t3v3__tap_2
XPHY_EDGE_ROW_28_Right_28 VDD VSS gf180mcu_as_sc_mcu7t3v3__tap_2
XFILLER_10_1294 VDD VDD VSS VSS gf180mcu_as_sc_mcu7t3v3__fill_1
XFILLER_98_127 VDD VDD VSS VSS gf180mcu_as_sc_mcu7t3v3__fill_1
XFILLER_84_1373 VDD VDD VSS VSS gf180mcu_as_sc_mcu7t3v3__fillcap_8
XFILLER_97_72 VDD VDD VSS VSS gf180mcu_as_sc_mcu7t3v3__fillcap_16
XTAP_TAPCELL_ROW_137_1_1857 VDD VSS gf180mcu_as_sc_mcu7t3v3__tap_2
XTAP_TAPCELL_ROW_149_3_3169 VDD VSS gf180mcu_as_sc_mcu7t3v3__tap_2
XFILLER_171_1376 VDD VDD VSS VSS gf180mcu_as_sc_mcu7t3v3__fillcap_16
X_3150_ VDD VDD VSS VSS _4127_/A _3240_/B _3150_/C _4126_/A _3156_/B gf180mcu_as_sc_mcu7t3v3__ao22_2
XFILLER_0_790 VDD VDD VSS VSS gf180mcu_as_sc_mcu7t3v3__fill_1
X_3081_ VDD VDD VSS VSS _3684_/A _3132_/B _3081_/C _3081_/Y _3615_/D gf180mcu_as_sc_mcu7t3v3__aoi211_2
XFILLER_208_575 VDD VDD VSS VSS gf180mcu_as_sc_mcu7t3v3__fillcap_16
XPHY_EDGE_ROW_40_3_Right_77 VDD VSS gf180mcu_as_sc_mcu7t3v3__tap_2
XPHY_EDGE_ROW_85_1_Left_295 VDD VSS gf180mcu_as_sc_mcu7t3v3__tap_2
XFILLER_208_597 VDD VDD VSS VSS gf180mcu_as_sc_mcu7t3v3__fillcap_16
XFILLER_21_1390 VDD VDD VSS VSS gf180mcu_as_sc_mcu7t3v3__fillcap_8
XFILLER_196_909 VDD VDD VSS VSS gf180mcu_as_sc_mcu7t3v3__fillcap_16
XFILLER_210_206 VDD VDD VSS VSS gf180mcu_as_sc_mcu7t3v3__fillcap_4
XFILLER_22_149 VDD VDD VSS VSS gf180mcu_as_sc_mcu7t3v3__fillcap_16
XFILLER_56_1453 VDD VDD VSS VSS gf180mcu_as_sc_mcu7t3v3__fillcap_4
Xclkbuf_leaf_26_clk_regs VDD VDD VSS VSS clkload0/A clkload8/A gf180mcu_as_sc_mcu7t3v3__clkbuff_12
X_3983_ VDD VDD VSS VSS _3983_/A _4103_/B _3983_/C _3983_/D _3985_/C gf180mcu_as_sc_mcu7t3v3__ao211_2
XFILLER_104_1407 VDD VDD VSS VSS gf180mcu_as_sc_mcu7t3v3__fill_1
XFILLER_143_1445 VDD VDD VSS VSS gf180mcu_as_sc_mcu7t3v3__fillcap_8
XFILLER_31_672 VDD VDD VSS VSS gf180mcu_as_sc_mcu7t3v3__fill_2
X_2934_ VDD VDD VSS VSS _3793_/A _3802_/A _3559_/A gf180mcu_as_sc_mcu7t3v3__or2_2
XFILLER_30_171 VDD VDD VSS VSS gf180mcu_as_sc_mcu7t3v3__fillcap_4
X_2865_ VDD VDD VSS VSS _2865_/B _4764_/Q _2866_/C gf180mcu_as_sc_mcu7t3v3__xnor2_2
X_4604_ VDD VDD VSS VSS _5198_/Q _4629_/B _4604_/C _5199_/Q _5198_/D gf180mcu_as_sc_mcu7t3v3__ao22_2
XFILLER_116_221 VDD VDD VSS VSS gf180mcu_as_sc_mcu7t3v3__fill_1
XFILLER_190_135 VDD VDD VSS VSS gf180mcu_as_sc_mcu7t3v3__fill_2
X_4535_ VDD VDD VSS VSS _4538_/C _4535_/C _5053_/Q _4536_/S gf180mcu_as_sc_mcu7t3v3__aoi21b_2
X_2796_ VDD VDD VSS VSS _2845_/A _2796_/B _2796_/C _2796_/D _2797_/D gf180mcu_as_sc_mcu7t3v3__ao211_2
XFILLER_117_27 VDD VDD VSS VSS gf180mcu_as_sc_mcu7t3v3__fillcap_16
XFILLER_176_1243 VDD VDD VSS VSS gf180mcu_as_sc_mcu7t3v3__fillcap_8
XPHY_EDGE_ROW_113_3_Left_498 VDD VSS gf180mcu_as_sc_mcu7t3v3__tap_2
XFILLER_176_1287 VDD VDD VSS VSS gf180mcu_as_sc_mcu7t3v3__fillcap_8
XFILLER_28_1500 VDD VDD VSS VSS gf180mcu_as_sc_mcu7t3v3__fillcap_4
XFILLER_89_116 VDD VDD VSS VSS gf180mcu_as_sc_mcu7t3v3__fillcap_16
X_4466_ VDD VDD VSS VSS _4469_/C _4466_/B _4521_/A gf180mcu_as_sc_mcu7t3v3__nor2_2
Xfanout803 VDD VDD VSS VSS _4488_/A _4570_/S gf180mcu_as_sc_mcu7t3v3__buff_12
Xfanout814 VDD VDD VSS VSS _2735_/D _2722_/B gf180mcu_as_sc_mcu7t3v3__buff_12
Xfanout825 VDD VDD VSS VSS fanout825/A _3795_/A gf180mcu_as_sc_mcu7t3v3__buff_12
X_4397_ VDD VDD VSS VSS _4397_/B _4497_/A _4398_/D gf180mcu_as_sc_mcu7t3v3__and2_2
X_3417_ VDD VDD VSS VSS _4932_/Q _3486_/B _3465_/C _4071_/A _3418_/C gf180mcu_as_sc_mcu7t3v3__ao22_2
XPHY_EDGE_ROW_50_3_Left_435 VDD VSS gf180mcu_as_sc_mcu7t3v3__tap_2
XPHY_EDGE_ROW_69_3_Right_106 VDD VSS gf180mcu_as_sc_mcu7t3v3__tap_2
Xfanout858 VDD VDD VSS VSS input34/Y _2668_/B gf180mcu_as_sc_mcu7t3v3__buff_12
X_3348_ VDD VDD VSS VSS _3349_/A _3997_/D _3468_/B _3348_/C gf180mcu_as_sc_mcu7t3v3__ao21_2
XFILLER_115_1558 VDD VDD VSS VSS gf180mcu_as_sc_mcu7t3v3__fillcap_8
XFILLER_133_59 VDD VDD VSS VSS gf180mcu_as_sc_mcu7t3v3__fillcap_8
XFILLER_26_1290 VDD VDD VSS VSS gf180mcu_as_sc_mcu7t3v3__fillcap_4
XFILLER_27_912 VDD VDD VSS VSS gf180mcu_as_sc_mcu7t3v3__fillcap_16
X_3279_ VDD VDD VSS VSS _3381_/S _3925_/A _3279_/A _3288_/A gf180mcu_as_sc_mcu7t3v3__mux2_2
XFILLER_26_422 VDD VDD VSS VSS gf180mcu_as_sc_mcu7t3v3__fillcap_4
X_5018_ VDD VDD VSS VSS clkload2/A _5018_/D _5018_/Q gf180mcu_as_sc_mcu7t3v3__dfxtp_2
XFILLER_201_206 VDD VDD VSS VSS gf180mcu_as_sc_mcu7t3v3__fillcap_4
XFILLER_201_228 VDD VDD VSS VSS gf180mcu_as_sc_mcu7t3v3__fillcap_16
XFILLER_10_823 VDD VDD VSS VSS gf180mcu_as_sc_mcu7t3v3__fillcap_16
XFILLER_158_34 VDD VDD VSS VSS gf180mcu_as_sc_mcu7t3v3__fill_1
XFILLER_166_121 VDD VDD VSS VSS gf180mcu_as_sc_mcu7t3v3__fillcap_4
XFILLER_194_430 VDD VDD VSS VSS gf180mcu_as_sc_mcu7t3v3__fillcap_8
XFILLER_42_45 VDD VDD VSS VSS gf180mcu_as_sc_mcu7t3v3__fillcap_4
XFILLER_210_784 VDD VDD VSS VSS gf180mcu_as_sc_mcu7t3v3__fillcap_4
XFILLER_5_359 VDD VDD VSS VSS gf180mcu_as_sc_mcu7t3v3__fillcap_8
XFILLER_81_1513 VDD VDD VSS VSS gf180mcu_as_sc_mcu7t3v3__fillcap_4
XPHY_EDGE_ROW_55_1_Right_576 VDD VSS gf180mcu_as_sc_mcu7t3v3__tap_2
XFILLER_42_1508 VDD VDD VSS VSS gf180mcu_as_sc_mcu7t3v3__fillcap_8
XFILLER_67_64 VDD VDD VSS VSS gf180mcu_as_sc_mcu7t3v3__fillcap_4
XFILLER_81_1568 VDD VDD VSS VSS gf180mcu_as_sc_mcu7t3v3__fill_1
XFILLER_88_193 VDD VDD VSS VSS gf180mcu_as_sc_mcu7t3v3__fillcap_16
XFILLER_188_1103 VDD VDD VSS VSS gf180mcu_as_sc_mcu7t3v3__fillcap_16
XFILLER_131_1360 VDD VDD VSS VSS gf180mcu_as_sc_mcu7t3v3__fill_2
XFILLER_17_411 VDD VDD VSS VSS gf180mcu_as_sc_mcu7t3v3__fillcap_8
XFILLER_17_422 VDD VDD VSS VSS gf180mcu_as_sc_mcu7t3v3__fillcap_8
XFILLER_29_282 VDD VDD VSS VSS gf180mcu_as_sc_mcu7t3v3__fillcap_16
XTAP_TAPCELL_ROW_205_2693 VDD VSS gf180mcu_as_sc_mcu7t3v3__tap_2
XTAP_TAPCELL_ROW_205_2682 VDD VSS gf180mcu_as_sc_mcu7t3v3__tap_2
XFILLER_178_909 VDD VDD VSS VSS gf180mcu_as_sc_mcu7t3v3__fillcap_16
XFILLER_205_556 VDD VDD VSS VSS gf180mcu_as_sc_mcu7t3v3__fillcap_4
XFILLER_205_578 VDD VDD VSS VSS gf180mcu_as_sc_mcu7t3v3__fillcap_16
XFILLER_16_90 VDD VDD VSS VSS gf180mcu_as_sc_mcu7t3v3__fillcap_4
XFILLER_189_279 VDD VDD VSS VSS gf180mcu_as_sc_mcu7t3v3__fill_1
XFILLER_34_1014 VDD VDD VSS VSS gf180mcu_as_sc_mcu7t3v3__fill_1
XFILLER_12_171 VDD VDD VSS VSS gf180mcu_as_sc_mcu7t3v3__fillcap_4
XFILLER_9_632 VDD VDD VSS VSS gf180mcu_as_sc_mcu7t3v3__fillcap_16
XFILLER_157_154 VDD VDD VSS VSS gf180mcu_as_sc_mcu7t3v3__fillcap_16
XFILLER_16_1481 VDD VDD VSS VSS gf180mcu_as_sc_mcu7t3v3__fillcap_16
XFILLER_9_654 VDD VDD VSS VSS gf180mcu_as_sc_mcu7t3v3__fill_1
X_2650_ VDD VDD VSS VSS _2650_/Y _2737_/A _2650_/B _2650_/C _2650_/D gf180mcu_as_sc_mcu7t3v3__aoi22_2
XFILLER_201_1030 VDD VDD VSS VSS gf180mcu_as_sc_mcu7t3v3__fillcap_16
XFILLER_201_1052 VDD VDD VSS VSS gf180mcu_as_sc_mcu7t3v3__fillcap_16
XFILLER_12_1367 VDD VDD VSS VSS gf180mcu_as_sc_mcu7t3v3__fillcap_4
Xoutput417 VDD VDD VSS VSS _4836_/Q south_out[31] gf180mcu_as_sc_mcu7t3v3__buff_12
Xoutput406 VDD VDD VSS VSS _4826_/Q south_out[21] gf180mcu_as_sc_mcu7t3v3__buff_12
X_2581_ VDD VDD VSS VSS _2581_/A _2858_/B _2674_/C _2581_/D _2581_/Y gf180mcu_as_sc_mcu7t3v3__ao211_2
XFILLER_181_680 VDD VDD VSS VSS gf180mcu_as_sc_mcu7t3v3__fillcap_16
Xoutput439 VDD VDD VSS VSS _4893_/Q west_out[20] gf180mcu_as_sc_mcu7t3v3__buff_12
Xoutput428 VDD VDD VSS VSS _4883_/Q west_out[10] gf180mcu_as_sc_mcu7t3v3__buff_12
X_4320_ VDD VDD VSS VSS _4324_/S _5150_/Q _5149_/Q _5149_/D gf180mcu_as_sc_mcu7t3v3__mux2_2
X_4251_ VDD VDD VSS VSS _4256_/S _4251_/B _5087_/Q _5087_/D gf180mcu_as_sc_mcu7t3v3__mux2_2
X_3202_ VDD VDD VSS VSS _3210_/B _3202_/B _3790_/A gf180mcu_as_sc_mcu7t3v3__nand2_2
X_4182_ VDD VDD VSS VSS _4242_/B _4197_/B _4197_/C _5020_/Q _5020_/D gf180mcu_as_sc_mcu7t3v3__ao22_2
X_3133_ VDD VDD VSS VSS _3140_/B _3163_/B _4114_/A gf180mcu_as_sc_mcu7t3v3__nand2_2
XFILLER_110_1411 VDD VDD VSS VSS gf180mcu_as_sc_mcu7t3v3__fill_2
XFILLER_208_350 VDD VDD VSS VSS gf180mcu_as_sc_mcu7t3v3__fill_1
X_3064_ VDD VDD VSS VSS _3141_/B _3064_/B _3064_/C _3065_/C gf180mcu_as_sc_mcu7t3v3__nor3_2
XTAP_TAPCELL_ROW_53_1_1605 VDD VSS gf180mcu_as_sc_mcu7t3v3__tap_2
XFILLER_110_1444 VDD VDD VSS VSS gf180mcu_as_sc_mcu7t3v3__fill_2
XFILLER_110_1455 VDD VDD VSS VSS gf180mcu_as_sc_mcu7t3v3__fill_1
XFILLER_94_196 VDD VDD VSS VSS gf180mcu_as_sc_mcu7t3v3__fillcap_16
XFILLER_97_1553 VDD VDD VSS VSS gf180mcu_as_sc_mcu7t3v3__fill_2
XFILLER_24_937 VDD VDD VSS VSS gf180mcu_as_sc_mcu7t3v3__fillcap_8
XFILLER_180_1409 VDD VDD VSS VSS gf180mcu_as_sc_mcu7t3v3__fillcap_16
X_3966_ VDD VDD VSS VSS _3966_/A _4032_/B _4027_/B _3966_/D _3970_/A gf180mcu_as_sc_mcu7t3v3__ao211_2
X_2917_ VDD VDD VSS VSS _2930_/A _3233_/C _3179_/B gf180mcu_as_sc_mcu7t3v3__nand2_2
XFILLER_176_463 VDD VDD VSS VSS gf180mcu_as_sc_mcu7t3v3__fill_1
XFILLER_191_400 VDD VDD VSS VSS gf180mcu_as_sc_mcu7t3v3__fillcap_16
X_3897_ VDD VDD VSS VSS _3897_/B _5187_/Q _4937_/D gf180mcu_as_sc_mcu7t3v3__and2_2
XFILLER_121_1540 VDD VDD VSS VSS gf180mcu_as_sc_mcu7t3v3__fillcap_16
XFILLER_128_37 VDD VDD VSS VSS gf180mcu_as_sc_mcu7t3v3__fill_2
XFILLER_12_37 VDD VDD VSS VSS gf180mcu_as_sc_mcu7t3v3__fillcap_16
XFILLER_176_485 VDD VDD VSS VSS gf180mcu_as_sc_mcu7t3v3__fillcap_4
XFILLER_178_1327 VDD VDD VSS VSS gf180mcu_as_sc_mcu7t3v3__fillcap_16
XFILLER_191_422 VDD VDD VSS VSS gf180mcu_as_sc_mcu7t3v3__fillcap_8
XFILLER_30_1412 VDD VDD VSS VSS gf180mcu_as_sc_mcu7t3v3__fillcap_8
X_2848_ VDD VDD VSS VSS _4948_/Q _3872_/A _3868_/C gf180mcu_as_sc_mcu7t3v3__and2_2
X_2779_ VDD VDD VSS VSS _5269_/Q _5275_/Q _4734_/B gf180mcu_as_sc_mcu7t3v3__or2_2
X_4518_ VDD VDD VSS VSS _4527_/S _5022_/Q _5051_/Q _4519_/B gf180mcu_as_sc_mcu7t3v3__mux2_2
X_4449_ VDD VDD VSS VSS _4449_/D _4561_/A _4449_/B _4449_/C _4450_/B gf180mcu_as_sc_mcu7t3v3__ao31_2
Xfanout600 VDD VDD VSS VSS _3919_/Y _4162_/B gf180mcu_as_sc_mcu7t3v3__buff_12
Xfanout622 VDD VDD VSS VSS _4264_/B _2734_/S gf180mcu_as_sc_mcu7t3v3__buff_12
XFILLER_144_69 VDD VDD VSS VSS gf180mcu_as_sc_mcu7t3v3__fillcap_16
XFILLER_24_1227 VDD VDD VSS VSS gf180mcu_as_sc_mcu7t3v3__fillcap_4
Xfanout644 VDD VDD VSS VSS _3452_/S _3381_/S gf180mcu_as_sc_mcu7t3v3__buff_12
Xfanout655 VDD VDD VSS VSS wire657/A _3241_/B gf180mcu_as_sc_mcu7t3v3__buff_12
Xfanout666 VDD VDD VSS VSS _2541_/Y _4328_/A gf180mcu_as_sc_mcu7t3v3__buff_12
XTAP_TAPCELL_ROW_31_1417 VDD VSS gf180mcu_as_sc_mcu7t3v3__tap_2
XTAP_TAPCELL_ROW_31_1406 VDD VSS gf180mcu_as_sc_mcu7t3v3__tap_2
Xfanout677 VDD VDD VSS VSS _3931_/Y _4103_/B gf180mcu_as_sc_mcu7t3v3__buff_12
Xfanout688 VDD VDD VSS VSS _4674_/B _4685_/C gf180mcu_as_sc_mcu7t3v3__buff_12
Xfanout699 VDD VDD VSS VSS _3928_/Y _4102_/B gf180mcu_as_sc_mcu7t3v3__buff_12
XFILLER_37_67 VDD VDD VSS VSS gf180mcu_as_sc_mcu7t3v3__fill_2
XFILLER_85_163 VDD VDD VSS VSS gf180mcu_as_sc_mcu7t3v3__fill_2
XFILLER_160_68 VDD VDD VSS VSS gf180mcu_as_sc_mcu7t3v3__fillcap_16
XFILLER_27_742 VDD VDD VSS VSS gf180mcu_as_sc_mcu7t3v3__fillcap_4
XTAP_TAPCELL_ROW_100_1_1744 VDD VSS gf180mcu_as_sc_mcu7t3v3__tap_2
XTAP_TAPCELL_ROW_112_3_3056 VDD VSS gf180mcu_as_sc_mcu7t3v3__tap_2
XFILLER_14_403 VDD VDD VSS VSS gf180mcu_as_sc_mcu7t3v3__fill_2
XFILLER_26_263 VDD VDD VSS VSS gf180mcu_as_sc_mcu7t3v3__fillcap_8
XFILLER_2_1089 VDD VDD VSS VSS gf180mcu_as_sc_mcu7t3v3__fill_1
XFILLER_15_948 VDD VDD VSS VSS gf180mcu_as_sc_mcu7t3v3__fill_1
XTAP_TAPCELL_ROW_29_1368 VDD VSS gf180mcu_as_sc_mcu7t3v3__tap_2
XFILLER_169_22 VDD VDD VSS VSS gf180mcu_as_sc_mcu7t3v3__fillcap_16
XFILLER_202_559 VDD VDD VSS VSS gf180mcu_as_sc_mcu7t3v3__fillcap_16
XFILLER_35_1323 VDD VDD VSS VSS gf180mcu_as_sc_mcu7t3v3__fillcap_4
XFILLER_53_88 VDD VDD VSS VSS gf180mcu_as_sc_mcu7t3v3__fillcap_16
XFILLER_74_1372 VDD VDD VSS VSS gf180mcu_as_sc_mcu7t3v3__fillcap_8
XTAP_TAPCELL_ROW_29_1379 VDD VSS gf180mcu_as_sc_mcu7t3v3__tap_2
XTAP_TAPCELL_ROW_175_2033 VDD VSS gf180mcu_as_sc_mcu7t3v3__tap_2
XTAP_TAPCELL_ROW_175_2022 VDD VSS gf180mcu_as_sc_mcu7t3v3__tap_2
XFILLER_195_750 VDD VDD VSS VSS gf180mcu_as_sc_mcu7t3v3__fillcap_16
XFILLER_74_1383 VDD VDD VSS VSS gf180mcu_as_sc_mcu7t3v3__fillcap_16
XFILLER_10_642 VDD VDD VSS VSS gf180mcu_as_sc_mcu7t3v3__fillcap_16
XFILLER_122_1348 VDD VDD VSS VSS gf180mcu_as_sc_mcu7t3v3__fillcap_16
XFILLER_183_912 VDD VDD VSS VSS gf180mcu_as_sc_mcu7t3v3__fillcap_16
XFILLER_195_772 VDD VDD VSS VSS gf180mcu_as_sc_mcu7t3v3__fillcap_16
XFILLER_202_1361 VDD VDD VSS VSS gf180mcu_as_sc_mcu7t3v3__fillcap_4
XTAP_TAPCELL_ROW_192_2391 VDD VSS gf180mcu_as_sc_mcu7t3v3__tap_2
XFILLER_185_54 VDD VDD VSS VSS gf180mcu_as_sc_mcu7t3v3__fillcap_16
XFILLER_202_1383 VDD VDD VSS VSS gf180mcu_as_sc_mcu7t3v3__fillcap_16
XFILLER_182_499 VDD VDD VSS VSS gf180mcu_as_sc_mcu7t3v3__fill_1
XFILLER_194_1151 VDD VDD VSS VSS gf180mcu_as_sc_mcu7t3v3__fillcap_4
XFILLER_5_156 VDD VDD VSS VSS gf180mcu_as_sc_mcu7t3v3__fill_1
XFILLER_118_81 VDD VDD VSS VSS gf180mcu_as_sc_mcu7t3v3__fillcap_8
XFILLER_194_1173 VDD VDD VSS VSS gf180mcu_as_sc_mcu7t3v3__fillcap_16
XFILLER_2_874 VDD VDD VSS VSS gf180mcu_as_sc_mcu7t3v3__fill_1
XPHY_EDGE_ROW_56_1_Right_577 VDD VSS gf180mcu_as_sc_mcu7t3v3__tap_2
XFILLER_133_1477 VDD VDD VSS VSS gf180mcu_as_sc_mcu7t3v3__fill_2
XFILLER_209_114 VDD VDD VSS VSS gf180mcu_as_sc_mcu7t3v3__fill_1
XFILLER_81_1398 VDD VDD VSS VSS gf180mcu_as_sc_mcu7t3v3__fillcap_16
Xmesh_tile_1010 VDD VDD VSS VSS nw_out[17] gf180mcu_as_sc_mcu7t3v3__tiel_4
XTAP_TAPCELL_ROW_207_2733 VDD VSS gf180mcu_as_sc_mcu7t3v3__tap_2
XTAP_TAPCELL_ROW_207_2722 VDD VSS gf180mcu_as_sc_mcu7t3v3__tap_2
XFILLER_133_1488 VDD VDD VSS VSS gf180mcu_as_sc_mcu7t3v3__fillcap_8
XFILLER_18_720 VDD VDD VSS VSS gf180mcu_as_sc_mcu7t3v3__fillcap_8
XFILLER_91_100 VDD VDD VSS VSS gf180mcu_as_sc_mcu7t3v3__fill_2
Xmesh_tile_1021 VDD VDD VSS VSS nw_out[28] gf180mcu_as_sc_mcu7t3v3__tiel_4
Xmesh_tile_1043 VDD VDD VSS VSS sw_out[16] gf180mcu_as_sc_mcu7t3v3__tiel_4
Xmesh_tile_1032 VDD VDD VSS VSS sw_out[5] gf180mcu_as_sc_mcu7t3v3__tiel_4
XFILLER_18_753 VDD VDD VSS VSS gf180mcu_as_sc_mcu7t3v3__fill_2
XFILLER_91_133 VDD VDD VSS VSS gf180mcu_as_sc_mcu7t3v3__fillcap_4
Xmesh_tile_1054 VDD VDD VSS VSS sw_out[27] gf180mcu_as_sc_mcu7t3v3__tiel_4
XFILLER_209_1504 VDD VDD VSS VSS gf180mcu_as_sc_mcu7t3v3__fillcap_16
XTAP_TAPCELL_ROW_199_2556 VDD VSS gf180mcu_as_sc_mcu7t3v3__tap_2
XTAP_TAPCELL_ROW_199_2545 VDD VSS gf180mcu_as_sc_mcu7t3v3__tap_2
X_3820_ VDD VDD VSS VSS _3821_/C _3820_/B _3915_/A gf180mcu_as_sc_mcu7t3v3__nor2_2
XFILLER_14_970 VDD VDD VSS VSS gf180mcu_as_sc_mcu7t3v3__fillcap_16
XFILLER_20_428 VDD VDD VSS VSS gf180mcu_as_sc_mcu7t3v3__fill_1
XPHY_EDGE_ROW_116_1_Left_326 VDD VSS gf180mcu_as_sc_mcu7t3v3__tap_2
X_3751_ VDD VDD VSS VSS _4126_/D _3751_/B _3751_/C _3751_/D _3752_/D gf180mcu_as_sc_mcu7t3v3__ao211_2
XFILLER_207_1294 VDD VDD VSS VSS gf180mcu_as_sc_mcu7t3v3__fillcap_16
X_2702_ VDD VDD VSS VSS _2709_/A _2702_/B _2702_/A _2702_/Y gf180mcu_as_sc_mcu7t3v3__mux2_2
XFILLER_105_1568 VDD VDD VSS VSS gf180mcu_as_sc_mcu7t3v3__fill_1
X_3682_ VDD VDD VSS VSS _3683_/C _3682_/C _3729_/B _4057_/A gf180mcu_as_sc_mcu7t3v3__aoi21_2
XFILLER_199_1084 VDD VDD VSS VSS gf180mcu_as_sc_mcu7t3v3__fillcap_16
X_2633_ VDD VDD VSS VSS _4646_/C _5232_/Q _5229_/Q _2776_/A _2634_/C gf180mcu_as_sc_mcu7t3v3__ao31_2
X_2564_ VDD VDD VSS VSS _2564_/Y _2565_/B _2736_/C gf180mcu_as_sc_mcu7t3v3__nor2_2
XFILLER_153_190 VDD VDD VSS VSS gf180mcu_as_sc_mcu7t3v3__fillcap_16
X_4303_ VDD VDD VSS VSS _4326_/S _5133_/Q _5132_/Q _5132_/D gf180mcu_as_sc_mcu7t3v3__mux2_2
XFILLER_138_1377 VDD VDD VSS VSS gf180mcu_as_sc_mcu7t3v3__fillcap_4
XTAP_TAPCELL_ROW_105_1_1759 VDD VSS gf180mcu_as_sc_mcu7t3v3__tap_2
X_5283_ VDD VDD VSS VSS _5285_/CLK _5283_/D _5283_/Q gf180mcu_as_sc_mcu7t3v3__dfxtp_2
X_2495_ VDD VDD VSS VSS _4954_/D _4594_/A _2495_/A gf180mcu_as_sc_mcu7t3v3__nor2b_2
XFILLER_151_1533 VDD VDD VSS VSS gf180mcu_as_sc_mcu7t3v3__fillcap_8
XFILLER_190_1560 VDD VDD VSS VSS gf180mcu_as_sc_mcu7t3v3__fillcap_8
X_4234_ VDD VDD VSS VSS _4256_/S _4234_/B _5070_/Q _5070_/D gf180mcu_as_sc_mcu7t3v3__mux2_2
XFILLER_151_1555 VDD VDD VSS VSS gf180mcu_as_sc_mcu7t3v3__fill_1
XFILLER_151_1566 VDD VDD VSS VSS gf180mcu_as_sc_mcu7t3v3__fill_2
X_4165_ VDD VDD VSS VSS _4165_/B _4165_/A _4257_/B gf180mcu_as_sc_mcu7t3v3__and2_2
XFILLER_82_100 VDD VDD VSS VSS gf180mcu_as_sc_mcu7t3v3__fillcap_4
X_3116_ VDD VDD VSS VSS _4790_/D _3116_/C _3124_/B _3715_/A gf180mcu_as_sc_mcu7t3v3__aoi21_2
XTAP_TAPCELL_ROW_72_1_1660 VDD VSS gf180mcu_as_sc_mcu7t3v3__tap_2
XFILLER_23_1282 VDD VDD VSS VSS gf180mcu_as_sc_mcu7t3v3__fill_1
X_4096_ VDD VDD VSS VSS _4096_/A _4130_/B _4128_/B _4096_/D _4097_/D gf180mcu_as_sc_mcu7t3v3__ao22_2
XFILLER_130_27 VDD VDD VSS VSS gf180mcu_as_sc_mcu7t3v3__fillcap_8
XFILLER_24_712 VDD VDD VSS VSS gf180mcu_as_sc_mcu7t3v3__fill_1
XFILLER_36_550 VDD VDD VSS VSS gf180mcu_as_sc_mcu7t3v3__fill_2
XFILLER_3_1398 VDD VDD VSS VSS gf180mcu_as_sc_mcu7t3v3__fill_2
XFILLER_82_177 VDD VDD VSS VSS gf180mcu_as_sc_mcu7t3v3__fillcap_4
X_3047_ VDD VDD VSS VSS _4025_/A _3079_/B _3047_/C _3047_/D _3048_/C gf180mcu_as_sc_mcu7t3v3__ao22_2
XFILLER_24_734 VDD VDD VSS VSS gf180mcu_as_sc_mcu7t3v3__fill_1
XTAP_TAPCELL_ROW_82_3_2966 VDD VSS gf180mcu_as_sc_mcu7t3v3__tap_2
XFILLER_145_1348 VDD VDD VSS VSS gf180mcu_as_sc_mcu7t3v3__fillcap_16
XFILLER_23_233 VDD VDD VSS VSS gf180mcu_as_sc_mcu7t3v3__fill_2
XPHY_EDGE_ROW_48_1_Left_258 VDD VSS gf180mcu_as_sc_mcu7t3v3__tap_2
X_4883__1084 VDD VDD VSS VSS _4883_/D gf180mcu_as_sc_mcu7t3v3__tiel_4
XFILLER_17_1031 VDD VDD VSS VSS gf180mcu_as_sc_mcu7t3v3__fillcap_8
X_4998_ VDD VDD VSS VSS _5085_/CLK _4998_/D _4998_/Q gf180mcu_as_sc_mcu7t3v3__dfxtp_2
XFILLER_177_783 VDD VDD VSS VSS gf180mcu_as_sc_mcu7t3v3__fillcap_16
XFILLER_183_219 VDD VDD VSS VSS gf180mcu_as_sc_mcu7t3v3__fill_1
XFILLER_23_69 VDD VDD VSS VSS gf180mcu_as_sc_mcu7t3v3__fill_1
XFILLER_32_1507 VDD VDD VSS VSS gf180mcu_as_sc_mcu7t3v3__fillcap_4
XTAP_TAPCELL_ROW_158_1_1920 VDD VSS gf180mcu_as_sc_mcu7t3v3__tap_2
X_3949_ VDD VDD VSS VSS _4031_/B _3949_/A _3951_/C gf180mcu_as_sc_mcu7t3v3__and2_2
XTAP_TAPCELL_ROW_24_1265 VDD VSS gf180mcu_as_sc_mcu7t3v3__tap_2
XTAP_TAPCELL_ROW_24_1254 VDD VSS gf180mcu_as_sc_mcu7t3v3__tap_2
XFILLER_139_58 VDD VDD VSS VSS gf180mcu_as_sc_mcu7t3v3__fillcap_8
XFILLER_176_271 VDD VDD VSS VSS gf180mcu_as_sc_mcu7t3v3__fill_1
XFILLER_192_731 VDD VDD VSS VSS gf180mcu_as_sc_mcu7t3v3__fillcap_4
XFILLER_136_135 VDD VDD VSS VSS gf180mcu_as_sc_mcu7t3v3__fill_1
XFILLER_136_157 VDD VDD VSS VSS gf180mcu_as_sc_mcu7t3v3__fillcap_16
XFILLER_178_1135 VDD VDD VSS VSS gf180mcu_as_sc_mcu7t3v3__fillcap_16
XFILLER_191_230 VDD VDD VSS VSS gf180mcu_as_sc_mcu7t3v3__fill_1
XFILLER_192_753 VDD VDD VSS VSS gf180mcu_as_sc_mcu7t3v3__fillcap_16
XFILLER_121_1381 VDD VDD VSS VSS gf180mcu_as_sc_mcu7t3v3__fill_2
XFILLER_156_1411 VDD VDD VSS VSS gf180mcu_as_sc_mcu7t3v3__fillcap_16
XFILLER_178_1157 VDD VDD VSS VSS gf180mcu_as_sc_mcu7t3v3__fill_1
XFILLER_30_1286 VDD VDD VSS VSS gf180mcu_as_sc_mcu7t3v3__fillcap_8
XFILLER_30_1297 VDD VDD VSS VSS gf180mcu_as_sc_mcu7t3v3__fillcap_8
XFILLER_69_1485 VDD VDD VSS VSS gf180mcu_as_sc_mcu7t3v3__fill_1
XPHY_EDGE_ROW_162_1_Left_372 VDD VSS gf180mcu_as_sc_mcu7t3v3__tap_2
XFILLER_171_34 VDD VDD VSS VSS gf180mcu_as_sc_mcu7t3v3__fillcap_16
XFILLER_24_1068 VDD VDD VSS VSS gf180mcu_as_sc_mcu7t3v3__fill_2
Xfanout485 VDD VDD VSS VSS _4150_/B _4158_/B gf180mcu_as_sc_mcu7t3v3__buff_12
XFILLER_0_18 VDD VDD VSS VSS gf180mcu_as_sc_mcu7t3v3__fillcap_16
XFILLER_206_139 VDD VDD VSS VSS gf180mcu_as_sc_mcu7t3v3__fillcap_16
XTAP_TAPCELL_ROW_131_1_1838 VDD VSS gf180mcu_as_sc_mcu7t3v3__tap_2
XFILLER_14_222 VDD VDD VSS VSS gf180mcu_as_sc_mcu7t3v3__fill_2
XFILLER_199_341 VDD VDD VSS VSS gf180mcu_as_sc_mcu7t3v3__fillcap_8
XFILLER_199_352 VDD VDD VSS VSS gf180mcu_as_sc_mcu7t3v3__fillcap_16
XFILLER_27_594 VDD VDD VSS VSS gf180mcu_as_sc_mcu7t3v3__fillcap_16
XPHY_EDGE_ROW_138_3_Left_523 VDD VSS gf180mcu_as_sc_mcu7t3v3__tap_2
XFILLER_128_1568 VDD VDD VSS VSS gf180mcu_as_sc_mcu7t3v3__fill_1
XFILLER_163_1415 VDD VDD VSS VSS gf180mcu_as_sc_mcu7t3v3__fill_1
XFILLER_37_1418 VDD VDD VSS VSS gf180mcu_as_sc_mcu7t3v3__fillcap_4
XFILLER_9_27 VDD VDD VSS VSS gf180mcu_as_sc_mcu7t3v3__fillcap_16
XTAP_TAPCELL_ROW_194_2431 VDD VSS gf180mcu_as_sc_mcu7t3v3__tap_2
XFILLER_187_536 VDD VDD VSS VSS gf180mcu_as_sc_mcu7t3v3__fill_2
XFILLER_30_737 VDD VDD VSS VSS gf180mcu_as_sc_mcu7t3v3__fill_2
XTAP_TAPCELL_ROW_194_2442 VDD VSS gf180mcu_as_sc_mcu7t3v3__tap_2
XFILLER_11_940 VDD VDD VSS VSS gf180mcu_as_sc_mcu7t3v3__fill_2
XFILLER_80_53 VDD VDD VSS VSS gf180mcu_as_sc_mcu7t3v3__fillcap_16
XFILLER_127_124 VDD VDD VSS VSS gf180mcu_as_sc_mcu7t3v3__fillcap_16
XFILLER_196_53 VDD VDD VSS VSS gf180mcu_as_sc_mcu7t3v3__fillcap_16
XFILLER_7_944 VDD VDD VSS VSS gf180mcu_as_sc_mcu7t3v3__fillcap_16
Xwire831 VDD VDD VSS VSS wire831/A _4032_/D gf180mcu_as_sc_mcu7t3v3__clkbuff_12
Xwire842 VDD VDD VSS VSS wire842/A _4159_/A gf180mcu_as_sc_mcu7t3v3__clkbuff_12
Xmax_cap608 VDD VDD VSS VSS _3903_/B _3902_/B gf180mcu_as_sc_mcu7t3v3__clkbuff_12
Xwire853 VDD VDD VSS VSS wire853/A _4072_/A gf180mcu_as_sc_mcu7t3v3__clkbuff_12
Xwire864 VDD VDD VSS VSS wire864/A _4148_/A gf180mcu_as_sc_mcu7t3v3__clkbuff_12
Xwire875 VDD VDD VSS VSS wire875/A _4105_/A gf180mcu_as_sc_mcu7t3v3__clkbuff_12
XFILLER_129_80 VDD VDD VSS VSS gf180mcu_as_sc_mcu7t3v3__fill_2
XFILLER_100_1476 VDD VDD VSS VSS gf180mcu_as_sc_mcu7t3v3__fillcap_16
XTAP_TAPCELL_ROW_77_1_1675 VDD VSS gf180mcu_as_sc_mcu7t3v3__tap_2
XFILLER_174_1566 VDD VDD VSS VSS gf180mcu_as_sc_mcu7t3v3__fill_2
XPHY_EDGE_ROW_57_1_Right_578 VDD VSS gf180mcu_as_sc_mcu7t3v3__tap_2
XFILLER_49_174 VDD VDD VSS VSS gf180mcu_as_sc_mcu7t3v3__fillcap_8
XFILLER_64_111 VDD VDD VSS VSS gf180mcu_as_sc_mcu7t3v3__fill_2
XFILLER_168_1348 VDD VDD VSS VSS gf180mcu_as_sc_mcu7t3v3__fillcap_16
XFILLER_64_166 VDD VDD VSS VSS gf180mcu_as_sc_mcu7t3v3__fillcap_8
XFILLER_64_177 VDD VDD VSS VSS gf180mcu_as_sc_mcu7t3v3__fillcap_16
XFILLER_94_1501 VDD VDD VSS VSS gf180mcu_as_sc_mcu7t3v3__fillcap_16
XFILLER_18_594 VDD VDD VSS VSS gf180mcu_as_sc_mcu7t3v3__fill_1
X_4921_ VDD VDD VSS VSS clkload9/A _4921_/D _4921_/Q gf180mcu_as_sc_mcu7t3v3__dfxtp_2
XFILLER_33_553 VDD VDD VSS VSS gf180mcu_as_sc_mcu7t3v3__fillcap_4
X_4852_ VDD VDD VSS VSS _5256_/CLK _4852_/D _4852_/Q gf180mcu_as_sc_mcu7t3v3__dfxtp_2
X_3803_ VDD VDD VSS VSS _3804_/B _3831_/A _3803_/B _3803_/A gf180mcu_as_sc_mcu7t3v3__aoi21b_2
XFILLER_20_225 VDD VDD VSS VSS gf180mcu_as_sc_mcu7t3v3__fillcap_8
XFILLER_20_247 VDD VDD VSS VSS gf180mcu_as_sc_mcu7t3v3__fillcap_16
X_4783_ VDD VDD VSS VSS _5220_/CLK _4783_/D _4783_/Q gf180mcu_as_sc_mcu7t3v3__dfxtp_2
XFILLER_174_720 VDD VDD VSS VSS gf180mcu_as_sc_mcu7t3v3__fill_2
X_3734_ VDD VDD VSS VSS _3738_/B _3734_/C _3758_/B _4110_/A gf180mcu_as_sc_mcu7t3v3__aoi21_2
XFILLER_105_1376 VDD VDD VSS VSS gf180mcu_as_sc_mcu7t3v3__fill_2
XTAP_TAPCELL_ROW_12_990 VDD VSS gf180mcu_as_sc_mcu7t3v3__tap_2
X_3665_ VDD VDD VSS VSS _4928_/Q _3727_/B _3741_/C _4040_/D _3666_/D gf180mcu_as_sc_mcu7t3v3__ao22_2
XFILLER_118_179 VDD VDD VSS VSS gf180mcu_as_sc_mcu7t3v3__fill_1
XFILLER_175_1319 VDD VDD VSS VSS gf180mcu_as_sc_mcu7t3v3__fillcap_4
X_2616_ VDD VDD VSS VSS _4628_/S _2883_/B _2634_/B gf180mcu_as_sc_mcu7t3v3__and2_2
X_3596_ VDD VDD VSS VSS _3968_/A _3649_/B _3656_/C _3968_/D _3597_/D gf180mcu_as_sc_mcu7t3v3__ao22_2
X_2547_ VDD VDD VSS VSS _4955_/D _2547_/B _4594_/A gf180mcu_as_sc_mcu7t3v3__nor2_2
XFILLER_125_27 VDD VDD VSS VSS gf180mcu_as_sc_mcu7t3v3__fillcap_8
X_5266_ VDD VDD VSS VSS _5285_/CLK _5266_/D _5266_/Q gf180mcu_as_sc_mcu7t3v3__dfxtp_2
X_2478_ VDD VDD VSS VSS _4947_/Q _2478_/B _2478_/A _5478_/A gf180mcu_as_sc_mcu7t3v3__mux2_2
XFILLER_116_1450 VDD VDD VSS VSS gf180mcu_as_sc_mcu7t3v3__fill_1
XFILLER_29_804 VDD VDD VSS VSS gf180mcu_as_sc_mcu7t3v3__fillcap_16
XFILLER_64_1393 VDD VDD VSS VSS gf180mcu_as_sc_mcu7t3v3__fillcap_16
XFILLER_99_1401 VDD VDD VSS VSS gf180mcu_as_sc_mcu7t3v3__fillcap_8
X_4217_ VDD VDD VSS VSS _4246_/B _4224_/B _4224_/C _5053_/Q _5053_/D gf180mcu_as_sc_mcu7t3v3__ao22_2
XFILLER_21_1208 VDD VDD VSS VSS gf180mcu_as_sc_mcu7t3v3__fill_2
XFILLER_28_314 VDD VDD VSS VSS gf180mcu_as_sc_mcu7t3v3__fill_1
X_5197_ VDD VDD VSS VSS _5197_/CLK _5197_/D _5197_/Q gf180mcu_as_sc_mcu7t3v3__dfxtp_2
XFILLER_186_1415 VDD VDD VSS VSS gf180mcu_as_sc_mcu7t3v3__fillcap_16
XFILLER_25_1399 VDD VDD VSS VSS gf180mcu_as_sc_mcu7t3v3__fill_1
XFILLER_28_325 VDD VDD VSS VSS gf180mcu_as_sc_mcu7t3v3__fill_1
XFILLER_99_1467 VDD VDD VSS VSS gf180mcu_as_sc_mcu7t3v3__fillcap_16
X_4148_ VDD VDD VSS VSS _4164_/S _4148_/B _4148_/A _4149_/B gf180mcu_as_sc_mcu7t3v3__mux2_2
XFILLER_18_69 VDD VDD VSS VSS gf180mcu_as_sc_mcu7t3v3__fillcap_8
X_4079_ VDD VDD VSS VSS _4079_/A _4129_/B _4129_/C _4933_/Q _4081_/C gf180mcu_as_sc_mcu7t3v3__ao22_2
XFILLER_70_169 VDD VDD VSS VSS gf180mcu_as_sc_mcu7t3v3__fillcap_4
XTAP_TAPCELL_ROW_26_1305 VDD VSS gf180mcu_as_sc_mcu7t3v3__tap_2
XFILLER_11_203 VDD VDD VSS VSS gf180mcu_as_sc_mcu7t3v3__fillcap_4
XFILLER_12_737 VDD VDD VSS VSS gf180mcu_as_sc_mcu7t3v3__fillcap_16
XFILLER_24_575 VDD VDD VSS VSS gf180mcu_as_sc_mcu7t3v3__fillcap_16
Xsram2048.u_bank0_913 VDD VDD VSS VSS sram2048.u_bank0/WEN[3] gf180mcu_as_sc_mcu7t3v3__tiel_4
XFILLER_7_207 VDD VDD VSS VSS gf180mcu_as_sc_mcu7t3v3__fill_2
Xclkload1 VDD VDD VSS VSS clkload1/A clkload1/Y gf180mcu_as_sc_mcu7t3v3__clkbuff_4
XFILLER_123_1476 VDD VDD VSS VSS gf180mcu_as_sc_mcu7t3v3__fill_2
XFILLER_166_34 VDD VDD VSS VSS gf180mcu_as_sc_mcu7t3v3__fill_1
XFILLER_50_45 VDD VDD VSS VSS gf180mcu_as_sc_mcu7t3v3__fillcap_4
XTAP_TAPCELL_ROW_10_949 VDD VSS gf180mcu_as_sc_mcu7t3v3__tap_2
XFILLER_180_734 VDD VDD VSS VSS gf180mcu_as_sc_mcu7t3v3__fill_1
XFILLER_4_936 VDD VDD VSS VSS gf180mcu_as_sc_mcu7t3v3__fillcap_8
XFILLER_4_947 VDD VDD VSS VSS gf180mcu_as_sc_mcu7t3v3__fill_2
XFILLER_182_22 VDD VDD VSS VSS gf180mcu_as_sc_mcu7t3v3__fillcap_8
XFILLER_191_1154 VDD VDD VSS VSS gf180mcu_as_sc_mcu7t3v3__fillcap_16
XFILLER_132_193 VDD VDD VSS VSS gf180mcu_as_sc_mcu7t3v3__fillcap_16
XTAP_TAPCELL_ROW_187_2290 VDD VSS gf180mcu_as_sc_mcu7t3v3__tap_2
XFILLER_130_1403 VDD VDD VSS VSS gf180mcu_as_sc_mcu7t3v3__fill_1
XFILLER_19_314 VDD VDD VSS VSS gf180mcu_as_sc_mcu7t3v3__fillcap_16
XFILLER_43_1466 VDD VDD VSS VSS gf180mcu_as_sc_mcu7t3v3__fillcap_16
XFILLER_8_1073 VDD VDD VSS VSS gf180mcu_as_sc_mcu7t3v3__fill_2
XFILLER_43_1488 VDD VDD VSS VSS gf180mcu_as_sc_mcu7t3v3__fillcap_8
XTAP_TAPCELL_ROW_183_2198 VDD VSS gf180mcu_as_sc_mcu7t3v3__tap_2
XFILLER_130_1469 VDD VDD VSS VSS gf180mcu_as_sc_mcu7t3v3__fillcap_8
XFILLER_201_18 VDD VDD VSS VSS gf180mcu_as_sc_mcu7t3v3__fillcap_16
XFILLER_34_317 VDD VDD VSS VSS gf180mcu_as_sc_mcu7t3v3__fillcap_16
XFILLER_34_339 VDD VDD VSS VSS gf180mcu_as_sc_mcu7t3v3__fill_1
XFILLER_46_177 VDD VDD VSS VSS gf180mcu_as_sc_mcu7t3v3__fillcap_16
XFILLER_188_801 VDD VDD VSS VSS gf180mcu_as_sc_mcu7t3v3__fillcap_4
XFILLER_188_823 VDD VDD VSS VSS gf180mcu_as_sc_mcu7t3v3__fillcap_16
XFILLER_203_610 VDD VDD VSS VSS gf180mcu_as_sc_mcu7t3v3__fillcap_16
XFILLER_203_632 VDD VDD VSS VSS gf180mcu_as_sc_mcu7t3v3__fillcap_16
XFILLER_206_1507 VDD VDD VSS VSS gf180mcu_as_sc_mcu7t3v3__fillcap_16
XFILLER_27_391 VDD VDD VSS VSS gf180mcu_as_sc_mcu7t3v3__fillcap_16
XPHY_EDGE_ROW_160_3_Right_197 VDD VSS gf180mcu_as_sc_mcu7t3v3__tap_2
XFILLER_147_208 VDD VDD VSS VSS gf180mcu_as_sc_mcu7t3v3__fill_2
XFILLER_54_1540 VDD VDD VSS VSS gf180mcu_as_sc_mcu7t3v3__fill_1
XFILLER_91_96 VDD VDD VSS VSS gf180mcu_as_sc_mcu7t3v3__fillcap_4
XFILLER_15_1535 VDD VDD VSS VSS gf180mcu_as_sc_mcu7t3v3__fillcap_4
XFILLER_30_578 VDD VDD VSS VSS gf180mcu_as_sc_mcu7t3v3__fillcap_4
XFILLER_50_1415 VDD VDD VSS VSS gf180mcu_as_sc_mcu7t3v3__fillcap_4
XFILLER_10_280 VDD VDD VSS VSS gf180mcu_as_sc_mcu7t3v3__fill_1
XFILLER_190_509 VDD VDD VSS VSS gf180mcu_as_sc_mcu7t3v3__fillcap_16
XFILLER_204_1275 VDD VDD VSS VSS gf180mcu_as_sc_mcu7t3v3__fillcap_16
XFILLER_204_1297 VDD VDD VSS VSS gf180mcu_as_sc_mcu7t3v3__fillcap_16
XFILLER_6_251 VDD VDD VSS VSS gf180mcu_as_sc_mcu7t3v3__fill_2
XFILLER_13_1292 VDD VDD VSS VSS gf180mcu_as_sc_mcu7t3v3__fillcap_16
XFILLER_196_1065 VDD VDD VSS VSS gf180mcu_as_sc_mcu7t3v3__fillcap_16
XFILLER_196_1087 VDD VDD VSS VSS gf180mcu_as_sc_mcu7t3v3__fillcap_16
XFILLER_7_796 VDD VDD VSS VSS gf180mcu_as_sc_mcu7t3v3__fillcap_4
X_3450_ VDD VDD VSS VSS _3450_/B _4103_/A _3451_/D gf180mcu_as_sc_mcu7t3v3__and2_2
XFILLER_139_1461 VDD VDD VSS VSS gf180mcu_as_sc_mcu7t3v3__fillcap_16
X_3381_ VDD VDD VSS VSS _3381_/S _4032_/D _3381_/A _3383_/B gf180mcu_as_sc_mcu7t3v3__mux2_2
X_2401_ VDD VDD VSS VSS _2765_/D _4754_/Q gf180mcu_as_sc_mcu7t3v3__inv_2
X_5120_ VDD VDD VSS VSS clkload7/A _5120_/D _5120_/Q gf180mcu_as_sc_mcu7t3v3__dfxtp_2
XFILLER_174_1396 VDD VDD VSS VSS gf180mcu_as_sc_mcu7t3v3__fillcap_4
XFILLER_48_1399 VDD VDD VSS VSS gf180mcu_as_sc_mcu7t3v3__fillcap_4
X_5051_ VDD VDD VSS VSS clkload4/A _5051_/D _5051_/Q gf180mcu_as_sc_mcu7t3v3__dfxtp_2
XFILLER_61_1566 VDD VDD VSS VSS gf180mcu_as_sc_mcu7t3v3__fill_2
XPHY_EDGE_ROW_58_1_Right_579 VDD VSS gf180mcu_as_sc_mcu7t3v3__tap_2
X_4002_ VDD VDD VSS VSS _4003_/C _4002_/B _4002_/A gf180mcu_as_sc_mcu7t3v3__nor2_2
XFILLER_37_100 VDD VDD VSS VSS gf180mcu_as_sc_mcu7t3v3__fill_2
XFILLER_1_72 VDD VDD VSS VSS gf180mcu_as_sc_mcu7t3v3__fillcap_16
XFILLER_26_807 VDD VDD VSS VSS gf180mcu_as_sc_mcu7t3v3__fillcap_16
XTAP_TAPCELL_ROW_113_3_3061 VDD VSS gf180mcu_as_sc_mcu7t3v3__tap_2
XFILLER_0_1357 VDD VDD VSS VSS gf180mcu_as_sc_mcu7t3v3__fill_2
XFILLER_146_1432 VDD VDD VSS VSS gf180mcu_as_sc_mcu7t3v3__fillcap_16
XFILLER_179_812 VDD VDD VSS VSS gf180mcu_as_sc_mcu7t3v3__fill_1
XFILLER_207_982 VDD VDD VSS VSS gf180mcu_as_sc_mcu7t3v3__fillcap_16
XFILLER_146_1465 VDD VDD VSS VSS gf180mcu_as_sc_mcu7t3v3__fill_2
XFILLER_179_834 VDD VDD VSS VSS gf180mcu_as_sc_mcu7t3v3__fillcap_4
XFILLER_55_1348 VDD VDD VSS VSS gf180mcu_as_sc_mcu7t3v3__fillcap_16
X_4904_ VDD VDD VSS VSS _4904_/CLK _4904_/D _4904_/Q gf180mcu_as_sc_mcu7t3v3__dfxtp_2
XFILLER_107_1449 VDD VDD VSS VSS gf180mcu_as_sc_mcu7t3v3__fillcap_16
XFILLER_33_394 VDD VDD VSS VSS gf180mcu_as_sc_mcu7t3v3__fillcap_16
X_4835_ VDD VDD VSS VSS _5073_/CLK _4835_/D _4835_/Q gf180mcu_as_sc_mcu7t3v3__dfxtp_2
XFILLER_21_578 VDD VDD VSS VSS gf180mcu_as_sc_mcu7t3v3__fillcap_4
X_4766_ VDD VDD VSS VSS clkload6/A _4766_/D _4766_/Q gf180mcu_as_sc_mcu7t3v3__dfxtp_2
XTAP_TAPCELL_ROW_21_1202 VDD VSS gf180mcu_as_sc_mcu7t3v3__tap_2
XFILLER_193_347 VDD VDD VSS VSS gf180mcu_as_sc_mcu7t3v3__fill_2
X_3717_ VDD VDD VSS VSS _3718_/C _4093_/D _3751_/B _3717_/C gf180mcu_as_sc_mcu7t3v3__ao21_2
XFILLER_174_561 VDD VDD VSS VSS gf180mcu_as_sc_mcu7t3v3__fillcap_4
X_4697_ VDD VDD VSS VSS _4707_/S _5253_/Q _4697_/A _5253_/D gf180mcu_as_sc_mcu7t3v3__mux2_2
XFILLER_106_127 VDD VDD VSS VSS gf180mcu_as_sc_mcu7t3v3__fill_1
XFILLER_175_1116 VDD VDD VSS VSS gf180mcu_as_sc_mcu7t3v3__fillcap_4
XFILLER_175_1138 VDD VDD VSS VSS gf180mcu_as_sc_mcu7t3v3__fillcap_4
XFILLER_20_37 VDD VDD VSS VSS gf180mcu_as_sc_mcu7t3v3__fillcap_16
X_3648_ VDD VDD VSS VSS _4926_/Q _3648_/B _3648_/C _4023_/A _3650_/C gf180mcu_as_sc_mcu7t3v3__ao22_2
XFILLER_136_37 VDD VDD VSS VSS gf180mcu_as_sc_mcu7t3v3__fillcap_8
XFILLER_192_1441 VDD VDD VSS VSS gf180mcu_as_sc_mcu7t3v3__fill_2
XFILLER_66_1433 VDD VDD VSS VSS gf180mcu_as_sc_mcu7t3v3__fillcap_16
X_3579_ VDD VDD VSS VSS _3580_/C _3579_/C _3660_/B _3943_/A gf180mcu_as_sc_mcu7t3v3__aoi21_2
XFILLER_1_928 VDD VDD VSS VSS gf180mcu_as_sc_mcu7t3v3__fillcap_16
XTAP_TAPCELL_ROW_19_1153 VDD VSS gf180mcu_as_sc_mcu7t3v3__tap_2
XTAP_TAPCELL_ROW_19_1142 VDD VSS gf180mcu_as_sc_mcu7t3v3__tap_2
XFILLER_114_1409 VDD VDD VSS VSS gf180mcu_as_sc_mcu7t3v3__fill_1
XFILLER_114_193 VDD VDD VSS VSS gf180mcu_as_sc_mcu7t3v3__fillcap_16
XFILLER_192_1485 VDD VDD VSS VSS gf180mcu_as_sc_mcu7t3v3__fillcap_16
Xinput306 VDD VDD VSS VSS west_in[30] _3796_/A gf180mcu_as_sc_mcu7t3v3__buff_12
XTAP_TAPCELL_ROW_57_3_2892 VDD VSS gf180mcu_as_sc_mcu7t3v3__tap_2
X_5249_ VDD VDD VSS VSS clkload6/A _5249_/D _5249_/Q gf180mcu_as_sc_mcu7t3v3__dfxtp_2
XFILLER_5_1246 VDD VDD VSS VSS gf180mcu_as_sc_mcu7t3v3__fill_2
XFILLER_21_1049 VDD VDD VSS VSS gf180mcu_as_sc_mcu7t3v3__fill_1
XFILLER_16_328 VDD VDD VSS VSS gf180mcu_as_sc_mcu7t3v3__fillcap_8
XFILLER_28_177 VDD VDD VSS VSS gf180mcu_as_sc_mcu7t3v3__fillcap_4
XFILLER_43_114 VDD VDD VSS VSS gf180mcu_as_sc_mcu7t3v3__fillcap_16
XFILLER_45_67 VDD VDD VSS VSS gf180mcu_as_sc_mcu7t3v3__fill_2
XFILLER_73_1415 VDD VDD VSS VSS gf180mcu_as_sc_mcu7t3v3__fill_1
XFILLER_197_664 VDD VDD VSS VSS gf180mcu_as_sc_mcu7t3v3__fillcap_16
XFILLER_200_613 VDD VDD VSS VSS gf180mcu_as_sc_mcu7t3v3__fillcap_16
XFILLER_38_1568 VDD VDD VSS VSS gf180mcu_as_sc_mcu7t3v3__fill_1
XFILLER_12_567 VDD VDD VSS VSS gf180mcu_as_sc_mcu7t3v3__fill_1
XFILLER_12_578 VDD VDD VSS VSS gf180mcu_as_sc_mcu7t3v3__fill_1
XFILLER_131_2 VDD VDD VSS VSS gf180mcu_as_sc_mcu7t3v3__fillcap_16
XFILLER_177_22 VDD VDD VSS VSS gf180mcu_as_sc_mcu7t3v3__fillcap_16
XFILLER_184_314 VDD VDD VSS VSS gf180mcu_as_sc_mcu7t3v3__fill_1
XTAP_TAPCELL_ROW_126_1_1822 VDD VSS gf180mcu_as_sc_mcu7t3v3__tap_2
XFILLER_61_88 VDD VDD VSS VSS gf180mcu_as_sc_mcu7t3v3__fillcap_8
XTAP_TAPCELL_ROW_138_3_3134 VDD VSS gf180mcu_as_sc_mcu7t3v3__tap_2
XFILLER_10_1410 VDD VDD VSS VSS gf180mcu_as_sc_mcu7t3v3__fillcap_4
XFILLER_177_88 VDD VDD VSS VSS gf180mcu_as_sc_mcu7t3v3__fillcap_16
XFILLER_32_1189 VDD VDD VSS VSS gf180mcu_as_sc_mcu7t3v3__fillcap_16
XFILLER_197_1396 VDD VDD VSS VSS gf180mcu_as_sc_mcu7t3v3__fillcap_4
XTAP_TAPCELL_ROW_189_2330 VDD VSS gf180mcu_as_sc_mcu7t3v3__tap_2
XFILLER_193_54 VDD VDD VSS VSS gf180mcu_as_sc_mcu7t3v3__fillcap_16
XTAP_TAPCELL_ROW_189_2341 VDD VSS gf180mcu_as_sc_mcu7t3v3__tap_2
XFILLER_171_1503 VDD VDD VSS VSS gf180mcu_as_sc_mcu7t3v3__fill_2
XFILLER_180_597 VDD VDD VSS VSS gf180mcu_as_sc_mcu7t3v3__fillcap_16
XFILLER_80_1408 VDD VDD VSS VSS gf180mcu_as_sc_mcu7t3v3__fillcap_16
XTAP_TAPCELL_ROW_106_1_1764 VDD VSS gf180mcu_as_sc_mcu7t3v3__tap_2
XTAP_TAPCELL_ROW_118_3_3076 VDD VSS gf180mcu_as_sc_mcu7t3v3__tap_2
XTAP_TAPCELL_ROW_210_2784 VDD VSS gf180mcu_as_sc_mcu7t3v3__tap_2
XFILLER_171_1558 VDD VDD VSS VSS gf180mcu_as_sc_mcu7t3v3__fillcap_8
XFILLER_3_298 VDD VDD VSS VSS gf180mcu_as_sc_mcu7t3v3__fill_2
XTAP_TAPCELL_ROW_210_2795 VDD VSS gf180mcu_as_sc_mcu7t3v3__tap_2
XTAP_TAPCELL_ROW_185_2249 VDD VSS gf180mcu_as_sc_mcu7t3v3__tap_2
XTAP_TAPCELL_ROW_185_2238 VDD VSS gf180mcu_as_sc_mcu7t3v3__tap_2
XFILLER_120_152 VDD VDD VSS VSS gf180mcu_as_sc_mcu7t3v3__fillcap_16
XFILLER_86_41 VDD VDD VSS VSS gf180mcu_as_sc_mcu7t3v3__fill_1
XPHY_EDGE_ROW_125_1_Left_335 VDD VSS gf180mcu_as_sc_mcu7t3v3__tap_2
XFILLER_120_174 VDD VDD VSS VSS gf180mcu_as_sc_mcu7t3v3__fill_1
XFILLER_19_111 VDD VDD VSS VSS gf180mcu_as_sc_mcu7t3v3__fillcap_16
XFILLER_169_1476 VDD VDD VSS VSS gf180mcu_as_sc_mcu7t3v3__fillcap_8
XFILLER_34_103 VDD VDD VSS VSS gf180mcu_as_sc_mcu7t3v3__fill_2
XFILLER_78_1348 VDD VDD VSS VSS gf180mcu_as_sc_mcu7t3v3__fillcap_4
XFILLER_34_147 VDD VDD VSS VSS gf180mcu_as_sc_mcu7t3v3__fillcap_16
XTAP_TAPCELL_ROW_83_3_2971 VDD VSS gf180mcu_as_sc_mcu7t3v3__tap_2
XFILLER_15_372 VDD VDD VSS VSS gf180mcu_as_sc_mcu7t3v3__fill_2
XFILLER_16_884 VDD VDD VSS VSS gf180mcu_as_sc_mcu7t3v3__fillcap_16
XFILLER_204_941 VDD VDD VSS VSS gf180mcu_as_sc_mcu7t3v3__fillcap_4
XFILLER_204_963 VDD VDD VSS VSS gf180mcu_as_sc_mcu7t3v3__fillcap_16
XFILLER_31_821 VDD VDD VSS VSS gf180mcu_as_sc_mcu7t3v3__fillcap_8
XFILLER_91_1526 VDD VDD VSS VSS gf180mcu_as_sc_mcu7t3v3__fillcap_4
X_2950_ VDD VDD VSS VSS _3930_/A _3076_/B _3076_/C _3933_/D _2951_/C gf180mcu_as_sc_mcu7t3v3__ao22_2
XPHY_EDGE_ROW_161_3_Right_198 VDD VSS gf180mcu_as_sc_mcu7t3v3__tap_2
X_2881_ VDD VDD VSS VSS _4719_/A _4763_/Q _2882_/D gf180mcu_as_sc_mcu7t3v3__and2_2
XFILLER_15_1332 VDD VDD VSS VSS gf180mcu_as_sc_mcu7t3v3__fillcap_16
XFILLER_187_174 VDD VDD VSS VSS gf180mcu_as_sc_mcu7t3v3__fillcap_16
X_4620_ VDD VDD VSS VSS _5214_/Q _4624_/B _4620_/C _5215_/Q _5214_/D gf180mcu_as_sc_mcu7t3v3__ao22_2
XFILLER_89_1411 VDD VDD VSS VSS gf180mcu_as_sc_mcu7t3v3__fillcap_4
XFILLER_190_317 VDD VDD VSS VSS gf180mcu_as_sc_mcu7t3v3__fillcap_16
X_4551_ VDD VDD VSS VSS _4552_/C _4559_/S _5026_/Q _4561_/A gf180mcu_as_sc_mcu7t3v3__ao21_2
XTAP_TAPCELL_ROW_174_1986 VDD VSS gf180mcu_as_sc_mcu7t3v3__tap_2
XTAP_TAPCELL_ROW_174_1975 VDD VSS gf180mcu_as_sc_mcu7t3v3__tap_2
XFILLER_7_571 VDD VDD VSS VSS gf180mcu_as_sc_mcu7t3v3__fill_1
XFILLER_89_1466 VDD VDD VSS VSS gf180mcu_as_sc_mcu7t3v3__fillcap_16
XFILLER_89_1488 VDD VDD VSS VSS gf180mcu_as_sc_mcu7t3v3__fillcap_8
Xwire491 VDD VDD VSS VSS _3132_/Y _4792_/D gf180mcu_as_sc_mcu7t3v3__clkbuff_12
X_4482_ VDD VDD VSS VSS _4485_/C _4482_/C _5047_/Q _4509_/S gf180mcu_as_sc_mcu7t3v3__aoi21b_2
X_3502_ VDD VDD VSS VSS _4160_/A _3502_/B _3502_/C _3502_/D _3504_/C gf180mcu_as_sc_mcu7t3v3__ao211_2
XTAP_TAPCELL_ROW_174_1997 VDD VSS gf180mcu_as_sc_mcu7t3v3__tap_2
X_3433_ VDD VDD VSS VSS _3479_/C _4088_/A _3435_/C gf180mcu_as_sc_mcu7t3v3__and2_2
XTAP_TAPCELL_ROW_152_1_1901 VDD VSS gf180mcu_as_sc_mcu7t3v3__tap_2
XPHY_EDGE_ROW_57_1_Left_267 VDD VSS gf180mcu_as_sc_mcu7t3v3__tap_2
X_5103_ VDD VDD VSS VSS _5260_/CLK _5103_/D _5103_/Q gf180mcu_as_sc_mcu7t3v3__dfxtp_2
X_3364_ VDD VDD VSS VSS _4013_/A _3451_/B _3364_/C _3364_/D _3365_/A gf180mcu_as_sc_mcu7t3v3__ao211_2
XTAP_TAPCELL_ROW_164_3_3213 VDD VSS gf180mcu_as_sc_mcu7t3v3__tap_2
X_3295_ VDD VDD VSS VSS _3943_/A _3382_/C _3295_/C _3296_/C _3416_/B gf180mcu_as_sc_mcu7t3v3__aoi211_2
XFILLER_111_174 VDD VDD VSS VSS gf180mcu_as_sc_mcu7t3v3__fillcap_16
XFILLER_22_1314 VDD VDD VSS VSS gf180mcu_as_sc_mcu7t3v3__fill_1
X_5034_ VDD VDD VSS VSS _5085_/CLK _5034_/D _5034_/Q gf180mcu_as_sc_mcu7t3v3__dfxtp_2
XTAP_TAPCELL_ROW_1_758 VDD VSS gf180mcu_as_sc_mcu7t3v3__tap_2
XTAP_TAPCELL_ROW_1_747 VDD VSS gf180mcu_as_sc_mcu7t3v3__tap_2
XFILLER_0_1121 VDD VDD VSS VSS gf180mcu_as_sc_mcu7t3v3__fill_1
XFILLER_148_1538 VDD VDD VSS VSS gf180mcu_as_sc_mcu7t3v3__fill_2
XFILLER_183_1418 VDD VDD VSS VSS gf180mcu_as_sc_mcu7t3v3__fill_2
XFILLER_25_136 VDD VDD VSS VSS gf180mcu_as_sc_mcu7t3v3__fillcap_4
XFILLER_25_158 VDD VDD VSS VSS gf180mcu_as_sc_mcu7t3v3__fillcap_16
XFILLER_0_1187 VDD VDD VSS VSS gf180mcu_as_sc_mcu7t3v3__fill_2
XFILLER_179_642 VDD VDD VSS VSS gf180mcu_as_sc_mcu7t3v3__fill_1
XFILLER_15_59 VDD VDD VSS VSS gf180mcu_as_sc_mcu7t3v3__fillcap_8
XFILLER_210_911 VDD VDD VSS VSS gf180mcu_as_sc_mcu7t3v3__fillcap_4
XFILLER_40_139 VDD VDD VSS VSS gf180mcu_as_sc_mcu7t3v3__fillcap_4
XPHY_EDGE_ROW_171_1_Left_381 VDD VSS gf180mcu_as_sc_mcu7t3v3__tap_2
XFILLER_178_163 VDD VDD VSS VSS gf180mcu_as_sc_mcu7t3v3__fill_2
XFILLER_178_174 VDD VDD VSS VSS gf180mcu_as_sc_mcu7t3v3__fill_1
XFILLER_181_1186 VDD VDD VSS VSS gf180mcu_as_sc_mcu7t3v3__fillcap_4
XFILLER_182_807 VDD VDD VSS VSS gf180mcu_as_sc_mcu7t3v3__fillcap_4
XFILLER_194_645 VDD VDD VSS VSS gf180mcu_as_sc_mcu7t3v3__fillcap_16
XFILLER_194_667 VDD VDD VSS VSS gf180mcu_as_sc_mcu7t3v3__fillcap_16
X_4818_ VDD VDD VSS VSS _5068_/CLK _4818_/D _4818_/Q gf180mcu_as_sc_mcu7t3v3__dfxtp_2
XFILLER_175_881 VDD VDD VSS VSS gf180mcu_as_sc_mcu7t3v3__fillcap_16
XFILLER_5_508 VDD VDD VSS VSS gf180mcu_as_sc_mcu7t3v3__fillcap_4
X_4749_ VDD VDD VSS VSS _4750_/C _4749_/B _4749_/A gf180mcu_as_sc_mcu7t3v3__nand2_2
XFILLER_147_47 VDD VDD VSS VSS gf180mcu_as_sc_mcu7t3v3__fill_2
XFILLER_68_1506 VDD VDD VSS VSS gf180mcu_as_sc_mcu7t3v3__fill_1
XTAP_TAPCELL_ROW_78_1_1680 VDD VSS gf180mcu_as_sc_mcu7t3v3__tap_2
XPHY_EDGE_ROW_123_3_Right_160 VDD VSS gf180mcu_as_sc_mcu7t3v3__tap_2
XFILLER_0_246 VDD VDD VSS VSS gf180mcu_as_sc_mcu7t3v3__fill_1
XPHY_EDGE_ROW_147_3_Left_532 VDD VSS gf180mcu_as_sc_mcu7t3v3__tap_2
XFILLER_44_1550 VDD VDD VSS VSS gf180mcu_as_sc_mcu7t3v3__fillcap_16
Xinput103 VDD VDD VSS VSS ne_in[32] _3521_/A gf180mcu_as_sc_mcu7t3v3__buff_12
Xinput114 VDD VDD VSS VSS north_in[11] _4023_/A gf180mcu_as_sc_mcu7t3v3__buff_12
Xinput125 VDD VDD VSS VSS north_in[21] _4102_/A gf180mcu_as_sc_mcu7t3v3__buff_12
Xinput136 VDD VDD VSS VSS north_in[31] _3510_/A gf180mcu_as_sc_mcu7t3v3__buff_12
XTAP_TAPCELL_ROW_88_3_2986 VDD VSS gf180mcu_as_sc_mcu7t3v3__tap_2
XFILLER_102_174 VDD VDD VSS VSS gf180mcu_as_sc_mcu7t3v3__fill_1
Xinput147 VDD VDD VSS VSS nw_in[10] _4016_/A gf180mcu_as_sc_mcu7t3v3__buff_12
Xinput158 VDD VDD VSS VSS nw_in[20] _4094_/A gf180mcu_as_sc_mcu7t3v3__buff_12
Xinput169 VDD VDD VSS VSS nw_in[30] _3801_/A gf180mcu_as_sc_mcu7t3v3__buff_12
XTAP_TAPCELL_ROW_180_2124 VDD VSS gf180mcu_as_sc_mcu7t3v3__tap_2
XFILLER_188_1329 VDD VDD VSS VSS gf180mcu_as_sc_mcu7t3v3__fillcap_16
XFILLER_63_209 VDD VDD VSS VSS gf180mcu_as_sc_mcu7t3v3__fill_1
XTAP_TAPCELL_ROW_180_2135 VDD VSS gf180mcu_as_sc_mcu7t3v3__tap_2
XFILLER_40_1469 VDD VDD VSS VSS gf180mcu_as_sc_mcu7t3v3__fillcap_8
XFILLER_112_50 VDD VDD VSS VSS gf180mcu_as_sc_mcu7t3v3__fill_2
XFILLER_71_220 VDD VDD VSS VSS gf180mcu_as_sc_mcu7t3v3__fill_2
XFILLER_32_629 VDD VDD VSS VSS gf180mcu_as_sc_mcu7t3v3__fillcap_4
XFILLER_31_128 VDD VDD VSS VSS gf180mcu_as_sc_mcu7t3v3__fill_1
XFILLER_185_612 VDD VDD VSS VSS gf180mcu_as_sc_mcu7t3v3__fill_1
XFILLER_185_623 VDD VDD VSS VSS gf180mcu_as_sc_mcu7t3v3__fillcap_4
XFILLER_198_995 VDD VDD VSS VSS gf180mcu_as_sc_mcu7t3v3__fillcap_16
XFILLER_201_944 VDD VDD VSS VSS gf180mcu_as_sc_mcu7t3v3__fillcap_16
XTAP_TAPCELL_ROW_51_1_1598 VDD VSS gf180mcu_as_sc_mcu7t3v3__tap_2
XTAP_TAPCELL_ROW_178_2097 VDD VSS gf180mcu_as_sc_mcu7t3v3__tap_2
XTAP_TAPCELL_ROW_178_2086 VDD VSS gf180mcu_as_sc_mcu7t3v3__tap_2
XFILLER_169_196 VDD VDD VSS VSS gf180mcu_as_sc_mcu7t3v3__fill_2
XFILLER_51_1543 VDD VDD VSS VSS gf180mcu_as_sc_mcu7t3v3__fillcap_8
XTAP_TAPCELL_ROW_157_1_1916 VDD VSS gf180mcu_as_sc_mcu7t3v3__tap_2
XFILLER_184_177 VDD VDD VSS VSS gf180mcu_as_sc_mcu7t3v3__fillcap_16
XTAP_TAPCELL_ROW_169_3_3228 VDD VSS gf180mcu_as_sc_mcu7t3v3__tap_2
XFILLER_201_1256 VDD VDD VSS VSS gf180mcu_as_sc_mcu7t3v3__fillcap_4
XFILLER_201_1278 VDD VDD VSS VSS gf180mcu_as_sc_mcu7t3v3__fillcap_16
X_4896__1071 VDD VDD VSS VSS _4896_/D gf180mcu_as_sc_mcu7t3v3__tiel_4
XFILLER_140_203 VDD VDD VSS VSS gf180mcu_as_sc_mcu7t3v3__fillcap_16
XFILLER_193_1046 VDD VDD VSS VSS gf180mcu_as_sc_mcu7t3v3__fillcap_4
XFILLER_193_1068 VDD VDD VSS VSS gf180mcu_as_sc_mcu7t3v3__fillcap_16
XPHY_EDGE_ROW_79_3_Left_464 VDD VSS gf180mcu_as_sc_mcu7t3v3__tap_2
XFILLER_136_1431 VDD VDD VSS VSS gf180mcu_as_sc_mcu7t3v3__fillcap_16
XFILLER_39_206 VDD VDD VSS VSS gf180mcu_as_sc_mcu7t3v3__fillcap_4
X_3080_ VDD VDD VSS VSS _3132_/B _3080_/B _3080_/C _3081_/C gf180mcu_as_sc_mcu7t3v3__nor3_2
XFILLER_208_521 VDD VDD VSS VSS gf180mcu_as_sc_mcu7t3v3__fillcap_4
XFILLER_208_543 VDD VDD VSS VSS gf180mcu_as_sc_mcu7t3v3__fillcap_16
XFILLER_35_489 VDD VDD VSS VSS gf180mcu_as_sc_mcu7t3v3__fill_1
X_3982_ VDD VDD VSS VSS _3982_/A _4023_/B _4023_/C _4921_/Q _3983_/D gf180mcu_as_sc_mcu7t3v3__ao22_2
XFILLER_143_1413 VDD VDD VSS VSS gf180mcu_as_sc_mcu7t3v3__fill_2
XFILLER_15_180 VDD VDD VSS VSS gf180mcu_as_sc_mcu7t3v3__fillcap_16
XFILLER_182_1462 VDD VDD VSS VSS gf180mcu_as_sc_mcu7t3v3__fillcap_8
XFILLER_94_2 VDD VDD VSS VSS gf180mcu_as_sc_mcu7t3v3__fill_2
X_2933_ VDD VDD VSS VSS _3922_/A _3793_/A _3802_/A gf180mcu_as_sc_mcu7t3v3__nor2_2
XFILLER_143_1457 VDD VDD VSS VSS gf180mcu_as_sc_mcu7t3v3__fill_2
XFILLER_176_667 VDD VDD VSS VSS gf180mcu_as_sc_mcu7t3v3__fill_2
XFILLER_206_1189 VDD VDD VSS VSS gf180mcu_as_sc_mcu7t3v3__fillcap_16
XPHY_EDGE_ROW_162_3_Right_199 VDD VSS gf180mcu_as_sc_mcu7t3v3__tap_2
X_2864_ VDD VDD VSS VSS _2865_/B _4764_/Q _2868_/B gf180mcu_as_sc_mcu7t3v3__and2_2
XFILLER_15_1173 VDD VDD VSS VSS gf180mcu_as_sc_mcu7t3v3__fill_1
XFILLER_175_144 VDD VDD VSS VSS gf180mcu_as_sc_mcu7t3v3__fill_1
XFILLER_191_626 VDD VDD VSS VSS gf180mcu_as_sc_mcu7t3v3__fillcap_4
X_4603_ VDD VDD VSS VSS _5197_/Q _4629_/B _4604_/C _5198_/Q _5197_/D gf180mcu_as_sc_mcu7t3v3__ao22_2
X_2795_ VDD VDD VSS VSS _4643_/B _2795_/A _5221_/Q _4626_/A _2796_/D gf180mcu_as_sc_mcu7t3v3__ao31_2
XFILLER_191_648 VDD VDD VSS VSS gf180mcu_as_sc_mcu7t3v3__fillcap_16
X_4534_ VDD VDD VSS VSS _4535_/C _4536_/S _5024_/Q _4538_/A gf180mcu_as_sc_mcu7t3v3__ao21_2
XFILLER_11_1048 VDD VDD VSS VSS gf180mcu_as_sc_mcu7t3v3__fill_2
X_4465_ VDD VDD VSS VSS _4465_/D _4510_/A _4465_/B _4465_/C _4466_/B gf180mcu_as_sc_mcu7t3v3__ao31_2
XFILLER_154_1520 VDD VDD VSS VSS gf180mcu_as_sc_mcu7t3v3__fill_1
XFILLER_176_1299 VDD VDD VSS VSS gf180mcu_as_sc_mcu7t3v3__fill_1
XFILLER_28_1523 VDD VDD VSS VSS gf180mcu_as_sc_mcu7t3v3__fillcap_8
XFILLER_63_1414 VDD VDD VSS VSS gf180mcu_as_sc_mcu7t3v3__fill_2
Xfanout804 VDD VDD VSS VSS _5094_/Q _4488_/A gf180mcu_as_sc_mcu7t3v3__buff_12
Xfanout815 VDD VDD VSS VSS _2735_/D _2736_/B gf180mcu_as_sc_mcu7t3v3__buff_12
X_4396_ VDD VDD VSS VSS _5167_/Q _4470_/B _4479_/C _5117_/Q _4397_/B gf180mcu_as_sc_mcu7t3v3__ao22_2
X_3416_ VDD VDD VSS VSS _4067_/A _3416_/B _3416_/C _4821_/D _3416_/D gf180mcu_as_sc_mcu7t3v3__aoi211_2
XFILLER_115_1504 VDD VDD VSS VSS gf180mcu_as_sc_mcu7t3v3__fillcap_8
X_3347_ VDD VDD VSS VSS _4000_/D _3466_/B _3347_/C _3347_/D _3348_/C gf180mcu_as_sc_mcu7t3v3__ao211_2
XFILLER_133_27 VDD VDD VSS VSS gf180mcu_as_sc_mcu7t3v3__fillcap_16
Xfanout859 VDD VDD VSS VSS input34/Y _2709_/A gf180mcu_as_sc_mcu7t3v3__buff_12
XFILLER_6_1363 VDD VDD VSS VSS gf180mcu_as_sc_mcu7t3v3__fill_2
X_5017_ VDD VDD VSS VSS clkload2/A _5017_/D _5017_/Q gf180mcu_as_sc_mcu7t3v3__dfxtp_2
X_3278_ VDD VDD VSS VSS _3522_/B _3814_/A _3278_/Y gf180mcu_as_sc_mcu7t3v3__and2_2
XFILLER_53_220 VDD VDD VSS VSS gf180mcu_as_sc_mcu7t3v3__fill_2
XFILLER_14_629 VDD VDD VSS VSS gf180mcu_as_sc_mcu7t3v3__fillcap_16
XFILLER_187_1395 VDD VDD VSS VSS gf180mcu_as_sc_mcu7t3v3__fillcap_4
XFILLER_198_225 VDD VDD VSS VSS gf180mcu_as_sc_mcu7t3v3__fillcap_16
XFILLER_26_489 VDD VDD VSS VSS gf180mcu_as_sc_mcu7t3v3__fillcap_8
XFILLER_198_247 VDD VDD VSS VSS gf180mcu_as_sc_mcu7t3v3__fillcap_16
XFILLER_10_802 VDD VDD VSS VSS gf180mcu_as_sc_mcu7t3v3__fill_2
XFILLER_70_1407 VDD VDD VSS VSS gf180mcu_as_sc_mcu7t3v3__fillcap_4
XFILLER_161_1568 VDD VDD VSS VSS gf180mcu_as_sc_mcu7t3v3__fill_1
XFILLER_179_494 VDD VDD VSS VSS gf180mcu_as_sc_mcu7t3v3__fill_1
XFILLER_194_442 VDD VDD VSS VSS gf180mcu_as_sc_mcu7t3v3__fill_1
XFILLER_21_172 VDD VDD VSS VSS gf180mcu_as_sc_mcu7t3v3__fill_1
XFILLER_195_976 VDD VDD VSS VSS gf180mcu_as_sc_mcu7t3v3__fillcap_4
XFILLER_195_998 VDD VDD VSS VSS gf180mcu_as_sc_mcu7t3v3__fillcap_16
XFILLER_202_1543 VDD VDD VSS VSS gf180mcu_as_sc_mcu7t3v3__fill_1
XFILLER_33_1262 VDD VDD VSS VSS gf180mcu_as_sc_mcu7t3v3__fillcap_8
XFILLER_124_1390 VDD VDD VSS VSS gf180mcu_as_sc_mcu7t3v3__fillcap_16
XFILLER_166_188 VDD VDD VSS VSS gf180mcu_as_sc_mcu7t3v3__fillcap_8
XFILLER_181_136 VDD VDD VSS VSS gf180mcu_as_sc_mcu7t3v3__fillcap_4
XFILLER_181_158 VDD VDD VSS VSS gf180mcu_as_sc_mcu7t3v3__fillcap_16
XFILLER_194_1399 VDD VDD VSS VSS gf180mcu_as_sc_mcu7t3v3__fillcap_16
XFILLER_3_18 VDD VDD VSS VSS gf180mcu_as_sc_mcu7t3v3__fill_2
XPHY_EDGE_ROW_124_3_Right_161 VDD VSS gf180mcu_as_sc_mcu7t3v3__tap_2
XFILLER_107_72 VDD VDD VSS VSS gf180mcu_as_sc_mcu7t3v3__fillcap_16
XFILLER_67_32 VDD VDD VSS VSS gf180mcu_as_sc_mcu7t3v3__fillcap_16
XFILLER_81_1558 VDD VDD VSS VSS gf180mcu_as_sc_mcu7t3v3__fillcap_8
XFILLER_190_22 VDD VDD VSS VSS gf180mcu_as_sc_mcu7t3v3__fillcap_8
XFILLER_7_1138 VDD VDD VSS VSS gf180mcu_as_sc_mcu7t3v3__fillcap_8
XTAP_TAPCELL_ROW_5_850 VDD VSS gf180mcu_as_sc_mcu7t3v3__tap_2
XFILLER_18_902 VDD VDD VSS VSS gf180mcu_as_sc_mcu7t3v3__fill_2
XFILLER_44_1380 VDD VDD VSS VSS gf180mcu_as_sc_mcu7t3v3__fill_1
XFILLER_123_93 VDD VDD VSS VSS gf180mcu_as_sc_mcu7t3v3__fill_2
XFILLER_205_524 VDD VDD VSS VSS gf180mcu_as_sc_mcu7t3v3__fillcap_16
XFILLER_83_31 VDD VDD VSS VSS gf180mcu_as_sc_mcu7t3v3__fill_2
XTAP_TAPCELL_ROW_205_2683 VDD VSS gf180mcu_as_sc_mcu7t3v3__tap_2
XTAP_TAPCELL_ROW_205_2672 VDD VSS gf180mcu_as_sc_mcu7t3v3__tap_2
XFILLER_189_247 VDD VDD VSS VSS gf180mcu_as_sc_mcu7t3v3__fillcap_16
XFILLER_32_437 VDD VDD VSS VSS gf180mcu_as_sc_mcu7t3v3__fillcap_4
XFILLER_12_1313 VDD VDD VSS VSS gf180mcu_as_sc_mcu7t3v3__fillcap_16
XFILLER_200_295 VDD VDD VSS VSS gf180mcu_as_sc_mcu7t3v3__fillcap_16
XFILLER_103_1474 VDD VDD VSS VSS gf180mcu_as_sc_mcu7t3v3__fillcap_4
Xoutput407 VDD VDD VSS VSS _4827_/Q south_out[22] gf180mcu_as_sc_mcu7t3v3__buff_12
X_2580_ VDD VDD VSS VSS _2852_/B _2580_/A _2581_/D gf180mcu_as_sc_mcu7t3v3__and2_2
XFILLER_86_1469 VDD VDD VSS VSS gf180mcu_as_sc_mcu7t3v3__fillcap_16
Xoutput429 VDD VDD VSS VSS _4884_/Q west_out[11] gf180mcu_as_sc_mcu7t3v3__buff_12
Xoutput418 VDD VDD VSS VSS _4837_/Q south_out[32] gf180mcu_as_sc_mcu7t3v3__buff_12
X_4250_ VDD VDD VSS VSS _4257_/S _4250_/B _5086_/Q _5086_/D gf180mcu_as_sc_mcu7t3v3__mux2_2
X_4181_ VDD VDD VSS VSS _4241_/B _4197_/B _4197_/C _5019_/Q _5019_/D gf180mcu_as_sc_mcu7t3v3__ao22_2
X_3201_ VDD VDD VSS VSS _3789_/A _3223_/B _3201_/C _3203_/B gf180mcu_as_sc_mcu7t3v3__nand3_2
XFILLER_79_161 VDD VDD VSS VSS gf180mcu_as_sc_mcu7t3v3__fillcap_4
X_3132_ VDD VDD VSS VSS _3731_/A _3132_/B _3132_/C _3132_/Y _3730_/D gf180mcu_as_sc_mcu7t3v3__aoi211_2
XFILLER_23_1464 VDD VDD VSS VSS gf180mcu_as_sc_mcu7t3v3__fillcap_4
XFILLER_27_209 VDD VDD VSS VSS gf180mcu_as_sc_mcu7t3v3__fill_1
XFILLER_3_1536 VDD VDD VSS VSS gf180mcu_as_sc_mcu7t3v3__fillcap_4
X_3063_ VDD VDD VSS VSS _4041_/A _3163_/B _3063_/C _3063_/D _3064_/C gf180mcu_as_sc_mcu7t3v3__ao22_2
XFILLER_208_384 VDD VDD VSS VSS gf180mcu_as_sc_mcu7t3v3__fill_1
XFILLER_36_754 VDD VDD VSS VSS gf180mcu_as_sc_mcu7t3v3__fill_2
XFILLER_24_905 VDD VDD VSS VSS gf180mcu_as_sc_mcu7t3v3__fillcap_16
XFILLER_93_1418 VDD VDD VSS VSS gf180mcu_as_sc_mcu7t3v3__fillcap_4
XTAP_TAPCELL_ROW_51_3_2873 VDD VSS gf180mcu_as_sc_mcu7t3v3__tap_2
XFILLER_184_1568 VDD VDD VSS VSS gf180mcu_as_sc_mcu7t3v3__fill_1
XFILLER_182_1270 VDD VDD VSS VSS gf180mcu_as_sc_mcu7t3v3__fillcap_16
XFILLER_195_206 VDD VDD VSS VSS gf180mcu_as_sc_mcu7t3v3__fillcap_4
XFILLER_195_228 VDD VDD VSS VSS gf180mcu_as_sc_mcu7t3v3__fillcap_4
X_3965_ VDD VDD VSS VSS _3965_/A _4032_/C _4030_/B _3965_/D _3966_/D gf180mcu_as_sc_mcu7t3v3__ao22_2
XFILLER_17_1257 VDD VDD VSS VSS gf180mcu_as_sc_mcu7t3v3__fill_2
XFILLER_32_971 VDD VDD VSS VSS gf180mcu_as_sc_mcu7t3v3__fill_2
X_3896_ VDD VDD VSS VSS _3897_/B _5186_/Q _4936_/D gf180mcu_as_sc_mcu7t3v3__and2_2
X_2916_ VDD VDD VSS VSS _3201_/C _2948_/B _3233_/C gf180mcu_as_sc_mcu7t3v3__and2_2
XFILLER_12_27 VDD VDD VSS VSS gf180mcu_as_sc_mcu7t3v3__fillcap_8
XFILLER_177_976 VDD VDD VSS VSS gf180mcu_as_sc_mcu7t3v3__fillcap_4
XFILLER_177_998 VDD VDD VSS VSS gf180mcu_as_sc_mcu7t3v3__fillcap_16
XFILLER_31_492 VDD VDD VSS VSS gf180mcu_as_sc_mcu7t3v3__fillcap_16
X_2847_ VDD VDD VSS VSS _5228_/Q _4372_/D _2847_/C _4371_/B _2853_/A gf180mcu_as_sc_mcu7t3v3__ao211_2
XFILLER_148_177 VDD VDD VSS VSS gf180mcu_as_sc_mcu7t3v3__fill_2
XFILLER_191_434 VDD VDD VSS VSS gf180mcu_as_sc_mcu7t3v3__fill_1
XFILLER_163_136 VDD VDD VSS VSS gf180mcu_as_sc_mcu7t3v3__fillcap_4
XFILLER_163_158 VDD VDD VSS VSS gf180mcu_as_sc_mcu7t3v3__fillcap_16
XFILLER_192_979 VDD VDD VSS VSS gf180mcu_as_sc_mcu7t3v3__fillcap_16
X_2778_ VDD VDD VSS VSS _2778_/B _5270_/Q _2781_/B gf180mcu_as_sc_mcu7t3v3__and2_2
X_4517_ VDD VDD VSS VSS _4520_/C _4993_/Q _4527_/S gf180mcu_as_sc_mcu7t3v3__nand2b_2
X_4448_ VDD VDD VSS VSS _4449_/D _4448_/B _4561_/A gf180mcu_as_sc_mcu7t3v3__nor2_2
XTAP_TAPCELL_ROW_35_1510 VDD VSS gf180mcu_as_sc_mcu7t3v3__tap_2
XFILLER_144_37 VDD VDD VSS VSS gf180mcu_as_sc_mcu7t3v3__fillcap_16
XFILLER_28_1331 VDD VDD VSS VSS gf180mcu_as_sc_mcu7t3v3__fillcap_16
Xfanout601 VDD VDD VSS VSS _4116_/A _4124_/D gf180mcu_as_sc_mcu7t3v3__buff_12
Xfanout612 VDD VDD VSS VSS _3125_/B _3042_/B gf180mcu_as_sc_mcu7t3v3__buff_12
Xfanout623 VDD VDD VSS VSS _2576_/Y _4264_/B gf180mcu_as_sc_mcu7t3v3__buff_12
XFILLER_154_1383 VDD VDD VSS VSS gf180mcu_as_sc_mcu7t3v3__fillcap_16
XFILLER_28_1364 VDD VDD VSS VSS gf180mcu_as_sc_mcu7t3v3__fill_1
XFILLER_28_1375 VDD VDD VSS VSS gf180mcu_as_sc_mcu7t3v3__fillcap_4
XFILLER_8_1447 VDD VDD VSS VSS gf180mcu_as_sc_mcu7t3v3__fill_1
Xfanout634 VDD VDD VSS VSS _3724_/B _3649_/B gf180mcu_as_sc_mcu7t3v3__buff_12
Xfanout645 VDD VDD VSS VSS _3267_/Y _3452_/S gf180mcu_as_sc_mcu7t3v3__buff_12
Xfanout656 VDD VDD VSS VSS _2947_/Y wire657/A gf180mcu_as_sc_mcu7t3v3__buff_12
Xfanout667 VDD VDD VSS VSS _4601_/C _4604_/C gf180mcu_as_sc_mcu7t3v3__buff_12
X_4379_ VDD VDD VSS VSS _4379_/B _5164_/Q _4380_/B gf180mcu_as_sc_mcu7t3v3__or2_2
XTAP_TAPCELL_ROW_31_1407 VDD VSS gf180mcu_as_sc_mcu7t3v3__tap_2
XFILLER_189_1402 VDD VDD VSS VSS gf180mcu_as_sc_mcu7t3v3__fillcap_4
XFILLER_24_1239 VDD VDD VSS VSS gf180mcu_as_sc_mcu7t3v3__fillcap_8
Xfanout678 VDD VDD VSS VSS _3931_/Y _4130_/B gf180mcu_as_sc_mcu7t3v3__buff_12
Xfanout689 VDD VDD VSS VSS _4101_/C _4031_/B gf180mcu_as_sc_mcu7t3v3__buff_12
XTAP_TAPCELL_ROW_31_1418 VDD VSS gf180mcu_as_sc_mcu7t3v3__tap_2
XFILLER_115_1389 VDD VDD VSS VSS gf180mcu_as_sc_mcu7t3v3__fillcap_16
XFILLER_189_1468 VDD VDD VSS VSS gf180mcu_as_sc_mcu7t3v3__fill_2
XFILLER_18_209 VDD VDD VSS VSS gf180mcu_as_sc_mcu7t3v3__fillcap_16
XFILLER_170_6 VDD VDD VSS VSS gf180mcu_as_sc_mcu7t3v3__fillcap_16
XFILLER_26_220 VDD VDD VSS VSS gf180mcu_as_sc_mcu7t3v3__fillcap_4
XFILLER_85_197 VDD VDD VSS VSS gf180mcu_as_sc_mcu7t3v3__fill_2
XTAP_TAPCELL_ROW_100_1_1745 VDD VSS gf180mcu_as_sc_mcu7t3v3__tap_2
XFILLER_183_1023 VDD VDD VSS VSS gf180mcu_as_sc_mcu7t3v3__fillcap_16
XFILLER_187_1170 VDD VDD VSS VSS gf180mcu_as_sc_mcu7t3v3__fillcap_16
XFILLER_187_1192 VDD VDD VSS VSS gf180mcu_as_sc_mcu7t3v3__fillcap_16
XFILLER_27_765 VDD VDD VSS VSS gf180mcu_as_sc_mcu7t3v3__fillcap_4
XTAP_TAPCELL_ROW_112_3_3057 VDD VSS gf180mcu_as_sc_mcu7t3v3__tap_2
XFILLER_187_718 VDD VDD VSS VSS gf180mcu_as_sc_mcu7t3v3__fillcap_16
XFILLER_199_556 VDD VDD VSS VSS gf180mcu_as_sc_mcu7t3v3__fillcap_4
XFILLER_202_505 VDD VDD VSS VSS gf180mcu_as_sc_mcu7t3v3__fillcap_16
XFILLER_26_275 VDD VDD VSS VSS gf180mcu_as_sc_mcu7t3v3__fill_2
XFILLER_41_212 VDD VDD VSS VSS gf180mcu_as_sc_mcu7t3v3__fillcap_8
XTAP_TAPCELL_ROW_29_1369 VDD VSS gf180mcu_as_sc_mcu7t3v3__tap_2
XTAP_TAPCELL_ROW_29_1358 VDD VSS gf180mcu_as_sc_mcu7t3v3__tap_2
XFILLER_14_448 VDD VDD VSS VSS gf180mcu_as_sc_mcu7t3v3__fillcap_4
XFILLER_199_578 VDD VDD VSS VSS gf180mcu_as_sc_mcu7t3v3__fillcap_16
XFILLER_202_527 VDD VDD VSS VSS gf180mcu_as_sc_mcu7t3v3__fillcap_16
XFILLER_30_919 VDD VDD VSS VSS gf180mcu_as_sc_mcu7t3v3__fillcap_4
XTAP_TAPCELL_ROW_200_2580 VDD VSS gf180mcu_as_sc_mcu7t3v3__tap_2
XTAP_TAPCELL_ROW_175_2023 VDD VSS gf180mcu_as_sc_mcu7t3v3__tap_2
XTAP_TAPCELL_ROW_175_2012 VDD VSS gf180mcu_as_sc_mcu7t3v3__tap_2
XFILLER_23_982 VDD VDD VSS VSS gf180mcu_as_sc_mcu7t3v3__fillcap_8
XPHY_EDGE_ROW_149_1_Right_670 VDD VSS gf180mcu_as_sc_mcu7t3v3__tap_2
XFILLER_185_22 VDD VDD VSS VSS gf180mcu_as_sc_mcu7t3v3__fillcap_16
XFILLER_33_1081 VDD VDD VSS VSS gf180mcu_as_sc_mcu7t3v3__fillcap_4
XPHY_EDGE_ROW_134_1_Left_344 VDD VSS gf180mcu_as_sc_mcu7t3v3__tap_2
XTAP_TAPCELL_ROW_192_2392 VDD VSS gf180mcu_as_sc_mcu7t3v3__tap_2
XFILLER_182_489 VDD VDD VSS VSS gf180mcu_as_sc_mcu7t3v3__fillcap_8
XFILLER_185_88 VDD VDD VSS VSS gf180mcu_as_sc_mcu7t3v3__fillcap_16
XTAP_TAPCELL_ROW_46_1_1582 VDD VSS gf180mcu_as_sc_mcu7t3v3__tap_2
XFILLER_172_1450 VDD VDD VSS VSS gf180mcu_as_sc_mcu7t3v3__fill_1
XFILLER_190_1049 VDD VDD VSS VSS gf180mcu_as_sc_mcu7t3v3__fillcap_16
XFILLER_1_352 VDD VDD VSS VSS gf180mcu_as_sc_mcu7t3v3__fillcap_16
XFILLER_46_1453 VDD VDD VSS VSS gf180mcu_as_sc_mcu7t3v3__fillcap_16
XFILLER_68_109 VDD VDD VSS VSS gf180mcu_as_sc_mcu7t3v3__fill_1
XFILLER_110_217 VDD VDD VSS VSS gf180mcu_as_sc_mcu7t3v3__fillcap_4
XFILLER_133_1412 VDD VDD VSS VSS gf180mcu_as_sc_mcu7t3v3__fillcap_4
XFILLER_172_1461 VDD VDD VSS VSS gf180mcu_as_sc_mcu7t3v3__fill_1
XPHY_EDGE_ROW_125_3_Right_162 VDD VSS gf180mcu_as_sc_mcu7t3v3__tap_2
XTAP_TAPCELL_ROW_56_3_2888 VDD VSS gf180mcu_as_sc_mcu7t3v3__tap_2
XFILLER_133_1445 VDD VDD VSS VSS gf180mcu_as_sc_mcu7t3v3__fillcap_16
XFILLER_204_18 VDD VDD VSS VSS gf180mcu_as_sc_mcu7t3v3__fillcap_16
XFILLER_209_104 VDD VDD VSS VSS gf180mcu_as_sc_mcu7t3v3__fillcap_8
Xmesh_tile_1000 VDD VDD VSS VSS nw_out[7] gf180mcu_as_sc_mcu7t3v3__tiel_4
Xmesh_tile_1011 VDD VDD VSS VSS nw_out[18] gf180mcu_as_sc_mcu7t3v3__tiel_4
XTAP_TAPCELL_ROW_207_2734 VDD VSS gf180mcu_as_sc_mcu7t3v3__tap_2
XTAP_TAPCELL_ROW_207_2723 VDD VSS gf180mcu_as_sc_mcu7t3v3__tap_2
Xmesh_tile_1044 VDD VDD VSS VSS sw_out[17] gf180mcu_as_sc_mcu7t3v3__tiel_4
Xmesh_tile_1033 VDD VDD VSS VSS sw_out[6] gf180mcu_as_sc_mcu7t3v3__tiel_4
Xmesh_tile_1022 VDD VDD VSS VSS nw_out[29] gf180mcu_as_sc_mcu7t3v3__tiel_4
XFILLER_18_732 VDD VDD VSS VSS gf180mcu_as_sc_mcu7t3v3__fill_2
Xmesh_tile_1055 VDD VDD VSS VSS sw_out[28] gf180mcu_as_sc_mcu7t3v3__tiel_4
XFILLER_206_855 VDD VDD VSS VSS gf180mcu_as_sc_mcu7t3v3__fillcap_16
XFILLER_33_702 VDD VDD VSS VSS gf180mcu_as_sc_mcu7t3v3__fillcap_4
XFILLER_91_178 VDD VDD VSS VSS gf180mcu_as_sc_mcu7t3v3__fill_2
XTAP_TAPCELL_ROW_199_2557 VDD VSS gf180mcu_as_sc_mcu7t3v3__tap_2
XTAP_TAPCELL_ROW_199_2546 VDD VSS gf180mcu_as_sc_mcu7t3v3__tap_2
XFILLER_18_798 VDD VDD VSS VSS gf180mcu_as_sc_mcu7t3v3__fillcap_4
XFILLER_206_877 VDD VDD VSS VSS gf180mcu_as_sc_mcu7t3v3__fillcap_16
XFILLER_207_1240 VDD VDD VSS VSS gf180mcu_as_sc_mcu7t3v3__fillcap_16
XFILLER_21_908 VDD VDD VSS VSS gf180mcu_as_sc_mcu7t3v3__fill_2
XFILLER_32_234 VDD VDD VSS VSS gf180mcu_as_sc_mcu7t3v3__fill_1
XFILLER_53_1413 VDD VDD VSS VSS gf180mcu_as_sc_mcu7t3v3__fill_2
XFILLER_105_1503 VDD VDD VSS VSS gf180mcu_as_sc_mcu7t3v3__fill_2
XFILLER_207_1262 VDD VDD VSS VSS gf180mcu_as_sc_mcu7t3v3__fillcap_16
X_3750_ VDD VDD VSS VSS _4127_/A _3758_/B _3772_/C _4126_/A _3751_/D gf180mcu_as_sc_mcu7t3v3__ao22_2
XFILLER_199_1030 VDD VDD VSS VSS gf180mcu_as_sc_mcu7t3v3__fillcap_16
XPHY_EDGE_ROW_66_1_Left_276 VDD VSS gf180mcu_as_sc_mcu7t3v3__tap_2
X_2701_ VDD VDD VSS VSS _2701_/D _2701_/A _2701_/B _2701_/C _2702_/A gf180mcu_as_sc_mcu7t3v3__ao31_2
XFILLER_105_1558 VDD VDD VSS VSS gf180mcu_as_sc_mcu7t3v3__fillcap_8
XFILLER_16_1290 VDD VDD VSS VSS gf180mcu_as_sc_mcu7t3v3__fillcap_4
XFILLER_199_1052 VDD VDD VSS VSS gf180mcu_as_sc_mcu7t3v3__fillcap_16
X_3681_ VDD VDD VSS VSS _3681_/D _4056_/D _3728_/B _3728_/C _3682_/C gf180mcu_as_sc_mcu7t3v3__ao31_2
XFILLER_12_1154 VDD VDD VSS VSS gf180mcu_as_sc_mcu7t3v3__fill_1
XFILLER_145_136 VDD VDD VSS VSS gf180mcu_as_sc_mcu7t3v3__fillcap_4
XFILLER_145_158 VDD VDD VSS VSS gf180mcu_as_sc_mcu7t3v3__fillcap_16
X_2632_ VDD VDD VSS VSS _2632_/B _5230_/Q _4646_/C gf180mcu_as_sc_mcu7t3v3__and2_2
X_2563_ VDD VDD VSS VSS _3872_/A _2563_/A _2565_/B gf180mcu_as_sc_mcu7t3v3__or2_2
XFILLER_99_212 VDD VDD VSS VSS gf180mcu_as_sc_mcu7t3v3__fillcap_8
X_5282_ VDD VDD VSS VSS _5285_/CLK _5282_/D _5282_/Q gf180mcu_as_sc_mcu7t3v3__dfxtp_2
X_4302_ VDD VDD VSS VSS _4326_/S _5132_/Q _5131_/Q _5131_/D gf180mcu_as_sc_mcu7t3v3__mux2_2
XFILLER_64_1520 VDD VDD VSS VSS gf180mcu_as_sc_mcu7t3v3__fill_1
X_4233_ VDD VDD VSS VSS _4253_/S _4233_/B _5069_/Q _5069_/D gf180mcu_as_sc_mcu7t3v3__mux2_2
X_2494_ VDD VDD VSS VSS _2495_/A _4954_/Q _5189_/Q _2794_/A gf180mcu_as_sc_mcu7t3v3__maj3_2
XFILLER_25_1504 VDD VDD VSS VSS gf180mcu_as_sc_mcu7t3v3__fillcap_8
XFILLER_67_142 VDD VDD VSS VSS gf180mcu_as_sc_mcu7t3v3__fillcap_4
X_4164_ VDD VDD VSS VSS _4164_/S _4164_/B _4164_/A _4165_/B gf180mcu_as_sc_mcu7t3v3__mux2_2
XFILLER_28_518 VDD VDD VSS VSS gf180mcu_as_sc_mcu7t3v3__fillcap_4
X_4095_ VDD VDD VSS VSS _4095_/A _4129_/B _4129_/C _4935_/Q _4097_/C gf180mcu_as_sc_mcu7t3v3__ao22_2
X_3115_ VDD VDD VSS VSS _3691_/D _3115_/A _3115_/B _3115_/C _3116_/C gf180mcu_as_sc_mcu7t3v3__ao31_2
XTAP_TAPCELL_ROW_72_1_1661 VDD VSS gf180mcu_as_sc_mcu7t3v3__tap_2
XFILLER_82_123 VDD VDD VSS VSS gf180mcu_as_sc_mcu7t3v3__fillcap_4
X_3046_ VDD VDD VSS VSS _3078_/B _4926_/Q _3047_/D gf180mcu_as_sc_mcu7t3v3__or2_2
XFILLER_97_1373 VDD VDD VSS VSS gf180mcu_as_sc_mcu7t3v3__fill_2
XFILLER_149_1463 VDD VDD VSS VSS gf180mcu_as_sc_mcu7t3v3__fill_1
XFILLER_23_201 VDD VDD VSS VSS gf180mcu_as_sc_mcu7t3v3__fillcap_8
XFILLER_23_212 VDD VDD VSS VSS gf180mcu_as_sc_mcu7t3v3__fillcap_8
XFILLER_24_724 VDD VDD VSS VSS gf180mcu_as_sc_mcu7t3v3__fillcap_8
XTAP_TAPCELL_ROW_82_3_2967 VDD VSS gf180mcu_as_sc_mcu7t3v3__tap_2
XFILLER_149_1485 VDD VDD VSS VSS gf180mcu_as_sc_mcu7t3v3__fill_1
XFILLER_196_559 VDD VDD VSS VSS gf180mcu_as_sc_mcu7t3v3__fillcap_16
XPHY_EDGE_ROW_156_3_Left_541 VDD VSS gf180mcu_as_sc_mcu7t3v3__tap_2
X_4997_ VDD VDD VSS VSS _5085_/CLK _4997_/D _4997_/Q gf180mcu_as_sc_mcu7t3v3__dfxtp_2
Xclkbuf_leaf_10_clk_regs VDD VDD VSS VSS clkbuf_leaf_7_clk_regs/A _5197_/CLK gf180mcu_as_sc_mcu7t3v3__clkbuff_12
XFILLER_183_209 VDD VDD VSS VSS gf180mcu_as_sc_mcu7t3v3__fill_1
XFILLER_23_59 VDD VDD VSS VSS gf180mcu_as_sc_mcu7t3v3__fillcap_8
XFILLER_71_1568 VDD VDD VSS VSS gf180mcu_as_sc_mcu7t3v3__fill_1
X_3948_ VDD VDD VSS VSS _3948_/A _4032_/B _4043_/B _3953_/C _3948_/D gf180mcu_as_sc_mcu7t3v3__aoi211_2
XTAP_TAPCELL_ROW_24_1255 VDD VSS gf180mcu_as_sc_mcu7t3v3__tap_2
XFILLER_136_103 VDD VDD VSS VSS gf180mcu_as_sc_mcu7t3v3__fill_2
XFILLER_178_1103 VDD VDD VSS VSS gf180mcu_as_sc_mcu7t3v3__fillcap_16
XFILLER_20_963 VDD VDD VSS VSS gf180mcu_as_sc_mcu7t3v3__fillcap_16
X_3879_ VDD VDD VSS VSS _3893_/B _5169_/Q _4919_/D gf180mcu_as_sc_mcu7t3v3__and2_2
XTAP_TAPCELL_ROW_24_1266 VDD VSS gf180mcu_as_sc_mcu7t3v3__tap_2
XFILLER_191_275 VDD VDD VSS VSS gf180mcu_as_sc_mcu7t3v3__fillcap_4
XFILLER_195_1450 VDD VDD VSS VSS gf180mcu_as_sc_mcu7t3v3__fillcap_16
XFILLER_195_1472 VDD VDD VSS VSS gf180mcu_as_sc_mcu7t3v3__fillcap_16
XFILLER_117_1418 VDD VDD VSS VSS gf180mcu_as_sc_mcu7t3v3__fillcap_16
XFILLER_8_1222 VDD VDD VSS VSS gf180mcu_as_sc_mcu7t3v3__fill_2
XTAP_TAPCELL_ROW_163_3_3209 VDD VSS gf180mcu_as_sc_mcu7t3v3__tap_2
XFILLER_48_78 VDD VDD VSS VSS gf180mcu_as_sc_mcu7t3v3__fillcap_4
Xfanout486 VDD VDD VSS VSS _3913_/Y _4150_/B gf180mcu_as_sc_mcu7t3v3__buff_12
XFILLER_206_107 VDD VDD VSS VSS gf180mcu_as_sc_mcu7t3v3__fillcap_16
XFILLER_15_702 VDD VDD VSS VSS gf180mcu_as_sc_mcu7t3v3__fillcap_8
XFILLER_27_562 VDD VDD VSS VSS gf180mcu_as_sc_mcu7t3v3__fillcap_16
XTAP_TAPCELL_ROW_131_1_1839 VDD VSS gf180mcu_as_sc_mcu7t3v3__tap_2
XTAP_TAPCELL_ROW_202_2620 VDD VSS gf180mcu_as_sc_mcu7t3v3__tap_2
XFILLER_14_201 VDD VDD VSS VSS gf180mcu_as_sc_mcu7t3v3__fillcap_4
XFILLER_161_2 VDD VDD VSS VSS gf180mcu_as_sc_mcu7t3v3__fillcap_16
XFILLER_73_178 VDD VDD VSS VSS gf180mcu_as_sc_mcu7t3v3__fill_1
XFILLER_76_1446 VDD VDD VSS VSS gf180mcu_as_sc_mcu7t3v3__fillcap_4
XFILLER_199_386 VDD VDD VSS VSS gf180mcu_as_sc_mcu7t3v3__fill_1
XFILLER_203_836 VDD VDD VSS VSS gf180mcu_as_sc_mcu7t3v3__fillcap_4
XFILLER_64_99 VDD VDD VSS VSS gf180mcu_as_sc_mcu7t3v3__fillcap_4
XPHY_EDGE_ROW_88_3_Left_473 VDD VSS gf180mcu_as_sc_mcu7t3v3__tap_2
XFILLER_187_559 VDD VDD VSS VSS gf180mcu_as_sc_mcu7t3v3__fill_1
XFILLER_203_858 VDD VDD VSS VSS gf180mcu_as_sc_mcu7t3v3__fillcap_16
XFILLER_80_32 VDD VDD VSS VSS gf180mcu_as_sc_mcu7t3v3__fill_2
XTAP_TAPCELL_ROW_194_2443 VDD VSS gf180mcu_as_sc_mcu7t3v3__tap_2
XTAP_TAPCELL_ROW_194_2432 VDD VSS gf180mcu_as_sc_mcu7t3v3__tap_2
XFILLER_183_710 VDD VDD VSS VSS gf180mcu_as_sc_mcu7t3v3__fillcap_4
XFILLER_31_1018 VDD VDD VSS VSS gf180mcu_as_sc_mcu7t3v3__fillcap_4
XFILLER_7_912 VDD VDD VSS VSS gf180mcu_as_sc_mcu7t3v3__fillcap_16
Xwire821 VDD VDD VSS VSS _2438_/Y _4067_/A gf180mcu_as_sc_mcu7t3v3__clkbuff_12
Xwire832 VDD VDD VSS VSS wire832/A _4021_/A gf180mcu_as_sc_mcu7t3v3__clkbuff_12
Xwire843 VDD VDD VSS VSS wire843/A _4153_/A gf180mcu_as_sc_mcu7t3v3__clkbuff_12
XFILLER_10_473 VDD VDD VSS VSS gf180mcu_as_sc_mcu7t3v3__fillcap_16
XFILLER_183_765 VDD VDD VSS VSS gf180mcu_as_sc_mcu7t3v3__fillcap_4
Xwire854 VDD VDD VSS VSS wire854/A _4063_/A gf180mcu_as_sc_mcu7t3v3__clkbuff_12
Xwire865 VDD VDD VSS VSS wire865/A _3787_/A gf180mcu_as_sc_mcu7t3v3__clkbuff_12
Xwire876 VDD VDD VSS VSS wire876/A _3943_/A gf180mcu_as_sc_mcu7t3v3__clkbuff_12
XFILLER_142_139 VDD VDD VSS VSS gf180mcu_as_sc_mcu7t3v3__fillcap_4
XFILLER_48_1537 VDD VDD VSS VSS gf180mcu_as_sc_mcu7t3v3__fillcap_4
XTAP_TAPCELL_ROW_77_1_1676 VDD VSS gf180mcu_as_sc_mcu7t3v3__tap_2
XFILLER_150_172 VDD VDD VSS VSS gf180mcu_as_sc_mcu7t3v3__fill_2
XPHY_EDGE_ROW_126_3_Right_163 VDD VSS gf180mcu_as_sc_mcu7t3v3__tap_2
XFILLER_49_142 VDD VDD VSS VSS gf180mcu_as_sc_mcu7t3v3__fillcap_16
XPHY_EDGE_ROW_206_Right_69 VDD VSS gf180mcu_as_sc_mcu7t3v3__tap_2
XFILLER_0_1528 VDD VDD VSS VSS gf180mcu_as_sc_mcu7t3v3__fill_2
XFILLER_20_1434 VDD VDD VSS VSS gf180mcu_as_sc_mcu7t3v3__fill_1
XFILLER_33_521 VDD VDD VSS VSS gf180mcu_as_sc_mcu7t3v3__fillcap_16
X_4920_ VDD VDD VSS VSS clkload3/A _4920_/D _4920_/Q gf180mcu_as_sc_mcu7t3v3__dfxtp_2
XFILLER_181_1538 VDD VDD VSS VSS gf180mcu_as_sc_mcu7t3v3__fill_2
X_4851_ VDD VDD VSS VSS _5241_/CLK _4851_/D _4851_/Q gf180mcu_as_sc_mcu7t3v3__dfxtp_2
XFILLER_178_559 VDD VDD VSS VSS gf180mcu_as_sc_mcu7t3v3__fill_2
XFILLER_57_1390 VDD VDD VSS VSS gf180mcu_as_sc_mcu7t3v3__fill_1
X_3802_ VDD VDD VSS VSS _3802_/A _3802_/B _3802_/C _3802_/D _3804_/A gf180mcu_as_sc_mcu7t3v3__ao211_2
X_4782_ VDD VDD VSS VSS _5142_/CLK _4782_/D _4782_/Q gf180mcu_as_sc_mcu7t3v3__dfxtp_2
XFILLER_14_1227 VDD VDD VSS VSS gf180mcu_as_sc_mcu7t3v3__fillcap_4
X_3733_ VDD VDD VSS VSS _3734_/C _4109_/D _3751_/B _3733_/C gf180mcu_as_sc_mcu7t3v3__ao21_2
XFILLER_173_220 VDD VDD VSS VSS gf180mcu_as_sc_mcu7t3v3__fill_2
XFILLER_9_271 VDD VDD VSS VSS gf180mcu_as_sc_mcu7t3v3__fillcap_8
XFILLER_9_282 VDD VDD VSS VSS gf180mcu_as_sc_mcu7t3v3__fillcap_16
XTAP_TAPCELL_ROW_12_991 VDD VSS gf180mcu_as_sc_mcu7t3v3__tap_2
X_3664_ VDD VDD VSS VSS _3668_/B _3664_/C _3726_/B _4038_/A gf180mcu_as_sc_mcu7t3v3__aoi21_2
XFILLER_179_1467 VDD VDD VSS VSS gf180mcu_as_sc_mcu7t3v3__fill_2
X_2615_ VDD VDD VSS VSS _4628_/S _2632_/B _5268_/Q gf180mcu_as_sc_mcu7t3v3__nor2_2
X_3595_ VDD VDD VSS VSS _4919_/Q _3648_/B _3648_/C _3967_/A _3597_/C gf180mcu_as_sc_mcu7t3v3__ao22_2
X_2546_ VDD VDD VSS VSS _2547_/B _2546_/A _2546_/B _2745_/B gf180mcu_as_sc_mcu7t3v3__maj3_2
XFILLER_125_39 VDD VDD VSS VSS gf180mcu_as_sc_mcu7t3v3__fill_2
XFILLER_9_1531 VDD VDD VSS VSS gf180mcu_as_sc_mcu7t3v3__fillcap_8
XFILLER_9_1542 VDD VDD VSS VSS gf180mcu_as_sc_mcu7t3v3__fill_2
X_5265_ VDD VDD VSS VSS _5280_/CLK _5265_/D _5265_/Q gf180mcu_as_sc_mcu7t3v3__dfxtp_2
X_2477_ VDD VDD VSS VSS _2477_/B _3907_/A _4950_/D gf180mcu_as_sc_mcu7t3v3__and2_2
X_5196_ VDD VDD VSS VSS _5197_/CLK _5196_/D _5196_/Q gf180mcu_as_sc_mcu7t3v3__dfxtp_2
X_4216_ VDD VDD VSS VSS _4245_/B _4228_/B _4228_/C _5052_/Q _5052_/D gf180mcu_as_sc_mcu7t3v3__ao22_2
XFILLER_116_1495 VDD VDD VSS VSS gf180mcu_as_sc_mcu7t3v3__fillcap_16
XFILLER_205_50 VDD VDD VSS VSS gf180mcu_as_sc_mcu7t3v3__fillcap_16
XFILLER_205_72 VDD VDD VSS VSS gf180mcu_as_sc_mcu7t3v3__fillcap_16
X_4147_ VDD VDD VSS VSS _4147_/A _4163_/B _4147_/C _4147_/D _4148_/B gf180mcu_as_sc_mcu7t3v3__ao211_2
XFILLER_112_1348 VDD VDD VSS VSS gf180mcu_as_sc_mcu7t3v3__fillcap_16
XFILLER_18_37 VDD VDD VSS VSS gf180mcu_as_sc_mcu7t3v3__fillcap_16
XFILLER_3_1130 VDD VDD VSS VSS gf180mcu_as_sc_mcu7t3v3__fillcap_4
XFILLER_99_1435 VDD VDD VSS VSS gf180mcu_as_sc_mcu7t3v3__fillcap_16
XFILLER_141_38 VDD VDD VSS VSS gf180mcu_as_sc_mcu7t3v3__fill_2
X_4078_ VDD VDD VSS VSS _4078_/A _4119_/B _4115_/B _4078_/D _4082_/A gf180mcu_as_sc_mcu7t3v3__ao211_2
XFILLER_24_521 VDD VDD VSS VSS gf180mcu_as_sc_mcu7t3v3__fillcap_4
XFILLER_3_1174 VDD VDD VSS VSS gf180mcu_as_sc_mcu7t3v3__fill_2
XFILLER_70_104 VDD VDD VSS VSS gf180mcu_as_sc_mcu7t3v3__fill_1
X_3029_ VDD VDD VSS VSS _4008_/A _3125_/B _3029_/C _3029_/D _3030_/C gf180mcu_as_sc_mcu7t3v3__ao22_2
XFILLER_184_1151 VDD VDD VSS VSS gf180mcu_as_sc_mcu7t3v3__fillcap_4
XFILLER_184_1173 VDD VDD VSS VSS gf180mcu_as_sc_mcu7t3v3__fillcap_16
XFILLER_24_543 VDD VDD VSS VSS gf180mcu_as_sc_mcu7t3v3__fillcap_16
XTAP_TAPCELL_ROW_26_1306 VDD VSS gf180mcu_as_sc_mcu7t3v3__tap_2
XFILLER_196_312 VDD VDD VSS VSS gf180mcu_as_sc_mcu7t3v3__fill_2
XFILLER_36_1430 VDD VDD VSS VSS gf180mcu_as_sc_mcu7t3v3__fillcap_16
Xsram2048.u_bank0_914 VDD VDD VSS VSS sram2048.u_bank0/WEN[4] gf180mcu_as_sc_mcu7t3v3__tiel_4
XFILLER_184_518 VDD VDD VSS VSS gf180mcu_as_sc_mcu7t3v3__fillcap_4
XFILLER_71_1354 VDD VDD VSS VSS gf180mcu_as_sc_mcu7t3v3__fill_1
XTAP_TAPCELL_ROW_107_3_3041 VDD VSS gf180mcu_as_sc_mcu7t3v3__tap_2
Xclkload2 VDD VDD VSS VSS clkload2/Y clkload2/A gf180mcu_as_sc_mcu7t3v3__inv_2
XFILLER_109_136 VDD VDD VSS VSS gf180mcu_as_sc_mcu7t3v3__fillcap_4
XFILLER_123_1488 VDD VDD VSS VSS gf180mcu_as_sc_mcu7t3v3__fillcap_16
XFILLER_164_220 VDD VDD VSS VSS gf180mcu_as_sc_mcu7t3v3__fill_2
XFILLER_50_57 VDD VDD VSS VSS gf180mcu_as_sc_mcu7t3v3__fillcap_16
XFILLER_191_1100 VDD VDD VSS VSS gf180mcu_as_sc_mcu7t3v3__fillcap_16
XFILLER_191_1122 VDD VDD VSS VSS gf180mcu_as_sc_mcu7t3v3__fillcap_16
XFILLER_182_34 VDD VDD VSS VSS gf180mcu_as_sc_mcu7t3v3__fill_1
XFILLER_43_1434 VDD VDD VSS VSS gf180mcu_as_sc_mcu7t3v3__fillcap_4
XTAP_TAPCELL_ROW_187_2291 VDD VSS gf180mcu_as_sc_mcu7t3v3__tap_2
XTAP_TAPCELL_ROW_187_2280 VDD VSS gf180mcu_as_sc_mcu7t3v3__tap_2
XFILLER_115_72 VDD VDD VSS VSS gf180mcu_as_sc_mcu7t3v3__fillcap_16
XFILLER_208_906 VDD VDD VSS VSS gf180mcu_as_sc_mcu7t3v3__fillcap_8
XFILLER_46_101 VDD VDD VSS VSS gf180mcu_as_sc_mcu7t3v3__fillcap_4
XFILLER_46_123 VDD VDD VSS VSS gf180mcu_as_sc_mcu7t3v3__fillcap_16
XTAP_TAPCELL_ROW_183_2199 VDD VSS gf180mcu_as_sc_mcu7t3v3__tap_2
XTAP_TAPCELL_ROW_183_2188 VDD VSS gf180mcu_as_sc_mcu7t3v3__tap_2
XFILLER_189_1084 VDD VDD VSS VSS gf180mcu_as_sc_mcu7t3v3__fillcap_16
XFILLER_207_438 VDD VDD VSS VSS gf180mcu_as_sc_mcu7t3v3__fillcap_16
XFILLER_75_65 VDD VDD VSS VSS gf180mcu_as_sc_mcu7t3v3__fillcap_4
XTAP_TAPCELL_ROW_150_1_1894 VDD VSS gf180mcu_as_sc_mcu7t3v3__tap_2
XFILLER_28_871 VDD VDD VSS VSS gf180mcu_as_sc_mcu7t3v3__fillcap_4
XFILLER_28_893 VDD VDD VSS VSS gf180mcu_as_sc_mcu7t3v3__fillcap_8
XFILLER_15_532 VDD VDD VSS VSS gf180mcu_as_sc_mcu7t3v3__fill_2
XFILLER_91_53 VDD VDD VSS VSS gf180mcu_as_sc_mcu7t3v3__fillcap_4
XFILLER_128_1399 VDD VDD VSS VSS gf180mcu_as_sc_mcu7t3v3__fillcap_16
XFILLER_204_1221 VDD VDD VSS VSS gf180mcu_as_sc_mcu7t3v3__fillcap_4
XFILLER_30_524 VDD VDD VSS VSS gf180mcu_as_sc_mcu7t3v3__fill_1
XFILLER_204_1243 VDD VDD VSS VSS gf180mcu_as_sc_mcu7t3v3__fillcap_16
XFILLER_102_1506 VDD VDD VSS VSS gf180mcu_as_sc_mcu7t3v3__fillcap_8
XFILLER_141_1555 VDD VDD VSS VSS gf180mcu_as_sc_mcu7t3v3__fill_1
XFILLER_141_1566 VDD VDD VSS VSS gf180mcu_as_sc_mcu7t3v3__fill_2
XFILLER_155_220 VDD VDD VSS VSS gf180mcu_as_sc_mcu7t3v3__fill_2
XFILLER_196_1011 VDD VDD VSS VSS gf180mcu_as_sc_mcu7t3v3__fillcap_4
XFILLER_50_1449 VDD VDD VSS VSS gf180mcu_as_sc_mcu7t3v3__fill_2
XFILLER_102_1539 VDD VDD VSS VSS gf180mcu_as_sc_mcu7t3v3__fill_2
XFILLER_183_562 VDD VDD VSS VSS gf180mcu_as_sc_mcu7t3v3__fillcap_16
XFILLER_196_1033 VDD VDD VSS VSS gf180mcu_as_sc_mcu7t3v3__fillcap_16
XFILLER_183_595 VDD VDD VSS VSS gf180mcu_as_sc_mcu7t3v3__fillcap_4
X_2400_ VDD VDD VSS VSS _2792_/A _4637_/A gf180mcu_as_sc_mcu7t3v3__inv_2
X_3380_ VDD VDD VSS VSS _4030_/A _3451_/B _3380_/C _3380_/D _3381_/A gf180mcu_as_sc_mcu7t3v3__ao211_2
XFILLER_48_1356 VDD VDD VSS VSS gf180mcu_as_sc_mcu7t3v3__fill_2
XFILLER_48_1378 VDD VDD VSS VSS gf180mcu_as_sc_mcu7t3v3__fill_2
XTAP_TAPCELL_ROW_133_3_3120 VDD VSS gf180mcu_as_sc_mcu7t3v3__tap_2
XFILLER_123_183 VDD VDD VSS VSS gf180mcu_as_sc_mcu7t3v3__fillcap_8
XFILLER_135_1348 VDD VDD VSS VSS gf180mcu_as_sc_mcu7t3v3__fillcap_8
X_5050_ VDD VDD VSS VSS clkload2/A _5050_/D _5050_/Q gf180mcu_as_sc_mcu7t3v3__dfxtp_2
XFILLER_22_1507 VDD VDD VSS VSS gf180mcu_as_sc_mcu7t3v3__fillcap_4
X_4001_ VDD VDD VSS VSS _4001_/A _4122_/B _4001_/C _4001_/D _4002_/B gf180mcu_as_sc_mcu7t3v3__ao211_2
XPHY_EDGE_ROW_127_3_Right_164 VDD VSS gf180mcu_as_sc_mcu7t3v3__tap_2
XFILLER_20_1231 VDD VDD VSS VSS gf180mcu_as_sc_mcu7t3v3__fill_1
XFILLER_0_1325 VDD VDD VSS VSS gf180mcu_as_sc_mcu7t3v3__fill_1
XFILLER_52_104 VDD VDD VSS VSS gf180mcu_as_sc_mcu7t3v3__fill_1
XFILLER_20_1297 VDD VDD VSS VSS gf180mcu_as_sc_mcu7t3v3__fillcap_16
X_4903_ VDD VDD VSS VSS _4904_/CLK _4903_/D _4903_/Q gf180mcu_as_sc_mcu7t3v3__dfxtp_2
XFILLER_178_334 VDD VDD VSS VSS gf180mcu_as_sc_mcu7t3v3__fillcap_4
XFILLER_34_874 VDD VDD VSS VSS gf180mcu_as_sc_mcu7t3v3__fill_1
XFILLER_59_1485 VDD VDD VSS VSS gf180mcu_as_sc_mcu7t3v3__fill_1
XFILLER_94_1376 VDD VDD VSS VSS gf180mcu_as_sc_mcu7t3v3__fillcap_4
XFILLER_209_1187 VDD VDD VSS VSS gf180mcu_as_sc_mcu7t3v3__fill_2
XFILLER_21_524 VDD VDD VSS VSS gf180mcu_as_sc_mcu7t3v3__fillcap_4
XFILLER_33_384 VDD VDD VSS VSS gf180mcu_as_sc_mcu7t3v3__fill_2
XFILLER_60_181 VDD VDD VSS VSS gf180mcu_as_sc_mcu7t3v3__fill_1
X_4834_ VDD VDD VSS VSS _5073_/CLK _4834_/D _4834_/Q gf180mcu_as_sc_mcu7t3v3__dfxtp_2
XFILLER_14_1002 VDD VDD VSS VSS gf180mcu_as_sc_mcu7t3v3__fillcap_8
XFILLER_187_890 VDD VDD VSS VSS gf180mcu_as_sc_mcu7t3v3__fillcap_16
X_4765_ VDD VDD VSS VSS clkload6/A _4765_/D _4765_/Q gf180mcu_as_sc_mcu7t3v3__dfxtp_2
XTAP_TAPCELL_ROW_21_1203 VDD VSS gf180mcu_as_sc_mcu7t3v3__tap_2
X_3716_ VDD VDD VSS VSS _4096_/A _3749_/B _3740_/C _4095_/A _3717_/C gf180mcu_as_sc_mcu7t3v3__ao22_2
XTAP_TAPCELL_ROW_77_3_2951 VDD VSS gf180mcu_as_sc_mcu7t3v3__tap_2
X_4696_ VDD VDD VSS VSS _4725_/B _5481_/A _5254_/Q _4697_/A gf180mcu_as_sc_mcu7t3v3__mux2_2
XFILLER_161_201 VDD VDD VSS VSS gf180mcu_as_sc_mcu7t3v3__fillcap_8
XFILLER_161_212 VDD VDD VSS VSS gf180mcu_as_sc_mcu7t3v3__fillcap_8
XFILLER_20_27 VDD VDD VSS VSS gf180mcu_as_sc_mcu7t3v3__fillcap_8
X_3647_ VDD VDD VSS VSS _4849_/D _3647_/C _3731_/B _3647_/A gf180mcu_as_sc_mcu7t3v3__aoi21_2
XFILLER_136_27 VDD VDD VSS VSS gf180mcu_as_sc_mcu7t3v3__fillcap_8
XFILLER_192_1431 VDD VDD VSS VSS gf180mcu_as_sc_mcu7t3v3__fillcap_4
X_3578_ VDD VDD VSS VSS _3939_/A _3652_/B _3578_/C _3608_/B _3579_/C gf180mcu_as_sc_mcu7t3v3__ao211_2
XFILLER_153_1404 VDD VDD VSS VSS gf180mcu_as_sc_mcu7t3v3__fillcap_8
XFILLER_27_1418 VDD VDD VSS VSS gf180mcu_as_sc_mcu7t3v3__fill_1
X_2529_ VDD VDD VSS VSS _2534_/A _5268_/Q _2795_/A _2530_/B gf180mcu_as_sc_mcu7t3v3__nor3_2
XTAP_TAPCELL_ROW_19_1154 VDD VSS gf180mcu_as_sc_mcu7t3v3__tap_2
XTAP_TAPCELL_ROW_19_1143 VDD VSS gf180mcu_as_sc_mcu7t3v3__tap_2
XFILLER_118_1568 VDD VDD VSS VSS gf180mcu_as_sc_mcu7t3v3__fill_1
Xinput307 VDD VDD VSS VSS west_in[31] _3511_/A gf180mcu_as_sc_mcu7t3v3__buff_12
XTAP_TAPCELL_ROW_57_3_2893 VDD VSS gf180mcu_as_sc_mcu7t3v3__tap_2
XFILLER_152_37 VDD VDD VSS VSS gf180mcu_as_sc_mcu7t3v3__fillcap_4
X_5248_ VDD VDD VSS VSS _5260_/CLK _5248_/D _5248_/Q gf180mcu_as_sc_mcu7t3v3__dfxtp_2
XFILLER_29_624 VDD VDD VSS VSS gf180mcu_as_sc_mcu7t3v3__fillcap_4
XFILLER_5_1236 VDD VDD VSS VSS gf180mcu_as_sc_mcu7t3v3__fill_1
X_5179_ VDD VDD VSS VSS clkload9/A _5179_/D _5179_/Q gf180mcu_as_sc_mcu7t3v3__dfxtp_2
XPHY_EDGE_ROW_143_1_Left_353 VDD VSS gf180mcu_as_sc_mcu7t3v3__tap_2
XFILLER_77_1530 VDD VDD VSS VSS gf180mcu_as_sc_mcu7t3v3__fill_1
XFILLER_204_419 VDD VDD VSS VSS gf180mcu_as_sc_mcu7t3v3__fillcap_16
XFILLER_125_1506 VDD VDD VSS VSS gf180mcu_as_sc_mcu7t3v3__fill_1
XFILLER_197_610 VDD VDD VSS VSS gf180mcu_as_sc_mcu7t3v3__fillcap_16
XFILLER_197_632 VDD VDD VSS VSS gf180mcu_as_sc_mcu7t3v3__fillcap_16
XFILLER_73_1438 VDD VDD VSS VSS gf180mcu_as_sc_mcu7t3v3__fillcap_4
XFILLER_12_535 VDD VDD VSS VSS gf180mcu_as_sc_mcu7t3v3__fillcap_16
XFILLER_24_395 VDD VDD VSS VSS gf180mcu_as_sc_mcu7t3v3__fillcap_4
XFILLER_129_209 VDD VDD VSS VSS gf180mcu_as_sc_mcu7t3v3__fill_1
XFILLER_61_67 VDD VDD VSS VSS gf180mcu_as_sc_mcu7t3v3__fill_2
XTAP_TAPCELL_ROW_126_1_1823 VDD VSS gf180mcu_as_sc_mcu7t3v3__tap_2
XFILLER_124_2 VDD VDD VSS VSS gf180mcu_as_sc_mcu7t3v3__fillcap_4
XFILLER_137_220 VDD VDD VSS VSS gf180mcu_as_sc_mcu7t3v3__fill_2
XFILLER_184_359 VDD VDD VSS VSS gf180mcu_as_sc_mcu7t3v3__fillcap_16
XTAP_TAPCELL_ROW_138_3_3135 VDD VSS gf180mcu_as_sc_mcu7t3v3__tap_2
XFILLER_32_1157 VDD VDD VSS VSS gf180mcu_as_sc_mcu7t3v3__fillcap_16
XFILLER_6_18 VDD VDD VSS VSS gf180mcu_as_sc_mcu7t3v3__fillcap_16
XPHY_EDGE_ROW_119_3_Left_504 VDD VSS gf180mcu_as_sc_mcu7t3v3__tap_2
XFILLER_10_1433 VDD VDD VSS VSS gf180mcu_as_sc_mcu7t3v3__fill_2
XFILLER_180_510 VDD VDD VSS VSS gf180mcu_as_sc_mcu7t3v3__fill_1
XFILLER_197_1364 VDD VDD VSS VSS gf180mcu_as_sc_mcu7t3v3__fillcap_16
XTAP_TAPCELL_ROW_189_2320 VDD VSS gf180mcu_as_sc_mcu7t3v3__tap_2
XFILLER_158_1348 VDD VDD VSS VSS gf180mcu_as_sc_mcu7t3v3__fillcap_16
XFILLER_180_565 VDD VDD VSS VSS gf180mcu_as_sc_mcu7t3v3__fill_1
XFILLER_193_22 VDD VDD VSS VSS gf180mcu_as_sc_mcu7t3v3__fillcap_16
XFILLER_84_1523 VDD VDD VSS VSS gf180mcu_as_sc_mcu7t3v3__fillcap_16
XTAP_TAPCELL_ROW_189_2331 VDD VSS gf180mcu_as_sc_mcu7t3v3__tap_2
XFILLER_10_1488 VDD VDD VSS VSS gf180mcu_as_sc_mcu7t3v3__fill_1
XFILLER_193_88 VDD VDD VSS VSS gf180mcu_as_sc_mcu7t3v3__fillcap_16
XFILLER_86_31 VDD VDD VSS VSS gf180mcu_as_sc_mcu7t3v3__fillcap_4
XTAP_TAPCELL_ROW_210_2796 VDD VSS gf180mcu_as_sc_mcu7t3v3__tap_2
XTAP_TAPCELL_ROW_210_2785 VDD VSS gf180mcu_as_sc_mcu7t3v3__tap_2
XTAP_TAPCELL_ROW_185_2239 VDD VSS gf180mcu_as_sc_mcu7t3v3__tap_2
XFILLER_0_951 VDD VDD VSS VSS gf180mcu_as_sc_mcu7t3v3__fill_1
XFILLER_0_973 VDD VDD VSS VSS gf180mcu_as_sc_mcu7t3v3__fillcap_4
XFILLER_86_97 VDD VDD VSS VSS gf180mcu_as_sc_mcu7t3v3__fillcap_8
XPHY_EDGE_ROW_75_1_Left_285 VDD VSS gf180mcu_as_sc_mcu7t3v3__tap_2
XFILLER_19_80 VDD VDD VSS VSS gf180mcu_as_sc_mcu7t3v3__fillcap_4
XFILLER_208_769 VDD VDD VSS VSS gf180mcu_as_sc_mcu7t3v3__fillcap_16
XFILLER_35_627 VDD VDD VSS VSS gf180mcu_as_sc_mcu7t3v3__fill_2
XFILLER_169_1488 VDD VDD VSS VSS gf180mcu_as_sc_mcu7t3v3__fillcap_16
XFILLER_207_279 VDD VDD VSS VSS gf180mcu_as_sc_mcu7t3v3__fill_1
XFILLER_16_874 VDD VDD VSS VSS gf180mcu_as_sc_mcu7t3v3__fill_1
XFILLER_187_120 VDD VDD VSS VSS gf180mcu_as_sc_mcu7t3v3__fillcap_16
XFILLER_187_142 VDD VDD VSS VSS gf180mcu_as_sc_mcu7t3v3__fillcap_16
X_2880_ VDD VDD VSS VSS _2882_/C _4329_/A _2880_/B _4643_/B gf180mcu_as_sc_mcu7t3v3__ao21_2
XFILLER_15_1322 VDD VDD VSS VSS gf180mcu_as_sc_mcu7t3v3__fillcap_8
XFILLER_31_877 VDD VDD VSS VSS gf180mcu_as_sc_mcu7t3v3__fillcap_4
XFILLER_106_1450 VDD VDD VSS VSS gf180mcu_as_sc_mcu7t3v3__fill_1
XFILLER_30_387 VDD VDD VSS VSS gf180mcu_as_sc_mcu7t3v3__fill_1
XFILLER_106_1494 VDD VDD VSS VSS gf180mcu_as_sc_mcu7t3v3__fillcap_16
XFILLER_11_1208 VDD VDD VSS VSS gf180mcu_as_sc_mcu7t3v3__fillcap_16
XFILLER_190_307 VDD VDD VSS VSS gf180mcu_as_sc_mcu7t3v3__fillcap_8
XFILLER_89_1434 VDD VDD VSS VSS gf180mcu_as_sc_mcu7t3v3__fillcap_16
X_4550_ VDD VDD VSS VSS _4553_/B _4550_/A gf180mcu_as_sc_mcu7t3v3__inv_2
XTAP_TAPCELL_ROW_174_1976 VDD VSS gf180mcu_as_sc_mcu7t3v3__tap_2
XFILLER_143_212 VDD VDD VSS VSS gf180mcu_as_sc_mcu7t3v3__fillcap_8
XFILLER_176_1437 VDD VDD VSS VSS gf180mcu_as_sc_mcu7t3v3__fillcap_16
XFILLER_184_893 VDD VDD VSS VSS gf180mcu_as_sc_mcu7t3v3__fillcap_16
XPHY_EDGE_ROW_103_3_Left_488 VDD VSS gf180mcu_as_sc_mcu7t3v3__tap_2
Xwire492 VDD VDD VSS VSS _3089_/Y _4787_/D gf180mcu_as_sc_mcu7t3v3__clkbuff_12
Xwire470 VDD VDD VSS VSS _3594_/Y _4842_/D gf180mcu_as_sc_mcu7t3v3__clkbuff_12
X_4481_ VDD VDD VSS VSS _4482_/C _4509_/S _5018_/Q _4510_/A gf180mcu_as_sc_mcu7t3v3__ao21_2
X_3501_ VDD VDD VSS VSS _4160_/D _3501_/B _3501_/C _4159_/A _3502_/D gf180mcu_as_sc_mcu7t3v3__ao22_2
XTAP_TAPCELL_ROW_174_1998 VDD VSS gf180mcu_as_sc_mcu7t3v3__tap_2
XTAP_TAPCELL_ROW_174_1987 VDD VSS gf180mcu_as_sc_mcu7t3v3__tap_2
XFILLER_176_1459 VDD VDD VSS VSS gf180mcu_as_sc_mcu7t3v3__fill_1
X_3432_ VDD VDD VSS VSS _4083_/A _3477_/B _3432_/C _4823_/D _3608_/D gf180mcu_as_sc_mcu7t3v3__aoi211_2
XTAP_TAPCELL_ROW_152_1_1902 VDD VSS gf180mcu_as_sc_mcu7t3v3__tap_2
X_3363_ VDD VDD VSS VSS _3449_/B _4013_/D _3363_/A _3364_/D gf180mcu_as_sc_mcu7t3v3__mux2_2
XPHY_EDGE_ROW_40_3_Left_425 VDD VSS gf180mcu_as_sc_mcu7t3v3__tap_2
X_5102_ VDD VDD VSS VSS _5260_/CLK _5102_/D _5102_/Q gf180mcu_as_sc_mcu7t3v3__dfxtp_2
XTAP_TAPCELL_ROW_164_3_3214 VDD VSS gf180mcu_as_sc_mcu7t3v3__tap_2
XFILLER_111_142 VDD VDD VSS VSS gf180mcu_as_sc_mcu7t3v3__fillcap_16
XFILLER_57_207 VDD VDD VSS VSS gf180mcu_as_sc_mcu7t3v3__fill_2
X_3294_ VDD VDD VSS VSS _3938_/D _3404_/B _3294_/C _3294_/D _3295_/C gf180mcu_as_sc_mcu7t3v3__ao211_2
XPHY_EDGE_ROW_165_3_Left_550 VDD VSS gf180mcu_as_sc_mcu7t3v3__tap_2
XTAP_TAPCELL_ROW_14_1040 VDD VSS gf180mcu_as_sc_mcu7t3v3__tap_2
X_5033_ VDD VDD VSS VSS clkload4/A _5033_/D _5033_/Q gf180mcu_as_sc_mcu7t3v3__dfxtp_2
XPHY_EDGE_ROW_128_3_Right_165 VDD VSS gf180mcu_as_sc_mcu7t3v3__tap_2
XFILLER_25_104 VDD VDD VSS VSS gf180mcu_as_sc_mcu7t3v3__fillcap_16
XFILLER_26_627 VDD VDD VSS VSS gf180mcu_as_sc_mcu7t3v3__fillcap_16
XTAP_TAPCELL_ROW_1_759 VDD VSS gf180mcu_as_sc_mcu7t3v3__tap_2
XTAP_TAPCELL_ROW_1_748 VDD VSS gf180mcu_as_sc_mcu7t3v3__tap_2
XFILLER_20_1061 VDD VDD VSS VSS gf180mcu_as_sc_mcu7t3v3__fillcap_16
XFILLER_0_1155 VDD VDD VSS VSS gf180mcu_as_sc_mcu7t3v3__fill_1
XFILLER_15_27 VDD VDD VSS VSS gf180mcu_as_sc_mcu7t3v3__fillcap_16
XFILLER_179_632 VDD VDD VSS VSS gf180mcu_as_sc_mcu7t3v3__fillcap_8
XFILLER_34_671 VDD VDD VSS VSS gf180mcu_as_sc_mcu7t3v3__fill_2
XFILLER_40_107 VDD VDD VSS VSS gf180mcu_as_sc_mcu7t3v3__fillcap_16
XFILLER_181_1154 VDD VDD VSS VSS gf180mcu_as_sc_mcu7t3v3__fillcap_16
XFILLER_21_321 VDD VDD VSS VSS gf180mcu_as_sc_mcu7t3v3__fillcap_4
XFILLER_16_1119 VDD VDD VSS VSS gf180mcu_as_sc_mcu7t3v3__fillcap_16
XFILLER_194_613 VDD VDD VSS VSS gf180mcu_as_sc_mcu7t3v3__fillcap_16
XFILLER_210_945 VDD VDD VSS VSS gf180mcu_as_sc_mcu7t3v3__fillcap_4
XFILLER_22_855 VDD VDD VSS VSS gf180mcu_as_sc_mcu7t3v3__fillcap_16
X_4817_ VDD VDD VSS VSS _5068_/CLK _4817_/D _4817_/Q gf180mcu_as_sc_mcu7t3v3__dfxtp_2
XFILLER_119_220 VDD VDD VSS VSS gf180mcu_as_sc_mcu7t3v3__fill_2
XFILLER_33_1466 VDD VDD VSS VSS gf180mcu_as_sc_mcu7t3v3__fillcap_4
XFILLER_33_1488 VDD VDD VSS VSS gf180mcu_as_sc_mcu7t3v3__fillcap_16
X_4748_ VDD VDD VSS VSS _4748_/A _4748_/B _4750_/B _5277_/Q _5277_/D gf180mcu_as_sc_mcu7t3v3__ao22_2
XFILLER_120_1469 VDD VDD VSS VSS gf180mcu_as_sc_mcu7t3v3__fillcap_16
XFILLER_68_1518 VDD VDD VSS VSS gf180mcu_as_sc_mcu7t3v3__fill_2
X_4679_ VDD VDD VSS VSS _5247_/Q _4685_/C _4681_/C _5248_/Q _4680_/C gf180mcu_as_sc_mcu7t3v3__ao22_2
XPHY_EDGE_ROW_1_Right_1 VDD VSS gf180mcu_as_sc_mcu7t3v3__tap_2
XFILLER_157_1381 VDD VDD VSS VSS gf180mcu_as_sc_mcu7t3v3__fill_1
XFILLER_157_1392 VDD VDD VSS VSS gf180mcu_as_sc_mcu7t3v3__fillcap_4
XFILLER_163_69 VDD VDD VSS VSS gf180mcu_as_sc_mcu7t3v3__fill_1
XPHY_EDGE_ROW_97_3_Left_482 VDD VSS gf180mcu_as_sc_mcu7t3v3__tap_2
Xinput104 VDD VDD VSS VSS ne_in[33] _3530_/A gf180mcu_as_sc_mcu7t3v3__buff_12
Xinput115 VDD VDD VSS VSS north_in[12] _4029_/A gf180mcu_as_sc_mcu7t3v3__buff_12
Xinput126 VDD VDD VSS VSS north_in[22] _4112_/A gf180mcu_as_sc_mcu7t3v3__buff_12
Xinput137 VDD VDD VSS VSS north_in[32] _3519_/A gf180mcu_as_sc_mcu7t3v3__buff_12
Xinput148 VDD VDD VSS VSS nw_in[11] _4022_/A gf180mcu_as_sc_mcu7t3v3__buff_12
Xinput159 VDD VDD VSS VSS nw_in[21] _4104_/A gf180mcu_as_sc_mcu7t3v3__buff_12
XTAP_TAPCELL_ROW_180_2125 VDD VSS gf180mcu_as_sc_mcu7t3v3__tap_2
XFILLER_29_454 VDD VDD VSS VSS gf180mcu_as_sc_mcu7t3v3__fillcap_16
XFILLER_40_1448 VDD VDD VSS VSS gf180mcu_as_sc_mcu7t3v3__fill_2
XFILLER_56_34 VDD VDD VSS VSS gf180mcu_as_sc_mcu7t3v3__fill_1
XFILLER_5_1044 VDD VDD VSS VSS gf180mcu_as_sc_mcu7t3v3__fillcap_4
XTAP_TAPCELL_ROW_180_2136 VDD VSS gf180mcu_as_sc_mcu7t3v3__tap_2
XTAP_TAPCELL_ROW_71_1_1657 VDD VSS gf180mcu_as_sc_mcu7t3v3__tap_2
XFILLER_186_1065 VDD VDD VSS VSS gf180mcu_as_sc_mcu7t3v3__fillcap_16
XFILLER_186_1087 VDD VDD VSS VSS gf180mcu_as_sc_mcu7t3v3__fillcap_16
XFILLER_198_941 VDD VDD VSS VSS gf180mcu_as_sc_mcu7t3v3__fillcap_4
XFILLER_13_844 VDD VDD VSS VSS gf180mcu_as_sc_mcu7t3v3__fill_1
XFILLER_169_142 VDD VDD VSS VSS gf180mcu_as_sc_mcu7t3v3__fill_1
XFILLER_198_963 VDD VDD VSS VSS gf180mcu_as_sc_mcu7t3v3__fillcap_16
XFILLER_201_912 VDD VDD VSS VSS gf180mcu_as_sc_mcu7t3v3__fillcap_16
XFILLER_12_354 VDD VDD VSS VSS gf180mcu_as_sc_mcu7t3v3__fill_2
XFILLER_184_101 VDD VDD VSS VSS gf180mcu_as_sc_mcu7t3v3__fillcap_4
XFILLER_200_422 VDD VDD VSS VSS gf180mcu_as_sc_mcu7t3v3__fill_1
XFILLER_51_1500 VDD VDD VSS VSS gf180mcu_as_sc_mcu7t3v3__fill_2
XTAP_TAPCELL_ROW_51_1_1599 VDD VSS gf180mcu_as_sc_mcu7t3v3__tap_2
XTAP_TAPCELL_ROW_178_2098 VDD VSS gf180mcu_as_sc_mcu7t3v3__tap_2
XTAP_TAPCELL_ROW_178_2087 VDD VSS gf180mcu_as_sc_mcu7t3v3__tap_2
XFILLER_12_387 VDD VDD VSS VSS gf180mcu_as_sc_mcu7t3v3__fillcap_16
XFILLER_184_123 VDD VDD VSS VSS gf180mcu_as_sc_mcu7t3v3__fillcap_4
XFILLER_36_1090 VDD VDD VSS VSS gf180mcu_as_sc_mcu7t3v3__fillcap_16
XTAP_TAPCELL_ROW_157_1_1917 VDD VSS gf180mcu_as_sc_mcu7t3v3__tap_2
XFILLER_201_1224 VDD VDD VSS VSS gf180mcu_as_sc_mcu7t3v3__fillcap_16
XFILLER_51_1555 VDD VDD VSS VSS gf180mcu_as_sc_mcu7t3v3__fill_1
XFILLER_51_1566 VDD VDD VSS VSS gf180mcu_as_sc_mcu7t3v3__fill_2
XTAP_TAPCELL_ROW_169_3_3229 VDD VSS gf180mcu_as_sc_mcu7t3v3__tap_2
XFILLER_125_212 VDD VDD VSS VSS gf180mcu_as_sc_mcu7t3v3__fillcap_8
XFILLER_193_1014 VDD VDD VSS VSS gf180mcu_as_sc_mcu7t3v3__fillcap_16
XFILLER_207_18 VDD VDD VSS VSS gf180mcu_as_sc_mcu7t3v3__fillcap_16
XFILLER_98_107 VDD VDD VSS VSS gf180mcu_as_sc_mcu7t3v3__fillcap_16
XFILLER_180_395 VDD VDD VSS VSS gf180mcu_as_sc_mcu7t3v3__fill_2
XFILLER_45_1348 VDD VDD VSS VSS gf180mcu_as_sc_mcu7t3v3__fillcap_4
XFILLER_153_80 VDD VDD VSS VSS gf180mcu_as_sc_mcu7t3v3__fillcap_4
XFILLER_36_914 VDD VDD VSS VSS gf180mcu_as_sc_mcu7t3v3__fillcap_4
XFILLER_36_947 VDD VDD VSS VSS gf180mcu_as_sc_mcu7t3v3__fillcap_4
XFILLER_22_107 VDD VDD VSS VSS gf180mcu_as_sc_mcu7t3v3__fillcap_8
XFILLER_95_1471 VDD VDD VSS VSS gf180mcu_as_sc_mcu7t3v3__fill_1
X_3981_ VDD VDD VSS VSS _3981_/A _4101_/B _4101_/C _3981_/D _3983_/C gf180mcu_as_sc_mcu7t3v3__ao22_2
X_2932_ VDD VDD VSS VSS _3179_/B _3233_/C _2932_/C _3216_/B _2947_/A gf180mcu_as_sc_mcu7t3v3__nand4_2
XFILLER_176_613 VDD VDD VSS VSS gf180mcu_as_sc_mcu7t3v3__fillcap_16
XFILLER_188_473 VDD VDD VSS VSS gf180mcu_as_sc_mcu7t3v3__fillcap_16
XFILLER_203_260 VDD VDD VSS VSS gf180mcu_as_sc_mcu7t3v3__fillcap_16
XFILLER_203_282 VDD VDD VSS VSS gf180mcu_as_sc_mcu7t3v3__fillcap_16
XFILLER_206_1135 VDD VDD VSS VSS gf180mcu_as_sc_mcu7t3v3__fillcap_16
XFILLER_206_1157 VDD VDD VSS VSS gf180mcu_as_sc_mcu7t3v3__fillcap_16
XFILLER_176_646 VDD VDD VSS VSS gf180mcu_as_sc_mcu7t3v3__fillcap_4
XFILLER_31_674 VDD VDD VSS VSS gf180mcu_as_sc_mcu7t3v3__fill_1
XFILLER_87_2 VDD VDD VSS VSS gf180mcu_as_sc_mcu7t3v3__fill_2
X_2863_ VDD VDD VSS VSS _4767_/Q _4763_/Q _2865_/B gf180mcu_as_sc_mcu7t3v3__and2_2
XPHY_EDGE_ROW_28_Left_239 VDD VSS gf180mcu_as_sc_mcu7t3v3__tap_2
X_4602_ VDD VDD VSS VSS _5196_/Q _4750_/D _4604_/C _5197_/Q _5196_/D gf180mcu_as_sc_mcu7t3v3__ao22_2
X_2794_ VDD VDD VSS VSS _2794_/B _2794_/A _4626_/A gf180mcu_as_sc_mcu7t3v3__xnor2_2
XFILLER_7_50 VDD VDD VSS VSS gf180mcu_as_sc_mcu7t3v3__fillcap_16
XFILLER_7_72 VDD VDD VSS VSS gf180mcu_as_sc_mcu7t3v3__fillcap_16
X_4533_ VDD VDD VSS VSS _4533_/B _4533_/A _4539_/C gf180mcu_as_sc_mcu7t3v3__and2_2
XFILLER_190_137 VDD VDD VSS VSS gf180mcu_as_sc_mcu7t3v3__fill_1
XFILLER_7_380 VDD VDD VSS VSS gf180mcu_as_sc_mcu7t3v3__fillcap_4
X_4464_ VDD VDD VSS VSS _4465_/D _4464_/B _4510_/A gf180mcu_as_sc_mcu7t3v3__nor2_2
Xclkbuf_leaf_35_clk_regs VDD VDD VSS VSS clkbuf_3_3__f_clk_regs/Y _5073_/CLK gf180mcu_as_sc_mcu7t3v3__clkbuff_12
Xfanout805 VDD VDD VSS VSS fanout809/Y _4509_/S gf180mcu_as_sc_mcu7t3v3__buff_12
Xfanout816 VDD VDD VSS VSS _2560_/Y _2735_/D gf180mcu_as_sc_mcu7t3v3__buff_12
X_4395_ VDD VDD VSS VSS _4398_/C _4395_/B _4521_/A gf180mcu_as_sc_mcu7t3v3__nor2_2
X_3415_ VDD VDD VSS VSS _3455_/B _3415_/B _3415_/C _3416_/C gf180mcu_as_sc_mcu7t3v3__nor3_2
XPHY_EDGE_ROW_0_Left_211 VDD VSS gf180mcu_as_sc_mcu7t3v3__tap_2
X_3346_ VDD VDD VSS VSS _3450_/B _4000_/A _3347_/D gf180mcu_as_sc_mcu7t3v3__and2_2
XFILLER_115_1549 VDD VDD VSS VSS gf180mcu_as_sc_mcu7t3v3__fillcap_4
XFILLER_97_173 VDD VDD VSS VSS gf180mcu_as_sc_mcu7t3v3__fill_2
X_5016_ VDD VDD VSS VSS clkload1/A _5016_/D _5016_/Q gf180mcu_as_sc_mcu7t3v3__dfxtp_2
X_3277_ VDD VDD VSS VSS _3522_/B _3814_/B _3280_/D gf180mcu_as_sc_mcu7t3v3__nor2_2
XTAP_TAPCELL_ROW_33_1460 VDD VSS gf180mcu_as_sc_mcu7t3v3__tap_2
XFILLER_26_37 VDD VDD VSS VSS gf180mcu_as_sc_mcu7t3v3__fillcap_16
XPHY_EDGE_ROW_129_3_Right_166 VDD VSS gf180mcu_as_sc_mcu7t3v3__tap_2
XFILLER_26_457 VDD VDD VSS VSS gf180mcu_as_sc_mcu7t3v3__fillcap_16
XFILLER_161_1503 VDD VDD VSS VSS gf180mcu_as_sc_mcu7t3v3__fill_2
XPHY_EDGE_ROW_174_Right_37 VDD VSS gf180mcu_as_sc_mcu7t3v3__tap_2
XFILLER_210_720 VDD VDD VSS VSS gf180mcu_as_sc_mcu7t3v3__fill_1
XFILLER_22_630 VDD VDD VSS VSS gf180mcu_as_sc_mcu7t3v3__fillcap_8
XFILLER_74_1566 VDD VDD VSS VSS gf180mcu_as_sc_mcu7t3v3__fill_2
XFILLER_161_1558 VDD VDD VSS VSS gf180mcu_as_sc_mcu7t3v3__fillcap_8
XFILLER_195_944 VDD VDD VSS VSS gf180mcu_as_sc_mcu7t3v3__fillcap_16
XFILLER_22_663 VDD VDD VSS VSS gf180mcu_as_sc_mcu7t3v3__fill_2
XFILLER_124_1380 VDD VDD VSS VSS gf180mcu_as_sc_mcu7t3v3__fill_1
XFILLER_210_775 VDD VDD VSS VSS gf180mcu_as_sc_mcu7t3v3__fill_2
XFILLER_107_212 VDD VDD VSS VSS gf180mcu_as_sc_mcu7t3v3__fillcap_8
XFILLER_181_104 VDD VDD VSS VSS gf180mcu_as_sc_mcu7t3v3__fillcap_16
XFILLER_194_1345 VDD VDD VSS VSS gf180mcu_as_sc_mcu7t3v3__fillcap_16
XFILLER_194_1367 VDD VDD VSS VSS gf180mcu_as_sc_mcu7t3v3__fillcap_16
XFILLER_68_1348 VDD VDD VSS VSS gf180mcu_as_sc_mcu7t3v3__fillcap_16
XFILLER_1_512 VDD VDD VSS VSS gf180mcu_as_sc_mcu7t3v3__fill_2
XFILLER_81_1504 VDD VDD VSS VSS gf180mcu_as_sc_mcu7t3v3__fill_2
XPHY_EDGE_ROW_183_Right_46 VDD VSS gf180mcu_as_sc_mcu7t3v3__tap_2
XFILLER_1_578 VDD VDD VSS VSS gf180mcu_as_sc_mcu7t3v3__fill_2
XFILLER_190_34 VDD VDD VSS VSS gf180mcu_as_sc_mcu7t3v3__fill_1
XFILLER_191_2 VDD VDD VSS VSS gf180mcu_as_sc_mcu7t3v3__fillcap_16
XTAP_TAPCELL_ROW_5_840 VDD VSS gf180mcu_as_sc_mcu7t3v3__tap_2
XFILLER_67_88 VDD VDD VSS VSS gf180mcu_as_sc_mcu7t3v3__fillcap_16
XTAP_TAPCELL_ROW_5_851 VDD VSS gf180mcu_as_sc_mcu7t3v3__tap_2
XFILLER_123_61 VDD VDD VSS VSS gf180mcu_as_sc_mcu7t3v3__fillcap_8
XFILLER_131_1362 VDD VDD VSS VSS gf180mcu_as_sc_mcu7t3v3__fill_1
XFILLER_29_273 VDD VDD VSS VSS gf180mcu_as_sc_mcu7t3v3__fillcap_4
XFILLER_123_72 VDD VDD VSS VSS gf180mcu_as_sc_mcu7t3v3__fill_1
XFILLER_18_947 VDD VDD VSS VSS gf180mcu_as_sc_mcu7t3v3__fillcap_8
XFILLER_44_221 VDD VDD VSS VSS gf180mcu_as_sc_mcu7t3v3__fill_1
XTAP_TAPCELL_ROW_205_2684 VDD VSS gf180mcu_as_sc_mcu7t3v3__tap_2
XTAP_TAPCELL_ROW_205_2673 VDD VSS gf180mcu_as_sc_mcu7t3v3__tap_2
XFILLER_199_54 VDD VDD VSS VSS gf180mcu_as_sc_mcu7t3v3__fillcap_16
XFILLER_33_906 VDD VDD VSS VSS gf180mcu_as_sc_mcu7t3v3__fillcap_4
XFILLER_33_928 VDD VDD VSS VSS gf180mcu_as_sc_mcu7t3v3__fill_2
XFILLER_79_1488 VDD VDD VSS VSS gf180mcu_as_sc_mcu7t3v3__fillcap_16
XPHY_EDGE_ROW_192_Right_55 VDD VSS gf180mcu_as_sc_mcu7t3v3__tap_2
XPHY_EDGE_ROW_106_1_Left_316 VDD VSS gf180mcu_as_sc_mcu7t3v3__tap_2
XTAP_TAPCELL_ROW_197_2496 VDD VSS gf180mcu_as_sc_mcu7t3v3__tap_2
XFILLER_13_696 VDD VDD VSS VSS gf180mcu_as_sc_mcu7t3v3__fillcap_4
XFILLER_197_292 VDD VDD VSS VSS gf180mcu_as_sc_mcu7t3v3__fillcap_16
XFILLER_200_241 VDD VDD VSS VSS gf180mcu_as_sc_mcu7t3v3__fillcap_4
XFILLER_207_1466 VDD VDD VSS VSS gf180mcu_as_sc_mcu7t3v3__fillcap_4
XFILLER_207_1488 VDD VDD VSS VSS gf180mcu_as_sc_mcu7t3v3__fillcap_16
XFILLER_185_465 VDD VDD VSS VSS gf180mcu_as_sc_mcu7t3v3__fillcap_16
XFILLER_199_1256 VDD VDD VSS VSS gf180mcu_as_sc_mcu7t3v3__fillcap_4
XFILLER_200_263 VDD VDD VSS VSS gf180mcu_as_sc_mcu7t3v3__fillcap_16
XFILLER_199_1278 VDD VDD VSS VSS gf180mcu_as_sc_mcu7t3v3__fillcap_16
XFILLER_8_177 VDD VDD VSS VSS gf180mcu_as_sc_mcu7t3v3__fill_1
Xoutput408 VDD VDD VSS VSS _4828_/Q south_out[23] gf180mcu_as_sc_mcu7t3v3__buff_12
XFILLER_138_1527 VDD VDD VSS VSS gf180mcu_as_sc_mcu7t3v3__fill_1
XFILLER_173_1418 VDD VDD VSS VSS gf180mcu_as_sc_mcu7t3v3__fillcap_4
XFILLER_86_1448 VDD VDD VSS VSS gf180mcu_as_sc_mcu7t3v3__fill_2
Xoutput419 VDD VDD VSS VSS _4838_/Q south_out[33] gf180mcu_as_sc_mcu7t3v3__buff_12
X_4180_ VDD VDD VSS VSS _4240_/B _4191_/B _4191_/C _5018_/Q _5018_/D gf180mcu_as_sc_mcu7t3v3__ao22_2
X_3200_ VDD VDD VSS VSS _3203_/A _3236_/C _3788_/D gf180mcu_as_sc_mcu7t3v3__nand2_2
XFILLER_164_90 VDD VDD VSS VSS gf180mcu_as_sc_mcu7t3v3__fillcap_8
XFILLER_79_184 VDD VDD VSS VSS gf180mcu_as_sc_mcu7t3v3__fill_1
X_3131_ VDD VDD VSS VSS _3132_/B _3131_/B _3131_/C _3132_/C gf180mcu_as_sc_mcu7t3v3__nor3_2
XFILLER_94_143 VDD VDD VSS VSS gf180mcu_as_sc_mcu7t3v3__fill_2
XFILLER_110_1413 VDD VDD VSS VSS gf180mcu_as_sc_mcu7t3v3__fill_1
XFILLER_23_1476 VDD VDD VSS VSS gf180mcu_as_sc_mcu7t3v3__fill_2
X_3062_ VDD VDD VSS VSS _3129_/B _4928_/Q _3063_/D gf180mcu_as_sc_mcu7t3v3__or2_2
XFILLER_110_1446 VDD VDD VSS VSS gf180mcu_as_sc_mcu7t3v3__fill_1
XFILLER_58_1506 VDD VDD VSS VSS gf180mcu_as_sc_mcu7t3v3__fillcap_8
XFILLER_97_1555 VDD VDD VSS VSS gf180mcu_as_sc_mcu7t3v3__fill_1
XFILLER_97_1566 VDD VDD VSS VSS gf180mcu_as_sc_mcu7t3v3__fill_2
XFILLER_35_254 VDD VDD VSS VSS gf180mcu_as_sc_mcu7t3v3__fillcap_16
XFILLER_36_788 VDD VDD VSS VSS gf180mcu_as_sc_mcu7t3v3__fill_1
XFILLER_58_1539 VDD VDD VSS VSS gf180mcu_as_sc_mcu7t3v3__fillcap_4
XPHY_EDGE_ROW_38_1_Left_248 VDD VSS gf180mcu_as_sc_mcu7t3v3__tap_2
XTAP_TAPCELL_ROW_51_3_2874 VDD VSS gf180mcu_as_sc_mcu7t3v3__tap_2
XFILLER_23_416 VDD VDD VSS VSS gf180mcu_as_sc_mcu7t3v3__fillcap_4
XFILLER_23_438 VDD VDD VSS VSS gf180mcu_as_sc_mcu7t3v3__fillcap_4
XFILLER_35_298 VDD VDD VSS VSS gf180mcu_as_sc_mcu7t3v3__fillcap_16
X_3964_ VDD VDD VSS VSS _4981_/Q _4142_/B _4232_/B _4142_/D _4981_/D gf180mcu_as_sc_mcu7t3v3__ao22_2
XFILLER_108_1364 VDD VDD VSS VSS gf180mcu_as_sc_mcu7t3v3__fillcap_16
XFILLER_148_123 VDD VDD VSS VSS gf180mcu_as_sc_mcu7t3v3__fillcap_8
XFILLER_177_944 VDD VDD VSS VSS gf180mcu_as_sc_mcu7t3v3__fillcap_16
XFILLER_204_591 VDD VDD VSS VSS gf180mcu_as_sc_mcu7t3v3__fillcap_4
X_3895_ VDD VDD VSS VSS _3897_/B _5185_/Q _4935_/D gf180mcu_as_sc_mcu7t3v3__and2_2
X_2915_ VDD VDD VSS VSS _3787_/A _3255_/B _3544_/C _3201_/C _3222_/D gf180mcu_as_sc_mcu7t3v3__aoi31_2
XFILLER_192_925 VDD VDD VSS VSS gf180mcu_as_sc_mcu7t3v3__fillcap_16
X_2846_ VDD VDD VSS VSS _5277_/Q _4637_/A _4708_/C _2847_/C _4748_/B gf180mcu_as_sc_mcu7t3v3__aoi31_2
XFILLER_163_104 VDD VDD VSS VSS gf180mcu_as_sc_mcu7t3v3__fillcap_16
XFILLER_192_947 VDD VDD VSS VSS gf180mcu_as_sc_mcu7t3v3__fillcap_16
XFILLER_30_1469 VDD VDD VSS VSS gf180mcu_as_sc_mcu7t3v3__fill_2
X_2777_ VDD VDD VSS VSS _2778_/B _4331_/A _5269_/Q _5272_/Q gf180mcu_as_sc_mcu7t3v3__aoi21b_2
XFILLER_191_479 VDD VDD VSS VSS gf180mcu_as_sc_mcu7t3v3__fill_1
XPHY_EDGE_ROW_152_1_Left_362 VDD VSS gf180mcu_as_sc_mcu7t3v3__tap_2
X_4516_ VDD VDD VSS VSS _4520_/B _5080_/Q _4527_/S gf180mcu_as_sc_mcu7t3v3__nand2_2
XTAP_TAPCELL_ROW_120_1_1804 VDD VSS gf180mcu_as_sc_mcu7t3v3__tap_2
X_4447_ VDD VDD VSS VSS _4579_/S _5014_/Q _5043_/Q _4448_/B gf180mcu_as_sc_mcu7t3v3__mux2_2
XTAP_TAPCELL_ROW_35_1500 VDD VSS gf180mcu_as_sc_mcu7t3v3__tap_2
XFILLER_119_1460 VDD VDD VSS VSS gf180mcu_as_sc_mcu7t3v3__fillcap_4
XFILLER_28_1321 VDD VDD VSS VSS gf180mcu_as_sc_mcu7t3v3__fill_2
XTAP_TAPCELL_ROW_132_3_3116 VDD VSS gf180mcu_as_sc_mcu7t3v3__tap_2
Xfanout602 VDD VDD VSS VSS _4141_/D _4116_/A gf180mcu_as_sc_mcu7t3v3__buff_12
Xfanout613 VDD VDD VSS VSS _2928_/Y _3125_/B gf180mcu_as_sc_mcu7t3v3__buff_12
Xfanout624 VDD VDD VSS VSS _4101_/B _4030_/B gf180mcu_as_sc_mcu7t3v3__buff_12
XTAP_TAPCELL_ROW_35_1511 VDD VSS gf180mcu_as_sc_mcu7t3v3__tap_2
XFILLER_8_1437 VDD VDD VSS VSS gf180mcu_as_sc_mcu7t3v3__fillcap_8
Xfanout635 VDD VDD VSS VSS _3563_/Y _3724_/B gf180mcu_as_sc_mcu7t3v3__buff_12
Xfanout646 VDD VDD VSS VSS _3267_/Y _3467_/B gf180mcu_as_sc_mcu7t3v3__buff_12
X_4378_ VDD VDD VSS VSS _5485_/A _4575_/C _4378_/C _4378_/D _4380_/A gf180mcu_as_sc_mcu7t3v3__ao211_2
XTAP_TAPCELL_ROW_31_1408 VDD VSS gf180mcu_as_sc_mcu7t3v3__tap_2
Xfanout668 VDD VDD VSS VSS _4620_/C _4622_/C gf180mcu_as_sc_mcu7t3v3__buff_12
Xfanout679 VDD VDD VSS VSS _3931_/Y _4159_/B gf180mcu_as_sc_mcu7t3v3__buff_12
X_3329_ VDD VDD VSS VSS _3981_/D _3403_/S _3329_/C _3401_/B _3331_/C gf180mcu_as_sc_mcu7t3v3__ao211_2
XTAP_TAPCELL_ROW_31_1419 VDD VSS gf180mcu_as_sc_mcu7t3v3__tap_2
XFILLER_189_1436 VDD VDD VSS VSS gf180mcu_as_sc_mcu7t3v3__fillcap_16
XFILLER_85_176 VDD VDD VSS VSS gf180mcu_as_sc_mcu7t3v3__fill_2
XFILLER_160_37 VDD VDD VSS VSS gf180mcu_as_sc_mcu7t3v3__fillcap_16
XFILLER_37_69 VDD VDD VSS VSS gf180mcu_as_sc_mcu7t3v3__fill_1
XTAP_TAPCELL_ROW_100_1_1746 VDD VSS gf180mcu_as_sc_mcu7t3v3__tap_2
XFILLER_14_405 VDD VDD VSS VSS gf180mcu_as_sc_mcu7t3v3__fill_1
XFILLER_15_928 VDD VDD VSS VSS gf180mcu_as_sc_mcu7t3v3__fillcap_16
XFILLER_163_6 VDD VDD VSS VSS gf180mcu_as_sc_mcu7t3v3__fillcap_16
XFILLER_199_524 VDD VDD VSS VSS gf180mcu_as_sc_mcu7t3v3__fillcap_16
XFILLER_27_788 VDD VDD VSS VSS gf180mcu_as_sc_mcu7t3v3__fillcap_16
XPHY_EDGE_ROW_128_3_Left_513 VDD VSS gf180mcu_as_sc_mcu7t3v3__tap_2
XTAP_TAPCELL_ROW_112_3_3058 VDD VSS gf180mcu_as_sc_mcu7t3v3__tap_2
XFILLER_14_416 VDD VDD VSS VSS gf180mcu_as_sc_mcu7t3v3__fillcap_16
XTAP_TAPCELL_ROW_29_1359 VDD VSS gf180mcu_as_sc_mcu7t3v3__tap_2
XFILLER_165_1480 VDD VDD VSS VSS gf180mcu_as_sc_mcu7t3v3__fillcap_4
XFILLER_183_1068 VDD VDD VSS VSS gf180mcu_as_sc_mcu7t3v3__fillcap_16
XFILLER_186_218 VDD VDD VSS VSS gf180mcu_as_sc_mcu7t3v3__fillcap_8
XFILLER_39_1472 VDD VDD VSS VSS gf180mcu_as_sc_mcu7t3v3__fill_2
XFILLER_53_68 VDD VDD VSS VSS gf180mcu_as_sc_mcu7t3v3__fill_2
XTAP_TAPCELL_ROW_200_2570 VDD VSS gf180mcu_as_sc_mcu7t3v3__tap_2
XTAP_TAPCELL_ROW_175_2024 VDD VSS gf180mcu_as_sc_mcu7t3v3__tap_2
XTAP_TAPCELL_ROW_175_2013 VDD VSS gf180mcu_as_sc_mcu7t3v3__tap_2
XFILLER_126_1453 VDD VDD VSS VSS gf180mcu_as_sc_mcu7t3v3__fillcap_8
XTAP_TAPCELL_ROW_200_2581 VDD VSS gf180mcu_as_sc_mcu7t3v3__tap_2
XFILLER_126_1497 VDD VDD VSS VSS gf180mcu_as_sc_mcu7t3v3__fillcap_8
XFILLER_210_550 VDD VDD VSS VSS gf180mcu_as_sc_mcu7t3v3__fill_1
XFILLER_22_482 VDD VDD VSS VSS gf180mcu_as_sc_mcu7t3v3__fillcap_16
XFILLER_182_402 VDD VDD VSS VSS gf180mcu_as_sc_mcu7t3v3__fill_1
XFILLER_194_273 VDD VDD VSS VSS gf180mcu_as_sc_mcu7t3v3__fillcap_8
XTAP_TAPCELL_ROW_192_2393 VDD VSS gf180mcu_as_sc_mcu7t3v3__tap_2
XFILLER_182_457 VDD VDD VSS VSS gf180mcu_as_sc_mcu7t3v3__fillcap_16
XPHY_EDGE_ROW_84_1_Left_294 VDD VSS gf180mcu_as_sc_mcu7t3v3__tap_2
XFILLER_204_2 VDD VDD VSS VSS gf180mcu_as_sc_mcu7t3v3__fillcap_16
XTAP_TAPCELL_ROW_46_1_1583 VDD VSS gf180mcu_as_sc_mcu7t3v3__tap_2
XFILLER_190_1017 VDD VDD VSS VSS gf180mcu_as_sc_mcu7t3v3__fillcap_16
XTAP_TAPCELL_ROW_56_3_2889 VDD VSS gf180mcu_as_sc_mcu7t3v3__tap_2
XFILLER_172_1495 VDD VDD VSS VSS gf180mcu_as_sc_mcu7t3v3__fill_1
Xmesh_tile_1001 VDD VDD VSS VSS nw_out[8] gf180mcu_as_sc_mcu7t3v3__tiel_4
XTAP_TAPCELL_ROW_207_2735 VDD VSS gf180mcu_as_sc_mcu7t3v3__tap_2
XTAP_TAPCELL_ROW_207_2724 VDD VSS gf180mcu_as_sc_mcu7t3v3__tap_2
XFILLER_94_53 VDD VDD VSS VSS gf180mcu_as_sc_mcu7t3v3__fillcap_16
Xmesh_tile_1012 VDD VDD VSS VSS nw_out[19] gf180mcu_as_sc_mcu7t3v3__tiel_4
Xmesh_tile_1034 VDD VDD VSS VSS sw_out[7] gf180mcu_as_sc_mcu7t3v3__tiel_4
Xmesh_tile_1023 VDD VDD VSS VSS nw_out[30] gf180mcu_as_sc_mcu7t3v3__tiel_4
XFILLER_206_801 VDD VDD VSS VSS gf180mcu_as_sc_mcu7t3v3__fillcap_4
XFILLER_206_823 VDD VDD VSS VSS gf180mcu_as_sc_mcu7t3v3__fillcap_16
Xmesh_tile_1056 VDD VDD VSS VSS sw_out[29] gf180mcu_as_sc_mcu7t3v3__tiel_4
Xmesh_tile_1045 VDD VDD VSS VSS sw_out[18] gf180mcu_as_sc_mcu7t3v3__tiel_4
XPHY_EDGE_ROW_112_3_Left_497 VDD VSS gf180mcu_as_sc_mcu7t3v3__tap_2
XTAP_TAPCELL_ROW_199_2558 VDD VSS gf180mcu_as_sc_mcu7t3v3__tap_2
XTAP_TAPCELL_ROW_199_2547 VDD VSS gf180mcu_as_sc_mcu7t3v3__tap_2
XFILLER_17_298 VDD VDD VSS VSS gf180mcu_as_sc_mcu7t3v3__fillcap_4
XFILLER_177_229 VDD VDD VSS VSS gf180mcu_as_sc_mcu7t3v3__fillcap_4
XFILLER_13_471 VDD VDD VSS VSS gf180mcu_as_sc_mcu7t3v3__fillcap_16
XFILLER_18_1567 VDD VDD VSS VSS gf180mcu_as_sc_mcu7t3v3__fill_2
XFILLER_203_1116 VDD VDD VSS VSS gf180mcu_as_sc_mcu7t3v3__fillcap_4
XFILLER_203_1138 VDD VDD VSS VSS gf180mcu_as_sc_mcu7t3v3__fillcap_16
XFILLER_53_1458 VDD VDD VSS VSS gf180mcu_as_sc_mcu7t3v3__fillcap_4
X_2700_ VDD VDD VSS VSS _2722_/B _2700_/A _2701_/D gf180mcu_as_sc_mcu7t3v3__and2_2
XFILLER_145_104 VDD VDD VSS VSS gf180mcu_as_sc_mcu7t3v3__fillcap_16
XFILLER_174_936 VDD VDD VSS VSS gf180mcu_as_sc_mcu7t3v3__fillcap_16
XFILLER_186_785 VDD VDD VSS VSS gf180mcu_as_sc_mcu7t3v3__fillcap_16
XFILLER_201_594 VDD VDD VSS VSS gf180mcu_as_sc_mcu7t3v3__fillcap_16
XFILLER_9_486 VDD VDD VSS VSS gf180mcu_as_sc_mcu7t3v3__fillcap_4
XTAP_TAPCELL_ROW_125_1_1819 VDD VSS gf180mcu_as_sc_mcu7t3v3__tap_2
X_3680_ VDD VDD VSS VSS _4930_/Q _3727_/B _3727_/C _4053_/D _3681_/D gf180mcu_as_sc_mcu7t3v3__ao22_2
X_2631_ VDD VDD VSS VSS _2631_/D _5232_/Q _5229_/Q _4975_/Q _2636_/A gf180mcu_as_sc_mcu7t3v3__ao31_2
XFILLER_160_107 VDD VDD VSS VSS gf180mcu_as_sc_mcu7t3v3__fillcap_16
X_2562_ VDD VDD VSS VSS _2826_/S _4769_/Q _4770_/Q _4975_/Q _2601_/D gf180mcu_as_sc_mcu7t3v3__ao22_2
XPHY_EDGE_ROW_206_Left_416 VDD VSS gf180mcu_as_sc_mcu7t3v3__tap_2
X_5281_ VDD VDD VSS VSS _5285_/CLK _5281_/D _5281_/Q gf180mcu_as_sc_mcu7t3v3__dfxtp_2
X_4301_ VDD VDD VSS VSS _4308_/S _5131_/Q _5130_/Q _5130_/D gf180mcu_as_sc_mcu7t3v3__mux2_2
XTAP_TAPCELL_ROW_92_1_1720 VDD VSS gf180mcu_as_sc_mcu7t3v3__tap_2
XFILLER_138_1368 VDD VDD VSS VSS gf180mcu_as_sc_mcu7t3v3__fill_2
XFILLER_64_1510 VDD VDD VSS VSS gf180mcu_as_sc_mcu7t3v3__fillcap_8
X_4232_ VDD VDD VSS VSS _4253_/S _4232_/B _5068_/Q _5068_/D gf180mcu_as_sc_mcu7t3v3__mux2_2
X_2493_ VDD VDD VSS VSS _5189_/Q _4954_/Q _2794_/B gf180mcu_as_sc_mcu7t3v3__xnor2_2
X_4163_ VDD VDD VSS VSS _4163_/A _4163_/B _4163_/C _4163_/D _4164_/B gf180mcu_as_sc_mcu7t3v3__ao211_2
XFILLER_151_1568 VDD VDD VSS VSS gf180mcu_as_sc_mcu7t3v3__fill_1
X_4094_ VDD VDD VSS VSS _4094_/A _4119_/B _4115_/B _4094_/D _4098_/A gf180mcu_as_sc_mcu7t3v3__ao211_2
X_3114_ VDD VDD VSS VSS _3115_/C _3114_/C _3150_/C _4085_/A gf180mcu_as_sc_mcu7t3v3__aoi21_2
XTAP_TAPCELL_ROW_72_1_1662 VDD VSS gf180mcu_as_sc_mcu7t3v3__tap_2
XFILLER_23_1262 VDD VDD VSS VSS gf180mcu_as_sc_mcu7t3v3__fillcap_16
XFILLER_3_1323 VDD VDD VSS VSS gf180mcu_as_sc_mcu7t3v3__fillcap_4
X_3045_ VDD VDD VSS VSS _3045_/A _3045_/B _3045_/C _3045_/D _3047_/C gf180mcu_as_sc_mcu7t3v3__ao211_2
XFILLER_149_1442 VDD VDD VSS VSS gf180mcu_as_sc_mcu7t3v3__fill_2
XFILLER_36_552 VDD VDD VSS VSS gf180mcu_as_sc_mcu7t3v3__fill_1
XFILLER_149_1453 VDD VDD VSS VSS gf180mcu_as_sc_mcu7t3v3__fillcap_8
XFILLER_149_1475 VDD VDD VSS VSS gf180mcu_as_sc_mcu7t3v3__fillcap_8
XFILLER_208_193 VDD VDD VSS VSS gf180mcu_as_sc_mcu7t3v3__fill_2
XFILLER_36_596 VDD VDD VSS VSS gf180mcu_as_sc_mcu7t3v3__fillcap_16
XTAP_TAPCELL_ROW_82_3_2968 VDD VSS gf180mcu_as_sc_mcu7t3v3__tap_2
XFILLER_149_1497 VDD VDD VSS VSS gf180mcu_as_sc_mcu7t3v3__fillcap_8
XFILLER_196_505 VDD VDD VSS VSS gf180mcu_as_sc_mcu7t3v3__fillcap_16
XFILLER_196_527 VDD VDD VSS VSS gf180mcu_as_sc_mcu7t3v3__fillcap_16
XFILLER_23_235 VDD VDD VSS VSS gf180mcu_as_sc_mcu7t3v3__fill_1
X_4996_ VDD VDD VSS VSS clkload5/A _4996_/D _4996_/Q gf180mcu_as_sc_mcu7t3v3__dfxtp_2
XFILLER_177_730 VDD VDD VSS VSS gf180mcu_as_sc_mcu7t3v3__fillcap_4
XFILLER_23_27 VDD VDD VSS VSS gf180mcu_as_sc_mcu7t3v3__fillcap_16
XFILLER_23_279 VDD VDD VSS VSS gf180mcu_as_sc_mcu7t3v3__fill_1
X_3947_ VDD VDD VSS VSS _3947_/A _4032_/C _4030_/B _3947_/D _3948_/D gf180mcu_as_sc_mcu7t3v3__ao22_2
XFILLER_139_27 VDD VDD VSS VSS gf180mcu_as_sc_mcu7t3v3__fillcap_16
XFILLER_71_1558 VDD VDD VSS VSS gf180mcu_as_sc_mcu7t3v3__fillcap_8
XTAP_TAPCELL_ROW_24_1256 VDD VSS gf180mcu_as_sc_mcu7t3v3__tap_2
X_3878_ VDD VDD VSS VSS _3893_/B _5168_/Q _4918_/D gf180mcu_as_sc_mcu7t3v3__and2_2
XTAP_TAPCELL_ROW_24_1267 VDD VSS gf180mcu_as_sc_mcu7t3v3__tap_2
XFILLER_191_243 VDD VDD VSS VSS gf180mcu_as_sc_mcu7t3v3__fillcap_16
X_2829_ VDD VDD VSS VSS _4975_/D _2829_/B _5284_/Q _5283_/D gf180mcu_as_sc_mcu7t3v3__mux2_2
XFILLER_121_1383 VDD VDD VSS VSS gf180mcu_as_sc_mcu7t3v3__fill_1
XFILLER_30_1255 VDD VDD VSS VSS gf180mcu_as_sc_mcu7t3v3__fill_2
XFILLER_69_1443 VDD VDD VSS VSS gf180mcu_as_sc_mcu7t3v3__fillcap_16
XFILLER_191_1326 VDD VDD VSS VSS gf180mcu_as_sc_mcu7t3v3__fillcap_4
X_5479_ VDD VDD VSS VSS _5479_/A _5479_/Y gf180mcu_as_sc_mcu7t3v3__buff_2
XFILLER_28_1151 VDD VDD VSS VSS gf180mcu_as_sc_mcu7t3v3__fillcap_4
Xfanout487 VDD VDD VSS VSS _3560_/Y _3730_/A gf180mcu_as_sc_mcu7t3v3__buff_12
XFILLER_104_85 VDD VDD VSS VSS gf180mcu_as_sc_mcu7t3v3__fillcap_16
XFILLER_76_1414 VDD VDD VSS VSS gf180mcu_as_sc_mcu7t3v3__fillcap_4
XTAP_TAPCELL_ROW_202_2621 VDD VSS gf180mcu_as_sc_mcu7t3v3__tap_2
XTAP_TAPCELL_ROW_202_2610 VDD VSS gf180mcu_as_sc_mcu7t3v3__tap_2
XFILLER_15_714 VDD VDD VSS VSS gf180mcu_as_sc_mcu7t3v3__fill_2
XFILLER_203_804 VDD VDD VSS VSS gf180mcu_as_sc_mcu7t3v3__fillcap_16
XFILLER_14_224 VDD VDD VSS VSS gf180mcu_as_sc_mcu7t3v3__fill_1
XFILLER_154_2 VDD VDD VSS VSS gf180mcu_as_sc_mcu7t3v3__fillcap_16
XFILLER_76_1469 VDD VDD VSS VSS gf180mcu_as_sc_mcu7t3v3__fillcap_16
XFILLER_30_739 VDD VDD VSS VSS gf180mcu_as_sc_mcu7t3v3__fill_1
XFILLER_35_1122 VDD VDD VSS VSS gf180mcu_as_sc_mcu7t3v3__fillcap_16
XTAP_TAPCELL_ROW_194_2444 VDD VSS gf180mcu_as_sc_mcu7t3v3__tap_2
XTAP_TAPCELL_ROW_194_2433 VDD VSS gf180mcu_as_sc_mcu7t3v3__tap_2
XFILLER_11_942 VDD VDD VSS VSS gf180mcu_as_sc_mcu7t3v3__fill_1
XFILLER_196_22 VDD VDD VSS VSS gf180mcu_as_sc_mcu7t3v3__fillcap_8
XTAP_TAPCELL_ROW_97_1_1735 VDD VSS gf180mcu_as_sc_mcu7t3v3__tap_2
XFILLER_127_104 VDD VDD VSS VSS gf180mcu_as_sc_mcu7t3v3__fillcap_8
XFILLER_204_1469 VDD VDD VSS VSS gf180mcu_as_sc_mcu7t3v3__fillcap_16
XFILLER_210_380 VDD VDD VSS VSS gf180mcu_as_sc_mcu7t3v3__fill_2
XFILLER_35_1188 VDD VDD VSS VSS gf180mcu_as_sc_mcu7t3v3__fill_2
XFILLER_80_77 VDD VDD VSS VSS gf180mcu_as_sc_mcu7t3v3__fillcap_4
Xwire833 VDD VDD VSS VSS wire833/A _3925_/A gf180mcu_as_sc_mcu7t3v3__clkbuff_12
XFILLER_7_968 VDD VDD VSS VSS gf180mcu_as_sc_mcu7t3v3__fillcap_4
Xwire844 VDD VDD VSS VSS wire844/A _4145_/A gf180mcu_as_sc_mcu7t3v3__clkbuff_12
Xwire855 VDD VDD VSS VSS wire855/A _4040_/A gf180mcu_as_sc_mcu7t3v3__clkbuff_12
Xwire866 VDD VDD VSS VSS wire866/A _4009_/A gf180mcu_as_sc_mcu7t3v3__clkbuff_12
Xwire877 VDD VDD VSS VSS wire877/A _4066_/A gf180mcu_as_sc_mcu7t3v3__clkbuff_12
XFILLER_129_82 VDD VDD VSS VSS gf180mcu_as_sc_mcu7t3v3__fill_1
XFILLER_142_107 VDD VDD VSS VSS gf180mcu_as_sc_mcu7t3v3__fillcap_8
XFILLER_183_788 VDD VDD VSS VSS gf180mcu_as_sc_mcu7t3v3__fillcap_16
XFILLER_196_1259 VDD VDD VSS VSS gf180mcu_as_sc_mcu7t3v3__fillcap_16
XFILLER_89_42 VDD VDD VSS VSS gf180mcu_as_sc_mcu7t3v3__fillcap_16
XFILLER_83_1418 VDD VDD VSS VSS gf180mcu_as_sc_mcu7t3v3__fillcap_16
XFILLER_87_1554 VDD VDD VSS VSS gf180mcu_as_sc_mcu7t3v3__fill_2
XFILLER_135_1519 VDD VDD VSS VSS gf180mcu_as_sc_mcu7t3v3__fillcap_8
XFILLER_150_140 VDD VDD VSS VSS gf180mcu_as_sc_mcu7t3v3__fill_1
XFILLER_174_1568 VDD VDD VSS VSS gf180mcu_as_sc_mcu7t3v3__fill_1
XTAP_TAPCELL_ROW_77_1_1677 VDD VSS gf180mcu_as_sc_mcu7t3v3__tap_2
XFILLER_49_110 VDD VDD VSS VSS gf180mcu_as_sc_mcu7t3v3__fill_1
XFILLER_111_1530 VDD VDD VSS VSS gf180mcu_as_sc_mcu7t3v3__fill_1
XFILLER_64_113 VDD VDD VSS VSS gf180mcu_as_sc_mcu7t3v3__fill_1
XFILLER_20_1424 VDD VDD VSS VSS gf180mcu_as_sc_mcu7t3v3__fillcap_8
Xclkbuf_2_3_0_clk_regs VDD VDD VSS VSS clkbuf_0_clk_regs/Y clkbuf_2_3_0_clk_regs/Y
+ gf180mcu_as_sc_mcu7t3v3__clkbuff_12
XFILLER_20_1479 VDD VDD VSS VSS gf180mcu_as_sc_mcu7t3v3__fillcap_4
XFILLER_33_500 VDD VDD VSS VSS gf180mcu_as_sc_mcu7t3v3__fillcap_4
XFILLER_205_174 VDD VDD VSS VSS gf180mcu_as_sc_mcu7t3v3__fillcap_16
X_4850_ VDD VDD VSS VSS _5241_/CLK _4850_/D _4850_/Q gf180mcu_as_sc_mcu7t3v3__dfxtp_2
XFILLER_178_527 VDD VDD VSS VSS gf180mcu_as_sc_mcu7t3v3__fillcap_16
X_3801_ VDD VDD VSS VSS _3801_/D _3801_/A _3801_/B _3801_/C _3802_/D gf180mcu_as_sc_mcu7t3v3__ao31_2
XFILLER_109_1470 VDD VDD VSS VSS gf180mcu_as_sc_mcu7t3v3__fillcap_16
XFILLER_14_791 VDD VDD VSS VSS gf180mcu_as_sc_mcu7t3v3__fillcap_8
XFILLER_18_1375 VDD VDD VSS VSS gf180mcu_as_sc_mcu7t3v3__fill_2
XFILLER_193_508 VDD VDD VSS VSS gf180mcu_as_sc_mcu7t3v3__fillcap_16
XFILLER_207_1060 VDD VDD VSS VSS gf180mcu_as_sc_mcu7t3v3__fill_1
XFILLER_33_599 VDD VDD VSS VSS gf180mcu_as_sc_mcu7t3v3__fillcap_16
X_4781_ VDD VDD VSS VSS _5142_/CLK _4781_/D _4781_/Q gf180mcu_as_sc_mcu7t3v3__dfxtp_2
XFILLER_118_104 VDD VDD VSS VSS gf180mcu_as_sc_mcu7t3v3__fill_1
XFILLER_13_290 VDD VDD VSS VSS gf180mcu_as_sc_mcu7t3v3__fillcap_4
XFILLER_144_1383 VDD VDD VSS VSS gf180mcu_as_sc_mcu7t3v3__fillcap_16
XFILLER_174_722 VDD VDD VSS VSS gf180mcu_as_sc_mcu7t3v3__fill_1
XFILLER_179_1402 VDD VDD VSS VSS gf180mcu_as_sc_mcu7t3v3__fillcap_16
X_3732_ VDD VDD VSS VSS _4113_/A _3749_/B _3740_/C _4112_/A _3733_/C gf180mcu_as_sc_mcu7t3v3__ao22_2
XFILLER_105_1378 VDD VDD VSS VSS gf180mcu_as_sc_mcu7t3v3__fill_1
XFILLER_186_593 VDD VDD VSS VSS gf180mcu_as_sc_mcu7t3v3__fill_2
XTAP_TAPCELL_ROW_12_992 VDD VSS gf180mcu_as_sc_mcu7t3v3__tap_2
Xclkload20 VDD VDD VSS VSS _5241_/CLK clkload20/Y gf180mcu_as_sc_mcu7t3v3__clkbuff_4
X_3663_ VDD VDD VSS VSS _3664_/C _4037_/D _3725_/B _3663_/C gf180mcu_as_sc_mcu7t3v3__ao21_2
X_2614_ VDD VDD VSS VSS _2883_/B _2614_/B _2776_/A gf180mcu_as_sc_mcu7t3v3__nand2_2
XFILLER_177_1170 VDD VDD VSS VSS gf180mcu_as_sc_mcu7t3v3__fillcap_16
X_3594_ VDD VDD VSS VSS _3962_/A _3608_/B _3594_/C _3594_/Y _3594_/D gf180mcu_as_sc_mcu7t3v3__aoi211_2
XFILLER_177_1192 VDD VDD VSS VSS gf180mcu_as_sc_mcu7t3v3__fillcap_8
X_2545_ VDD VDD VSS VSS _5125_/Q _2545_/B _4328_/A _2745_/B _2545_/D gf180mcu_as_sc_mcu7t3v3__aoi31_2
X_5264_ VDD VDD VSS VSS _5280_/CLK _5264_/D _5264_/Q gf180mcu_as_sc_mcu7t3v3__dfxtp_2
X_2476_ VDD VDD VSS VSS _2476_/B _3907_/A _4951_/D gf180mcu_as_sc_mcu7t3v3__and2_2
X_5195_ VDD VDD VSS VSS _5197_/CLK _5195_/D _5195_/Q gf180mcu_as_sc_mcu7t3v3__dfxtp_2
X_4215_ VDD VDD VSS VSS _4244_/B _4228_/B _4228_/C _5051_/Q _5051_/D gf180mcu_as_sc_mcu7t3v3__ao22_2
XFILLER_116_1463 VDD VDD VSS VSS gf180mcu_as_sc_mcu7t3v3__fillcap_16
X_4146_ VDD VDD VSS VSS _4146_/A _4162_/B _4160_/B _4146_/D _4147_/D gf180mcu_as_sc_mcu7t3v3__ao22_2
XFILLER_55_135 VDD VDD VSS VSS gf180mcu_as_sc_mcu7t3v3__fillcap_4
X_4077_ VDD VDD VSS VSS _4077_/A _4118_/B _4118_/C _4077_/D _4078_/D gf180mcu_as_sc_mcu7t3v3__ao22_2
X_3028_ VDD VDD VSS VSS _3129_/B _4924_/Q _3029_/D gf180mcu_as_sc_mcu7t3v3__or2_2
XFILLER_34_37 VDD VDD VSS VSS gf180mcu_as_sc_mcu7t3v3__fillcap_16
XTAP_TAPCELL_ROW_26_1307 VDD VSS gf180mcu_as_sc_mcu7t3v3__tap_2
XFILLER_12_728 VDD VDD VSS VSS gf180mcu_as_sc_mcu7t3v3__fillcap_4
XFILLER_196_335 VDD VDD VSS VSS gf180mcu_as_sc_mcu7t3v3__fillcap_16
XFILLER_197_836 VDD VDD VSS VSS gf180mcu_as_sc_mcu7t3v3__fillcap_4
XFILLER_197_858 VDD VDD VSS VSS gf180mcu_as_sc_mcu7t3v3__fillcap_16
XFILLER_200_807 VDD VDD VSS VSS gf180mcu_as_sc_mcu7t3v3__fillcap_8
Xsram2048.u_bank0_915 VDD VDD VSS VSS sram2048.u_bank0/WEN[5] gf180mcu_as_sc_mcu7t3v3__tiel_4
XFILLER_180_1049 VDD VDD VSS VSS gf180mcu_as_sc_mcu7t3v3__fillcap_16
XFILLER_36_1464 VDD VDD VSS VSS gf180mcu_as_sc_mcu7t3v3__fillcap_16
X_4979_ VDD VDD VSS VSS clkload5/A _4979_/D _4979_/Q gf180mcu_as_sc_mcu7t3v3__dfxtp_2
XFILLER_109_104 VDD VDD VSS VSS gf180mcu_as_sc_mcu7t3v3__fillcap_4
XFILLER_11_249 VDD VDD VSS VSS gf180mcu_as_sc_mcu7t3v3__fillcap_16
XFILLER_7_209 VDD VDD VSS VSS gf180mcu_as_sc_mcu7t3v3__fill_1
XTAP_TAPCELL_ROW_107_3_3042 VDD VSS gf180mcu_as_sc_mcu7t3v3__tap_2
Xclkload3 VDD VDD VSS VSS clkload3/Y clkload3/A gf180mcu_as_sc_mcu7t3v3__inv_6
XFILLER_123_1478 VDD VDD VSS VSS gf180mcu_as_sc_mcu7t3v3__fill_1
XFILLER_20_783 VDD VDD VSS VSS gf180mcu_as_sc_mcu7t3v3__fillcap_16
XFILLER_4_949 VDD VDD VSS VSS gf180mcu_as_sc_mcu7t3v3__fill_1
XPHY_EDGE_ROW_115_1_Left_325 VDD VSS gf180mcu_as_sc_mcu7t3v3__tap_2
XTAP_TAPCELL_ROW_187_2292 VDD VSS gf180mcu_as_sc_mcu7t3v3__tap_2
XTAP_TAPCELL_ROW_187_2281 VDD VSS gf180mcu_as_sc_mcu7t3v3__tap_2
XFILLER_82_1495 VDD VDD VSS VSS gf180mcu_as_sc_mcu7t3v3__fillcap_4
XFILLER_8_1075 VDD VDD VSS VSS gf180mcu_as_sc_mcu7t3v3__fill_1
XFILLER_130_1449 VDD VDD VSS VSS gf180mcu_as_sc_mcu7t3v3__fill_2
XFILLER_189_1030 VDD VDD VSS VSS gf180mcu_as_sc_mcu7t3v3__fillcap_16
XFILLER_208_918 VDD VDD VSS VSS gf180mcu_as_sc_mcu7t3v3__fill_2
XFILLER_78_1509 VDD VDD VSS VSS gf180mcu_as_sc_mcu7t3v3__fill_2
XTAP_TAPCELL_ROW_183_2189 VDD VSS gf180mcu_as_sc_mcu7t3v3__tap_2
XFILLER_189_1052 VDD VDD VSS VSS gf180mcu_as_sc_mcu7t3v3__fillcap_16
XTAP_TAPCELL_ROW_150_1_1895 VDD VSS gf180mcu_as_sc_mcu7t3v3__tap_2
XFILLER_131_50 VDD VDD VSS VSS gf180mcu_as_sc_mcu7t3v3__fillcap_16
XFILLER_131_83 VDD VDD VSS VSS gf180mcu_as_sc_mcu7t3v3__fillcap_16
XFILLER_61_138 VDD VDD VSS VSS gf180mcu_as_sc_mcu7t3v3__fill_2
XFILLER_91_10 VDD VDD VSS VSS gf180mcu_as_sc_mcu7t3v3__fillcap_4
XFILLER_180_1550 VDD VDD VSS VSS gf180mcu_as_sc_mcu7t3v3__fillcap_16
XFILLER_202_155 VDD VDD VSS VSS gf180mcu_as_sc_mcu7t3v3__fillcap_16
XFILLER_30_514 VDD VDD VSS VSS gf180mcu_as_sc_mcu7t3v3__fillcap_8
XFILLER_30_547 VDD VDD VSS VSS gf180mcu_as_sc_mcu7t3v3__fill_2
XFILLER_202_177 VDD VDD VSS VSS gf180mcu_as_sc_mcu7t3v3__fillcap_16
XFILLER_102_1518 VDD VDD VSS VSS gf180mcu_as_sc_mcu7t3v3__fill_2
XFILLER_11_772 VDD VDD VSS VSS gf180mcu_as_sc_mcu7t3v3__fillcap_16
XFILLER_200_1119 VDD VDD VSS VSS gf180mcu_as_sc_mcu7t3v3__fillcap_16
XFILLER_6_253 VDD VDD VSS VSS gf180mcu_as_sc_mcu7t3v3__fill_1
XFILLER_40_80 VDD VDD VSS VSS gf180mcu_as_sc_mcu7t3v3__fillcap_16
XFILLER_174_1310 VDD VDD VSS VSS gf180mcu_as_sc_mcu7t3v3__fillcap_16
XFILLER_123_151 VDD VDD VSS VSS gf180mcu_as_sc_mcu7t3v3__fillcap_16
XFILLER_139_1485 VDD VDD VSS VSS gf180mcu_as_sc_mcu7t3v3__fill_1
XFILLER_3_960 VDD VDD VSS VSS gf180mcu_as_sc_mcu7t3v3__fillcap_16
XFILLER_3_982 VDD VDD VSS VSS gf180mcu_as_sc_mcu7t3v3__fillcap_16
XPHY_EDGE_ROW_47_1_Left_257 VDD VSS gf180mcu_as_sc_mcu7t3v3__tap_2
XTAP_TAPCELL_ROW_133_3_3121 VDD VSS gf180mcu_as_sc_mcu7t3v3__tap_2
X_4882__1085 VDD VDD VSS VSS _4882_/D gf180mcu_as_sc_mcu7t3v3__tiel_4
X_4000_ VDD VDD VSS VSS _4000_/A _4130_/B _4128_/B _4000_/D _4001_/D gf180mcu_as_sc_mcu7t3v3__ao22_2
XFILLER_37_102 VDD VDD VSS VSS gf180mcu_as_sc_mcu7t3v3__fill_1
XFILLER_61_1568 VDD VDD VSS VSS gf180mcu_as_sc_mcu7t3v3__fill_1
XFILLER_20_1221 VDD VDD VSS VSS gf180mcu_as_sc_mcu7t3v3__fillcap_4
XFILLER_18_360 VDD VDD VSS VSS gf180mcu_as_sc_mcu7t3v3__fillcap_16
XFILLER_0_1359 VDD VDD VSS VSS gf180mcu_as_sc_mcu7t3v3__fill_1
XFILLER_185_1461 VDD VDD VSS VSS gf180mcu_as_sc_mcu7t3v3__fillcap_8
XFILLER_45_190 VDD VDD VSS VSS gf180mcu_as_sc_mcu7t3v3__fillcap_16
XPHY_EDGE_ROW_161_1_Left_371 VDD VSS gf180mcu_as_sc_mcu7t3v3__tap_2
X_4902_ VDD VDD VSS VSS _4904_/CLK _4902_/D _4902_/Q gf180mcu_as_sc_mcu7t3v3__dfxtp_2
XFILLER_181_1325 VDD VDD VSS VSS gf180mcu_as_sc_mcu7t3v3__fillcap_4
XFILLER_209_1155 VDD VDD VSS VSS gf180mcu_as_sc_mcu7t3v3__fillcap_16
XFILLER_33_352 VDD VDD VSS VSS gf180mcu_as_sc_mcu7t3v3__fillcap_16
XFILLER_107_1418 VDD VDD VSS VSS gf180mcu_as_sc_mcu7t3v3__fillcap_4
XFILLER_146_1467 VDD VDD VSS VSS gf180mcu_as_sc_mcu7t3v3__fill_1
XFILLER_94_1399 VDD VDD VSS VSS gf180mcu_as_sc_mcu7t3v3__fillcap_16
X_4833_ VDD VDD VSS VSS _5073_/CLK _4833_/D _4833_/Q gf180mcu_as_sc_mcu7t3v3__dfxtp_2
XFILLER_14_1014 VDD VDD VSS VSS gf180mcu_as_sc_mcu7t3v3__fill_1
XFILLER_194_839 VDD VDD VSS VSS gf180mcu_as_sc_mcu7t3v3__fillcap_16
XFILLER_21_558 VDD VDD VSS VSS gf180mcu_as_sc_mcu7t3v3__fill_2
X_4764_ VDD VDD VSS VSS _5241_/CLK _4764_/D _4764_/Q gf180mcu_as_sc_mcu7t3v3__dfxtp_2
XFILLER_146_221 VDD VDD VSS VSS gf180mcu_as_sc_mcu7t3v3__fill_1
XFILLER_174_541 VDD VDD VSS VSS gf180mcu_as_sc_mcu7t3v3__fill_2
XFILLER_193_349 VDD VDD VSS VSS gf180mcu_as_sc_mcu7t3v3__fill_1
X_3715_ VDD VDD VSS VSS _4858_/D _3715_/C _3758_/D _3715_/A gf180mcu_as_sc_mcu7t3v3__aoi21_2
XTAP_TAPCELL_ROW_77_3_2952 VDD VSS gf180mcu_as_sc_mcu7t3v3__tap_2
X_4695_ VDD VDD VSS VSS _4707_/S _5252_/Q _4695_/A _5252_/D gf180mcu_as_sc_mcu7t3v3__mux2_2
XFILLER_174_596 VDD VDD VSS VSS gf180mcu_as_sc_mcu7t3v3__fillcap_16
X_3646_ VDD VDD VSS VSS _3730_/D _3730_/A _3646_/B _3646_/C _3647_/C gf180mcu_as_sc_mcu7t3v3__ao31_2
XFILLER_1_908 VDD VDD VSS VSS gf180mcu_as_sc_mcu7t3v3__fill_2
XPHY_EDGE_ROW_137_3_Left_522 VDD VSS gf180mcu_as_sc_mcu7t3v3__tap_2
X_3577_ VDD VDD VSS VSS _3578_/C _3938_/A _3658_/B _3577_/C gf180mcu_as_sc_mcu7t3v3__ao21_2
XFILLER_0_418 VDD VDD VSS VSS gf180mcu_as_sc_mcu7t3v3__fillcap_4
XFILLER_192_1454 VDD VDD VSS VSS gf180mcu_as_sc_mcu7t3v3__fillcap_4
X_2528_ VDD VDD VSS VSS _4657_/B _5268_/Q _4643_/B gf180mcu_as_sc_mcu7t3v3__or2_2
XTAP_TAPCELL_ROW_19_1155 VDD VSS gf180mcu_as_sc_mcu7t3v3__tap_2
XTAP_TAPCELL_ROW_19_1144 VDD VSS gf180mcu_as_sc_mcu7t3v3__tap_2
XFILLER_153_1438 VDD VDD VSS VSS gf180mcu_as_sc_mcu7t3v3__fill_1
XPHY_EDGE_ROW_59_3_Right_96 VDD VSS gf180mcu_as_sc_mcu7t3v3__tap_2
X_5247_ VDD VDD VSS VSS _5262_/CLK _5247_/D _5247_/Q gf180mcu_as_sc_mcu7t3v3__dfxtp_2
Xinput308 VDD VDD VSS VSS west_in[32] _3520_/A gf180mcu_as_sc_mcu7t3v3__buff_12
XFILLER_152_27 VDD VDD VSS VSS gf180mcu_as_sc_mcu7t3v3__fillcap_8
X_2459_ VDD VDD VSS VSS _4952_/D _4353_/A _3869_/A _2474_/A gf180mcu_as_sc_mcu7t3v3__nand3_2
XFILLER_28_102 VDD VDD VSS VSS gf180mcu_as_sc_mcu7t3v3__fill_2
XFILLER_5_1226 VDD VDD VSS VSS gf180mcu_as_sc_mcu7t3v3__fill_2
X_5178_ VDD VDD VSS VSS clkload1/A _5178_/D _5178_/Q gf180mcu_as_sc_mcu7t3v3__dfxtp_2
XFILLER_25_1187 VDD VDD VSS VSS gf180mcu_as_sc_mcu7t3v3__fill_2
XFILLER_28_157 VDD VDD VSS VSS gf180mcu_as_sc_mcu7t3v3__fillcap_4
X_4129_ VDD VDD VSS VSS _4129_/A _4129_/B _4129_/C _4939_/Q _4130_/D gf180mcu_as_sc_mcu7t3v3__ao22_2
XTAP_TAPCELL_ROW_40_1_1564 VDD VSS gf180mcu_as_sc_mcu7t3v3__tap_2
XFILLER_25_853 VDD VDD VSS VSS gf180mcu_as_sc_mcu7t3v3__fillcap_16
XFILLER_43_138 VDD VDD VSS VSS gf180mcu_as_sc_mcu7t3v3__fill_2
XFILLER_45_69 VDD VDD VSS VSS gf180mcu_as_sc_mcu7t3v3__fill_1
XFILLER_164_1523 VDD VDD VSS VSS gf180mcu_as_sc_mcu7t3v3__fillcap_16
XFILLER_24_341 VDD VDD VSS VSS gf180mcu_as_sc_mcu7t3v3__fill_1
XFILLER_125_1518 VDD VDD VSS VSS gf180mcu_as_sc_mcu7t3v3__fillcap_8
XFILLER_205_1520 VDD VDD VSS VSS gf180mcu_as_sc_mcu7t3v3__fillcap_16
XFILLER_51_160 VDD VDD VSS VSS gf180mcu_as_sc_mcu7t3v3__fill_2
XFILLER_185_839 VDD VDD VSS VSS gf180mcu_as_sc_mcu7t3v3__fill_1
XFILLER_205_1542 VDD VDD VSS VSS gf180mcu_as_sc_mcu7t3v3__fillcap_16
XFILLER_61_35 VDD VDD VSS VSS gf180mcu_as_sc_mcu7t3v3__fillcap_16
XTAP_TAPCELL_ROW_126_1_1824 VDD VSS gf180mcu_as_sc_mcu7t3v3__tap_2
XFILLER_184_349 VDD VDD VSS VSS gf180mcu_as_sc_mcu7t3v3__fill_2
XFILLER_197_1310 VDD VDD VSS VSS gf180mcu_as_sc_mcu7t3v3__fillcap_16
XFILLER_36_1294 VDD VDD VSS VSS gf180mcu_as_sc_mcu7t3v3__fillcap_8
XTAP_TAPCELL_ROW_138_3_3136 VDD VSS gf180mcu_as_sc_mcu7t3v3__tap_2
XFILLER_197_1332 VDD VDD VSS VSS gf180mcu_as_sc_mcu7t3v3__fillcap_16
XPHY_EDGE_ROW_175_Left_385 VDD VSS gf180mcu_as_sc_mcu7t3v3__tap_2
XFILLER_192_382 VDD VDD VSS VSS gf180mcu_as_sc_mcu7t3v3__fill_2
XPHY_EDGE_ROW_69_3_Left_454 VDD VSS gf180mcu_as_sc_mcu7t3v3__tap_2
XTAP_TAPCELL_ROW_189_2321 VDD VSS gf180mcu_as_sc_mcu7t3v3__tap_2
XFILLER_101_1562 VDD VDD VSS VSS gf180mcu_as_sc_mcu7t3v3__fillcap_4
XFILLER_10_1445 VDD VDD VSS VSS gf180mcu_as_sc_mcu7t3v3__fill_1
XTAP_TAPCELL_ROW_189_2332 VDD VSS gf180mcu_as_sc_mcu7t3v3__tap_2
XFILLER_171_1505 VDD VDD VSS VSS gf180mcu_as_sc_mcu7t3v3__fill_1
XFILLER_84_1568 VDD VDD VSS VSS gf180mcu_as_sc_mcu7t3v3__fill_1
XFILLER_0_941 VDD VDD VSS VSS gf180mcu_as_sc_mcu7t3v3__fillcap_4
XFILLER_171_1549 VDD VDD VSS VSS gf180mcu_as_sc_mcu7t3v3__fillcap_4
XTAP_TAPCELL_ROW_210_2797 VDD VSS gf180mcu_as_sc_mcu7t3v3__tap_2
XTAP_TAPCELL_ROW_210_2786 VDD VSS gf180mcu_as_sc_mcu7t3v3__tap_2
XFILLER_208_715 VDD VDD VSS VSS gf180mcu_as_sc_mcu7t3v3__fillcap_16
XFILLER_169_1412 VDD VDD VSS VSS gf180mcu_as_sc_mcu7t3v3__fillcap_4
XFILLER_169_1434 VDD VDD VSS VSS gf180mcu_as_sc_mcu7t3v3__fillcap_16
XFILLER_19_135 VDD VDD VSS VSS gf180mcu_as_sc_mcu7t3v3__fillcap_4
XFILLER_208_737 VDD VDD VSS VSS gf180mcu_as_sc_mcu7t3v3__fillcap_16
XPHY_EDGE_ROW_184_Left_394 VDD VSS gf180mcu_as_sc_mcu7t3v3__tap_2
XTAP_TAPCELL_ROW_3_790 VDD VSS gf180mcu_as_sc_mcu7t3v3__tap_2
XFILLER_207_269 VDD VDD VSS VSS gf180mcu_as_sc_mcu7t3v3__fillcap_8
XFILLER_15_352 VDD VDD VSS VSS gf180mcu_as_sc_mcu7t3v3__fillcap_16
XFILLER_15_374 VDD VDD VSS VSS gf180mcu_as_sc_mcu7t3v3__fill_1
XFILLER_176_839 VDD VDD VSS VSS gf180mcu_as_sc_mcu7t3v3__fillcap_8
XFILLER_188_699 VDD VDD VSS VSS gf180mcu_as_sc_mcu7t3v3__fillcap_16
XFILLER_203_486 VDD VDD VSS VSS gf180mcu_as_sc_mcu7t3v3__fillcap_4
XFILLER_30_333 VDD VDD VSS VSS gf180mcu_as_sc_mcu7t3v3__fillcap_16
XFILLER_175_349 VDD VDD VSS VSS gf180mcu_as_sc_mcu7t3v3__fill_1
X_3500_ VDD VDD VSS VSS _3500_/B _4161_/A _3502_/C gf180mcu_as_sc_mcu7t3v3__and2_2
XTAP_TAPCELL_ROW_174_1977 VDD VSS gf180mcu_as_sc_mcu7t3v3__tap_2
XTAP_TAPCELL_ROW_174_1966 VDD VSS gf180mcu_as_sc_mcu7t3v3__tap_2
XFILLER_167_90 VDD VDD VSS VSS gf180mcu_as_sc_mcu7t3v3__fillcap_8
XFILLER_176_1427 VDD VDD VSS VSS gf180mcu_as_sc_mcu7t3v3__fillcap_8
Xwire493 VDD VDD VSS VSS wire494/Y _4786_/D gf180mcu_as_sc_mcu7t3v3__clkbuff_12
Xwire471 VDD VDD VSS VSS _3587_/Y _4841_/D gf180mcu_as_sc_mcu7t3v3__clkbuff_12
X_4480_ VDD VDD VSS VSS _4480_/B _4497_/A _4486_/C gf180mcu_as_sc_mcu7t3v3__and2_2
XTAP_TAPCELL_ROW_174_1999 VDD VSS gf180mcu_as_sc_mcu7t3v3__tap_2
XTAP_TAPCELL_ROW_174_1988 VDD VSS gf180mcu_as_sc_mcu7t3v3__tap_2
X_3431_ VDD VDD VSS VSS _3455_/B _3431_/B _3431_/C _3432_/C gf180mcu_as_sc_mcu7t3v3__nor3_2
XFILLER_174_1140 VDD VDD VSS VSS gf180mcu_as_sc_mcu7t3v3__fillcap_16
X_3362_ VDD VDD VSS VSS _4925_/Q _3448_/B _3448_/C _4014_/A _3363_/A gf180mcu_as_sc_mcu7t3v3__ao22_2
XTAP_TAPCELL_ROW_45_1_1579 VDD VSS gf180mcu_as_sc_mcu7t3v3__tap_2
X_5101_ VDD VDD VSS VSS _5260_/CLK _5101_/D _5101_/Q gf180mcu_as_sc_mcu7t3v3__dfxtp_2
X_3293_ VDD VDD VSS VSS _3938_/A _3381_/S _3382_/B _3939_/A _3294_/D gf180mcu_as_sc_mcu7t3v3__ao22_2
XTAP_TAPCELL_ROW_14_1030 VDD VSS gf180mcu_as_sc_mcu7t3v3__tap_2
XTAP_TAPCELL_ROW_14_1041 VDD VSS gf180mcu_as_sc_mcu7t3v3__tap_2
X_5032_ VDD VDD VSS VSS _5090_/CLK _5032_/D _5032_/Q gf180mcu_as_sc_mcu7t3v3__dfxtp_2
XFILLER_152_1493 VDD VDD VSS VSS gf180mcu_as_sc_mcu7t3v3__fill_2
XFILLER_61_1387 VDD VDD VSS VSS gf180mcu_as_sc_mcu7t3v3__fillcap_8
XFILLER_0_1101 VDD VDD VSS VSS gf180mcu_as_sc_mcu7t3v3__fillcap_4
XFILLER_113_1488 VDD VDD VSS VSS gf180mcu_as_sc_mcu7t3v3__fill_2
XTAP_TAPCELL_ROW_1_749 VDD VSS gf180mcu_as_sc_mcu7t3v3__tap_2
XFILLER_202_30 VDD VDD VSS VSS gf180mcu_as_sc_mcu7t3v3__fillcap_4
XFILLER_181_1100 VDD VDD VSS VSS gf180mcu_as_sc_mcu7t3v3__fillcap_16
XFILLER_202_85 VDD VDD VSS VSS gf180mcu_as_sc_mcu7t3v3__fillcap_16
XFILLER_22_801 VDD VDD VSS VSS gf180mcu_as_sc_mcu7t3v3__fillcap_4
XFILLER_34_650 VDD VDD VSS VSS gf180mcu_as_sc_mcu7t3v3__fillcap_8
XFILLER_0_1189 VDD VDD VSS VSS gf180mcu_as_sc_mcu7t3v3__fill_1
XFILLER_181_1122 VDD VDD VSS VSS gf180mcu_as_sc_mcu7t3v3__fillcap_16
XFILLER_22_823 VDD VDD VSS VSS gf180mcu_as_sc_mcu7t3v3__fillcap_16
X_4816_ VDD VDD VSS VSS _5068_/CLK _4816_/D _4816_/Q gf180mcu_as_sc_mcu7t3v3__dfxtp_2
XTAP_TAPCELL_ROW_98_1_1740 VDD VSS gf180mcu_as_sc_mcu7t3v3__tap_2
XFILLER_210_979 VDD VDD VSS VSS gf180mcu_as_sc_mcu7t3v3__fillcap_4
XFILLER_33_1434 VDD VDD VSS VSS gf180mcu_as_sc_mcu7t3v3__fillcap_16
XFILLER_175_850 VDD VDD VSS VSS gf180mcu_as_sc_mcu7t3v3__fillcap_4
X_4747_ VDD VDD VSS VSS _5276_/Q _4750_/B _4747_/C _4747_/D _5276_/D gf180mcu_as_sc_mcu7t3v3__ao22_2
XFILLER_120_1437 VDD VDD VSS VSS gf180mcu_as_sc_mcu7t3v3__fillcap_8
XFILLER_147_27 VDD VDD VSS VSS gf180mcu_as_sc_mcu7t3v3__fillcap_16
X_4678_ VDD VDD VSS VSS _5246_/D _5100_/Q _4731_/B _4678_/C gf180mcu_as_sc_mcu7t3v3__ao21_2
XFILLER_179_1084 VDD VDD VSS VSS gf180mcu_as_sc_mcu7t3v3__fillcap_16
X_3629_ VDD VDD VSS VSS _3998_/A _3726_/B _3629_/C _3758_/D _3630_/C gf180mcu_as_sc_mcu7t3v3__ao211_2
Xinput105 VDD VDD VSS VSS ne_in[3] wire908/A gf180mcu_as_sc_mcu7t3v3__buff_12
Xinput116 VDD VDD VSS VSS north_in[13] _4039_/A gf180mcu_as_sc_mcu7t3v3__buff_12
Xinput127 VDD VDD VSS VSS north_in[23] _4120_/A gf180mcu_as_sc_mcu7t3v3__buff_12
XFILLER_193_6 VDD VDD VSS VSS gf180mcu_as_sc_mcu7t3v3__fillcap_16
XFILLER_29_400 VDD VDD VSS VSS gf180mcu_as_sc_mcu7t3v3__fillcap_16
XFILLER_29_422 VDD VDD VSS VSS gf180mcu_as_sc_mcu7t3v3__fillcap_16
XFILLER_9_1192 VDD VDD VSS VSS gf180mcu_as_sc_mcu7t3v3__fillcap_16
Xinput138 VDD VDD VSS VSS north_in[33] _3534_/A gf180mcu_as_sc_mcu7t3v3__buff_12
Xinput149 VDD VDD VSS VSS nw_in[12] _4032_/A gf180mcu_as_sc_mcu7t3v3__buff_12
XTAP_TAPCELL_ROW_180_2137 VDD VSS gf180mcu_as_sc_mcu7t3v3__tap_2
XTAP_TAPCELL_ROW_180_2126 VDD VSS gf180mcu_as_sc_mcu7t3v3__tap_2
XFILLER_131_1566 VDD VDD VSS VSS gf180mcu_as_sc_mcu7t3v3__fill_2
XFILLER_186_1011 VDD VDD VSS VSS gf180mcu_as_sc_mcu7t3v3__fillcap_4
XFILLER_186_1033 VDD VDD VSS VSS gf180mcu_as_sc_mcu7t3v3__fillcap_16
XTAP_TAPCELL_ROW_71_1_1658 VDD VSS gf180mcu_as_sc_mcu7t3v3__tap_2
XFILLER_112_52 VDD VDD VSS VSS gf180mcu_as_sc_mcu7t3v3__fill_1
XFILLER_205_718 VDD VDD VSS VSS gf180mcu_as_sc_mcu7t3v3__fillcap_16
XFILLER_189_419 VDD VDD VSS VSS gf180mcu_as_sc_mcu7t3v3__fill_1
XFILLER_12_311 VDD VDD VSS VSS gf180mcu_as_sc_mcu7t3v3__fillcap_4
XFILLER_164_1364 VDD VDD VSS VSS gf180mcu_as_sc_mcu7t3v3__fill_2
XFILLER_169_110 VDD VDD VSS VSS gf180mcu_as_sc_mcu7t3v3__fillcap_16
XFILLER_188_34 VDD VDD VSS VSS gf180mcu_as_sc_mcu7t3v3__fill_1
XFILLER_197_430 VDD VDD VSS VSS gf180mcu_as_sc_mcu7t3v3__fillcap_4
XFILLER_125_1348 VDD VDD VSS VSS gf180mcu_as_sc_mcu7t3v3__fillcap_16
XFILLER_24_193 VDD VDD VSS VSS gf180mcu_as_sc_mcu7t3v3__fillcap_16
Xclkbuf_leaf_5_clk_regs VDD VDD VSS VSS clkbuf_leaf_9_clk_regs/A _5216_/CLK gf180mcu_as_sc_mcu7t3v3__clkbuff_12
XTAP_TAPCELL_ROW_178_2099 VDD VSS gf180mcu_as_sc_mcu7t3v3__tap_2
XTAP_TAPCELL_ROW_178_2088 VDD VSS gf180mcu_as_sc_mcu7t3v3__tap_2
XFILLER_169_198 VDD VDD VSS VSS gf180mcu_as_sc_mcu7t3v3__fill_1
XTAP_TAPCELL_ROW_157_3_3191 VDD VSS gf180mcu_as_sc_mcu7t3v3__tap_2
XFILLER_12_1507 VDD VDD VSS VSS gf180mcu_as_sc_mcu7t3v3__fillcap_16
XFILLER_184_157 VDD VDD VSS VSS gf180mcu_as_sc_mcu7t3v3__fillcap_4
XFILLER_200_489 VDD VDD VSS VSS gf180mcu_as_sc_mcu7t3v3__fillcap_16
XFILLER_181_820 VDD VDD VSS VSS gf180mcu_as_sc_mcu7t3v3__fillcap_4
XFILLER_181_831 VDD VDD VSS VSS gf180mcu_as_sc_mcu7t3v3__fillcap_8
XFILLER_193_680 VDD VDD VSS VSS gf180mcu_as_sc_mcu7t3v3__fillcap_16
XFILLER_181_842 VDD VDD VSS VSS gf180mcu_as_sc_mcu7t3v3__fillcap_8
XFILLER_10_1286 VDD VDD VSS VSS gf180mcu_as_sc_mcu7t3v3__fillcap_8
XFILLER_10_1297 VDD VDD VSS VSS gf180mcu_as_sc_mcu7t3v3__fillcap_4
XFILLER_49_1485 VDD VDD VSS VSS gf180mcu_as_sc_mcu7t3v3__fill_1
XPHY_EDGE_ROW_192_Left_402 VDD VSS gf180mcu_as_sc_mcu7t3v3__tap_2
XFILLER_153_92 VDD VDD VSS VSS gf180mcu_as_sc_mcu7t3v3__fillcap_4
XFILLER_35_403 VDD VDD VSS VSS gf180mcu_as_sc_mcu7t3v3__fillcap_16
XFILLER_35_447 VDD VDD VSS VSS gf180mcu_as_sc_mcu7t3v3__fillcap_16
XFILLER_1_1465 VDD VDD VSS VSS gf180mcu_as_sc_mcu7t3v3__fillcap_4
XFILLER_95_1461 VDD VDD VSS VSS gf180mcu_as_sc_mcu7t3v3__fillcap_8
X_3980_ VDD VDD VSS VSS _4983_/Q _4158_/B _4234_/B _4117_/D _4983_/D gf180mcu_as_sc_mcu7t3v3__ao22_2
XFILLER_16_683 VDD VDD VSS VSS gf180mcu_as_sc_mcu7t3v3__fillcap_16
XFILLER_206_1103 VDD VDD VSS VSS gf180mcu_as_sc_mcu7t3v3__fillcap_16
XFILLER_22_119 VDD VDD VSS VSS gf180mcu_as_sc_mcu7t3v3__fill_1
XFILLER_95_1483 VDD VDD VSS VSS gf180mcu_as_sc_mcu7t3v3__fill_2
X_2931_ VDD VDD VSS VSS _2931_/Y _3223_/C _3222_/D gf180mcu_as_sc_mcu7t3v3__nor2_2
XFILLER_143_1415 VDD VDD VSS VSS gf180mcu_as_sc_mcu7t3v3__fill_1
XFILLER_94_4 VDD VDD VSS VSS gf180mcu_as_sc_mcu7t3v3__fill_1
Xclkbuf_0_clk VDD VDD VSS VSS clkbuf_0_clk/A clkbuf_0_clk/Y gf180mcu_as_sc_mcu7t3v3__clkbuff_12
XFILLER_108_1568 VDD VDD VSS VSS gf180mcu_as_sc_mcu7t3v3__fill_1
XFILLER_175_124 VDD VDD VSS VSS gf180mcu_as_sc_mcu7t3v3__fill_2
X_4601_ VDD VDD VSS VSS _5195_/Q _4750_/D _4601_/C _5196_/Q _5195_/D gf180mcu_as_sc_mcu7t3v3__ao22_2
X_2862_ VDD VDD VSS VSS _4763_/Q _4742_/A _2871_/B _4763_/D gf180mcu_as_sc_mcu7t3v3__nor3_2
XFILLER_30_185 VDD VDD VSS VSS gf180mcu_as_sc_mcu7t3v3__fillcap_4
XFILLER_30_196 VDD VDD VSS VSS gf180mcu_as_sc_mcu7t3v3__fillcap_16
X_2793_ VDD VDD VSS VSS _2793_/B _2876_/B _2796_/C gf180mcu_as_sc_mcu7t3v3__and2_2
XFILLER_11_1017 VDD VDD VSS VSS gf180mcu_as_sc_mcu7t3v3__fillcap_16
XFILLER_8_871 VDD VDD VSS VSS gf180mcu_as_sc_mcu7t3v3__fillcap_4
X_4532_ VDD VDD VSS VSS _5183_/Q _4575_/B _4532_/C _5101_/Q _4533_/B gf180mcu_as_sc_mcu7t3v3__ao22_2
XFILLER_176_1224 VDD VDD VSS VSS gf180mcu_as_sc_mcu7t3v3__fill_1
X_4463_ VDD VDD VSS VSS _4509_/S _5016_/Q _5045_/Q _4464_/B gf180mcu_as_sc_mcu7t3v3__mux2_2
XFILLER_176_1279 VDD VDD VSS VSS gf180mcu_as_sc_mcu7t3v3__fill_1
X_3414_ VDD VDD VSS VSS _4064_/A _3467_/C _3445_/C _4066_/A _3415_/C gf180mcu_as_sc_mcu7t3v3__ao22_2
XPHY_EDGE_ROW_15_Right_15 VDD VSS gf180mcu_as_sc_mcu7t3v3__tap_2
XTAP_TAPCELL_ROW_101_3_3023 VDD VSS gf180mcu_as_sc_mcu7t3v3__tap_2
Xfanout806 VDD VDD VSS VSS fanout809/Y _4483_/S gf180mcu_as_sc_mcu7t3v3__buff_12
X_4394_ VDD VDD VSS VSS _4394_/D _4546_/A _4394_/B _4394_/C _4395_/B gf180mcu_as_sc_mcu7t3v3__ao31_2
XFILLER_63_1438 VDD VDD VSS VSS gf180mcu_as_sc_mcu7t3v3__fillcap_4
X_3345_ VDD VDD VSS VSS _4923_/Q _3448_/B _3465_/C _3999_/A _3347_/C gf180mcu_as_sc_mcu7t3v3__ao22_2
X_3276_ VDD VDD VSS VSS _3814_/B _3280_/B _3553_/A gf180mcu_as_sc_mcu7t3v3__nand2_2
XFILLER_26_1282 VDD VDD VSS VSS gf180mcu_as_sc_mcu7t3v3__fillcap_8
X_5015_ VDD VDD VSS VSS _5082_/CLK _5015_/D _5015_/Q gf180mcu_as_sc_mcu7t3v3__dfxtp_2
XTAP_TAPCELL_ROW_33_1461 VDD VSS gf180mcu_as_sc_mcu7t3v3__tap_2
XTAP_TAPCELL_ROW_33_1450 VDD VSS gf180mcu_as_sc_mcu7t3v3__tap_2
XFILLER_22_1157 VDD VDD VSS VSS gf180mcu_as_sc_mcu7t3v3__fillcap_16
XFILLER_26_403 VDD VDD VSS VSS gf180mcu_as_sc_mcu7t3v3__fillcap_8
XFILLER_27_904 VDD VDD VSS VSS gf180mcu_as_sc_mcu7t3v3__fillcap_4
XFILLER_6_1398 VDD VDD VSS VSS gf180mcu_as_sc_mcu7t3v3__fill_1
XFILLER_26_27 VDD VDD VSS VSS gf180mcu_as_sc_mcu7t3v3__fillcap_8
XPHY_EDGE_ROW_24_Right_24 VDD VSS gf180mcu_as_sc_mcu7t3v3__tap_2
XFILLER_179_430 VDD VDD VSS VSS gf180mcu_as_sc_mcu7t3v3__fill_1
XFILLER_195_912 VDD VDD VSS VSS gf180mcu_as_sc_mcu7t3v3__fillcap_16
XFILLER_22_642 VDD VDD VSS VSS gf180mcu_as_sc_mcu7t3v3__fill_2
XFILLER_10_804 VDD VDD VSS VSS gf180mcu_as_sc_mcu7t3v3__fill_1
XFILLER_202_1501 VDD VDD VSS VSS gf180mcu_as_sc_mcu7t3v3__fillcap_4
XFILLER_210_765 VDD VDD VSS VSS gf180mcu_as_sc_mcu7t3v3__fillcap_4
XFILLER_42_37 VDD VDD VSS VSS gf180mcu_as_sc_mcu7t3v3__fillcap_8
XPHY_EDGE_ROW_124_1_Left_334 VDD VSS gf180mcu_as_sc_mcu7t3v3__tap_2
XFILLER_10_859 VDD VDD VSS VSS gf180mcu_as_sc_mcu7t3v3__fill_2
XFILLER_158_37 VDD VDD VSS VSS gf180mcu_as_sc_mcu7t3v3__fillcap_16
XFILLER_202_1523 VDD VDD VSS VSS gf180mcu_as_sc_mcu7t3v3__fillcap_16
XFILLER_159_1400 VDD VDD VSS VSS gf180mcu_as_sc_mcu7t3v3__fill_2
XFILLER_159_1422 VDD VDD VSS VSS gf180mcu_as_sc_mcu7t3v3__fill_2
XFILLER_194_1313 VDD VDD VSS VSS gf180mcu_as_sc_mcu7t3v3__fillcap_16
XFILLER_159_1488 VDD VDD VSS VSS gf180mcu_as_sc_mcu7t3v3__fill_1
XFILLER_174_36 VDD VDD VSS VSS gf180mcu_as_sc_mcu7t3v3__fillcap_16
XFILLER_190_661 VDD VDD VSS VSS gf180mcu_as_sc_mcu7t3v3__fillcap_4
XFILLER_190_683 VDD VDD VSS VSS gf180mcu_as_sc_mcu7t3v3__fillcap_16
XFILLER_200_1291 VDD VDD VSS VSS gf180mcu_as_sc_mcu7t3v3__fillcap_4
XPHY_EDGE_ROW_33_Right_33 VDD VSS gf180mcu_as_sc_mcu7t3v3__tap_2
Xmax_cap590 VDD VDD VSS VSS _3124_/B _3181_/A gf180mcu_as_sc_mcu7t3v3__clkbuff_12
XFILLER_107_63 VDD VDD VSS VSS gf180mcu_as_sc_mcu7t3v3__fillcap_4
XFILLER_192_1081 VDD VDD VSS VSS gf180mcu_as_sc_mcu7t3v3__fillcap_4
XFILLER_1_557 VDD VDD VSS VSS gf180mcu_as_sc_mcu7t3v3__fill_2
XFILLER_7_1118 VDD VDD VSS VSS gf180mcu_as_sc_mcu7t3v3__fill_2
XFILLER_88_174 VDD VDD VSS VSS gf180mcu_as_sc_mcu7t3v3__fill_1
XTAP_TAPCELL_ROW_5_841 VDD VSS gf180mcu_as_sc_mcu7t3v3__tap_2
XTAP_TAPCELL_ROW_5_830 VDD VSS gf180mcu_as_sc_mcu7t3v3__tap_2
XFILLER_184_2 VDD VDD VSS VSS gf180mcu_as_sc_mcu7t3v3__fillcap_16
XFILLER_18_904 VDD VDD VSS VSS gf180mcu_as_sc_mcu7t3v3__fill_1
XFILLER_123_95 VDD VDD VSS VSS gf180mcu_as_sc_mcu7t3v3__fill_1
XFILLER_44_211 VDD VDD VSS VSS gf180mcu_as_sc_mcu7t3v3__fillcap_8
XFILLER_79_1434 VDD VDD VSS VSS gf180mcu_as_sc_mcu7t3v3__fillcap_4
XTAP_TAPCELL_ROW_205_2674 VDD VSS gf180mcu_as_sc_mcu7t3v3__tap_2
XFILLER_166_1448 VDD VDD VSS VSS gf180mcu_as_sc_mcu7t3v3__fill_2
XFILLER_199_22 VDD VDD VSS VSS gf180mcu_as_sc_mcu7t3v3__fillcap_16
XTAP_TAPCELL_ROW_205_2685 VDD VSS gf180mcu_as_sc_mcu7t3v3__tap_2
XFILLER_83_88 VDD VDD VSS VSS gf180mcu_as_sc_mcu7t3v3__fillcap_16
XFILLER_199_88 VDD VDD VSS VSS gf180mcu_as_sc_mcu7t3v3__fillcap_16
XFILLER_207_1434 VDD VDD VSS VSS gf180mcu_as_sc_mcu7t3v3__fillcap_16
XPHY_EDGE_ROW_56_1_Left_266 VDD VSS gf180mcu_as_sc_mcu7t3v3__tap_2
XTAP_TAPCELL_ROW_197_2497 VDD VSS gf180mcu_as_sc_mcu7t3v3__tap_2
XFILLER_13_664 VDD VDD VSS VSS gf180mcu_as_sc_mcu7t3v3__fillcap_16
XFILLER_185_422 VDD VDD VSS VSS gf180mcu_as_sc_mcu7t3v3__fillcap_4
XFILLER_197_260 VDD VDD VSS VSS gf180mcu_as_sc_mcu7t3v3__fillcap_16
XFILLER_197_282 VDD VDD VSS VSS gf180mcu_as_sc_mcu7t3v3__fill_2
XFILLER_8_101 VDD VDD VSS VSS gf180mcu_as_sc_mcu7t3v3__fillcap_4
XFILLER_12_185 VDD VDD VSS VSS gf180mcu_as_sc_mcu7t3v3__fill_2
XFILLER_199_1224 VDD VDD VSS VSS gf180mcu_as_sc_mcu7t3v3__fillcap_16
XFILLER_8_123 VDD VDD VSS VSS gf180mcu_as_sc_mcu7t3v3__fillcap_16
XTAP_TAPCELL_ROW_106_3_3038 VDD VSS gf180mcu_as_sc_mcu7t3v3__tap_2
XFILLER_32_81 VDD VDD VSS VSS gf180mcu_as_sc_mcu7t3v3__fill_2
XFILLER_12_1359 VDD VDD VSS VSS gf180mcu_as_sc_mcu7t3v3__fillcap_4
XFILLER_172_127 VDD VDD VSS VSS gf180mcu_as_sc_mcu7t3v3__fill_1
XFILLER_86_1416 VDD VDD VSS VSS gf180mcu_as_sc_mcu7t3v3__fill_2
XFILLER_181_672 VDD VDD VSS VSS gf180mcu_as_sc_mcu7t3v3__fill_1
Xoutput409 VDD VDD VSS VSS _4829_/Q south_out[24] gf180mcu_as_sc_mcu7t3v3__buff_12
XFILLER_10_1083 VDD VDD VSS VSS gf180mcu_as_sc_mcu7t3v3__fill_2
XFILLER_180_171 VDD VDD VSS VSS gf180mcu_as_sc_mcu7t3v3__fillcap_4
XFILLER_5_885 VDD VDD VSS VSS gf180mcu_as_sc_mcu7t3v3__fillcap_16
XFILLER_180_193 VDD VDD VSS VSS gf180mcu_as_sc_mcu7t3v3__fillcap_16
XPHY_EDGE_ROW_170_1_Left_380 VDD VSS gf180mcu_as_sc_mcu7t3v3__tap_2
X_3130_ VDD VDD VSS VSS _4105_/A _3130_/B _3130_/C _3130_/D _3131_/C gf180mcu_as_sc_mcu7t3v3__ao22_2
XTAP_TAPCELL_ROW_71_3_2933 VDD VSS gf180mcu_as_sc_mcu7t3v3__tap_2
XFILLER_23_1422 VDD VDD VSS VSS gf180mcu_as_sc_mcu7t3v3__fill_2
XFILLER_62_1460 VDD VDD VSS VSS gf180mcu_as_sc_mcu7t3v3__fillcap_16
XFILLER_94_155 VDD VDD VSS VSS gf180mcu_as_sc_mcu7t3v3__fillcap_16
XFILLER_94_177 VDD VDD VSS VSS gf180mcu_as_sc_mcu7t3v3__fillcap_4
XFILLER_97_1512 VDD VDD VSS VSS gf180mcu_as_sc_mcu7t3v3__fill_1
X_3061_ VDD VDD VSS VSS _3145_/A _3061_/B _3061_/C _3145_/D _3063_/C gf180mcu_as_sc_mcu7t3v3__ao211_2
XFILLER_35_222 VDD VDD VSS VSS gf180mcu_as_sc_mcu7t3v3__fillcap_16
XFILLER_36_745 VDD VDD VSS VSS gf180mcu_as_sc_mcu7t3v3__fill_2
XFILLER_184_1537 VDD VDD VSS VSS gf180mcu_as_sc_mcu7t3v3__fillcap_4
XFILLER_58_1518 VDD VDD VSS VSS gf180mcu_as_sc_mcu7t3v3__fill_2
XFILLER_93_1409 VDD VDD VSS VSS gf180mcu_as_sc_mcu7t3v3__fillcap_4
XTAP_TAPCELL_ROW_51_3_2875 VDD VSS gf180mcu_as_sc_mcu7t3v3__tap_2
XFILLER_177_912 VDD VDD VSS VSS gf180mcu_as_sc_mcu7t3v3__fillcap_16
XFILLER_189_750 VDD VDD VSS VSS gf180mcu_as_sc_mcu7t3v3__fillcap_16
XFILLER_189_772 VDD VDD VSS VSS gf180mcu_as_sc_mcu7t3v3__fillcap_16
XPHY_EDGE_ROW_146_3_Left_531 VDD VSS gf180mcu_as_sc_mcu7t3v3__tap_2
X_3963_ VDD VDD VSS VSS _4232_/B _3963_/B _4116_/A gf180mcu_as_sc_mcu7t3v3__nor2_2
XFILLER_182_1294 VDD VDD VSS VSS gf180mcu_as_sc_mcu7t3v3__fill_1
XFILLER_188_271 VDD VDD VSS VSS gf180mcu_as_sc_mcu7t3v3__fillcap_4
XFILLER_32_973 VDD VDD VSS VSS gf180mcu_as_sc_mcu7t3v3__fill_1
X_3894_ VDD VDD VSS VSS _3908_/B _5184_/Q _4934_/D gf180mcu_as_sc_mcu7t3v3__and2_2
X_2914_ VDD VDD VSS VSS _3787_/A _3255_/B _3544_/C _3223_/C gf180mcu_as_sc_mcu7t3v3__nand3_2
XFILLER_108_1387 VDD VDD VSS VSS gf180mcu_as_sc_mcu7t3v3__fill_1
XFILLER_17_1259 VDD VDD VSS VSS gf180mcu_as_sc_mcu7t3v3__fill_1
XFILLER_31_483 VDD VDD VSS VSS gf180mcu_as_sc_mcu7t3v3__fillcap_4
X_2845_ VDD VDD VSS VSS _2845_/A _2845_/B _2856_/A _4683_/B _2854_/B gf180mcu_as_sc_mcu7t3v3__ao22_2
XFILLER_128_18 VDD VDD VSS VSS gf180mcu_as_sc_mcu7t3v3__fillcap_16
XFILLER_148_179 VDD VDD VSS VSS gf180mcu_as_sc_mcu7t3v3__fill_1
X_4515_ VDD VDD VSS VSS _4515_/B _4591_/A _4522_/C gf180mcu_as_sc_mcu7t3v3__and2_2
X_2776_ VDD VDD VSS VSS _2776_/B _2776_/A _2783_/A gf180mcu_as_sc_mcu7t3v3__and2_2
XFILLER_176_1065 VDD VDD VSS VSS gf180mcu_as_sc_mcu7t3v3__fillcap_16
XFILLER_176_1087 VDD VDD VSS VSS gf180mcu_as_sc_mcu7t3v3__fillcap_16
X_4446_ VDD VDD VSS VSS _4449_/C _4985_/Q _4579_/S gf180mcu_as_sc_mcu7t3v3__nand2b_2
XTAP_TAPCELL_ROW_35_1501 VDD VSS gf180mcu_as_sc_mcu7t3v3__tap_2
XFILLER_67_1393 VDD VDD VSS VSS gf180mcu_as_sc_mcu7t3v3__fillcap_16
XTAP_TAPCELL_ROW_120_1_1805 VDD VSS gf180mcu_as_sc_mcu7t3v3__tap_2
XTAP_TAPCELL_ROW_132_3_3117 VDD VSS gf180mcu_as_sc_mcu7t3v3__tap_2
Xfanout603 VDD VDD VSS VSS _3893_/B _3890_/B gf180mcu_as_sc_mcu7t3v3__buff_12
Xfanout614 VDD VDD VSS VSS _3229_/B _3240_/B gf180mcu_as_sc_mcu7t3v3__buff_12
X_4377_ VDD VDD VSS VSS _4377_/B _4377_/A _4378_/C gf180mcu_as_sc_mcu7t3v3__and2_2
Xfanout625 VDD VDD VSS VSS wire628/Y _4101_/B gf180mcu_as_sc_mcu7t3v3__buff_12
Xfanout636 VDD VDD VSS VSS _3563_/Y _3749_/B gf180mcu_as_sc_mcu7t3v3__buff_12
Xfanout647 VDD VDD VSS VSS _3267_/Y _3502_/B gf180mcu_as_sc_mcu7t3v3__buff_12
Xfanout658 VDD VDD VSS VSS _3125_/C _3042_/C gf180mcu_as_sc_mcu7t3v3__buff_12
X_3328_ VDD VDD VSS VSS _4921_/Q _3402_/B _3402_/C _3982_/A _3329_/C gf180mcu_as_sc_mcu7t3v3__ao22_2
XFILLER_41_1500 VDD VDD VSS VSS gf180mcu_as_sc_mcu7t3v3__fillcap_16
Xfanout669 VDD VDD VSS VSS _4629_/C _4620_/C gf180mcu_as_sc_mcu7t3v3__buff_12
XTAP_TAPCELL_ROW_31_1409 VDD VSS gf180mcu_as_sc_mcu7t3v3__tap_2
X_3259_ VDD VDD VSS VSS _3811_/A _3548_/A _3261_/B gf180mcu_as_sc_mcu7t3v3__and2_2
XFILLER_27_734 VDD VDD VSS VSS gf180mcu_as_sc_mcu7t3v3__fillcap_8
XFILLER_37_59 VDD VDD VSS VSS gf180mcu_as_sc_mcu7t3v3__fillcap_8
XFILLER_41_1566 VDD VDD VSS VSS gf180mcu_as_sc_mcu7t3v3__fill_2
XFILLER_85_199 VDD VDD VSS VSS gf180mcu_as_sc_mcu7t3v3__fill_1
XFILLER_26_244 VDD VDD VSS VSS gf180mcu_as_sc_mcu7t3v3__fill_1
X_4895__1072 VDD VDD VSS VSS _4895_/D gf180mcu_as_sc_mcu7t3v3__tiel_4
XFILLER_183_1047 VDD VDD VSS VSS gf180mcu_as_sc_mcu7t3v3__fill_2
XFILLER_26_277 VDD VDD VSS VSS gf180mcu_as_sc_mcu7t3v3__fill_1
XPHY_EDGE_ROW_78_3_Left_463 VDD VSS gf180mcu_as_sc_mcu7t3v3__tap_2
XFILLER_156_6 VDD VDD VSS VSS gf180mcu_as_sc_mcu7t3v3__fillcap_16
XTAP_TAPCELL_ROW_200_2571 VDD VSS gf180mcu_as_sc_mcu7t3v3__tap_2
XTAP_TAPCELL_ROW_175_2014 VDD VSS gf180mcu_as_sc_mcu7t3v3__tap_2
XFILLER_179_282 VDD VDD VSS VSS gf180mcu_as_sc_mcu7t3v3__fillcap_4
XFILLER_23_973 VDD VDD VSS VSS gf180mcu_as_sc_mcu7t3v3__fillcap_4
XFILLER_35_1315 VDD VDD VSS VSS gf180mcu_as_sc_mcu7t3v3__fill_1
XFILLER_35_1348 VDD VDD VSS VSS gf180mcu_as_sc_mcu7t3v3__fillcap_4
XTAP_TAPCELL_ROW_66_1_1642 VDD VSS gf180mcu_as_sc_mcu7t3v3__tap_2
XTAP_TAPCELL_ROW_200_2582 VDD VSS gf180mcu_as_sc_mcu7t3v3__tap_2
XTAP_TAPCELL_ROW_175_2025 VDD VSS gf180mcu_as_sc_mcu7t3v3__tap_2
XFILLER_161_1356 VDD VDD VSS VSS gf180mcu_as_sc_mcu7t3v3__fill_2
XFILLER_194_230 VDD VDD VSS VSS gf180mcu_as_sc_mcu7t3v3__fillcap_8
XFILLER_10_667 VDD VDD VSS VSS gf180mcu_as_sc_mcu7t3v3__fillcap_4
XFILLER_182_414 VDD VDD VSS VSS gf180mcu_as_sc_mcu7t3v3__fillcap_16
XFILLER_194_285 VDD VDD VSS VSS gf180mcu_as_sc_mcu7t3v3__fill_2
XFILLER_210_595 VDD VDD VSS VSS gf180mcu_as_sc_mcu7t3v3__fillcap_4
XFILLER_33_1072 VDD VDD VSS VSS gf180mcu_as_sc_mcu7t3v3__fill_2
XTAP_TAPCELL_ROW_192_2394 VDD VSS gf180mcu_as_sc_mcu7t3v3__tap_2
XFILLER_10_689 VDD VDD VSS VSS gf180mcu_as_sc_mcu7t3v3__fillcap_16
XFILLER_33_1094 VDD VDD VSS VSS gf180mcu_as_sc_mcu7t3v3__fillcap_8
XFILLER_5_104 VDD VDD VSS VSS gf180mcu_as_sc_mcu7t3v3__fillcap_16
XFILLER_5_137 VDD VDD VSS VSS gf180mcu_as_sc_mcu7t3v3__fill_2
XFILLER_6_649 VDD VDD VSS VSS gf180mcu_as_sc_mcu7t3v3__fillcap_16
XTAP_TAPCELL_ROW_76_3_2948 VDD VSS gf180mcu_as_sc_mcu7t3v3__tap_2
XFILLER_162_171 VDD VDD VSS VSS gf180mcu_as_sc_mcu7t3v3__fillcap_4
XFILLER_29_1119 VDD VDD VSS VSS gf180mcu_as_sc_mcu7t3v3__fill_1
XTAP_TAPCELL_ROW_46_1_1584 VDD VSS gf180mcu_as_sc_mcu7t3v3__tap_2
XFILLER_85_1482 VDD VDD VSS VSS gf180mcu_as_sc_mcu7t3v3__fillcap_4
XFILLER_2_877 VDD VDD VSS VSS gf180mcu_as_sc_mcu7t3v3__fillcap_8
XFILLER_46_1477 VDD VDD VSS VSS gf180mcu_as_sc_mcu7t3v3__fill_2
XFILLER_78_77 VDD VDD VSS VSS gf180mcu_as_sc_mcu7t3v3__fillcap_16
Xmesh_tile_1002 VDD VDD VSS VSS nw_out[9] gf180mcu_as_sc_mcu7t3v3__tiel_4
XTAP_TAPCELL_ROW_207_2725 VDD VSS gf180mcu_as_sc_mcu7t3v3__tap_2
XFILLER_76_155 VDD VDD VSS VSS gf180mcu_as_sc_mcu7t3v3__fillcap_16
XFILLER_94_32 VDD VDD VSS VSS gf180mcu_as_sc_mcu7t3v3__fill_2
Xmesh_tile_1013 VDD VDD VSS VSS nw_out[20] gf180mcu_as_sc_mcu7t3v3__tiel_4
Xmesh_tile_1035 VDD VDD VSS VSS sw_out[8] gf180mcu_as_sc_mcu7t3v3__tiel_4
Xmesh_tile_1024 VDD VDD VSS VSS nw_out[31] gf180mcu_as_sc_mcu7t3v3__tiel_4
XTAP_TAPCELL_ROW_207_2736 VDD VSS gf180mcu_as_sc_mcu7t3v3__tap_2
XFILLER_18_734 VDD VDD VSS VSS gf180mcu_as_sc_mcu7t3v3__fill_1
XFILLER_76_177 VDD VDD VSS VSS gf180mcu_as_sc_mcu7t3v3__fillcap_16
XFILLER_91_125 VDD VDD VSS VSS gf180mcu_as_sc_mcu7t3v3__fillcap_8
Xmesh_tile_1057 VDD VDD VSS VSS sw_out[30] gf180mcu_as_sc_mcu7t3v3__tiel_4
Xmesh_tile_1046 VDD VDD VSS VSS sw_out[19] gf180mcu_as_sc_mcu7t3v3__tiel_4
XTAP_TAPCELL_ROW_199_2559 VDD VSS gf180mcu_as_sc_mcu7t3v3__tap_2
XTAP_TAPCELL_ROW_199_2548 VDD VSS gf180mcu_as_sc_mcu7t3v3__tap_2
XFILLER_92_1453 VDD VDD VSS VSS gf180mcu_as_sc_mcu7t3v3__fillcap_16
XFILLER_105_1505 VDD VDD VSS VSS gf180mcu_as_sc_mcu7t3v3__fill_1
XFILLER_186_731 VDD VDD VSS VSS gf180mcu_as_sc_mcu7t3v3__fillcap_4
XFILLER_198_591 VDD VDD VSS VSS gf180mcu_as_sc_mcu7t3v3__fillcap_4
XFILLER_32_258 VDD VDD VSS VSS gf180mcu_as_sc_mcu7t3v3__fillcap_16
XFILLER_53_1415 VDD VDD VSS VSS gf180mcu_as_sc_mcu7t3v3__fill_1
XFILLER_140_1418 VDD VDD VSS VSS gf180mcu_as_sc_mcu7t3v3__fill_2
XFILLER_186_753 VDD VDD VSS VSS gf180mcu_as_sc_mcu7t3v3__fillcap_16
XFILLER_201_540 VDD VDD VSS VSS gf180mcu_as_sc_mcu7t3v3__fillcap_16
XFILLER_201_562 VDD VDD VSS VSS gf180mcu_as_sc_mcu7t3v3__fillcap_16
XFILLER_43_91 VDD VDD VSS VSS gf180mcu_as_sc_mcu7t3v3__fill_1
XFILLER_185_263 VDD VDD VSS VSS gf180mcu_as_sc_mcu7t3v3__fillcap_16
XFILLER_9_454 VDD VDD VSS VSS gf180mcu_as_sc_mcu7t3v3__fillcap_16
X_2630_ VDD VDD VSS VSS _2631_/D _5263_/Q _2695_/A _4643_/B gf180mcu_as_sc_mcu7t3v3__ao21_2
XFILLER_185_296 VDD VDD VSS VSS gf180mcu_as_sc_mcu7t3v3__fill_1
XFILLER_12_1178 VDD VDD VSS VSS gf180mcu_as_sc_mcu7t3v3__fillcap_4
X_2561_ VDD VDD VSS VSS _2666_/A _4952_/D _2831_/B gf180mcu_as_sc_mcu7t3v3__nand2b_2
XFILLER_99_203 VDD VDD VSS VSS gf180mcu_as_sc_mcu7t3v3__fillcap_4
X_5280_ VDD VDD VSS VSS _5280_/CLK _5280_/D _5280_/Q gf180mcu_as_sc_mcu7t3v3__dfxtp_2
X_4300_ VDD VDD VSS VSS _4308_/S _5130_/Q _5129_/Q _5129_/D gf180mcu_as_sc_mcu7t3v3__mux2_2
X_2492_ VDD VDD VSS VSS _4649_/A _5274_/Q _2794_/A gf180mcu_as_sc_mcu7t3v3__and2_2
XTAP_TAPCELL_ROW_92_1_1721 VDD VSS gf180mcu_as_sc_mcu7t3v3__tap_2
X_4231_ VDD VDD VSS VSS _4257_/S _4231_/B _5067_/Q _5067_/D gf180mcu_as_sc_mcu7t3v3__mux2_2
XFILLER_4_74 VDD VDD VSS VSS gf180mcu_as_sc_mcu7t3v3__fillcap_4
XFILLER_25_1539 VDD VDD VSS VSS gf180mcu_as_sc_mcu7t3v3__fill_1
X_4162_ VDD VDD VSS VSS _4162_/B _4162_/A _4163_/D gf180mcu_as_sc_mcu7t3v3__and2_2
XFILLER_151_1558 VDD VDD VSS VSS gf180mcu_as_sc_mcu7t3v3__fillcap_8
XFILLER_7_1460 VDD VDD VSS VSS gf180mcu_as_sc_mcu7t3v3__fillcap_8
X_4093_ VDD VDD VSS VSS _4093_/A _4118_/B _4118_/C _4093_/D _4094_/D gf180mcu_as_sc_mcu7t3v3__ao22_2
X_3113_ VDD VDD VSS VSS _4086_/A _3229_/B _3113_/C _3113_/D _3114_/C gf180mcu_as_sc_mcu7t3v3__ao22_2
X_3044_ VDD VDD VSS VSS _4023_/A _3076_/B _3127_/C _4024_/D _3045_/C gf180mcu_as_sc_mcu7t3v3__ao22_2
XFILLER_184_1345 VDD VDD VSS VSS gf180mcu_as_sc_mcu7t3v3__fillcap_16
XFILLER_208_1017 VDD VDD VSS VSS gf180mcu_as_sc_mcu7t3v3__fillcap_4
XFILLER_24_737 VDD VDD VSS VSS gf180mcu_as_sc_mcu7t3v3__fill_1
XFILLER_58_1348 VDD VDD VSS VSS gf180mcu_as_sc_mcu7t3v3__fillcap_4
XFILLER_97_1375 VDD VDD VSS VSS gf180mcu_as_sc_mcu7t3v3__fill_1
XFILLER_184_1367 VDD VDD VSS VSS gf180mcu_as_sc_mcu7t3v3__fillcap_16
X_4995_ VDD VDD VSS VSS _5082_/CLK _4995_/D _4995_/Q gf180mcu_as_sc_mcu7t3v3__dfxtp_2
XFILLER_205_890 VDD VDD VSS VSS gf180mcu_as_sc_mcu7t3v3__fillcap_16
XFILLER_210_52 VDD VDD VSS VSS gf180mcu_as_sc_mcu7t3v3__fillcap_16
XFILLER_71_1504 VDD VDD VSS VSS gf180mcu_as_sc_mcu7t3v3__fillcap_16
X_3946_ VDD VDD VSS VSS _4979_/Q _4142_/B _4230_/B _4142_/D _4979_/D gf180mcu_as_sc_mcu7t3v3__ao22_2
XFILLER_177_764 VDD VDD VSS VSS gf180mcu_as_sc_mcu7t3v3__fillcap_4
XFILLER_32_781 VDD VDD VSS VSS gf180mcu_as_sc_mcu7t3v3__fillcap_4
X_3877_ VDD VDD VSS VSS _3890_/B _5167_/Q _4917_/D gf180mcu_as_sc_mcu7t3v3__and2_2
XTAP_TAPCELL_ROW_24_1268 VDD VSS gf180mcu_as_sc_mcu7t3v3__tap_2
XTAP_TAPCELL_ROW_24_1257 VDD VSS gf180mcu_as_sc_mcu7t3v3__tap_2
XFILLER_20_987 VDD VDD VSS VSS gf180mcu_as_sc_mcu7t3v3__fillcap_4
XFILLER_30_1223 VDD VDD VSS VSS gf180mcu_as_sc_mcu7t3v3__fill_2
X_2828_ VDD VDD VSS VSS _4975_/D _2828_/B _5283_/Q _5282_/D gf180mcu_as_sc_mcu7t3v3__mux2_2
XFILLER_121_1373 VDD VDD VSS VSS gf180mcu_as_sc_mcu7t3v3__fillcap_8
X_2759_ VDD VDD VSS VSS _4633_/A _5233_/Q _2806_/D _2795_/A _2761_/D gf180mcu_as_sc_mcu7t3v3__ao211_2
XFILLER_144_171 VDD VDD VSS VSS gf180mcu_as_sc_mcu7t3v3__fillcap_4
XFILLER_155_38 VDD VDD VSS VSS gf180mcu_as_sc_mcu7t3v3__fillcap_16
XFILLER_2_107 VDD VDD VSS VSS gf180mcu_as_sc_mcu7t3v3__fill_2
XFILLER_69_1488 VDD VDD VSS VSS gf180mcu_as_sc_mcu7t3v3__fill_1
X_5478_ VDD VDD VSS VSS _5478_/A _5478_/Y gf180mcu_as_sc_mcu7t3v3__buff_2
XFILLER_144_193 VDD VDD VSS VSS gf180mcu_as_sc_mcu7t3v3__fillcap_16
XFILLER_156_1469 VDD VDD VSS VSS gf180mcu_as_sc_mcu7t3v3__fillcap_16
X_4429_ VDD VDD VSS VSS _4509_/S _5012_/Q _5041_/Q _4430_/B gf180mcu_as_sc_mcu7t3v3__mux2_2
XFILLER_8_1224 VDD VDD VSS VSS gf180mcu_as_sc_mcu7t3v3__fill_1
XFILLER_58_111 VDD VDD VSS VSS gf180mcu_as_sc_mcu7t3v3__fill_2
Xfanout488 VDD VDD VSS VSS _3560_/Y _3794_/S gf180mcu_as_sc_mcu7t3v3__buff_12
XFILLER_189_1256 VDD VDD VSS VSS gf180mcu_as_sc_mcu7t3v3__fillcap_4
XFILLER_58_177 VDD VDD VSS VSS gf180mcu_as_sc_mcu7t3v3__fillcap_16
XFILLER_189_1278 VDD VDD VSS VSS gf180mcu_as_sc_mcu7t3v3__fillcap_16
XFILLER_73_158 VDD VDD VSS VSS gf180mcu_as_sc_mcu7t3v3__fillcap_16
XTAP_TAPCELL_ROW_202_2622 VDD VSS gf180mcu_as_sc_mcu7t3v3__tap_2
XTAP_TAPCELL_ROW_202_2611 VDD VSS gf180mcu_as_sc_mcu7t3v3__tap_2
XFILLER_167_1554 VDD VDD VSS VSS gf180mcu_as_sc_mcu7t3v3__fill_2
XFILLER_14_247 VDD VDD VSS VSS gf180mcu_as_sc_mcu7t3v3__fillcap_16
XFILLER_163_1418 VDD VDD VSS VSS gf180mcu_as_sc_mcu7t3v3__fillcap_16
XFILLER_35_1101 VDD VDD VSS VSS gf180mcu_as_sc_mcu7t3v3__fillcap_8
XTAP_TAPCELL_ROW_194_2445 VDD VSS gf180mcu_as_sc_mcu7t3v3__tap_2
XTAP_TAPCELL_ROW_194_2434 VDD VSS gf180mcu_as_sc_mcu7t3v3__tap_2
XFILLER_120_85 VDD VDD VSS VSS gf180mcu_as_sc_mcu7t3v3__fillcap_16
XFILLER_204_1415 VDD VDD VSS VSS gf180mcu_as_sc_mcu7t3v3__fillcap_16
XFILLER_204_1437 VDD VDD VSS VSS gf180mcu_as_sc_mcu7t3v3__fillcap_16
XFILLER_80_34 VDD VDD VSS VSS gf180mcu_as_sc_mcu7t3v3__fill_1
XTAP_TAPCELL_ROW_97_1_1736 VDD VSS gf180mcu_as_sc_mcu7t3v3__tap_2
XFILLER_10_442 VDD VDD VSS VSS gf180mcu_as_sc_mcu7t3v3__fill_2
XFILLER_196_34 VDD VDD VSS VSS gf180mcu_as_sc_mcu7t3v3__fill_1
Xwire834 VDD VDD VSS VSS wire834/A _4006_/D gf180mcu_as_sc_mcu7t3v3__clkbuff_12
XFILLER_13_72 VDD VDD VSS VSS gf180mcu_as_sc_mcu7t3v3__fillcap_16
XFILLER_182_233 VDD VDD VSS VSS gf180mcu_as_sc_mcu7t3v3__fillcap_4
XFILLER_195_594 VDD VDD VSS VSS gf180mcu_as_sc_mcu7t3v3__fillcap_16
XFILLER_196_1205 VDD VDD VSS VSS gf180mcu_as_sc_mcu7t3v3__fillcap_16
XFILLER_196_1227 VDD VDD VSS VSS gf180mcu_as_sc_mcu7t3v3__fillcap_16
Xwire845 VDD VDD VSS VSS wire845/A _4138_/A gf180mcu_as_sc_mcu7t3v3__clkbuff_12
Xwire856 VDD VDD VSS VSS wire856/A _4015_/A gf180mcu_as_sc_mcu7t3v3__clkbuff_12
Xwire867 VDD VDD VSS VSS wire867/A _3993_/A gf180mcu_as_sc_mcu7t3v3__clkbuff_12
XFILLER_10_497 VDD VDD VSS VSS gf180mcu_as_sc_mcu7t3v3__fill_2
XFILLER_129_72 VDD VDD VSS VSS gf180mcu_as_sc_mcu7t3v3__fillcap_8
XFILLER_129_94 VDD VDD VSS VSS gf180mcu_as_sc_mcu7t3v3__fillcap_4
XFILLER_182_266 VDD VDD VSS VSS gf180mcu_as_sc_mcu7t3v3__fillcap_16
XFILLER_6_457 VDD VDD VSS VSS gf180mcu_as_sc_mcu7t3v3__fill_1
XFILLER_89_10 VDD VDD VSS VSS gf180mcu_as_sc_mcu7t3v3__fill_1
Xwire878 VDD VDD VSS VSS wire878/A _4057_/A gf180mcu_as_sc_mcu7t3v3__clkbuff_12
XFILLER_142_119 VDD VDD VSS VSS gf180mcu_as_sc_mcu7t3v3__fill_2
XFILLER_174_1514 VDD VDD VSS VSS gf180mcu_as_sc_mcu7t3v3__fillcap_16
XFILLER_87_1566 VDD VDD VSS VSS gf180mcu_as_sc_mcu7t3v3__fill_2
XFILLER_174_1536 VDD VDD VSS VSS gf180mcu_as_sc_mcu7t3v3__fill_1
XFILLER_150_152 VDD VDD VSS VSS gf180mcu_as_sc_mcu7t3v3__fillcap_16
XFILLER_150_174 VDD VDD VSS VSS gf180mcu_as_sc_mcu7t3v3__fill_1
XFILLER_96_217 VDD VDD VSS VSS gf180mcu_as_sc_mcu7t3v3__fillcap_4
XFILLER_64_103 VDD VDD VSS VSS gf180mcu_as_sc_mcu7t3v3__fill_2
XFILLER_64_125 VDD VDD VSS VSS gf180mcu_as_sc_mcu7t3v3__fillcap_16
XFILLER_18_586 VDD VDD VSS VSS gf180mcu_as_sc_mcu7t3v3__fillcap_8
XFILLER_205_120 VDD VDD VSS VSS gf180mcu_as_sc_mcu7t3v3__fillcap_16
XFILLER_18_597 VDD VDD VSS VSS gf180mcu_as_sc_mcu7t3v3__fillcap_8
XFILLER_205_142 VDD VDD VSS VSS gf180mcu_as_sc_mcu7t3v3__fillcap_16
XFILLER_209_1326 VDD VDD VSS VSS gf180mcu_as_sc_mcu7t3v3__fillcap_4
XFILLER_209_1348 VDD VDD VSS VSS gf180mcu_as_sc_mcu7t3v3__fillcap_16
XFILLER_18_1321 VDD VDD VSS VSS gf180mcu_as_sc_mcu7t3v3__fillcap_4
X_4780_ VDD VDD VSS VSS _5142_/CLK _4780_/D _4780_/Q gf180mcu_as_sc_mcu7t3v3__dfxtp_2
X_3800_ VDD VDD VSS VSS _3800_/D _3800_/A _3807_/B _3800_/C _3801_/D gf180mcu_as_sc_mcu7t3v3__ao31_2
XFILLER_202_871 VDD VDD VSS VSS gf180mcu_as_sc_mcu7t3v3__fillcap_4
X_3731_ VDD VDD VSS VSS _4860_/D _3731_/C _3731_/B _3731_/A gf180mcu_as_sc_mcu7t3v3__aoi21_2
XFILLER_186_561 VDD VDD VSS VSS gf180mcu_as_sc_mcu7t3v3__fillcap_16
XFILLER_202_893 VDD VDD VSS VSS gf180mcu_as_sc_mcu7t3v3__fillcap_16
Xclkload10 VDD VDD VSS VSS _4924_/CLK clkload10/Y gf180mcu_as_sc_mcu7t3v3__clkbuff_4
X_3662_ VDD VDD VSS VSS _4040_/A _3724_/B _3740_/C _4039_/A _3663_/C gf180mcu_as_sc_mcu7t3v3__ao22_2
XFILLER_174_778 VDD VDD VSS VSS gf180mcu_as_sc_mcu7t3v3__fillcap_4
XFILLER_179_1469 VDD VDD VSS VSS gf180mcu_as_sc_mcu7t3v3__fill_1
XFILLER_62_2 VDD VDD VSS VSS gf180mcu_as_sc_mcu7t3v3__fill_2
XTAP_TAPCELL_ROW_12_993 VDD VSS gf180mcu_as_sc_mcu7t3v3__tap_2
Xclkload21 VDD VDD VSS VSS clkload21/Y _5262_/CLK gf180mcu_as_sc_mcu7t3v3__inv_4
X_3593_ VDD VDD VSS VSS _3961_/A _3660_/B _3608_/B _3594_/C _3593_/D gf180mcu_as_sc_mcu7t3v3__aoi211_2
X_2613_ VDD VDD VSS VSS _2621_/B _5229_/Q _2614_/B gf180mcu_as_sc_mcu7t3v3__or2_2
X_2544_ VDD VDD VSS VSS _2771_/D _2798_/B gf180mcu_as_sc_mcu7t3v3__inv_2
X_5263_ VDD VDD VSS VSS _5280_/CLK _5263_/D _5263_/Q gf180mcu_as_sc_mcu7t3v3__dfxtp_2
X_2475_ VDD VDD VSS VSS _2589_/A _4949_/Q _2476_/B gf180mcu_as_sc_mcu7t3v3__and2_2
XFILLER_141_174 VDD VDD VSS VSS gf180mcu_as_sc_mcu7t3v3__fill_2
XFILLER_29_1483 VDD VDD VSS VSS gf180mcu_as_sc_mcu7t3v3__fillcap_16
X_5194_ VDD VDD VSS VSS _5197_/CLK _5194_/D _5194_/Q gf180mcu_as_sc_mcu7t3v3__dfxtp_2
X_4214_ VDD VDD VSS VSS _4243_/B _4222_/B _4222_/C _5050_/Q _5050_/D gf180mcu_as_sc_mcu7t3v3__ao22_2
XFILLER_25_1336 VDD VDD VSS VSS gf180mcu_as_sc_mcu7t3v3__fill_1
X_4145_ VDD VDD VSS VSS _4145_/A _4159_/B _4145_/C _4145_/D _4147_/C gf180mcu_as_sc_mcu7t3v3__ao211_2
XTAP_TAPCELL_ROW_17_1094 VDD VSS gf180mcu_as_sc_mcu7t3v3__tap_2
XFILLER_141_18 VDD VDD VSS VSS gf180mcu_as_sc_mcu7t3v3__fillcap_16
XFILLER_28_317 VDD VDD VSS VSS gf180mcu_as_sc_mcu7t3v3__fillcap_8
XFILLER_3_1110 VDD VDD VSS VSS gf180mcu_as_sc_mcu7t3v3__fillcap_8
XPHY_EDGE_ROW_133_1_Left_343 VDD VSS gf180mcu_as_sc_mcu7t3v3__tap_2
XFILLER_209_481 VDD VDD VSS VSS gf180mcu_as_sc_mcu7t3v3__fillcap_8
XFILLER_23_1060 VDD VDD VSS VSS gf180mcu_as_sc_mcu7t3v3__fillcap_4
XFILLER_55_158 VDD VDD VSS VSS gf180mcu_as_sc_mcu7t3v3__fill_2
XTAP_TAPCELL_ROW_127_3_3101 VDD VSS gf180mcu_as_sc_mcu7t3v3__tap_2
X_4076_ VDD VDD VSS VSS _4995_/Q _4142_/B _4246_/B _4142_/D _4995_/D gf180mcu_as_sc_mcu7t3v3__ao22_2
XFILLER_209_492 VDD VDD VSS VSS gf180mcu_as_sc_mcu7t3v3__fillcap_16
X_3027_ VDD VDD VSS VSS _3128_/A _3027_/B _3027_/C _3128_/D _3029_/C gf180mcu_as_sc_mcu7t3v3__ao211_2
XFILLER_197_804 VDD VDD VSS VSS gf180mcu_as_sc_mcu7t3v3__fillcap_16
XFILLER_36_394 VDD VDD VSS VSS gf180mcu_as_sc_mcu7t3v3__fillcap_8
XFILLER_70_139 VDD VDD VSS VSS gf180mcu_as_sc_mcu7t3v3__fillcap_16
XFILLER_180_1017 VDD VDD VSS VSS gf180mcu_as_sc_mcu7t3v3__fillcap_16
XFILLER_196_314 VDD VDD VSS VSS gf180mcu_as_sc_mcu7t3v3__fill_1
XFILLER_196_325 VDD VDD VSS VSS gf180mcu_as_sc_mcu7t3v3__fill_2
XTAP_TAPCELL_ROW_26_1308 VDD VSS gf180mcu_as_sc_mcu7t3v3__tap_2
XFILLER_75_1492 VDD VDD VSS VSS gf180mcu_as_sc_mcu7t3v3__fill_2
X_4978_ VDD VDD VSS VSS _5082_/CLK _4978_/D _4978_/Q gf180mcu_as_sc_mcu7t3v3__dfxtp_2
Xsram2048.u_bank0_916 VDD VDD VSS VSS sram2048.u_bank0/WEN[6] gf180mcu_as_sc_mcu7t3v3__tiel_4
XFILLER_123_1413 VDD VDD VSS VSS gf180mcu_as_sc_mcu7t3v3__fill_2
XFILLER_32_1329 VDD VDD VSS VSS gf180mcu_as_sc_mcu7t3v3__fillcap_16
XFILLER_36_1498 VDD VDD VSS VSS gf180mcu_as_sc_mcu7t3v3__fillcap_16
XTAP_TAPCELL_ROW_107_3_3043 VDD VSS gf180mcu_as_sc_mcu7t3v3__tap_2
Xclkload4 VDD VDD VSS VSS clkload4/Y clkload4/A gf180mcu_as_sc_mcu7t3v3__inv_2
X_3929_ VDD VDD VSS VSS _3929_/Y _3929_/B _3929_/A gf180mcu_as_sc_mcu7t3v3__nor2_2
XFILLER_192_520 VDD VDD VSS VSS gf180mcu_as_sc_mcu7t3v3__fillcap_4
XFILLER_197_1536 VDD VDD VSS VSS gf180mcu_as_sc_mcu7t3v3__fillcap_4
XFILLER_50_37 VDD VDD VSS VSS gf180mcu_as_sc_mcu7t3v3__fillcap_8
XFILLER_166_37 VDD VDD VSS VSS gf180mcu_as_sc_mcu7t3v3__fillcap_16
XFILLER_192_575 VDD VDD VSS VSS gf180mcu_as_sc_mcu7t3v3__fillcap_16
XFILLER_192_597 VDD VDD VSS VSS gf180mcu_as_sc_mcu7t3v3__fillcap_16
XFILLER_117_182 VDD VDD VSS VSS gf180mcu_as_sc_mcu7t3v3__fillcap_4
XFILLER_132_141 VDD VDD VSS VSS gf180mcu_as_sc_mcu7t3v3__fill_2
XFILLER_59_68 VDD VDD VSS VSS gf180mcu_as_sc_mcu7t3v3__fill_2
XTAP_TAPCELL_ROW_170_1_1954 VDD VSS gf180mcu_as_sc_mcu7t3v3__tap_2
XFILLER_132_174 VDD VDD VSS VSS gf180mcu_as_sc_mcu7t3v3__fill_1
XFILLER_182_69 VDD VDD VSS VSS gf180mcu_as_sc_mcu7t3v3__fillcap_16
XFILLER_8_1010 VDD VDD VSS VSS gf180mcu_as_sc_mcu7t3v3__fillcap_4
XTAP_TAPCELL_ROW_187_2293 VDD VSS gf180mcu_as_sc_mcu7t3v3__tap_2
XTAP_TAPCELL_ROW_187_2282 VDD VSS gf180mcu_as_sc_mcu7t3v3__tap_2
XFILLER_8_1065 VDD VDD VSS VSS gf180mcu_as_sc_mcu7t3v3__fillcap_8
XFILLER_93_209 VDD VDD VSS VSS gf180mcu_as_sc_mcu7t3v3__fill_1
XPHY_EDGE_ROW_65_1_Left_275 VDD VSS gf180mcu_as_sc_mcu7t3v3__tap_2
XFILLER_210_1430 VDD VDD VSS VSS gf180mcu_as_sc_mcu7t3v3__fill_1
XFILLER_8_1087 VDD VDD VSS VSS gf180mcu_as_sc_mcu7t3v3__fillcap_16
XFILLER_46_158 VDD VDD VSS VSS gf180mcu_as_sc_mcu7t3v3__fillcap_16
XTAP_TAPCELL_ROW_150_1_1896 VDD VSS gf180mcu_as_sc_mcu7t3v3__tap_2
XFILLER_15_534 VDD VDD VSS VSS gf180mcu_as_sc_mcu7t3v3__fill_1
XFILLER_199_174 VDD VDD VSS VSS gf180mcu_as_sc_mcu7t3v3__fillcap_16
XFILLER_202_101 VDD VDD VSS VSS gf180mcu_as_sc_mcu7t3v3__fillcap_4
XFILLER_202_123 VDD VDD VSS VSS gf180mcu_as_sc_mcu7t3v3__fillcap_16
XFILLER_91_88 VDD VDD VSS VSS gf180mcu_as_sc_mcu7t3v3__fillcap_8
XFILLER_10_261 VDD VDD VSS VSS gf180mcu_as_sc_mcu7t3v3__fill_1
XFILLER_141_1568 VDD VDD VSS VSS gf180mcu_as_sc_mcu7t3v3__fill_1
XFILLER_13_1262 VDD VDD VSS VSS gf180mcu_as_sc_mcu7t3v3__fill_2
XFILLER_7_788 VDD VDD VSS VSS gf180mcu_as_sc_mcu7t3v3__fillcap_8
XFILLER_108_193 VDD VDD VSS VSS gf180mcu_as_sc_mcu7t3v3__fillcap_4
XFILLER_174_1344 VDD VDD VSS VSS gf180mcu_as_sc_mcu7t3v3__fillcap_16
XFILLER_174_1366 VDD VDD VSS VSS gf180mcu_as_sc_mcu7t3v3__fill_1
XFILLER_87_1396 VDD VDD VSS VSS gf180mcu_as_sc_mcu7t3v3__fillcap_8
XPHY_EDGE_ROW_155_3_Left_540 VDD VSS gf180mcu_as_sc_mcu7t3v3__tap_2
XFILLER_37_114 VDD VDD VSS VSS gf180mcu_as_sc_mcu7t3v3__fillcap_16
XFILLER_61_1558 VDD VDD VSS VSS gf180mcu_as_sc_mcu7t3v3__fillcap_8
XFILLER_111_1372 VDD VDD VSS VSS gf180mcu_as_sc_mcu7t3v3__fillcap_4
XFILLER_207_952 VDD VDD VSS VSS gf180mcu_as_sc_mcu7t3v3__fill_2
XFILLER_25_309 VDD VDD VSS VSS gf180mcu_as_sc_mcu7t3v3__fillcap_16
XFILLER_37_158 VDD VDD VSS VSS gf180mcu_as_sc_mcu7t3v3__fillcap_16
XFILLER_206_451 VDD VDD VSS VSS gf180mcu_as_sc_mcu7t3v3__fillcap_4
XFILLER_206_473 VDD VDD VSS VSS gf180mcu_as_sc_mcu7t3v3__fillcap_16
XFILLER_20_1288 VDD VDD VSS VSS gf180mcu_as_sc_mcu7t3v3__fillcap_4
XFILLER_52_139 VDD VDD VSS VSS gf180mcu_as_sc_mcu7t3v3__fillcap_16
X_4901_ VDD VDD VSS VSS _4904_/CLK _4901_/D _4901_/Q gf180mcu_as_sc_mcu7t3v3__dfxtp_2
XFILLER_146_1479 VDD VDD VSS VSS gf180mcu_as_sc_mcu7t3v3__fillcap_16
XFILLER_181_1348 VDD VDD VSS VSS gf180mcu_as_sc_mcu7t3v3__fillcap_16
XFILLER_18_1140 VDD VDD VSS VSS gf180mcu_as_sc_mcu7t3v3__fill_2
XFILLER_194_807 VDD VDD VSS VSS gf180mcu_as_sc_mcu7t3v3__fillcap_16
XFILLER_209_1189 VDD VDD VSS VSS gf180mcu_as_sc_mcu7t3v3__fill_1
XFILLER_33_386 VDD VDD VSS VSS gf180mcu_as_sc_mcu7t3v3__fill_1
X_4832_ VDD VDD VSS VSS _5073_/CLK _4832_/D _4832_/Q gf180mcu_as_sc_mcu7t3v3__dfxtp_2
Xclkbuf_leaf_29_clk_regs VDD VDD VSS VSS clkbuf_3_0__f_clk_regs/Y clkload2/A gf180mcu_as_sc_mcu7t3v3__clkbuff_12
X_4763_ VDD VDD VSS VSS _5241_/CLK _4763_/D _4763_/Q gf180mcu_as_sc_mcu7t3v3__dfxtp_2
XFILLER_186_391 VDD VDD VSS VSS gf180mcu_as_sc_mcu7t3v3__fill_2
XFILLER_193_328 VDD VDD VSS VSS gf180mcu_as_sc_mcu7t3v3__fill_1
X_4694_ VDD VDD VSS VSS _4725_/B _5480_/A _5253_/Q _4695_/A gf180mcu_as_sc_mcu7t3v3__mux2_2
X_3714_ VDD VDD VSS VSS _3714_/D _3794_/S _3714_/B _3714_/C _3715_/C gf180mcu_as_sc_mcu7t3v3__ao31_2
X_4835__1097 VDD VDD VSS VSS _4835_/D gf180mcu_as_sc_mcu7t3v3__tiel_4
XTAP_TAPCELL_ROW_77_3_2953 VDD VSS gf180mcu_as_sc_mcu7t3v3__tap_2
XFILLER_31_1373 VDD VDD VSS VSS gf180mcu_as_sc_mcu7t3v3__fillcap_16
X_3645_ VDD VDD VSS VSS _3646_/C _3645_/C _3729_/B _4017_/A gf180mcu_as_sc_mcu7t3v3__aoi21_2
X_3576_ VDD VDD VSS VSS _3938_/D _3650_/B _3576_/C _3576_/D _3577_/C gf180mcu_as_sc_mcu7t3v3__ao211_2
XFILLER_118_1515 VDD VDD VSS VSS gf180mcu_as_sc_mcu7t3v3__fillcap_4
XFILLER_66_1469 VDD VDD VSS VSS gf180mcu_as_sc_mcu7t3v3__fillcap_16
XPHY_EDGE_ROW_87_3_Left_472 VDD VSS gf180mcu_as_sc_mcu7t3v3__tap_2
X_2527_ VDD VDD VSS VSS _4655_/B _4657_/B _5268_/Q gf180mcu_as_sc_mcu7t3v3__nor2_2
XTAP_TAPCELL_ROW_19_1145 VDD VSS gf180mcu_as_sc_mcu7t3v3__tap_2
X_5246_ VDD VDD VSS VSS _5262_/CLK _5246_/D _5246_/Q gf180mcu_as_sc_mcu7t3v3__dfxtp_2
Xinput309 VDD VDD VSS VSS west_in[33] _3548_/A gf180mcu_as_sc_mcu7t3v3__buff_12
X_2458_ VDD VDD VSS VSS _3869_/A _3846_/B _3847_/A gf180mcu_as_sc_mcu7t3v3__nand2_2
XTAP_TAPCELL_ROW_19_1156 VDD VSS gf180mcu_as_sc_mcu7t3v3__tap_2
XFILLER_25_1133 VDD VDD VSS VSS gf180mcu_as_sc_mcu7t3v3__fillcap_16
XFILLER_29_27 VDD VDD VSS VSS gf180mcu_as_sc_mcu7t3v3__fillcap_16
X_5177_ VDD VDD VSS VSS clkload7/A _5177_/D _5177_/Q gf180mcu_as_sc_mcu7t3v3__dfxtp_2
XFILLER_83_220 VDD VDD VSS VSS gf180mcu_as_sc_mcu7t3v3__fill_2
X_4128_ VDD VDD VSS VSS _4128_/B _4128_/A _4130_/C gf180mcu_as_sc_mcu7t3v3__and2_2
XTAP_TAPCELL_ROW_40_1_1565 VDD VSS gf180mcu_as_sc_mcu7t3v3__tap_2
X_4059_ VDD VDD VSS VSS _4059_/B _4107_/A _4244_/B gf180mcu_as_sc_mcu7t3v3__and2_2
XFILLER_186_1259 VDD VDD VSS VSS gf180mcu_as_sc_mcu7t3v3__fillcap_16
XFILLER_45_59 VDD VDD VSS VSS gf180mcu_as_sc_mcu7t3v3__fillcap_8
XFILLER_101_43 VDD VDD VSS VSS gf180mcu_as_sc_mcu7t3v3__fillcap_4
XFILLER_38_1527 VDD VDD VSS VSS gf180mcu_as_sc_mcu7t3v3__fill_2
XFILLER_73_1418 VDD VDD VSS VSS gf180mcu_as_sc_mcu7t3v3__fillcap_4
XFILLER_164_1568 VDD VDD VSS VSS gf180mcu_as_sc_mcu7t3v3__fill_1
XFILLER_178_870 VDD VDD VSS VSS gf180mcu_as_sc_mcu7t3v3__fillcap_4
XFILLER_184_306 VDD VDD VSS VSS gf180mcu_as_sc_mcu7t3v3__fillcap_8
XFILLER_184_317 VDD VDD VSS VSS gf180mcu_as_sc_mcu7t3v3__fillcap_16
XFILLER_196_155 VDD VDD VSS VSS gf180mcu_as_sc_mcu7t3v3__fillcap_16
XFILLER_196_177 VDD VDD VSS VSS gf180mcu_as_sc_mcu7t3v3__fillcap_16
XFILLER_201_1418 VDD VDD VSS VSS gf180mcu_as_sc_mcu7t3v3__fillcap_16
XFILLER_32_1126 VDD VDD VSS VSS gf180mcu_as_sc_mcu7t3v3__fill_2
XFILLER_61_69 VDD VDD VSS VSS gf180mcu_as_sc_mcu7t3v3__fill_1
XFILLER_193_1208 VDD VDD VSS VSS gf180mcu_as_sc_mcu7t3v3__fillcap_16
XFILLER_192_394 VDD VDD VSS VSS gf180mcu_as_sc_mcu7t3v3__fillcap_4
XTAP_TAPCELL_ROW_189_2333 VDD VSS gf180mcu_as_sc_mcu7t3v3__tap_2
XTAP_TAPCELL_ROW_189_2322 VDD VSS gf180mcu_as_sc_mcu7t3v3__tap_2
XFILLER_180_589 VDD VDD VSS VSS gf180mcu_as_sc_mcu7t3v3__fillcap_4
XFILLER_0_920 VDD VDD VSS VSS gf180mcu_as_sc_mcu7t3v3__fill_1
Xclkbuf_regs_0_clk VDD VDD VSS VSS clk clkbuf_regs_0_clk/Y gf180mcu_as_sc_mcu7t3v3__clkbuff_12
XTAP_TAPCELL_ROW_210_2798 VDD VSS gf180mcu_as_sc_mcu7t3v3__tap_2
XTAP_TAPCELL_ROW_210_2787 VDD VSS gf180mcu_as_sc_mcu7t3v3__tap_2
XFILLER_0_997 VDD VDD VSS VSS gf180mcu_as_sc_mcu7t3v3__fillcap_4
XFILLER_120_177 VDD VDD VSS VSS gf180mcu_as_sc_mcu7t3v3__fillcap_16
XFILLER_134_1383 VDD VDD VSS VSS gf180mcu_as_sc_mcu7t3v3__fillcap_4
XFILLER_207_204 VDD VDD VSS VSS gf180mcu_as_sc_mcu7t3v3__fillcap_4
XFILLER_19_158 VDD VDD VSS VSS gf180mcu_as_sc_mcu7t3v3__fillcap_16
XFILLER_207_237 VDD VDD VSS VSS gf180mcu_as_sc_mcu7t3v3__fillcap_16
XFILLER_210_1260 VDD VDD VSS VSS gf180mcu_as_sc_mcu7t3v3__fill_1
XFILLER_21_1542 VDD VDD VSS VSS gf180mcu_as_sc_mcu7t3v3__fill_2
XFILLER_35_607 VDD VDD VSS VSS gf180mcu_as_sc_mcu7t3v3__fillcap_16
XFILLER_35_629 VDD VDD VSS VSS gf180mcu_as_sc_mcu7t3v3__fill_1
XTAP_TAPCELL_ROW_3_791 VDD VSS gf180mcu_as_sc_mcu7t3v3__tap_2
XFILLER_15_342 VDD VDD VSS VSS gf180mcu_as_sc_mcu7t3v3__fillcap_8
XFILLER_91_1518 VDD VDD VSS VSS gf180mcu_as_sc_mcu7t3v3__fillcap_8
XFILLER_176_807 VDD VDD VSS VSS gf180mcu_as_sc_mcu7t3v3__fillcap_4
XFILLER_188_645 VDD VDD VSS VSS gf180mcu_as_sc_mcu7t3v3__fillcap_16
XFILLER_188_667 VDD VDD VSS VSS gf180mcu_as_sc_mcu7t3v3__fillcap_16
XFILLER_203_454 VDD VDD VSS VSS gf180mcu_as_sc_mcu7t3v3__fillcap_16
XFILLER_206_1329 VDD VDD VSS VSS gf180mcu_as_sc_mcu7t3v3__fillcap_16
XFILLER_30_301 VDD VDD VSS VSS gf180mcu_as_sc_mcu7t3v3__fill_2
XFILLER_198_1119 VDD VDD VSS VSS gf180mcu_as_sc_mcu7t3v3__fillcap_16
XFILLER_89_1403 VDD VDD VSS VSS gf180mcu_as_sc_mcu7t3v3__fillcap_8
XFILLER_11_570 VDD VDD VSS VSS gf180mcu_as_sc_mcu7t3v3__fillcap_4
XFILLER_141_1376 VDD VDD VSS VSS gf180mcu_as_sc_mcu7t3v3__fill_2
XFILLER_184_873 VDD VDD VSS VSS gf180mcu_as_sc_mcu7t3v3__fill_2
XFILLER_51_91 VDD VDD VSS VSS gf180mcu_as_sc_mcu7t3v3__fillcap_16
XTAP_TAPCELL_ROW_174_1967 VDD VSS gf180mcu_as_sc_mcu7t3v3__tap_2
XFILLER_183_383 VDD VDD VSS VSS gf180mcu_as_sc_mcu7t3v3__fillcap_4
Xwire494 VDD VDD VSS VSS _3081_/Y wire494/Y gf180mcu_as_sc_mcu7t3v3__clkbuff_12
Xwire472 VDD VDD VSS VSS _3580_/Y _4840_/D gf180mcu_as_sc_mcu7t3v3__clkbuff_12
Xwire461 VDD VDD VSS VSS _3760_/Y _4864_/D gf180mcu_as_sc_mcu7t3v3__clkbuff_12
XTAP_TAPCELL_ROW_174_1989 VDD VSS gf180mcu_as_sc_mcu7t3v3__tap_2
XTAP_TAPCELL_ROW_174_1978 VDD VSS gf180mcu_as_sc_mcu7t3v3__tap_2
XFILLER_13_1092 VDD VDD VSS VSS gf180mcu_as_sc_mcu7t3v3__fill_1
XFILLER_183_394 VDD VDD VSS VSS gf180mcu_as_sc_mcu7t3v3__fillcap_16
X_3430_ VDD VDD VSS VSS _4078_/A _3467_/C _3445_/C _4081_/A _3431_/C gf180mcu_as_sc_mcu7t3v3__ao22_2
X_3361_ VDD VDD VSS VSS _3450_/B _4015_/A _3364_/C gf180mcu_as_sc_mcu7t3v3__and2_2
XFILLER_174_1174 VDD VDD VSS VSS gf180mcu_as_sc_mcu7t3v3__fillcap_16
X_5100_ VDD VDD VSS VSS _5260_/CLK _5100_/D _5100_/Q gf180mcu_as_sc_mcu7t3v3__dfxtp_2
XFILLER_6_1503 VDD VDD VSS VSS gf180mcu_as_sc_mcu7t3v3__fill_2
X_5031_ VDD VDD VSS VSS _5082_/CLK _5031_/D _5031_/Q gf180mcu_as_sc_mcu7t3v3__dfxtp_2
X_3292_ VDD VDD VSS VSS _3941_/A _3403_/S _3292_/C _3292_/D _3294_/C gf180mcu_as_sc_mcu7t3v3__ao211_2
XFILLER_26_1453 VDD VDD VSS VSS gf180mcu_as_sc_mcu7t3v3__fillcap_16
XFILLER_57_209 VDD VDD VSS VSS gf180mcu_as_sc_mcu7t3v3__fill_1
XFILLER_61_1355 VDD VDD VSS VSS gf180mcu_as_sc_mcu7t3v3__fillcap_16
XTAP_TAPCELL_ROW_14_1031 VDD VSS gf180mcu_as_sc_mcu7t3v3__tap_2
XTAP_TAPCELL_ROW_14_1042 VDD VSS gf180mcu_as_sc_mcu7t3v3__tap_2
XFILLER_113_1445 VDD VDD VSS VSS gf180mcu_as_sc_mcu7t3v3__fillcap_16
XFILLER_26_1486 VDD VDD VSS VSS gf180mcu_as_sc_mcu7t3v3__fillcap_16
XFILLER_61_1399 VDD VDD VSS VSS gf180mcu_as_sc_mcu7t3v3__fill_2
XFILLER_187_1524 VDD VDD VSS VSS gf180mcu_as_sc_mcu7t3v3__fillcap_16
XFILLER_202_53 VDD VDD VSS VSS gf180mcu_as_sc_mcu7t3v3__fillcap_16
XFILLER_4_1282 VDD VDD VSS VSS gf180mcu_as_sc_mcu7t3v3__fill_2
XFILLER_34_662 VDD VDD VSS VSS gf180mcu_as_sc_mcu7t3v3__fill_2
XFILLER_34_673 VDD VDD VSS VSS gf180mcu_as_sc_mcu7t3v3__fill_1
XFILLER_178_155 VDD VDD VSS VSS gf180mcu_as_sc_mcu7t3v3__fill_1
XFILLER_33_1402 VDD VDD VSS VSS gf180mcu_as_sc_mcu7t3v3__fillcap_16
X_4815_ VDD VDD VSS VSS _4919_/CLK _4815_/D _4815_/Q gf180mcu_as_sc_mcu7t3v3__dfxtp_2
XFILLER_178_177 VDD VDD VSS VSS gf180mcu_as_sc_mcu7t3v3__fillcap_8
XFILLER_21_356 VDD VDD VSS VSS gf180mcu_as_sc_mcu7t3v3__fill_1
XFILLER_72_1495 VDD VDD VSS VSS gf180mcu_as_sc_mcu7t3v3__fillcap_16
XFILLER_120_1405 VDD VDD VSS VSS gf180mcu_as_sc_mcu7t3v3__fillcap_16
XFILLER_179_1030 VDD VDD VSS VSS gf180mcu_as_sc_mcu7t3v3__fillcap_16
XFILLER_193_136 VDD VDD VSS VSS gf180mcu_as_sc_mcu7t3v3__fillcap_4
XFILLER_193_158 VDD VDD VSS VSS gf180mcu_as_sc_mcu7t3v3__fillcap_16
X_4746_ VDD VDD VSS VSS _4746_/A _4746_/B _4746_/C _4747_/C _4746_/D gf180mcu_as_sc_mcu7t3v3__aoi211_2
XFILLER_120_1449 VDD VDD VSS VSS gf180mcu_as_sc_mcu7t3v3__fill_2
XFILLER_179_1052 VDD VDD VSS VSS gf180mcu_as_sc_mcu7t3v3__fillcap_16
X_4677_ VDD VDD VSS VSS _5246_/Q _4685_/C _4681_/C _5247_/Q _4678_/C gf180mcu_as_sc_mcu7t3v3__ao22_2
XFILLER_194_1539 VDD VDD VSS VSS gf180mcu_as_sc_mcu7t3v3__fillcap_4
XFILLER_31_1192 VDD VDD VSS VSS gf180mcu_as_sc_mcu7t3v3__fill_2
X_3628_ VDD VDD VSS VSS _3629_/C _3997_/A _3761_/B _3628_/C gf180mcu_as_sc_mcu7t3v3__ao21_2
XFILLER_1_717 VDD VDD VSS VSS gf180mcu_as_sc_mcu7t3v3__fill_1
XTAP_TAPCELL_ROW_91_1_1717 VDD VSS gf180mcu_as_sc_mcu7t3v3__tap_2
XFILLER_163_38 VDD VDD VSS VSS gf180mcu_as_sc_mcu7t3v3__fillcap_16
X_3559_ VDD VDD VSS VSS _3559_/A _3922_/B _3559_/C _3559_/Y _3805_/B gf180mcu_as_sc_mcu7t3v3__aoi211_2
XFILLER_44_1520 VDD VDD VSS VSS gf180mcu_as_sc_mcu7t3v3__fill_1
Xinput106 VDD VDD VSS VSS ne_in[4] wire907/A gf180mcu_as_sc_mcu7t3v3__buff_12
Xinput117 VDD VDD VSS VSS north_in[14] _4045_/A gf180mcu_as_sc_mcu7t3v3__buff_12
XTAP_TAPCELL_ROW_184_2230 VDD VSS gf180mcu_as_sc_mcu7t3v3__tap_2
XFILLER_102_166 VDD VDD VSS VSS gf180mcu_as_sc_mcu7t3v3__fillcap_8
XFILLER_5_1013 VDD VDD VSS VSS gf180mcu_as_sc_mcu7t3v3__fillcap_16
X_5229_ VDD VDD VSS VSS _5241_/CLK _5229_/D _5229_/Q gf180mcu_as_sc_mcu7t3v3__dfxtp_2
Xinput128 VDD VDD VSS VSS north_in[24] _4129_/A gf180mcu_as_sc_mcu7t3v3__buff_12
Xinput139 VDD VDD VSS VSS north_in[3] _3959_/A gf180mcu_as_sc_mcu7t3v3__buff_12
XFILLER_186_6 VDD VDD VSS VSS gf180mcu_as_sc_mcu7t3v3__fillcap_16
XTAP_TAPCELL_ROW_180_2138 VDD VSS gf180mcu_as_sc_mcu7t3v3__tap_2
XTAP_TAPCELL_ROW_180_2127 VDD VSS gf180mcu_as_sc_mcu7t3v3__tap_2
XFILLER_29_489 VDD VDD VSS VSS gf180mcu_as_sc_mcu7t3v3__fill_1
XFILLER_56_69 VDD VDD VSS VSS gf180mcu_as_sc_mcu7t3v3__fillcap_16
XFILLER_5_1079 VDD VDD VSS VSS gf180mcu_as_sc_mcu7t3v3__fillcap_16
XTAP_TAPCELL_ROW_71_1_1659 VDD VSS gf180mcu_as_sc_mcu7t3v3__tap_2
XFILLER_71_212 VDD VDD VSS VSS gf180mcu_as_sc_mcu7t3v3__fillcap_8
XFILLER_25_640 VDD VDD VSS VSS gf180mcu_as_sc_mcu7t3v3__fillcap_4
XFILLER_12_334 VDD VDD VSS VSS gf180mcu_as_sc_mcu7t3v3__fillcap_16
XFILLER_164_1376 VDD VDD VSS VSS gf180mcu_as_sc_mcu7t3v3__fillcap_4
XTAP_TAPCELL_ROW_145_1_1880 VDD VSS gf180mcu_as_sc_mcu7t3v3__tap_2
XTAP_TAPCELL_ROW_178_2089 VDD VSS gf180mcu_as_sc_mcu7t3v3__tap_2
XTAP_TAPCELL_ROW_178_2078 VDD VSS gf180mcu_as_sc_mcu7t3v3__tap_2
XFILLER_169_188 VDD VDD VSS VSS gf180mcu_as_sc_mcu7t3v3__fillcap_8
XFILLER_197_486 VDD VDD VSS VSS gf180mcu_as_sc_mcu7t3v3__fillcap_4
XFILLER_200_457 VDD VDD VSS VSS gf180mcu_as_sc_mcu7t3v3__fillcap_16
XFILLER_36_1081 VDD VDD VSS VSS gf180mcu_as_sc_mcu7t3v3__fillcap_4
XTAP_TAPCELL_ROW_157_3_3192 VDD VSS gf180mcu_as_sc_mcu7t3v3__tap_2
XFILLER_51_1568 VDD VDD VSS VSS gf180mcu_as_sc_mcu7t3v3__fill_1
XFILLER_10_1243 VDD VDD VSS VSS gf180mcu_as_sc_mcu7t3v3__fillcap_4
XFILLER_181_854 VDD VDD VSS VSS gf180mcu_as_sc_mcu7t3v3__fill_1
XFILLER_21_50 VDD VDD VSS VSS gf180mcu_as_sc_mcu7t3v3__fillcap_16
XFILLER_101_1393 VDD VDD VSS VSS gf180mcu_as_sc_mcu7t3v3__fill_2
XFILLER_137_72 VDD VDD VSS VSS gf180mcu_as_sc_mcu7t3v3__fillcap_16
XFILLER_175_1450 VDD VDD VSS VSS gf180mcu_as_sc_mcu7t3v3__fillcap_4
XFILLER_181_898 VDD VDD VSS VSS gf180mcu_as_sc_mcu7t3v3__fillcap_8
XFILLER_175_1472 VDD VDD VSS VSS gf180mcu_as_sc_mcu7t3v3__fillcap_16
XFILLER_97_43 VDD VDD VSS VSS gf180mcu_as_sc_mcu7t3v3__fillcap_16
XFILLER_0_750 VDD VDD VSS VSS gf180mcu_as_sc_mcu7t3v3__fillcap_4
XFILLER_84_1399 VDD VDD VSS VSS gf180mcu_as_sc_mcu7t3v3__fillcap_16
XTAP_TAPCELL_ROW_40_3_2840 VDD VSS gf180mcu_as_sc_mcu7t3v3__tap_2
XFILLER_47_220 VDD VDD VSS VSS gf180mcu_as_sc_mcu7t3v3__fill_2
XFILLER_16_651 VDD VDD VSS VSS gf180mcu_as_sc_mcu7t3v3__fill_2
XFILLER_15_150 VDD VDD VSS VSS gf180mcu_as_sc_mcu7t3v3__fill_2
XFILLER_182_1421 VDD VDD VSS VSS gf180mcu_as_sc_mcu7t3v3__fill_2
XFILLER_56_1424 VDD VDD VSS VSS gf180mcu_as_sc_mcu7t3v3__fillcap_4
X_2930_ VDD VDD VSS VSS _2930_/Y _3216_/B _2930_/A gf180mcu_as_sc_mcu7t3v3__nor2_2
XFILLER_143_1405 VDD VDD VSS VSS gf180mcu_as_sc_mcu7t3v3__fillcap_8
XFILLER_188_453 VDD VDD VSS VSS gf180mcu_as_sc_mcu7t3v3__fill_2
XFILLER_189_976 VDD VDD VSS VSS gf180mcu_as_sc_mcu7t3v3__fillcap_4
XFILLER_189_998 VDD VDD VSS VSS gf180mcu_as_sc_mcu7t3v3__fillcap_16
XFILLER_204_785 VDD VDD VSS VSS gf180mcu_as_sc_mcu7t3v3__fillcap_16
XFILLER_31_632 VDD VDD VSS VSS gf180mcu_as_sc_mcu7t3v3__fillcap_4
XFILLER_56_1457 VDD VDD VSS VSS gf180mcu_as_sc_mcu7t3v3__fill_1
XFILLER_62_90 VDD VDD VSS VSS gf180mcu_as_sc_mcu7t3v3__fillcap_8
XFILLER_87_4 VDD VDD VSS VSS gf180mcu_as_sc_mcu7t3v3__fill_1
X_4600_ VDD VDD VSS VSS _5194_/Q _4750_/D _4604_/C _5195_/Q _5194_/D gf180mcu_as_sc_mcu7t3v3__ao22_2
X_2861_ VDD VDD VSS VSS _2871_/B _2861_/B _4733_/B gf180mcu_as_sc_mcu7t3v3__nand2_2
X_2792_ VDD VDD VSS VSS _4732_/C _2792_/A _5267_/Q _4732_/B _2793_/B gf180mcu_as_sc_mcu7t3v3__ao31_2
XFILLER_15_1165 VDD VDD VSS VSS gf180mcu_as_sc_mcu7t3v3__fillcap_8
XPHY_EDGE_ROW_142_1_Left_352 VDD VSS gf180mcu_as_sc_mcu7t3v3__tap_2
X_4531_ VDD VDD VSS VSS _5181_/Q _4592_/B _4531_/C _4531_/D _5181_/D gf180mcu_as_sc_mcu7t3v3__ao211_2
X_4462_ VDD VDD VSS VSS _4465_/C _4987_/Q _4483_/S gf180mcu_as_sc_mcu7t3v3__nand2b_2
XFILLER_131_206 VDD VDD VSS VSS gf180mcu_as_sc_mcu7t3v3__fillcap_4
X_3413_ VDD VDD VSS VSS _3467_/B _4064_/D _3413_/A _3415_/B gf180mcu_as_sc_mcu7t3v3__mux2_2
XFILLER_154_1523 VDD VDD VSS VSS gf180mcu_as_sc_mcu7t3v3__fillcap_16
XFILLER_28_1504 VDD VDD VSS VSS gf180mcu_as_sc_mcu7t3v3__fill_1
XFILLER_63_1406 VDD VDD VSS VSS gf180mcu_as_sc_mcu7t3v3__fillcap_8
XTAP_TAPCELL_ROW_101_3_3024 VDD VSS gf180mcu_as_sc_mcu7t3v3__tap_2
Xfanout807 VDD VDD VSS VSS fanout809/Y _4559_/S gf180mcu_as_sc_mcu7t3v3__buff_12
X_4393_ VDD VDD VSS VSS _4394_/D _4393_/B _4546_/A gf180mcu_as_sc_mcu7t3v3__nor2_2
XFILLER_154_1567 VDD VDD VSS VSS gf180mcu_as_sc_mcu7t3v3__fill_2
XFILLER_97_120 VDD VDD VSS VSS gf180mcu_as_sc_mcu7t3v3__fillcap_8
XFILLER_97_142 VDD VDD VSS VSS gf180mcu_as_sc_mcu7t3v3__fillcap_4
X_3344_ VDD VDD VSS VSS _3344_/B _3525_/A _4812_/D gf180mcu_as_sc_mcu7t3v3__and2_2
X_3275_ VDD VDD VSS VSS _3280_/D _3275_/B _3275_/A gf180mcu_as_sc_mcu7t3v3__nand2_2
XFILLER_22_1103 VDD VDD VSS VSS gf180mcu_as_sc_mcu7t3v3__fillcap_16
XFILLER_26_1294 VDD VDD VSS VSS gf180mcu_as_sc_mcu7t3v3__fill_1
X_5014_ VDD VDD VSS VSS _5085_/CLK _5014_/D _5014_/Q gf180mcu_as_sc_mcu7t3v3__dfxtp_2
XTAP_TAPCELL_ROW_33_1462 VDD VSS gf180mcu_as_sc_mcu7t3v3__tap_2
XTAP_TAPCELL_ROW_33_1451 VDD VSS gf180mcu_as_sc_mcu7t3v3__tap_2
XFILLER_187_1310 VDD VDD VSS VSS gf180mcu_as_sc_mcu7t3v3__fillcap_16
XFILLER_187_1332 VDD VDD VSS VSS gf180mcu_as_sc_mcu7t3v3__fillcap_16
XPHY_EDGE_ROW_118_3_Left_503 VDD VSS gf180mcu_as_sc_mcu7t3v3__tap_2
XFILLER_26_426 VDD VDD VSS VSS gf180mcu_as_sc_mcu7t3v3__fill_2
XFILLER_53_212 VDD VDD VSS VSS gf180mcu_as_sc_mcu7t3v3__fillcap_8
XFILLER_199_718 VDD VDD VSS VSS gf180mcu_as_sc_mcu7t3v3__fillcap_16
XFILLER_26_448 VDD VDD VSS VSS gf180mcu_as_sc_mcu7t3v3__fillcap_4
XFILLER_35_982 VDD VDD VSS VSS gf180mcu_as_sc_mcu7t3v3__fillcap_16
XFILLER_161_1505 VDD VDD VSS VSS gf180mcu_as_sc_mcu7t3v3__fill_1
XFILLER_74_1568 VDD VDD VSS VSS gf180mcu_as_sc_mcu7t3v3__fill_1
XFILLER_210_755 VDD VDD VSS VSS gf180mcu_as_sc_mcu7t3v3__fillcap_4
XFILLER_21_142 VDD VDD VSS VSS gf180mcu_as_sc_mcu7t3v3__fillcap_16
XFILLER_42_27 VDD VDD VSS VSS gf180mcu_as_sc_mcu7t3v3__fillcap_8
XFILLER_210_777 VDD VDD VSS VSS gf180mcu_as_sc_mcu7t3v3__fill_1
XFILLER_210_788 VDD VDD VSS VSS gf180mcu_as_sc_mcu7t3v3__fill_2
XFILLER_33_1254 VDD VDD VSS VSS gf180mcu_as_sc_mcu7t3v3__fillcap_4
XPHY_EDGE_ROW_74_1_Left_284 VDD VSS gf180mcu_as_sc_mcu7t3v3__tap_2
XFILLER_182_629 VDD VDD VSS VSS gf180mcu_as_sc_mcu7t3v3__fillcap_16
XFILLER_194_489 VDD VDD VSS VSS gf180mcu_as_sc_mcu7t3v3__fillcap_16
X_4729_ VDD VDD VSS VSS _5265_/D _5265_/Q _4730_/C _4729_/C gf180mcu_as_sc_mcu7t3v3__ao21_2
XTAP_TAPCELL_ROW_45_3_2855 VDD VSS gf180mcu_as_sc_mcu7t3v3__tap_2
XFILLER_107_31 VDD VDD VSS VSS gf180mcu_as_sc_mcu7t3v3__fillcap_16
XFILLER_27_1014 VDD VDD VSS VSS gf180mcu_as_sc_mcu7t3v3__fillcap_16
XFILLER_81_1517 VDD VDD VSS VSS gf180mcu_as_sc_mcu7t3v3__fill_1
XFILLER_88_131 VDD VDD VSS VSS gf180mcu_as_sc_mcu7t3v3__fill_2
XFILLER_27_1047 VDD VDD VSS VSS gf180mcu_as_sc_mcu7t3v3__fill_2
XTAP_TAPCELL_ROW_5_831 VDD VSS gf180mcu_as_sc_mcu7t3v3__tap_2
XFILLER_29_220 VDD VDD VSS VSS gf180mcu_as_sc_mcu7t3v3__fill_2
XFILLER_44_1383 VDD VDD VSS VSS gf180mcu_as_sc_mcu7t3v3__fillcap_16
XFILLER_67_68 VDD VDD VSS VSS gf180mcu_as_sc_mcu7t3v3__fill_2
XTAP_TAPCELL_ROW_5_842 VDD VSS gf180mcu_as_sc_mcu7t3v3__tap_2
XFILLER_190_69 VDD VDD VSS VSS gf180mcu_as_sc_mcu7t3v3__fillcap_16
XFILLER_79_1413 VDD VDD VSS VSS gf180mcu_as_sc_mcu7t3v3__fill_2
XFILLER_123_85 VDD VDD VSS VSS gf180mcu_as_sc_mcu7t3v3__fillcap_8
XPHY_EDGE_ROW_102_3_Left_487 VDD VSS gf180mcu_as_sc_mcu7t3v3__tap_2
XTAP_TAPCELL_ROW_205_2675 VDD VSS gf180mcu_as_sc_mcu7t3v3__tap_2
XTAP_TAPCELL_ROW_205_2686 VDD VSS gf180mcu_as_sc_mcu7t3v3__tap_2
XFILLER_16_61 VDD VDD VSS VSS gf180mcu_as_sc_mcu7t3v3__fill_2
XFILLER_207_1402 VDD VDD VSS VSS gf180mcu_as_sc_mcu7t3v3__fillcap_16
XFILLER_26_971 VDD VDD VSS VSS gf180mcu_as_sc_mcu7t3v3__fill_2
XFILLER_32_429 VDD VDD VSS VSS gf180mcu_as_sc_mcu7t3v3__fillcap_8
XFILLER_13_632 VDD VDD VSS VSS gf180mcu_as_sc_mcu7t3v3__fillcap_16
XFILLER_16_94 VDD VDD VSS VSS gf180mcu_as_sc_mcu7t3v3__fill_1
XFILLER_25_492 VDD VDD VSS VSS gf180mcu_as_sc_mcu7t3v3__fillcap_8
XTAP_TAPCELL_ROW_197_2498 VDD VSS gf180mcu_as_sc_mcu7t3v3__tap_2
XFILLER_103_1400 VDD VDD VSS VSS gf180mcu_as_sc_mcu7t3v3__fillcap_16
XFILLER_157_136 VDD VDD VSS VSS gf180mcu_as_sc_mcu7t3v3__fillcap_4
XFILLER_186_979 VDD VDD VSS VSS gf180mcu_as_sc_mcu7t3v3__fillcap_16
XFILLER_201_766 VDD VDD VSS VSS gf180mcu_as_sc_mcu7t3v3__fillcap_4
XFILLER_201_788 VDD VDD VSS VSS gf180mcu_as_sc_mcu7t3v3__fillcap_8
XFILLER_205_1170 VDD VDD VSS VSS gf180mcu_as_sc_mcu7t3v3__fillcap_16
XTAP_TAPCELL_ROW_106_3_3039 VDD VSS gf180mcu_as_sc_mcu7t3v3__tap_2
XFILLER_142_1471 VDD VDD VSS VSS gf180mcu_as_sc_mcu7t3v3__fill_1
XFILLER_205_1192 VDD VDD VSS VSS gf180mcu_as_sc_mcu7t3v3__fillcap_16
XFILLER_103_1466 VDD VDD VSS VSS gf180mcu_as_sc_mcu7t3v3__fillcap_8
XFILLER_103_1488 VDD VDD VSS VSS gf180mcu_as_sc_mcu7t3v3__fillcap_16
XFILLER_177_1512 VDD VDD VSS VSS gf180mcu_as_sc_mcu7t3v3__fill_2
XFILLER_51_1398 VDD VDD VSS VSS gf180mcu_as_sc_mcu7t3v3__fillcap_16
XFILLER_10_1095 VDD VDD VSS VSS gf180mcu_as_sc_mcu7t3v3__fillcap_16
XFILLER_175_1280 VDD VDD VSS VSS gf180mcu_as_sc_mcu7t3v3__fillcap_4
XFILLER_79_142 VDD VDD VSS VSS gf180mcu_as_sc_mcu7t3v3__fillcap_8
XTAP_TAPCELL_ROW_71_3_2934 VDD VSS gf180mcu_as_sc_mcu7t3v3__tap_2
XFILLER_0_580 VDD VDD VSS VSS gf180mcu_as_sc_mcu7t3v3__fillcap_4
XFILLER_209_800 VDD VDD VSS VSS gf180mcu_as_sc_mcu7t3v3__fill_1
XFILLER_94_123 VDD VDD VSS VSS gf180mcu_as_sc_mcu7t3v3__fillcap_16
X_3060_ VDD VDD VSS VSS _4039_/A _3127_/B _3127_/C _4040_/D _3061_/C gf180mcu_as_sc_mcu7t3v3__ao22_2
XFILLER_3_1528 VDD VDD VSS VSS gf180mcu_as_sc_mcu7t3v3__fillcap_8
XFILLER_208_376 VDD VDD VSS VSS gf180mcu_as_sc_mcu7t3v3__fillcap_8
XFILLER_208_387 VDD VDD VSS VSS gf180mcu_as_sc_mcu7t3v3__fillcap_16
XFILLER_97_1568 VDD VDD VSS VSS gf180mcu_as_sc_mcu7t3v3__fill_1
XFILLER_17_982 VDD VDD VSS VSS gf180mcu_as_sc_mcu7t3v3__fillcap_4
XFILLER_35_278 VDD VDD VSS VSS gf180mcu_as_sc_mcu7t3v3__fill_2
XFILLER_147_1371 VDD VDD VSS VSS gf180mcu_as_sc_mcu7t3v3__fill_2
XFILLER_32_941 VDD VDD VSS VSS gf180mcu_as_sc_mcu7t3v3__fillcap_4
X_3962_ VDD VDD VSS VSS _3962_/A _4027_/B _3962_/C _3962_/D _3963_/B gf180mcu_as_sc_mcu7t3v3__ao22_2
XFILLER_176_412 VDD VDD VSS VSS gf180mcu_as_sc_mcu7t3v3__fillcap_4
XFILLER_17_1249 VDD VDD VSS VSS gf180mcu_as_sc_mcu7t3v3__fillcap_8
XFILLER_32_963 VDD VDD VSS VSS gf180mcu_as_sc_mcu7t3v3__fillcap_8
XPHY_EDGE_ROW_130_1_Right_651 VDD VSS gf180mcu_as_sc_mcu7t3v3__tap_2
XPHY_EDGE_ROW_96_3_Left_481 VDD VSS gf180mcu_as_sc_mcu7t3v3__tap_2
X_3893_ VDD VDD VSS VSS _3893_/B _5183_/Q _4933_/D gf180mcu_as_sc_mcu7t3v3__and2_2
X_2913_ VDD VDD VSS VSS _3788_/D _3796_/D _3544_/C gf180mcu_as_sc_mcu7t3v3__or2_2
X_2844_ VDD VDD VSS VSS _4746_/A _4746_/B _2844_/C _4746_/D _2856_/A gf180mcu_as_sc_mcu7t3v3__ao211_2
XFILLER_121_1511 VDD VDD VSS VSS gf180mcu_as_sc_mcu7t3v3__fill_2
XFILLER_176_489 VDD VDD VSS VSS gf180mcu_as_sc_mcu7t3v3__fill_1
XFILLER_121_1566 VDD VDD VSS VSS gf180mcu_as_sc_mcu7t3v3__fill_2
XFILLER_176_1011 VDD VDD VSS VSS gf180mcu_as_sc_mcu7t3v3__fillcap_4
XFILLER_191_459 VDD VDD VSS VSS gf180mcu_as_sc_mcu7t3v3__fillcap_16
XFILLER_30_1449 VDD VDD VSS VSS gf180mcu_as_sc_mcu7t3v3__fillcap_16
X_4514_ VDD VDD VSS VSS _5181_/Q _4575_/B _4532_/C _5115_/Q _4515_/B gf180mcu_as_sc_mcu7t3v3__ao22_2
X_2775_ VDD VDD VSS VSS _5232_/Q _5231_/Q _5229_/Q _2776_/B gf180mcu_as_sc_mcu7t3v3__nor3_2
XFILLER_176_1033 VDD VDD VSS VSS gf180mcu_as_sc_mcu7t3v3__fillcap_16
XFILLER_171_161 VDD VDD VSS VSS gf180mcu_as_sc_mcu7t3v3__fill_2
XFILLER_208_85 VDD VDD VSS VSS gf180mcu_as_sc_mcu7t3v3__fillcap_16
X_4445_ VDD VDD VSS VSS _4449_/B _5072_/Q _4579_/S gf180mcu_as_sc_mcu7t3v3__nand2_2
XFILLER_144_18 VDD VDD VSS VSS gf180mcu_as_sc_mcu7t3v3__fillcap_16
XFILLER_28_1323 VDD VDD VSS VSS gf180mcu_as_sc_mcu7t3v3__fill_1
XTAP_TAPCELL_ROW_120_1_1806 VDD VSS gf180mcu_as_sc_mcu7t3v3__tap_2
XTAP_TAPCELL_ROW_132_3_3118 VDD VSS gf180mcu_as_sc_mcu7t3v3__tap_2
Xfanout604 VDD VDD VSS VSS _3897_/B _3893_/B gf180mcu_as_sc_mcu7t3v3__buff_12
Xfanout615 VDD VDD VSS VSS _2928_/Y _3229_/B gf180mcu_as_sc_mcu7t3v3__buff_12
X_4376_ VDD VDD VSS VSS _4379_/B _4376_/B _5163_/Q _5163_/D gf180mcu_as_sc_mcu7t3v3__mux2_2
XTAP_TAPCELL_ROW_35_1502 VDD VSS gf180mcu_as_sc_mcu7t3v3__tap_2
XFILLER_154_1364 VDD VDD VSS VSS gf180mcu_as_sc_mcu7t3v3__fillcap_4
XFILLER_28_1367 VDD VDD VSS VSS gf180mcu_as_sc_mcu7t3v3__fillcap_8
Xfanout626 VDD VDD VSS VSS wire628/Y _4118_/C gf180mcu_as_sc_mcu7t3v3__buff_12
Xfanout637 VDD VDD VSS VSS _3563_/Y _3779_/B gf180mcu_as_sc_mcu7t3v3__buff_12
Xfanout648 VDD VDD VSS VSS _3451_/B _3404_/B gf180mcu_as_sc_mcu7t3v3__buff_12
X_3327_ VDD VDD VSS VSS _3608_/A _3416_/B _3327_/C _4810_/D _3416_/D gf180mcu_as_sc_mcu7t3v3__aoi211_2
XFILLER_85_123 VDD VDD VSS VSS gf180mcu_as_sc_mcu7t3v3__fillcap_4
Xfanout659 VDD VDD VSS VSS _2930_/Y _3125_/C gf180mcu_as_sc_mcu7t3v3__buff_12
XFILLER_27_702 VDD VDD VSS VSS gf180mcu_as_sc_mcu7t3v3__fillcap_16
XFILLER_37_27 VDD VDD VSS VSS gf180mcu_as_sc_mcu7t3v3__fillcap_16
X_3258_ VDD VDD VSS VSS _3263_/A _3271_/A _3271_/B gf180mcu_as_sc_mcu7t3v3__nor2b_2
XFILLER_85_178 VDD VDD VSS VSS gf180mcu_as_sc_mcu7t3v3__fill_1
XFILLER_85_189 VDD VDD VSS VSS gf180mcu_as_sc_mcu7t3v3__fillcap_8
X_3189_ VDD VDD VSS VSS _3239_/A _3216_/C _3238_/C gf180mcu_as_sc_mcu7t3v3__or2_2
XFILLER_27_746 VDD VDD VSS VSS gf180mcu_as_sc_mcu7t3v3__fill_1
XFILLER_27_757 VDD VDD VSS VSS gf180mcu_as_sc_mcu7t3v3__fillcap_8
XFILLER_186_209 VDD VDD VSS VSS gf180mcu_as_sc_mcu7t3v3__fill_2
XTAP_TAPCELL_ROW_175_2015 VDD VSS gf180mcu_as_sc_mcu7t3v3__tap_2
XFILLER_35_1327 VDD VDD VSS VSS gf180mcu_as_sc_mcu7t3v3__fill_2
XTAP_TAPCELL_ROW_66_1_1643 VDD VSS gf180mcu_as_sc_mcu7t3v3__tap_2
XTAP_TAPCELL_ROW_200_2583 VDD VSS gf180mcu_as_sc_mcu7t3v3__tap_2
XTAP_TAPCELL_ROW_200_2572 VDD VSS gf180mcu_as_sc_mcu7t3v3__tap_2
XTAP_TAPCELL_ROW_175_2026 VDD VSS gf180mcu_as_sc_mcu7t3v3__tap_2
XFILLER_10_613 VDD VDD VSS VSS gf180mcu_as_sc_mcu7t3v3__fill_2
XFILLER_139_136 VDD VDD VSS VSS gf180mcu_as_sc_mcu7t3v3__fillcap_4
XFILLER_194_242 VDD VDD VSS VSS gf180mcu_as_sc_mcu7t3v3__fill_2
XFILLER_139_158 VDD VDD VSS VSS gf180mcu_as_sc_mcu7t3v3__fillcap_16
XFILLER_210_585 VDD VDD VSS VSS gf180mcu_as_sc_mcu7t3v3__fillcap_4
XTAP_TAPCELL_ROW_192_2395 VDD VSS gf180mcu_as_sc_mcu7t3v3__tap_2
XFILLER_194_297 VDD VDD VSS VSS gf180mcu_as_sc_mcu7t3v3__fillcap_16
XTAP_TAPCELL_ROW_76_3_2949 VDD VSS gf180mcu_as_sc_mcu7t3v3__tap_2
XFILLER_118_41 VDD VDD VSS VSS gf180mcu_as_sc_mcu7t3v3__fill_2
XFILLER_191_960 VDD VDD VSS VSS gf180mcu_as_sc_mcu7t3v3__fillcap_16
XFILLER_198_1291 VDD VDD VSS VSS gf180mcu_as_sc_mcu7t3v3__fillcap_4
XFILLER_191_982 VDD VDD VSS VSS gf180mcu_as_sc_mcu7t3v3__fillcap_16
XFILLER_85_1450 VDD VDD VSS VSS gf180mcu_as_sc_mcu7t3v3__fill_1
XFILLER_46_1423 VDD VDD VSS VSS gf180mcu_as_sc_mcu7t3v3__fillcap_16
XFILLER_78_45 VDD VDD VSS VSS gf180mcu_as_sc_mcu7t3v3__fillcap_16
XFILLER_172_1453 VDD VDD VSS VSS gf180mcu_as_sc_mcu7t3v3__fillcap_8
XFILLER_76_123 VDD VDD VSS VSS gf180mcu_as_sc_mcu7t3v3__fillcap_16
XTAP_TAPCELL_ROW_207_2726 VDD VSS gf180mcu_as_sc_mcu7t3v3__tap_2
XFILLER_134_73 VDD VDD VSS VSS gf180mcu_as_sc_mcu7t3v3__fillcap_16
Xmesh_tile_1003 VDD VDD VSS VSS nw_out[10] gf180mcu_as_sc_mcu7t3v3__tiel_4
Xmesh_tile_1014 VDD VDD VSS VSS nw_out[21] gf180mcu_as_sc_mcu7t3v3__tiel_4
Xmesh_tile_1025 VDD VDD VSS VSS nw_out[32] gf180mcu_as_sc_mcu7t3v3__tiel_4
XTAP_TAPCELL_ROW_207_2737 VDD VSS gf180mcu_as_sc_mcu7t3v3__tap_2
XFILLER_17_212 VDD VDD VSS VSS gf180mcu_as_sc_mcu7t3v3__fillcap_16
XFILLER_94_77 VDD VDD VSS VSS gf180mcu_as_sc_mcu7t3v3__fillcap_4
Xmesh_tile_1058 VDD VDD VSS VSS sw_out[31] gf180mcu_as_sc_mcu7t3v3__tiel_4
Xmesh_tile_1047 VDD VDD VSS VSS sw_out[20] gf180mcu_as_sc_mcu7t3v3__tiel_4
Xmesh_tile_1036 VDD VDD VSS VSS sw_out[9] gf180mcu_as_sc_mcu7t3v3__tiel_4
XFILLER_91_137 VDD VDD VSS VSS gf180mcu_as_sc_mcu7t3v3__fill_2
XTAP_TAPCELL_ROW_199_2549 VDD VSS gf180mcu_as_sc_mcu7t3v3__tap_2
XFILLER_17_278 VDD VDD VSS VSS gf180mcu_as_sc_mcu7t3v3__fill_2
XFILLER_205_346 VDD VDD VSS VSS gf180mcu_as_sc_mcu7t3v3__fillcap_4
XFILLER_32_204 VDD VDD VSS VSS gf180mcu_as_sc_mcu7t3v3__fillcap_16
XFILLER_92_1410 VDD VDD VSS VSS gf180mcu_as_sc_mcu7t3v3__fillcap_8
XFILLER_205_368 VDD VDD VSS VSS gf180mcu_as_sc_mcu7t3v3__fillcap_16
XFILLER_57_1552 VDD VDD VSS VSS gf180mcu_as_sc_mcu7t3v3__fillcap_4
XFILLER_53_1405 VDD VDD VSS VSS gf180mcu_as_sc_mcu7t3v3__fillcap_8
XFILLER_9_400 VDD VDD VSS VSS gf180mcu_as_sc_mcu7t3v3__fillcap_16
XFILLER_9_422 VDD VDD VSS VSS gf180mcu_as_sc_mcu7t3v3__fillcap_16
XFILLER_16_1282 VDD VDD VSS VSS gf180mcu_as_sc_mcu7t3v3__fillcap_8
XFILLER_12_1168 VDD VDD VSS VSS gf180mcu_as_sc_mcu7t3v3__fill_2
XFILLER_177_1320 VDD VDD VSS VSS gf180mcu_as_sc_mcu7t3v3__fillcap_8
X_2560_ VDD VDD VSS VSS _2560_/Y _2831_/B _4952_/D gf180mcu_as_sc_mcu7t3v3__nor2b_2
X_2491_ VDD VDD VSS VSS _4649_/A _5269_/Q _4371_/A gf180mcu_as_sc_mcu7t3v3__nor2b_2
XTAP_TAPCELL_ROW_92_1_1722 VDD VSS gf180mcu_as_sc_mcu7t3v3__tap_2
XFILLER_138_1348 VDD VDD VSS VSS gf180mcu_as_sc_mcu7t3v3__fillcap_16
XFILLER_181_492 VDD VDD VSS VSS gf180mcu_as_sc_mcu7t3v3__fillcap_16
X_4230_ VDD VDD VSS VSS _4253_/S _4230_/B _5066_/Q _5066_/D gf180mcu_as_sc_mcu7t3v3__mux2_2
XFILLER_151_1504 VDD VDD VSS VSS gf180mcu_as_sc_mcu7t3v3__fill_2
XFILLER_190_1531 VDD VDD VSS VSS gf180mcu_as_sc_mcu7t3v3__fill_2
XFILLER_64_1534 VDD VDD VSS VSS gf180mcu_as_sc_mcu7t3v3__fillcap_4
X_4161_ VDD VDD VSS VSS _4161_/A _4161_/B _4161_/C _4161_/D _4163_/C gf180mcu_as_sc_mcu7t3v3__ao211_2
X_4092_ VDD VDD VSS VSS _4997_/Q _4166_/B _4248_/B _4166_/D _4997_/D gf180mcu_as_sc_mcu7t3v3__ao22_2
X_3112_ VDD VDD VSS VSS _3145_/A _3112_/B _3112_/C _3145_/D _3113_/D gf180mcu_as_sc_mcu7t3v3__ao211_2
XFILLER_208_140 VDD VDD VSS VSS gf180mcu_as_sc_mcu7t3v3__fill_1
XFILLER_82_104 VDD VDD VSS VSS gf180mcu_as_sc_mcu7t3v3__fill_1
X_3043_ VDD VDD VSS VSS _3126_/S _4021_/D _4024_/A _3045_/B gf180mcu_as_sc_mcu7t3v3__mux2_2
XFILLER_184_1313 VDD VDD VSS VSS gf180mcu_as_sc_mcu7t3v3__fillcap_16
XFILLER_188_1471 VDD VDD VSS VSS gf180mcu_as_sc_mcu7t3v3__fill_1
XFILLER_209_696 VDD VDD VSS VSS gf180mcu_as_sc_mcu7t3v3__fillcap_4
XFILLER_36_543 VDD VDD VSS VSS gf180mcu_as_sc_mcu7t3v3__fill_1
X_4994_ VDD VDD VSS VSS _5095_/CLK _4994_/D _4994_/Q gf180mcu_as_sc_mcu7t3v3__dfxtp_2
XFILLER_23_259 VDD VDD VSS VSS gf180mcu_as_sc_mcu7t3v3__fillcap_16
X_3945_ VDD VDD VSS VSS _4230_/B _3945_/B _4124_/D gf180mcu_as_sc_mcu7t3v3__nor2_2
XTAP_TAPCELL_ROW_28_1350 VDD VSS gf180mcu_as_sc_mcu7t3v3__tap_2
XFILLER_182_1081 VDD VDD VSS VSS gf180mcu_as_sc_mcu7t3v3__fillcap_4
XFILLER_210_86 VDD VDD VSS VSS gf180mcu_as_sc_mcu7t3v3__fillcap_16
XPHY_EDGE_ROW_131_1_Right_652 VDD VSS gf180mcu_as_sc_mcu7t3v3__tap_2
XFILLER_176_253 VDD VDD VSS VSS gf180mcu_as_sc_mcu7t3v3__fillcap_16
XFILLER_17_1068 VDD VDD VSS VSS gf180mcu_as_sc_mcu7t3v3__fillcap_16
X_3876_ VDD VDD VSS VSS _3890_/B _5166_/Q _4916_/D gf180mcu_as_sc_mcu7t3v3__and2_2
XTAP_TAPCELL_ROW_24_1269 VDD VSS gf180mcu_as_sc_mcu7t3v3__tap_2
XTAP_TAPCELL_ROW_24_1258 VDD VSS gf180mcu_as_sc_mcu7t3v3__tap_2
XFILLER_176_297 VDD VDD VSS VSS gf180mcu_as_sc_mcu7t3v3__fill_1
XFILLER_191_212 VDD VDD VSS VSS gf180mcu_as_sc_mcu7t3v3__fillcap_16
X_2827_ VDD VDD VSS VSS _4975_/D _2827_/B _5282_/Q _5281_/D gf180mcu_as_sc_mcu7t3v3__mux2_2
XFILLER_30_1257 VDD VDD VSS VSS gf180mcu_as_sc_mcu7t3v3__fill_1
X_2758_ VDD VDD VSS VSS _4633_/A _5233_/Q _2806_/D _2809_/B _2795_/A gf180mcu_as_sc_mcu7t3v3__aoi211_2
XPHY_EDGE_ROW_105_1_Left_315 VDD VSS gf180mcu_as_sc_mcu7t3v3__tap_2
XTAP_TAPCELL_ROW_151_3_3173 VDD VSS gf180mcu_as_sc_mcu7t3v3__tap_2
X_4428_ VDD VDD VSS VSS _4431_/C _4983_/Q _4509_/S gf180mcu_as_sc_mcu7t3v3__nand2b_2
X_2689_ VDD VDD VSS VSS _5158_/Q _4267_/S _4279_/S _5182_/Q _2690_/C gf180mcu_as_sc_mcu7t3v3__ao22_2
XFILLER_48_37 VDD VDD VSS VSS gf180mcu_as_sc_mcu7t3v3__fillcap_4
X_4359_ VDD VDD VSS VSS _4364_/B _4364_/A _4360_/A gf180mcu_as_sc_mcu7t3v3__xnor2_2
XFILLER_189_1224 VDD VDD VSS VSS gf180mcu_as_sc_mcu7t3v3__fillcap_16
XFILLER_58_145 VDD VDD VSS VSS gf180mcu_as_sc_mcu7t3v3__fillcap_4
XFILLER_80_1380 VDD VDD VSS VSS gf180mcu_as_sc_mcu7t3v3__fill_1
XFILLER_104_32 VDD VDD VSS VSS gf180mcu_as_sc_mcu7t3v3__fill_2
XFILLER_132_1481 VDD VDD VSS VSS gf180mcu_as_sc_mcu7t3v3__fill_1
XFILLER_73_104 VDD VDD VSS VSS gf180mcu_as_sc_mcu7t3v3__fillcap_16
XFILLER_199_301 VDD VDD VSS VSS gf180mcu_as_sc_mcu7t3v3__fillcap_16
XTAP_TAPCELL_ROW_202_2612 VDD VSS gf180mcu_as_sc_mcu7t3v3__tap_2
XFILLER_15_716 VDD VDD VSS VSS gf180mcu_as_sc_mcu7t3v3__fill_1
XTAP_TAPCELL_ROW_202_2623 VDD VSS gf180mcu_as_sc_mcu7t3v3__tap_2
XFILLER_167_1566 VDD VDD VSS VSS gf180mcu_as_sc_mcu7t3v3__fill_2
XFILLER_120_53 VDD VDD VSS VSS gf180mcu_as_sc_mcu7t3v3__fillcap_16
XFILLER_159_209 VDD VDD VSS VSS gf180mcu_as_sc_mcu7t3v3__fill_1
XFILLER_202_349 VDD VDD VSS VSS gf180mcu_as_sc_mcu7t3v3__fillcap_16
XFILLER_208_1563 VDD VDD VSS VSS gf180mcu_as_sc_mcu7t3v3__fillcap_4
XTAP_TAPCELL_ROW_194_2446 VDD VSS gf180mcu_as_sc_mcu7t3v3__tap_2
XTAP_TAPCELL_ROW_194_2435 VDD VSS gf180mcu_as_sc_mcu7t3v3__tap_2
XFILLER_167_220 VDD VDD VSS VSS gf180mcu_as_sc_mcu7t3v3__fill_2
XFILLER_195_540 VDD VDD VSS VSS gf180mcu_as_sc_mcu7t3v3__fillcap_16
XFILLER_35_1146 VDD VDD VSS VSS gf180mcu_as_sc_mcu7t3v3__fill_1
XTAP_TAPCELL_ROW_97_1_1737 VDD VSS gf180mcu_as_sc_mcu7t3v3__tap_2
XFILLER_183_702 VDD VDD VSS VSS gf180mcu_as_sc_mcu7t3v3__fillcap_8
XFILLER_195_562 VDD VDD VSS VSS gf180mcu_as_sc_mcu7t3v3__fillcap_16
XFILLER_210_382 VDD VDD VSS VSS gf180mcu_as_sc_mcu7t3v3__fill_1
XFILLER_13_1422 VDD VDD VSS VSS gf180mcu_as_sc_mcu7t3v3__fill_1
XFILLER_183_757 VDD VDD VSS VSS gf180mcu_as_sc_mcu7t3v3__fillcap_8
XFILLER_202_1151 VDD VDD VSS VSS gf180mcu_as_sc_mcu7t3v3__fillcap_4
Xwire835 VDD VDD VSS VSS wire835/A _4000_/A gf180mcu_as_sc_mcu7t3v3__clkbuff_12
Xwire846 VDD VDD VSS VSS wire846/A _4130_/A gf180mcu_as_sc_mcu7t3v3__clkbuff_12
Xwire857 VDD VDD VSS VSS wire857/A _3933_/A gf180mcu_as_sc_mcu7t3v3__clkbuff_12
Xwire868 VDD VDD VSS VSS wire868/A _3985_/A gf180mcu_as_sc_mcu7t3v3__clkbuff_12
XFILLER_100_1403 VDD VDD VSS VSS gf180mcu_as_sc_mcu7t3v3__fill_1
XFILLER_202_1173 VDD VDD VSS VSS gf180mcu_as_sc_mcu7t3v3__fillcap_16
Xwire879 VDD VDD VSS VSS wire879/A _4049_/A gf180mcu_as_sc_mcu7t3v3__clkbuff_12
XFILLER_100_1447 VDD VDD VSS VSS gf180mcu_as_sc_mcu7t3v3__fillcap_4
XFILLER_89_88 VDD VDD VSS VSS gf180mcu_as_sc_mcu7t3v3__fillcap_16
XFILLER_145_72 VDD VDD VSS VSS gf180mcu_as_sc_mcu7t3v3__fillcap_16
XPHY_EDGE_ROW_189_Right_52 VDD VSS gf180mcu_as_sc_mcu7t3v3__tap_2
XFILLER_18_510 VDD VDD VSS VSS gf180mcu_as_sc_mcu7t3v3__fill_2
XFILLER_18_543 VDD VDD VSS VSS gf180mcu_as_sc_mcu7t3v3__fillcap_4
XFILLER_20_1437 VDD VDD VSS VSS gf180mcu_as_sc_mcu7t3v3__fillcap_4
XPHY_EDGE_ROW_151_1_Left_361 VDD VSS gf180mcu_as_sc_mcu7t3v3__tap_2
XFILLER_178_507 VDD VDD VSS VSS gf180mcu_as_sc_mcu7t3v3__fill_1
XFILLER_199_890 VDD VDD VSS VSS gf180mcu_as_sc_mcu7t3v3__fillcap_16
XFILLER_206_699 VDD VDD VSS VSS gf180mcu_as_sc_mcu7t3v3__fillcap_16
XFILLER_33_557 VDD VDD VSS VSS gf180mcu_as_sc_mcu7t3v3__fill_2
XFILLER_54_91 VDD VDD VSS VSS gf180mcu_as_sc_mcu7t3v3__fillcap_8
XFILLER_72_192 VDD VDD VSS VSS gf180mcu_as_sc_mcu7t3v3__fill_1
XPHY_EDGE_ROW_198_Right_61 VDD VSS gf180mcu_as_sc_mcu7t3v3__tap_2
X_3730_ VDD VDD VSS VSS _3730_/D _3730_/A _3730_/B _3730_/C _3731_/C gf180mcu_as_sc_mcu7t3v3__ao31_2
XFILLER_14_1219 VDD VDD VSS VSS gf180mcu_as_sc_mcu7t3v3__fillcap_4
XTAP_TAPCELL_ROW_144_1_1876 VDD VSS gf180mcu_as_sc_mcu7t3v3__tap_2
XTAP_TAPCELL_ROW_156_3_3188 VDD VSS gf180mcu_as_sc_mcu7t3v3__tap_2
XFILLER_118_139 VDD VDD VSS VSS gf180mcu_as_sc_mcu7t3v3__fillcap_4
XFILLER_173_212 VDD VDD VSS VSS gf180mcu_as_sc_mcu7t3v3__fillcap_8
XFILLER_179_1426 VDD VDD VSS VSS gf180mcu_as_sc_mcu7t3v3__fillcap_4
XFILLER_31_1511 VDD VDD VSS VSS gf180mcu_as_sc_mcu7t3v3__fill_2
X_3661_ VDD VDD VSS VSS _3661_/A _3661_/B _3661_/C _3661_/Y _3661_/D gf180mcu_as_sc_mcu7t3v3__aoi211_2
XTAP_TAPCELL_ROW_46_3_2860 VDD VSS gf180mcu_as_sc_mcu7t3v3__tap_2
XFILLER_179_1459 VDD VDD VSS VSS gf180mcu_as_sc_mcu7t3v3__fillcap_8
XTAP_TAPCELL_ROW_12_994 VDD VSS gf180mcu_as_sc_mcu7t3v3__tap_2
Xclkload11 VDD VDD VSS VSS _4904_/CLK clkload11/Y gf180mcu_as_sc_mcu7t3v3__clkbuff_4
Xclkload22 VDD VDD VSS VSS clkload22/Y _5280_/CLK gf180mcu_as_sc_mcu7t3v3__inv_2
X_3592_ VDD VDD VSS VSS _3956_/D _3650_/B _3592_/C _3592_/D _3593_/D gf180mcu_as_sc_mcu7t3v3__ao211_2
X_2612_ VDD VDD VSS VSS _2621_/B _5230_/Q _5232_/Q gf180mcu_as_sc_mcu7t3v3__nor2b_2
XFILLER_55_2 VDD VDD VSS VSS gf180mcu_as_sc_mcu7t3v3__fill_2
XPHY_EDGE_ROW_127_3_Left_512 VDD VSS gf180mcu_as_sc_mcu7t3v3__tap_2
X_2543_ VDD VDD VSS VSS _2798_/B _4328_/A _5125_/Q gf180mcu_as_sc_mcu7t3v3__nand2_2
XFILLER_126_172 VDD VDD VSS VSS gf180mcu_as_sc_mcu7t3v3__fill_2
XFILLER_126_194 VDD VDD VSS VSS gf180mcu_as_sc_mcu7t3v3__fill_2
XFILLER_141_142 VDD VDD VSS VSS gf180mcu_as_sc_mcu7t3v3__fillcap_4
XFILLER_29_1451 VDD VDD VSS VSS gf180mcu_as_sc_mcu7t3v3__fillcap_16
XPHY_EDGE_ROW_49_3_Right_86 VDD VSS gf180mcu_as_sc_mcu7t3v3__tap_2
X_5262_ VDD VDD VSS VSS _5262_/CLK _5262_/D _5262_/Q gf180mcu_as_sc_mcu7t3v3__dfxtp_2
X_2474_ VDD VDD VSS VSS _2474_/A _4350_/D _2474_/C _2589_/A gf180mcu_as_sc_mcu7t3v3__nor3_2
XFILLER_155_1481 VDD VDD VSS VSS gf180mcu_as_sc_mcu7t3v3__fillcap_4
XFILLER_190_1361 VDD VDD VSS VSS gf180mcu_as_sc_mcu7t3v3__fillcap_4
XFILLER_25_1326 VDD VDD VSS VSS gf180mcu_as_sc_mcu7t3v3__fillcap_4
X_5193_ VDD VDD VSS VSS _5197_/CLK _5193_/D _5193_/Q gf180mcu_as_sc_mcu7t3v3__dfxtp_2
X_4213_ VDD VDD VSS VSS _4242_/B _4228_/B _4228_/C _5049_/Q _5049_/D gf180mcu_as_sc_mcu7t3v3__ao22_2
X_4144_ VDD VDD VSS VSS _4144_/A _4160_/C _4152_/C _4941_/Q _4145_/D gf180mcu_as_sc_mcu7t3v3__ao22_2
XTAP_TAPCELL_ROW_17_1095 VDD VSS gf180mcu_as_sc_mcu7t3v3__tap_2
XFILLER_151_1389 VDD VDD VSS VSS gf180mcu_as_sc_mcu7t3v3__fillcap_16
XFILLER_18_18 VDD VDD VSS VSS gf180mcu_as_sc_mcu7t3v3__fillcap_16
XFILLER_209_460 VDD VDD VSS VSS gf180mcu_as_sc_mcu7t3v3__fill_1
XFILLER_3_1122 VDD VDD VSS VSS gf180mcu_as_sc_mcu7t3v3__fillcap_8
XPHY_EDGE_ROW_83_1_Left_293 VDD VSS gf180mcu_as_sc_mcu7t3v3__tap_2
XTAP_TAPCELL_ROW_127_3_3102 VDD VSS gf180mcu_as_sc_mcu7t3v3__tap_2
X_4075_ VDD VDD VSS VSS _4075_/A _4141_/B _4075_/C _4246_/B _4124_/D gf180mcu_as_sc_mcu7t3v3__aoi211_2
XFILLER_70_107 VDD VDD VSS VSS gf180mcu_as_sc_mcu7t3v3__fillcap_16
X_3026_ VDD VDD VSS VSS _4005_/A _3127_/B _3127_/C _4007_/A _3027_/C gf180mcu_as_sc_mcu7t3v3__ao22_2
XFILLER_24_513 VDD VDD VSS VSS gf180mcu_as_sc_mcu7t3v3__fillcap_8
XFILLER_36_384 VDD VDD VSS VSS gf180mcu_as_sc_mcu7t3v3__fillcap_4
XTAP_TAPCELL_ROW_26_1309 VDD VSS gf180mcu_as_sc_mcu7t3v3__tap_2
XFILLER_11_207 VDD VDD VSS VSS gf180mcu_as_sc_mcu7t3v3__fill_2
XFILLER_149_220 VDD VDD VSS VSS gf180mcu_as_sc_mcu7t3v3__fill_2
XFILLER_196_359 VDD VDD VSS VSS gf180mcu_as_sc_mcu7t3v3__fillcap_16
X_4977_ VDD VDD VSS VSS _4977_/CLK _4977_/D _4977_/Q gf180mcu_as_sc_mcu7t3v3__dfxtp_2
Xsram2048.u_bank0_917 VDD VDD VSS VSS sram2048.u_bank0/WEN[7] gf180mcu_as_sc_mcu7t3v3__tiel_4
Xclkload5 VDD VDD VSS VSS clkload5/A clkload5/Y gf180mcu_as_sc_mcu7t3v3__clkbuff_4
X_3928_ VDD VDD VSS VSS _3928_/Y _3932_/D _3928_/A gf180mcu_as_sc_mcu7t3v3__nor2_2
XFILLER_177_595 VDD VDD VSS VSS gf180mcu_as_sc_mcu7t3v3__fillcap_4
XFILLER_197_1504 VDD VDD VSS VSS gf180mcu_as_sc_mcu7t3v3__fillcap_16
XFILLER_50_27 VDD VDD VSS VSS gf180mcu_as_sc_mcu7t3v3__fillcap_8
XFILLER_50_49 VDD VDD VSS VSS gf180mcu_as_sc_mcu7t3v3__fill_1
XPHY_EDGE_ROW_132_1_Right_653 VDD VSS gf180mcu_as_sc_mcu7t3v3__tap_2
X_3859_ VDD VDD VSS VSS _3862_/A _3873_/A gf180mcu_as_sc_mcu7t3v3__inv_2
XFILLER_192_543 VDD VDD VSS VSS gf180mcu_as_sc_mcu7t3v3__fillcap_16
XPHY_EDGE_ROW_202_Right_65 VDD VSS gf180mcu_as_sc_mcu7t3v3__tap_2
XPHY_EDGE_ROW_59_3_Left_444 VDD VSS gf180mcu_as_sc_mcu7t3v3__tap_2
XFILLER_30_1065 VDD VDD VSS VSS gf180mcu_as_sc_mcu7t3v3__fillcap_16
XPHY_EDGE_ROW_111_3_Left_496 VDD VSS gf180mcu_as_sc_mcu7t3v3__tap_2
XFILLER_30_1087 VDD VDD VSS VSS gf180mcu_as_sc_mcu7t3v3__fillcap_16
XFILLER_195_1294 VDD VDD VSS VSS gf180mcu_as_sc_mcu7t3v3__fillcap_16
XTAP_TAPCELL_ROW_170_1_1955 VDD VSS gf180mcu_as_sc_mcu7t3v3__tap_2
XFILLER_182_37 VDD VDD VSS VSS gf180mcu_as_sc_mcu7t3v3__fillcap_16
XFILLER_43_1415 VDD VDD VSS VSS gf180mcu_as_sc_mcu7t3v3__fill_1
XFILLER_82_1453 VDD VDD VSS VSS gf180mcu_as_sc_mcu7t3v3__fillcap_16
XFILLER_8_1033 VDD VDD VSS VSS gf180mcu_as_sc_mcu7t3v3__fillcap_16
XTAP_TAPCELL_ROW_187_2294 VDD VSS gf180mcu_as_sc_mcu7t3v3__tap_2
XTAP_TAPCELL_ROW_187_2283 VDD VSS gf180mcu_as_sc_mcu7t3v3__tap_2
XFILLER_115_53 VDD VDD VSS VSS gf180mcu_as_sc_mcu7t3v3__fillcap_16
XFILLER_134_1565 VDD VDD VSS VSS gf180mcu_as_sc_mcu7t3v3__fillcap_4
XFILLER_130_1429 VDD VDD VSS VSS gf180mcu_as_sc_mcu7t3v3__fillcap_16
XFILLER_75_57 VDD VDD VSS VSS gf180mcu_as_sc_mcu7t3v3__fillcap_8
XFILLER_210_1464 VDD VDD VSS VSS gf180mcu_as_sc_mcu7t3v3__fillcap_16
XFILLER_15_524 VDD VDD VSS VSS gf180mcu_as_sc_mcu7t3v3__fillcap_8
XFILLER_199_120 VDD VDD VSS VSS gf180mcu_as_sc_mcu7t3v3__fillcap_16
XFILLER_199_142 VDD VDD VSS VSS gf180mcu_as_sc_mcu7t3v3__fillcap_16
XFILLER_15_579 VDD VDD VSS VSS gf180mcu_as_sc_mcu7t3v3__fillcap_16
XFILLER_167_1396 VDD VDD VSS VSS gf180mcu_as_sc_mcu7t3v3__fillcap_16
XFILLER_91_45 VDD VDD VSS VSS gf180mcu_as_sc_mcu7t3v3__fillcap_8
XFILLER_187_359 VDD VDD VSS VSS gf180mcu_as_sc_mcu7t3v3__fillcap_16
XFILLER_15_1539 VDD VDD VSS VSS gf180mcu_as_sc_mcu7t3v3__fill_1
XFILLER_30_549 VDD VDD VSS VSS gf180mcu_as_sc_mcu7t3v3__fill_1
XFILLER_50_1419 VDD VDD VSS VSS gf180mcu_as_sc_mcu7t3v3__fill_2
XFILLER_141_1558 VDD VDD VSS VSS gf180mcu_as_sc_mcu7t3v3__fillcap_8
XFILLER_155_212 VDD VDD VSS VSS gf180mcu_as_sc_mcu7t3v3__fillcap_8
XFILLER_196_893 VDD VDD VSS VSS gf180mcu_as_sc_mcu7t3v3__fillcap_16
XFILLER_10_295 VDD VDD VSS VSS gf180mcu_as_sc_mcu7t3v3__fillcap_16
XFILLER_87_1364 VDD VDD VSS VSS gf180mcu_as_sc_mcu7t3v3__fillcap_16
XFILLER_123_142 VDD VDD VSS VSS gf180mcu_as_sc_mcu7t3v3__fill_2
XFILLER_48_1348 VDD VDD VSS VSS gf180mcu_as_sc_mcu7t3v3__fillcap_8
XFILLER_49_80 VDD VDD VSS VSS gf180mcu_as_sc_mcu7t3v3__fillcap_4
XFILLER_19_830 VDD VDD VSS VSS gf180mcu_as_sc_mcu7t3v3__fillcap_8
XFILLER_4_1431 VDD VDD VSS VSS gf180mcu_as_sc_mcu7t3v3__fillcap_4
XFILLER_34_800 VDD VDD VSS VSS gf180mcu_as_sc_mcu7t3v3__fillcap_4
XFILLER_52_107 VDD VDD VSS VSS gf180mcu_as_sc_mcu7t3v3__fillcap_16
XFILLER_98_1471 VDD VDD VSS VSS gf180mcu_as_sc_mcu7t3v3__fillcap_16
XFILLER_18_384 VDD VDD VSS VSS gf180mcu_as_sc_mcu7t3v3__fill_1
XFILLER_209_1102 VDD VDD VSS VSS gf180mcu_as_sc_mcu7t3v3__fillcap_16
XFILLER_59_1444 VDD VDD VSS VSS gf180mcu_as_sc_mcu7t3v3__fillcap_4
X_4900_ VDD VDD VSS VSS _4904_/CLK _4900_/D _4900_/Q gf180mcu_as_sc_mcu7t3v3__dfxtp_2
XFILLER_179_838 VDD VDD VSS VSS gf180mcu_as_sc_mcu7t3v3__fill_2
XFILLER_34_855 VDD VDD VSS VSS gf180mcu_as_sc_mcu7t3v3__fill_1
XFILLER_34_877 VDD VDD VSS VSS gf180mcu_as_sc_mcu7t3v3__fill_2
XFILLER_59_1488 VDD VDD VSS VSS gf180mcu_as_sc_mcu7t3v3__fillcap_16
XFILLER_94_1368 VDD VDD VSS VSS gf180mcu_as_sc_mcu7t3v3__fillcap_8
X_4831_ VDD VDD VSS VSS _5073_/CLK _4831_/D _4831_/Q gf180mcu_as_sc_mcu7t3v3__dfxtp_2
XFILLER_60_151 VDD VDD VSS VSS gf180mcu_as_sc_mcu7t3v3__fillcap_4
X_4762_ VDD VDD VSS VSS _5192_/CLK _4762_/D _4762_/Q gf180mcu_as_sc_mcu7t3v3__dfxtp_2
XFILLER_146_201 VDD VDD VSS VSS gf180mcu_as_sc_mcu7t3v3__fillcap_16
XFILLER_201_190 VDD VDD VSS VSS gf180mcu_as_sc_mcu7t3v3__fillcap_16
X_4693_ VDD VDD VSS VSS _4707_/S _5251_/Q _4693_/A _5251_/D gf180mcu_as_sc_mcu7t3v3__mux2_2
X_3713_ VDD VDD VSS VSS _3714_/C _3713_/C _3766_/B _4089_/A gf180mcu_as_sc_mcu7t3v3__aoi21_2
XFILLER_14_1049 VDD VDD VSS VSS gf180mcu_as_sc_mcu7t3v3__fillcap_16
XFILLER_174_543 VDD VDD VSS VSS gf180mcu_as_sc_mcu7t3v3__fill_1
XFILLER_174_565 VDD VDD VSS VSS gf180mcu_as_sc_mcu7t3v3__fill_1
X_3644_ VDD VDD VSS VSS _3644_/D _4016_/D _3728_/B _3728_/C _3645_/C gf180mcu_as_sc_mcu7t3v3__ao31_2
XFILLER_179_1256 VDD VDD VSS VSS gf180mcu_as_sc_mcu7t3v3__fillcap_4
XFILLER_179_1278 VDD VDD VSS VSS gf180mcu_as_sc_mcu7t3v3__fillcap_16
XFILLER_157_1521 VDD VDD VSS VSS gf180mcu_as_sc_mcu7t3v3__fill_2
XFILLER_66_1415 VDD VDD VSS VSS gf180mcu_as_sc_mcu7t3v3__fillcap_4
X_3575_ VDD VDD VSS VSS _3942_/A _3649_/B _3656_/C _3941_/A _3576_/D gf180mcu_as_sc_mcu7t3v3__ao22_2
XTAP_TAPCELL_ROW_60_1_1624 VDD VSS gf180mcu_as_sc_mcu7t3v3__tap_2
X_2526_ VDD VDD VSS VSS _4657_/B _5230_/Q _2632_/B gf180mcu_as_sc_mcu7t3v3__nor2b_2
XTAP_TAPCELL_ROW_19_1146 VDD VSS gf180mcu_as_sc_mcu7t3v3__tap_2
XFILLER_153_1418 VDD VDD VSS VSS gf180mcu_as_sc_mcu7t3v3__fillcap_16
X_5245_ VDD VDD VSS VSS clkload6/A _5245_/D _5245_/Q gf180mcu_as_sc_mcu7t3v3__dfxtp_2
X_2457_ VDD VDD VSS VSS _3846_/B _4911_/Q _4912_/Q gf180mcu_as_sc_mcu7t3v3__nor2_2
XTAP_TAPCELL_ROW_19_1157 VDD VSS gf180mcu_as_sc_mcu7t3v3__tap_2
XFILLER_29_1281 VDD VDD VSS VSS gf180mcu_as_sc_mcu7t3v3__fillcap_16
XFILLER_9_1364 VDD VDD VSS VSS gf180mcu_as_sc_mcu7t3v3__fillcap_4
XFILLER_25_1167 VDD VDD VSS VSS gf180mcu_as_sc_mcu7t3v3__fillcap_16
XFILLER_28_104 VDD VDD VSS VSS gf180mcu_as_sc_mcu7t3v3__fill_1
XFILLER_9_1397 VDD VDD VSS VSS gf180mcu_as_sc_mcu7t3v3__fill_2
X_5176_ VDD VDD VSS VSS clkload7/A _5176_/D _5176_/Q gf180mcu_as_sc_mcu7t3v3__dfxtp_2
XFILLER_186_1205 VDD VDD VSS VSS gf180mcu_as_sc_mcu7t3v3__fillcap_16
XFILLER_25_1189 VDD VDD VSS VSS gf180mcu_as_sc_mcu7t3v3__fill_1
XFILLER_28_115 VDD VDD VSS VSS gf180mcu_as_sc_mcu7t3v3__fill_2
X_4127_ VDD VDD VSS VSS _4127_/A _4162_/B _4136_/C _4132_/C _4127_/D gf180mcu_as_sc_mcu7t3v3__aoi211_2
XTAP_TAPCELL_ROW_40_1_1566 VDD VSS gf180mcu_as_sc_mcu7t3v3__tap_2
XTAP_TAPCELL_ROW_182_2180 VDD VSS gf180mcu_as_sc_mcu7t3v3__tap_2
XFILLER_186_1227 VDD VDD VSS VSS gf180mcu_as_sc_mcu7t3v3__fillcap_16
XFILLER_45_27 VDD VDD VSS VSS gf180mcu_as_sc_mcu7t3v3__fillcap_16
X_4058_ VDD VDD VSS VSS _4106_/S _4058_/B _4058_/A _4059_/B gf180mcu_as_sc_mcu7t3v3__mux2_2
XFILLER_25_822 VDD VDD VSS VSS gf180mcu_as_sc_mcu7t3v3__fillcap_4
X_3009_ VDD VDD VSS VSS _3990_/A _3127_/B _3076_/C _3989_/D _3010_/C gf180mcu_as_sc_mcu7t3v3__ao22_2
XFILLER_196_101 VDD VDD VSS VSS gf180mcu_as_sc_mcu7t3v3__fillcap_4
XFILLER_77_1566 VDD VDD VSS VSS gf180mcu_as_sc_mcu7t3v3__fill_2
XFILLER_12_527 VDD VDD VSS VSS gf180mcu_as_sc_mcu7t3v3__fill_1
XFILLER_196_123 VDD VDD VSS VSS gf180mcu_as_sc_mcu7t3v3__fillcap_16
XFILLER_24_387 VDD VDD VSS VSS gf180mcu_as_sc_mcu7t3v3__fillcap_8
XFILLER_51_162 VDD VDD VSS VSS gf180mcu_as_sc_mcu7t3v3__fill_1
XFILLER_101_88 VDD VDD VSS VSS gf180mcu_as_sc_mcu7t3v3__fill_1
XFILLER_127_1380 VDD VDD VSS VSS gf180mcu_as_sc_mcu7t3v3__fillcap_16
XFILLER_137_212 VDD VDD VSS VSS gf180mcu_as_sc_mcu7t3v3__fillcap_8
XFILLER_178_893 VDD VDD VSS VSS gf180mcu_as_sc_mcu7t3v3__fillcap_16
XFILLER_205_1566 VDD VDD VSS VSS gf180mcu_as_sc_mcu7t3v3__fill_2
XFILLER_36_1285 VDD VDD VSS VSS gf180mcu_as_sc_mcu7t3v3__fillcap_4
XFILLER_193_874 VDD VDD VSS VSS gf180mcu_as_sc_mcu7t3v3__fillcap_16
XPHY_EDGE_ROW_133_1_Right_654 VDD VSS gf180mcu_as_sc_mcu7t3v3__tap_2
XFILLER_10_1414 VDD VDD VSS VSS gf180mcu_as_sc_mcu7t3v3__fill_2
XFILLER_192_384 VDD VDD VSS VSS gf180mcu_as_sc_mcu7t3v3__fill_1
XFILLER_10_1469 VDD VDD VSS VSS gf180mcu_as_sc_mcu7t3v3__fillcap_4
XFILLER_180_557 VDD VDD VSS VSS gf180mcu_as_sc_mcu7t3v3__fillcap_8
XFILLER_4_737 VDD VDD VSS VSS gf180mcu_as_sc_mcu7t3v3__fill_1
XTAP_TAPCELL_ROW_189_2334 VDD VSS gf180mcu_as_sc_mcu7t3v3__tap_2
XTAP_TAPCELL_ROW_189_2323 VDD VSS gf180mcu_as_sc_mcu7t3v3__tap_2
XFILLER_105_120 VDD VDD VSS VSS gf180mcu_as_sc_mcu7t3v3__fillcap_16
XFILLER_105_142 VDD VDD VSS VSS gf180mcu_as_sc_mcu7t3v3__fillcap_4
XFILLER_10_85 VDD VDD VSS VSS gf180mcu_as_sc_mcu7t3v3__fillcap_16
XFILLER_120_101 VDD VDD VSS VSS gf180mcu_as_sc_mcu7t3v3__fillcap_4
XFILLER_126_41 VDD VDD VSS VSS gf180mcu_as_sc_mcu7t3v3__fill_2
XTAP_TAPCELL_ROW_210_2799 VDD VSS gf180mcu_as_sc_mcu7t3v3__tap_2
XTAP_TAPCELL_ROW_210_2788 VDD VSS gf180mcu_as_sc_mcu7t3v3__tap_2
XFILLER_0_965 VDD VDD VSS VSS gf180mcu_as_sc_mcu7t3v3__fillcap_4
XFILLER_120_123 VDD VDD VSS VSS gf180mcu_as_sc_mcu7t3v3__fillcap_4
XFILLER_126_85 VDD VDD VSS VSS gf180mcu_as_sc_mcu7t3v3__fillcap_8
Xoutput390 VDD VDD VSS VSS _4778_/Q se_out[7] gf180mcu_as_sc_mcu7t3v3__buff_12
XFILLER_86_78 VDD VDD VSS VSS gf180mcu_as_sc_mcu7t3v3__fillcap_8
XFILLER_19_72 VDD VDD VSS VSS gf180mcu_as_sc_mcu7t3v3__fillcap_8
XFILLER_74_221 VDD VDD VSS VSS gf180mcu_as_sc_mcu7t3v3__fill_1
XFILLER_169_1458 VDD VDD VSS VSS gf180mcu_as_sc_mcu7t3v3__fillcap_4
XFILLER_210_1294 VDD VDD VSS VSS gf180mcu_as_sc_mcu7t3v3__fillcap_4
XFILLER_34_107 VDD VDD VSS VSS gf180mcu_as_sc_mcu7t3v3__fill_2
XTAP_TAPCELL_ROW_3_792 VDD VSS gf180mcu_as_sc_mcu7t3v3__tap_2
XFILLER_16_866 VDD VDD VSS VSS gf180mcu_as_sc_mcu7t3v3__fillcap_8
XFILLER_188_613 VDD VDD VSS VSS gf180mcu_as_sc_mcu7t3v3__fillcap_16
XFILLER_203_400 VDD VDD VSS VSS gf180mcu_as_sc_mcu7t3v3__fillcap_16
XFILLER_203_422 VDD VDD VSS VSS gf180mcu_as_sc_mcu7t3v3__fillcap_16
XFILLER_42_173 VDD VDD VSS VSS gf180mcu_as_sc_mcu7t3v3__fill_2
XFILLER_19_1472 VDD VDD VSS VSS gf180mcu_as_sc_mcu7t3v3__fillcap_4
XFILLER_54_1352 VDD VDD VSS VSS gf180mcu_as_sc_mcu7t3v3__fill_2
XTAP_TAPCELL_ROW_65_1_1639 VDD VSS gf180mcu_as_sc_mcu7t3v3__tap_2
XFILLER_106_1442 VDD VDD VSS VSS gf180mcu_as_sc_mcu7t3v3__fillcap_8
XFILLER_106_1453 VDD VDD VSS VSS gf180mcu_as_sc_mcu7t3v3__fillcap_4
XFILLER_175_329 VDD VDD VSS VSS gf180mcu_as_sc_mcu7t3v3__fillcap_16
XFILLER_30_379 VDD VDD VSS VSS gf180mcu_as_sc_mcu7t3v3__fillcap_4
XFILLER_204_1065 VDD VDD VSS VSS gf180mcu_as_sc_mcu7t3v3__fillcap_16
XFILLER_204_1087 VDD VDD VSS VSS gf180mcu_as_sc_mcu7t3v3__fillcap_16
XFILLER_89_1415 VDD VDD VSS VSS gf180mcu_as_sc_mcu7t3v3__fill_1
XTAP_TAPCELL_ROW_174_1968 VDD VSS gf180mcu_as_sc_mcu7t3v3__tap_2
Xwire473 VDD VDD VSS VSS _3573_/Y _4839_/D gf180mcu_as_sc_mcu7t3v3__clkbuff_12
Xwire462 VDD VDD VSS VSS _3746_/Y _4862_/D gf180mcu_as_sc_mcu7t3v3__clkbuff_12
XTAP_TAPCELL_ROW_174_1979 VDD VSS gf180mcu_as_sc_mcu7t3v3__tap_2
Xwire495 VDD VDD VSS VSS _3073_/Y _4785_/D gf180mcu_as_sc_mcu7t3v3__clkbuff_12
X_3360_ VDD VDD VSS VSS _3639_/A _3416_/B _3360_/C _4814_/D _3416_/D gf180mcu_as_sc_mcu7t3v3__aoi211_2
XFILLER_111_101 VDD VDD VSS VSS gf180mcu_as_sc_mcu7t3v3__fill_1
XFILLER_26_1432 VDD VDD VSS VSS gf180mcu_as_sc_mcu7t3v3__fill_2
X_5030_ VDD VDD VSS VSS _5095_/CLK _5030_/D _5030_/Q gf180mcu_as_sc_mcu7t3v3__dfxtp_2
X_3291_ VDD VDD VSS VSS _4916_/Q _3402_/B _3402_/C _3940_/A _3292_/D gf180mcu_as_sc_mcu7t3v3__ao22_2
XTAP_TAPCELL_ROW_14_1032 VDD VSS gf180mcu_as_sc_mcu7t3v3__tap_2
XTAP_TAPCELL_ROW_14_1043 VDD VSS gf180mcu_as_sc_mcu7t3v3__tap_2
XFILLER_152_1495 VDD VDD VSS VSS gf180mcu_as_sc_mcu7t3v3__fill_1
XFILLER_18_2 VDD VDD VSS VSS gf180mcu_as_sc_mcu7t3v3__fillcap_16
XFILLER_19_693 VDD VDD VSS VSS gf180mcu_as_sc_mcu7t3v3__fillcap_4
XFILLER_207_750 VDD VDD VSS VSS gf180mcu_as_sc_mcu7t3v3__fillcap_16
XFILLER_207_772 VDD VDD VSS VSS gf180mcu_as_sc_mcu7t3v3__fillcap_16
XFILLER_178_101 VDD VDD VSS VSS gf180mcu_as_sc_mcu7t3v3__fillcap_4
XFILLER_178_123 VDD VDD VSS VSS gf180mcu_as_sc_mcu7t3v3__fillcap_16
XFILLER_210_915 VDD VDD VSS VSS gf180mcu_as_sc_mcu7t3v3__fill_2
XPHY_EDGE_ROW_114_1_Left_324 VDD VSS gf180mcu_as_sc_mcu7t3v3__tap_2
X_4814_ VDD VDD VSS VSS _4919_/CLK _4814_/D _4814_/Q gf180mcu_as_sc_mcu7t3v3__dfxtp_2
XFILLER_119_201 VDD VDD VSS VSS gf180mcu_as_sc_mcu7t3v3__fillcap_8
XFILLER_119_212 VDD VDD VSS VSS gf180mcu_as_sc_mcu7t3v3__fillcap_8
XFILLER_193_104 VDD VDD VSS VSS gf180mcu_as_sc_mcu7t3v3__fillcap_16
X_4745_ VDD VDD VSS VSS _4747_/D _4745_/A _5275_/D gf180mcu_as_sc_mcu7t3v3__and2_2
XFILLER_31_18 VDD VDD VSS VSS gf180mcu_as_sc_mcu7t3v3__fillcap_16
XFILLER_134_204 VDD VDD VSS VSS gf180mcu_as_sc_mcu7t3v3__fillcap_16
XFILLER_174_362 VDD VDD VSS VSS gf180mcu_as_sc_mcu7t3v3__fill_1
XFILLER_194_1507 VDD VDD VSS VSS gf180mcu_as_sc_mcu7t3v3__fillcap_16
X_4676_ VDD VDD VSS VSS _5245_/D _5115_/Q _4731_/B _4676_/C gf180mcu_as_sc_mcu7t3v3__ao21_2
XFILLER_174_384 VDD VDD VSS VSS gf180mcu_as_sc_mcu7t3v3__fillcap_4
XFILLER_190_855 VDD VDD VSS VSS gf180mcu_as_sc_mcu7t3v3__fillcap_16
X_3627_ VDD VDD VSS VSS _3997_/D _3751_/B _3627_/C _3627_/D _3628_/C gf180mcu_as_sc_mcu7t3v3__ao211_2
XFILLER_190_877 VDD VDD VSS VSS gf180mcu_as_sc_mcu7t3v3__fillcap_16
XFILLER_200_1485 VDD VDD VSS VSS gf180mcu_as_sc_mcu7t3v3__fillcap_16
X_3558_ VDD VDD VSS VSS _3805_/B _3558_/B _3817_/C gf180mcu_as_sc_mcu7t3v3__nand2_2
XTAP_TAPCELL_ROW_91_1_1718 VDD VSS gf180mcu_as_sc_mcu7t3v3__tap_2
XFILLER_0_206 VDD VDD VSS VSS gf180mcu_as_sc_mcu7t3v3__fillcap_4
Xmax_cap784 VDD VDD VSS VSS _5157_/Q _4590_/A gf180mcu_as_sc_mcu7t3v3__clkbuff_12
X_2509_ VDD VDD VSS VSS _5275_/Q _5269_/Q _5270_/Q _4331_/A _4749_/A gf180mcu_as_sc_mcu7t3v3__nand4_2
XFILLER_102_123 VDD VDD VSS VSS gf180mcu_as_sc_mcu7t3v3__fillcap_16
XFILLER_192_1275 VDD VDD VSS VSS gf180mcu_as_sc_mcu7t3v3__fillcap_16
XFILLER_192_1297 VDD VDD VSS VSS gf180mcu_as_sc_mcu7t3v3__fillcap_16
XFILLER_44_1510 VDD VDD VSS VSS gf180mcu_as_sc_mcu7t3v3__fillcap_8
Xinput107 VDD VDD VSS VSS ne_in[5] wire906/A gf180mcu_as_sc_mcu7t3v3__buff_12
Xinput118 VDD VDD VSS VSS north_in[15] _4054_/A gf180mcu_as_sc_mcu7t3v3__buff_12
X_3489_ VDD VDD VSS VSS _4146_/D _3502_/B _3522_/C _4147_/A _3490_/D gf180mcu_as_sc_mcu7t3v3__ao22_2
XTAP_TAPCELL_ROW_184_2231 VDD VSS gf180mcu_as_sc_mcu7t3v3__tap_2
XTAP_TAPCELL_ROW_184_2220 VDD VSS gf180mcu_as_sc_mcu7t3v3__tap_2
XFILLER_9_1183 VDD VDD VSS VSS gf180mcu_as_sc_mcu7t3v3__fillcap_4
X_5228_ VDD VDD VSS VSS _5233_/CLK _5228_/D _5228_/Q gf180mcu_as_sc_mcu7t3v3__dfxtp_2
Xinput129 VDD VDD VSS VSS north_in[25] _4137_/A gf180mcu_as_sc_mcu7t3v3__buff_12
XFILLER_56_37 VDD VDD VSS VSS gf180mcu_as_sc_mcu7t3v3__fillcap_16
X_5159_ VDD VDD VSS VSS clkload7/A _5159_/D _5159_/Q gf180mcu_as_sc_mcu7t3v3__dfxtp_2
XTAP_TAPCELL_ROW_180_2139 VDD VSS gf180mcu_as_sc_mcu7t3v3__tap_2
XTAP_TAPCELL_ROW_180_2128 VDD VSS gf180mcu_as_sc_mcu7t3v3__tap_2
XFILLER_131_1568 VDD VDD VSS VSS gf180mcu_as_sc_mcu7t3v3__fill_1
XFILLER_179_6 VDD VDD VSS VSS gf180mcu_as_sc_mcu7t3v3__fillcap_16
XFILLER_16_107 VDD VDD VSS VSS gf180mcu_as_sc_mcu7t3v3__fillcap_16
XTAP_TAPCELL_ROW_0_740 VDD VSS gf180mcu_as_sc_mcu7t3v3__tap_2
XFILLER_112_98 VDD VDD VSS VSS gf180mcu_as_sc_mcu7t3v3__fillcap_4
XFILLER_129_1453 VDD VDD VSS VSS gf180mcu_as_sc_mcu7t3v3__fillcap_4
XFILLER_24_151 VDD VDD VSS VSS gf180mcu_as_sc_mcu7t3v3__fillcap_16
XFILLER_77_1385 VDD VDD VSS VSS gf180mcu_as_sc_mcu7t3v3__fillcap_4
XPHY_EDGE_ROW_46_1_Left_256 VDD VSS gf180mcu_as_sc_mcu7t3v3__tap_2
XFILLER_164_1366 VDD VDD VSS VSS gf180mcu_as_sc_mcu7t3v3__fill_1
XFILLER_169_134 VDD VDD VSS VSS gf180mcu_as_sc_mcu7t3v3__fillcap_4
XFILLER_188_69 VDD VDD VSS VSS gf180mcu_as_sc_mcu7t3v3__fillcap_16
XFILLER_197_454 VDD VDD VSS VSS gf180mcu_as_sc_mcu7t3v3__fillcap_16
XTAP_TAPCELL_ROW_178_2079 VDD VSS gf180mcu_as_sc_mcu7t3v3__tap_2
XFILLER_12_379 VDD VDD VSS VSS gf180mcu_as_sc_mcu7t3v3__fillcap_4
XFILLER_164_1399 VDD VDD VSS VSS gf180mcu_as_sc_mcu7t3v3__fillcap_16
XFILLER_185_627 VDD VDD VSS VSS gf180mcu_as_sc_mcu7t3v3__fill_2
XFILLER_199_1418 VDD VDD VSS VSS gf180mcu_as_sc_mcu7t3v3__fillcap_16
XTAP_TAPCELL_ROW_145_1_1881 VDD VSS gf180mcu_as_sc_mcu7t3v3__tap_2
XTAP_TAPCELL_ROW_157_3_3193 VDD VSS gf180mcu_as_sc_mcu7t3v3__tap_2
X_4881__1086 VDD VDD VSS VSS _4881_/D gf180mcu_as_sc_mcu7t3v3__tiel_4
XFILLER_205_1396 VDD VDD VSS VSS gf180mcu_as_sc_mcu7t3v3__fillcap_4
XFILLER_51_1558 VDD VDD VSS VSS gf180mcu_as_sc_mcu7t3v3__fillcap_8
XFILLER_197_1186 VDD VDD VSS VSS gf180mcu_as_sc_mcu7t3v3__fillcap_4
XPHY_EDGE_ROW_134_1_Right_655 VDD VSS gf180mcu_as_sc_mcu7t3v3__tap_2
XFILLER_88_1470 VDD VDD VSS VSS gf180mcu_as_sc_mcu7t3v3__fillcap_8
XPHY_EDGE_ROW_160_1_Left_370 VDD VSS gf180mcu_as_sc_mcu7t3v3__tap_2
XFILLER_180_387 VDD VDD VSS VSS gf180mcu_as_sc_mcu7t3v3__fillcap_8
XFILLER_49_1465 VDD VDD VSS VSS gf180mcu_as_sc_mcu7t3v3__fillcap_16
XFILLER_171_1348 VDD VDD VSS VSS gf180mcu_as_sc_mcu7t3v3__fillcap_16
XFILLER_97_88 VDD VDD VSS VSS gf180mcu_as_sc_mcu7t3v3__fillcap_16
XTAP_TAPCELL_ROW_40_3_2841 VDD VSS gf180mcu_as_sc_mcu7t3v3__tap_2
XFILLER_0_784 VDD VDD VSS VSS gf180mcu_as_sc_mcu7t3v3__fillcap_4
XFILLER_153_72 VDD VDD VSS VSS gf180mcu_as_sc_mcu7t3v3__fillcap_8
XFILLER_36_928 VDD VDD VSS VSS gf180mcu_as_sc_mcu7t3v3__fill_2
XPHY_EDGE_ROW_110_3_Right_147 VDD VSS gf180mcu_as_sc_mcu7t3v3__tap_2
XFILLER_21_1362 VDD VDD VSS VSS gf180mcu_as_sc_mcu7t3v3__fill_2
XPHY_EDGE_ROW_136_3_Left_521 VDD VSS gf180mcu_as_sc_mcu7t3v3__tap_2
XFILLER_108_1515 VDD VDD VSS VSS gf180mcu_as_sc_mcu7t3v3__fill_2
XFILLER_189_944 VDD VDD VSS VSS gf180mcu_as_sc_mcu7t3v3__fillcap_16
XFILLER_204_731 VDD VDD VSS VSS gf180mcu_as_sc_mcu7t3v3__fillcap_4
XFILLER_204_753 VDD VDD VSS VSS gf180mcu_as_sc_mcu7t3v3__fillcap_16
XFILLER_95_1485 VDD VDD VSS VSS gf180mcu_as_sc_mcu7t3v3__fill_1
XPHY_EDGE_ROW_58_3_Right_95 VDD VSS gf180mcu_as_sc_mcu7t3v3__tap_2
X_2860_ VDD VDD VSS VSS _2861_/B _4733_/B _2873_/C gf180mcu_as_sc_mcu7t3v3__and2_2
XFILLER_15_1122 VDD VDD VSS VSS gf180mcu_as_sc_mcu7t3v3__fillcap_16
XFILLER_175_104 VDD VDD VSS VSS gf180mcu_as_sc_mcu7t3v3__fillcap_16
XFILLER_176_638 VDD VDD VSS VSS gf180mcu_as_sc_mcu7t3v3__fillcap_8
XFILLER_182_1499 VDD VDD VSS VSS gf180mcu_as_sc_mcu7t3v3__fillcap_4
XFILLER_30_143 VDD VDD VSS VSS gf180mcu_as_sc_mcu7t3v3__fill_1
XFILLER_175_126 VDD VDD VSS VSS gf180mcu_as_sc_mcu7t3v3__fill_1
X_2791_ VDD VDD VSS VSS _4732_/C _4732_/B _2791_/A gf180mcu_as_sc_mcu7t3v3__nor2b_2
XFILLER_190_107 VDD VDD VSS VSS gf180mcu_as_sc_mcu7t3v3__fillcap_16
X_4530_ VDD VDD VSS VSS _4531_/D _4530_/B _4589_/A gf180mcu_as_sc_mcu7t3v3__nor2_2
XFILLER_32_1491 VDD VDD VSS VSS gf180mcu_as_sc_mcu7t3v3__fillcap_8
X_4461_ VDD VDD VSS VSS _4465_/B _5074_/Q _4509_/S gf180mcu_as_sc_mcu7t3v3__nand2_2
X_3412_ VDD VDD VSS VSS _4065_/A _3468_/B _3412_/C _3412_/D _3413_/A gf180mcu_as_sc_mcu7t3v3__ao22_2
XTAP_TAPCELL_ROW_101_3_3025 VDD VSS gf180mcu_as_sc_mcu7t3v3__tap_2
X_4392_ VDD VDD VSS VSS _4542_/A _5008_/Q _5037_/Q _4393_/B gf180mcu_as_sc_mcu7t3v3__mux2_2
XFILLER_63_1418 VDD VDD VSS VSS gf180mcu_as_sc_mcu7t3v3__fillcap_4
Xfanout808 VDD VDD VSS VSS fanout809/Y _4579_/S gf180mcu_as_sc_mcu7t3v3__buff_12
X_3343_ VDD VDD VSS VSS _3505_/S _3343_/B _3994_/A _3344_/B gf180mcu_as_sc_mcu7t3v3__mux2_2
X_3274_ VDD VDD VSS VSS _3925_/D _3404_/B _3274_/C _3274_/D _3279_/A gf180mcu_as_sc_mcu7t3v3__ao211_2
XFILLER_38_221 VDD VDD VSS VSS gf180mcu_as_sc_mcu7t3v3__fill_1
X_5013_ VDD VDD VSS VSS clkload5/A _5013_/D _5013_/Q gf180mcu_as_sc_mcu7t3v3__dfxtp_2
XTAP_TAPCELL_ROW_33_1463 VDD VSS gf180mcu_as_sc_mcu7t3v3__tap_2
XTAP_TAPCELL_ROW_33_1452 VDD VSS gf180mcu_as_sc_mcu7t3v3__tap_2
XFILLER_27_928 VDD VDD VSS VSS gf180mcu_as_sc_mcu7t3v3__fillcap_16
XFILLER_6_1367 VDD VDD VSS VSS gf180mcu_as_sc_mcu7t3v3__fill_1
XPHY_EDGE_ROW_68_3_Left_453 VDD VSS gf180mcu_as_sc_mcu7t3v3__tap_2
XFILLER_183_1208 VDD VDD VSS VSS gf180mcu_as_sc_mcu7t3v3__fillcap_4
XFILLER_187_1399 VDD VDD VSS VSS gf180mcu_as_sc_mcu7t3v3__fill_1
XFILLER_4_1091 VDD VDD VSS VSS gf180mcu_as_sc_mcu7t3v3__fill_2
XPHY_EDGE_ROW_5_Right_5 VDD VSS gf180mcu_as_sc_mcu7t3v3__tap_2
XFILLER_210_745 VDD VDD VSS VSS gf180mcu_as_sc_mcu7t3v3__fill_2
XFILLER_22_655 VDD VDD VSS VSS gf180mcu_as_sc_mcu7t3v3__fillcap_8
XFILLER_22_677 VDD VDD VSS VSS gf180mcu_as_sc_mcu7t3v3__fillcap_16
XFILLER_10_839 VDD VDD VSS VSS gf180mcu_as_sc_mcu7t3v3__fillcap_16
XFILLER_194_457 VDD VDD VSS VSS gf180mcu_as_sc_mcu7t3v3__fillcap_16
Xclkbuf_leaf_13_clk_regs VDD VDD VSS VSS clkbuf_leaf_7_clk_regs/A _5192_/CLK gf180mcu_as_sc_mcu7t3v3__clkbuff_12
X_2989_ VDD VDD VSS VSS _3594_/D _3115_/A _2989_/B _2989_/C _2990_/C gf180mcu_as_sc_mcu7t3v3__ao31_2
X_4728_ VDD VDD VSS VSS _5110_/Q _4731_/B _4730_/B _5266_/Q _4729_/C gf180mcu_as_sc_mcu7t3v3__ao22_2
XTAP_TAPCELL_ROW_45_3_2856 VDD VSS gf180mcu_as_sc_mcu7t3v3__tap_2
XFILLER_11_1542 VDD VDD VSS VSS gf180mcu_as_sc_mcu7t3v3__fill_2
XFILLER_159_1424 VDD VDD VSS VSS gf180mcu_as_sc_mcu7t3v3__fill_1
XPHY_EDGE_ROW_15_Left_226 VDD VSS gf180mcu_as_sc_mcu7t3v3__tap_2
X_4659_ VDD VDD VSS VSS _4660_/C _4659_/B _4659_/A gf180mcu_as_sc_mcu7t3v3__nor2_2
XFILLER_174_192 VDD VDD VSS VSS gf180mcu_as_sc_mcu7t3v3__fill_1
XFILLER_122_218 VDD VDD VSS VSS gf180mcu_as_sc_mcu7t3v3__fillcap_4
XFILLER_1_559 VDD VDD VSS VSS gf180mcu_as_sc_mcu7t3v3__fill_1
XTAP_TAPCELL_ROW_5_832 VDD VSS gf180mcu_as_sc_mcu7t3v3__tap_2
XFILLER_190_37 VDD VDD VSS VSS gf180mcu_as_sc_mcu7t3v3__fillcap_16
XTAP_TAPCELL_ROW_5_843 VDD VSS gf180mcu_as_sc_mcu7t3v3__tap_2
XFILLER_188_1119 VDD VDD VSS VSS gf180mcu_as_sc_mcu7t3v3__fillcap_16
XPHY_EDGE_ROW_24_Left_235 VDD VSS gf180mcu_as_sc_mcu7t3v3__tap_2
X_4899__1068 VDD VDD VSS VSS _4899_/D gf180mcu_as_sc_mcu7t3v3__tiel_4
XFILLER_29_265 VDD VDD VSS VSS gf180mcu_as_sc_mcu7t3v3__fillcap_8
XFILLER_29_298 VDD VDD VSS VSS gf180mcu_as_sc_mcu7t3v3__fillcap_8
XFILLER_83_68 VDD VDD VSS VSS gf180mcu_as_sc_mcu7t3v3__fill_2
XTAP_TAPCELL_ROW_205_2687 VDD VSS gf180mcu_as_sc_mcu7t3v3__tap_2
XTAP_TAPCELL_ROW_205_2676 VDD VSS gf180mcu_as_sc_mcu7t3v3__tap_2
XTAP_TAPCELL_ROW_197_2499 VDD VSS gf180mcu_as_sc_mcu7t3v3__tap_2
XFILLER_157_104 VDD VDD VSS VSS gf180mcu_as_sc_mcu7t3v3__fillcap_16
XFILLER_186_925 VDD VDD VSS VSS gf180mcu_as_sc_mcu7t3v3__fillcap_16
XFILLER_186_947 VDD VDD VSS VSS gf180mcu_as_sc_mcu7t3v3__fillcap_16
XFILLER_197_284 VDD VDD VSS VSS gf180mcu_as_sc_mcu7t3v3__fill_1
XFILLER_201_734 VDD VDD VSS VSS gf180mcu_as_sc_mcu7t3v3__fillcap_16
XFILLER_9_626 VDD VDD VSS VSS gf180mcu_as_sc_mcu7t3v3__fillcap_4
XFILLER_12_187 VDD VDD VSS VSS gf180mcu_as_sc_mcu7t3v3__fill_1
XFILLER_55_1480 VDD VDD VSS VSS gf180mcu_as_sc_mcu7t3v3__fillcap_4
XFILLER_9_648 VDD VDD VSS VSS gf180mcu_as_sc_mcu7t3v3__fillcap_4
XFILLER_103_1434 VDD VDD VSS VSS gf180mcu_as_sc_mcu7t3v3__fillcap_16
XFILLER_16_1497 VDD VDD VSS VSS gf180mcu_as_sc_mcu7t3v3__fillcap_8
XFILLER_172_107 VDD VDD VSS VSS gf180mcu_as_sc_mcu7t3v3__fillcap_16
XFILLER_32_83 VDD VDD VSS VSS gf180mcu_as_sc_mcu7t3v3__fill_1
XFILLER_8_169 VDD VDD VSS VSS gf180mcu_as_sc_mcu7t3v3__fillcap_4
XPHY_EDGE_ROW_33_Left_244 VDD VSS gf180mcu_as_sc_mcu7t3v3__tap_2
XFILLER_103_1478 VDD VDD VSS VSS gf180mcu_as_sc_mcu7t3v3__fill_1
XFILLER_148_61 VDD VDD VSS VSS gf180mcu_as_sc_mcu7t3v3__fillcap_4
XFILLER_201_1046 VDD VDD VSS VSS gf180mcu_as_sc_mcu7t3v3__fillcap_4
XFILLER_201_1068 VDD VDD VSS VSS gf180mcu_as_sc_mcu7t3v3__fillcap_16
XFILLER_86_1418 VDD VDD VSS VSS gf180mcu_as_sc_mcu7t3v3__fill_1
XFILLER_4_331 VDD VDD VSS VSS gf180mcu_as_sc_mcu7t3v3__fillcap_4
XPHY_EDGE_ROW_135_1_Right_656 VDD VSS gf180mcu_as_sc_mcu7t3v3__tap_2
XFILLER_10_1063 VDD VDD VSS VSS gf180mcu_as_sc_mcu7t3v3__fillcap_16
XFILLER_181_696 VDD VDD VSS VSS gf180mcu_as_sc_mcu7t3v3__fillcap_4
XTAP_TAPCELL_ROW_71_3_2935 VDD VSS gf180mcu_as_sc_mcu7t3v3__tap_2
XFILLER_23_1402 VDD VDD VSS VSS gf180mcu_as_sc_mcu7t3v3__fillcap_4
XFILLER_23_1424 VDD VDD VSS VSS gf180mcu_as_sc_mcu7t3v3__fill_1
XFILLER_79_176 VDD VDD VSS VSS gf180mcu_as_sc_mcu7t3v3__fillcap_8
XFILLER_94_102 VDD VDD VSS VSS gf180mcu_as_sc_mcu7t3v3__fill_2
XFILLER_209_834 VDD VDD VSS VSS gf180mcu_as_sc_mcu7t3v3__fillcap_4
XFILLER_23_1468 VDD VDD VSS VSS gf180mcu_as_sc_mcu7t3v3__fill_2
XFILLER_21_1170 VDD VDD VSS VSS gf180mcu_as_sc_mcu7t3v3__fillcap_8
XFILLER_36_747 VDD VDD VSS VSS gf180mcu_as_sc_mcu7t3v3__fill_1
XFILLER_97_1558 VDD VDD VSS VSS gf180mcu_as_sc_mcu7t3v3__fillcap_8
XPHY_EDGE_ROW_111_3_Right_148 VDD VSS gf180mcu_as_sc_mcu7t3v3__tap_2
XFILLER_21_1192 VDD VDD VSS VSS gf180mcu_as_sc_mcu7t3v3__fillcap_16
X_3961_ VDD VDD VSS VSS _3962_/D _3961_/C _4033_/B _3961_/A gf180mcu_as_sc_mcu7t3v3__aoi21_2
XFILLER_177_903 VDD VDD VSS VSS gf180mcu_as_sc_mcu7t3v3__fillcap_4
X_2912_ VDD VDD VSS VSS _3255_/C _3788_/D _3796_/D gf180mcu_as_sc_mcu7t3v3__nor2_2
XFILLER_17_1217 VDD VDD VSS VSS gf180mcu_as_sc_mcu7t3v3__fillcap_16
XFILLER_31_430 VDD VDD VSS VSS gf180mcu_as_sc_mcu7t3v3__fill_2
X_3892_ VDD VDD VSS VSS _3902_/B _5182_/Q _4932_/D gf180mcu_as_sc_mcu7t3v3__and2_2
XFILLER_160_1550 VDD VDD VSS VSS gf180mcu_as_sc_mcu7t3v3__fillcap_16
XFILLER_176_457 VDD VDD VSS VSS gf180mcu_as_sc_mcu7t3v3__fillcap_4
XFILLER_85_2 VDD VDD VSS VSS gf180mcu_as_sc_mcu7t3v3__fill_2
X_2843_ VDD VDD VSS VSS _4290_/B _5226_/Q _4746_/B gf180mcu_as_sc_mcu7t3v3__xnor2_2
XFILLER_191_416 VDD VDD VSS VSS gf180mcu_as_sc_mcu7t3v3__fillcap_4
X_2774_ VDD VDD VSS VSS _4259_/B _4719_/A _4649_/B gf180mcu_as_sc_mcu7t3v3__and2_2
XFILLER_156_170 VDD VDD VSS VSS gf180mcu_as_sc_mcu7t3v3__fillcap_4
X_4513_ VDD VDD VSS VSS _5179_/Q _4574_/B _4513_/C _4513_/D _5179_/D gf180mcu_as_sc_mcu7t3v3__ao211_2
XFILLER_208_53 VDD VDD VSS VSS gf180mcu_as_sc_mcu7t3v3__fillcap_16
XTAP_TAPCELL_ROW_120_3_3080 VDD VSS gf180mcu_as_sc_mcu7t3v3__tap_2
X_4444_ VDD VDD VSS VSS _4444_/B _4533_/A _4451_/C gf180mcu_as_sc_mcu7t3v3__and2_2
XFILLER_28_1313 VDD VDD VSS VSS gf180mcu_as_sc_mcu7t3v3__fillcap_8
Xfanout605 VDD VDD VSS VSS _3908_/B _3897_/B gf180mcu_as_sc_mcu7t3v3__buff_12
X_4375_ VDD VDD VSS VSS _5164_/Q _4575_/B _4575_/C _5484_/A _4376_/B gf180mcu_as_sc_mcu7t3v3__ao22_2
XTAP_TAPCELL_ROW_35_1503 VDD VSS gf180mcu_as_sc_mcu7t3v3__tap_2
XFILLER_119_1485 VDD VDD VSS VSS gf180mcu_as_sc_mcu7t3v3__fill_1
Xfanout616 VDD VDD VSS VSS _4493_/B _4470_/B gf180mcu_as_sc_mcu7t3v3__buff_12
Xfanout627 VDD VDD VSS VSS _3924_/Y _4161_/B gf180mcu_as_sc_mcu7t3v3__buff_12
Xfanout638 VDD VDD VSS VSS _3725_/B _3650_/B gf180mcu_as_sc_mcu7t3v3__buff_12
Xfanout649 VDD VDD VSS VSS _3262_/Y _3451_/B gf180mcu_as_sc_mcu7t3v3__buff_12
X_3326_ VDD VDD VSS VSS _3477_/B _3326_/B _3326_/C _3327_/C gf180mcu_as_sc_mcu7t3v3__nor3_2
XFILLER_189_1406 VDD VDD VSS VSS gf180mcu_as_sc_mcu7t3v3__fill_2
XFILLER_28_1379 VDD VDD VSS VSS gf180mcu_as_sc_mcu7t3v3__fill_1
XPHY_EDGE_ROW_73_3_Right_110 VDD VSS gf180mcu_as_sc_mcu7t3v3__tap_2
X_3257_ VDD VDD VSS VSS _3271_/B _3812_/A _3257_/A gf180mcu_as_sc_mcu7t3v3__nand2_2
XTAP_TAPCELL_ROW_86_1_1702 VDD VSS gf180mcu_as_sc_mcu7t3v3__tap_2
XFILLER_2_1017 VDD VDD VSS VSS gf180mcu_as_sc_mcu7t3v3__fillcap_16
XFILLER_41_1568 VDD VDD VSS VSS gf180mcu_as_sc_mcu7t3v3__fill_1
XFILLER_6_1175 VDD VDD VSS VSS gf180mcu_as_sc_mcu7t3v3__fill_1
X_3188_ VDD VDD VSS VSS _3235_/B _3188_/B _4159_/A _3191_/D gf180mcu_as_sc_mcu7t3v3__mux2_2
XTAP_TAPCELL_ROW_98_3_3014 VDD VSS gf180mcu_as_sc_mcu7t3v3__tap_2
XFILLER_26_224 VDD VDD VSS VSS gf180mcu_as_sc_mcu7t3v3__fill_1
XFILLER_27_769 VDD VDD VSS VSS gf180mcu_as_sc_mcu7t3v3__fill_1
XFILLER_53_27 VDD VDD VSS VSS gf180mcu_as_sc_mcu7t3v3__fillcap_16
XFILLER_183_1049 VDD VDD VSS VSS gf180mcu_as_sc_mcu7t3v3__fill_1
XFILLER_35_780 VDD VDD VSS VSS gf180mcu_as_sc_mcu7t3v3__fillcap_4
XFILLER_39_1442 VDD VDD VSS VSS gf180mcu_as_sc_mcu7t3v3__fill_2
XTAP_TAPCELL_ROW_200_2562 VDD VSS gf180mcu_as_sc_mcu7t3v3__tap_2
XFILLER_139_104 VDD VDD VSS VSS gf180mcu_as_sc_mcu7t3v3__fillcap_16
XFILLER_169_38 VDD VDD VSS VSS gf180mcu_as_sc_mcu7t3v3__fillcap_16
XFILLER_179_262 VDD VDD VSS VSS gf180mcu_as_sc_mcu7t3v3__fillcap_4
XFILLER_210_520 VDD VDD VSS VSS gf180mcu_as_sc_mcu7t3v3__fill_1
XFILLER_22_430 VDD VDD VSS VSS gf180mcu_as_sc_mcu7t3v3__fillcap_16
XTAP_TAPCELL_ROW_66_1_1644 VDD VSS gf180mcu_as_sc_mcu7t3v3__tap_2
XTAP_TAPCELL_ROW_200_2573 VDD VSS gf180mcu_as_sc_mcu7t3v3__tap_2
XTAP_TAPCELL_ROW_175_2027 VDD VSS gf180mcu_as_sc_mcu7t3v3__tap_2
XTAP_TAPCELL_ROW_175_2016 VDD VSS gf180mcu_as_sc_mcu7t3v3__tap_2
XFILLER_183_906 VDD VDD VSS VSS gf180mcu_as_sc_mcu7t3v3__fillcap_4
XFILLER_195_766 VDD VDD VSS VSS gf180mcu_as_sc_mcu7t3v3__fillcap_4
XFILLER_74_1399 VDD VDD VSS VSS gf180mcu_as_sc_mcu7t3v3__fillcap_16
XFILLER_154_107 VDD VDD VSS VSS gf180mcu_as_sc_mcu7t3v3__fillcap_4
XFILLER_183_928 VDD VDD VSS VSS gf180mcu_as_sc_mcu7t3v3__fillcap_16
XFILLER_195_788 VDD VDD VSS VSS gf180mcu_as_sc_mcu7t3v3__fillcap_16
XFILLER_210_575 VDD VDD VSS VSS gf180mcu_as_sc_mcu7t3v3__fill_2
XFILLER_33_1052 VDD VDD VSS VSS gf180mcu_as_sc_mcu7t3v3__fillcap_16
XFILLER_147_170 VDD VDD VSS VSS gf180mcu_as_sc_mcu7t3v3__fillcap_16
XFILLER_33_1085 VDD VDD VSS VSS gf180mcu_as_sc_mcu7t3v3__fill_2
XTAP_TAPCELL_ROW_192_2396 VDD VSS gf180mcu_as_sc_mcu7t3v3__tap_2
XFILLER_202_1399 VDD VDD VSS VSS gf180mcu_as_sc_mcu7t3v3__fillcap_16
XFILLER_5_139 VDD VDD VSS VSS gf180mcu_as_sc_mcu7t3v3__fill_1
XFILLER_190_493 VDD VDD VSS VSS gf180mcu_as_sc_mcu7t3v3__fillcap_16
XFILLER_194_1189 VDD VDD VSS VSS gf180mcu_as_sc_mcu7t3v3__fillcap_16
XFILLER_1_345 VDD VDD VSS VSS gf180mcu_as_sc_mcu7t3v3__fillcap_4
XFILLER_2_868 VDD VDD VSS VSS gf180mcu_as_sc_mcu7t3v3__fillcap_4
XFILLER_172_1487 VDD VDD VSS VSS gf180mcu_as_sc_mcu7t3v3__fillcap_8
XFILLER_46_1479 VDD VDD VSS VSS gf180mcu_as_sc_mcu7t3v3__fill_1
XTAP_TAPCELL_ROW_207_2716 VDD VSS gf180mcu_as_sc_mcu7t3v3__tap_2
XFILLER_94_34 VDD VDD VSS VSS gf180mcu_as_sc_mcu7t3v3__fill_1
Xmesh_tile_1004 VDD VDD VSS VSS nw_out[11] gf180mcu_as_sc_mcu7t3v3__tiel_4
Xmesh_tile_1015 VDD VDD VSS VSS nw_out[22] gf180mcu_as_sc_mcu7t3v3__tiel_4
Xmesh_tile_1026 VDD VDD VSS VSS nw_out[33] gf180mcu_as_sc_mcu7t3v3__tiel_4
XTAP_TAPCELL_ROW_207_2727 VDD VSS gf180mcu_as_sc_mcu7t3v3__tap_2
Xmesh_tile_1059 VDD VDD VSS VSS sw_out[32] gf180mcu_as_sc_mcu7t3v3__tiel_4
Xmesh_tile_1048 VDD VDD VSS VSS sw_out[21] gf180mcu_as_sc_mcu7t3v3__tiel_4
Xmesh_tile_1037 VDD VDD VSS VSS sw_out[10] gf180mcu_as_sc_mcu7t3v3__tiel_4
XFILLER_205_314 VDD VDD VSS VSS gf180mcu_as_sc_mcu7t3v3__fillcap_16
XFILLER_27_61 VDD VDD VSS VSS gf180mcu_as_sc_mcu7t3v3__fillcap_8
XFILLER_150_62 VDD VDD VSS VSS gf180mcu_as_sc_mcu7t3v3__fillcap_16
XFILLER_27_83 VDD VDD VSS VSS gf180mcu_as_sc_mcu7t3v3__fillcap_16
XFILLER_18_1515 VDD VDD VSS VSS gf180mcu_as_sc_mcu7t3v3__fillcap_4
XFILLER_26_780 VDD VDD VSS VSS gf180mcu_as_sc_mcu7t3v3__fill_2
XFILLER_92_1422 VDD VDD VSS VSS gf180mcu_as_sc_mcu7t3v3__fill_2
XFILLER_144_1523 VDD VDD VSS VSS gf180mcu_as_sc_mcu7t3v3__fillcap_16
XFILLER_92_1477 VDD VDD VSS VSS gf180mcu_as_sc_mcu7t3v3__fillcap_16
XFILLER_14_986 VDD VDD VSS VSS gf180mcu_as_sc_mcu7t3v3__fillcap_16
XFILLER_18_1559 VDD VDD VSS VSS gf180mcu_as_sc_mcu7t3v3__fillcap_8
XTAP_TAPCELL_ROW_113_1_1783 VDD VSS gf180mcu_as_sc_mcu7t3v3__tap_2
XTAP_TAPCELL_ROW_125_3_3095 VDD VSS gf180mcu_as_sc_mcu7t3v3__tap_2
XFILLER_12_1136 VDD VDD VSS VSS gf180mcu_as_sc_mcu7t3v3__fillcap_16
XFILLER_16_1294 VDD VDD VSS VSS gf180mcu_as_sc_mcu7t3v3__fill_1
XFILLER_177_1332 VDD VDD VSS VSS gf180mcu_as_sc_mcu7t3v3__fillcap_16
XFILLER_177_1376 VDD VDD VSS VSS gf180mcu_as_sc_mcu7t3v3__fillcap_16
X_2490_ VDD VDD VSS VSS _4371_/A _4331_/A _5270_/Q gf180mcu_as_sc_mcu7t3v3__nor2_2
XPHY_EDGE_ROW_136_1_Right_657 VDD VSS gf180mcu_as_sc_mcu7t3v3__tap_2
X_4160_ VDD VDD VSS VSS _4160_/A _4160_/B _4160_/C _4160_/D _4161_/D gf180mcu_as_sc_mcu7t3v3__ao22_2
XTAP_TAPCELL_ROW_90_3_2990 VDD VSS gf180mcu_as_sc_mcu7t3v3__tap_2
XFILLER_64_1568 VDD VDD VSS VSS gf180mcu_as_sc_mcu7t3v3__fill_1
XPHY_EDGE_ROW_123_1_Left_333 VDD VSS gf180mcu_as_sc_mcu7t3v3__tap_2
X_3111_ VDD VDD VSS VSS _4087_/A _3233_/B _3169_/C _4088_/D _3112_/C gf180mcu_as_sc_mcu7t3v3__ao22_2
XFILLER_67_146 VDD VDD VSS VSS gf180mcu_as_sc_mcu7t3v3__fill_2
X_4091_ VDD VDD VSS VSS _4091_/A _4141_/B _4091_/C _4248_/B _4124_/D gf180mcu_as_sc_mcu7t3v3__aoi211_2
XTAP_TAPCELL_ROW_30_1400 VDD VSS gf180mcu_as_sc_mcu7t3v3__tap_2
XFILLER_209_664 VDD VDD VSS VSS gf180mcu_as_sc_mcu7t3v3__fillcap_16
Xinput290 VDD VDD VSS VSS west_in[16] _4065_/A gf180mcu_as_sc_mcu7t3v3__buff_12
X_3042_ VDD VDD VSS VSS _4022_/A _3042_/B _3042_/C _4021_/A _3048_/B gf180mcu_as_sc_mcu7t3v3__ao22_2
XFILLER_208_174 VDD VDD VSS VSS gf180mcu_as_sc_mcu7t3v3__fill_1
XFILLER_75_190 VDD VDD VSS VSS gf180mcu_as_sc_mcu7t3v3__fillcap_8
XFILLER_82_127 VDD VDD VSS VSS gf180mcu_as_sc_mcu7t3v3__fill_1
XFILLER_149_1434 VDD VDD VSS VSS gf180mcu_as_sc_mcu7t3v3__fillcap_8
XFILLER_188_1483 VDD VDD VSS VSS gf180mcu_as_sc_mcu7t3v3__fillcap_16
XPHY_EDGE_ROW_112_3_Right_149 VDD VSS gf180mcu_as_sc_mcu7t3v3__tap_2
XFILLER_90_160 VDD VDD VSS VSS gf180mcu_as_sc_mcu7t3v3__fillcap_8
X_4993_ VDD VDD VSS VSS clkload2/A _4993_/D _4993_/Q gf180mcu_as_sc_mcu7t3v3__dfxtp_2
XTAP_TAPCELL_ROW_28_1340 VDD VSS gf180mcu_as_sc_mcu7t3v3__tap_2
X_3944_ VDD VDD VSS VSS _3944_/A _4027_/B _3944_/C _3944_/D _3945_/B gf180mcu_as_sc_mcu7t3v3__ao22_2
XTAP_TAPCELL_ROW_28_1351 VDD VSS gf180mcu_as_sc_mcu7t3v3__tap_2
XFILLER_71_1528 VDD VDD VSS VSS gf180mcu_as_sc_mcu7t3v3__fill_1
X_3875_ VDD VDD VSS VSS _3897_/B _5165_/Q _4915_/D gf180mcu_as_sc_mcu7t3v3__and2_2
XFILLER_176_243 VDD VDD VSS VSS gf180mcu_as_sc_mcu7t3v3__fill_2
XFILLER_31_282 VDD VDD VSS VSS gf180mcu_as_sc_mcu7t3v3__fillcap_16
X_2826_ VDD VDD VSS VSS _2826_/S _2826_/B _5281_/Q _5280_/D gf180mcu_as_sc_mcu7t3v3__mux2_2
XTAP_TAPCELL_ROW_24_1259 VDD VSS gf180mcu_as_sc_mcu7t3v3__tap_2
XTAP_TAPCELL_ROW_24_1248 VDD VSS gf180mcu_as_sc_mcu7t3v3__tap_2
XFILLER_129_170 VDD VDD VSS VSS gf180mcu_as_sc_mcu7t3v3__fillcap_8
XFILLER_136_107 VDD VDD VSS VSS gf180mcu_as_sc_mcu7t3v3__fillcap_16
XFILLER_160_1380 VDD VDD VSS VSS gf180mcu_as_sc_mcu7t3v3__fill_1
XFILLER_177_799 VDD VDD VSS VSS gf180mcu_as_sc_mcu7t3v3__fillcap_4
XFILLER_34_1383 VDD VDD VSS VSS gf180mcu_as_sc_mcu7t3v3__fillcap_16
XFILLER_180_909 VDD VDD VSS VSS gf180mcu_as_sc_mcu7t3v3__fillcap_16
XFILLER_192_769 VDD VDD VSS VSS gf180mcu_as_sc_mcu7t3v3__fillcap_16
X_2757_ VDD VDD VSS VSS _4377_/A _2765_/C _2765_/B _4691_/A gf180mcu_as_sc_mcu7t3v3__aoi21_2
XFILLER_156_1427 VDD VDD VSS VSS gf180mcu_as_sc_mcu7t3v3__fillcap_16
XFILLER_191_279 VDD VDD VSS VSS gf180mcu_as_sc_mcu7t3v3__fill_1
XFILLER_2_109 VDD VDD VSS VSS gf180mcu_as_sc_mcu7t3v3__fill_1
X_2688_ VDD VDD VSS VSS _2732_/S _4958_/Q _4967_/Q _2691_/B gf180mcu_as_sc_mcu7t3v3__mux2_2
XTAP_TAPCELL_ROW_151_3_3174 VDD VSS gf180mcu_as_sc_mcu7t3v3__tap_2
X_4427_ VDD VDD VSS VSS _4431_/B _5070_/Q _4509_/S gf180mcu_as_sc_mcu7t3v3__nand2_2
XPHY_EDGE_ROW_55_1_Left_265 VDD VSS gf180mcu_as_sc_mcu7t3v3__tap_2
XFILLER_24_1007 VDD VDD VSS VSS gf180mcu_as_sc_mcu7t3v3__fillcap_8
XFILLER_28_1165 VDD VDD VSS VSS gf180mcu_as_sc_mcu7t3v3__fillcap_4
XFILLER_48_27 VDD VDD VSS VSS gf180mcu_as_sc_mcu7t3v3__fillcap_8
XFILLER_58_102 VDD VDD VSS VSS gf180mcu_as_sc_mcu7t3v3__fill_2
XFILLER_58_113 VDD VDD VSS VSS gf180mcu_as_sc_mcu7t3v3__fill_1
X_4358_ VDD VDD VSS VSS _4379_/B _4358_/B _5159_/Q _5159_/D gf180mcu_as_sc_mcu7t3v3__mux2_2
XFILLER_100_221 VDD VDD VSS VSS gf180mcu_as_sc_mcu7t3v3__fill_1
Xfanout479 VDD VDD VSS VSS _4227_/C _4224_/C gf180mcu_as_sc_mcu7t3v3__buff_12
X_4289_ VDD VDD VSS VSS _4289_/S _5485_/A _5123_/Q _5123_/D gf180mcu_as_sc_mcu7t3v3__mux2_2
X_3309_ VDD VDD VSS VSS _3957_/A _3382_/B _3382_/C _3961_/A _3310_/C gf180mcu_as_sc_mcu7t3v3__ao22_2
XPHY_EDGE_ROW_74_3_Right_111 VDD VSS gf180mcu_as_sc_mcu7t3v3__tap_2
XFILLER_76_1406 VDD VDD VSS VSS gf180mcu_as_sc_mcu7t3v3__fillcap_8
XTAP_TAPCELL_ROW_118_1_1798 VDD VSS gf180mcu_as_sc_mcu7t3v3__tap_2
XTAP_TAPCELL_ROW_202_2613 VDD VSS gf180mcu_as_sc_mcu7t3v3__tap_2
XFILLER_167_1534 VDD VDD VSS VSS gf180mcu_as_sc_mcu7t3v3__fillcap_16
XFILLER_64_37 VDD VDD VSS VSS gf180mcu_as_sc_mcu7t3v3__fillcap_16
XTAP_TAPCELL_ROW_202_2624 VDD VSS gf180mcu_as_sc_mcu7t3v3__tap_2
XFILLER_14_205 VDD VDD VSS VSS gf180mcu_as_sc_mcu7t3v3__fill_2
XFILLER_187_508 VDD VDD VSS VSS gf180mcu_as_sc_mcu7t3v3__fillcap_16
XFILLER_199_368 VDD VDD VSS VSS gf180mcu_as_sc_mcu7t3v3__fillcap_16
XFILLER_81_171 VDD VDD VSS VSS gf180mcu_as_sc_mcu7t3v3__fill_2
XFILLER_202_317 VDD VDD VSS VSS gf180mcu_as_sc_mcu7t3v3__fillcap_16
XPHY_EDGE_ROW_202_Left_412 VDD VSS gf180mcu_as_sc_mcu7t3v3__tap_2
XTAP_TAPCELL_ROW_194_2436 VDD VSS gf180mcu_as_sc_mcu7t3v3__tap_2
XFILLER_10_411 VDD VDD VSS VSS gf180mcu_as_sc_mcu7t3v3__fill_2
XFILLER_11_912 VDD VDD VSS VSS gf180mcu_as_sc_mcu7t3v3__fillcap_16
XFILLER_23_761 VDD VDD VSS VSS gf180mcu_as_sc_mcu7t3v3__fillcap_8
XFILLER_23_772 VDD VDD VSS VSS gf180mcu_as_sc_mcu7t3v3__fillcap_16
XTAP_TAPCELL_ROW_194_2447 VDD VSS gf180mcu_as_sc_mcu7t3v3__tap_2
XFILLER_183_714 VDD VDD VSS VSS gf180mcu_as_sc_mcu7t3v3__fill_2
XFILLER_22_271 VDD VDD VSS VSS gf180mcu_as_sc_mcu7t3v3__fillcap_4
XFILLER_80_69 VDD VDD VSS VSS gf180mcu_as_sc_mcu7t3v3__fillcap_8
XFILLER_11_978 VDD VDD VSS VSS gf180mcu_as_sc_mcu7t3v3__fill_2
XFILLER_196_69 VDD VDD VSS VSS gf180mcu_as_sc_mcu7t3v3__fillcap_16
Xwire836 VDD VDD VSS VSS wire836/A _3983_/A gf180mcu_as_sc_mcu7t3v3__clkbuff_12
Xwire847 VDD VDD VSS VSS wire847/A _4121_/A gf180mcu_as_sc_mcu7t3v3__clkbuff_12
XFILLER_10_499 VDD VDD VSS VSS gf180mcu_as_sc_mcu7t3v3__fill_1
XFILLER_183_769 VDD VDD VSS VSS gf180mcu_as_sc_mcu7t3v3__fill_1
Xwire869 VDD VDD VSS VSS wire869/A _3977_/A gf180mcu_as_sc_mcu7t3v3__clkbuff_12
XFILLER_87_1568 VDD VDD VSS VSS gf180mcu_as_sc_mcu7t3v3__fill_1
XFILLER_137_1360 VDD VDD VSS VSS gf180mcu_as_sc_mcu7t3v3__fill_2
XPHY_EDGE_ROW_145_3_Left_530 VDD VSS gf180mcu_as_sc_mcu7t3v3__tap_2
XPHY_EDGE_ROW_60_1_Right_581 VDD VSS gf180mcu_as_sc_mcu7t3v3__tap_2
XFILLER_161_50 VDD VDD VSS VSS gf180mcu_as_sc_mcu7t3v3__fillcap_16
XFILLER_161_72 VDD VDD VSS VSS gf180mcu_as_sc_mcu7t3v3__fillcap_16
XFILLER_38_93 VDD VDD VSS VSS gf180mcu_as_sc_mcu7t3v3__fillcap_8
XFILLER_64_149 VDD VDD VSS VSS gf180mcu_as_sc_mcu7t3v3__fillcap_4
XFILLER_111_1566 VDD VDD VSS VSS gf180mcu_as_sc_mcu7t3v3__fill_2
XFILLER_206_645 VDD VDD VSS VSS gf180mcu_as_sc_mcu7t3v3__fillcap_16
XFILLER_94_1517 VDD VDD VSS VSS gf180mcu_as_sc_mcu7t3v3__fillcap_4
XFILLER_206_667 VDD VDD VSS VSS gf180mcu_as_sc_mcu7t3v3__fillcap_16
XFILLER_72_171 VDD VDD VSS VSS gf180mcu_as_sc_mcu7t3v3__fillcap_4
XFILLER_207_1030 VDD VDD VSS VSS gf180mcu_as_sc_mcu7t3v3__fillcap_16
XFILLER_183_1380 VDD VDD VSS VSS gf180mcu_as_sc_mcu7t3v3__fillcap_8
XFILLER_18_1345 VDD VDD VSS VSS gf180mcu_as_sc_mcu7t3v3__fillcap_16
XFILLER_207_1052 VDD VDD VSS VSS gf180mcu_as_sc_mcu7t3v3__fillcap_8
XFILLER_13_282 VDD VDD VSS VSS gf180mcu_as_sc_mcu7t3v3__fillcap_8
XFILLER_144_1375 VDD VDD VSS VSS gf180mcu_as_sc_mcu7t3v3__fillcap_4
XFILLER_18_1367 VDD VDD VSS VSS gf180mcu_as_sc_mcu7t3v3__fillcap_8
XFILLER_18_1389 VDD VDD VSS VSS gf180mcu_as_sc_mcu7t3v3__fillcap_16
XTAP_TAPCELL_ROW_144_1_1877 VDD VSS gf180mcu_as_sc_mcu7t3v3__tap_2
XTAP_TAPCELL_ROW_156_3_3189 VDD VSS gf180mcu_as_sc_mcu7t3v3__tap_2
XFILLER_105_1348 VDD VDD VSS VSS gf180mcu_as_sc_mcu7t3v3__fillcap_8
XFILLER_118_107 VDD VDD VSS VSS gf180mcu_as_sc_mcu7t3v3__fillcap_16
XFILLER_70_80 VDD VDD VSS VSS gf180mcu_as_sc_mcu7t3v3__fillcap_4
X_3660_ VDD VDD VSS VSS _3661_/C _3660_/C _3660_/B _4033_/A gf180mcu_as_sc_mcu7t3v3__aoi21_2
XFILLER_62_4 VDD VDD VSS VSS gf180mcu_as_sc_mcu7t3v3__fill_1
XTAP_TAPCELL_ROW_12_984 VDD VSS gf180mcu_as_sc_mcu7t3v3__tap_2
XTAP_TAPCELL_ROW_12_995 VDD VSS gf180mcu_as_sc_mcu7t3v3__tap_2
Xclkload12 VDD VDD VSS VSS clkload12/Y _4933_/CLK gf180mcu_as_sc_mcu7t3v3__inv_6
Xclkload23 VDD VDD VSS VSS clkload23/Y _5111_/CLK gf180mcu_as_sc_mcu7t3v3__inv_2
X_3591_ VDD VDD VSS VSS _3957_/A _3652_/B _3658_/B _3956_/A _3592_/D gf180mcu_as_sc_mcu7t3v3__ao22_2
X_2611_ VDD VDD VSS VSS _2776_/A _2771_/A _4708_/A gf180mcu_as_sc_mcu7t3v3__nor2_2
X_2542_ VDD VDD VSS VSS _4327_/C _4328_/A gf180mcu_as_sc_mcu7t3v3__inv_2
XFILLER_5_492 VDD VDD VSS VSS gf180mcu_as_sc_mcu7t3v3__fillcap_16
XPHY_EDGE_ROW_77_3_Left_462 VDD VSS gf180mcu_as_sc_mcu7t3v3__tap_2
X_5261_ VDD VDD VSS VSS _5262_/CLK _5261_/D _5261_/Q gf180mcu_as_sc_mcu7t3v3__dfxtp_2
X_4894__1073 VDD VDD VSS VSS _4894_/D gf180mcu_as_sc_mcu7t3v3__tiel_4
XPHY_EDGE_ROW_137_1_Right_658 VDD VSS gf180mcu_as_sc_mcu7t3v3__tap_2
X_4212_ VDD VDD VSS VSS _4241_/B _4228_/B _4228_/C _5048_/Q _5048_/D gf180mcu_as_sc_mcu7t3v3__ao22_2
X_2473_ VDD VDD VSS VSS _2474_/C _4362_/B _4369_/B gf180mcu_as_sc_mcu7t3v3__nand2_2
XFILLER_141_176 VDD VDD VSS VSS gf180mcu_as_sc_mcu7t3v3__fill_1
X_5192_ VDD VDD VSS VSS _5192_/CLK _5192_/D _5192_/Q gf180mcu_as_sc_mcu7t3v3__dfxtp_2
XFILLER_116_1444 VDD VDD VSS VSS gf180mcu_as_sc_mcu7t3v3__fillcap_4
X_4143_ VDD VDD VSS VSS _4143_/A _4161_/B _4159_/C _4143_/D _4145_/C gf180mcu_as_sc_mcu7t3v3__ao22_2
X_4074_ VDD VDD VSS VSS _4075_/C _4074_/B _4074_/A gf180mcu_as_sc_mcu7t3v3__nor2_2
XTAP_TAPCELL_ROW_17_1096 VDD VSS gf180mcu_as_sc_mcu7t3v3__tap_2
XFILLER_3_1134 VDD VDD VSS VSS gf180mcu_as_sc_mcu7t3v3__fill_2
XFILLER_55_127 VDD VDD VSS VSS gf180mcu_as_sc_mcu7t3v3__fillcap_8
XTAP_TAPCELL_ROW_127_3_3103 VDD VSS gf180mcu_as_sc_mcu7t3v3__tap_2
X_3025_ VDD VDD VSS VSS _3126_/S _4006_/A _4006_/D _3027_/B gf180mcu_as_sc_mcu7t3v3__mux2_2
XFILLER_36_330 VDD VDD VSS VSS gf180mcu_as_sc_mcu7t3v3__fillcap_8
XFILLER_188_1291 VDD VDD VSS VSS gf180mcu_as_sc_mcu7t3v3__fillcap_4
XFILLER_34_18 VDD VDD VSS VSS gf180mcu_as_sc_mcu7t3v3__fillcap_16
XFILLER_63_182 VDD VDD VSS VSS gf180mcu_as_sc_mcu7t3v3__fillcap_4
XFILLER_36_1412 VDD VDD VSS VSS gf180mcu_as_sc_mcu7t3v3__fillcap_16
XFILLER_162_1431 VDD VDD VSS VSS gf180mcu_as_sc_mcu7t3v3__fillcap_16
XFILLER_189_390 VDD VDD VSS VSS gf180mcu_as_sc_mcu7t3v3__fill_2
XFILLER_196_327 VDD VDD VSS VSS gf180mcu_as_sc_mcu7t3v3__fill_1
X_4976_ VDD VDD VSS VSS _5285_/CLK _4976_/D _4976_/Q gf180mcu_as_sc_mcu7t3v3__dfxtp_2
XFILLER_123_1415 VDD VDD VSS VSS gf180mcu_as_sc_mcu7t3v3__fill_1
XFILLER_123_1426 VDD VDD VSS VSS gf180mcu_as_sc_mcu7t3v3__fillcap_16
XFILLER_20_731 VDD VDD VSS VSS gf180mcu_as_sc_mcu7t3v3__fillcap_4
X_3927_ VDD VDD VSS VSS _3927_/Y _3927_/B _3927_/A gf180mcu_as_sc_mcu7t3v3__nor2_2
XFILLER_203_1450 VDD VDD VSS VSS gf180mcu_as_sc_mcu7t3v3__fillcap_16
XFILLER_20_753 VDD VDD VSS VSS gf180mcu_as_sc_mcu7t3v3__fill_2
Xclkload6 VDD VDD VSS VSS clkload6/A clkload6/Y gf180mcu_as_sc_mcu7t3v3__clkbuff_12
X_3858_ VDD VDD VSS VSS _3858_/A _3858_/B _3858_/C _3858_/D _3873_/A gf180mcu_as_sc_mcu7t3v3__nand4_2
XFILLER_203_1472 VDD VDD VSS VSS gf180mcu_as_sc_mcu7t3v3__fillcap_16
XFILLER_30_1033 VDD VDD VSS VSS gf180mcu_as_sc_mcu7t3v3__fillcap_16
X_3789_ VDD VDD VSS VSS _3789_/D _3789_/A _3812_/B _3797_/C _3790_/D gf180mcu_as_sc_mcu7t3v3__ao31_2
X_2809_ VDD VDD VSS VSS _2809_/B _4708_/C _2811_/C gf180mcu_as_sc_mcu7t3v3__and2_2
XFILLER_195_1240 VDD VDD VSS VSS gf180mcu_as_sc_mcu7t3v3__fillcap_16
XPHY_EDGE_ROW_99_1_Right_620 VDD VSS gf180mcu_as_sc_mcu7t3v3__tap_2
XFILLER_195_1262 VDD VDD VSS VSS gf180mcu_as_sc_mcu7t3v3__fillcap_16
XFILLER_132_154 VDD VDD VSS VSS gf180mcu_as_sc_mcu7t3v3__fillcap_16
XTAP_TAPCELL_ROW_170_1_1956 VDD VSS gf180mcu_as_sc_mcu7t3v3__tap_2
XTAP_TAPCELL_ROW_187_2284 VDD VSS gf180mcu_as_sc_mcu7t3v3__tap_2
XFILLER_43_1438 VDD VDD VSS VSS gf180mcu_as_sc_mcu7t3v3__fill_1
XTAP_TAPCELL_ROW_187_2295 VDD VSS gf180mcu_as_sc_mcu7t3v3__tap_2
XFILLER_75_69 VDD VDD VSS VSS gf180mcu_as_sc_mcu7t3v3__fill_1
XPHY_EDGE_ROW_75_3_Right_112 VDD VSS gf180mcu_as_sc_mcu7t3v3__tap_2
XFILLER_27_330 VDD VDD VSS VSS gf180mcu_as_sc_mcu7t3v3__fillcap_4
XFILLER_39_190 VDD VDD VSS VSS gf180mcu_as_sc_mcu7t3v3__fillcap_16
XFILLER_210_1498 VDD VDD VSS VSS gf180mcu_as_sc_mcu7t3v3__fillcap_16
XFILLER_27_363 VDD VDD VSS VSS gf180mcu_as_sc_mcu7t3v3__fillcap_4
XFILLER_128_1348 VDD VDD VSS VSS gf180mcu_as_sc_mcu7t3v3__fillcap_16
XFILLER_187_316 VDD VDD VSS VSS gf180mcu_as_sc_mcu7t3v3__fillcap_16
XFILLER_188_839 VDD VDD VSS VSS gf180mcu_as_sc_mcu7t3v3__fillcap_16
XFILLER_203_626 VDD VDD VSS VSS gf180mcu_as_sc_mcu7t3v3__fillcap_4
XFILLER_203_648 VDD VDD VSS VSS gf180mcu_as_sc_mcu7t3v3__fillcap_16
XFILLER_91_57 VDD VDD VSS VSS gf180mcu_as_sc_mcu7t3v3__fill_1
XFILLER_208_1361 VDD VDD VSS VSS gf180mcu_as_sc_mcu7t3v3__fillcap_4
XFILLER_54_1534 VDD VDD VSS VSS gf180mcu_as_sc_mcu7t3v3__fillcap_4
XFILLER_91_68 VDD VDD VSS VSS gf180mcu_as_sc_mcu7t3v3__fill_2
XFILLER_141_1504 VDD VDD VSS VSS gf180mcu_as_sc_mcu7t3v3__fillcap_8
XFILLER_196_872 VDD VDD VSS VSS gf180mcu_as_sc_mcu7t3v3__fill_2
XFILLER_208_1383 VDD VDD VSS VSS gf180mcu_as_sc_mcu7t3v3__fillcap_16
XFILLER_30_539 VDD VDD VSS VSS gf180mcu_as_sc_mcu7t3v3__fillcap_8
XPHY_EDGE_ROW_7_Left_218 VDD VSS gf180mcu_as_sc_mcu7t3v3__tap_2
XFILLER_11_753 VDD VDD VSS VSS gf180mcu_as_sc_mcu7t3v3__fill_2
XFILLER_7_702 VDD VDD VSS VSS gf180mcu_as_sc_mcu7t3v3__fillcap_4
Xwire633 VDD VDD VSS VSS _3821_/Y _4168_/A gf180mcu_as_sc_mcu7t3v3__clkbuff_12
XFILLER_183_544 VDD VDD VSS VSS gf180mcu_as_sc_mcu7t3v3__fillcap_16
XFILLER_7_768 VDD VDD VSS VSS gf180mcu_as_sc_mcu7t3v3__fill_2
XFILLER_108_140 VDD VDD VSS VSS gf180mcu_as_sc_mcu7t3v3__fill_2
XFILLER_13_1264 VDD VDD VSS VSS gf180mcu_as_sc_mcu7t3v3__fill_1
XFILLER_183_599 VDD VDD VSS VSS gf180mcu_as_sc_mcu7t3v3__fill_1
XFILLER_178_1493 VDD VDD VSS VSS gf180mcu_as_sc_mcu7t3v3__fillcap_8
XFILLER_139_1477 VDD VDD VSS VSS gf180mcu_as_sc_mcu7t3v3__fillcap_8
XFILLER_3_941 VDD VDD VSS VSS gf180mcu_as_sc_mcu7t3v3__fillcap_8
XFILLER_139_1488 VDD VDD VSS VSS gf180mcu_as_sc_mcu7t3v3__fillcap_16
XFILLER_2_473 VDD VDD VSS VSS gf180mcu_as_sc_mcu7t3v3__fill_2
XFILLER_61_1516 VDD VDD VSS VSS gf180mcu_as_sc_mcu7t3v3__fill_1
XPHY_EDGE_ROW_61_1_Right_582 VDD VSS gf180mcu_as_sc_mcu7t3v3__tap_2
XFILLER_37_138 VDD VDD VSS VSS gf180mcu_as_sc_mcu7t3v3__fill_2
XFILLER_1_88 VDD VDD VSS VSS gf180mcu_as_sc_mcu7t3v3__fill_2
XFILLER_207_954 VDD VDD VSS VSS gf180mcu_as_sc_mcu7t3v3__fill_1
XFILLER_34_823 VDD VDD VSS VSS gf180mcu_as_sc_mcu7t3v3__fillcap_16
XFILLER_59_1434 VDD VDD VSS VSS gf180mcu_as_sc_mcu7t3v3__fill_2
XFILLER_59_1456 VDD VDD VSS VSS gf180mcu_as_sc_mcu7t3v3__fillcap_16
XFILLER_146_1415 VDD VDD VSS VSS gf180mcu_as_sc_mcu7t3v3__fillcap_4
XFILLER_146_1448 VDD VDD VSS VSS gf180mcu_as_sc_mcu7t3v3__fill_2
XFILLER_181_1317 VDD VDD VSS VSS gf180mcu_as_sc_mcu7t3v3__fillcap_8
XFILLER_185_1497 VDD VDD VSS VSS gf180mcu_as_sc_mcu7t3v3__fill_1
XFILLER_207_998 VDD VDD VSS VSS gf180mcu_as_sc_mcu7t3v3__fillcap_16
XFILLER_209_1147 VDD VDD VSS VSS gf180mcu_as_sc_mcu7t3v3__fillcap_4
X_4830_ VDD VDD VSS VSS _5073_/CLK _4830_/D _4830_/Q gf180mcu_as_sc_mcu7t3v3__dfxtp_2
XFILLER_21_528 VDD VDD VSS VSS gf180mcu_as_sc_mcu7t3v3__fill_1
XFILLER_18_1142 VDD VDD VSS VSS gf180mcu_as_sc_mcu7t3v3__fill_1
X_4761_ VDD VDD VSS VSS _5285_/CLK _4761_/D _4761_/Q gf180mcu_as_sc_mcu7t3v3__dfxtp_2
XFILLER_14_1017 VDD VDD VSS VSS gf180mcu_as_sc_mcu7t3v3__fillcap_16
X_4692_ VDD VDD VSS VSS _4725_/B _5479_/A _5252_/Q _4693_/A gf180mcu_as_sc_mcu7t3v3__mux2_2
X_3712_ VDD VDD VSS VSS _3712_/D _4085_/A _3736_/B _3800_/C _3713_/C gf180mcu_as_sc_mcu7t3v3__ao31_2
XFILLER_179_1224 VDD VDD VSS VSS gf180mcu_as_sc_mcu7t3v3__fillcap_16
XFILLER_70_1380 VDD VDD VSS VSS gf180mcu_as_sc_mcu7t3v3__fill_1
X_3643_ VDD VDD VSS VSS _4925_/Q _3727_/B _3727_/C _4013_/D _3644_/D gf180mcu_as_sc_mcu7t3v3__ao22_2
XFILLER_31_1397 VDD VDD VSS VSS gf180mcu_as_sc_mcu7t3v3__fill_2
X_3574_ VDD VDD VSS VSS _4916_/Q _3648_/B _3648_/C _3940_/A _3576_/C gf180mcu_as_sc_mcu7t3v3__ao22_2
XTAP_TAPCELL_ROW_60_1_1625 VDD VSS gf180mcu_as_sc_mcu7t3v3__tap_2
XFILLER_114_121 VDD VDD VSS VSS gf180mcu_as_sc_mcu7t3v3__fill_1
XFILLER_114_132 VDD VDD VSS VSS gf180mcu_as_sc_mcu7t3v3__fillcap_16
XFILLER_157_1566 VDD VDD VSS VSS gf180mcu_as_sc_mcu7t3v3__fill_2
XFILLER_66_1449 VDD VDD VSS VSS gf180mcu_as_sc_mcu7t3v3__fill_2
X_2525_ VDD VDD VSS VSS _2771_/A _2525_/A _2632_/B gf180mcu_as_sc_mcu7t3v3__and2_2
XFILLER_9_1332 VDD VDD VSS VSS gf180mcu_as_sc_mcu7t3v3__fillcap_16
X_5244_ VDD VDD VSS VSS clkload6/A _5244_/D _5244_/Q gf180mcu_as_sc_mcu7t3v3__dfxtp_2
X_2456_ VDD VDD VSS VSS _4353_/A _2456_/C _2456_/B _4546_/A gf180mcu_as_sc_mcu7t3v3__aoi21_2
XTAP_TAPCELL_ROW_19_1158 VDD VSS gf180mcu_as_sc_mcu7t3v3__tap_2
XTAP_TAPCELL_ROW_19_1147 VDD VSS gf180mcu_as_sc_mcu7t3v3__tap_2
XPHY_EDGE_ROW_138_1_Right_659 VDD VSS gf180mcu_as_sc_mcu7t3v3__tap_2
X_5175_ VDD VDD VSS VSS clkload9/A _5175_/D _5175_/Q gf180mcu_as_sc_mcu7t3v3__dfxtp_2
Xclkbuf_leaf_38_clk_regs VDD VDD VSS VSS clkbuf_leaf_2_clk_regs/A _5068_/CLK gf180mcu_as_sc_mcu7t3v3__clkbuff_12
XFILLER_29_628 VDD VDD VSS VSS gf180mcu_as_sc_mcu7t3v3__fill_2
X_4126_ VDD VDD VSS VSS _4126_/A _4160_/B _4161_/B _4126_/D _4127_/D gf180mcu_as_sc_mcu7t3v3__ao22_2
XTAP_TAPCELL_ROW_182_2181 VDD VSS gf180mcu_as_sc_mcu7t3v3__tap_2
XTAP_TAPCELL_ROW_182_2170 VDD VSS gf180mcu_as_sc_mcu7t3v3__tap_2
XFILLER_28_149 VDD VDD VSS VSS gf180mcu_as_sc_mcu7t3v3__fillcap_8
X_4057_ VDD VDD VSS VSS _4057_/A _4105_/B _4057_/C _4057_/D _4058_/B gf180mcu_as_sc_mcu7t3v3__ao211_2
XFILLER_24_311 VDD VDD VSS VSS gf180mcu_as_sc_mcu7t3v3__fillcap_4
X_3008_ VDD VDD VSS VSS _3008_/S _3989_/A _3991_/A _3010_/B gf180mcu_as_sc_mcu7t3v3__mux2_2
XFILLER_24_333 VDD VDD VSS VSS gf180mcu_as_sc_mcu7t3v3__fillcap_8
XFILLER_200_629 VDD VDD VSS VSS gf180mcu_as_sc_mcu7t3v3__fillcap_16
XFILLER_24_399 VDD VDD VSS VSS gf180mcu_as_sc_mcu7t3v3__fill_1
X_4959_ VDD VDD VSS VSS _5111_/CLK _4959_/D _4959_/Q gf180mcu_as_sc_mcu7t3v3__dfxtp_2
XFILLER_177_38 VDD VDD VSS VSS gf180mcu_as_sc_mcu7t3v3__fillcap_16
XFILLER_193_820 VDD VDD VSS VSS gf180mcu_as_sc_mcu7t3v3__fillcap_16
XFILLER_124_6 VDD VDD VSS VSS gf180mcu_as_sc_mcu7t3v3__fill_2
XFILLER_193_842 VDD VDD VSS VSS gf180mcu_as_sc_mcu7t3v3__fillcap_16
XFILLER_14_1562 VDD VDD VSS VSS gf180mcu_as_sc_mcu7t3v3__fillcap_4
XFILLER_192_374 VDD VDD VSS VSS gf180mcu_as_sc_mcu7t3v3__fillcap_8
Xclkbuf_2_2_0_clk_regs VDD VDD VSS VSS clkbuf_0_clk_regs/Y clkbuf_2_2_0_clk_regs/Y
+ gf180mcu_as_sc_mcu7t3v3__clkbuff_12
XFILLER_10_1437 VDD VDD VSS VSS gf180mcu_as_sc_mcu7t3v3__fillcap_8
XTAP_TAPCELL_ROW_189_2335 VDD VSS gf180mcu_as_sc_mcu7t3v3__tap_2
XTAP_TAPCELL_ROW_189_2324 VDD VSS gf180mcu_as_sc_mcu7t3v3__tap_2
XFILLER_10_53 VDD VDD VSS VSS gf180mcu_as_sc_mcu7t3v3__fillcap_16
XFILLER_126_53 VDD VDD VSS VSS gf180mcu_as_sc_mcu7t3v3__fillcap_16
Xoutput380 VDD VDD VSS VSS _4800_/Q se_out[29] gf180mcu_as_sc_mcu7t3v3__buff_12
XTAP_TAPCELL_ROW_210_2789 VDD VSS gf180mcu_as_sc_mcu7t3v3__tap_2
XFILLER_0_933 VDD VDD VSS VSS gf180mcu_as_sc_mcu7t3v3__fillcap_4
XFILLER_86_46 VDD VDD VSS VSS gf180mcu_as_sc_mcu7t3v3__fillcap_16
Xoutput391 VDD VDD VSS VSS _4779_/Q se_out[8] gf180mcu_as_sc_mcu7t3v3__buff_12
XFILLER_0_988 VDD VDD VSS VSS gf180mcu_as_sc_mcu7t3v3__fillcap_4
XFILLER_120_168 VDD VDD VSS VSS gf180mcu_as_sc_mcu7t3v3__fillcap_4
XFILLER_169_1404 VDD VDD VSS VSS gf180mcu_as_sc_mcu7t3v3__fillcap_8
XFILLER_19_127 VDD VDD VSS VSS gf180mcu_as_sc_mcu7t3v3__fillcap_8
XFILLER_142_85 VDD VDD VSS VSS gf180mcu_as_sc_mcu7t3v3__fill_1
XFILLER_19_95 VDD VDD VSS VSS gf180mcu_as_sc_mcu7t3v3__fillcap_16
XFILLER_16_823 VDD VDD VSS VSS gf180mcu_as_sc_mcu7t3v3__fillcap_16
XFILLER_28_683 VDD VDD VSS VSS gf180mcu_as_sc_mcu7t3v3__fillcap_4
XPHY_EDGE_ROW_76_3_Right_113 VDD VSS gf180mcu_as_sc_mcu7t3v3__tap_2
XTAP_TAPCELL_ROW_3_793 VDD VSS gf180mcu_as_sc_mcu7t3v3__tap_2
XFILLER_204_979 VDD VDD VSS VSS gf180mcu_as_sc_mcu7t3v3__fillcap_16
XFILLER_30_303 VDD VDD VSS VSS gf180mcu_as_sc_mcu7t3v3__fill_1
XFILLER_35_72 VDD VDD VSS VSS gf180mcu_as_sc_mcu7t3v3__fillcap_16
XFILLER_106_1410 VDD VDD VSS VSS gf180mcu_as_sc_mcu7t3v3__fillcap_16
XFILLER_204_1011 VDD VDD VSS VSS gf180mcu_as_sc_mcu7t3v3__fillcap_4
XFILLER_42_185 VDD VDD VSS VSS gf180mcu_as_sc_mcu7t3v3__fill_1
XFILLER_175_319 VDD VDD VSS VSS gf180mcu_as_sc_mcu7t3v3__fill_2
XFILLER_204_1033 VDD VDD VSS VSS gf180mcu_as_sc_mcu7t3v3__fillcap_16
XFILLER_141_1356 VDD VDD VSS VSS gf180mcu_as_sc_mcu7t3v3__fillcap_4
XFILLER_15_1348 VDD VDD VSS VSS gf180mcu_as_sc_mcu7t3v3__fillcap_16
XFILLER_184_853 VDD VDD VSS VSS gf180mcu_as_sc_mcu7t3v3__fillcap_16
XFILLER_195_190 VDD VDD VSS VSS gf180mcu_as_sc_mcu7t3v3__fillcap_16
XPHY_EDGE_ROW_132_1_Left_342 VDD VSS gf180mcu_as_sc_mcu7t3v3__tap_2
Xwire474 VDD VDD VSS VSS _3098_/Y _4788_/D gf180mcu_as_sc_mcu7t3v3__clkbuff_12
Xwire463 VDD VDD VSS VSS _3699_/Y _4856_/D gf180mcu_as_sc_mcu7t3v3__clkbuff_12
XTAP_TAPCELL_ROW_174_1969 VDD VSS gf180mcu_as_sc_mcu7t3v3__tap_2
Xwire496 VDD VDD VSS VSS _3065_/Y _4784_/D gf180mcu_as_sc_mcu7t3v3__clkbuff_12
XFILLER_174_1121 VDD VDD VSS VSS gf180mcu_as_sc_mcu7t3v3__fill_1
XTAP_TAPCELL_ROW_139_1_1861 VDD VSS gf180mcu_as_sc_mcu7t3v3__tap_2
X_3290_ VDD VDD VSS VSS _3401_/B _3942_/A _3292_/C gf180mcu_as_sc_mcu7t3v3__and2_2
XFILLER_111_113 VDD VDD VSS VSS gf180mcu_as_sc_mcu7t3v3__fillcap_16
XFILLER_26_1411 VDD VDD VSS VSS gf180mcu_as_sc_mcu7t3v3__fill_1
XFILLER_22_1308 VDD VDD VSS VSS gf180mcu_as_sc_mcu7t3v3__fillcap_4
XFILLER_6_1538 VDD VDD VSS VSS gf180mcu_as_sc_mcu7t3v3__fillcap_4
XTAP_TAPCELL_ROW_14_1033 VDD VSS gf180mcu_as_sc_mcu7t3v3__tap_2
XFILLER_152_1485 VDD VDD VSS VSS gf180mcu_as_sc_mcu7t3v3__fillcap_8
XFILLER_26_1477 VDD VDD VSS VSS gf180mcu_as_sc_mcu7t3v3__fillcap_4
XPHY_EDGE_ROW_62_1_Right_583 VDD VSS gf180mcu_as_sc_mcu7t3v3__tap_2
XTAP_TAPCELL_ROW_14_1044 VDD VSS gf180mcu_as_sc_mcu7t3v3__tap_2
XFILLER_113_1469 VDD VDD VSS VSS gf180mcu_as_sc_mcu7t3v3__fillcap_16
XFILLER_20_1010 VDD VDD VSS VSS gf180mcu_as_sc_mcu7t3v3__fillcap_4
XFILLER_19_661 VDD VDD VSS VSS gf180mcu_as_sc_mcu7t3v3__fillcap_8
XFILLER_202_22 VDD VDD VSS VSS gf180mcu_as_sc_mcu7t3v3__fillcap_8
XFILLER_18_171 VDD VDD VSS VSS gf180mcu_as_sc_mcu7t3v3__fillcap_4
XFILLER_18_193 VDD VDD VSS VSS gf180mcu_as_sc_mcu7t3v3__fillcap_16
XFILLER_20_1087 VDD VDD VSS VSS gf180mcu_as_sc_mcu7t3v3__fill_2
XFILLER_179_625 VDD VDD VSS VSS gf180mcu_as_sc_mcu7t3v3__fillcap_4
XFILLER_185_1294 VDD VDD VSS VSS gf180mcu_as_sc_mcu7t3v3__fillcap_16
XFILLER_34_664 VDD VDD VSS VSS gf180mcu_as_sc_mcu7t3v3__fill_1
XFILLER_21_325 VDD VDD VSS VSS gf180mcu_as_sc_mcu7t3v3__fill_2
XFILLER_33_174 VDD VDD VSS VSS gf180mcu_as_sc_mcu7t3v3__fillcap_16
X_4813_ VDD VDD VSS VSS _5068_/CLK _4813_/D _4813_/Q gf180mcu_as_sc_mcu7t3v3__dfxtp_2
XFILLER_175_820 VDD VDD VSS VSS gf180mcu_as_sc_mcu7t3v3__fillcap_16
XFILLER_187_680 VDD VDD VSS VSS gf180mcu_as_sc_mcu7t3v3__fillcap_16
XFILLER_210_949 VDD VDD VSS VSS gf180mcu_as_sc_mcu7t3v3__fill_2
XFILLER_72_1453 VDD VDD VSS VSS gf180mcu_as_sc_mcu7t3v3__fillcap_16
XPHY_EDGE_ROW_64_1_Left_274 VDD VSS gf180mcu_as_sc_mcu7t3v3__tap_2
X_4744_ VDD VDD VSS VSS _4747_/D _4744_/A _5274_/D gf180mcu_as_sc_mcu7t3v3__and2_2
XFILLER_175_842 VDD VDD VSS VSS gf180mcu_as_sc_mcu7t3v3__fillcap_8
XFILLER_30_881 VDD VDD VSS VSS gf180mcu_as_sc_mcu7t3v3__fill_1
XFILLER_175_897 VDD VDD VSS VSS gf180mcu_as_sc_mcu7t3v3__fillcap_8
XFILLER_190_801 VDD VDD VSS VSS gf180mcu_as_sc_mcu7t3v3__fillcap_4
XFILLER_190_823 VDD VDD VSS VSS gf180mcu_as_sc_mcu7t3v3__fillcap_16
XFILLER_200_1431 VDD VDD VSS VSS gf180mcu_as_sc_mcu7t3v3__fillcap_4
XPHY_EDGE_ROW_180_Left_390 VDD VSS gf180mcu_as_sc_mcu7t3v3__tap_2
X_4675_ VDD VDD VSS VSS _5245_/Q _4685_/C _4681_/C _5246_/Q _4676_/C gf180mcu_as_sc_mcu7t3v3__ao22_2
XFILLER_200_1453 VDD VDD VSS VSS gf180mcu_as_sc_mcu7t3v3__fillcap_16
XFILLER_31_1194 VDD VDD VSS VSS gf180mcu_as_sc_mcu7t3v3__fill_1
X_3626_ VDD VDD VSS VSS _4000_/A _3749_/B _3741_/C _4000_/D _3627_/D gf180mcu_as_sc_mcu7t3v3__ao22_2
XFILLER_192_1221 VDD VDD VSS VSS gf180mcu_as_sc_mcu7t3v3__fillcap_4
X_3557_ VDD VDD VSS VSS _3805_/A _3557_/B _3559_/C gf180mcu_as_sc_mcu7t3v3__nand2b_2
XTAP_TAPCELL_ROW_91_1_1719 VDD VSS gf180mcu_as_sc_mcu7t3v3__tap_2
XFILLER_192_1243 VDD VDD VSS VSS gf180mcu_as_sc_mcu7t3v3__fillcap_16
XFILLER_27_1208 VDD VDD VSS VSS gf180mcu_as_sc_mcu7t3v3__fillcap_4
X_2508_ VDD VDD VSS VSS _4739_/B _4331_/A _4643_/A gf180mcu_as_sc_mcu7t3v3__and2_2
XFILLER_157_1396 VDD VDD VSS VSS gf180mcu_as_sc_mcu7t3v3__fill_1
X_5227_ VDD VDD VSS VSS _5233_/CLK _5227_/D _5227_/Q gf180mcu_as_sc_mcu7t3v3__dfxtp_2
Xinput108 VDD VDD VSS VSS ne_in[6] wire905/A gf180mcu_as_sc_mcu7t3v3__buff_12
X_3488_ VDD VDD VSS VSS _3490_/C _4143_/A _3500_/B _3488_/C gf180mcu_as_sc_mcu7t3v3__ao21_2
XTAP_TAPCELL_ROW_184_2221 VDD VSS gf180mcu_as_sc_mcu7t3v3__tap_2
XTAP_TAPCELL_ROW_184_2210 VDD VSS gf180mcu_as_sc_mcu7t3v3__tap_2
XFILLER_44_1566 VDD VDD VSS VSS gf180mcu_as_sc_mcu7t3v3__fill_2
XFILLER_9_1173 VDD VDD VSS VSS gf180mcu_as_sc_mcu7t3v3__fill_2
Xinput119 VDD VDD VSS VSS north_in[16] _4061_/A gf180mcu_as_sc_mcu7t3v3__buff_12
X_2439_ VDD VDD VSS VSS _4075_/A _2439_/A gf180mcu_as_sc_mcu7t3v3__inv_2
XFILLER_40_1408 VDD VDD VSS VSS gf180mcu_as_sc_mcu7t3v3__fillcap_16
XFILLER_5_1048 VDD VDD VSS VSS gf180mcu_as_sc_mcu7t3v3__fill_2
X_5158_ VDD VDD VSS VSS clkload8/A _5158_/D _5158_/Q gf180mcu_as_sc_mcu7t3v3__dfxtp_2
XTAP_TAPCELL_ROW_180_2129 VDD VSS gf180mcu_as_sc_mcu7t3v3__tap_2
XFILLER_131_1558 VDD VDD VSS VSS gf180mcu_as_sc_mcu7t3v3__fillcap_8
X_5089_ VDD VDD VSS VSS _5090_/CLK _5089_/D _5089_/Q gf180mcu_as_sc_mcu7t3v3__dfxtp_2
X_4109_ VDD VDD VSS VSS _4109_/A _4118_/B _4118_/C _4109_/D _4110_/D gf180mcu_as_sc_mcu7t3v3__ao22_2
XTAP_TAPCELL_ROW_165_1_1940 VDD VSS gf180mcu_as_sc_mcu7t3v3__tap_2
XTAP_TAPCELL_ROW_0_730 VDD VSS gf180mcu_as_sc_mcu7t3v3__tap_2
XFILLER_204_209 VDD VDD VSS VSS gf180mcu_as_sc_mcu7t3v3__fillcap_16
XTAP_TAPCELL_ROW_0_741 VDD VSS gf180mcu_as_sc_mcu7t3v3__tap_2
XFILLER_197_400 VDD VDD VSS VSS gf180mcu_as_sc_mcu7t3v3__fillcap_16
XFILLER_197_422 VDD VDD VSS VSS gf180mcu_as_sc_mcu7t3v3__fillcap_8
XFILLER_38_1348 VDD VDD VSS VSS gf180mcu_as_sc_mcu7t3v3__fill_1
XFILLER_188_37 VDD VDD VSS VSS gf180mcu_as_sc_mcu7t3v3__fillcap_16
XFILLER_25_697 VDD VDD VSS VSS gf180mcu_as_sc_mcu7t3v3__fill_2
XFILLER_90_1520 VDD VDD VSS VSS gf180mcu_as_sc_mcu7t3v3__fill_1
XFILLER_36_1072 VDD VDD VSS VSS gf180mcu_as_sc_mcu7t3v3__fill_2
XFILLER_8_307 VDD VDD VSS VSS gf180mcu_as_sc_mcu7t3v3__fillcap_8
XFILLER_184_127 VDD VDD VSS VSS gf180mcu_as_sc_mcu7t3v3__fill_2
XFILLER_205_1364 VDD VDD VSS VSS gf180mcu_as_sc_mcu7t3v3__fillcap_16
XFILLER_8_329 VDD VDD VSS VSS gf180mcu_as_sc_mcu7t3v3__fillcap_16
XTAP_TAPCELL_ROW_60_3_2900 VDD VSS gf180mcu_as_sc_mcu7t3v3__tap_2
XFILLER_192_171 VDD VDD VSS VSS gf180mcu_as_sc_mcu7t3v3__fillcap_4
XFILLER_197_1154 VDD VDD VSS VSS gf180mcu_as_sc_mcu7t3v3__fillcap_16
XFILLER_4_524 VDD VDD VSS VSS gf180mcu_as_sc_mcu7t3v3__fill_1
XFILLER_180_333 VDD VDD VSS VSS gf180mcu_as_sc_mcu7t3v3__fillcap_16
XFILLER_192_193 VDD VDD VSS VSS gf180mcu_as_sc_mcu7t3v3__fillcap_4
XFILLER_137_96 VDD VDD VSS VSS gf180mcu_as_sc_mcu7t3v3__fillcap_4
XFILLER_140_219 VDD VDD VSS VSS gf180mcu_as_sc_mcu7t3v3__fill_2
XFILLER_4_579 VDD VDD VSS VSS gf180mcu_as_sc_mcu7t3v3__fillcap_4
XFILLER_136_1447 VDD VDD VSS VSS gf180mcu_as_sc_mcu7t3v3__fillcap_4
XFILLER_175_1496 VDD VDD VSS VSS gf180mcu_as_sc_mcu7t3v3__fill_1
XFILLER_49_1488 VDD VDD VSS VSS gf180mcu_as_sc_mcu7t3v3__fillcap_16
XFILLER_97_67 VDD VDD VSS VSS gf180mcu_as_sc_mcu7t3v3__fill_2
XTAP_TAPCELL_ROW_40_3_2842 VDD VSS gf180mcu_as_sc_mcu7t3v3__tap_2
XTAP_TAPCELL_ROW_8_896 VDD VSS gf180mcu_as_sc_mcu7t3v3__tap_2
XFILLER_153_84 VDD VDD VSS VSS gf180mcu_as_sc_mcu7t3v3__fill_1
XFILLER_208_559 VDD VDD VSS VSS gf180mcu_as_sc_mcu7t3v3__fillcap_16
XFILLER_21_1352 VDD VDD VSS VSS gf180mcu_as_sc_mcu7t3v3__fill_2
X_4834__1098 VDD VDD VSS VSS _4834_/D gf180mcu_as_sc_mcu7t3v3__tiel_4
XFILLER_189_912 VDD VDD VSS VSS gf180mcu_as_sc_mcu7t3v3__fillcap_16
XFILLER_210_1081 VDD VDD VSS VSS gf180mcu_as_sc_mcu7t3v3__fillcap_4
XPHY_EDGE_ROW_77_3_Right_114 VDD VSS gf180mcu_as_sc_mcu7t3v3__tap_2
XFILLER_15_152 VDD VDD VSS VSS gf180mcu_as_sc_mcu7t3v3__fill_1
XFILLER_16_653 VDD VDD VSS VSS gf180mcu_as_sc_mcu7t3v3__fill_1
XFILLER_182_1423 VDD VDD VSS VSS gf180mcu_as_sc_mcu7t3v3__fill_1
XPHY_EDGE_ROW_86_3_Left_471 VDD VSS gf180mcu_as_sc_mcu7t3v3__tap_2
XFILLER_15_196 VDD VDD VSS VSS gf180mcu_as_sc_mcu7t3v3__fillcap_4
XFILLER_188_433 VDD VDD VSS VSS gf180mcu_as_sc_mcu7t3v3__fillcap_16
XFILLER_30_155 VDD VDD VSS VSS gf180mcu_as_sc_mcu7t3v3__fillcap_16
XFILLER_175_138 VDD VDD VSS VSS gf180mcu_as_sc_mcu7t3v3__fill_2
XFILLER_30_177 VDD VDD VSS VSS gf180mcu_as_sc_mcu7t3v3__fillcap_8
X_2790_ VDD VDD VSS VSS _4331_/A _2802_/A _2790_/C _5270_/Q _4732_/B gf180mcu_as_sc_mcu7t3v3__ao22_2
XFILLER_15_1189 VDD VDD VSS VSS gf180mcu_as_sc_mcu7t3v3__fill_1
XFILLER_116_205 VDD VDD VSS VSS gf180mcu_as_sc_mcu7t3v3__fillcap_16
XFILLER_176_1227 VDD VDD VSS VSS gf180mcu_as_sc_mcu7t3v3__fillcap_16
XFILLER_184_683 VDD VDD VSS VSS gf180mcu_as_sc_mcu7t3v3__fillcap_16
XFILLER_7_384 VDD VDD VSS VSS gf180mcu_as_sc_mcu7t3v3__fill_1
X_4460_ VDD VDD VSS VSS _5173_/Q _4592_/B _4460_/C _4460_/D _5173_/D gf180mcu_as_sc_mcu7t3v3__ao211_2
X_4391_ VDD VDD VSS VSS _4394_/C _4979_/Q _4542_/A gf180mcu_as_sc_mcu7t3v3__nand2b_2
X_3411_ VDD VDD VSS VSS _3442_/B _4063_/A _3412_/D gf180mcu_as_sc_mcu7t3v3__or2_2
XFILLER_67_1555 VDD VDD VSS VSS gf180mcu_as_sc_mcu7t3v3__fill_1
XFILLER_67_1566 VDD VDD VSS VSS gf180mcu_as_sc_mcu7t3v3__fill_2
X_3342_ VDD VDD VSS VSS _3342_/B _3342_/A _3343_/B gf180mcu_as_sc_mcu7t3v3__or2_2
Xfanout809 VDD VDD VSS VSS _5094_/Q fanout809/Y gf180mcu_as_sc_mcu7t3v3__buff_12
XFILLER_6_1313 VDD VDD VSS VSS gf180mcu_as_sc_mcu7t3v3__fill_2
X_3273_ VDD VDD VSS VSS _3933_/A _3401_/B _3403_/S _3933_/D _3274_/D gf180mcu_as_sc_mcu7t3v3__ao22_2
X_5012_ VDD VDD VSS VSS clkload2/A _5012_/D _5012_/Q gf180mcu_as_sc_mcu7t3v3__dfxtp_2
XTAP_TAPCELL_ROW_33_1464 VDD VSS gf180mcu_as_sc_mcu7t3v3__tap_2
XTAP_TAPCELL_ROW_33_1453 VDD VSS gf180mcu_as_sc_mcu7t3v3__tap_2
XFILLER_22_1127 VDD VDD VSS VSS gf180mcu_as_sc_mcu7t3v3__fillcap_4
XFILLER_6_1379 VDD VDD VSS VSS gf180mcu_as_sc_mcu7t3v3__fill_2
XFILLER_26_428 VDD VDD VSS VSS gf180mcu_as_sc_mcu7t3v3__fill_1
XPHY_EDGE_ROW_63_1_Right_584 VDD VSS gf180mcu_as_sc_mcu7t3v3__tap_2
XTAP_TAPCELL_ROW_65_3_2915 VDD VSS gf180mcu_as_sc_mcu7t3v3__tap_2
XFILLER_179_422 VDD VDD VSS VSS gf180mcu_as_sc_mcu7t3v3__fillcap_8
XFILLER_22_601 VDD VDD VSS VSS gf180mcu_as_sc_mcu7t3v3__fill_2
XFILLER_74_1515 VDD VDD VSS VSS gf180mcu_as_sc_mcu7t3v3__fillcap_4
XFILLER_10_807 VDD VDD VSS VSS gf180mcu_as_sc_mcu7t3v3__fillcap_16
XFILLER_158_18 VDD VDD VSS VSS gf180mcu_as_sc_mcu7t3v3__fillcap_16
XFILLER_194_414 VDD VDD VSS VSS gf180mcu_as_sc_mcu7t3v3__fillcap_16
XFILLER_210_735 VDD VDD VSS VSS gf180mcu_as_sc_mcu7t3v3__fillcap_4
XFILLER_21_122 VDD VDD VSS VSS gf180mcu_as_sc_mcu7t3v3__fillcap_4
XFILLER_194_447 VDD VDD VSS VSS gf180mcu_as_sc_mcu7t3v3__fillcap_8
XFILLER_21_166 VDD VDD VSS VSS gf180mcu_as_sc_mcu7t3v3__fillcap_4
X_2988_ VDD VDD VSS VSS _2989_/C _2988_/C _3042_/C _3965_/A gf180mcu_as_sc_mcu7t3v3__aoi21_2
X_4727_ VDD VDD VSS VSS _5264_/D _5109_/Q _4731_/B _4727_/C gf180mcu_as_sc_mcu7t3v3__ao21_2
XTAP_TAPCELL_ROW_45_3_2857 VDD VSS gf180mcu_as_sc_mcu7t3v3__tap_2
XFILLER_159_1414 VDD VDD VSS VSS gf180mcu_as_sc_mcu7t3v3__fill_2
XFILLER_198_1485 VDD VDD VSS VSS gf180mcu_as_sc_mcu7t3v3__fillcap_16
X_4658_ VDD VDD VSS VSS _4658_/B _4659_/B _4660_/B gf180mcu_as_sc_mcu7t3v3__and2_2
XFILLER_159_1458 VDD VDD VSS VSS gf180mcu_as_sc_mcu7t3v3__fill_2
Xinput90 VDD VDD VSS VSS ne_in[20] _4093_/A gf180mcu_as_sc_mcu7t3v3__buff_12
X_3609_ VDD VDD VSS VSS _3983_/A _3649_/B _3648_/C _3982_/A _3610_/C gf180mcu_as_sc_mcu7t3v3__ao22_2
XFILLER_88_100 VDD VDD VSS VSS gf180mcu_as_sc_mcu7t3v3__fillcap_4
X_4589_ VDD VDD VSS VSS _4592_/C _4589_/B _4589_/A gf180mcu_as_sc_mcu7t3v3__nor2_2
XFILLER_88_133 VDD VDD VSS VSS gf180mcu_as_sc_mcu7t3v3__fill_1
XFILLER_107_88 VDD VDD VSS VSS gf180mcu_as_sc_mcu7t3v3__fill_2
XFILLER_27_1049 VDD VDD VSS VSS gf180mcu_as_sc_mcu7t3v3__fill_1
XFILLER_67_48 VDD VDD VSS VSS gf180mcu_as_sc_mcu7t3v3__fillcap_16
XFILLER_44_1352 VDD VDD VSS VSS gf180mcu_as_sc_mcu7t3v3__fill_2
XFILLER_44_1374 VDD VDD VSS VSS gf180mcu_as_sc_mcu7t3v3__fillcap_4
XFILLER_88_177 VDD VDD VSS VSS gf180mcu_as_sc_mcu7t3v3__fillcap_16
XTAP_TAPCELL_ROW_5_844 VDD VSS gf180mcu_as_sc_mcu7t3v3__tap_2
XTAP_TAPCELL_ROW_5_833 VDD VSS gf180mcu_as_sc_mcu7t3v3__tap_2
XFILLER_29_233 VDD VDD VSS VSS gf180mcu_as_sc_mcu7t3v3__fillcap_16
XFILLER_79_1415 VDD VDD VSS VSS gf180mcu_as_sc_mcu7t3v3__fill_1
XTAP_TAPCELL_ROW_209_2780 VDD VSS gf180mcu_as_sc_mcu7t3v3__tap_2
XFILLER_29_277 VDD VDD VSS VSS gf180mcu_as_sc_mcu7t3v3__fill_2
XTAP_TAPCELL_ROW_205_2688 VDD VSS gf180mcu_as_sc_mcu7t3v3__tap_2
XTAP_TAPCELL_ROW_205_2677 VDD VSS gf180mcu_as_sc_mcu7t3v3__tap_2
XFILLER_198_731 VDD VDD VSS VSS gf180mcu_as_sc_mcu7t3v3__fillcap_4
XFILLER_198_753 VDD VDD VSS VSS gf180mcu_as_sc_mcu7t3v3__fillcap_8
XFILLER_201_702 VDD VDD VSS VSS gf180mcu_as_sc_mcu7t3v3__fillcap_16
XPHY_EDGE_ROW_11_Right_11 VDD VSS gf180mcu_as_sc_mcu7t3v3__tap_2
XFILLER_198_786 VDD VDD VSS VSS gf180mcu_as_sc_mcu7t3v3__fillcap_16
XTAP_TAPCELL_ROW_93_3_3000 VDD VSS gf180mcu_as_sc_mcu7t3v3__tap_2
XFILLER_12_155 VDD VDD VSS VSS gf180mcu_as_sc_mcu7t3v3__fillcap_16
XFILLER_12_177 VDD VDD VSS VSS gf180mcu_as_sc_mcu7t3v3__fillcap_8
XFILLER_16_1465 VDD VDD VSS VSS gf180mcu_as_sc_mcu7t3v3__fillcap_16
XFILLER_201_1014 VDD VDD VSS VSS gf180mcu_as_sc_mcu7t3v3__fillcap_16
XFILLER_12_1329 VDD VDD VSS VSS gf180mcu_as_sc_mcu7t3v3__fill_2
XFILLER_165_171 VDD VDD VSS VSS gf180mcu_as_sc_mcu7t3v3__fillcap_4
XFILLER_177_1514 VDD VDD VSS VSS gf180mcu_as_sc_mcu7t3v3__fill_1
XFILLER_86_1408 VDD VDD VSS VSS gf180mcu_as_sc_mcu7t3v3__fillcap_8
XFILLER_181_664 VDD VDD VSS VSS gf180mcu_as_sc_mcu7t3v3__fillcap_8
XFILLER_4_387 VDD VDD VSS VSS gf180mcu_as_sc_mcu7t3v3__fill_1
XFILLER_79_133 VDD VDD VSS VSS gf180mcu_as_sc_mcu7t3v3__fillcap_4
XPHY_EDGE_ROW_20_Right_20 VDD VSS gf180mcu_as_sc_mcu7t3v3__tap_2
XFILLER_114_1520 VDD VDD VSS VSS gf180mcu_as_sc_mcu7t3v3__fill_1
XFILLER_110_1428 VDD VDD VSS VSS gf180mcu_as_sc_mcu7t3v3__fillcap_16
XFILLER_1_1210 VDD VDD VSS VSS gf180mcu_as_sc_mcu7t3v3__fill_1
XFILLER_184_1507 VDD VDD VSS VSS gf180mcu_as_sc_mcu7t3v3__fillcap_4
XFILLER_1_1254 VDD VDD VSS VSS gf180mcu_as_sc_mcu7t3v3__fillcap_4
X_3960_ VDD VDD VSS VSS _3960_/A _4030_/C _3960_/C _3960_/D _3961_/C gf180mcu_as_sc_mcu7t3v3__ao211_2
XFILLER_188_241 VDD VDD VSS VSS gf180mcu_as_sc_mcu7t3v3__fillcap_4
XPHY_EDGE_ROW_78_3_Right_115 VDD VSS gf180mcu_as_sc_mcu7t3v3__tap_2
X_2911_ VDD VDD VSS VSS _3253_/A _3254_/A _3255_/B gf180mcu_as_sc_mcu7t3v3__or2_2
XFILLER_147_1384 VDD VDD VSS VSS gf180mcu_as_sc_mcu7t3v3__fill_2
XFILLER_182_1286 VDD VDD VSS VSS gf180mcu_as_sc_mcu7t3v3__fillcap_8
XFILLER_188_263 VDD VDD VSS VSS gf180mcu_as_sc_mcu7t3v3__fillcap_8
X_3891_ VDD VDD VSS VSS _3902_/B _5181_/Q _4931_/D gf180mcu_as_sc_mcu7t3v3__and2_2
XFILLER_182_1297 VDD VDD VSS VSS gf180mcu_as_sc_mcu7t3v3__fillcap_16
XFILLER_31_475 VDD VDD VSS VSS gf180mcu_as_sc_mcu7t3v3__fillcap_8
X_2842_ VDD VDD VSS VSS _2842_/A _2842_/B _2842_/C _2842_/D _4290_/B gf180mcu_as_sc_mcu7t3v3__ao22_2
XFILLER_34_1565 VDD VDD VSS VSS gf180mcu_as_sc_mcu7t3v3__fillcap_4
X_2773_ VDD VDD VSS VSS _4259_/B _2773_/B _5229_/Q gf180mcu_as_sc_mcu7t3v3__nor2_2
XFILLER_121_1568 VDD VDD VSS VSS gf180mcu_as_sc_mcu7t3v3__fill_1
XFILLER_184_480 VDD VDD VSS VSS gf180mcu_as_sc_mcu7t3v3__fillcap_8
XFILLER_8_671 VDD VDD VSS VSS gf180mcu_as_sc_mcu7t3v3__fill_2
X_4512_ VDD VDD VSS VSS _4513_/D _4512_/B _4512_/A gf180mcu_as_sc_mcu7t3v3__nor2_2
XFILLER_156_193 VDD VDD VSS VSS gf180mcu_as_sc_mcu7t3v3__fillcap_4
XTAP_TAPCELL_ROW_120_3_3081 VDD VSS gf180mcu_as_sc_mcu7t3v3__tap_2
X_4443_ VDD VDD VSS VSS _5173_/Q _4575_/B _4532_/C _5123_/Q _4444_/B gf180mcu_as_sc_mcu7t3v3__ao22_2
Xfanout606 VDD VDD VSS VSS _3902_/B _3908_/B gf180mcu_as_sc_mcu7t3v3__buff_12
X_4374_ VDD VDD VSS VSS _4379_/B _4374_/B _5162_/Q _5162_/D gf180mcu_as_sc_mcu7t3v3__mux2_2
XTAP_TAPCELL_ROW_35_1504 VDD VSS gf180mcu_as_sc_mcu7t3v3__tap_2
XFILLER_119_1464 VDD VDD VSS VSS gf180mcu_as_sc_mcu7t3v3__fill_2
XFILLER_193_1393 VDD VDD VSS VSS gf180mcu_as_sc_mcu7t3v3__fillcap_4
XFILLER_28_1347 VDD VDD VSS VSS gf180mcu_as_sc_mcu7t3v3__fill_1
Xfanout617 VDD VDD VSS VSS _4493_/B _4554_/B gf180mcu_as_sc_mcu7t3v3__buff_12
Xfanout639 VDD VDD VSS VSS _3562_/Y _3725_/B gf180mcu_as_sc_mcu7t3v3__buff_12
X_3325_ VDD VDD VSS VSS _3976_/A _3382_/B _3382_/C _3977_/A _3326_/C gf180mcu_as_sc_mcu7t3v3__ao22_2
XFILLER_154_1399 VDD VDD VSS VSS gf180mcu_as_sc_mcu7t3v3__fillcap_16
X_3256_ VDD VDD VSS VSS _3268_/A _3519_/C _3510_/C _3517_/D _3271_/A gf180mcu_as_sc_mcu7t3v3__nand4_2
XTAP_TAPCELL_ROW_86_1_1703 VDD VSS gf180mcu_as_sc_mcu7t3v3__tap_2
XFILLER_41_1558 VDD VDD VSS VSS gf180mcu_as_sc_mcu7t3v3__fillcap_8
X_3187_ VDD VDD VSS VSS _3223_/B _3236_/B _3201_/C _3235_/B gf180mcu_as_sc_mcu7t3v3__nand3_2
XTAP_TAPCELL_ROW_98_3_3015 VDD VSS gf180mcu_as_sc_mcu7t3v3__tap_2
XFILLER_26_236 VDD VDD VSS VSS gf180mcu_as_sc_mcu7t3v3__fillcap_8
XPHY_EDGE_ROW_64_1_Right_585 VDD VSS gf180mcu_as_sc_mcu7t3v3__tap_2
XFILLER_183_1039 VDD VDD VSS VSS gf180mcu_as_sc_mcu7t3v3__fillcap_8
XFILLER_187_1186 VDD VDD VSS VSS gf180mcu_as_sc_mcu7t3v3__fillcap_4
XFILLER_26_247 VDD VDD VSS VSS gf180mcu_as_sc_mcu7t3v3__fillcap_16
XTAP_TAPCELL_ROW_179_2120 VDD VSS gf180mcu_as_sc_mcu7t3v3__tap_2
XFILLER_126_1402 VDD VDD VSS VSS gf180mcu_as_sc_mcu7t3v3__fill_1
XFILLER_165_1484 VDD VDD VSS VSS gf180mcu_as_sc_mcu7t3v3__fill_2
XFILLER_35_1329 VDD VDD VSS VSS gf180mcu_as_sc_mcu7t3v3__fill_1
XTAP_TAPCELL_ROW_200_2574 VDD VSS gf180mcu_as_sc_mcu7t3v3__tap_2
XTAP_TAPCELL_ROW_200_2563 VDD VSS gf180mcu_as_sc_mcu7t3v3__tap_2
XTAP_TAPCELL_ROW_175_2028 VDD VSS gf180mcu_as_sc_mcu7t3v3__tap_2
XTAP_TAPCELL_ROW_175_2017 VDD VSS gf180mcu_as_sc_mcu7t3v3__tap_2
XFILLER_161_1348 VDD VDD VSS VSS gf180mcu_as_sc_mcu7t3v3__fillcap_8
XFILLER_195_734 VDD VDD VSS VSS gf180mcu_as_sc_mcu7t3v3__fillcap_16
XFILLER_194_244 VDD VDD VSS VSS gf180mcu_as_sc_mcu7t3v3__fill_1
XFILLER_210_565 VDD VDD VSS VSS gf180mcu_as_sc_mcu7t3v3__fillcap_4
XTAP_TAPCELL_ROW_192_2386 VDD VSS gf180mcu_as_sc_mcu7t3v3__tap_2
XFILLER_185_38 VDD VDD VSS VSS gf180mcu_as_sc_mcu7t3v3__fillcap_16
XFILLER_202_1345 VDD VDD VSS VSS gf180mcu_as_sc_mcu7t3v3__fillcap_16
XFILLER_202_1367 VDD VDD VSS VSS gf180mcu_as_sc_mcu7t3v3__fillcap_16
XTAP_TAPCELL_ROW_192_2397 VDD VSS gf180mcu_as_sc_mcu7t3v3__tap_2
XFILLER_118_65 VDD VDD VSS VSS gf180mcu_as_sc_mcu7t3v3__fillcap_16
XFILLER_162_163 VDD VDD VSS VSS gf180mcu_as_sc_mcu7t3v3__fillcap_8
XFILLER_194_1135 VDD VDD VSS VSS gf180mcu_as_sc_mcu7t3v3__fillcap_16
XFILLER_194_1157 VDD VDD VSS VSS gf180mcu_as_sc_mcu7t3v3__fillcap_16
XFILLER_2_814 VDD VDD VSS VSS gf180mcu_as_sc_mcu7t3v3__fill_2
XFILLER_162_185 VDD VDD VSS VSS gf180mcu_as_sc_mcu7t3v3__fill_2
XFILLER_85_1474 VDD VDD VSS VSS gf180mcu_as_sc_mcu7t3v3__fillcap_8
XFILLER_1_368 VDD VDD VSS VSS gf180mcu_as_sc_mcu7t3v3__fillcap_4
XFILLER_46_1447 VDD VDD VSS VSS gf180mcu_as_sc_mcu7t3v3__fillcap_4
XFILLER_46_1469 VDD VDD VSS VSS gf180mcu_as_sc_mcu7t3v3__fillcap_8
XFILLER_76_103 VDD VDD VSS VSS gf180mcu_as_sc_mcu7t3v3__fill_2
XTAP_TAPCELL_ROW_207_2717 VDD VSS gf180mcu_as_sc_mcu7t3v3__tap_2
Xmesh_tile_1005 VDD VDD VSS VSS nw_out[12] gf180mcu_as_sc_mcu7t3v3__tiel_4
Xmesh_tile_1016 VDD VDD VSS VSS nw_out[23] gf180mcu_as_sc_mcu7t3v3__tiel_4
XTAP_TAPCELL_ROW_207_2728 VDD VSS gf180mcu_as_sc_mcu7t3v3__tap_2
XFILLER_18_704 VDD VDD VSS VSS gf180mcu_as_sc_mcu7t3v3__fillcap_16
XPHY_EDGE_ROW_141_1_Left_351 VDD VSS gf180mcu_as_sc_mcu7t3v3__tap_2
Xmesh_tile_1049 VDD VDD VSS VSS sw_out[22] gf180mcu_as_sc_mcu7t3v3__tiel_4
Xmesh_tile_1038 VDD VDD VSS VSS sw_out[11] gf180mcu_as_sc_mcu7t3v3__tiel_4
Xmesh_tile_1027 VDD VDD VSS VSS sw_out[0] gf180mcu_as_sc_mcu7t3v3__tiel_4
XFILLER_18_737 VDD VDD VSS VSS gf180mcu_as_sc_mcu7t3v3__fillcap_16
XFILLER_91_139 VDD VDD VSS VSS gf180mcu_as_sc_mcu7t3v3__fill_1
XFILLER_32_228 VDD VDD VSS VSS gf180mcu_as_sc_mcu7t3v3__fillcap_4
XFILLER_207_1256 VDD VDD VSS VSS gf180mcu_as_sc_mcu7t3v3__fillcap_4
XFILLER_144_1568 VDD VDD VSS VSS gf180mcu_as_sc_mcu7t3v3__fill_1
XFILLER_207_1278 VDD VDD VSS VSS gf180mcu_as_sc_mcu7t3v3__fillcap_16
XFILLER_43_83 VDD VDD VSS VSS gf180mcu_as_sc_mcu7t3v3__fillcap_8
XTAP_TAPCELL_ROW_113_1_1784 VDD VSS gf180mcu_as_sc_mcu7t3v3__tap_2
XTAP_TAPCELL_ROW_125_3_3096 VDD VSS gf180mcu_as_sc_mcu7t3v3__tap_2
XFILLER_159_72 VDD VDD VSS VSS gf180mcu_as_sc_mcu7t3v3__fillcap_4
XFILLER_199_1046 VDD VDD VSS VSS gf180mcu_as_sc_mcu7t3v3__fillcap_4
XFILLER_12_1126 VDD VDD VSS VSS gf180mcu_as_sc_mcu7t3v3__fill_2
XFILLER_138_171 VDD VDD VSS VSS gf180mcu_as_sc_mcu7t3v3__fillcap_4
XFILLER_177_1300 VDD VDD VSS VSS gf180mcu_as_sc_mcu7t3v3__fill_2
XFILLER_199_1068 VDD VDD VSS VSS gf180mcu_as_sc_mcu7t3v3__fillcap_16
XPHY_EDGE_ROW_117_3_Left_502 VDD VSS gf180mcu_as_sc_mcu7t3v3__tap_2
XFILLER_182_995 VDD VDD VSS VSS gf180mcu_as_sc_mcu7t3v3__fillcap_16
XPHY_EDGE_ROW_39_3_Right_76 VDD VSS gf180mcu_as_sc_mcu7t3v3__tap_2
XFILLER_153_174 VDD VDD VSS VSS gf180mcu_as_sc_mcu7t3v3__fillcap_16
XFILLER_4_66 VDD VDD VSS VSS gf180mcu_as_sc_mcu7t3v3__fillcap_8
XTAP_TAPCELL_ROW_90_3_2991 VDD VSS gf180mcu_as_sc_mcu7t3v3__tap_2
X_3110_ VDD VDD VSS VSS _3121_/B _4934_/Q _3113_/C gf180mcu_as_sc_mcu7t3v3__or2_2
XFILLER_209_610 VDD VDD VSS VSS gf180mcu_as_sc_mcu7t3v3__fillcap_16
XFILLER_23_1200 VDD VDD VSS VSS gf180mcu_as_sc_mcu7t3v3__fillcap_8
XPHY_EDGE_ROW_73_1_Left_283 VDD VSS gf180mcu_as_sc_mcu7t3v3__tap_2
X_4090_ VDD VDD VSS VSS _4091_/C _4090_/B _4090_/A gf180mcu_as_sc_mcu7t3v3__nor2_2
XTAP_TAPCELL_ROW_30_1401 VDD VSS gf180mcu_as_sc_mcu7t3v3__tap_2
XFILLER_114_1383 VDD VDD VSS VSS gf180mcu_as_sc_mcu7t3v3__fillcap_16
XFILLER_209_632 VDD VDD VSS VSS gf180mcu_as_sc_mcu7t3v3__fillcap_16
XFILLER_23_1255 VDD VDD VSS VSS gf180mcu_as_sc_mcu7t3v3__fillcap_4
XFILLER_36_512 VDD VDD VSS VSS gf180mcu_as_sc_mcu7t3v3__fill_2
XFILLER_3_1327 VDD VDD VSS VSS gf180mcu_as_sc_mcu7t3v3__fill_2
Xinput280 VDD VDD VSS VSS sw_in[7] _3994_/A gf180mcu_as_sc_mcu7t3v3__buff_12
X_3041_ VDD VDD VSS VSS _3041_/Y _3041_/C _3132_/B _3647_/A gf180mcu_as_sc_mcu7t3v3__aoi21_2
Xinput291 VDD VDD VSS VSS west_in[17] _4069_/D gf180mcu_as_sc_mcu7t3v3__buff_12
XFILLER_1_1084 VDD VDD VSS VSS gf180mcu_as_sc_mcu7t3v3__fillcap_16
XFILLER_90_172 VDD VDD VSS VSS gf180mcu_as_sc_mcu7t3v3__fill_2
X_4992_ VDD VDD VSS VSS _5085_/CLK _4992_/D _4992_/Q gf180mcu_as_sc_mcu7t3v3__dfxtp_2
XFILLER_17_1015 VDD VDD VSS VSS gf180mcu_as_sc_mcu7t3v3__fillcap_16
XPHY_EDGE_ROW_79_3_Right_116 VDD VSS gf180mcu_as_sc_mcu7t3v3__tap_2
X_3943_ VDD VDD VSS VSS _3944_/D _3943_/C _4033_/B _3943_/A gf180mcu_as_sc_mcu7t3v3__aoi21_2
XTAP_TAPCELL_ROW_28_1352 VDD VSS gf180mcu_as_sc_mcu7t3v3__tap_2
XTAP_TAPCELL_ROW_28_1341 VDD VSS gf180mcu_as_sc_mcu7t3v3__tap_2
XFILLER_177_734 VDD VDD VSS VSS gf180mcu_as_sc_mcu7t3v3__fill_2
XFILLER_189_594 VDD VDD VSS VSS gf180mcu_as_sc_mcu7t3v3__fillcap_16
XFILLER_204_381 VDD VDD VSS VSS gf180mcu_as_sc_mcu7t3v3__fillcap_4
XFILLER_20_902 VDD VDD VSS VSS gf180mcu_as_sc_mcu7t3v3__fillcap_4
XFILLER_32_773 VDD VDD VSS VSS gf180mcu_as_sc_mcu7t3v3__fillcap_8
X_3874_ VDD VDD VSS VSS _3874_/B _3874_/A _4946_/D gf180mcu_as_sc_mcu7t3v3__and2_2
XFILLER_192_715 VDD VDD VSS VSS gf180mcu_as_sc_mcu7t3v3__fillcap_16
XFILLER_31_272 VDD VDD VSS VSS gf180mcu_as_sc_mcu7t3v3__fillcap_8
XPHY_EDGE_ROW_49_3_Left_434 VDD VSS gf180mcu_as_sc_mcu7t3v3__tap_2
X_2825_ VDD VDD VSS VSS _2826_/S _2825_/B _5280_/Q _5279_/D gf180mcu_as_sc_mcu7t3v3__mux2_2
XTAP_TAPCELL_ROW_24_1249 VDD VSS gf180mcu_as_sc_mcu7t3v3__tap_2
XTAP_TAPCELL_ROW_171_3_3233 VDD VSS gf180mcu_as_sc_mcu7t3v3__tap_2
XFILLER_178_1119 VDD VDD VSS VSS gf180mcu_as_sc_mcu7t3v3__fillcap_16
XFILLER_192_737 VDD VDD VSS VSS gf180mcu_as_sc_mcu7t3v3__fillcap_16
XFILLER_20_979 VDD VDD VSS VSS gf180mcu_as_sc_mcu7t3v3__fillcap_8
XFILLER_30_1215 VDD VDD VSS VSS gf180mcu_as_sc_mcu7t3v3__fillcap_8
XFILLER_129_182 VDD VDD VSS VSS gf180mcu_as_sc_mcu7t3v3__fill_2
XFILLER_9_991 VDD VDD VSS VSS gf180mcu_as_sc_mcu7t3v3__fill_1
XPHY_EDGE_ROW_101_3_Left_486 VDD VSS gf180mcu_as_sc_mcu7t3v3__tap_2
X_2756_ VDD VDD VSS VSS _4627_/A _4633_/A _2766_/C gf180mcu_as_sc_mcu7t3v3__and2_2
XFILLER_195_1466 VDD VDD VSS VSS gf180mcu_as_sc_mcu7t3v3__fillcap_4
X_2687_ VDD VDD VSS VSS _2731_/S _5174_/Q _5166_/Q _2690_/B gf180mcu_as_sc_mcu7t3v3__mux2_2
XFILLER_195_1488 VDD VDD VSS VSS gf180mcu_as_sc_mcu7t3v3__fillcap_16
XTAP_TAPCELL_ROW_151_3_3175 VDD VSS gf180mcu_as_sc_mcu7t3v3__tap_2
X_4426_ VDD VDD VSS VSS _4426_/B _4497_/A _4433_/C gf180mcu_as_sc_mcu7t3v3__and2_2
XFILLER_8_1205 VDD VDD VSS VSS gf180mcu_as_sc_mcu7t3v3__fillcap_4
XFILLER_171_18 VDD VDD VSS VSS gf180mcu_as_sc_mcu7t3v3__fillcap_16
XFILLER_8_1227 VDD VDD VSS VSS gf180mcu_as_sc_mcu7t3v3__fillcap_16
X_4357_ VDD VDD VSS VSS _5480_/A _4540_/C _4357_/C _4357_/D _4358_/B gf180mcu_as_sc_mcu7t3v3__ao211_2
X_4288_ VDD VDD VSS VSS _4289_/S _5484_/A _5122_/Q _5122_/D gf180mcu_as_sc_mcu7t3v3__mux2_2
X_3308_ VDD VDD VSS VSS _3381_/S _3956_/A _3308_/A _3310_/B gf180mcu_as_sc_mcu7t3v3__mux2_2
XFILLER_104_34 VDD VDD VSS VSS gf180mcu_as_sc_mcu7t3v3__fill_1
XFILLER_104_45 VDD VDD VSS VSS gf180mcu_as_sc_mcu7t3v3__fill_2
X_3239_ VDD VDD VSS VSS _3240_/D _3521_/A _3239_/A gf180mcu_as_sc_mcu7t3v3__nor2b_2
XFILLER_73_128 VDD VDD VSS VSS gf180mcu_as_sc_mcu7t3v3__fill_1
XTAP_TAPCELL_ROW_118_1_1799 VDD VSS gf180mcu_as_sc_mcu7t3v3__tap_2
XFILLER_199_325 VDD VDD VSS VSS gf180mcu_as_sc_mcu7t3v3__fill_2
XFILLER_27_578 VDD VDD VSS VSS gf180mcu_as_sc_mcu7t3v3__fillcap_16
XFILLER_41_1399 VDD VDD VSS VSS gf180mcu_as_sc_mcu7t3v3__fillcap_4
XFILLER_76_1418 VDD VDD VSS VSS gf180mcu_as_sc_mcu7t3v3__fill_1
XTAP_TAPCELL_ROW_202_2625 VDD VSS gf180mcu_as_sc_mcu7t3v3__tap_2
XTAP_TAPCELL_ROW_202_2614 VDD VSS gf180mcu_as_sc_mcu7t3v3__tap_2
XFILLER_167_1568 VDD VDD VSS VSS gf180mcu_as_sc_mcu7t3v3__fill_1
XPHY_EDGE_ROW_65_1_Right_586 VDD VSS gf180mcu_as_sc_mcu7t3v3__tap_2
XFILLER_14_239 VDD VDD VSS VSS gf180mcu_as_sc_mcu7t3v3__fillcap_4
XTAP_TAPCELL_ROW_194_2437 VDD VSS gf180mcu_as_sc_mcu7t3v3__tap_2
XFILLER_80_37 VDD VDD VSS VSS gf180mcu_as_sc_mcu7t3v3__fillcap_16
XTAP_TAPCELL_ROW_194_2448 VDD VSS gf180mcu_as_sc_mcu7t3v3__tap_2
XFILLER_196_37 VDD VDD VSS VSS gf180mcu_as_sc_mcu7t3v3__fillcap_16
XFILLER_7_906 VDD VDD VSS VSS gf180mcu_as_sc_mcu7t3v3__fillcap_4
XFILLER_182_225 VDD VDD VSS VSS gf180mcu_as_sc_mcu7t3v3__fillcap_8
XFILLER_7_928 VDD VDD VSS VSS gf180mcu_as_sc_mcu7t3v3__fillcap_16
Xwire837 VDD VDD VSS VSS wire837/A _3533_/A gf180mcu_as_sc_mcu7t3v3__clkbuff_12
Xwire848 VDD VDD VSS VSS wire848/A _4113_/A gf180mcu_as_sc_mcu7t3v3__clkbuff_12
XFILLER_100_1416 VDD VDD VSS VSS gf180mcu_as_sc_mcu7t3v3__fillcap_4
XFILLER_10_489 VDD VDD VSS VSS gf180mcu_as_sc_mcu7t3v3__fillcap_8
XFILLER_182_247 VDD VDD VSS VSS gf180mcu_as_sc_mcu7t3v3__fillcap_8
XFILLER_135_163 VDD VDD VSS VSS gf180mcu_as_sc_mcu7t3v3__fillcap_16
XFILLER_87_1558 VDD VDD VSS VSS gf180mcu_as_sc_mcu7t3v3__fillcap_8
XFILLER_11_1170 VDD VDD VSS VSS gf180mcu_as_sc_mcu7t3v3__fillcap_16
XFILLER_11_1192 VDD VDD VSS VSS gf180mcu_as_sc_mcu7t3v3__fillcap_16
XFILLER_190_280 VDD VDD VSS VSS gf180mcu_as_sc_mcu7t3v3__fillcap_16
XFILLER_8_2 VDD VDD VSS VSS gf180mcu_as_sc_mcu7t3v3__fillcap_16
XFILLER_96_209 VDD VDD VSS VSS gf180mcu_as_sc_mcu7t3v3__fillcap_8
XFILLER_150_177 VDD VDD VSS VSS gf180mcu_as_sc_mcu7t3v3__fillcap_4
XPHY_EDGE_ROW_95_3_Left_480 VDD VSS gf180mcu_as_sc_mcu7t3v3__tap_2
XFILLER_137_1394 VDD VDD VSS VSS gf180mcu_as_sc_mcu7t3v3__fillcap_16
XFILLER_24_1531 VDD VDD VSS VSS gf180mcu_as_sc_mcu7t3v3__fill_1
XFILLER_111_1512 VDD VDD VSS VSS gf180mcu_as_sc_mcu7t3v3__fillcap_4
XFILLER_49_158 VDD VDD VSS VSS gf180mcu_as_sc_mcu7t3v3__fillcap_16
XFILLER_206_613 VDD VDD VSS VSS gf180mcu_as_sc_mcu7t3v3__fillcap_16
XTAP_TAPCELL_ROW_164_1_1936 VDD VSS gf180mcu_as_sc_mcu7t3v3__tap_2
XFILLER_33_504 VDD VDD VSS VSS gf180mcu_as_sc_mcu7t3v3__fill_2
XTAP_TAPCELL_ROW_66_3_2920 VDD VSS gf180mcu_as_sc_mcu7t3v3__tap_2
XFILLER_33_537 VDD VDD VSS VSS gf180mcu_as_sc_mcu7t3v3__fillcap_16
XFILLER_14_751 VDD VDD VSS VSS gf180mcu_as_sc_mcu7t3v3__fill_1
XFILLER_18_1313 VDD VDD VSS VSS gf180mcu_as_sc_mcu7t3v3__fillcap_8
XFILLER_33_559 VDD VDD VSS VSS gf180mcu_as_sc_mcu7t3v3__fill_1
XFILLER_109_1441 VDD VDD VSS VSS gf180mcu_as_sc_mcu7t3v3__fillcap_16
XFILLER_20_209 VDD VDD VSS VSS gf180mcu_as_sc_mcu7t3v3__fillcap_16
XFILLER_57_1384 VDD VDD VSS VSS gf180mcu_as_sc_mcu7t3v3__fillcap_4
XFILLER_13_294 VDD VDD VSS VSS gf180mcu_as_sc_mcu7t3v3__fill_1
XFILLER_207_1086 VDD VDD VSS VSS gf180mcu_as_sc_mcu7t3v3__fillcap_16
XTAP_TAPCELL_ROW_144_1_1878 VDD VSS gf180mcu_as_sc_mcu7t3v3__tap_2
XFILLER_186_597 VDD VDD VSS VSS gf180mcu_as_sc_mcu7t3v3__fillcap_16
XFILLER_201_384 VDD VDD VSS VSS gf180mcu_as_sc_mcu7t3v3__fillcap_4
XTAP_TAPCELL_ROW_12_985 VDD VSS gf180mcu_as_sc_mcu7t3v3__tap_2
XTAP_TAPCELL_ROW_12_996 VDD VSS gf180mcu_as_sc_mcu7t3v3__tap_2
Xclkload13 VDD VDD VSS VSS clkload13/Y _4916_/CLK gf180mcu_as_sc_mcu7t3v3__inv_6
Xclkload24 VDD VDD VSS VSS clkload24/Y _4946_/CLK gf180mcu_as_sc_mcu7t3v3__inv_6
X_3590_ VDD VDD VSS VSS _3960_/A _3649_/B _3590_/C _3590_/D _3592_/C gf180mcu_as_sc_mcu7t3v3__ao211_2
X_2610_ VDD VDD VSS VSS _2668_/B _2610_/B _2610_/A _2610_/Y gf180mcu_as_sc_mcu7t3v3__mux2_2
XFILLER_55_4 VDD VDD VSS VSS gf180mcu_as_sc_mcu7t3v3__fill_1
X_2541_ VDD VDD VSS VSS _4719_/A _2541_/B _2541_/C _5277_/Q _2541_/Y gf180mcu_as_sc_mcu7t3v3__ao22_2
XFILLER_126_174 VDD VDD VSS VSS gf180mcu_as_sc_mcu7t3v3__fill_1
XFILLER_126_185 VDD VDD VSS VSS gf180mcu_as_sc_mcu7t3v3__fill_2
XFILLER_5_482 VDD VDD VSS VSS gf180mcu_as_sc_mcu7t3v3__fill_1
X_5260_ VDD VDD VSS VSS _5260_/CLK _5260_/D _5260_/Q gf180mcu_as_sc_mcu7t3v3__dfxtp_2
X_2472_ VDD VDD VSS VSS _4362_/B _2472_/C _2472_/B _4561_/A gf180mcu_as_sc_mcu7t3v3__aoi21_2
XFILLER_87_209 VDD VDD VSS VSS gf180mcu_as_sc_mcu7t3v3__fill_1
X_4211_ VDD VDD VSS VSS _4240_/B _4222_/B _4222_/C _5047_/Q _5047_/D gf180mcu_as_sc_mcu7t3v3__ao22_2
XFILLER_141_188 VDD VDD VSS VSS gf180mcu_as_sc_mcu7t3v3__fill_2
XFILLER_155_1450 VDD VDD VSS VSS gf180mcu_as_sc_mcu7t3v3__fillcap_4
X_5191_ VDD VDD VSS VSS _5192_/CLK _5191_/D _5191_/Q gf180mcu_as_sc_mcu7t3v3__dfxtp_2
XFILLER_95_220 VDD VDD VSS VSS gf180mcu_as_sc_mcu7t3v3__fill_2
X_4142_ VDD VDD VSS VSS _5003_/Q _4142_/B _4254_/B _4142_/D _5003_/D gf180mcu_as_sc_mcu7t3v3__ao22_2
XFILLER_205_66 VDD VDD VSS VSS gf180mcu_as_sc_mcu7t3v3__fillcap_4
XFILLER_205_88 VDD VDD VSS VSS gf180mcu_as_sc_mcu7t3v3__fillcap_16
XFILLER_23_1030 VDD VDD VSS VSS gf180mcu_as_sc_mcu7t3v3__fill_2
XFILLER_99_1418 VDD VDD VSS VSS gf180mcu_as_sc_mcu7t3v3__fill_2
X_4073_ VDD VDD VSS VSS _4073_/A _4122_/B _4073_/C _4073_/D _4074_/B gf180mcu_as_sc_mcu7t3v3__ao211_2
XTAP_TAPCELL_ROW_17_1097 VDD VSS gf180mcu_as_sc_mcu7t3v3__tap_2
XFILLER_23_1052 VDD VDD VSS VSS gf180mcu_as_sc_mcu7t3v3__fillcap_8
XFILLER_36_320 VDD VDD VSS VSS gf180mcu_as_sc_mcu7t3v3__fill_2
XFILLER_55_139 VDD VDD VSS VSS gf180mcu_as_sc_mcu7t3v3__fill_1
X_3024_ VDD VDD VSS VSS _3031_/B _3130_/B _4009_/A gf180mcu_as_sc_mcu7t3v3__nand2_2
XFILLER_36_342 VDD VDD VSS VSS gf180mcu_as_sc_mcu7t3v3__fillcap_16
XFILLER_184_1189 VDD VDD VSS VSS gf180mcu_as_sc_mcu7t3v3__fillcap_16
XFILLER_196_317 VDD VDD VSS VSS gf180mcu_as_sc_mcu7t3v3__fillcap_8
XFILLER_24_559 VDD VDD VSS VSS gf180mcu_as_sc_mcu7t3v3__fillcap_16
X_4975_ VDD VDD VSS VSS _5285_/CLK _4975_/D _4975_/Q gf180mcu_as_sc_mcu7t3v3__dfxtp_2
XFILLER_11_209 VDD VDD VSS VSS gf180mcu_as_sc_mcu7t3v3__fill_1
XFILLER_127_1530 VDD VDD VSS VSS gf180mcu_as_sc_mcu7t3v3__fill_1
XFILLER_36_1446 VDD VDD VSS VSS gf180mcu_as_sc_mcu7t3v3__fillcap_16
XFILLER_75_1484 VDD VDD VSS VSS gf180mcu_as_sc_mcu7t3v3__fill_2
X_3926_ VDD VDD VSS VSS _3926_/A _4032_/B _4043_/B _3926_/D _3935_/A gf180mcu_as_sc_mcu7t3v3__ao211_2
XFILLER_162_1465 VDD VDD VSS VSS gf180mcu_as_sc_mcu7t3v3__fillcap_4
XFILLER_177_542 VDD VDD VSS VSS gf180mcu_as_sc_mcu7t3v3__fillcap_4
XFILLER_32_592 VDD VDD VSS VSS gf180mcu_as_sc_mcu7t3v3__fill_2
XFILLER_71_1348 VDD VDD VSS VSS gf180mcu_as_sc_mcu7t3v3__fillcap_4
XPHY_EDGE_ROW_199_Left_409 VDD VSS gf180mcu_as_sc_mcu7t3v3__tap_2
XFILLER_109_108 VDD VDD VSS VSS gf180mcu_as_sc_mcu7t3v3__fill_1
Xclkload7 VDD VDD VSS VSS clkload7/A clkload7/Y gf180mcu_as_sc_mcu7t3v3__clkbuff_4
X_3857_ VDD VDD VSS VSS _5145_/Q _5146_/Q _3857_/C _3858_/D gf180mcu_as_sc_mcu7t3v3__nor3_2
XFILLER_30_1012 VDD VDD VSS VSS gf180mcu_as_sc_mcu7t3v3__fill_2
X_3788_ VDD VDD VSS VSS _3788_/A _3796_/B _3796_/C _3788_/D _3789_/D gf180mcu_as_sc_mcu7t3v3__ao22_2
X_2808_ VDD VDD VSS VSS _4965_/D _5189_/Q _4643_/B _4660_/A gf180mcu_as_sc_mcu7t3v3__ao21_2
X_2739_ VDD VDD VSS VSS _4947_/Q _2739_/B _2739_/A _5480_/A gf180mcu_as_sc_mcu7t3v3__mux2_2
XFILLER_117_174 VDD VDD VSS VSS gf180mcu_as_sc_mcu7t3v3__fillcap_8
XFILLER_132_133 VDD VDD VSS VSS gf180mcu_as_sc_mcu7t3v3__fillcap_8
XFILLER_191_1116 VDD VDD VSS VSS gf180mcu_as_sc_mcu7t3v3__fillcap_4
XFILLER_191_1138 VDD VDD VSS VSS gf180mcu_as_sc_mcu7t3v3__fillcap_16
XFILLER_132_177 VDD VDD VSS VSS gf180mcu_as_sc_mcu7t3v3__fillcap_16
XFILLER_134_1523 VDD VDD VSS VSS gf180mcu_as_sc_mcu7t3v3__fillcap_8
XFILLER_8_1002 VDD VDD VSS VSS gf180mcu_as_sc_mcu7t3v3__fillcap_8
X_4409_ VDD VDD VSS VSS _4409_/B _4533_/A _4416_/C gf180mcu_as_sc_mcu7t3v3__and2_2
XTAP_TAPCELL_ROW_187_2285 VDD VSS gf180mcu_as_sc_mcu7t3v3__tap_2
XFILLER_86_220 VDD VDD VSS VSS gf180mcu_as_sc_mcu7t3v3__fill_2
XTAP_TAPCELL_ROW_187_2296 VDD VSS gf180mcu_as_sc_mcu7t3v3__tap_2
XFILLER_115_88 VDD VDD VSS VSS gf180mcu_as_sc_mcu7t3v3__fillcap_16
XFILLER_210_1400 VDD VDD VSS VSS gf180mcu_as_sc_mcu7t3v3__fill_1
XFILLER_82_1499 VDD VDD VSS VSS gf180mcu_as_sc_mcu7t3v3__fill_2
XFILLER_46_139 VDD VDD VSS VSS gf180mcu_as_sc_mcu7t3v3__fillcap_8
XFILLER_210_1455 VDD VDD VSS VSS gf180mcu_as_sc_mcu7t3v3__fill_2
XFILLER_188_807 VDD VDD VSS VSS gf180mcu_as_sc_mcu7t3v3__fillcap_16
XFILLER_27_375 VDD VDD VSS VSS gf180mcu_as_sc_mcu7t3v3__fillcap_16
XPHY_EDGE_ROW_66_1_Right_587 VDD VSS gf180mcu_as_sc_mcu7t3v3__tap_2
XFILLER_54_1513 VDD VDD VSS VSS gf180mcu_as_sc_mcu7t3v3__fill_1
XFILLER_24_85 VDD VDD VSS VSS gf180mcu_as_sc_mcu7t3v3__fillcap_16
XFILLER_54_1568 VDD VDD VSS VSS gf180mcu_as_sc_mcu7t3v3__fill_1
XFILLER_204_1259 VDD VDD VSS VSS gf180mcu_as_sc_mcu7t3v3__fillcap_16
Xclkbuf_leaf_8_clk_regs VDD VDD VSS VSS clkbuf_leaf_9_clk_regs/A _5220_/CLK gf180mcu_as_sc_mcu7t3v3__clkbuff_12
XFILLER_13_1254 VDD VDD VSS VSS gf180mcu_as_sc_mcu7t3v3__fillcap_4
XFILLER_196_1049 VDD VDD VSS VSS gf180mcu_as_sc_mcu7t3v3__fillcap_16
XFILLER_139_1445 VDD VDD VSS VSS gf180mcu_as_sc_mcu7t3v3__fillcap_16
XFILLER_61_1506 VDD VDD VSS VSS gf180mcu_as_sc_mcu7t3v3__fill_1
XFILLER_77_220 VDD VDD VSS VSS gf180mcu_as_sc_mcu7t3v3__fill_2
XFILLER_0_1319 VDD VDD VSS VSS gf180mcu_as_sc_mcu7t3v3__fillcap_4
XFILLER_111_1364 VDD VDD VSS VSS gf180mcu_as_sc_mcu7t3v3__fillcap_8
XFILLER_207_944 VDD VDD VSS VSS gf180mcu_as_sc_mcu7t3v3__fillcap_8
XFILLER_24_1383 VDD VDD VSS VSS gf180mcu_as_sc_mcu7t3v3__fillcap_16
XFILLER_111_1386 VDD VDD VSS VSS gf180mcu_as_sc_mcu7t3v3__fillcap_16
XFILLER_98_1495 VDD VDD VSS VSS gf180mcu_as_sc_mcu7t3v3__fillcap_8
XFILLER_33_345 VDD VDD VSS VSS gf180mcu_as_sc_mcu7t3v3__fillcap_4
XFILLER_34_868 VDD VDD VSS VSS gf180mcu_as_sc_mcu7t3v3__fillcap_4
XFILLER_94_1348 VDD VDD VSS VSS gf180mcu_as_sc_mcu7t3v3__fillcap_8
XPHY_EDGE_ROW_104_1_Left_314 VDD VSS gf180mcu_as_sc_mcu7t3v3__tap_2
XFILLER_178_317 VDD VDD VSS VSS gf180mcu_as_sc_mcu7t3v3__fillcap_4
XFILLER_181_1329 VDD VDD VSS VSS gf180mcu_as_sc_mcu7t3v3__fill_1
XFILLER_18_1110 VDD VDD VSS VSS gf180mcu_as_sc_mcu7t3v3__fill_1
XFILLER_34_879 VDD VDD VSS VSS gf180mcu_as_sc_mcu7t3v3__fill_1
X_4760_ VDD VDD VSS VSS _5285_/CLK _4760_/D _4760_/Q gf180mcu_as_sc_mcu7t3v3__dfxtp_2
X_4691_ VDD VDD VSS VSS _4691_/D _4691_/A _4749_/B _4691_/C _4707_/S gf180mcu_as_sc_mcu7t3v3__ao31_2
X_3711_ VDD VDD VSS VSS _4934_/Q _3740_/B _3741_/C _4088_/D _3712_/D gf180mcu_as_sc_mcu7t3v3__ao22_2
XFILLER_31_1321 VDD VDD VSS VSS gf180mcu_as_sc_mcu7t3v3__fill_2
X_3642_ VDD VDD VSS VSS _3646_/B _3642_/C _3726_/B _4016_/A gf180mcu_as_sc_mcu7t3v3__aoi21_2
X_3573_ VDD VDD VSS VSS _3936_/A _3608_/B _3573_/C _3573_/Y _3615_/D gf180mcu_as_sc_mcu7t3v3__aoi211_2
XTAP_TAPCELL_ROW_60_1_1626 VDD VSS gf180mcu_as_sc_mcu7t3v3__tap_2
X_2524_ VDD VDD VSS VSS _2771_/A _2806_/D _4637_/A gf180mcu_as_sc_mcu7t3v3__nor2_2
XFILLER_114_177 VDD VDD VSS VSS gf180mcu_as_sc_mcu7t3v3__fillcap_16
XFILLER_192_1469 VDD VDD VSS VSS gf180mcu_as_sc_mcu7t3v3__fillcap_16
X_5243_ VDD VDD VSS VSS _5260_/CLK _5243_/D _5243_/Q gf180mcu_as_sc_mcu7t3v3__dfxtp_2
X_2455_ VDD VDD VSS VSS _2456_/B _2455_/A gf180mcu_as_sc_mcu7t3v3__inv_2
XTAP_TAPCELL_ROW_19_1159 VDD VSS gf180mcu_as_sc_mcu7t3v3__tap_2
XTAP_TAPCELL_ROW_19_1148 VDD VSS gf180mcu_as_sc_mcu7t3v3__tap_2
X_5174_ VDD VDD VSS VSS clkload1/A _5174_/D _5174_/Q gf180mcu_as_sc_mcu7t3v3__dfxtp_2
XFILLER_9_1399 VDD VDD VSS VSS gf180mcu_as_sc_mcu7t3v3__fill_1
X_4125_ VDD VDD VSS VSS _5001_/Q _4150_/B _4252_/B _4158_/D _5001_/D gf180mcu_as_sc_mcu7t3v3__ao22_2
XFILLER_28_139 VDD VDD VSS VSS gf180mcu_as_sc_mcu7t3v3__fill_2
XFILLER_83_212 VDD VDD VSS VSS gf180mcu_as_sc_mcu7t3v3__fillcap_8
XTAP_TAPCELL_ROW_182_2182 VDD VSS gf180mcu_as_sc_mcu7t3v3__tap_2
XTAP_TAPCELL_ROW_182_2171 VDD VSS gf180mcu_as_sc_mcu7t3v3__tap_2
X_4056_ VDD VDD VSS VSS _4056_/A _4104_/B _4104_/C _4056_/D _4057_/D gf180mcu_as_sc_mcu7t3v3__ao22_2
X_3007_ VDD VDD VSS VSS _3071_/B _3993_/A _3013_/C gf180mcu_as_sc_mcu7t3v3__and2_2
XFILLER_38_1508 VDD VDD VSS VSS gf180mcu_as_sc_mcu7t3v3__fill_1
XFILLER_77_1568 VDD VDD VSS VSS gf180mcu_as_sc_mcu7t3v3__fill_1
XFILLER_197_626 VDD VDD VSS VSS gf180mcu_as_sc_mcu7t3v3__fillcap_4
XFILLER_197_648 VDD VDD VSS VSS gf180mcu_as_sc_mcu7t3v3__fillcap_16
XFILLER_24_367 VDD VDD VSS VSS gf180mcu_as_sc_mcu7t3v3__fill_2
XFILLER_178_840 VDD VDD VSS VSS gf180mcu_as_sc_mcu7t3v3__fillcap_16
X_4958_ VDD VDD VSS VSS _5111_/CLK _4958_/D _4958_/Q gf180mcu_as_sc_mcu7t3v3__dfxtp_2
XFILLER_137_203 VDD VDD VSS VSS gf180mcu_as_sc_mcu7t3v3__fillcap_4
XFILLER_205_1568 VDD VDD VSS VSS gf180mcu_as_sc_mcu7t3v3__fill_1
X_4889_ VDD VDD VSS VSS _4924_/CLK _4889_/D _4889_/Q gf180mcu_as_sc_mcu7t3v3__dfxtp_2
X_3909_ VDD VDD VSS VSS _4168_/A _4199_/A _4141_/D gf180mcu_as_sc_mcu7t3v3__or2_2
XFILLER_20_584 VDD VDD VSS VSS gf180mcu_as_sc_mcu7t3v3__fillcap_4
XFILLER_10_1416 VDD VDD VSS VSS gf180mcu_as_sc_mcu7t3v3__fill_1
XFILLER_101_1566 VDD VDD VSS VSS gf180mcu_as_sc_mcu7t3v3__fill_2
XFILLER_152_217 VDD VDD VSS VSS gf180mcu_as_sc_mcu7t3v3__fillcap_4
XPHY_EDGE_ROW_150_1_Left_360 VDD VSS gf180mcu_as_sc_mcu7t3v3__tap_2
XTAP_TAPCELL_ROW_189_2336 VDD VSS gf180mcu_as_sc_mcu7t3v3__tap_2
XTAP_TAPCELL_ROW_189_2325 VDD VSS gf180mcu_as_sc_mcu7t3v3__tap_2
XFILLER_193_38 VDD VDD VSS VSS gf180mcu_as_sc_mcu7t3v3__fillcap_16
XFILLER_84_1539 VDD VDD VSS VSS gf180mcu_as_sc_mcu7t3v3__fill_2
XFILLER_0_901 VDD VDD VSS VSS gf180mcu_as_sc_mcu7t3v3__fillcap_4
Xoutput370 VDD VDD VSS VSS _4772_/Q se_out[1] gf180mcu_as_sc_mcu7t3v3__buff_12
XFILLER_59_220 VDD VDD VSS VSS gf180mcu_as_sc_mcu7t3v3__fill_2
Xoutput392 VDD VDD VSS VSS _4780_/Q se_out[9] gf180mcu_as_sc_mcu7t3v3__buff_12
Xoutput381 VDD VDD VSS VSS _4773_/Q se_out[2] gf180mcu_as_sc_mcu7t3v3__buff_12
XFILLER_134_1364 VDD VDD VSS VSS gf180mcu_as_sc_mcu7t3v3__fillcap_4
XFILLER_134_1375 VDD VDD VSS VSS gf180mcu_as_sc_mcu7t3v3__fillcap_4
XFILLER_19_139 VDD VDD VSS VSS gf180mcu_as_sc_mcu7t3v3__fill_1
XFILLER_210_1230 VDD VDD VSS VSS gf180mcu_as_sc_mcu7t3v3__fill_1
XFILLER_142_97 VDD VDD VSS VSS gf180mcu_as_sc_mcu7t3v3__fillcap_8
XFILLER_210_1285 VDD VDD VSS VSS gf180mcu_as_sc_mcu7t3v3__fill_2
XFILLER_34_109 VDD VDD VSS VSS gf180mcu_as_sc_mcu7t3v3__fill_1
XPHY_EDGE_ROW_126_3_Left_511 VDD VSS gf180mcu_as_sc_mcu7t3v3__tap_2
XTAP_TAPCELL_ROW_3_794 VDD VSS gf180mcu_as_sc_mcu7t3v3__tap_2
XFILLER_204_925 VDD VDD VSS VSS gf180mcu_as_sc_mcu7t3v3__fillcap_16
XFILLER_204_947 VDD VDD VSS VSS gf180mcu_as_sc_mcu7t3v3__fillcap_16
XPHY_EDGE_ROW_48_3_Right_85 VDD VSS gf180mcu_as_sc_mcu7t3v3__tap_2
XFILLER_187_136 VDD VDD VSS VSS gf180mcu_as_sc_mcu7t3v3__fillcap_4
XFILLER_187_158 VDD VDD VSS VSS gf180mcu_as_sc_mcu7t3v3__fillcap_16
XFILLER_58_1490 VDD VDD VSS VSS gf180mcu_as_sc_mcu7t3v3__fillcap_16
XPHY_EDGE_ROW_67_1_Right_588 VDD VSS gf180mcu_as_sc_mcu7t3v3__tap_2
XFILLER_184_821 VDD VDD VSS VSS gf180mcu_as_sc_mcu7t3v3__fillcap_16
XFILLER_7_500 VDD VDD VSS VSS gf180mcu_as_sc_mcu7t3v3__fillcap_4
XFILLER_11_562 VDD VDD VSS VSS gf180mcu_as_sc_mcu7t3v3__fillcap_8
XFILLER_51_72 VDD VDD VSS VSS gf180mcu_as_sc_mcu7t3v3__fillcap_8
XFILLER_167_72 VDD VDD VSS VSS gf180mcu_as_sc_mcu7t3v3__fillcap_4
XPHY_EDGE_ROW_82_1_Left_292 VDD VSS gf180mcu_as_sc_mcu7t3v3__tap_2
Xwire475 VDD VDD VSS VSS _3041_/Y _4781_/D gf180mcu_as_sc_mcu7t3v3__clkbuff_12
Xwire464 VDD VDD VSS VSS _3676_/Y _4853_/D gf180mcu_as_sc_mcu7t3v3__clkbuff_12
XFILLER_13_1084 VDD VDD VSS VSS gf180mcu_as_sc_mcu7t3v3__fillcap_8
XFILLER_143_206 VDD VDD VSS VSS gf180mcu_as_sc_mcu7t3v3__fillcap_4
XFILLER_183_375 VDD VDD VSS VSS gf180mcu_as_sc_mcu7t3v3__fillcap_8
Xwire497 VDD VDD VSS VSS wire498/Y _4783_/D gf180mcu_as_sc_mcu7t3v3__clkbuff_12
XFILLER_178_1291 VDD VDD VSS VSS gf180mcu_as_sc_mcu7t3v3__fillcap_4
XTAP_TAPCELL_ROW_139_1_1862 VDD VSS gf180mcu_as_sc_mcu7t3v3__tap_2
XFILLER_174_1166 VDD VDD VSS VSS gf180mcu_as_sc_mcu7t3v3__fill_1
XFILLER_26_1434 VDD VDD VSS VSS gf180mcu_as_sc_mcu7t3v3__fill_1
XFILLER_111_158 VDD VDD VSS VSS gf180mcu_as_sc_mcu7t3v3__fillcap_16
XFILLER_152_1453 VDD VDD VSS VSS gf180mcu_as_sc_mcu7t3v3__fillcap_16
XTAP_TAPCELL_ROW_14_1034 VDD VSS gf180mcu_as_sc_mcu7t3v3__tap_2
XTAP_TAPCELL_ROW_14_1045 VDD VSS gf180mcu_as_sc_mcu7t3v3__tap_2
XFILLER_4_1252 VDD VDD VSS VSS gf180mcu_as_sc_mcu7t3v3__fill_2
XPHY_EDGE_ROW_58_3_Left_443 VDD VSS gf180mcu_as_sc_mcu7t3v3__tap_2
XFILLER_19_673 VDD VDD VSS VSS gf180mcu_as_sc_mcu7t3v3__fill_2
XFILLER_202_34 VDD VDD VSS VSS gf180mcu_as_sc_mcu7t3v3__fill_1
XFILLER_20_1033 VDD VDD VSS VSS gf180mcu_as_sc_mcu7t3v3__fill_2
XPHY_EDGE_ROW_110_3_Left_495 VDD VSS gf180mcu_as_sc_mcu7t3v3__tap_2
XFILLER_0_1149 VDD VDD VSS VSS gf180mcu_as_sc_mcu7t3v3__fillcap_4
XFILLER_185_1240 VDD VDD VSS VSS gf180mcu_as_sc_mcu7t3v3__fillcap_16
XFILLER_185_1262 VDD VDD VSS VSS gf180mcu_as_sc_mcu7t3v3__fillcap_16
XFILLER_20_1077 VDD VDD VSS VSS gf180mcu_as_sc_mcu7t3v3__fillcap_8
XFILLER_34_621 VDD VDD VSS VSS gf180mcu_as_sc_mcu7t3v3__fill_2
XFILLER_206_295 VDD VDD VSS VSS gf180mcu_as_sc_mcu7t3v3__fillcap_16
XFILLER_33_142 VDD VDD VSS VSS gf180mcu_as_sc_mcu7t3v3__fillcap_16
XFILLER_210_917 VDD VDD VSS VSS gf180mcu_as_sc_mcu7t3v3__fill_1
X_4812_ VDD VDD VSS VSS _5068_/CLK _4812_/D _4812_/Q gf180mcu_as_sc_mcu7t3v3__dfxtp_2
XFILLER_194_629 VDD VDD VSS VSS gf180mcu_as_sc_mcu7t3v3__fillcap_16
X_4743_ VDD VDD VSS VSS _4748_/A _5272_/Q _5273_/D gf180mcu_as_sc_mcu7t3v3__and2_2
XFILLER_175_854 VDD VDD VSS VSS gf180mcu_as_sc_mcu7t3v3__fill_2
XFILLER_186_191 VDD VDD VSS VSS gf180mcu_as_sc_mcu7t3v3__fill_2
XFILLER_174_342 VDD VDD VSS VSS gf180mcu_as_sc_mcu7t3v3__fillcap_16
X_4674_ VDD VDD VSS VSS _5244_/D _5244_/Q _4674_/B _4674_/C gf180mcu_as_sc_mcu7t3v3__ao21_2
X_3625_ VDD VDD VSS VSS _4923_/Q _3727_/B _3740_/C _3999_/A _3627_/C gf180mcu_as_sc_mcu7t3v3__ao22_2
X_3556_ VDD VDD VSS VSS _3556_/Y _3559_/C _3557_/B gf180mcu_as_sc_mcu7t3v3__nor2_2
XFILLER_157_1375 VDD VDD VSS VSS gf180mcu_as_sc_mcu7t3v3__fillcap_4
X_2507_ VDD VDD VSS VSS _5269_/Q _5270_/Q _4331_/A _4741_/B gf180mcu_as_sc_mcu7t3v3__nand3_2
XFILLER_170_1520 VDD VDD VSS VSS gf180mcu_as_sc_mcu7t3v3__fill_1
X_5226_ VDD VDD VSS VSS _5233_/CLK _5226_/D _5226_/Q gf180mcu_as_sc_mcu7t3v3__dfxtp_2
Xinput109 VDD VDD VSS VSS ne_in[7] wire904/A gf180mcu_as_sc_mcu7t3v3__buff_12
X_3487_ VDD VDD VSS VSS _4143_/D _3503_/B _3487_/C _3487_/D _3488_/C gf180mcu_as_sc_mcu7t3v3__ao211_2
XTAP_TAPCELL_ROW_184_2222 VDD VSS gf180mcu_as_sc_mcu7t3v3__tap_2
XTAP_TAPCELL_ROW_184_2211 VDD VSS gf180mcu_as_sc_mcu7t3v3__tap_2
XFILLER_131_1504 VDD VDD VSS VSS gf180mcu_as_sc_mcu7t3v3__fillcap_4
X_2438_ VDD VDD VSS VSS _2438_/Y _2438_/A gf180mcu_as_sc_mcu7t3v3__inv_2
X_5157_ VDD VDD VSS VSS clkload7/A _5157_/D _5157_/Q gf180mcu_as_sc_mcu7t3v3__dfxtp_2
X_5088_ VDD VDD VSS VSS _5095_/CLK _5088_/D _5088_/Q gf180mcu_as_sc_mcu7t3v3__dfxtp_2
X_4108_ VDD VDD VSS VSS _4999_/Q _4166_/B _4250_/B _4166_/D _4999_/D gf180mcu_as_sc_mcu7t3v3__ao22_2
XTAP_TAPCELL_ROW_165_1_1941 VDD VSS gf180mcu_as_sc_mcu7t3v3__tap_2
XTAP_TAPCELL_ROW_0_720 VDD VSS gf180mcu_as_sc_mcu7t3v3__tap_2
XTAP_TAPCELL_ROW_0_731 VDD VSS gf180mcu_as_sc_mcu7t3v3__tap_2
X_4039_ VDD VDD VSS VSS _4039_/A _4102_/B _4102_/C _4928_/Q _4041_/C gf180mcu_as_sc_mcu7t3v3__ao22_2
XFILLER_25_632 VDD VDD VSS VSS gf180mcu_as_sc_mcu7t3v3__fillcap_8
XFILLER_72_27 VDD VDD VSS VSS gf180mcu_as_sc_mcu7t3v3__fillcap_4
XFILLER_129_1488 VDD VDD VSS VSS gf180mcu_as_sc_mcu7t3v3__fillcap_16
XFILLER_13_827 VDD VDD VSS VSS gf180mcu_as_sc_mcu7t3v3__fill_2
XFILLER_197_434 VDD VDD VSS VSS gf180mcu_as_sc_mcu7t3v3__fill_2
XFILLER_198_979 VDD VDD VSS VSS gf180mcu_as_sc_mcu7t3v3__fillcap_16
XFILLER_201_906 VDD VDD VSS VSS gf180mcu_as_sc_mcu7t3v3__fillcap_4
XFILLER_201_928 VDD VDD VSS VSS gf180mcu_as_sc_mcu7t3v3__fillcap_16
XFILLER_205_1310 VDD VDD VSS VSS gf180mcu_as_sc_mcu7t3v3__fillcap_16
XFILLER_90_1510 VDD VDD VSS VSS gf180mcu_as_sc_mcu7t3v3__fillcap_8
XFILLER_185_629 VDD VDD VSS VSS gf180mcu_as_sc_mcu7t3v3__fill_1
XFILLER_205_1332 VDD VDD VSS VSS gf180mcu_as_sc_mcu7t3v3__fillcap_16
XFILLER_36_1051 VDD VDD VSS VSS gf180mcu_as_sc_mcu7t3v3__fill_2
XFILLER_197_1100 VDD VDD VSS VSS gf180mcu_as_sc_mcu7t3v3__fillcap_16
XFILLER_200_449 VDD VDD VSS VSS gf180mcu_as_sc_mcu7t3v3__fillcap_4
XTAP_TAPCELL_ROW_60_3_2901 VDD VSS gf180mcu_as_sc_mcu7t3v3__tap_2
XFILLER_197_1122 VDD VDD VSS VSS gf180mcu_as_sc_mcu7t3v3__fillcap_16
XFILLER_20_370 VDD VDD VSS VSS gf180mcu_as_sc_mcu7t3v3__fillcap_4
X_4906__1061 VDD VDD VSS VSS _4906_/D gf180mcu_as_sc_mcu7t3v3__tiel_4
XFILLER_108_2 VDD VDD VSS VSS gf180mcu_as_sc_mcu7t3v3__fill_2
XFILLER_136_1415 VDD VDD VSS VSS gf180mcu_as_sc_mcu7t3v3__fillcap_16
XPHY_EDGE_ROW_208_Right_71 VDD VSS gf180mcu_as_sc_mcu7t3v3__tap_2
XTAP_TAPCELL_ROW_39_3_2837 VDD VSS gf180mcu_as_sc_mcu7t3v3__tap_2
XTAP_TAPCELL_ROW_8_897 VDD VSS gf180mcu_as_sc_mcu7t3v3__tap_2
XFILLER_208_505 VDD VDD VSS VSS gf180mcu_as_sc_mcu7t3v3__fillcap_16
XFILLER_47_212 VDD VDD VSS VSS gf180mcu_as_sc_mcu7t3v3__fillcap_8
XFILLER_153_96 VDD VDD VSS VSS gf180mcu_as_sc_mcu7t3v3__fill_2
XFILLER_208_527 VDD VDD VSS VSS gf180mcu_as_sc_mcu7t3v3__fillcap_16
XFILLER_21_1364 VDD VDD VSS VSS gf180mcu_as_sc_mcu7t3v3__fill_1
XFILLER_29_960 VDD VDD VSS VSS gf180mcu_as_sc_mcu7t3v3__fillcap_16
XFILLER_60_1380 VDD VDD VSS VSS gf180mcu_as_sc_mcu7t3v3__fill_1
XFILLER_95_1410 VDD VDD VSS VSS gf180mcu_as_sc_mcu7t3v3__fillcap_4
XFILLER_1_1469 VDD VDD VSS VSS gf180mcu_as_sc_mcu7t3v3__fill_1
XFILLER_15_142 VDD VDD VSS VSS gf180mcu_as_sc_mcu7t3v3__fillcap_8
XFILLER_147_1566 VDD VDD VSS VSS gf180mcu_as_sc_mcu7t3v3__fill_2
XFILLER_15_164 VDD VDD VSS VSS gf180mcu_as_sc_mcu7t3v3__fillcap_16
XFILLER_31_624 VDD VDD VSS VSS gf180mcu_as_sc_mcu7t3v3__fillcap_4
XFILLER_56_1449 VDD VDD VSS VSS gf180mcu_as_sc_mcu7t3v3__fill_2
XTAP_TAPCELL_ROW_84_1_1696 VDD VSS gf180mcu_as_sc_mcu7t3v3__tap_2
XFILLER_176_629 VDD VDD VSS VSS gf180mcu_as_sc_mcu7t3v3__fill_2
XFILLER_188_489 VDD VDD VSS VSS gf180mcu_as_sc_mcu7t3v3__fillcap_16
XFILLER_203_276 VDD VDD VSS VSS gf180mcu_as_sc_mcu7t3v3__fillcap_4
XFILLER_203_298 VDD VDD VSS VSS gf180mcu_as_sc_mcu7t3v3__fillcap_16
XFILLER_30_123 VDD VDD VSS VSS gf180mcu_as_sc_mcu7t3v3__fillcap_16
XPHY_EDGE_ROW_68_1_Right_589 VDD VSS gf180mcu_as_sc_mcu7t3v3__tap_2
XFILLER_12_893 VDD VDD VSS VSS gf180mcu_as_sc_mcu7t3v3__fillcap_4
XFILLER_184_662 VDD VDD VSS VSS gf180mcu_as_sc_mcu7t3v3__fill_2
XFILLER_183_172 VDD VDD VSS VSS gf180mcu_as_sc_mcu7t3v3__fillcap_16
XFILLER_7_66 VDD VDD VSS VSS gf180mcu_as_sc_mcu7t3v3__fillcap_4
XFILLER_7_88 VDD VDD VSS VSS gf180mcu_as_sc_mcu7t3v3__fillcap_16
X_4390_ VDD VDD VSS VSS _4394_/B _5066_/Q _4542_/A gf180mcu_as_sc_mcu7t3v3__nand2_2
X_3410_ VDD VDD VSS VSS _4062_/A _3466_/B _3410_/C _3479_/C _3412_/C gf180mcu_as_sc_mcu7t3v3__ao211_2
XFILLER_28_1507 VDD VDD VSS VSS gf180mcu_as_sc_mcu7t3v3__fillcap_16
X_3341_ VDD VDD VSS VSS _3992_/A _3382_/B _3382_/C _3993_/A _3342_/B gf180mcu_as_sc_mcu7t3v3__ao22_2
X_3272_ VDD VDD VSS VSS _3272_/Y _3517_/D _3518_/C gf180mcu_as_sc_mcu7t3v3__nor2_2
XFILLER_117_1370 VDD VDD VSS VSS gf180mcu_as_sc_mcu7t3v3__fill_1
X_5011_ VDD VDD VSS VSS clkload5/A _5011_/D _5011_/Q gf180mcu_as_sc_mcu7t3v3__dfxtp_2
XTAP_TAPCELL_ROW_55_1_1610 VDD VSS gf180mcu_as_sc_mcu7t3v3__tap_2
XTAP_TAPCELL_ROW_33_1465 VDD VSS gf180mcu_as_sc_mcu7t3v3__tap_2
XTAP_TAPCELL_ROW_33_1454 VDD VSS gf180mcu_as_sc_mcu7t3v3__tap_2
XFILLER_22_1139 VDD VDD VSS VSS gf180mcu_as_sc_mcu7t3v3__fillcap_16
XFILLER_26_1297 VDD VDD VSS VSS gf180mcu_as_sc_mcu7t3v3__fillcap_16
XFILLER_27_908 VDD VDD VSS VSS gf180mcu_as_sc_mcu7t3v3__fill_2
XFILLER_4_1060 VDD VDD VSS VSS gf180mcu_as_sc_mcu7t3v3__fillcap_16
XFILLER_187_1379 VDD VDD VSS VSS gf180mcu_as_sc_mcu7t3v3__fillcap_16
XFILLER_198_209 VDD VDD VSS VSS gf180mcu_as_sc_mcu7t3v3__fillcap_16
XFILLER_19_492 VDD VDD VSS VSS gf180mcu_as_sc_mcu7t3v3__fillcap_4
XFILLER_4_1093 VDD VDD VSS VSS gf180mcu_as_sc_mcu7t3v3__fill_1
XTAP_TAPCELL_ROW_65_3_2916 VDD VSS gf180mcu_as_sc_mcu7t3v3__tap_2
XFILLER_34_473 VDD VDD VSS VSS gf180mcu_as_sc_mcu7t3v3__fillcap_8
XFILLER_179_467 VDD VDD VSS VSS gf180mcu_as_sc_mcu7t3v3__fill_1
XFILLER_210_725 VDD VDD VSS VSS gf180mcu_as_sc_mcu7t3v3__fillcap_4
XFILLER_210_747 VDD VDD VSS VSS gf180mcu_as_sc_mcu7t3v3__fill_1
XTAP_TAPCELL_ROW_177_2070 VDD VSS gf180mcu_as_sc_mcu7t3v3__tap_2
XFILLER_210_769 VDD VDD VSS VSS gf180mcu_as_sc_mcu7t3v3__fill_2
X_2987_ VDD VDD VSS VSS _3966_/A _3042_/B _2987_/C _2987_/D _2988_/C gf180mcu_as_sc_mcu7t3v3__ao22_2
XFILLER_198_1431 VDD VDD VSS VSS gf180mcu_as_sc_mcu7t3v3__fillcap_4
XFILLER_33_1246 VDD VDD VSS VSS gf180mcu_as_sc_mcu7t3v3__fillcap_8
X_4726_ VDD VDD VSS VSS _5265_/Q _4730_/B _4730_/C _5264_/Q _4727_/C gf180mcu_as_sc_mcu7t3v3__ao22_2
XFILLER_174_172 VDD VDD VSS VSS gf180mcu_as_sc_mcu7t3v3__fillcap_4
XFILLER_175_673 VDD VDD VSS VSS gf180mcu_as_sc_mcu7t3v3__fill_2
XFILLER_198_1453 VDD VDD VSS VSS gf180mcu_as_sc_mcu7t3v3__fillcap_16
X_4657_ VDD VDD VSS VSS _4658_/B _4657_/B _5229_/Q gf180mcu_as_sc_mcu7t3v3__nand2b_2
XFILLER_174_18 VDD VDD VSS VSS gf180mcu_as_sc_mcu7t3v3__fillcap_16
Xinput80 VDD VDD VSS VSS ne_in[11] wire832/A gf180mcu_as_sc_mcu7t3v3__buff_12
Xinput91 VDD VDD VSS VSS ne_in[21] wire827/A gf180mcu_as_sc_mcu7t3v3__buff_12
X_3608_ VDD VDD VSS VSS _3608_/A _3608_/B _3608_/C _3608_/Y _3608_/D gf180mcu_as_sc_mcu7t3v3__aoi211_2
X_4588_ VDD VDD VSS VSS _4588_/D _4588_/A _4588_/B _4588_/C _4589_/B gf180mcu_as_sc_mcu7t3v3__ao31_2
XFILLER_88_123 VDD VDD VSS VSS gf180mcu_as_sc_mcu7t3v3__fillcap_8
X_3539_ VDD VDD VSS VSS _3539_/B _4946_/Q _3914_/B gf180mcu_as_sc_mcu7t3v3__and2_2
XFILLER_107_67 VDD VDD VSS VSS gf180mcu_as_sc_mcu7t3v3__fill_2
XFILLER_27_1039 VDD VDD VSS VSS gf180mcu_as_sc_mcu7t3v3__fillcap_8
Xclkbuf_leaf_22_clk_regs VDD VDD VSS VSS clkbuf_3_5__f_clk_regs/Y _5280_/CLK gf180mcu_as_sc_mcu7t3v3__clkbuff_12
XFILLER_29_212 VDD VDD VSS VSS gf180mcu_as_sc_mcu7t3v3__fillcap_8
X_5209_ VDD VDD VSS VSS _5214_/CLK _5209_/D _5209_/Q gf180mcu_as_sc_mcu7t3v3__dfxtp_2
XTAP_TAPCELL_ROW_5_845 VDD VSS gf180mcu_as_sc_mcu7t3v3__tap_2
XTAP_TAPCELL_ROW_5_834 VDD VSS gf180mcu_as_sc_mcu7t3v3__tap_2
XFILLER_131_1356 VDD VDD VSS VSS gf180mcu_as_sc_mcu7t3v3__fillcap_4
XFILLER_170_1372 VDD VDD VSS VSS gf180mcu_as_sc_mcu7t3v3__fill_2
XFILLER_170_1383 VDD VDD VSS VSS gf180mcu_as_sc_mcu7t3v3__fillcap_16
XTAP_TAPCELL_ROW_209_2781 VDD VSS gf180mcu_as_sc_mcu7t3v3__tap_2
XTAP_TAPCELL_ROW_209_2770 VDD VSS gf180mcu_as_sc_mcu7t3v3__tap_2
XFILLER_79_1438 VDD VDD VSS VSS gf180mcu_as_sc_mcu7t3v3__fill_2
XFILLER_205_508 VDD VDD VSS VSS gf180mcu_as_sc_mcu7t3v3__fillcap_16
XFILLER_26_941 VDD VDD VSS VSS gf180mcu_as_sc_mcu7t3v3__fillcap_4
XTAP_TAPCELL_ROW_205_2689 VDD VSS gf180mcu_as_sc_mcu7t3v3__tap_2
XTAP_TAPCELL_ROW_205_2678 VDD VSS gf180mcu_as_sc_mcu7t3v3__tap_2
XFILLER_16_53 VDD VDD VSS VSS gf180mcu_as_sc_mcu7t3v3__fillcap_8
XFILLER_26_963 VDD VDD VSS VSS gf180mcu_as_sc_mcu7t3v3__fillcap_8
XFILLER_12_101 VDD VDD VSS VSS gf180mcu_as_sc_mcu7t3v3__fillcap_4
XFILLER_13_602 VDD VDD VSS VSS gf180mcu_as_sc_mcu7t3v3__fillcap_16
XFILLER_25_462 VDD VDD VSS VSS gf180mcu_as_sc_mcu7t3v3__fillcap_16
XFILLER_12_123 VDD VDD VSS VSS gf180mcu_as_sc_mcu7t3v3__fillcap_16
XTAP_TAPCELL_ROW_93_3_3001 VDD VSS gf180mcu_as_sc_mcu7t3v3__tap_2
XFILLER_16_1433 VDD VDD VSS VSS gf180mcu_as_sc_mcu7t3v3__fill_2
XFILLER_185_426 VDD VDD VSS VSS gf180mcu_as_sc_mcu7t3v3__fill_1
XFILLER_90_1373 VDD VDD VSS VSS gf180mcu_as_sc_mcu7t3v3__fillcap_8
XFILLER_200_279 VDD VDD VSS VSS gf180mcu_as_sc_mcu7t3v3__fillcap_16
XFILLER_181_632 VDD VDD VSS VSS gf180mcu_as_sc_mcu7t3v3__fillcap_16
XFILLER_193_492 VDD VDD VSS VSS gf180mcu_as_sc_mcu7t3v3__fillcap_16
XFILLER_113_209 VDD VDD VSS VSS gf180mcu_as_sc_mcu7t3v3__fill_1
XFILLER_10_1087 VDD VDD VSS VSS gf180mcu_as_sc_mcu7t3v3__fill_1
XFILLER_79_101 VDD VDD VSS VSS gf180mcu_as_sc_mcu7t3v3__fillcap_16
XFILLER_121_220 VDD VDD VSS VSS gf180mcu_as_sc_mcu7t3v3__fill_2
XPHY_EDGE_ROW_113_1_Left_323 VDD VSS gf180mcu_as_sc_mcu7t3v3__tap_2
XFILLER_0_550 VDD VDD VSS VSS gf180mcu_as_sc_mcu7t3v3__fill_2
XFILLER_94_104 VDD VDD VSS VSS gf180mcu_as_sc_mcu7t3v3__fill_1
XFILLER_110_1407 VDD VDD VSS VSS gf180mcu_as_sc_mcu7t3v3__fillcap_4
XFILLER_208_346 VDD VDD VSS VSS gf180mcu_as_sc_mcu7t3v3__fillcap_4
XFILLER_97_1538 VDD VDD VSS VSS gf180mcu_as_sc_mcu7t3v3__fillcap_4
XFILLER_97_1549 VDD VDD VSS VSS gf180mcu_as_sc_mcu7t3v3__fillcap_4
XFILLER_16_451 VDD VDD VSS VSS gf180mcu_as_sc_mcu7t3v3__fillcap_4
XFILLER_17_963 VDD VDD VSS VSS gf180mcu_as_sc_mcu7t3v3__fillcap_16
XFILLER_182_1221 VDD VDD VSS VSS gf180mcu_as_sc_mcu7t3v3__fillcap_4
XFILLER_182_1243 VDD VDD VSS VSS gf180mcu_as_sc_mcu7t3v3__fillcap_4
X_2910_ VDD VDD VSS VSS _3818_/D _3253_/A _3254_/A gf180mcu_as_sc_mcu7t3v3__nor2_2
XFILLER_182_1254 VDD VDD VSS VSS gf180mcu_as_sc_mcu7t3v3__fillcap_16
XFILLER_31_443 VDD VDD VSS VSS gf180mcu_as_sc_mcu7t3v3__fillcap_16
X_3890_ VDD VDD VSS VSS _3890_/B _5180_/Q _4930_/D gf180mcu_as_sc_mcu7t3v3__and2_2
XFILLER_188_275 VDD VDD VSS VSS gf180mcu_as_sc_mcu7t3v3__fill_2
XFILLER_31_487 VDD VDD VSS VSS gf180mcu_as_sc_mcu7t3v3__fill_2
XFILLER_85_4 VDD VDD VSS VSS gf180mcu_as_sc_mcu7t3v3__fill_1
XTAP_TAPCELL_ROW_140_3_3140 VDD VSS gf180mcu_as_sc_mcu7t3v3__tap_2
X_2841_ VDD VDD VSS VSS _2841_/B _2841_/A _2842_/C gf180mcu_as_sc_mcu7t3v3__xnor2_2
XFILLER_185_960 VDD VDD VSS VSS gf180mcu_as_sc_mcu7t3v3__fillcap_16
X_2772_ VDD VDD VSS VSS _2773_/B _2776_/A _5230_/Q gf180mcu_as_sc_mcu7t3v3__nand2_2
XFILLER_121_1558 VDD VDD VSS VSS gf180mcu_as_sc_mcu7t3v3__fillcap_8
XFILLER_185_982 VDD VDD VSS VSS gf180mcu_as_sc_mcu7t3v3__fillcap_16
XFILLER_8_650 VDD VDD VSS VSS gf180mcu_as_sc_mcu7t3v3__fillcap_8
XFILLER_8_683 VDD VDD VSS VSS gf180mcu_as_sc_mcu7t3v3__fill_2
X_4511_ VDD VDD VSS VSS _4511_/D _4561_/A _4511_/B _4511_/C _4512_/B gf180mcu_as_sc_mcu7t3v3__ao31_2
XFILLER_171_131 VDD VDD VSS VSS gf180mcu_as_sc_mcu7t3v3__fillcap_8
X_4442_ VDD VDD VSS VSS _5171_/Q _4504_/B _4442_/C _4442_/D _5171_/D gf180mcu_as_sc_mcu7t3v3__ao211_2
XFILLER_119_1410 VDD VDD VSS VSS gf180mcu_as_sc_mcu7t3v3__fillcap_4
XFILLER_171_153 VDD VDD VSS VSS gf180mcu_as_sc_mcu7t3v3__fillcap_8
XTAP_TAPCELL_ROW_120_3_3082 VDD VSS gf180mcu_as_sc_mcu7t3v3__tap_2
XFILLER_158_1492 VDD VDD VSS VSS gf180mcu_as_sc_mcu7t3v3__fillcap_4
XPHY_EDGE_ROW_45_1_Left_255 VDD VSS gf180mcu_as_sc_mcu7t3v3__tap_2
X_4373_ VDD VDD VSS VSS _5483_/A _4575_/C _4373_/C _4590_/B _4374_/B gf180mcu_as_sc_mcu7t3v3__ao22_2
XTAP_TAPCELL_ROW_35_1505 VDD VSS gf180mcu_as_sc_mcu7t3v3__tap_2
Xfanout607 VDD VDD VSS VSS _4946_/D _3903_/B gf180mcu_as_sc_mcu7t3v3__buff_12
Xfanout618 VDD VDD VSS VSS _4575_/B _4493_/B gf180mcu_as_sc_mcu7t3v3__buff_12
Xfanout629 VDD VDD VSS VSS _4104_/C _4032_/C gf180mcu_as_sc_mcu7t3v3__buff_12
X_3324_ VDD VDD VSS VSS _3381_/S _3976_/D _3324_/A _3326_/B gf180mcu_as_sc_mcu7t3v3__mux2_2
XFILLER_189_1408 VDD VDD VSS VSS gf180mcu_as_sc_mcu7t3v3__fill_1
XFILLER_80_1542 VDD VDD VSS VSS gf180mcu_as_sc_mcu7t3v3__fill_2
XFILLER_85_115 VDD VDD VSS VSS gf180mcu_as_sc_mcu7t3v3__fillcap_8
X_4880__1087 VDD VDD VSS VSS _4880_/D gf180mcu_as_sc_mcu7t3v3__tiel_4
X_3255_ VDD VDD VSS VSS _3787_/A _3255_/B _3255_/C _3517_/D gf180mcu_as_sc_mcu7t3v3__nand3_2
XFILLER_26_204 VDD VDD VSS VSS gf180mcu_as_sc_mcu7t3v3__fillcap_16
X_3186_ VDD VDD VSS VSS _3186_/D _4159_/D _3236_/B _3236_/C _3188_/B gf180mcu_as_sc_mcu7t3v3__ao31_2
XTAP_TAPCELL_ROW_98_3_3016 VDD VSS gf180mcu_as_sc_mcu7t3v3__tap_2
XTAP_TAPCELL_ROW_86_1_1704 VDD VSS gf180mcu_as_sc_mcu7t3v3__tap_2
XFILLER_187_1154 VDD VDD VSS VSS gf180mcu_as_sc_mcu7t3v3__fillcap_16
XPHY_EDGE_ROW_133_3_Right_170 VDD VSS gf180mcu_as_sc_mcu7t3v3__tap_2
XTAP_TAPCELL_ROW_179_2121 VDD VSS gf180mcu_as_sc_mcu7t3v3__tap_2
XTAP_TAPCELL_ROW_179_2110 VDD VSS gf180mcu_as_sc_mcu7t3v3__tap_2
XFILLER_165_1452 VDD VDD VSS VSS gf180mcu_as_sc_mcu7t3v3__fillcap_16
XFILLER_126_1436 VDD VDD VSS VSS gf180mcu_as_sc_mcu7t3v3__fillcap_4
XFILLER_195_702 VDD VDD VSS VSS gf180mcu_as_sc_mcu7t3v3__fillcap_16
XFILLER_34_281 VDD VDD VSS VSS gf180mcu_as_sc_mcu7t3v3__fill_1
XFILLER_39_1488 VDD VDD VSS VSS gf180mcu_as_sc_mcu7t3v3__fillcap_16
XFILLER_74_1357 VDD VDD VSS VSS gf180mcu_as_sc_mcu7t3v3__fill_2
XTAP_TAPCELL_ROW_200_2575 VDD VSS gf180mcu_as_sc_mcu7t3v3__tap_2
XTAP_TAPCELL_ROW_200_2564 VDD VSS gf180mcu_as_sc_mcu7t3v3__tap_2
XTAP_TAPCELL_ROW_175_2029 VDD VSS gf180mcu_as_sc_mcu7t3v3__tap_2
XTAP_TAPCELL_ROW_175_2018 VDD VSS gf180mcu_as_sc_mcu7t3v3__tap_2
XFILLER_210_555 VDD VDD VSS VSS gf180mcu_as_sc_mcu7t3v3__fillcap_4
XFILLER_22_454 VDD VDD VSS VSS gf180mcu_as_sc_mcu7t3v3__fill_1
XFILLER_23_977 VDD VDD VSS VSS gf180mcu_as_sc_mcu7t3v3__fill_2
XTAP_TAPCELL_ROW_196_2490 VDD VSS gf180mcu_as_sc_mcu7t3v3__tap_2
XFILLER_202_1313 VDD VDD VSS VSS gf180mcu_as_sc_mcu7t3v3__fillcap_16
XFILLER_210_577 VDD VDD VSS VSS gf180mcu_as_sc_mcu7t3v3__fill_1
XFILLER_22_498 VDD VDD VSS VSS gf180mcu_as_sc_mcu7t3v3__fillcap_16
XFILLER_175_470 VDD VDD VSS VSS gf180mcu_as_sc_mcu7t3v3__fillcap_4
XFILLER_210_599 VDD VDD VSS VSS gf180mcu_as_sc_mcu7t3v3__fill_2
X_4709_ VDD VDD VSS VSS _4717_/S _5257_/Q _5258_/Q _4710_/B gf180mcu_as_sc_mcu7t3v3__mux2_2
XTAP_TAPCELL_ROW_192_2398 VDD VSS gf180mcu_as_sc_mcu7t3v3__tap_2
XTAP_TAPCELL_ROW_192_2387 VDD VSS gf180mcu_as_sc_mcu7t3v3__tap_2
XFILLER_194_1103 VDD VDD VSS VSS gf180mcu_as_sc_mcu7t3v3__fillcap_16
XFILLER_190_473 VDD VDD VSS VSS gf180mcu_as_sc_mcu7t3v3__fillcap_4
XFILLER_200_1081 VDD VDD VSS VSS gf180mcu_as_sc_mcu7t3v3__fillcap_4
XPHY_EDGE_ROW_135_3_Left_520 VDD VSS gf180mcu_as_sc_mcu7t3v3__tap_2
XFILLER_103_220 VDD VDD VSS VSS gf180mcu_as_sc_mcu7t3v3__fill_2
XPHY_EDGE_ROW_57_3_Right_94 VDD VSS gf180mcu_as_sc_mcu7t3v3__tap_2
Xmesh_tile_1006 VDD VDD VSS VSS nw_out[13] gf180mcu_as_sc_mcu7t3v3__tiel_4
Xmesh_tile_1017 VDD VDD VSS VSS nw_out[24] gf180mcu_as_sc_mcu7t3v3__tiel_4
XTAP_TAPCELL_ROW_207_2729 VDD VSS gf180mcu_as_sc_mcu7t3v3__tap_2
XTAP_TAPCELL_ROW_207_2718 VDD VSS gf180mcu_as_sc_mcu7t3v3__tap_2
XFILLER_94_69 VDD VDD VSS VSS gf180mcu_as_sc_mcu7t3v3__fillcap_8
XTAP_TAPCELL_ROW_133_1_1843 VDD VSS gf180mcu_as_sc_mcu7t3v3__tap_2
Xmesh_tile_1039 VDD VDD VSS VSS sw_out[12] gf180mcu_as_sc_mcu7t3v3__tiel_4
Xmesh_tile_1028 VDD VDD VSS VSS sw_out[1] gf180mcu_as_sc_mcu7t3v3__tiel_4
XFILLER_22_1470 VDD VDD VSS VSS gf180mcu_as_sc_mcu7t3v3__fillcap_4
XTAP_TAPCELL_ROW_145_3_3155 VDD VSS gf180mcu_as_sc_mcu7t3v3__tap_2
XFILLER_206_839 VDD VDD VSS VSS gf180mcu_as_sc_mcu7t3v3__fillcap_16
XFILLER_92_1424 VDD VDD VSS VSS gf180mcu_as_sc_mcu7t3v3__fill_1
XFILLER_207_1224 VDD VDD VSS VSS gf180mcu_as_sc_mcu7t3v3__fillcap_16
XFILLER_57_1566 VDD VDD VSS VSS gf180mcu_as_sc_mcu7t3v3__fill_2
XFILLER_185_212 VDD VDD VSS VSS gf180mcu_as_sc_mcu7t3v3__fillcap_16
XTAP_TAPCELL_ROW_113_1_1785 VDD VSS gf180mcu_as_sc_mcu7t3v3__tap_2
XFILLER_13_487 VDD VDD VSS VSS gf180mcu_as_sc_mcu7t3v3__fill_2
XFILLER_199_1014 VDD VDD VSS VSS gf180mcu_as_sc_mcu7t3v3__fillcap_16
XTAP_TAPCELL_ROW_125_3_3097 VDD VSS gf180mcu_as_sc_mcu7t3v3__tap_2
XFILLER_182_941 VDD VDD VSS VSS gf180mcu_as_sc_mcu7t3v3__fillcap_4
XFILLER_182_963 VDD VDD VSS VSS gf180mcu_as_sc_mcu7t3v3__fillcap_16
XPHY_EDGE_ROW_67_3_Left_452 VDD VSS gf180mcu_as_sc_mcu7t3v3__tap_2
XFILLER_153_142 VDD VDD VSS VSS gf180mcu_as_sc_mcu7t3v3__fillcap_16
XFILLER_181_473 VDD VDD VSS VSS gf180mcu_as_sc_mcu7t3v3__fillcap_4
XFILLER_99_207 VDD VDD VSS VSS gf180mcu_as_sc_mcu7t3v3__fill_2
XFILLER_175_72 VDD VDD VSS VSS gf180mcu_as_sc_mcu7t3v3__fillcap_16
XFILLER_190_1501 VDD VDD VSS VSS gf180mcu_as_sc_mcu7t3v3__fillcap_4
XFILLER_4_34 VDD VDD VSS VSS gf180mcu_as_sc_mcu7t3v3__fill_1
XFILLER_190_1523 VDD VDD VSS VSS gf180mcu_as_sc_mcu7t3v3__fillcap_8
XTAP_TAPCELL_ROW_90_3_2992 VDD VSS gf180mcu_as_sc_mcu7t3v3__tap_2
XFILLER_4_78 VDD VDD VSS VSS gf180mcu_as_sc_mcu7t3v3__fill_2
XFILLER_67_104 VDD VDD VSS VSS gf180mcu_as_sc_mcu7t3v3__fill_1
XFILLER_0_380 VDD VDD VSS VSS gf180mcu_as_sc_mcu7t3v3__fill_2
XFILLER_67_148 VDD VDD VSS VSS gf180mcu_as_sc_mcu7t3v3__fill_1
XFILLER_68_92 VDD VDD VSS VSS gf180mcu_as_sc_mcu7t3v3__fillcap_8
XFILLER_114_1373 VDD VDD VSS VSS gf180mcu_as_sc_mcu7t3v3__fillcap_8
XFILLER_82_107 VDD VDD VSS VSS gf180mcu_as_sc_mcu7t3v3__fillcap_16
Xinput270 VDD VDD VSS VSS sw_in[29] _3794_/A gf180mcu_as_sc_mcu7t3v3__buff_12
Xinput281 VDD VDD VSS VSS sw_in[8] _2430_/A gf180mcu_as_sc_mcu7t3v3__buff_12
X_3040_ VDD VDD VSS VSS _3615_/D _3115_/A _3040_/B _3040_/C _3041_/C gf180mcu_as_sc_mcu7t3v3__ao31_2
XFILLER_149_1414 VDD VDD VSS VSS gf180mcu_as_sc_mcu7t3v3__fill_2
XFILLER_23_1278 VDD VDD VSS VSS gf180mcu_as_sc_mcu7t3v3__fillcap_4
Xinput292 VDD VDD VSS VSS west_in[18] _4077_/D gf180mcu_as_sc_mcu7t3v3__buff_12
XFILLER_1_1052 VDD VDD VSS VSS gf180mcu_as_sc_mcu7t3v3__fillcap_16
XFILLER_24_708 VDD VDD VSS VSS gf180mcu_as_sc_mcu7t3v3__fillcap_4
XFILLER_36_546 VDD VDD VSS VSS gf180mcu_as_sc_mcu7t3v3__fillcap_4
XFILLER_84_80 VDD VDD VSS VSS gf180mcu_as_sc_mcu7t3v3__fillcap_4
X_4991_ VDD VDD VSS VSS clkload4/A _4991_/D _4991_/Q gf180mcu_as_sc_mcu7t3v3__dfxtp_2
XFILLER_177_702 VDD VDD VSS VSS gf180mcu_as_sc_mcu7t3v3__fill_2
XFILLER_189_551 VDD VDD VSS VSS gf180mcu_as_sc_mcu7t3v3__fillcap_8
XFILLER_189_562 VDD VDD VSS VSS gf180mcu_as_sc_mcu7t3v3__fillcap_16
X_3942_ VDD VDD VSS VSS _3942_/A _4030_/C _3942_/C _3942_/D _3943_/C gf180mcu_as_sc_mcu7t3v3__ao211_2
XTAP_TAPCELL_ROW_28_1353 VDD VSS gf180mcu_as_sc_mcu7t3v3__tap_2
XTAP_TAPCELL_ROW_28_1342 VDD VSS gf180mcu_as_sc_mcu7t3v3__tap_2
XFILLER_176_223 VDD VDD VSS VSS gf180mcu_as_sc_mcu7t3v3__fillcap_16
XFILLER_31_240 VDD VDD VSS VSS gf180mcu_as_sc_mcu7t3v3__fillcap_16
XFILLER_32_785 VDD VDD VSS VSS gf180mcu_as_sc_mcu7t3v3__fill_1
X_3873_ VDD VDD VSS VSS _3873_/A _3873_/B _3873_/C _3874_/B gf180mcu_as_sc_mcu7t3v3__nor3_2
XFILLER_177_768 VDD VDD VSS VSS gf180mcu_as_sc_mcu7t3v3__fill_2
XFILLER_20_947 VDD VDD VSS VSS gf180mcu_as_sc_mcu7t3v3__fillcap_16
XFILLER_34_1341 VDD VDD VSS VSS gf180mcu_as_sc_mcu7t3v3__fillcap_8
X_2824_ VDD VDD VSS VSS _4974_/D _2830_/B _4761_/Q _4760_/D gf180mcu_as_sc_mcu7t3v3__mux2_2
XTAP_TAPCELL_ROW_171_3_3234 VDD VSS gf180mcu_as_sc_mcu7t3v3__tap_2
X_4898__1069 VDD VDD VSS VSS _4898_/D gf180mcu_as_sc_mcu7t3v3__tiel_4
XFILLER_191_259 VDD VDD VSS VSS gf180mcu_as_sc_mcu7t3v3__fillcap_16
XFILLER_30_1227 VDD VDD VSS VSS gf180mcu_as_sc_mcu7t3v3__fill_2
X_2755_ VDD VDD VSS VSS _2780_/B _4633_/A _2765_/C gf180mcu_as_sc_mcu7t3v3__and2_2
XFILLER_195_1434 VDD VDD VSS VSS gf180mcu_as_sc_mcu7t3v3__fillcap_16
XFILLER_69_1459 VDD VDD VSS VSS gf180mcu_as_sc_mcu7t3v3__fillcap_4
X_2686_ VDD VDD VSS VSS _2709_/A _2686_/B _2686_/C _2686_/D _2686_/Y gf180mcu_as_sc_mcu7t3v3__ao22_2
XTAP_TAPCELL_ROW_138_1_1858 VDD VSS gf180mcu_as_sc_mcu7t3v3__tap_2
X_4425_ VDD VDD VSS VSS _5171_/Q _4470_/B _4479_/C _5121_/Q _4426_/B gf180mcu_as_sc_mcu7t3v3__ao22_2
XFILLER_28_1123 VDD VDD VSS VSS gf180mcu_as_sc_mcu7t3v3__fill_1
X_4356_ VDD VDD VSS VSS _4356_/B _4554_/B _4357_/D gf180mcu_as_sc_mcu7t3v3__and2_2
XFILLER_58_104 VDD VDD VSS VSS gf180mcu_as_sc_mcu7t3v3__fill_1
X_3307_ VDD VDD VSS VSS _3308_/A _3956_/D _3404_/B _3307_/C gf180mcu_as_sc_mcu7t3v3__ao21_2
XFILLER_58_137 VDD VDD VSS VSS gf180mcu_as_sc_mcu7t3v3__fillcap_8
X_4287_ VDD VDD VSS VSS _4289_/S _5483_/A _5121_/Q _5121_/D gf180mcu_as_sc_mcu7t3v3__mux2_2
X_3238_ VDD VDD VSS VSS _3240_/C _3238_/C _3238_/B _3238_/A gf180mcu_as_sc_mcu7t3v3__aoi21_2
XFILLER_132_1473 VDD VDD VSS VSS gf180mcu_as_sc_mcu7t3v3__fill_1
X_3169_ VDD VDD VSS VSS _4144_/A _3233_/B _3169_/C _4143_/D _3170_/C gf180mcu_as_sc_mcu7t3v3__ao22_2
XFILLER_27_546 VDD VDD VSS VSS gf180mcu_as_sc_mcu7t3v3__fill_2
XTAP_TAPCELL_ROW_202_2626 VDD VSS gf180mcu_as_sc_mcu7t3v3__tap_2
XTAP_TAPCELL_ROW_202_2615 VDD VSS gf180mcu_as_sc_mcu7t3v3__tap_2
XTAP_TAPCELL_ROW_198_2530 VDD VSS gf180mcu_as_sc_mcu7t3v3__tap_2
XFILLER_14_218 VDD VDD VSS VSS gf180mcu_as_sc_mcu7t3v3__fillcap_4
XFILLER_167_1558 VDD VDD VSS VSS gf180mcu_as_sc_mcu7t3v3__fillcap_8
XFILLER_81_173 VDD VDD VSS VSS gf180mcu_as_sc_mcu7t3v3__fill_1
XPHY_EDGE_ROW_134_3_Right_171 VDD VSS gf180mcu_as_sc_mcu7t3v3__tap_2
XFILLER_208_1555 VDD VDD VSS VSS gf180mcu_as_sc_mcu7t3v3__fillcap_8
XFILLER_167_212 VDD VDD VSS VSS gf180mcu_as_sc_mcu7t3v3__fillcap_8
XFILLER_35_1138 VDD VDD VSS VSS gf180mcu_as_sc_mcu7t3v3__fillcap_8
XTAP_TAPCELL_ROW_194_2449 VDD VSS gf180mcu_as_sc_mcu7t3v3__tap_2
XTAP_TAPCELL_ROW_194_2438 VDD VSS gf180mcu_as_sc_mcu7t3v3__tap_2
XFILLER_10_413 VDD VDD VSS VSS gf180mcu_as_sc_mcu7t3v3__fill_1
XFILLER_11_936 VDD VDD VSS VSS gf180mcu_as_sc_mcu7t3v3__fillcap_4
XFILLER_10_457 VDD VDD VSS VSS gf180mcu_as_sc_mcu7t3v3__fillcap_16
XFILLER_13_43 VDD VDD VSS VSS gf180mcu_as_sc_mcu7t3v3__fillcap_16
Xwire827 VDD VDD VSS VSS wire827/A _4104_/D gf180mcu_as_sc_mcu7t3v3__clkbuff_12
Xwire838 VDD VDD VSS VSS wire838/A _3517_/A gf180mcu_as_sc_mcu7t3v3__clkbuff_12
Xwire849 VDD VDD VSS VSS wire849/A _4103_/A gf180mcu_as_sc_mcu7t3v3__clkbuff_12
XFILLER_129_43 VDD VDD VSS VSS gf180mcu_as_sc_mcu7t3v3__fillcap_16
XFILLER_182_237 VDD VDD VSS VSS gf180mcu_as_sc_mcu7t3v3__fill_1
XFILLER_100_1439 VDD VDD VSS VSS gf180mcu_as_sc_mcu7t3v3__fillcap_8
XFILLER_129_98 VDD VDD VSS VSS gf180mcu_as_sc_mcu7t3v3__fill_1
XFILLER_150_134 VDD VDD VSS VSS gf180mcu_as_sc_mcu7t3v3__fillcap_4
XFILLER_1_199 VDD VDD VSS VSS gf180mcu_as_sc_mcu7t3v3__fillcap_8
XFILLER_49_137 VDD VDD VSS VSS gf180mcu_as_sc_mcu7t3v3__fill_2
XFILLER_64_107 VDD VDD VSS VSS gf180mcu_as_sc_mcu7t3v3__fillcap_4
XFILLER_111_1568 VDD VDD VSS VSS gf180mcu_as_sc_mcu7t3v3__fill_1
XTAP_TAPCELL_ROW_164_1_1937 VDD VSS gf180mcu_as_sc_mcu7t3v3__tap_2
XFILLER_18_1325 VDD VDD VSS VSS gf180mcu_as_sc_mcu7t3v3__fill_2
XFILLER_201_330 VDD VDD VSS VSS gf180mcu_as_sc_mcu7t3v3__fillcap_16
XFILLER_201_352 VDD VDD VSS VSS gf180mcu_as_sc_mcu7t3v3__fillcap_16
XFILLER_144_1399 VDD VDD VSS VSS gf180mcu_as_sc_mcu7t3v3__fillcap_4
XFILLER_179_1418 VDD VDD VSS VSS gf180mcu_as_sc_mcu7t3v3__fillcap_8
XFILLER_31_1503 VDD VDD VSS VSS gf180mcu_as_sc_mcu7t3v3__fillcap_8
XFILLER_9_255 VDD VDD VSS VSS gf180mcu_as_sc_mcu7t3v3__fillcap_16
XTAP_TAPCELL_ROW_12_986 VDD VSS gf180mcu_as_sc_mcu7t3v3__tap_2
XTAP_TAPCELL_ROW_12_997 VDD VSS gf180mcu_as_sc_mcu7t3v3__tap_2
Xclkload14 VDD VDD VSS VSS clkload14/Y _5082_/CLK gf180mcu_as_sc_mcu7t3v3__inv_2
Xclkload25 VDD VDD VSS VSS _5220_/CLK clkload25/Y gf180mcu_as_sc_mcu7t3v3__clkbuff_4
X_2540_ VDD VDD VSS VSS _2541_/C _4371_/B _4372_/D _2792_/A gf180mcu_as_sc_mcu7t3v3__aoi21_2
XFILLER_126_164 VDD VDD VSS VSS gf180mcu_as_sc_mcu7t3v3__fillcap_8
XFILLER_6_984 VDD VDD VSS VSS gf180mcu_as_sc_mcu7t3v3__fill_2
X_2471_ VDD VDD VSS VSS _2472_/B _2471_/A gf180mcu_as_sc_mcu7t3v3__inv_2
XFILLER_177_1186 VDD VDD VSS VSS gf180mcu_as_sc_mcu7t3v3__fillcap_4
X_4210_ VDD VDD VSS VSS _4239_/B _4222_/B _4222_/C _5046_/Q _5046_/D gf180mcu_as_sc_mcu7t3v3__ao22_2
XFILLER_64_1356 VDD VDD VSS VSS gf180mcu_as_sc_mcu7t3v3__fill_2
X_5190_ VDD VDD VSS VSS _5192_/CLK _5190_/D _5190_/Q gf180mcu_as_sc_mcu7t3v3__dfxtp_2
XFILLER_205_34 VDD VDD VSS VSS gf180mcu_as_sc_mcu7t3v3__fillcap_16
X_4141_ VDD VDD VSS VSS _4141_/A _4141_/B _4141_/C _4254_/B _4141_/D gf180mcu_as_sc_mcu7t3v3__aoi211_2
XFILLER_116_1479 VDD VDD VSS VSS gf180mcu_as_sc_mcu7t3v3__fillcap_16
XFILLER_209_430 VDD VDD VSS VSS gf180mcu_as_sc_mcu7t3v3__fill_1
X_4072_ VDD VDD VSS VSS _4072_/A _4130_/B _4128_/B _4072_/D _4073_/D gf180mcu_as_sc_mcu7t3v3__ao22_2
XTAP_TAPCELL_ROW_17_1098 VDD VSS gf180mcu_as_sc_mcu7t3v3__tap_2
XFILLER_23_1064 VDD VDD VSS VSS gf180mcu_as_sc_mcu7t3v3__fill_2
XFILLER_3_1136 VDD VDD VSS VSS gf180mcu_as_sc_mcu7t3v3__fill_1
XFILLER_48_170 VDD VDD VSS VSS gf180mcu_as_sc_mcu7t3v3__fillcap_4
X_3023_ VDD VDD VSS VSS _4003_/A _3141_/B _3023_/C _3023_/Y _3691_/D gf180mcu_as_sc_mcu7t3v3__aoi211_2
XFILLER_184_1135 VDD VDD VSS VSS gf180mcu_as_sc_mcu7t3v3__fillcap_16
XFILLER_24_527 VDD VDD VSS VSS gf180mcu_as_sc_mcu7t3v3__fillcap_16
XFILLER_36_376 VDD VDD VSS VSS gf180mcu_as_sc_mcu7t3v3__fillcap_8
XFILLER_63_162 VDD VDD VSS VSS gf180mcu_as_sc_mcu7t3v3__fill_1
XFILLER_184_1157 VDD VDD VSS VSS gf180mcu_as_sc_mcu7t3v3__fillcap_16
X_4974_ VDD VDD VSS VSS _5285_/CLK _4974_/D _4974_/Q gf180mcu_as_sc_mcu7t3v3__dfxtp_2
XFILLER_149_212 VDD VDD VSS VSS gf180mcu_as_sc_mcu7t3v3__fillcap_8
XFILLER_205_680 VDD VDD VSS VSS gf180mcu_as_sc_mcu7t3v3__fillcap_16
X_3925_ VDD VDD VSS VSS _3925_/A _4032_/C _4030_/B _3925_/D _3926_/D gf180mcu_as_sc_mcu7t3v3__ao22_2
XFILLER_164_204 VDD VDD VSS VSS gf180mcu_as_sc_mcu7t3v3__fillcap_16
XFILLER_177_587 VDD VDD VSS VSS gf180mcu_as_sc_mcu7t3v3__fillcap_8
XFILLER_192_524 VDD VDD VSS VSS gf180mcu_as_sc_mcu7t3v3__fill_1
XFILLER_20_755 VDD VDD VSS VSS gf180mcu_as_sc_mcu7t3v3__fill_1
Xclkload8 VDD VDD VSS VSS clkload8/Y clkload8/A gf180mcu_as_sc_mcu7t3v3__inv_2
X_3856_ VDD VDD VSS VSS _5144_/Q _5143_/Q _3857_/C gf180mcu_as_sc_mcu7t3v3__or2_2
XFILLER_20_799 VDD VDD VSS VSS gf180mcu_as_sc_mcu7t3v3__fillcap_4
X_3787_ VDD VDD VSS VSS _3818_/D _3787_/A _3796_/C gf180mcu_as_sc_mcu7t3v3__and2_2
X_2807_ VDD VDD VSS VSS _4660_/A _4259_/C _4643_/B gf180mcu_as_sc_mcu7t3v3__nor2_2
XFILLER_117_131 VDD VDD VSS VSS gf180mcu_as_sc_mcu7t3v3__fillcap_8
XFILLER_117_142 VDD VDD VSS VSS gf180mcu_as_sc_mcu7t3v3__fillcap_16
X_2738_ VDD VDD VSS VSS _4947_/Q _2738_/B _2738_/A _5479_/A gf180mcu_as_sc_mcu7t3v3__mux2_2
XFILLER_117_186 VDD VDD VSS VSS gf180mcu_as_sc_mcu7t3v3__fill_1
X_4408_ VDD VDD VSS VSS _5169_/Q _4470_/B _4479_/C _5119_/Q _4409_/B gf180mcu_as_sc_mcu7t3v3__ao22_2
X_2669_ VDD VDD VSS VSS _2673_/B _5133_/Q _2670_/D gf180mcu_as_sc_mcu7t3v3__and2_2
XFILLER_8_1014 VDD VDD VSS VSS gf180mcu_as_sc_mcu7t3v3__fill_1
XPHY_EDGE_ROW_159_1_Right_680 VDD VSS gf180mcu_as_sc_mcu7t3v3__tap_2
XFILLER_43_1418 VDD VDD VSS VSS gf180mcu_as_sc_mcu7t3v3__fillcap_16
X_4339_ VDD VDD VSS VSS _4350_/C _4339_/B _4350_/A gf180mcu_as_sc_mcu7t3v3__nor2_2
XTAP_TAPCELL_ROW_187_2297 VDD VSS gf180mcu_as_sc_mcu7t3v3__tap_2
XTAP_TAPCELL_ROW_187_2286 VDD VSS gf180mcu_as_sc_mcu7t3v3__tap_2
XFILLER_189_1046 VDD VDD VSS VSS gf180mcu_as_sc_mcu7t3v3__fillcap_4
XFILLER_210_1445 VDD VDD VSS VSS gf180mcu_as_sc_mcu7t3v3__fillcap_4
XFILLER_46_107 VDD VDD VSS VSS gf180mcu_as_sc_mcu7t3v3__fillcap_16
XTAP_TAPCELL_ROW_54_1_1606 VDD VSS gf180mcu_as_sc_mcu7t3v3__tap_2
XFILLER_189_1068 VDD VDD VSS VSS gf180mcu_as_sc_mcu7t3v3__fillcap_16
XFILLER_28_855 VDD VDD VSS VSS gf180mcu_as_sc_mcu7t3v3__fillcap_16
XFILLER_28_877 VDD VDD VSS VSS gf180mcu_as_sc_mcu7t3v3__fillcap_16
XFILLER_131_66 VDD VDD VSS VSS gf180mcu_as_sc_mcu7t3v3__fillcap_4
XFILLER_131_99 VDD VDD VSS VSS gf180mcu_as_sc_mcu7t3v3__fill_2
XFILLER_93_1530 VDD VDD VSS VSS gf180mcu_as_sc_mcu7t3v3__fill_1
XPHY_EDGE_ROW_135_3_Right_172 VDD VSS gf180mcu_as_sc_mcu7t3v3__tap_2
XFILLER_180_1566 VDD VDD VSS VSS gf180mcu_as_sc_mcu7t3v3__fill_2
XFILLER_204_1205 VDD VDD VSS VSS gf180mcu_as_sc_mcu7t3v3__fillcap_16
XFILLER_204_1227 VDD VDD VSS VSS gf180mcu_as_sc_mcu7t3v3__fillcap_16
XFILLER_24_53 VDD VDD VSS VSS gf180mcu_as_sc_mcu7t3v3__fillcap_16
XPHY_EDGE_ROW_122_1_Left_332 VDD VSS gf180mcu_as_sc_mcu7t3v3__tap_2
XFILLER_11_755 VDD VDD VSS VSS gf180mcu_as_sc_mcu7t3v3__fill_1
XFILLER_138_2 VDD VDD VSS VSS gf180mcu_as_sc_mcu7t3v3__fillcap_16
XFILLER_141_1539 VDD VDD VSS VSS gf180mcu_as_sc_mcu7t3v3__fillcap_16
XFILLER_196_874 VDD VDD VSS VSS gf180mcu_as_sc_mcu7t3v3__fill_1
XFILLER_196_1017 VDD VDD VSS VSS gf180mcu_as_sc_mcu7t3v3__fillcap_16
Xwire657 VDD VDD VSS VSS wire657/A _3071_/B gf180mcu_as_sc_mcu7t3v3__clkbuff_12
XFILLER_104_1383 VDD VDD VSS VSS gf180mcu_as_sc_mcu7t3v3__fillcap_16
XFILLER_108_142 VDD VDD VSS VSS gf180mcu_as_sc_mcu7t3v3__fill_1
XFILLER_156_30 VDD VDD VSS VSS gf180mcu_as_sc_mcu7t3v3__fillcap_4
XFILLER_6_247 VDD VDD VSS VSS gf180mcu_as_sc_mcu7t3v3__fillcap_4
XFILLER_139_1413 VDD VDD VSS VSS gf180mcu_as_sc_mcu7t3v3__fill_2
XFILLER_40_96 VDD VDD VSS VSS gf180mcu_as_sc_mcu7t3v3__fillcap_8
XFILLER_123_123 VDD VDD VSS VSS gf180mcu_as_sc_mcu7t3v3__fillcap_16
XFILLER_156_85 VDD VDD VSS VSS gf180mcu_as_sc_mcu7t3v3__fillcap_16
XFILLER_123_167 VDD VDD VSS VSS gf180mcu_as_sc_mcu7t3v3__fillcap_16
XFILLER_3_976 VDD VDD VSS VSS gf180mcu_as_sc_mcu7t3v3__fillcap_4
XFILLER_49_72 VDD VDD VSS VSS gf180mcu_as_sc_mcu7t3v3__fillcap_8
XFILLER_207_912 VDD VDD VSS VSS gf180mcu_as_sc_mcu7t3v3__fillcap_16
Xfanout790 VDD VDD VSS VSS _4581_/A _4502_/A gf180mcu_as_sc_mcu7t3v3__buff_12
XFILLER_111_1376 VDD VDD VSS VSS gf180mcu_as_sc_mcu7t3v3__fill_2
XFILLER_185_1422 VDD VDD VSS VSS gf180mcu_as_sc_mcu7t3v3__fill_1
XFILLER_18_376 VDD VDD VSS VSS gf180mcu_as_sc_mcu7t3v3__fillcap_8
XFILLER_20_1259 VDD VDD VSS VSS gf180mcu_as_sc_mcu7t3v3__fillcap_16
XFILLER_59_1436 VDD VDD VSS VSS gf180mcu_as_sc_mcu7t3v3__fill_1
XFILLER_18_398 VDD VDD VSS VSS gf180mcu_as_sc_mcu7t3v3__fill_1
XFILLER_21_508 VDD VDD VSS VSS gf180mcu_as_sc_mcu7t3v3__fillcap_16
XFILLER_33_368 VDD VDD VSS VSS gf180mcu_as_sc_mcu7t3v3__fillcap_16
XFILLER_60_143 VDD VDD VSS VSS gf180mcu_as_sc_mcu7t3v3__fillcap_8
XPHY_EDGE_ROW_54_1_Left_264 VDD VSS gf180mcu_as_sc_mcu7t3v3__tap_2
XFILLER_202_661 VDD VDD VSS VSS gf180mcu_as_sc_mcu7t3v3__fillcap_4
X_3710_ VDD VDD VSS VSS _3714_/B _3710_/C _3758_/B _4086_/A gf180mcu_as_sc_mcu7t3v3__aoi21_2
XFILLER_186_373 VDD VDD VSS VSS gf180mcu_as_sc_mcu7t3v3__fillcap_4
XFILLER_187_874 VDD VDD VSS VSS gf180mcu_as_sc_mcu7t3v3__fillcap_16
XFILLER_202_683 VDD VDD VSS VSS gf180mcu_as_sc_mcu7t3v3__fillcap_16
X_4690_ VDD VDD VSS VSS _5250_/D _5250_/Q _4691_/D _4690_/C gf180mcu_as_sc_mcu7t3v3__ao21_2
XFILLER_174_546 VDD VDD VSS VSS gf180mcu_as_sc_mcu7t3v3__fill_2
X_3641_ VDD VDD VSS VSS _3642_/C _4013_/A _3725_/B _3641_/C gf180mcu_as_sc_mcu7t3v3__ao21_2
X_3572_ VDD VDD VSS VSS _3934_/A _3660_/B _3652_/D _3573_/C _3572_/D gf180mcu_as_sc_mcu7t3v3__aoi211_2
XFILLER_31_1399 VDD VDD VSS VSS gf180mcu_as_sc_mcu7t3v3__fill_1
X_2523_ VDD VDD VSS VSS _4637_/A _5227_/Q _2842_/D gf180mcu_as_sc_mcu7t3v3__or2_2
XFILLER_118_1519 VDD VDD VSS VSS gf180mcu_as_sc_mcu7t3v3__fill_2
XFILLER_157_1568 VDD VDD VSS VSS gf180mcu_as_sc_mcu7t3v3__fill_1
XFILLER_192_1415 VDD VDD VSS VSS gf180mcu_as_sc_mcu7t3v3__fillcap_16
XFILLER_192_1437 VDD VDD VSS VSS gf180mcu_as_sc_mcu7t3v3__fillcap_4
XFILLER_29_1240 VDD VDD VSS VSS gf180mcu_as_sc_mcu7t3v3__fillcap_16
X_5242_ VDD VDD VSS VSS clkload6/A _5242_/D _5242_/Q gf180mcu_as_sc_mcu7t3v3__dfxtp_2
X_2454_ VDD VDD VSS VSS _4586_/S _5091_/Q _5004_/Q _2455_/A gf180mcu_as_sc_mcu7t3v3__mux2_2
XTAP_TAPCELL_ROW_19_1149 VDD VSS gf180mcu_as_sc_mcu7t3v3__tap_2
XTAP_TAPCELL_ROW_19_1138 VDD VSS gf180mcu_as_sc_mcu7t3v3__tap_2
XFILLER_29_1262 VDD VDD VSS VSS gf180mcu_as_sc_mcu7t3v3__fillcap_4
X_5173_ VDD VDD VSS VSS clkload7/A _5173_/D _5173_/Q gf180mcu_as_sc_mcu7t3v3__dfxtp_2
XFILLER_29_608 VDD VDD VSS VSS gf180mcu_as_sc_mcu7t3v3__fillcap_16
X_4124_ VDD VDD VSS VSS _4124_/A _4141_/B _4124_/C _4252_/B _4124_/D gf180mcu_as_sc_mcu7t3v3__aoi211_2
XFILLER_28_107 VDD VDD VSS VSS gf180mcu_as_sc_mcu7t3v3__fillcap_8
XFILLER_7_1080 VDD VDD VSS VSS gf180mcu_as_sc_mcu7t3v3__fill_2
Xinput1 VDD VDD VSS VSS boot_addr[0] input1/Y gf180mcu_as_sc_mcu7t3v3__buff_12
XTAP_TAPCELL_ROW_182_2172 VDD VSS gf180mcu_as_sc_mcu7t3v3__tap_2
XTAP_TAPCELL_ROW_146_3_3160 VDD VSS gf180mcu_as_sc_mcu7t3v3__tap_2
X_4055_ VDD VDD VSS VSS _4055_/A _4103_/B _4055_/C _4055_/D _4057_/C gf180mcu_as_sc_mcu7t3v3__ao211_2
XTAP_TAPCELL_ROW_182_2183 VDD VSS gf180mcu_as_sc_mcu7t3v3__tap_2
XFILLER_209_282 VDD VDD VSS VSS gf180mcu_as_sc_mcu7t3v3__fillcap_16
XFILLER_25_814 VDD VDD VSS VSS gf180mcu_as_sc_mcu7t3v3__fillcap_8
X_3006_ VDD VDD VSS VSS _3616_/A _3057_/B _3006_/C _3006_/Y _3615_/D gf180mcu_as_sc_mcu7t3v3__aoi211_2
XFILLER_25_869 VDD VDD VSS VSS gf180mcu_as_sc_mcu7t3v3__fill_2
XFILLER_77_1558 VDD VDD VSS VSS gf180mcu_as_sc_mcu7t3v3__fillcap_8
XFILLER_101_47 VDD VDD VSS VSS gf180mcu_as_sc_mcu7t3v3__fill_2
XFILLER_164_1539 VDD VDD VSS VSS gf180mcu_as_sc_mcu7t3v3__fill_2
XFILLER_101_69 VDD VDD VSS VSS gf180mcu_as_sc_mcu7t3v3__fill_1
XFILLER_205_1536 VDD VDD VSS VSS gf180mcu_as_sc_mcu7t3v3__fillcap_4
X_4957_ VDD VDD VSS VSS _5285_/CLK _4957_/D _4957_/Q gf180mcu_as_sc_mcu7t3v3__dfxtp_2
XFILLER_178_874 VDD VDD VSS VSS gf180mcu_as_sc_mcu7t3v3__fill_1
XFILLER_205_1558 VDD VDD VSS VSS gf180mcu_as_sc_mcu7t3v3__fillcap_8
X_4888_ VDD VDD VSS VSS _4904_/CLK _4888_/D _4888_/Q gf180mcu_as_sc_mcu7t3v3__dfxtp_2
X_3908_ VDD VDD VSS VSS _3908_/B _5161_/Q _4977_/D gf180mcu_as_sc_mcu7t3v3__and2_2
XFILLER_197_1326 VDD VDD VSS VSS gf180mcu_as_sc_mcu7t3v3__fillcap_4
XFILLER_20_552 VDD VDD VSS VSS gf180mcu_as_sc_mcu7t3v3__fillcap_16
X_3839_ VDD VDD VSS VSS _3839_/B _3839_/A _4911_/D gf180mcu_as_sc_mcu7t3v3__and2_2
XFILLER_197_1348 VDD VDD VSS VSS gf180mcu_as_sc_mcu7t3v3__fillcap_16
XTAP_TAPCELL_ROW_189_2326 VDD VSS gf180mcu_as_sc_mcu7t3v3__tap_2
XTAP_TAPCELL_ROW_189_2337 VDD VSS gf180mcu_as_sc_mcu7t3v3__tap_2
Xoutput371 VDD VDD VSS VSS _4791_/Q se_out[20] gf180mcu_as_sc_mcu7t3v3__buff_12
Xoutput360 VDD VDD VSS VSS _4781_/Q se_out[10] gf180mcu_as_sc_mcu7t3v3__buff_12
XFILLER_86_37 VDD VDD VSS VSS gf180mcu_as_sc_mcu7t3v3__fillcap_4
Xoutput393 VDD VDD VSS VSS _4805_/Q south_out[0] gf180mcu_as_sc_mcu7t3v3__buff_12
Xoutput382 VDD VDD VSS VSS _4801_/Q se_out[30] gf180mcu_as_sc_mcu7t3v3__buff_12
XFILLER_134_1387 VDD VDD VSS VSS gf180mcu_as_sc_mcu7t3v3__fill_1
XFILLER_207_208 VDD VDD VSS VSS gf180mcu_as_sc_mcu7t3v3__fill_2
XFILLER_16_803 VDD VDD VSS VSS gf180mcu_as_sc_mcu7t3v3__fill_2
XFILLER_210_1275 VDD VDD VSS VSS gf180mcu_as_sc_mcu7t3v3__fillcap_4
XTAP_TAPCELL_ROW_3_795 VDD VSS gf180mcu_as_sc_mcu7t3v3__tap_2
XPHY_EDGE_ROW_76_3_Left_461 VDD VSS gf180mcu_as_sc_mcu7t3v3__tap_2
XFILLER_15_368 VDD VDD VSS VSS gf180mcu_as_sc_mcu7t3v3__fillcap_4
XFILLER_187_104 VDD VDD VSS VSS gf180mcu_as_sc_mcu7t3v3__fillcap_16
XFILLER_42_143 VDD VDD VSS VSS gf180mcu_as_sc_mcu7t3v3__fill_2
X_4893__1074 VDD VDD VSS VSS _4893_/D gf180mcu_as_sc_mcu7t3v3__tiel_4
XFILLER_145_1461 VDD VDD VSS VSS gf180mcu_as_sc_mcu7t3v3__fillcap_16
XFILLER_19_1442 VDD VDD VSS VSS gf180mcu_as_sc_mcu7t3v3__fill_1
XPHY_EDGE_ROW_136_3_Right_173 VDD VSS gf180mcu_as_sc_mcu7t3v3__tap_2
XFILLER_180_1363 VDD VDD VSS VSS gf180mcu_as_sc_mcu7t3v3__fill_2
XFILLER_30_349 VDD VDD VSS VSS gf180mcu_as_sc_mcu7t3v3__fill_2
XTAP_TAPCELL_ROW_159_1_1921 VDD VSS gf180mcu_as_sc_mcu7t3v3__tap_2
XFILLER_11_574 VDD VDD VSS VSS gf180mcu_as_sc_mcu7t3v3__fill_1
XFILLER_89_1418 VDD VDD VSS VSS gf180mcu_as_sc_mcu7t3v3__fillcap_16
XFILLER_13_1052 VDD VDD VSS VSS gf180mcu_as_sc_mcu7t3v3__fillcap_16
XFILLER_183_343 VDD VDD VSS VSS gf180mcu_as_sc_mcu7t3v3__fillcap_4
XFILLER_184_877 VDD VDD VSS VSS gf180mcu_as_sc_mcu7t3v3__fillcap_16
Xwire476 VDD VDD VSS VSS _3032_/Y _4780_/D gf180mcu_as_sc_mcu7t3v3__clkbuff_12
Xwire465 VDD VDD VSS VSS _3661_/Y _4851_/D gf180mcu_as_sc_mcu7t3v3__clkbuff_12
Xwire498 VDD VDD VSS VSS _3057_/Y wire498/Y gf180mcu_as_sc_mcu7t3v3__clkbuff_12
XTAP_TAPCELL_ROW_139_1_1863 VDD VSS gf180mcu_as_sc_mcu7t3v3__tap_2
XFILLER_117_1530 VDD VDD VSS VSS gf180mcu_as_sc_mcu7t3v3__fill_1
XFILLER_183_72 VDD VDD VSS VSS gf180mcu_as_sc_mcu7t3v3__fillcap_16
XFILLER_26_1424 VDD VDD VSS VSS gf180mcu_as_sc_mcu7t3v3__fillcap_8
XFILLER_111_137 VDD VDD VSS VSS gf180mcu_as_sc_mcu7t3v3__fill_2
XFILLER_65_1484 VDD VDD VSS VSS gf180mcu_as_sc_mcu7t3v3__fill_2
XFILLER_6_1507 VDD VDD VSS VSS gf180mcu_as_sc_mcu7t3v3__fillcap_4
XTAP_TAPCELL_ROW_14_1035 VDD VSS gf180mcu_as_sc_mcu7t3v3__tap_2
XTAP_TAPCELL_ROW_14_1046 VDD VSS gf180mcu_as_sc_mcu7t3v3__tap_2
XFILLER_0_1117 VDD VDD VSS VSS gf180mcu_as_sc_mcu7t3v3__fillcap_4
XFILLER_19_685 VDD VDD VSS VSS gf180mcu_as_sc_mcu7t3v3__fillcap_8
XFILLER_206_241 VDD VDD VSS VSS gf180mcu_as_sc_mcu7t3v3__fillcap_4
XFILLER_206_263 VDD VDD VSS VSS gf180mcu_as_sc_mcu7t3v3__fillcap_16
XFILLER_4_1297 VDD VDD VSS VSS gf180mcu_as_sc_mcu7t3v3__fillcap_4
XFILLER_181_1116 VDD VDD VSS VSS gf180mcu_as_sc_mcu7t3v3__fillcap_4
X_4811_ VDD VDD VSS VSS _5068_/CLK _4811_/D _4811_/Q gf180mcu_as_sc_mcu7t3v3__dfxtp_2
XFILLER_124_1501 VDD VDD VSS VSS gf180mcu_as_sc_mcu7t3v3__fillcap_16
XFILLER_181_1138 VDD VDD VSS VSS gf180mcu_as_sc_mcu7t3v3__fillcap_16
XFILLER_21_305 VDD VDD VSS VSS gf180mcu_as_sc_mcu7t3v3__fillcap_16
XFILLER_22_839 VDD VDD VSS VSS gf180mcu_as_sc_mcu7t3v3__fillcap_16
XFILLER_34_688 VDD VDD VSS VSS gf180mcu_as_sc_mcu7t3v3__fillcap_8
XFILLER_37_1553 VDD VDD VSS VSS gf180mcu_as_sc_mcu7t3v3__fill_2
XFILLER_72_1433 VDD VDD VSS VSS gf180mcu_as_sc_mcu7t3v3__fillcap_4
XFILLER_92_91 VDD VDD VSS VSS gf180mcu_as_sc_mcu7t3v3__fill_2
XFILLER_124_1523 VDD VDD VSS VSS gf180mcu_as_sc_mcu7t3v3__fillcap_16
XFILLER_21_349 VDD VDD VSS VSS gf180mcu_as_sc_mcu7t3v3__fill_1
X_4742_ VDD VDD VSS VSS _5272_/D _4742_/C _4742_/B _4742_/A gf180mcu_as_sc_mcu7t3v3__aoi21b_2
XFILLER_186_181 VDD VDD VSS VSS gf180mcu_as_sc_mcu7t3v3__fill_2
X_4673_ VDD VDD VSS VSS _5114_/Q _4731_/B _4681_/C _5245_/Q _4674_/C gf180mcu_as_sc_mcu7t3v3__ao22_2
XFILLER_30_894 VDD VDD VSS VSS gf180mcu_as_sc_mcu7t3v3__fill_2
XFILLER_31_1130 VDD VDD VSS VSS gf180mcu_as_sc_mcu7t3v3__fill_2
X_3624_ VDD VDD VSS VSS _3624_/B _3624_/A _4846_/D gf180mcu_as_sc_mcu7t3v3__and2_2
XFILLER_174_376 VDD VDD VSS VSS gf180mcu_as_sc_mcu7t3v3__fillcap_8
XFILLER_31_1185 VDD VDD VSS VSS gf180mcu_as_sc_mcu7t3v3__fillcap_4
Xmax_cap754 VDD VDD VSS VSS _3075_/S _3008_/S gf180mcu_as_sc_mcu7t3v3__clkbuff_12
X_3555_ VDD VDD VSS VSS _3559_/C _3561_/B _3561_/A gf180mcu_as_sc_mcu7t3v3__nand2b_2
X_3486_ VDD VDD VSS VSS _4941_/Q _3486_/B _3501_/B _4144_/A _3487_/D gf180mcu_as_sc_mcu7t3v3__ao22_2
X_2506_ VDD VDD VSS VSS _4736_/B _5270_/Q _4739_/B gf180mcu_as_sc_mcu7t3v3__and2_2
XFILLER_44_1502 VDD VDD VSS VSS gf180mcu_as_sc_mcu7t3v3__fill_1
X_5225_ VDD VDD VSS VSS _5280_/CLK _5225_/D _5225_/Q gf180mcu_as_sc_mcu7t3v3__dfxtp_2
X_2437_ VDD VDD VSS VSS _3684_/A _4058_/A gf180mcu_as_sc_mcu7t3v3__inv_2
XTAP_TAPCELL_ROW_184_2223 VDD VSS gf180mcu_as_sc_mcu7t3v3__tap_2
XTAP_TAPCELL_ROW_184_2212 VDD VSS gf180mcu_as_sc_mcu7t3v3__tap_2
XFILLER_29_416 VDD VDD VSS VSS gf180mcu_as_sc_mcu7t3v3__fillcap_4
XFILLER_44_1568 VDD VDD VSS VSS gf180mcu_as_sc_mcu7t3v3__fill_1
XFILLER_9_1175 VDD VDD VSS VSS gf180mcu_as_sc_mcu7t3v3__fill_1
X_5156_ VDD VDD VSS VSS _5278_/CLK _5156_/D _5156_/Q gf180mcu_as_sc_mcu7t3v3__dfxtp_2
XFILLER_29_438 VDD VDD VSS VSS gf180mcu_as_sc_mcu7t3v3__fillcap_16
X_5087_ VDD VDD VSS VSS clkload1/A _5087_/D _5087_/Q gf180mcu_as_sc_mcu7t3v3__dfxtp_2
X_4107_ VDD VDD VSS VSS _4107_/B _4107_/A _4250_/B gf180mcu_as_sc_mcu7t3v3__and2_2
XFILLER_71_205 VDD VDD VSS VSS gf180mcu_as_sc_mcu7t3v3__fillcap_4
XTAP_TAPCELL_ROW_0_710 VDD VSS gf180mcu_as_sc_mcu7t3v3__tap_2
XTAP_TAPCELL_ROW_0_721 VDD VSS gf180mcu_as_sc_mcu7t3v3__tap_2
X_4038_ VDD VDD VSS VSS _4038_/A _4119_/B _4115_/B _4038_/D _4042_/A gf180mcu_as_sc_mcu7t3v3__ao211_2
XFILLER_186_1049 VDD VDD VSS VSS gf180mcu_as_sc_mcu7t3v3__fillcap_16
XFILLER_25_644 VDD VDD VSS VSS gf180mcu_as_sc_mcu7t3v3__fill_1
XTAP_TAPCELL_ROW_0_732 VDD VSS gf180mcu_as_sc_mcu7t3v3__tap_2
XFILLER_129_1445 VDD VDD VSS VSS gf180mcu_as_sc_mcu7t3v3__fillcap_8
XFILLER_198_925 VDD VDD VSS VSS gf180mcu_as_sc_mcu7t3v3__fillcap_16
XFILLER_198_947 VDD VDD VSS VSS gf180mcu_as_sc_mcu7t3v3__fillcap_16
XFILLER_169_126 VDD VDD VSS VSS gf180mcu_as_sc_mcu7t3v3__fillcap_8
XFILLER_25_699 VDD VDD VSS VSS gf180mcu_as_sc_mcu7t3v3__fill_1
XFILLER_178_671 VDD VDD VSS VSS gf180mcu_as_sc_mcu7t3v3__fill_1
XFILLER_184_107 VDD VDD VSS VSS gf180mcu_as_sc_mcu7t3v3__fillcap_16
XFILLER_200_406 VDD VDD VSS VSS gf180mcu_as_sc_mcu7t3v3__fillcap_16
XFILLER_184_129 VDD VDD VSS VSS gf180mcu_as_sc_mcu7t3v3__fill_1
XFILLER_201_1208 VDD VDD VSS VSS gf180mcu_as_sc_mcu7t3v3__fillcap_16
XFILLER_36_1085 VDD VDD VSS VSS gf180mcu_as_sc_mcu7t3v3__fill_2
XFILLER_14_1350 VDD VDD VSS VSS gf180mcu_as_sc_mcu7t3v3__fillcap_8
XFILLER_177_192 VDD VDD VSS VSS gf180mcu_as_sc_mcu7t3v3__fill_2
XTAP_TAPCELL_ROW_60_3_2902 VDD VSS gf180mcu_as_sc_mcu7t3v3__tap_2
XFILLER_10_1203 VDD VDD VSS VSS gf180mcu_as_sc_mcu7t3v3__fill_2
XFILLER_193_696 VDD VDD VSS VSS gf180mcu_as_sc_mcu7t3v3__fillcap_4
XFILLER_137_43 VDD VDD VSS VSS gf180mcu_as_sc_mcu7t3v3__fillcap_16
XFILLER_49_1413 VDD VDD VSS VSS gf180mcu_as_sc_mcu7t3v3__fill_2
XFILLER_97_69 VDD VDD VSS VSS gf180mcu_as_sc_mcu7t3v3__fill_1
Xdelaybuf_2_clk VDD VDD VSS VSS delaybuf_2_clk/A clkbuf_0_clk/A gf180mcu_as_sc_mcu7t3v3__clkbuff_12
XFILLER_0_754 VDD VDD VSS VSS gf180mcu_as_sc_mcu7t3v3__fill_2
XTAP_TAPCELL_ROW_8_898 VDD VSS gf180mcu_as_sc_mcu7t3v3__tap_2
XTAP_TAPCELL_ROW_39_3_2838 VDD VSS gf180mcu_as_sc_mcu7t3v3__tap_2
XFILLER_21_1332 VDD VDD VSS VSS gf180mcu_as_sc_mcu7t3v3__fillcap_16
XFILLER_35_419 VDD VDD VSS VSS gf180mcu_as_sc_mcu7t3v3__fill_1
XFILLER_112_1482 VDD VDD VSS VSS gf180mcu_as_sc_mcu7t3v3__fill_2
XFILLER_21_1398 VDD VDD VSS VSS gf180mcu_as_sc_mcu7t3v3__fill_2
XFILLER_56_1428 VDD VDD VSS VSS gf180mcu_as_sc_mcu7t3v3__fill_2
XFILLER_16_699 VDD VDD VSS VSS gf180mcu_as_sc_mcu7t3v3__fillcap_8
XFILLER_188_457 VDD VDD VSS VSS gf180mcu_as_sc_mcu7t3v3__fillcap_16
XFILLER_203_244 VDD VDD VSS VSS gf180mcu_as_sc_mcu7t3v3__fillcap_16
XFILLER_206_1119 VDD VDD VSS VSS gf180mcu_as_sc_mcu7t3v3__fillcap_16
XFILLER_30_102 VDD VDD VSS VSS gf180mcu_as_sc_mcu7t3v3__fill_2
XFILLER_31_636 VDD VDD VSS VSS gf180mcu_as_sc_mcu7t3v3__fill_1
XFILLER_95_1488 VDD VDD VSS VSS gf180mcu_as_sc_mcu7t3v3__fill_2
XFILLER_19_1250 VDD VDD VSS VSS gf180mcu_as_sc_mcu7t3v3__fill_1
XFILLER_62_61 VDD VDD VSS VSS gf180mcu_as_sc_mcu7t3v3__fill_2
XTAP_TAPCELL_ROW_84_1_1697 VDD VSS gf180mcu_as_sc_mcu7t3v3__tap_2
XFILLER_12_872 VDD VDD VSS VSS gf180mcu_as_sc_mcu7t3v3__fill_2
XFILLER_19_1294 VDD VDD VSS VSS gf180mcu_as_sc_mcu7t3v3__fillcap_16
XPHY_EDGE_ROW_137_3_Right_174 VDD VSS gf180mcu_as_sc_mcu7t3v3__tap_2
XFILLER_200_995 VDD VDD VSS VSS gf180mcu_as_sc_mcu7t3v3__fillcap_16
XFILLER_7_34 VDD VDD VSS VSS gf180mcu_as_sc_mcu7t3v3__fillcap_16
XFILLER_183_162 VDD VDD VSS VSS gf180mcu_as_sc_mcu7t3v3__fill_2
XFILLER_32_1461 VDD VDD VSS VSS gf180mcu_as_sc_mcu7t3v3__fill_2
XFILLER_7_364 VDD VDD VSS VSS gf180mcu_as_sc_mcu7t3v3__fillcap_16
XFILLER_193_1521 VDD VDD VSS VSS gf180mcu_as_sc_mcu7t3v3__fillcap_16
X_3340_ VDD VDD VSS VSS _3381_/S _3992_/D _3340_/A _3342_/A gf180mcu_as_sc_mcu7t3v3__mux2_2
XFILLER_154_1516 VDD VDD VSS VSS gf180mcu_as_sc_mcu7t3v3__fillcap_4
XFILLER_67_1568 VDD VDD VSS VSS gf180mcu_as_sc_mcu7t3v3__fill_1
XFILLER_97_146 VDD VDD VSS VSS gf180mcu_as_sc_mcu7t3v3__fill_2
X_5010_ VDD VDD VSS VSS _5068_/CLK _5010_/D _5010_/Q gf180mcu_as_sc_mcu7t3v3__dfxtp_2
X_3271_ VDD VDD VSS VSS _3271_/B _3271_/A _3271_/Y gf180mcu_as_sc_mcu7t3v3__or2_2
XFILLER_6_1315 VDD VDD VSS VSS gf180mcu_as_sc_mcu7t3v3__fill_1
XTAP_TAPCELL_ROW_33_1455 VDD VSS gf180mcu_as_sc_mcu7t3v3__tap_2
XTAP_TAPCELL_ROW_55_1_1611 VDD VSS gf180mcu_as_sc_mcu7t3v3__tap_2
XTAP_TAPCELL_ROW_33_1466 VDD VSS gf180mcu_as_sc_mcu7t3v3__tap_2
XFILLER_207_594 VDD VDD VSS VSS gf180mcu_as_sc_mcu7t3v3__fillcap_16
XFILLER_34_452 VDD VDD VSS VSS gf180mcu_as_sc_mcu7t3v3__fill_2
XFILLER_35_953 VDD VDD VSS VSS gf180mcu_as_sc_mcu7t3v3__fillcap_16
XTAP_TAPCELL_ROW_65_3_2917 VDD VSS gf180mcu_as_sc_mcu7t3v3__tap_2
XFILLER_195_906 VDD VDD VSS VSS gf180mcu_as_sc_mcu7t3v3__fillcap_4
XFILLER_22_614 VDD VDD VSS VSS gf180mcu_as_sc_mcu7t3v3__fillcap_16
XFILLER_195_928 VDD VDD VSS VSS gf180mcu_as_sc_mcu7t3v3__fillcap_16
XTAP_TAPCELL_ROW_177_2071 VDD VSS gf180mcu_as_sc_mcu7t3v3__tap_2
XTAP_TAPCELL_ROW_177_2060 VDD VSS gf180mcu_as_sc_mcu7t3v3__tap_2
XFILLER_194_438 VDD VDD VSS VSS gf180mcu_as_sc_mcu7t3v3__fillcap_4
XFILLER_210_759 VDD VDD VSS VSS gf180mcu_as_sc_mcu7t3v3__fill_2
XFILLER_37_1372 VDD VDD VSS VSS gf180mcu_as_sc_mcu7t3v3__fillcap_4
X_2986_ VDD VDD VSS VSS _3045_/A _2986_/B _2986_/C _3045_/D _2987_/D gf180mcu_as_sc_mcu7t3v3__ao211_2
XFILLER_124_1364 VDD VDD VSS VSS gf180mcu_as_sc_mcu7t3v3__fillcap_16
XFILLER_202_1539 VDD VDD VSS VSS gf180mcu_as_sc_mcu7t3v3__fillcap_4
XFILLER_33_1258 VDD VDD VSS VSS gf180mcu_as_sc_mcu7t3v3__fill_2
X_4725_ VDD VDD VSS VSS _5263_/D _5108_/Q _4725_/B _4725_/C gf180mcu_as_sc_mcu7t3v3__ao21_2
XFILLER_11_1501 VDD VDD VSS VSS gf180mcu_as_sc_mcu7t3v3__fillcap_8
X_4656_ VDD VDD VSS VSS _4659_/B _4656_/B _5238_/Q _5238_/D gf180mcu_as_sc_mcu7t3v3__mux2_2
XFILLER_194_1329 VDD VDD VSS VSS gf180mcu_as_sc_mcu7t3v3__fillcap_16
Xinput70 VDD VDD VSS VSS east_in[33] wire837/A gf180mcu_as_sc_mcu7t3v3__buff_12
Xinput81 VDD VDD VSS VSS ne_in[12] wire831/A gf180mcu_as_sc_mcu7t3v3__buff_12
X_4587_ VDD VDD VSS VSS _4588_/D _4587_/B _4588_/A gf180mcu_as_sc_mcu7t3v3__nor2_2
X_3607_ VDD VDD VSS VSS _3977_/A _3660_/B _3608_/B _3608_/C _3607_/D gf180mcu_as_sc_mcu7t3v3__aoi211_2
Xinput92 VDD VDD VSS VSS ne_in[22] _4109_/A gf180mcu_as_sc_mcu7t3v3__buff_12
X_3538_ VDD VDD VSS VSS _3539_/B _4944_/Q _4945_/Q gf180mcu_as_sc_mcu7t3v3__nor2_2
XFILLER_190_699 VDD VDD VSS VSS gf180mcu_as_sc_mcu7t3v3__fillcap_16
XFILLER_130_221 VDD VDD VSS VSS gf180mcu_as_sc_mcu7t3v3__fill_1
X_3469_ VDD VDD VSS VSS _4122_/A _3522_/C _3469_/C _3470_/C _3476_/D gf180mcu_as_sc_mcu7t3v3__aoi211_2
X_5208_ VDD VDD VSS VSS _5214_/CLK _5208_/D _5208_/Q gf180mcu_as_sc_mcu7t3v3__dfxtp_2
XTAP_TAPCELL_ROW_5_846 VDD VSS gf180mcu_as_sc_mcu7t3v3__tap_2
XTAP_TAPCELL_ROW_5_835 VDD VSS gf180mcu_as_sc_mcu7t3v3__tap_2
XPHY_EDGE_ROW_131_1_Left_341 VDD VSS gf180mcu_as_sc_mcu7t3v3__tap_2
XTAP_TAPCELL_ROW_102_1_1750 VDD VSS gf180mcu_as_sc_mcu7t3v3__tap_2
X_5139_ VDD VDD VSS VSS _5142_/CLK _5139_/D _5139_/Q gf180mcu_as_sc_mcu7t3v3__dfxtp_2
XTAP_TAPCELL_ROW_209_2771 VDD VSS gf180mcu_as_sc_mcu7t3v3__tap_2
XTAP_TAPCELL_ROW_209_2760 VDD VSS gf180mcu_as_sc_mcu7t3v3__tap_2
XFILLER_17_419 VDD VDD VSS VSS gf180mcu_as_sc_mcu7t3v3__fill_1
XFILLER_29_257 VDD VDD VSS VSS gf180mcu_as_sc_mcu7t3v3__fill_1
XFILLER_29_279 VDD VDD VSS VSS gf180mcu_as_sc_mcu7t3v3__fill_1
XTAP_TAPCELL_ROW_114_3_3062 VDD VSS gf180mcu_as_sc_mcu7t3v3__tap_2
XFILLER_177_6 VDD VDD VSS VSS gf180mcu_as_sc_mcu7t3v3__fillcap_16
XFILLER_83_27 VDD VDD VSS VSS gf180mcu_as_sc_mcu7t3v3__fillcap_4
XTAP_TAPCELL_ROW_205_2679 VDD VSS gf180mcu_as_sc_mcu7t3v3__tap_2
XFILLER_199_38 VDD VDD VSS VSS gf180mcu_as_sc_mcu7t3v3__fillcap_16
XFILLER_25_430 VDD VDD VSS VSS gf180mcu_as_sc_mcu7t3v3__fillcap_4
XFILLER_181_1480 VDD VDD VSS VSS gf180mcu_as_sc_mcu7t3v3__fillcap_4
XFILLER_185_416 VDD VDD VSS VSS gf180mcu_as_sc_mcu7t3v3__fillcap_4
XFILLER_185_438 VDD VDD VSS VSS gf180mcu_as_sc_mcu7t3v3__fill_2
XFILLER_197_276 VDD VDD VSS VSS gf180mcu_as_sc_mcu7t3v3__fillcap_4
XFILLER_200_225 VDD VDD VSS VSS gf180mcu_as_sc_mcu7t3v3__fillcap_16
XFILLER_200_247 VDD VDD VSS VSS gf180mcu_as_sc_mcu7t3v3__fillcap_16
XFILLER_55_1472 VDD VDD VSS VSS gf180mcu_as_sc_mcu7t3v3__fillcap_8
XFILLER_9_618 VDD VDD VSS VSS gf180mcu_as_sc_mcu7t3v3__fillcap_8
XFILLER_142_1453 VDD VDD VSS VSS gf180mcu_as_sc_mcu7t3v3__fillcap_16
XFILLER_21_691 VDD VDD VSS VSS gf180mcu_as_sc_mcu7t3v3__fillcap_8
XFILLER_32_53 VDD VDD VSS VSS gf180mcu_as_sc_mcu7t3v3__fillcap_16
XFILLER_8_139 VDD VDD VSS VSS gf180mcu_as_sc_mcu7t3v3__fill_2
XFILLER_148_53 VDD VDD VSS VSS gf180mcu_as_sc_mcu7t3v3__fillcap_8
XFILLER_10_1033 VDD VDD VSS VSS gf180mcu_as_sc_mcu7t3v3__fillcap_4
XFILLER_175_1240 VDD VDD VSS VSS gf180mcu_as_sc_mcu7t3v3__fillcap_16
XFILLER_175_1262 VDD VDD VSS VSS gf180mcu_as_sc_mcu7t3v3__fillcap_4
XFILLER_164_74 VDD VDD VSS VSS gf180mcu_as_sc_mcu7t3v3__fillcap_16
XPHY_EDGE_ROW_63_1_Left_273 VDD VSS gf180mcu_as_sc_mcu7t3v3__tap_2
XFILLER_0_584 VDD VDD VSS VSS gf180mcu_as_sc_mcu7t3v3__fill_2
XFILLER_209_826 VDD VDD VSS VSS gf180mcu_as_sc_mcu7t3v3__fillcap_8
XFILLER_114_1566 VDD VDD VSS VSS gf180mcu_as_sc_mcu7t3v3__fill_2
XFILLER_57_83 VDD VDD VSS VSS gf180mcu_as_sc_mcu7t3v3__fillcap_16
XFILLER_17_931 VDD VDD VSS VSS gf180mcu_as_sc_mcu7t3v3__fillcap_16
XFILLER_35_205 VDD VDD VSS VSS gf180mcu_as_sc_mcu7t3v3__fillcap_4
XFILLER_35_238 VDD VDD VSS VSS gf180mcu_as_sc_mcu7t3v3__fillcap_16
XPHY_EDGE_ROW_11_Left_222 VDD VSS gf180mcu_as_sc_mcu7t3v3__tap_2
XFILLER_17_986 VDD VDD VSS VSS gf180mcu_as_sc_mcu7t3v3__fill_1
XFILLER_31_400 VDD VDD VSS VSS gf180mcu_as_sc_mcu7t3v3__fillcap_4
XFILLER_108_1348 VDD VDD VSS VSS gf180mcu_as_sc_mcu7t3v3__fillcap_16
XFILLER_147_1386 VDD VDD VSS VSS gf180mcu_as_sc_mcu7t3v3__fill_1
XFILLER_177_928 VDD VDD VSS VSS gf180mcu_as_sc_mcu7t3v3__fillcap_16
XFILLER_189_766 VDD VDD VSS VSS gf180mcu_as_sc_mcu7t3v3__fillcap_4
XFILLER_189_788 VDD VDD VSS VSS gf180mcu_as_sc_mcu7t3v3__fillcap_16
XFILLER_204_575 VDD VDD VSS VSS gf180mcu_as_sc_mcu7t3v3__fillcap_16
XFILLER_204_597 VDD VDD VSS VSS gf180mcu_as_sc_mcu7t3v3__fillcap_16
XFILLER_31_422 VDD VDD VSS VSS gf180mcu_as_sc_mcu7t3v3__fillcap_8
X_2840_ VDD VDD VSS VSS _2840_/A _2840_/B _2840_/C _2840_/D _2841_/B gf180mcu_as_sc_mcu7t3v3__nand4_2
XFILLER_148_107 VDD VDD VSS VSS gf180mcu_as_sc_mcu7t3v3__fillcap_16
XFILLER_176_416 VDD VDD VSS VSS gf180mcu_as_sc_mcu7t3v3__fill_2
XPHY_EDGE_ROW_39_3_Left_424 VDD VSS gf180mcu_as_sc_mcu7t3v3__tap_2
XTAP_TAPCELL_ROW_140_3_3141 VDD VSS gf180mcu_as_sc_mcu7t3v3__tap_2
XFILLER_192_909 VDD VDD VSS VSS gf180mcu_as_sc_mcu7t3v3__fillcap_16
XPHY_EDGE_ROW_138_3_Right_175 VDD VSS gf180mcu_as_sc_mcu7t3v3__tap_2
X_2771_ VDD VDD VSS VSS _2771_/A _2771_/B _2771_/C _2771_/D _2796_/B gf180mcu_as_sc_mcu7t3v3__ao211_2
XTAP_TAPCELL_ROW_26_1292 VDD VSS gf180mcu_as_sc_mcu7t3v3__tap_2
XFILLER_156_162 VDD VDD VSS VSS gf180mcu_as_sc_mcu7t3v3__fillcap_8
XFILLER_8_662 VDD VDD VSS VSS gf180mcu_as_sc_mcu7t3v3__fill_2
X_4510_ VDD VDD VSS VSS _4511_/D _4510_/B _4510_/A gf180mcu_as_sc_mcu7t3v3__nor2_2
XPHY_EDGE_ROW_20_Left_231 VDD VSS gf180mcu_as_sc_mcu7t3v3__tap_2
X_4441_ VDD VDD VSS VSS _4442_/D _4441_/B _4512_/A gf180mcu_as_sc_mcu7t3v3__nor2_2
XFILLER_208_34 VDD VDD VSS VSS gf180mcu_as_sc_mcu7t3v3__fill_1
XPHY_EDGE_ROW_9_Right_9 VDD VSS gf180mcu_as_sc_mcu7t3v3__tap_2
XTAP_TAPCELL_ROW_107_1_1765 VDD VSS gf180mcu_as_sc_mcu7t3v3__tap_2
XFILLER_119_1444 VDD VDD VSS VSS gf180mcu_as_sc_mcu7t3v3__fillcap_16
XFILLER_171_198 VDD VDD VSS VSS gf180mcu_as_sc_mcu7t3v3__fill_2
XTAP_TAPCELL_ROW_119_3_3077 VDD VSS gf180mcu_as_sc_mcu7t3v3__tap_2
X_4372_ VDD VDD VSS VSS _4736_/B _4372_/B _4372_/C _4373_/C _4372_/D gf180mcu_as_sc_mcu7t3v3__aoi31_2
XTAP_TAPCELL_ROW_35_1506 VDD VSS gf180mcu_as_sc_mcu7t3v3__tap_2
XFILLER_119_1466 VDD VDD VSS VSS gf180mcu_as_sc_mcu7t3v3__fill_1
Xfanout619 VDD VDD VSS VSS _4590_/B _4575_/B gf180mcu_as_sc_mcu7t3v3__buff_12
X_3323_ VDD VDD VSS VSS _3973_/A _3404_/B _3323_/C _3323_/D _3324_/A gf180mcu_as_sc_mcu7t3v3__ao22_2
XFILLER_119_1488 VDD VDD VSS VSS gf180mcu_as_sc_mcu7t3v3__fillcap_16
XFILLER_154_1368 VDD VDD VSS VSS gf180mcu_as_sc_mcu7t3v3__fill_1
X_3254_ VDD VDD VSS VSS _3518_/A _3818_/C _3254_/A gf180mcu_as_sc_mcu7t3v3__nand2_2
XFILLER_26_1062 VDD VDD VSS VSS gf180mcu_as_sc_mcu7t3v3__fillcap_4
XFILLER_26_1084 VDD VDD VSS VSS gf180mcu_as_sc_mcu7t3v3__fill_1
XFILLER_41_1516 VDD VDD VSS VSS gf180mcu_as_sc_mcu7t3v3__fill_2
XFILLER_85_127 VDD VDD VSS VSS gf180mcu_as_sc_mcu7t3v3__fill_1
XFILLER_187_1100 VDD VDD VSS VSS gf180mcu_as_sc_mcu7t3v3__fillcap_16
XFILLER_187_1122 VDD VDD VSS VSS gf180mcu_as_sc_mcu7t3v3__fillcap_16
X_3185_ VDD VDD VSS VSS _3185_/D _4160_/D _3236_/B _3222_/D _3186_/D gf180mcu_as_sc_mcu7t3v3__ao31_2
XFILLER_199_508 VDD VDD VSS VSS gf180mcu_as_sc_mcu7t3v3__fillcap_16
XTAP_TAPCELL_ROW_84_3_2972 VDD VSS gf180mcu_as_sc_mcu7t3v3__tap_2
XTAP_TAPCELL_ROW_179_2111 VDD VSS gf180mcu_as_sc_mcu7t3v3__tap_2
XTAP_TAPCELL_ROW_179_2100 VDD VSS gf180mcu_as_sc_mcu7t3v3__tap_2
XFILLER_23_912 VDD VDD VSS VSS gf180mcu_as_sc_mcu7t3v3__fillcap_16
XFILLER_35_772 VDD VDD VSS VSS gf180mcu_as_sc_mcu7t3v3__fillcap_8
XFILLER_39_1434 VDD VDD VSS VSS gf180mcu_as_sc_mcu7t3v3__fillcap_8
XFILLER_39_1456 VDD VDD VSS VSS gf180mcu_as_sc_mcu7t3v3__fillcap_16
XFILLER_41_208 VDD VDD VSS VSS gf180mcu_as_sc_mcu7t3v3__fill_2
XFILLER_179_254 VDD VDD VSS VSS gf180mcu_as_sc_mcu7t3v3__fillcap_8
XTAP_TAPCELL_ROW_200_2576 VDD VSS gf180mcu_as_sc_mcu7t3v3__tap_2
XTAP_TAPCELL_ROW_200_2565 VDD VSS gf180mcu_as_sc_mcu7t3v3__tap_2
XTAP_TAPCELL_ROW_175_2019 VDD VSS gf180mcu_as_sc_mcu7t3v3__tap_2
XTAP_TAPCELL_ROW_196_2491 VDD VSS gf180mcu_as_sc_mcu7t3v3__tap_2
XTAP_TAPCELL_ROW_196_2480 VDD VSS gf180mcu_as_sc_mcu7t3v3__tap_2
XFILLER_194_257 VDD VDD VSS VSS gf180mcu_as_sc_mcu7t3v3__fillcap_16
XFILLER_210_589 VDD VDD VSS VSS gf180mcu_as_sc_mcu7t3v3__fill_2
X_2969_ VDD VDD VSS VSS _3045_/A _2969_/B _2969_/C _3045_/D _2971_/C gf180mcu_as_sc_mcu7t3v3__ao211_2
X_4708_ VDD VDD VSS VSS _4717_/S _4708_/A _4708_/B _4708_/C gf180mcu_as_sc_mcu7t3v3__ao21_2
XTAP_TAPCELL_ROW_192_2399 VDD VSS gf180mcu_as_sc_mcu7t3v3__tap_2
XTAP_TAPCELL_ROW_192_2388 VDD VSS gf180mcu_as_sc_mcu7t3v3__tap_2
XFILLER_118_34 VDD VDD VSS VSS gf180mcu_as_sc_mcu7t3v3__fill_1
XFILLER_137_1500 VDD VDD VSS VSS gf180mcu_as_sc_mcu7t3v3__fill_2
XFILLER_190_452 VDD VDD VSS VSS gf180mcu_as_sc_mcu7t3v3__fill_2
XFILLER_85_1410 VDD VDD VSS VSS gf180mcu_as_sc_mcu7t3v3__fillcap_4
X_4639_ VDD VDD VSS VSS _4640_/S _5105_/Q _5230_/Q _5230_/D gf180mcu_as_sc_mcu7t3v3__mux2_2
XFILLER_78_27 VDD VDD VSS VSS gf180mcu_as_sc_mcu7t3v3__fillcap_8
XPHY_EDGE_ROW_85_3_Left_470 VDD VSS gf180mcu_as_sc_mcu7t3v3__tap_2
XFILLER_137_1566 VDD VDD VSS VSS gf180mcu_as_sc_mcu7t3v3__fill_2
Xmesh_tile_1007 VDD VDD VSS VSS nw_out[14] gf180mcu_as_sc_mcu7t3v3__tiel_4
XTAP_TAPCELL_ROW_207_2719 VDD VSS gf180mcu_as_sc_mcu7t3v3__tap_2
XFILLER_94_37 VDD VDD VSS VSS gf180mcu_as_sc_mcu7t3v3__fillcap_16
Xmesh_tile_1018 VDD VDD VSS VSS nw_out[25] gf180mcu_as_sc_mcu7t3v3__tiel_4
Xmesh_tile_1029 VDD VDD VSS VSS sw_out[2] gf180mcu_as_sc_mcu7t3v3__tiel_4
XFILLER_17_205 VDD VDD VSS VSS gf180mcu_as_sc_mcu7t3v3__fillcap_4
XFILLER_18_728 VDD VDD VSS VSS gf180mcu_as_sc_mcu7t3v3__fillcap_4
XFILLER_206_807 VDD VDD VSS VSS gf180mcu_as_sc_mcu7t3v3__fillcap_16
XFILLER_84_171 VDD VDD VSS VSS gf180mcu_as_sc_mcu7t3v3__fillcap_4
XTAP_TAPCELL_ROW_133_1_1844 VDD VSS gf180mcu_as_sc_mcu7t3v3__tap_2
XTAP_TAPCELL_ROW_145_3_3156 VDD VSS gf180mcu_as_sc_mcu7t3v3__tap_2
XFILLER_168_2 VDD VDD VSS VSS gf180mcu_as_sc_mcu7t3v3__fillcap_16
XFILLER_2_1565 VDD VDD VSS VSS gf180mcu_as_sc_mcu7t3v3__fillcap_4
XFILLER_84_193 VDD VDD VSS VSS gf180mcu_as_sc_mcu7t3v3__fillcap_4
XFILLER_183_1542 VDD VDD VSS VSS gf180mcu_as_sc_mcu7t3v3__fill_2
XFILLER_25_260 VDD VDD VSS VSS gf180mcu_as_sc_mcu7t3v3__fillcap_16
XFILLER_13_422 VDD VDD VSS VSS gf180mcu_as_sc_mcu7t3v3__fillcap_16
XFILLER_14_934 VDD VDD VSS VSS gf180mcu_as_sc_mcu7t3v3__fillcap_4
XFILLER_18_1507 VDD VDD VSS VSS gf180mcu_as_sc_mcu7t3v3__fillcap_8
XFILLER_25_293 VDD VDD VSS VSS gf180mcu_as_sc_mcu7t3v3__fillcap_16
XFILLER_92_1447 VDD VDD VSS VSS gf180mcu_as_sc_mcu7t3v3__fillcap_4
XFILLER_92_1469 VDD VDD VSS VSS gf180mcu_as_sc_mcu7t3v3__fill_1
XFILLER_185_246 VDD VDD VSS VSS gf180mcu_as_sc_mcu7t3v3__fillcap_4
XFILLER_186_769 VDD VDD VSS VSS gf180mcu_as_sc_mcu7t3v3__fillcap_16
XFILLER_201_556 VDD VDD VSS VSS gf180mcu_as_sc_mcu7t3v3__fillcap_4
XFILLER_201_578 VDD VDD VSS VSS gf180mcu_as_sc_mcu7t3v3__fillcap_16
XFILLER_12_1128 VDD VDD VSS VSS gf180mcu_as_sc_mcu7t3v3__fill_1
XFILLER_185_279 VDD VDD VSS VSS gf180mcu_as_sc_mcu7t3v3__fill_1
XFILLER_153_121 VDD VDD VSS VSS gf180mcu_as_sc_mcu7t3v3__fillcap_16
XFILLER_16_1297 VDD VDD VSS VSS gf180mcu_as_sc_mcu7t3v3__fillcap_8
XTAP_TAPCELL_ROW_79_1_1681 VDD VSS gf180mcu_as_sc_mcu7t3v3__tap_2
XFILLER_5_698 VDD VDD VSS VSS gf180mcu_as_sc_mcu7t3v3__fill_2
XFILLER_64_1538 VDD VDD VSS VSS gf180mcu_as_sc_mcu7t3v3__fill_2
XFILLER_190_1568 VDD VDD VSS VSS gf180mcu_as_sc_mcu7t3v3__fill_1
XFILLER_1_871 VDD VDD VSS VSS gf180mcu_as_sc_mcu7t3v3__fill_2
XTAP_TAPCELL_ROW_89_3_2987 VDD VSS gf180mcu_as_sc_mcu7t3v3__tap_2
XFILLER_191_50 VDD VDD VSS VSS gf180mcu_as_sc_mcu7t3v3__fillcap_16
XFILLER_191_72 VDD VDD VSS VSS gf180mcu_as_sc_mcu7t3v3__fillcap_16
Xinput260 VDD VDD VSS VSS sw_in[1] _2424_/A gf180mcu_as_sc_mcu7t3v3__buff_12
Xinput271 VDD VDD VSS VSS sw_in[2] _3302_/A gf180mcu_as_sc_mcu7t3v3__buff_12
XFILLER_188_1453 VDD VDD VSS VSS gf180mcu_as_sc_mcu7t3v3__fillcap_16
XFILLER_3_1329 VDD VDD VSS VSS gf180mcu_as_sc_mcu7t3v3__fill_1
Xinput282 VDD VDD VSS VSS sw_in[9] _4010_/A gf180mcu_as_sc_mcu7t3v3__buff_12
Xinput293 VDD VDD VSS VSS west_in[19] _4085_/D gf180mcu_as_sc_mcu7t3v3__buff_12
XFILLER_208_166 VDD VDD VSS VSS gf180mcu_as_sc_mcu7t3v3__fillcap_8
XFILLER_208_177 VDD VDD VSS VSS gf180mcu_as_sc_mcu7t3v3__fillcap_16
XFILLER_17_772 VDD VDD VSS VSS gf180mcu_as_sc_mcu7t3v3__fillcap_16
XFILLER_90_174 VDD VDD VSS VSS gf180mcu_as_sc_mcu7t3v3__fill_1
X_4990_ VDD VDD VSS VSS clkload2/A _4990_/D _4990_/Q gf180mcu_as_sc_mcu7t3v3__dfxtp_2
X_3941_ VDD VDD VSS VSS _4031_/B _3941_/A _3942_/D gf180mcu_as_sc_mcu7t3v3__and2_2
XTAP_TAPCELL_ROW_28_1354 VDD VSS gf180mcu_as_sc_mcu7t3v3__tap_2
XTAP_TAPCELL_ROW_28_1343 VDD VSS gf180mcu_as_sc_mcu7t3v3__tap_2
XFILLER_177_736 VDD VDD VSS VSS gf180mcu_as_sc_mcu7t3v3__fill_1
X_3872_ VDD VDD VSS VSS _3872_/A _4948_/Q _5127_/Q _3872_/D _3873_/C gf180mcu_as_sc_mcu7t3v3__ao211_2
X_2823_ VDD VDD VSS VSS _5484_/A _2833_/A _2830_/B gf180mcu_as_sc_mcu7t3v3__and2_2
XTAP_TAPCELL_ROW_171_3_3235 VDD VSS gf180mcu_as_sc_mcu7t3v3__tap_2
XFILLER_191_205 VDD VDD VSS VSS gf180mcu_as_sc_mcu7t3v3__fillcap_4
X_2754_ VDD VDD VSS VSS _2754_/D _2833_/A _4975_/D _5478_/A _4627_/A gf180mcu_as_sc_mcu7t3v3__ao31_2
XFILLER_129_195 VDD VDD VSS VSS gf180mcu_as_sc_mcu7t3v3__fillcap_8
XFILLER_195_1402 VDD VDD VSS VSS gf180mcu_as_sc_mcu7t3v3__fillcap_16
XFILLER_30_1239 VDD VDD VSS VSS gf180mcu_as_sc_mcu7t3v3__fillcap_16
XPHY_EDGE_ROW_139_3_Right_176 VDD VSS gf180mcu_as_sc_mcu7t3v3__tap_2
XFILLER_201_1380 VDD VDD VSS VSS gf180mcu_as_sc_mcu7t3v3__fillcap_16
X_2685_ VDD VDD VSS VSS _2686_/D _2737_/A _2736_/B _2685_/A gf180mcu_as_sc_mcu7t3v3__aoi21b_2
X_4424_ VDD VDD VSS VSS _5169_/Q _4592_/B _4424_/C _4424_/D _5169_/D gf180mcu_as_sc_mcu7t3v3__ao211_2
XFILLER_193_1170 VDD VDD VSS VSS gf180mcu_as_sc_mcu7t3v3__fillcap_16
XFILLER_28_1135 VDD VDD VSS VSS gf180mcu_as_sc_mcu7t3v3__fillcap_16
XTAP_TAPCELL_ROW_138_1_1859 VDD VSS gf180mcu_as_sc_mcu7t3v3__tap_2
X_4355_ VDD VDD VSS VSS _4366_/S _5160_/Q _4355_/A _4356_/B gf180mcu_as_sc_mcu7t3v3__mux2_2
XFILLER_193_1192 VDD VDD VSS VSS gf180mcu_as_sc_mcu7t3v3__fillcap_16
XFILLER_28_1157 VDD VDD VSS VSS gf180mcu_as_sc_mcu7t3v3__fillcap_8
X_3306_ VDD VDD VSS VSS _3958_/A _3403_/S _3306_/C _3306_/D _3307_/C gf180mcu_as_sc_mcu7t3v3__ao211_2
XFILLER_45_1460 VDD VDD VSS VSS gf180mcu_as_sc_mcu7t3v3__fillcap_8
X_4286_ VDD VDD VSS VSS _4289_/S _5482_/A _5120_/Q _5120_/D gf180mcu_as_sc_mcu7t3v3__mux2_2
XFILLER_58_149 VDD VDD VSS VSS gf180mcu_as_sc_mcu7t3v3__fill_1
X_3237_ VDD VDD VSS VSS _3238_/B _3237_/C _3237_/B _3520_/A gf180mcu_as_sc_mcu7t3v3__aoi21b_2
XFILLER_104_69 VDD VDD VSS VSS gf180mcu_as_sc_mcu7t3v3__fillcap_16
XFILLER_167_1504 VDD VDD VSS VSS gf180mcu_as_sc_mcu7t3v3__fill_2
X_3168_ VDD VDD VSS VSS _3179_/B _4941_/Q _3171_/C gf180mcu_as_sc_mcu7t3v3__or2_2
XTAP_TAPCELL_ROW_202_2627 VDD VSS gf180mcu_as_sc_mcu7t3v3__tap_2
XTAP_TAPCELL_ROW_202_2616 VDD VSS gf180mcu_as_sc_mcu7t3v3__tap_2
XTAP_TAPCELL_ROW_198_2520 VDD VSS gf180mcu_as_sc_mcu7t3v3__tap_2
XFILLER_199_349 VDD VDD VSS VSS gf180mcu_as_sc_mcu7t3v3__fill_1
XFILLER_208_1501 VDD VDD VSS VSS gf180mcu_as_sc_mcu7t3v3__fillcap_4
X_3099_ VDD VDD VSS VSS _3106_/B _3163_/B _4081_/A gf180mcu_as_sc_mcu7t3v3__nand2_2
XTAP_TAPCELL_ROW_198_2531 VDD VSS gf180mcu_as_sc_mcu7t3v3__tap_2
XFILLER_208_1523 VDD VDD VSS VSS gf180mcu_as_sc_mcu7t3v3__fillcap_16
XFILLER_35_591 VDD VDD VSS VSS gf180mcu_as_sc_mcu7t3v3__fillcap_16
XFILLER_208_1567 VDD VDD VSS VSS gf180mcu_as_sc_mcu7t3v3__fill_2
XTAP_TAPCELL_ROW_194_2439 VDD VSS gf180mcu_as_sc_mcu7t3v3__tap_2
XFILLER_10_403 VDD VDD VSS VSS gf180mcu_as_sc_mcu7t3v3__fillcap_8
XFILLER_210_342 VDD VDD VSS VSS gf180mcu_as_sc_mcu7t3v3__fillcap_4
XFILLER_22_263 VDD VDD VSS VSS gf180mcu_as_sc_mcu7t3v3__fillcap_8
XFILLER_206_1291 VDD VDD VSS VSS gf180mcu_as_sc_mcu7t3v3__fillcap_4
XFILLER_52_1453 VDD VDD VSS VSS gf180mcu_as_sc_mcu7t3v3__fillcap_16
Xwire828 VDD VDD VSS VSS wire828/A _3938_/A gf180mcu_as_sc_mcu7t3v3__clkbuff_12
Xwire839 VDD VDD VSS VSS wire839/A _3508_/A gf180mcu_as_sc_mcu7t3v3__clkbuff_12
XFILLER_13_88 VDD VDD VSS VSS gf180mcu_as_sc_mcu7t3v3__fillcap_16
XFILLER_87_1505 VDD VDD VSS VSS gf180mcu_as_sc_mcu7t3v3__fillcap_4
XFILLER_191_750 VDD VDD VSS VSS gf180mcu_as_sc_mcu7t3v3__fillcap_16
XFILLER_191_772 VDD VDD VSS VSS gf180mcu_as_sc_mcu7t3v3__fillcap_16
XFILLER_198_1081 VDD VDD VSS VSS gf180mcu_as_sc_mcu7t3v3__fillcap_4
XFILLER_87_1538 VDD VDD VSS VSS gf180mcu_as_sc_mcu7t3v3__fillcap_16
XFILLER_135_187 VDD VDD VSS VSS gf180mcu_as_sc_mcu7t3v3__fill_2
XFILLER_145_43 VDD VDD VSS VSS gf180mcu_as_sc_mcu7t3v3__fillcap_16
XFILLER_2_646 VDD VDD VSS VSS gf180mcu_as_sc_mcu7t3v3__fillcap_8
XFILLER_150_168 VDD VDD VSS VSS gf180mcu_as_sc_mcu7t3v3__fillcap_4
XFILLER_20_1408 VDD VDD VSS VSS gf180mcu_as_sc_mcu7t3v3__fillcap_16
XFILLER_111_1558 VDD VDD VSS VSS gf180mcu_as_sc_mcu7t3v3__fillcap_8
XTAP_TAPCELL_ROW_164_1_1938 VDD VSS gf180mcu_as_sc_mcu7t3v3__tap_2
XFILLER_205_136 VDD VDD VSS VSS gf180mcu_as_sc_mcu7t3v3__fillcap_4
XFILLER_2_1362 VDD VDD VSS VSS gf180mcu_as_sc_mcu7t3v3__fill_2
XFILLER_33_506 VDD VDD VSS VSS gf180mcu_as_sc_mcu7t3v3__fill_1
XFILLER_72_163 VDD VDD VSS VSS gf180mcu_as_sc_mcu7t3v3__fillcap_8
XFILLER_14_731 VDD VDD VSS VSS gf180mcu_as_sc_mcu7t3v3__fillcap_4
XFILLER_205_158 VDD VDD VSS VSS gf180mcu_as_sc_mcu7t3v3__fillcap_16
XFILLER_14_775 VDD VDD VSS VSS gf180mcu_as_sc_mcu7t3v3__fillcap_16
XFILLER_13_274 VDD VDD VSS VSS gf180mcu_as_sc_mcu7t3v3__fillcap_4
XFILLER_9_212 VDD VDD VSS VSS gf180mcu_as_sc_mcu7t3v3__fill_1
XFILLER_173_205 VDD VDD VSS VSS gf180mcu_as_sc_mcu7t3v3__fillcap_4
XFILLER_186_577 VDD VDD VSS VSS gf180mcu_as_sc_mcu7t3v3__fillcap_16
XTAP_TAPCELL_ROW_23_1240 VDD VSS gf180mcu_as_sc_mcu7t3v3__tap_2
XPHY_EDGE_ROW_80_1_Right_601 VDD VSS gf180mcu_as_sc_mcu7t3v3__tap_2
XTAP_TAPCELL_ROW_12_987 VDD VSS gf180mcu_as_sc_mcu7t3v3__tap_2
XTAP_TAPCELL_ROW_12_998 VDD VSS gf180mcu_as_sc_mcu7t3v3__tap_2
Xclkload15 VDD VDD VSS VSS clkload15/Y _5090_/CLK gf180mcu_as_sc_mcu7t3v3__inv_6
Xclkload26 VDD VDD VSS VSS _5142_/CLK clkload26/Y gf180mcu_as_sc_mcu7t3v3__clkbuff_4
XFILLER_6_941 VDD VDD VSS VSS gf180mcu_as_sc_mcu7t3v3__fillcap_4
XFILLER_177_1154 VDD VDD VSS VSS gf180mcu_as_sc_mcu7t3v3__fillcap_16
XFILLER_181_260 VDD VDD VSS VSS gf180mcu_as_sc_mcu7t3v3__fillcap_16
XFILLER_182_794 VDD VDD VSS VSS gf180mcu_as_sc_mcu7t3v3__fillcap_8
X_2470_ VDD VDD VSS VSS _4579_/S _5092_/Q _5005_/Q _2471_/A gf180mcu_as_sc_mcu7t3v3__mux2_2
XFILLER_141_146 VDD VDD VSS VSS gf180mcu_as_sc_mcu7t3v3__fill_1
XFILLER_181_282 VDD VDD VSS VSS gf180mcu_as_sc_mcu7t3v3__fillcap_4
XFILLER_29_1422 VDD VDD VSS VSS gf180mcu_as_sc_mcu7t3v3__fill_2
X_4140_ VDD VDD VSS VSS _4141_/C _4140_/B _4140_/A gf180mcu_as_sc_mcu7t3v3__nor2_2
XFILLER_155_1485 VDD VDD VSS VSS gf180mcu_as_sc_mcu7t3v3__fill_1
XFILLER_29_1499 VDD VDD VSS VSS gf180mcu_as_sc_mcu7t3v3__fillcap_16
XFILLER_7_1262 VDD VDD VSS VSS gf180mcu_as_sc_mcu7t3v3__fillcap_16
XFILLER_99_1409 VDD VDD VSS VSS gf180mcu_as_sc_mcu7t3v3__fill_2
X_4071_ VDD VDD VSS VSS _4071_/A _4129_/B _4129_/C _4932_/Q _4073_/C gf180mcu_as_sc_mcu7t3v3__ao22_2
XTAP_TAPCELL_ROW_17_1099 VDD VSS gf180mcu_as_sc_mcu7t3v3__tap_2
X_3022_ VDD VDD VSS VSS _3141_/B _3022_/B _3022_/C _3023_/C gf180mcu_as_sc_mcu7t3v3__nor3_2
XFILLER_184_1103 VDD VDD VSS VSS gf180mcu_as_sc_mcu7t3v3__fillcap_16
XFILLER_196_308 VDD VDD VSS VSS gf180mcu_as_sc_mcu7t3v3__fillcap_4
XFILLER_36_388 VDD VDD VSS VSS gf180mcu_as_sc_mcu7t3v3__fill_2
XFILLER_63_174 VDD VDD VSS VSS gf180mcu_as_sc_mcu7t3v3__fillcap_8
X_4973_ VDD VDD VSS VSS _5233_/CLK _4973_/D _4973_/Q gf180mcu_as_sc_mcu7t3v3__dfxtp_2
X_3924_ VDD VDD VSS VSS _3924_/A _3931_/A _3924_/C _3924_/Y gf180mcu_as_sc_mcu7t3v3__nor3_2
XFILLER_123_1418 VDD VDD VSS VSS gf180mcu_as_sc_mcu7t3v3__fill_1
XFILLER_20_723 VDD VDD VSS VSS gf180mcu_as_sc_mcu7t3v3__fillcap_8
XFILLER_32_572 VDD VDD VSS VSS gf180mcu_as_sc_mcu7t3v3__fillcap_16
XFILLER_32_594 VDD VDD VSS VSS gf180mcu_as_sc_mcu7t3v3__fill_1
Xclkload9 VDD VDD VSS VSS clkload9/Y clkload9/A gf180mcu_as_sc_mcu7t3v3__inv_4
X_3855_ VDD VDD VSS VSS _5149_/Q _5150_/Q _3855_/C _3858_/C gf180mcu_as_sc_mcu7t3v3__nor3_2
XFILLER_177_599 VDD VDD VSS VSS gf180mcu_as_sc_mcu7t3v3__fill_2
XFILLER_30_1014 VDD VDD VSS VSS gf180mcu_as_sc_mcu7t3v3__fill_1
XPHY_EDGE_ROW_140_1_Left_350 VDD VSS gf180mcu_as_sc_mcu7t3v3__tap_2
X_3786_ VDD VDD VSS VSS _3811_/B _3786_/A _3796_/B gf180mcu_as_sc_mcu7t3v3__and2_2
X_2806_ VDD VDD VSS VSS _4259_/C _2806_/A _2806_/B _2806_/C _2806_/D gf180mcu_as_sc_mcu7t3v3__aoi22_2
X_2737_ VDD VDD VSS VSS _2737_/A _2737_/B _2737_/C _2737_/D _2737_/Y gf180mcu_as_sc_mcu7t3v3__ao22_2
X_2668_ VDD VDD VSS VSS _2668_/Y _2668_/C _2668_/B _2668_/A gf180mcu_as_sc_mcu7t3v3__aoi21b_2
XFILLER_117_198 VDD VDD VSS VSS gf180mcu_as_sc_mcu7t3v3__fillcap_8
XFILLER_47_1511 VDD VDD VSS VSS gf180mcu_as_sc_mcu7t3v3__fillcap_8
XFILLER_82_1413 VDD VDD VSS VSS gf180mcu_as_sc_mcu7t3v3__fillcap_16
X_4407_ VDD VDD VSS VSS _5167_/Q _4504_/B _4407_/C _4407_/D _5167_/D gf180mcu_as_sc_mcu7t3v3__ao211_2
XFILLER_47_1566 VDD VDD VSS VSS gf180mcu_as_sc_mcu7t3v3__fill_2
X_2599_ VDD VDD VSS VSS _2659_/S _2601_/D _2599_/B _2599_/A gf180mcu_as_sc_mcu7t3v3__aoi21b_2
XTAP_TAPCELL_ROW_187_2276 VDD VSS gf180mcu_as_sc_mcu7t3v3__tap_2
XFILLER_86_200 VDD VDD VSS VSS gf180mcu_as_sc_mcu7t3v3__fillcap_16
X_4338_ VDD VDD VSS VSS _4590_/C _4590_/B _4338_/A gf180mcu_as_sc_mcu7t3v3__nor2_2
XTAP_TAPCELL_ROW_187_2287 VDD VSS gf180mcu_as_sc_mcu7t3v3__tap_2
XFILLER_189_1014 VDD VDD VSS VSS gf180mcu_as_sc_mcu7t3v3__fillcap_16
X_4269_ VDD VDD VSS VSS _4272_/S _5481_/A _5103_/Q _5103_/D gf180mcu_as_sc_mcu7t3v3__mux2_2
XFILLER_210_1435 VDD VDD VSS VSS gf180mcu_as_sc_mcu7t3v3__fillcap_4
XFILLER_28_823 VDD VDD VSS VSS gf180mcu_as_sc_mcu7t3v3__fillcap_16
XPHY_EDGE_ROW_116_3_Left_501 VDD VSS gf180mcu_as_sc_mcu7t3v3__tap_2
XTAP_TAPCELL_ROW_54_1_1607 VDD VSS gf180mcu_as_sc_mcu7t3v3__tap_2
XFILLER_210_1457 VDD VDD VSS VSS gf180mcu_as_sc_mcu7t3v3__fill_1
XFILLER_131_34 VDD VDD VSS VSS gf180mcu_as_sc_mcu7t3v3__fillcap_16
XPHY_EDGE_ROW_38_3_Right_75 VDD VSS gf180mcu_as_sc_mcu7t3v3__tap_2
XFILLER_167_1356 VDD VDD VSS VSS gf180mcu_as_sc_mcu7t3v3__fill_2
XFILLER_54_185 VDD VDD VSS VSS gf180mcu_as_sc_mcu7t3v3__fill_2
XFILLER_180_1501 VDD VDD VSS VSS gf180mcu_as_sc_mcu7t3v3__fillcap_4
XFILLER_202_139 VDD VDD VSS VSS gf180mcu_as_sc_mcu7t3v3__fillcap_16
XFILLER_10_222 VDD VDD VSS VSS gf180mcu_as_sc_mcu7t3v3__fill_1
XFILLER_11_745 VDD VDD VSS VSS gf180mcu_as_sc_mcu7t3v3__fillcap_8
XFILLER_11_767 VDD VDD VSS VSS gf180mcu_as_sc_mcu7t3v3__fill_2
XFILLER_195_352 VDD VDD VSS VSS gf180mcu_as_sc_mcu7t3v3__fill_2
XFILLER_210_172 VDD VDD VSS VSS gf180mcu_as_sc_mcu7t3v3__fillcap_4
XPHY_EDGE_ROW_72_1_Left_282 VDD VSS gf180mcu_as_sc_mcu7t3v3__tap_2
XFILLER_10_255 VDD VDD VSS VSS gf180mcu_as_sc_mcu7t3v3__fillcap_4
XFILLER_13_1212 VDD VDD VSS VSS gf180mcu_as_sc_mcu7t3v3__fill_1
XFILLER_108_132 VDD VDD VSS VSS gf180mcu_as_sc_mcu7t3v3__fillcap_8
XFILLER_156_53 VDD VDD VSS VSS gf180mcu_as_sc_mcu7t3v3__fillcap_16
XFILLER_40_64 VDD VDD VSS VSS gf180mcu_as_sc_mcu7t3v3__fillcap_16
XTAP_TAPCELL_ROW_108_1_1770 VDD VSS gf180mcu_as_sc_mcu7t3v3__tap_2
XFILLER_172_30 VDD VDD VSS VSS gf180mcu_as_sc_mcu7t3v3__fillcap_4
XPHY_EDGE_ROW_48_3_Left_433 VDD VSS gf180mcu_as_sc_mcu7t3v3__tap_2
XFILLER_172_85 VDD VDD VSS VSS gf180mcu_as_sc_mcu7t3v3__fillcap_16
XFILLER_20_1205 VDD VDD VSS VSS gf180mcu_as_sc_mcu7t3v3__fillcap_16
XFILLER_24_1363 VDD VDD VSS VSS gf180mcu_as_sc_mcu7t3v3__fill_2
XFILLER_63_1390 VDD VDD VSS VSS gf180mcu_as_sc_mcu7t3v3__fillcap_16
Xfanout780 VDD VDD VSS VSS _5224_/Q _4633_/A gf180mcu_as_sc_mcu7t3v3__buff_12
Xfanout791 VDD VDD VSS VSS _4581_/A _4572_/A gf180mcu_as_sc_mcu7t3v3__buff_12
XFILLER_18_311 VDD VDD VSS VSS gf180mcu_as_sc_mcu7t3v3__fillcap_4
XFILLER_18_333 VDD VDD VSS VSS gf180mcu_as_sc_mcu7t3v3__fillcap_16
XFILLER_20_1227 VDD VDD VSS VSS gf180mcu_as_sc_mcu7t3v3__fillcap_4
XFILLER_98_1453 VDD VDD VSS VSS gf180mcu_as_sc_mcu7t3v3__fillcap_4
XPHY_EDGE_ROW_100_3_Left_485 VDD VSS gf180mcu_as_sc_mcu7t3v3__tap_2
XFILLER_34_804 VDD VDD VSS VSS gf180mcu_as_sc_mcu7t3v3__fill_1
XFILLER_59_1415 VDD VDD VSS VSS gf180mcu_as_sc_mcu7t3v3__fill_1
XFILLER_59_1448 VDD VDD VSS VSS gf180mcu_as_sc_mcu7t3v3__fill_1
XFILLER_65_72 VDD VDD VSS VSS gf180mcu_as_sc_mcu7t3v3__fill_1
XFILLER_206_489 VDD VDD VSS VSS gf180mcu_as_sc_mcu7t3v3__fillcap_16
XFILLER_45_174 VDD VDD VSS VSS gf180mcu_as_sc_mcu7t3v3__fillcap_16
XFILLER_187_820 VDD VDD VSS VSS gf180mcu_as_sc_mcu7t3v3__fillcap_16
XFILLER_199_680 VDD VDD VSS VSS gf180mcu_as_sc_mcu7t3v3__fillcap_16
XFILLER_187_842 VDD VDD VSS VSS gf180mcu_as_sc_mcu7t3v3__fillcap_16
XFILLER_60_177 VDD VDD VSS VSS gf180mcu_as_sc_mcu7t3v3__fillcap_4
XFILLER_14_594 VDD VDD VSS VSS gf180mcu_as_sc_mcu7t3v3__fill_1
XFILLER_174_503 VDD VDD VSS VSS gf180mcu_as_sc_mcu7t3v3__fillcap_4
XFILLER_18_1167 VDD VDD VSS VSS gf180mcu_as_sc_mcu7t3v3__fill_2
XFILLER_31_1301 VDD VDD VSS VSS gf180mcu_as_sc_mcu7t3v3__fillcap_16
XFILLER_70_1383 VDD VDD VSS VSS gf180mcu_as_sc_mcu7t3v3__fillcap_16
X_3640_ VDD VDD VSS VSS _4015_/A _3724_/B _3724_/C _4014_/A _3641_/C gf180mcu_as_sc_mcu7t3v3__ao22_2
X_3571_ VDD VDD VSS VSS _3925_/D _3650_/B _3571_/C _3571_/D _3572_/D gf180mcu_as_sc_mcu7t3v3__ao211_2
XFILLER_114_102 VDD VDD VSS VSS gf180mcu_as_sc_mcu7t3v3__fill_2
XFILLER_157_1525 VDD VDD VSS VSS gf180mcu_as_sc_mcu7t3v3__fillcap_4
XFILLER_182_580 VDD VDD VSS VSS gf180mcu_as_sc_mcu7t3v3__fillcap_8
XFILLER_31_1389 VDD VDD VSS VSS gf180mcu_as_sc_mcu7t3v3__fillcap_8
XPHY_EDGE_ROW_81_1_Right_602 VDD VSS gf180mcu_as_sc_mcu7t3v3__tap_2
X_2522_ VDD VDD VSS VSS _2765_/B _2545_/B _2522_/C _2545_/D gf180mcu_as_sc_mcu7t3v3__nor3_2
XFILLER_157_1558 VDD VDD VSS VSS gf180mcu_as_sc_mcu7t3v3__fillcap_8
XFILLER_66_1419 VDD VDD VSS VSS gf180mcu_as_sc_mcu7t3v3__fill_2
XFILLER_9_1302 VDD VDD VSS VSS gf180mcu_as_sc_mcu7t3v3__fillcap_4
X_5241_ VDD VDD VSS VSS _5241_/CLK _5241_/D _5241_/Q gf180mcu_as_sc_mcu7t3v3__dfxtp_2
X_2453_ VDD VDD VSS VSS _2456_/C _2453_/C _5062_/Q _4586_/S gf180mcu_as_sc_mcu7t3v3__aoi21b_2
XTAP_TAPCELL_ROW_19_1139 VDD VSS gf180mcu_as_sc_mcu7t3v3__tap_2
XFILLER_190_1151 VDD VDD VSS VSS gf180mcu_as_sc_mcu7t3v3__fillcap_4
X_5172_ VDD VDD VSS VSS clkload9/A _5172_/D _5172_/Q gf180mcu_as_sc_mcu7t3v3__dfxtp_2
XFILLER_190_1173 VDD VDD VSS VSS gf180mcu_as_sc_mcu7t3v3__fillcap_16
XFILLER_25_1149 VDD VDD VSS VSS gf180mcu_as_sc_mcu7t3v3__fillcap_8
XFILLER_9_1368 VDD VDD VSS VSS gf180mcu_as_sc_mcu7t3v3__fill_2
X_4123_ VDD VDD VSS VSS _4124_/C _4123_/B _4123_/A gf180mcu_as_sc_mcu7t3v3__nor2_2
XPHY_EDGE_ROW_3_Left_214 VDD VSS gf180mcu_as_sc_mcu7t3v3__tap_2
Xinput2 VDD VDD VSS VSS boot_addr[10] input2/Y gf180mcu_as_sc_mcu7t3v3__buff_12
X_4054_ VDD VDD VSS VSS _4054_/A _4102_/B _4102_/C _4930_/Q _4055_/D gf180mcu_as_sc_mcu7t3v3__ao22_2
XTAP_TAPCELL_ROW_182_2173 VDD VSS gf180mcu_as_sc_mcu7t3v3__tap_2
X_3005_ VDD VDD VSS VSS _3005_/A _3005_/B _3005_/C _3006_/C gf180mcu_as_sc_mcu7t3v3__nor3_2
XTAP_TAPCELL_ROW_182_2184 VDD VSS gf180mcu_as_sc_mcu7t3v3__tap_2
XFILLER_25_826 VDD VDD VSS VSS gf180mcu_as_sc_mcu7t3v3__fill_2
XFILLER_77_1515 VDD VDD VSS VSS gf180mcu_as_sc_mcu7t3v3__fill_1
XFILLER_51_111 VDD VDD VSS VSS gf180mcu_as_sc_mcu7t3v3__fill_2
XFILLER_24_369 VDD VDD VSS VSS gf180mcu_as_sc_mcu7t3v3__fill_1
XFILLER_178_831 VDD VDD VSS VSS gf180mcu_as_sc_mcu7t3v3__fill_2
XFILLER_205_1504 VDD VDD VSS VSS gf180mcu_as_sc_mcu7t3v3__fillcap_16
XFILLER_51_188 VDD VDD VSS VSS gf180mcu_as_sc_mcu7t3v3__fillcap_16
X_4956_ VDD VDD VSS VSS _5256_/CLK _4956_/D _4956_/Q gf180mcu_as_sc_mcu7t3v3__dfxtp_2
XFILLER_177_352 VDD VDD VSS VSS gf180mcu_as_sc_mcu7t3v3__fill_1
X_4887_ VDD VDD VSS VSS _4924_/CLK _4887_/D _4887_/Q gf180mcu_as_sc_mcu7t3v3__dfxtp_2
X_3907_ VDD VDD VSS VSS _3907_/B _3907_/A _4948_/D gf180mcu_as_sc_mcu7t3v3__and2_2
XFILLER_192_311 VDD VDD VSS VSS gf180mcu_as_sc_mcu7t3v3__fillcap_4
XFILLER_36_1289 VDD VDD VSS VSS gf180mcu_as_sc_mcu7t3v3__fill_2
X_3838_ VDD VDD VSS VSS _3839_/B _3844_/C _3838_/B _4911_/Q gf180mcu_as_sc_mcu7t3v3__aoi21_2
XFILLER_14_1554 VDD VDD VSS VSS gf180mcu_as_sc_mcu7t3v3__fillcap_8
XFILLER_20_597 VDD VDD VSS VSS gf180mcu_as_sc_mcu7t3v3__fillcap_8
Xclkbuf_leaf_16_clk_regs VDD VDD VSS VSS clkbuf_3_4__f_clk_regs/Y _5233_/CLK gf180mcu_as_sc_mcu7t3v3__clkbuff_12
XFILLER_10_1429 VDD VDD VSS VSS gf180mcu_as_sc_mcu7t3v3__fillcap_4
XFILLER_203_1294 VDD VDD VSS VSS gf180mcu_as_sc_mcu7t3v3__fillcap_16
X_3769_ VDD VDD VSS VSS _3778_/B _4151_/D _3771_/C gf180mcu_as_sc_mcu7t3v3__and2_2
XTAP_TAPCELL_ROW_189_2327 VDD VSS gf180mcu_as_sc_mcu7t3v3__tap_2
XFILLER_101_1568 VDD VDD VSS VSS gf180mcu_as_sc_mcu7t3v3__fill_1
XTAP_TAPCELL_ROW_189_2338 VDD VSS gf180mcu_as_sc_mcu7t3v3__tap_2
XFILLER_105_146 VDD VDD VSS VSS gf180mcu_as_sc_mcu7t3v3__fill_2
XFILLER_195_1084 VDD VDD VSS VSS gf180mcu_as_sc_mcu7t3v3__fillcap_16
Xoutput361 VDD VDD VSS VSS _4782_/Q se_out[11] gf180mcu_as_sc_mcu7t3v3__buff_12
Xoutput350 VDD VDD VSS VSS _4871_/Q east_out[32] gf180mcu_as_sc_mcu7t3v3__buff_12
XFILLER_0_925 VDD VDD VSS VSS gf180mcu_as_sc_mcu7t3v3__fillcap_4
XFILLER_120_127 VDD VDD VSS VSS gf180mcu_as_sc_mcu7t3v3__fill_2
XPHY_EDGE_ROW_186_Right_49 VDD VSS gf180mcu_as_sc_mcu7t3v3__tap_2
Xoutput394 VDD VDD VSS VSS _4815_/Q south_out[10] gf180mcu_as_sc_mcu7t3v3__buff_12
Xoutput383 VDD VDD VSS VSS _4802_/Q se_out[31] gf180mcu_as_sc_mcu7t3v3__buff_12
Xoutput372 VDD VDD VSS VSS _4792_/Q se_out[21] gf180mcu_as_sc_mcu7t3v3__buff_12
XFILLER_0_958 VDD VDD VSS VSS gf180mcu_as_sc_mcu7t3v3__fill_2
XFILLER_47_1385 VDD VDD VSS VSS gf180mcu_as_sc_mcu7t3v3__fill_1
XFILLER_134_1399 VDD VDD VSS VSS gf180mcu_as_sc_mcu7t3v3__fillcap_4
XFILLER_19_43 VDD VDD VSS VSS gf180mcu_as_sc_mcu7t3v3__fillcap_16
XFILLER_142_55 VDD VDD VSS VSS gf180mcu_as_sc_mcu7t3v3__fill_2
XFILLER_169_1418 VDD VDD VSS VSS gf180mcu_as_sc_mcu7t3v3__fillcap_16
XFILLER_210_1265 VDD VDD VSS VSS gf180mcu_as_sc_mcu7t3v3__fillcap_4
XFILLER_210_1287 VDD VDD VSS VSS gf180mcu_as_sc_mcu7t3v3__fill_1
XFILLER_28_664 VDD VDD VSS VSS gf180mcu_as_sc_mcu7t3v3__fill_1
XTAP_TAPCELL_ROW_3_796 VDD VSS gf180mcu_as_sc_mcu7t3v3__tap_2
XFILLER_15_314 VDD VDD VSS VSS gf180mcu_as_sc_mcu7t3v3__fill_1
XFILLER_210_1298 VDD VDD VSS VSS gf180mcu_as_sc_mcu7t3v3__fill_2
XFILLER_27_174 VDD VDD VSS VSS gf180mcu_as_sc_mcu7t3v3__fill_1
XPHY_EDGE_ROW_195_Right_58 VDD VSS gf180mcu_as_sc_mcu7t3v3__tap_2
XFILLER_30_317 VDD VDD VSS VSS gf180mcu_as_sc_mcu7t3v3__fillcap_16
XFILLER_42_177 VDD VDD VSS VSS gf180mcu_as_sc_mcu7t3v3__fillcap_8
XFILLER_184_801 VDD VDD VSS VSS gf180mcu_as_sc_mcu7t3v3__fillcap_4
XFILLER_196_661 VDD VDD VSS VSS gf180mcu_as_sc_mcu7t3v3__fillcap_4
XFILLER_19_1476 VDD VDD VSS VSS gf180mcu_as_sc_mcu7t3v3__fill_2
XTAP_TAPCELL_ROW_159_1_1922 VDD VSS gf180mcu_as_sc_mcu7t3v3__tap_2
XFILLER_106_1457 VDD VDD VSS VSS gf180mcu_as_sc_mcu7t3v3__fill_2
XFILLER_141_1348 VDD VDD VSS VSS gf180mcu_as_sc_mcu7t3v3__fillcap_8
XFILLER_196_683 VDD VDD VSS VSS gf180mcu_as_sc_mcu7t3v3__fillcap_16
Xwire466 VDD VDD VSS VSS _3654_/Y _4850_/D gf180mcu_as_sc_mcu7t3v3__clkbuff_12
Xwire477 VDD VDD VSS VSS _2990_/Y _4775_/D gf180mcu_as_sc_mcu7t3v3__clkbuff_12
Xwire499 VDD VDD VSS VSS wire500/Y _4782_/D gf180mcu_as_sc_mcu7t3v3__clkbuff_12
XFILLER_174_1124 VDD VDD VSS VSS gf180mcu_as_sc_mcu7t3v3__fillcap_16
XFILLER_65_1430 VDD VDD VSS VSS gf180mcu_as_sc_mcu7t3v3__fill_2
XFILLER_2_251 VDD VDD VSS VSS gf180mcu_as_sc_mcu7t3v3__fillcap_8
XFILLER_65_1452 VDD VDD VSS VSS gf180mcu_as_sc_mcu7t3v3__fillcap_16
XFILLER_26_1469 VDD VDD VSS VSS gf180mcu_as_sc_mcu7t3v3__fillcap_8
XFILLER_4_1210 VDD VDD VSS VSS gf180mcu_as_sc_mcu7t3v3__fill_2
XTAP_TAPCELL_ROW_14_1036 VDD VSS gf180mcu_as_sc_mcu7t3v3__tap_2
XTAP_TAPCELL_ROW_14_1047 VDD VSS gf180mcu_as_sc_mcu7t3v3__tap_2
XFILLER_20_1002 VDD VDD VSS VSS gf180mcu_as_sc_mcu7t3v3__fillcap_8
XFILLER_24_1182 VDD VDD VSS VSS gf180mcu_as_sc_mcu7t3v3__fillcap_16
XFILLER_20_1035 VDD VDD VSS VSS gf180mcu_as_sc_mcu7t3v3__fill_1
XFILLER_4_1254 VDD VDD VSS VSS gf180mcu_as_sc_mcu7t3v3__fill_1
XFILLER_19_697 VDD VDD VSS VSS gf180mcu_as_sc_mcu7t3v3__fill_2
XFILLER_202_69 VDD VDD VSS VSS gf180mcu_as_sc_mcu7t3v3__fillcap_16
XFILLER_22_807 VDD VDD VSS VSS gf180mcu_as_sc_mcu7t3v3__fillcap_16
XFILLER_34_667 VDD VDD VSS VSS gf180mcu_as_sc_mcu7t3v3__fillcap_4
X_4810_ VDD VDD VSS VSS _4919_/CLK _4810_/D _4810_/Q gf180mcu_as_sc_mcu7t3v3__dfxtp_2
XFILLER_203_960 VDD VDD VSS VSS gf180mcu_as_sc_mcu7t3v3__fillcap_16
XFILLER_203_982 VDD VDD VSS VSS gf180mcu_as_sc_mcu7t3v3__fillcap_16
XFILLER_33_1418 VDD VDD VSS VSS gf180mcu_as_sc_mcu7t3v3__fillcap_16
X_4741_ VDD VDD VSS VSS _4742_/B _4762_/Q _4741_/B _5275_/Q gf180mcu_as_sc_mcu7t3v3__aoi21_2
XFILLER_124_1568 VDD VDD VSS VSS gf180mcu_as_sc_mcu7t3v3__fill_1
X_4672_ VDD VDD VSS VSS _5243_/D _5243_/Q _4685_/C _4672_/C gf180mcu_as_sc_mcu7t3v3__ao21_2
XFILLER_186_193 VDD VDD VSS VSS gf180mcu_as_sc_mcu7t3v3__fill_1
X_3623_ VDD VDD VSS VSS _3730_/A _3623_/B _3994_/A _3624_/B gf180mcu_as_sc_mcu7t3v3__mux2_2
XFILLER_174_388 VDD VDD VSS VSS gf180mcu_as_sc_mcu7t3v3__fill_2
XFILLER_179_1046 VDD VDD VSS VSS gf180mcu_as_sc_mcu7t3v3__fillcap_4
XFILLER_179_1068 VDD VDD VSS VSS gf180mcu_as_sc_mcu7t3v3__fillcap_16
XPHY_EDGE_ROW_82_1_Right_603 VDD VSS gf180mcu_as_sc_mcu7t3v3__tap_2
X_3554_ VDD VDD VSS VSS _3561_/B _3801_/C _3554_/A gf180mcu_as_sc_mcu7t3v3__nand2_2
X_3485_ VDD VDD VSS VSS _3501_/C _4145_/A _3487_/C gf180mcu_as_sc_mcu7t3v3__and2_2
X_2505_ VDD VDD VSS VSS _5269_/Q _5275_/Q _4736_/B gf180mcu_as_sc_mcu7t3v3__and2_2
X_5224_ VDD VDD VSS VSS _5233_/CLK _5224_/D _5224_/Q gf180mcu_as_sc_mcu7t3v3__dfxtp_2
X_2436_ VDD VDD VSS VSS _3676_/A _4050_/A gf180mcu_as_sc_mcu7t3v3__inv_2
XTAP_TAPCELL_ROW_184_2224 VDD VSS gf180mcu_as_sc_mcu7t3v3__tap_2
XTAP_TAPCELL_ROW_184_2213 VDD VSS gf180mcu_as_sc_mcu7t3v3__tap_2
XFILLER_9_1165 VDD VDD VSS VSS gf180mcu_as_sc_mcu7t3v3__fillcap_8
XFILLER_5_1029 VDD VDD VSS VSS gf180mcu_as_sc_mcu7t3v3__fillcap_8
XFILLER_9_1187 VDD VDD VSS VSS gf180mcu_as_sc_mcu7t3v3__fill_2
X_5155_ VDD VDD VSS VSS _5198_/CLK _5155_/D _5155_/Q gf180mcu_as_sc_mcu7t3v3__dfxtp_2
X_5086_ VDD VDD VSS VSS _5095_/CLK _5086_/D _5086_/Q gf180mcu_as_sc_mcu7t3v3__dfxtp_2
X_4106_ VDD VDD VSS VSS _4106_/S _4106_/B _4106_/A _4107_/B gf180mcu_as_sc_mcu7t3v3__mux2_2
XFILLER_186_1017 VDD VDD VSS VSS gf180mcu_as_sc_mcu7t3v3__fillcap_16
XTAP_TAPCELL_ROW_0_700 VDD VSS gf180mcu_as_sc_mcu7t3v3__tap_2
XTAP_TAPCELL_ROW_0_711 VDD VSS gf180mcu_as_sc_mcu7t3v3__tap_2
XTAP_TAPCELL_ROW_0_722 VDD VSS gf180mcu_as_sc_mcu7t3v3__tap_2
X_4037_ VDD VDD VSS VSS _4037_/A _4118_/B _4118_/C _4037_/D _4038_/D gf180mcu_as_sc_mcu7t3v3__ao22_2
XFILLER_129_1413 VDD VDD VSS VSS gf180mcu_as_sc_mcu7t3v3__fill_2
XTAP_TAPCELL_ROW_0_733 VDD VSS gf180mcu_as_sc_mcu7t3v3__tap_2
XFILLER_12_317 VDD VDD VSS VSS gf180mcu_as_sc_mcu7t3v3__fill_2
XFILLER_164_1348 VDD VDD VSS VSS gf180mcu_as_sc_mcu7t3v3__fillcap_16
XFILLER_169_138 VDD VDD VSS VSS gf180mcu_as_sc_mcu7t3v3__fill_2
XFILLER_188_18 VDD VDD VSS VSS gf180mcu_as_sc_mcu7t3v3__fillcap_16
XFILLER_24_177 VDD VDD VSS VSS gf180mcu_as_sc_mcu7t3v3__fillcap_16
XFILLER_36_1042 VDD VDD VSS VSS gf180mcu_as_sc_mcu7t3v3__fill_2
XFILLER_36_1053 VDD VDD VSS VSS gf180mcu_as_sc_mcu7t3v3__fill_1
X_4939_ VDD VDD VSS VSS _4977_/CLK _4939_/D _4939_/Q gf180mcu_as_sc_mcu7t3v3__dfxtp_2
XFILLER_21_862 VDD VDD VSS VSS gf180mcu_as_sc_mcu7t3v3__fill_1
XFILLER_181_804 VDD VDD VSS VSS gf180mcu_as_sc_mcu7t3v3__fillcap_16
XFILLER_193_664 VDD VDD VSS VSS gf180mcu_as_sc_mcu7t3v3__fillcap_16
XFILLER_14_1362 VDD VDD VSS VSS gf180mcu_as_sc_mcu7t3v3__fill_2
XFILLER_4_516 VDD VDD VSS VSS gf180mcu_as_sc_mcu7t3v3__fillcap_8
XFILLER_108_4 VDD VDD VSS VSS gf180mcu_as_sc_mcu7t3v3__fill_1
XFILLER_192_185 VDD VDD VSS VSS gf180mcu_as_sc_mcu7t3v3__fill_1
XFILLER_21_66 VDD VDD VSS VSS gf180mcu_as_sc_mcu7t3v3__fillcap_4
XFILLER_137_88 VDD VDD VSS VSS gf180mcu_as_sc_mcu7t3v3__fillcap_8
XPHY_EDGE_ROW_103_1_Left_313 VDD VSS gf180mcu_as_sc_mcu7t3v3__tap_2
XFILLER_0_722 VDD VDD VSS VSS gf180mcu_as_sc_mcu7t3v3__fill_1
XFILLER_175_1488 VDD VDD VSS VSS gf180mcu_as_sc_mcu7t3v3__fillcap_8
XFILLER_97_59 VDD VDD VSS VSS gf180mcu_as_sc_mcu7t3v3__fillcap_8
XFILLER_153_43 VDD VDD VSS VSS gf180mcu_as_sc_mcu7t3v3__fillcap_16
XTAP_TAPCELL_ROW_8_899 VDD VSS gf180mcu_as_sc_mcu7t3v3__tap_2
XTAP_TAPCELL_ROW_39_3_2839 VDD VSS gf180mcu_as_sc_mcu7t3v3__tap_2
XFILLER_0_788 VDD VDD VSS VSS gf180mcu_as_sc_mcu7t3v3__fill_2
XFILLER_198_2 VDD VDD VSS VSS gf180mcu_as_sc_mcu7t3v3__fillcap_16
XFILLER_210_1051 VDD VDD VSS VSS gf180mcu_as_sc_mcu7t3v3__fill_2
XFILLER_16_601 VDD VDD VSS VSS gf180mcu_as_sc_mcu7t3v3__fill_2
XFILLER_46_85 VDD VDD VSS VSS gf180mcu_as_sc_mcu7t3v3__fillcap_16
XFILLER_95_1445 VDD VDD VSS VSS gf180mcu_as_sc_mcu7t3v3__fillcap_16
XFILLER_16_667 VDD VDD VSS VSS gf180mcu_as_sc_mcu7t3v3__fillcap_16
XFILLER_186_1562 VDD VDD VSS VSS gf180mcu_as_sc_mcu7t3v3__fillcap_4
XFILLER_203_212 VDD VDD VSS VSS gf180mcu_as_sc_mcu7t3v3__fillcap_16
XFILLER_147_1568 VDD VDD VSS VSS gf180mcu_as_sc_mcu7t3v3__fill_1
XFILLER_19_1262 VDD VDD VSS VSS gf180mcu_as_sc_mcu7t3v3__fillcap_16
XTAP_TAPCELL_ROW_84_1_1698 VDD VSS gf180mcu_as_sc_mcu7t3v3__tap_2
XFILLER_200_963 VDD VDD VSS VSS gf180mcu_as_sc_mcu7t3v3__fillcap_16
XFILLER_8_855 VDD VDD VSS VSS gf180mcu_as_sc_mcu7t3v3__fillcap_16
XFILLER_11_394 VDD VDD VSS VSS gf180mcu_as_sc_mcu7t3v3__fillcap_16
XFILLER_176_1208 VDD VDD VSS VSS gf180mcu_as_sc_mcu7t3v3__fillcap_16
XFILLER_184_664 VDD VDD VSS VSS gf180mcu_as_sc_mcu7t3v3__fill_1
XFILLER_183_196 VDD VDD VSS VSS gf180mcu_as_sc_mcu7t3v3__fillcap_4
XFILLER_67_1558 VDD VDD VSS VSS gf180mcu_as_sc_mcu7t3v3__fillcap_8
XFILLER_154_1539 VDD VDD VSS VSS gf180mcu_as_sc_mcu7t3v3__fill_1
X_3270_ VDD VDD VSS VSS _3270_/Y _3271_/B _3271_/A gf180mcu_as_sc_mcu7t3v3__nor2_2
XPHY_EDGE_ROW_209_Left_419 VDD VSS gf180mcu_as_sc_mcu7t3v3__tap_2
XFILLER_26_1244 VDD VDD VSS VSS gf180mcu_as_sc_mcu7t3v3__fill_2
XTAP_TAPCELL_ROW_33_1456 VDD VSS gf180mcu_as_sc_mcu7t3v3__tap_2
XFILLER_22_1119 VDD VDD VSS VSS gf180mcu_as_sc_mcu7t3v3__fillcap_8
XFILLER_6_1349 VDD VDD VSS VSS gf180mcu_as_sc_mcu7t3v3__fill_2
XTAP_TAPCELL_ROW_33_1467 VDD VSS gf180mcu_as_sc_mcu7t3v3__tap_2
XFILLER_187_1326 VDD VDD VSS VSS gf180mcu_as_sc_mcu7t3v3__fillcap_4
Xclkbuf_2_1_0_clk_regs VDD VDD VSS VSS clkbuf_0_clk_regs/Y clkbuf_2_1_0_clk_regs/Y
+ gf180mcu_as_sc_mcu7t3v3__clkbuff_12
XFILLER_187_1348 VDD VDD VSS VSS gf180mcu_as_sc_mcu7t3v3__fillcap_4
XFILLER_207_540 VDD VDD VSS VSS gf180mcu_as_sc_mcu7t3v3__fillcap_16
XFILLER_207_562 VDD VDD VSS VSS gf180mcu_as_sc_mcu7t3v3__fillcap_16
XFILLER_4_1084 VDD VDD VSS VSS gf180mcu_as_sc_mcu7t3v3__fill_1
XFILLER_74_1507 VDD VDD VSS VSS gf180mcu_as_sc_mcu7t3v3__fillcap_8
XFILLER_35_998 VDD VDD VSS VSS gf180mcu_as_sc_mcu7t3v3__fillcap_16
XFILLER_210_705 VDD VDD VSS VSS gf180mcu_as_sc_mcu7t3v3__fillcap_4
XFILLER_210_716 VDD VDD VSS VSS gf180mcu_as_sc_mcu7t3v3__fillcap_4
XTAP_TAPCELL_ROW_177_2072 VDD VSS gf180mcu_as_sc_mcu7t3v3__tap_2
XTAP_TAPCELL_ROW_177_2061 VDD VSS gf180mcu_as_sc_mcu7t3v3__tap_2
XFILLER_202_1507 VDD VDD VSS VSS gf180mcu_as_sc_mcu7t3v3__fillcap_16
XFILLER_21_158 VDD VDD VSS VSS gf180mcu_as_sc_mcu7t3v3__fillcap_8
XFILLER_33_1215 VDD VDD VSS VSS gf180mcu_as_sc_mcu7t3v3__fillcap_4
X_4724_ VDD VDD VSS VSS _5264_/Q _4730_/B _4730_/C _5263_/Q _4725_/C gf180mcu_as_sc_mcu7t3v3__ao22_2
X_2985_ VDD VDD VSS VSS _3967_/A _3076_/B _3076_/C _3968_/D _2986_/C gf180mcu_as_sc_mcu7t3v3__ao22_2
XFILLER_174_163 VDD VDD VSS VSS gf180mcu_as_sc_mcu7t3v3__fillcap_4
X_4655_ VDD VDD VSS VSS _4656_/B _5239_/Q _4655_/B _4746_/D gf180mcu_as_sc_mcu7t3v3__ao21_2
XFILLER_190_645 VDD VDD VSS VSS gf180mcu_as_sc_mcu7t3v3__fillcap_16
XFILLER_200_1275 VDD VDD VSS VSS gf180mcu_as_sc_mcu7t3v3__fillcap_16
XPHY_EDGE_ROW_125_3_Left_510 VDD VSS gf180mcu_as_sc_mcu7t3v3__tap_2
Xinput60 VDD VDD VSS VSS east_in[24] wire846/A gf180mcu_as_sc_mcu7t3v3__buff_12
Xinput71 VDD VDD VSS VSS east_in[3] _3960_/A gf180mcu_as_sc_mcu7t3v3__buff_12
Xinput82 VDD VDD VSS VSS ne_in[13] _4037_/A gf180mcu_as_sc_mcu7t3v3__buff_12
X_4586_ VDD VDD VSS VSS _4586_/S _5030_/Q _5059_/Q _4587_/B gf180mcu_as_sc_mcu7t3v3__mux2_2
X_3606_ VDD VDD VSS VSS _3973_/A _3650_/B _3606_/C _3606_/D _3607_/D gf180mcu_as_sc_mcu7t3v3__ao211_2
XFILLER_190_667 VDD VDD VSS VSS gf180mcu_as_sc_mcu7t3v3__fillcap_16
XFILLER_1_508 VDD VDD VSS VSS gf180mcu_as_sc_mcu7t3v3__fillcap_4
XFILLER_200_1297 VDD VDD VSS VSS gf180mcu_as_sc_mcu7t3v3__fillcap_16
Xinput93 VDD VDD VSS VSS ne_in[23] _4118_/A gf180mcu_as_sc_mcu7t3v3__buff_12
X_3537_ VDD VDD VSS VSS _3932_/B _3537_/A _3777_/B gf180mcu_as_sc_mcu7t3v3__and2_2
XFILLER_107_47 VDD VDD VSS VSS gf180mcu_as_sc_mcu7t3v3__fillcap_16
XFILLER_192_1065 VDD VDD VSS VSS gf180mcu_as_sc_mcu7t3v3__fillcap_16
XPHY_EDGE_ROW_47_3_Right_84 VDD VSS gf180mcu_as_sc_mcu7t3v3__tap_2
XPHY_EDGE_ROW_83_1_Right_604 VDD VSS gf180mcu_as_sc_mcu7t3v3__tap_2
XFILLER_107_69 VDD VDD VSS VSS gf180mcu_as_sc_mcu7t3v3__fill_1
XFILLER_192_1087 VDD VDD VSS VSS gf180mcu_as_sc_mcu7t3v3__fillcap_16
X_3468_ VDD VDD VSS VSS _4118_/D _3468_/B _3468_/C _3468_/D _3469_/C gf180mcu_as_sc_mcu7t3v3__ao211_2
X_5207_ VDD VDD VSS VSS _5214_/CLK _5207_/D _5207_/Q gf180mcu_as_sc_mcu7t3v3__dfxtp_2
X_3399_ VDD VDD VSS VSS _3505_/S _3399_/B _4050_/A _3400_/B gf180mcu_as_sc_mcu7t3v3__mux2_2
X_2419_ VDD VDD VSS VSS _3240_/A _3522_/A gf180mcu_as_sc_mcu7t3v3__inv_2
XTAP_TAPCELL_ROW_5_847 VDD VSS gf180mcu_as_sc_mcu7t3v3__tap_2
XTAP_TAPCELL_ROW_5_836 VDD VSS gf180mcu_as_sc_mcu7t3v3__tap_2
XFILLER_123_35 VDD VDD VSS VSS gf180mcu_as_sc_mcu7t3v3__fillcap_4
XFILLER_44_1366 VDD VDD VSS VSS gf180mcu_as_sc_mcu7t3v3__fillcap_8
XFILLER_44_1399 VDD VDD VSS VSS gf180mcu_as_sc_mcu7t3v3__fillcap_8
X_5138_ VDD VDD VSS VSS _5142_/CLK _5138_/D _5138_/Q gf180mcu_as_sc_mcu7t3v3__dfxtp_2
XTAP_TAPCELL_ROW_209_2772 VDD VSS gf180mcu_as_sc_mcu7t3v3__tap_2
XTAP_TAPCELL_ROW_209_2761 VDD VSS gf180mcu_as_sc_mcu7t3v3__tap_2
XFILLER_79_1418 VDD VDD VSS VSS gf180mcu_as_sc_mcu7t3v3__fillcap_16
XPHY_EDGE_ROW_81_1_Left_291 VDD VSS gf180mcu_as_sc_mcu7t3v3__tap_2
XTAP_TAPCELL_ROW_102_1_1751 VDD VSS gf180mcu_as_sc_mcu7t3v3__tap_2
XTAP_TAPCELL_ROW_114_3_3063 VDD VSS gf180mcu_as_sc_mcu7t3v3__tap_2
X_5069_ VDD VDD VSS VSS _5073_/CLK _5069_/D _5069_/Q gf180mcu_as_sc_mcu7t3v3__dfxtp_2
XFILLER_13_626 VDD VDD VSS VSS gf180mcu_as_sc_mcu7t3v3__fillcap_4
XFILLER_207_1418 VDD VDD VSS VSS gf180mcu_as_sc_mcu7t3v3__fillcap_16
XFILLER_25_486 VDD VDD VSS VSS gf180mcu_as_sc_mcu7t3v3__fillcap_4
XFILLER_0_1493 VDD VDD VSS VSS gf180mcu_as_sc_mcu7t3v3__fill_2
XFILLER_13_648 VDD VDD VSS VSS gf180mcu_as_sc_mcu7t3v3__fillcap_16
XFILLER_197_244 VDD VDD VSS VSS gf180mcu_as_sc_mcu7t3v3__fillcap_16
Xclkbuf_leaf_31_clk_regs VDD VDD VSS VSS clkbuf_3_0__f_clk_regs/Y clkload3/A gf180mcu_as_sc_mcu7t3v3__clkbuff_12
XFILLER_199_1208 VDD VDD VSS VSS gf180mcu_as_sc_mcu7t3v3__fillcap_16
XFILLER_55_1484 VDD VDD VSS VSS gf180mcu_as_sc_mcu7t3v3__fill_2
XFILLER_8_107 VDD VDD VSS VSS gf180mcu_as_sc_mcu7t3v3__fillcap_16
XFILLER_165_130 VDD VDD VSS VSS gf180mcu_as_sc_mcu7t3v3__fill_2
XFILLER_181_1492 VDD VDD VSS VSS gf180mcu_as_sc_mcu7t3v3__fillcap_8
XFILLER_205_1186 VDD VDD VSS VSS gf180mcu_as_sc_mcu7t3v3__fillcap_4
XFILLER_148_65 VDD VDD VSS VSS gf180mcu_as_sc_mcu7t3v3__fill_2
XFILLER_194_995 VDD VDD VSS VSS gf180mcu_as_sc_mcu7t3v3__fillcap_16
XPHY_EDGE_ROW_57_3_Left_442 VDD VSS gf180mcu_as_sc_mcu7t3v3__tap_2
XFILLER_113_2 VDD VDD VSS VSS gf180mcu_as_sc_mcu7t3v3__fillcap_16
XFILLER_14_1181 VDD VDD VSS VSS gf180mcu_as_sc_mcu7t3v3__fill_2
XFILLER_180_155 VDD VDD VSS VSS gf180mcu_as_sc_mcu7t3v3__fillcap_16
XFILLER_5_869 VDD VDD VSS VSS gf180mcu_as_sc_mcu7t3v3__fillcap_16
XFILLER_180_177 VDD VDD VSS VSS gf180mcu_as_sc_mcu7t3v3__fillcap_16
XFILLER_62_1411 VDD VDD VSS VSS gf180mcu_as_sc_mcu7t3v3__fillcap_8
XTAP_TAPCELL_ROW_58_3_2894 VDD VSS gf180mcu_as_sc_mcu7t3v3__tap_2
XFILLER_0_552 VDD VDD VSS VSS gf180mcu_as_sc_mcu7t3v3__fill_1
XFILLER_114_1523 VDD VDD VSS VSS gf180mcu_as_sc_mcu7t3v3__fillcap_4
XFILLER_180_30 VDD VDD VSS VSS gf180mcu_as_sc_mcu7t3v3__fillcap_4
XFILLER_209_838 VDD VDD VSS VSS gf180mcu_as_sc_mcu7t3v3__fill_2
XFILLER_94_139 VDD VDD VSS VSS gf180mcu_as_sc_mcu7t3v3__fillcap_4
XTAP_TAPCELL_ROW_160_3_3200 VDD VSS gf180mcu_as_sc_mcu7t3v3__tap_2
XFILLER_180_85 VDD VDD VSS VSS gf180mcu_as_sc_mcu7t3v3__fillcap_16
XFILLER_189_734 VDD VDD VSS VSS gf180mcu_as_sc_mcu7t3v3__fillcap_16
XFILLER_204_521 VDD VDD VSS VSS gf180mcu_as_sc_mcu7t3v3__fillcap_4
XFILLER_204_543 VDD VDD VSS VSS gf180mcu_as_sc_mcu7t3v3__fillcap_16
XFILLER_73_72 VDD VDD VSS VSS gf180mcu_as_sc_mcu7t3v3__fillcap_16
XFILLER_177_907 VDD VDD VSS VSS gf180mcu_as_sc_mcu7t3v3__fill_2
XFILLER_189_72 VDD VDD VSS VSS gf180mcu_as_sc_mcu7t3v3__fillcap_16
XFILLER_147_1398 VDD VDD VSS VSS gf180mcu_as_sc_mcu7t3v3__fillcap_16
XFILLER_188_288 VDD VDD VSS VSS gf180mcu_as_sc_mcu7t3v3__fillcap_16
XTAP_TAPCELL_ROW_140_3_3142 VDD VSS gf180mcu_as_sc_mcu7t3v3__tap_2
XFILLER_31_489 VDD VDD VSS VSS gf180mcu_as_sc_mcu7t3v3__fill_1
XFILLER_34_1557 VDD VDD VSS VSS gf180mcu_as_sc_mcu7t3v3__fillcap_8
X_2770_ VDD VDD VSS VSS _2840_/A _2840_/B _2770_/C _2771_/C _2770_/D gf180mcu_as_sc_mcu7t3v3__oai211_2
XTAP_TAPCELL_ROW_26_1293 VDD VSS gf180mcu_as_sc_mcu7t3v3__tap_2
XFILLER_156_130 VDD VDD VSS VSS gf180mcu_as_sc_mcu7t3v3__fillcap_16
XFILLER_156_174 VDD VDD VSS VSS gf180mcu_as_sc_mcu7t3v3__fill_1
XFILLER_8_685 VDD VDD VSS VSS gf180mcu_as_sc_mcu7t3v3__fill_1
X_4440_ VDD VDD VSS VSS _4440_/D _4502_/A _4440_/B _4440_/C _4441_/B gf180mcu_as_sc_mcu7t3v3__ao31_2
XFILLER_158_1450 VDD VDD VSS VSS gf180mcu_as_sc_mcu7t3v3__fill_1
XFILLER_176_1049 VDD VDD VSS VSS gf180mcu_as_sc_mcu7t3v3__fillcap_16
XTAP_TAPCELL_ROW_107_1_1766 VDD VSS gf180mcu_as_sc_mcu7t3v3__tap_2
XTAP_TAPCELL_ROW_119_3_3078 VDD VSS gf180mcu_as_sc_mcu7t3v3__tap_2
X_4371_ VDD VDD VSS VSS _4372_/C _4371_/B _4371_/A gf180mcu_as_sc_mcu7t3v3__nor2b_2
XTAP_TAPCELL_ROW_35_1507 VDD VSS gf180mcu_as_sc_mcu7t3v3__tap_2
Xfanout609 VDD VDD VSS VSS _3761_/B _3658_/B gf180mcu_as_sc_mcu7t3v3__buff_12
X_3322_ VDD VDD VSS VSS _3442_/B _3975_/A _3323_/D gf180mcu_as_sc_mcu7t3v3__or2_2
X_3253_ VDD VDD VSS VSS _3509_/A _3818_/C _3253_/A gf180mcu_as_sc_mcu7t3v3__nand2_2
XFILLER_6_1135 VDD VDD VSS VSS gf180mcu_as_sc_mcu7t3v3__fill_2
X_3184_ VDD VDD VSS VSS _3185_/D _3213_/A gf180mcu_as_sc_mcu7t3v3__inv_2
XFILLER_27_718 VDD VDD VSS VSS gf180mcu_as_sc_mcu7t3v3__fillcap_16
X_4905__1062 VDD VDD VSS VSS _4905_/D gf180mcu_as_sc_mcu7t3v3__tiel_4
XFILLER_207_370 VDD VDD VSS VSS gf180mcu_as_sc_mcu7t3v3__fill_1
XTAP_TAPCELL_ROW_84_3_2973 VDD VSS gf180mcu_as_sc_mcu7t3v3__tap_2
XTAP_TAPCELL_ROW_179_2112 VDD VSS gf180mcu_as_sc_mcu7t3v3__tap_2
XTAP_TAPCELL_ROW_179_2101 VDD VSS gf180mcu_as_sc_mcu7t3v3__tap_2
XFILLER_179_222 VDD VDD VSS VSS gf180mcu_as_sc_mcu7t3v3__fillcap_16
XFILLER_23_957 VDD VDD VSS VSS gf180mcu_as_sc_mcu7t3v3__fillcap_16
XFILLER_74_1359 VDD VDD VSS VSS gf180mcu_as_sc_mcu7t3v3__fill_1
XTAP_TAPCELL_ROW_200_2577 VDD VSS gf180mcu_as_sc_mcu7t3v3__tap_2
XTAP_TAPCELL_ROW_200_2566 VDD VSS gf180mcu_as_sc_mcu7t3v3__tap_2
XFILLER_179_266 VDD VDD VSS VSS gf180mcu_as_sc_mcu7t3v3__fill_2
XFILLER_194_214 VDD VDD VSS VSS gf180mcu_as_sc_mcu7t3v3__fillcap_16
XFILLER_210_535 VDD VDD VSS VSS gf180mcu_as_sc_mcu7t3v3__fillcap_4
XFILLER_210_546 VDD VDD VSS VSS gf180mcu_as_sc_mcu7t3v3__fillcap_4
XFILLER_23_979 VDD VDD VSS VSS gf180mcu_as_sc_mcu7t3v3__fill_1
XTAP_TAPCELL_ROW_196_2492 VDD VSS gf180mcu_as_sc_mcu7t3v3__tap_2
XTAP_TAPCELL_ROW_196_2481 VDD VSS gf180mcu_as_sc_mcu7t3v3__tap_2
X_2968_ VDD VDD VSS VSS _3950_/A _3076_/B _3076_/C _3949_/A _2969_/C gf180mcu_as_sc_mcu7t3v3__ao22_2
XFILLER_176_995 VDD VDD VSS VSS gf180mcu_as_sc_mcu7t3v3__fillcap_16
XFILLER_33_1045 VDD VDD VSS VSS gf180mcu_as_sc_mcu7t3v3__fillcap_4
X_4707_ VDD VDD VSS VSS _4707_/S _5256_/Q _4707_/A _5256_/D gf180mcu_as_sc_mcu7t3v3__mux2_2
XTAP_TAPCELL_ROW_192_2389 VDD VSS gf180mcu_as_sc_mcu7t3v3__tap_2
XFILLER_11_1332 VDD VDD VSS VSS gf180mcu_as_sc_mcu7t3v3__fillcap_4
X_4638_ VDD VDD VSS VSS _4683_/C _5104_/Q _5229_/Q _5229_/D gf180mcu_as_sc_mcu7t3v3__mux2_2
X_2899_ VDD VDD VSS VSS _4946_/Q _4945_/Q _3249_/B gf180mcu_as_sc_mcu7t3v3__and2_2
XFILLER_191_976 VDD VDD VSS VSS gf180mcu_as_sc_mcu7t3v3__fillcap_4
XFILLER_11_1387 VDD VDD VSS VSS gf180mcu_as_sc_mcu7t3v3__fill_1
XFILLER_162_177 VDD VDD VSS VSS gf180mcu_as_sc_mcu7t3v3__fillcap_8
XFILLER_191_998 VDD VDD VSS VSS gf180mcu_as_sc_mcu7t3v3__fillcap_16
XTAP_TAPCELL_ROW_153_1_1903 VDD VSS gf180mcu_as_sc_mcu7t3v3__tap_2
X_4569_ VDD VDD VSS VSS _4572_/C _4999_/Q _4570_/S gf180mcu_as_sc_mcu7t3v3__nand2b_2
XTAP_TAPCELL_ROW_165_3_3215 VDD VSS gf180mcu_as_sc_mcu7t3v3__tap_2
XFILLER_1_349 VDD VDD VSS VSS gf180mcu_as_sc_mcu7t3v3__fill_1
XFILLER_46_1439 VDD VDD VSS VSS gf180mcu_as_sc_mcu7t3v3__fillcap_8
XFILLER_85_1488 VDD VDD VSS VSS gf180mcu_as_sc_mcu7t3v3__fillcap_16
XPHY_EDGE_ROW_84_1_Right_605 VDD VSS gf180mcu_as_sc_mcu7t3v3__tap_2
XFILLER_134_34 VDD VDD VSS VSS gf180mcu_as_sc_mcu7t3v3__fill_1
XFILLER_134_45 VDD VDD VSS VSS gf180mcu_as_sc_mcu7t3v3__fillcap_4
XFILLER_76_139 VDD VDD VSS VSS gf180mcu_as_sc_mcu7t3v3__fillcap_16
Xmesh_tile_1008 VDD VDD VSS VSS nw_out[15] gf180mcu_as_sc_mcu7t3v3__tiel_4
XFILLER_134_89 VDD VDD VSS VSS gf180mcu_as_sc_mcu7t3v3__fill_2
Xmesh_tile_1019 VDD VDD VSS VSS nw_out[26] gf180mcu_as_sc_mcu7t3v3__tiel_4
XFILLER_17_228 VDD VDD VSS VSS gf180mcu_as_sc_mcu7t3v3__fillcap_8
XFILLER_27_43 VDD VDD VSS VSS gf180mcu_as_sc_mcu7t3v3__fillcap_4
XTAP_TAPCELL_ROW_133_1_1845 VDD VSS gf180mcu_as_sc_mcu7t3v3__tap_2
XTAP_TAPCELL_ROW_145_3_3157 VDD VSS gf180mcu_as_sc_mcu7t3v3__tap_2
XFILLER_18_1519 VDD VDD VSS VSS gf180mcu_as_sc_mcu7t3v3__fill_1
XFILLER_57_1568 VDD VDD VSS VSS gf180mcu_as_sc_mcu7t3v3__fill_1
XFILLER_186_715 VDD VDD VSS VSS gf180mcu_as_sc_mcu7t3v3__fillcap_16
XFILLER_186_737 VDD VDD VSS VSS gf180mcu_as_sc_mcu7t3v3__fillcap_16
XFILLER_198_575 VDD VDD VSS VSS gf180mcu_as_sc_mcu7t3v3__fillcap_16
XFILLER_198_597 VDD VDD VSS VSS gf180mcu_as_sc_mcu7t3v3__fillcap_16
XFILLER_201_524 VDD VDD VSS VSS gf180mcu_as_sc_mcu7t3v3__fillcap_16
XFILLER_9_416 VDD VDD VSS VSS gf180mcu_as_sc_mcu7t3v3__fillcap_4
XFILLER_13_489 VDD VDD VSS VSS gf180mcu_as_sc_mcu7t3v3__fill_1
XFILLER_16_1254 VDD VDD VSS VSS gf180mcu_as_sc_mcu7t3v3__fillcap_16
XFILLER_9_438 VDD VDD VSS VSS gf180mcu_as_sc_mcu7t3v3__fillcap_16
XFILLER_12_1118 VDD VDD VSS VSS gf180mcu_as_sc_mcu7t3v3__fillcap_8
XFILLER_138_185 VDD VDD VSS VSS gf180mcu_as_sc_mcu7t3v3__fill_2
XFILLER_99_209 VDD VDD VSS VSS gf180mcu_as_sc_mcu7t3v3__fill_1
XTAP_TAPCELL_ROW_79_1_1682 VDD VSS gf180mcu_as_sc_mcu7t3v3__tap_2
XTAP_TAPCELL_ROW_21_1190 VDD VSS gf180mcu_as_sc_mcu7t3v3__tap_2
XFILLER_68_61 VDD VDD VSS VSS gf180mcu_as_sc_mcu7t3v3__fill_2
XTAP_TAPCELL_ROW_89_3_2988 VDD VSS gf180mcu_as_sc_mcu7t3v3__tap_2
XFILLER_0_382 VDD VDD VSS VSS gf180mcu_as_sc_mcu7t3v3__fill_1
XFILLER_7_1422 VDD VDD VSS VSS gf180mcu_as_sc_mcu7t3v3__fill_2
XFILLER_188_1410 VDD VDD VSS VSS gf180mcu_as_sc_mcu7t3v3__fillcap_16
XFILLER_208_101 VDD VDD VSS VSS gf180mcu_as_sc_mcu7t3v3__fillcap_4
XFILLER_23_1247 VDD VDD VSS VSS gf180mcu_as_sc_mcu7t3v3__fillcap_8
Xinput250 VDD VDD VSS VSS sw_in[10] _4018_/A gf180mcu_as_sc_mcu7t3v3__buff_12
Xinput261 VDD VDD VSS VSS sw_in[20] _2442_/A gf180mcu_as_sc_mcu7t3v3__buff_12
Xinput272 VDD VDD VSS VSS sw_in[30] _3803_/A gf180mcu_as_sc_mcu7t3v3__buff_12
Xinput283 VDD VDD VSS VSS west_in[0] _3925_/D gf180mcu_as_sc_mcu7t3v3__buff_12
Xinput294 VDD VDD VSS VSS west_in[1] _3938_/D gf180mcu_as_sc_mcu7t3v3__buff_12
XTAP_TAPCELL_ROW_37_1_2830 VDD VSS gf180mcu_as_sc_mcu7t3v3__tap_2
XFILLER_184_1329 VDD VDD VSS VSS gf180mcu_as_sc_mcu7t3v3__fillcap_16
XFILLER_23_209 VDD VDD VSS VSS gf180mcu_as_sc_mcu7t3v3__fill_1
X_3940_ VDD VDD VSS VSS _3940_/A _4023_/B _4023_/C _4916_/Q _3942_/C gf180mcu_as_sc_mcu7t3v3__ao22_2
XFILLER_177_704 VDD VDD VSS VSS gf180mcu_as_sc_mcu7t3v3__fill_1
XFILLER_205_874 VDD VDD VSS VSS gf180mcu_as_sc_mcu7t3v3__fillcap_16
XFILLER_210_36 VDD VDD VSS VSS gf180mcu_as_sc_mcu7t3v3__fillcap_16
XTAP_TAPCELL_ROW_28_1355 VDD VSS gf180mcu_as_sc_mcu7t3v3__tap_2
XTAP_TAPCELL_ROW_28_1344 VDD VSS gf180mcu_as_sc_mcu7t3v3__tap_2
XFILLER_31_220 VDD VDD VSS VSS gf180mcu_as_sc_mcu7t3v3__fill_2
X_3871_ VDD VDD VSS VSS _3872_/D _3871_/B _5224_/Q gf180mcu_as_sc_mcu7t3v3__nand2_2
XFILLER_176_247 VDD VDD VSS VSS gf180mcu_as_sc_mcu7t3v3__fill_2
XTAP_TAPCELL_ROW_158_1_1918 VDD VSS gf180mcu_as_sc_mcu7t3v3__tap_2
X_2822_ VDD VDD VSS VSS _4974_/D _2829_/B _4760_/Q _4759_/D gf180mcu_as_sc_mcu7t3v3__mux2_2
XFILLER_176_269 VDD VDD VSS VSS gf180mcu_as_sc_mcu7t3v3__fill_2
XFILLER_76_2 VDD VDD VSS VSS gf180mcu_as_sc_mcu7t3v3__fill_2
XFILLER_9_972 VDD VDD VSS VSS gf180mcu_as_sc_mcu7t3v3__fillcap_8
X_2753_ VDD VDD VSS VSS _2833_/A _4975_/D _5478_/A _2780_/B _2754_/D gf180mcu_as_sc_mcu7t3v3__aoi31_2
XFILLER_191_228 VDD VDD VSS VSS gf180mcu_as_sc_mcu7t3v3__fill_2
X_2684_ VDD VDD VSS VSS _2735_/A _2684_/B _2684_/C _2736_/B _2686_/C gf180mcu_as_sc_mcu7t3v3__ao211_2
XFILLER_144_155 VDD VDD VSS VSS gf180mcu_as_sc_mcu7t3v3__fillcap_16
XFILLER_144_177 VDD VDD VSS VSS gf180mcu_as_sc_mcu7t3v3__fillcap_16
X_4423_ VDD VDD VSS VSS _4423_/B _4533_/A _4424_/D gf180mcu_as_sc_mcu7t3v3__and2_2
XFILLER_28_1103 VDD VDD VSS VSS gf180mcu_as_sc_mcu7t3v3__fillcap_16
X_4354_ VDD VDD VSS VSS _4354_/B _5159_/Q _4355_/A gf180mcu_as_sc_mcu7t3v3__xnor2_2
X_3305_ VDD VDD VSS VSS _3401_/B _3960_/A _3306_/D gf180mcu_as_sc_mcu7t3v3__and2_2
XFILLER_100_203 VDD VDD VSS VSS gf180mcu_as_sc_mcu7t3v3__fillcap_16
XFILLER_45_1472 VDD VDD VSS VSS gf180mcu_as_sc_mcu7t3v3__fill_2
X_4285_ VDD VDD VSS VSS _4289_/S _5481_/A _5119_/Q _5119_/D gf180mcu_as_sc_mcu7t3v3__mux2_2
XFILLER_132_1453 VDD VDD VSS VSS gf180mcu_as_sc_mcu7t3v3__fillcap_16
X_3236_ VDD VDD VSS VSS _3236_/D _3236_/A _3236_/B _3236_/C _3237_/C gf180mcu_as_sc_mcu7t3v3__ao31_2
XFILLER_104_37 VDD VDD VSS VSS gf180mcu_as_sc_mcu7t3v3__fillcap_8
X_3167_ VDD VDD VSS VSS _3176_/S _4143_/A _4145_/A _3170_/B gf180mcu_as_sc_mcu7t3v3__mux2_2
X_3098_ VDD VDD VSS VSS _3098_/Y _3098_/C _3141_/B _4075_/A gf180mcu_as_sc_mcu7t3v3__aoi21_2
XTAP_TAPCELL_ROW_202_2617 VDD VSS gf180mcu_as_sc_mcu7t3v3__tap_2
XTAP_TAPCELL_ROW_202_2606 VDD VSS gf180mcu_as_sc_mcu7t3v3__tap_2
XTAP_TAPCELL_ROW_198_2521 VDD VSS gf180mcu_as_sc_mcu7t3v3__tap_2
XFILLER_199_317 VDD VDD VSS VSS gf180mcu_as_sc_mcu7t3v3__fillcap_8
XTAP_TAPCELL_ROW_198_2532 VDD VSS gf180mcu_as_sc_mcu7t3v3__tap_2
XFILLER_120_69 VDD VDD VSS VSS gf180mcu_as_sc_mcu7t3v3__fillcap_16
XFILLER_35_1118 VDD VDD VSS VSS gf180mcu_as_sc_mcu7t3v3__fill_2
XPHY_EDGE_ROW_112_1_Left_322 VDD VSS gf180mcu_as_sc_mcu7t3v3__tap_2
XFILLER_10_426 VDD VDD VSS VSS gf180mcu_as_sc_mcu7t3v3__fillcap_16
XFILLER_195_556 VDD VDD VSS VSS gf180mcu_as_sc_mcu7t3v3__fillcap_4
XFILLER_195_578 VDD VDD VSS VSS gf180mcu_as_sc_mcu7t3v3__fillcap_16
XFILLER_210_376 VDD VDD VSS VSS gf180mcu_as_sc_mcu7t3v3__fillcap_4
Xwire829 VDD VDD VSS VSS wire829/A _4056_/D gf180mcu_as_sc_mcu7t3v3__clkbuff_12
XFILLER_100_1408 VDD VDD VSS VSS gf180mcu_as_sc_mcu7t3v3__fillcap_8
XFILLER_129_67 VDD VDD VSS VSS gf180mcu_as_sc_mcu7t3v3__fill_2
XFILLER_135_100 VDD VDD VSS VSS gf180mcu_as_sc_mcu7t3v3__fillcap_16
XFILLER_13_67 VDD VDD VSS VSS gf180mcu_as_sc_mcu7t3v3__fill_2
XFILLER_202_1189 VDD VDD VSS VSS gf180mcu_as_sc_mcu7t3v3__fillcap_16
XFILLER_202_6 VDD VDD VSS VSS gf180mcu_as_sc_mcu7t3v3__fillcap_16
XPHY_EDGE_ROW_178_Left_388 VDD VSS gf180mcu_as_sc_mcu7t3v3__tap_2
XFILLER_89_220 VDD VDD VSS VSS gf180mcu_as_sc_mcu7t3v3__fill_2
XFILLER_1_146 VDD VDD VSS VSS gf180mcu_as_sc_mcu7t3v3__fill_1
XFILLER_145_88 VDD VDD VSS VSS gf180mcu_as_sc_mcu7t3v3__fillcap_16
XFILLER_49_139 VDD VDD VSS VSS gf180mcu_as_sc_mcu7t3v3__fill_1
XPHY_EDGE_ROW_85_1_Right_606 VDD VSS gf180mcu_as_sc_mcu7t3v3__tap_2
XFILLER_111_1504 VDD VDD VSS VSS gf180mcu_as_sc_mcu7t3v3__fillcap_8
XFILLER_150_1520 VDD VDD VSS VSS gf180mcu_as_sc_mcu7t3v3__fill_1
XFILLER_24_1523 VDD VDD VSS VSS gf180mcu_as_sc_mcu7t3v3__fillcap_8
XFILLER_38_53 VDD VDD VSS VSS gf180mcu_as_sc_mcu7t3v3__fillcap_16
XFILLER_57_150 VDD VDD VSS VSS gf180mcu_as_sc_mcu7t3v3__fillcap_4
XFILLER_205_104 VDD VDD VSS VSS gf180mcu_as_sc_mcu7t3v3__fillcap_16
XPHY_EDGE_ROW_187_Left_397 VDD VSS gf180mcu_as_sc_mcu7t3v3__tap_2
XFILLER_26_592 VDD VDD VSS VSS gf180mcu_as_sc_mcu7t3v3__fill_2
XPHY_EDGE_ROW_44_1_Left_254 VDD VSS gf180mcu_as_sc_mcu7t3v3__tap_2
XFILLER_148_1493 VDD VDD VSS VSS gf180mcu_as_sc_mcu7t3v3__fill_2
XFILLER_109_1488 VDD VDD VSS VSS gf180mcu_as_sc_mcu7t3v3__fillcap_16
XFILLER_186_545 VDD VDD VSS VSS gf180mcu_as_sc_mcu7t3v3__fillcap_16
XFILLER_198_383 VDD VDD VSS VSS gf180mcu_as_sc_mcu7t3v3__fill_2
XFILLER_202_855 VDD VDD VSS VSS gf180mcu_as_sc_mcu7t3v3__fillcap_16
XFILLER_202_877 VDD VDD VSS VSS gf180mcu_as_sc_mcu7t3v3__fillcap_16
XFILLER_144_1379 VDD VDD VSS VSS gf180mcu_as_sc_mcu7t3v3__fill_2
XFILLER_16_1040 VDD VDD VSS VSS gf180mcu_as_sc_mcu7t3v3__fill_2
XTAP_TAPCELL_ROW_23_1241 VDD VSS gf180mcu_as_sc_mcu7t3v3__tap_2
XTAP_TAPCELL_ROW_23_1230 VDD VSS gf180mcu_as_sc_mcu7t3v3__tap_2
XFILLER_177_1100 VDD VDD VSS VSS gf180mcu_as_sc_mcu7t3v3__fillcap_16
XFILLER_70_84 VDD VDD VSS VSS gf180mcu_as_sc_mcu7t3v3__fill_2
XFILLER_9_279 VDD VDD VSS VSS gf180mcu_as_sc_mcu7t3v3__fill_1
XTAP_TAPCELL_ROW_12_988 VDD VSS gf180mcu_as_sc_mcu7t3v3__tap_2
Xclkload16 VDD VDD VSS VSS _4919_/CLK clkload16/Y gf180mcu_as_sc_mcu7t3v3__clkbuff_12
XFILLER_177_1122 VDD VDD VSS VSS gf180mcu_as_sc_mcu7t3v3__fillcap_16
XFILLER_182_762 VDD VDD VSS VSS gf180mcu_as_sc_mcu7t3v3__fillcap_16
XTAP_TAPCELL_ROW_12_999 VDD VSS gf180mcu_as_sc_mcu7t3v3__tap_2
Xclkload27 VDD VDD VSS VSS _5197_/CLK clkload27/Y gf180mcu_as_sc_mcu7t3v3__clkbuff_4
XFILLER_126_177 VDD VDD VSS VSS gf180mcu_as_sc_mcu7t3v3__fillcap_8
XFILLER_6_986 VDD VDD VSS VSS gf180mcu_as_sc_mcu7t3v3__fill_1
XFILLER_79_60 VDD VDD VSS VSS gf180mcu_as_sc_mcu7t3v3__fillcap_8
XFILLER_141_158 VDD VDD VSS VSS gf180mcu_as_sc_mcu7t3v3__fill_1
XFILLER_29_1467 VDD VDD VSS VSS gf180mcu_as_sc_mcu7t3v3__fill_2
XFILLER_9_1539 VDD VDD VSS VSS gf180mcu_as_sc_mcu7t3v3__fill_1
XFILLER_116_1448 VDD VDD VSS VSS gf180mcu_as_sc_mcu7t3v3__fill_2
XFILLER_64_1358 VDD VDD VSS VSS gf180mcu_as_sc_mcu7t3v3__fill_1
XFILLER_95_201 VDD VDD VSS VSS gf180mcu_as_sc_mcu7t3v3__fillcap_8
XFILLER_95_212 VDD VDD VSS VSS gf180mcu_as_sc_mcu7t3v3__fillcap_8
XFILLER_7_1230 VDD VDD VSS VSS gf180mcu_as_sc_mcu7t3v3__fillcap_8
XFILLER_7_1252 VDD VDD VSS VSS gf180mcu_as_sc_mcu7t3v3__fillcap_8
X_4070_ VDD VDD VSS VSS _4070_/A _4119_/B _4115_/B _4070_/D _4074_/A gf180mcu_as_sc_mcu7t3v3__ao211_2
X_3021_ VDD VDD VSS VSS _4001_/A _3130_/B _3021_/C _3021_/D _3022_/C gf180mcu_as_sc_mcu7t3v3__ao22_2
XFILLER_209_465 VDD VDD VSS VSS gf180mcu_as_sc_mcu7t3v3__fillcap_16
XFILLER_23_1066 VDD VDD VSS VSS gf180mcu_as_sc_mcu7t3v3__fill_1
XFILLER_23_1099 VDD VDD VSS VSS gf180mcu_as_sc_mcu7t3v3__fillcap_16
XFILLER_63_142 VDD VDD VSS VSS gf180mcu_as_sc_mcu7t3v3__fillcap_16
XFILLER_17_581 VDD VDD VSS VSS gf180mcu_as_sc_mcu7t3v3__fillcap_16
XFILLER_63_186 VDD VDD VSS VSS gf180mcu_as_sc_mcu7t3v3__fill_2
X_4972_ VDD VDD VSS VSS _5111_/CLK _4972_/D _4972_/Q gf180mcu_as_sc_mcu7t3v3__dfxtp_2
XFILLER_75_1465 VDD VDD VSS VSS gf180mcu_as_sc_mcu7t3v3__fillcap_4
XPHY_EDGE_ROW_56_3_Right_93 VDD VSS gf180mcu_as_sc_mcu7t3v3__tap_2
X_3923_ VDD VDD VSS VSS _3923_/B _3923_/A _3923_/Y gf180mcu_as_sc_mcu7t3v3__and2_2
XFILLER_127_1566 VDD VDD VSS VSS gf180mcu_as_sc_mcu7t3v3__fill_2
X_3854_ VDD VDD VSS VSS _5148_/Q _5147_/Q _3855_/C gf180mcu_as_sc_mcu7t3v3__or2_2
XFILLER_192_504 VDD VDD VSS VSS gf180mcu_as_sc_mcu7t3v3__fillcap_16
X_2805_ VDD VDD VSS VSS _2840_/D _2805_/A _2806_/C gf180mcu_as_sc_mcu7t3v3__and2_2
XFILLER_30_1004 VDD VDD VSS VSS gf180mcu_as_sc_mcu7t3v3__fillcap_8
XFILLER_34_1173 VDD VDD VSS VSS gf180mcu_as_sc_mcu7t3v3__fill_1
X_3785_ VDD VDD VSS VSS _3785_/B _3907_/A _4867_/D gf180mcu_as_sc_mcu7t3v3__and2_2
XFILLER_192_559 VDD VDD VSS VSS gf180mcu_as_sc_mcu7t3v3__fillcap_16
XFILLER_199_1380 VDD VDD VSS VSS gf180mcu_as_sc_mcu7t3v3__fillcap_16
X_2736_ VDD VDD VSS VSS _2737_/D _2736_/C _2736_/B _2736_/A gf180mcu_as_sc_mcu7t3v3__aoi21b_2
XFILLER_132_103 VDD VDD VSS VSS gf180mcu_as_sc_mcu7t3v3__fill_2
X_2667_ VDD VDD VSS VSS input9/Y _2722_/B _2667_/C _2668_/C _2729_/C gf180mcu_as_sc_mcu7t3v3__aoi211_2
X_4406_ VDD VDD VSS VSS _4407_/D _4406_/B _4521_/A gf180mcu_as_sc_mcu7t3v3__nor2_2
XFILLER_82_1447 VDD VDD VSS VSS gf180mcu_as_sc_mcu7t3v3__fillcap_4
X_2598_ VDD VDD VSS VSS _2598_/B _2598_/A _2599_/B gf180mcu_as_sc_mcu7t3v3__and2_2
XFILLER_134_1515 VDD VDD VSS VSS gf180mcu_as_sc_mcu7t3v3__fillcap_4
XFILLER_82_1469 VDD VDD VSS VSS gf180mcu_as_sc_mcu7t3v3__fillcap_16
XFILLER_8_1049 VDD VDD VSS VSS gf180mcu_as_sc_mcu7t3v3__fillcap_16
X_4337_ VDD VDD VSS VSS _4366_/S _4337_/B _5157_/Q _4345_/B gf180mcu_as_sc_mcu7t3v3__mux2_2
XTAP_TAPCELL_ROW_187_2288 VDD VSS gf180mcu_as_sc_mcu7t3v3__tap_2
XTAP_TAPCELL_ROW_187_2277 VDD VSS gf180mcu_as_sc_mcu7t3v3__tap_2
XFILLER_115_69 VDD VDD VSS VSS gf180mcu_as_sc_mcu7t3v3__fill_1
X_4268_ VDD VDD VSS VSS _4273_/S _5480_/A _5102_/Q _5102_/D gf180mcu_as_sc_mcu7t3v3__mux2_2
XFILLER_210_1425 VDD VDD VSS VSS gf180mcu_as_sc_mcu7t3v3__fill_2
X_3219_ VDD VDD VSS VSS _4801_/D _3219_/B _3844_/C gf180mcu_as_sc_mcu7t3v3__nor2_2
XTAP_TAPCELL_ROW_54_1_1608 VDD VSS gf180mcu_as_sc_mcu7t3v3__tap_2
XFILLER_27_312 VDD VDD VSS VSS gf180mcu_as_sc_mcu7t3v3__fillcap_4
XPHY_EDGE_ROW_66_3_Left_451 VDD VSS gf180mcu_as_sc_mcu7t3v3__tap_2
X_4199_ VDD VDD VSS VSS _4199_/Y _4228_/B _4199_/A gf180mcu_as_sc_mcu7t3v3__nor2_2
XFILLER_27_345 VDD VDD VSS VSS gf180mcu_as_sc_mcu7t3v3__fillcap_4
XFILLER_27_367 VDD VDD VSS VSS gf180mcu_as_sc_mcu7t3v3__fill_1
XFILLER_199_136 VDD VDD VSS VSS gf180mcu_as_sc_mcu7t3v3__fillcap_4
XFILLER_199_158 VDD VDD VSS VSS gf180mcu_as_sc_mcu7t3v3__fillcap_16
XFILLER_202_107 VDD VDD VSS VSS gf180mcu_as_sc_mcu7t3v3__fillcap_16
XFILLER_23_540 VDD VDD VSS VSS gf180mcu_as_sc_mcu7t3v3__fillcap_16
XFILLER_54_1538 VDD VDD VSS VSS gf180mcu_as_sc_mcu7t3v3__fill_2
XFILLER_180_1568 VDD VDD VSS VSS gf180mcu_as_sc_mcu7t3v3__fill_1
XFILLER_7_706 VDD VDD VSS VSS gf180mcu_as_sc_mcu7t3v3__fill_2
XFILLER_17_1393 VDD VDD VSS VSS gf180mcu_as_sc_mcu7t3v3__fillcap_4
XFILLER_195_386 VDD VDD VSS VSS gf180mcu_as_sc_mcu7t3v3__fillcap_16
XFILLER_108_177 VDD VDD VSS VSS gf180mcu_as_sc_mcu7t3v3__fillcap_16
XFILLER_139_1415 VDD VDD VSS VSS gf180mcu_as_sc_mcu7t3v3__fill_1
XFILLER_174_1328 VDD VDD VSS VSS gf180mcu_as_sc_mcu7t3v3__fillcap_16
XFILLER_2_400 VDD VDD VSS VSS gf180mcu_as_sc_mcu7t3v3__fill_1
XFILLER_6_2 VDD VDD VSS VSS gf180mcu_as_sc_mcu7t3v3__fillcap_16
XFILLER_77_212 VDD VDD VSS VSS gf180mcu_as_sc_mcu7t3v3__fillcap_8
XFILLER_172_53 VDD VDD VSS VSS gf180mcu_as_sc_mcu7t3v3__fillcap_16
XFILLER_49_96 VDD VDD VSS VSS gf180mcu_as_sc_mcu7t3v3__fill_2
XPHY_EDGE_ROW_86_1_Right_607 VDD VSS gf180mcu_as_sc_mcu7t3v3__tap_2
XPHY_EDGE_ROW_195_Left_405 VDD VSS gf180mcu_as_sc_mcu7t3v3__tap_2
Xfanout770 VDD VDD VSS VSS _2677_/Y _4272_/S gf180mcu_as_sc_mcu7t3v3__buff_12
Xfanout781 VDD VDD VSS VSS _5223_/Q _4703_/A gf180mcu_as_sc_mcu7t3v3__buff_12
Xfanout792 VDD VDD VSS VSS _4581_/A _4561_/A gf180mcu_as_sc_mcu7t3v3__buff_12
XFILLER_150_1383 VDD VDD VSS VSS gf180mcu_as_sc_mcu7t3v3__fillcap_8
XFILLER_185_1402 VDD VDD VSS VSS gf180mcu_as_sc_mcu7t3v3__fillcap_16
XFILLER_45_120 VDD VDD VSS VSS gf180mcu_as_sc_mcu7t3v3__fillcap_4
XTAP_TAPCELL_ROW_101_1_1747 VDD VSS gf180mcu_as_sc_mcu7t3v3__tap_2
XTAP_TAPCELL_ROW_113_3_3059 VDD VSS gf180mcu_as_sc_mcu7t3v3__tap_2
XFILLER_111_1378 VDD VDD VSS VSS gf180mcu_as_sc_mcu7t3v3__fill_1
XFILLER_206_435 VDD VDD VSS VSS gf180mcu_as_sc_mcu7t3v3__fillcap_16
XFILLER_45_142 VDD VDD VSS VSS gf180mcu_as_sc_mcu7t3v3__fillcap_16
XFILLER_65_84 VDD VDD VSS VSS gf180mcu_as_sc_mcu7t3v3__fillcap_4
XFILLER_98_1487 VDD VDD VSS VSS gf180mcu_as_sc_mcu7t3v3__fill_1
XFILLER_146_1419 VDD VDD VSS VSS gf180mcu_as_sc_mcu7t3v3__fill_1
XFILLER_206_457 VDD VDD VSS VSS gf180mcu_as_sc_mcu7t3v3__fillcap_16
XFILLER_209_1118 VDD VDD VSS VSS gf180mcu_as_sc_mcu7t3v3__fill_2
XFILLER_33_304 VDD VDD VSS VSS gf180mcu_as_sc_mcu7t3v3__fill_2
XFILLER_14_562 VDD VDD VSS VSS gf180mcu_as_sc_mcu7t3v3__fillcap_16
XFILLER_183_1170 VDD VDD VSS VSS gf180mcu_as_sc_mcu7t3v3__fillcap_16
XFILLER_183_1192 VDD VDD VSS VSS gf180mcu_as_sc_mcu7t3v3__fillcap_16
XFILLER_60_167 VDD VDD VSS VSS gf180mcu_as_sc_mcu7t3v3__fillcap_8
XFILLER_81_72 VDD VDD VSS VSS gf180mcu_as_sc_mcu7t3v3__fillcap_8
XFILLER_18_1157 VDD VDD VSS VSS gf180mcu_as_sc_mcu7t3v3__fill_1
XFILLER_197_72 VDD VDD VSS VSS gf180mcu_as_sc_mcu7t3v3__fillcap_16
XFILLER_146_217 VDD VDD VSS VSS gf180mcu_as_sc_mcu7t3v3__fillcap_4
XFILLER_161_1490 VDD VDD VSS VSS gf180mcu_as_sc_mcu7t3v3__fill_1
XFILLER_174_537 VDD VDD VSS VSS gf180mcu_as_sc_mcu7t3v3__fillcap_4
XFILLER_10_790 VDD VDD VSS VSS gf180mcu_as_sc_mcu7t3v3__fillcap_8
XFILLER_174_548 VDD VDD VSS VSS gf180mcu_as_sc_mcu7t3v3__fill_1
XFILLER_31_1357 VDD VDD VSS VSS gf180mcu_as_sc_mcu7t3v3__fillcap_16
X_3570_ VDD VDD VSS VSS _3926_/A _3652_/B _3658_/B _3925_/A _3571_/D gf180mcu_as_sc_mcu7t3v3__ao22_2
XFILLER_122_1485 VDD VDD VSS VSS gf180mcu_as_sc_mcu7t3v3__fillcap_16
XFILLER_161_209 VDD VDD VSS VSS gf180mcu_as_sc_mcu7t3v3__fill_1
X_2521_ VDD VDD VSS VSS _2522_/C _4331_/A _5270_/Q _5269_/Q gf180mcu_as_sc_mcu7t3v3__aoi21_2
XFILLER_182_592 VDD VDD VSS VSS gf180mcu_as_sc_mcu7t3v3__fill_2
XFILLER_5_282 VDD VDD VSS VSS gf180mcu_as_sc_mcu7t3v3__fillcap_16
X_5240_ VDD VDD VSS VSS _5241_/CLK _5240_/D _5240_/Q gf180mcu_as_sc_mcu7t3v3__dfxtp_2
XTAP_TAPCELL_ROW_166_3_3220 VDD VSS gf180mcu_as_sc_mcu7t3v3__tap_2
X_2452_ VDD VDD VSS VSS _2453_/C _4586_/S _5033_/Q _4546_/A gf180mcu_as_sc_mcu7t3v3__ao21_2
XFILLER_25_1117 VDD VDD VSS VSS gf180mcu_as_sc_mcu7t3v3__fill_2
XPHY_EDGE_ROW_18_Right_18 VDD VSS gf180mcu_as_sc_mcu7t3v3__tap_2
X_5171_ VDD VDD VSS VSS clkload9/A _5171_/D _5171_/Q gf180mcu_as_sc_mcu7t3v3__dfxtp_2
XFILLER_29_1297 VDD VDD VSS VSS gf180mcu_as_sc_mcu7t3v3__fillcap_16
X_4122_ VDD VDD VSS VSS _4122_/A _4122_/B _4122_/C _4122_/D _4123_/B gf180mcu_as_sc_mcu7t3v3__ao211_2
XFILLER_42_1453 VDD VDD VSS VSS gf180mcu_as_sc_mcu7t3v3__fillcap_16
X_4053_ VDD VDD VSS VSS _4053_/A _4101_/B _4101_/C _4053_/D _4055_/C gf180mcu_as_sc_mcu7t3v3__ao22_2
XFILLER_36_120 VDD VDD VSS VSS gf180mcu_as_sc_mcu7t3v3__fillcap_16
Xinput3 VDD VDD VSS VSS boot_addr[1] input3/Y gf180mcu_as_sc_mcu7t3v3__buff_12
X_3004_ VDD VDD VSS VSS _3985_/A _3079_/B _3004_/C _3004_/D _3005_/C gf180mcu_as_sc_mcu7t3v3__ao22_2
XTAP_TAPCELL_ROW_182_2185 VDD VSS gf180mcu_as_sc_mcu7t3v3__tap_2
XTAP_TAPCELL_ROW_182_2174 VDD VSS gf180mcu_as_sc_mcu7t3v3__tap_2
XFILLER_188_1081 VDD VDD VSS VSS gf180mcu_as_sc_mcu7t3v3__fillcap_4
XFILLER_36_164 VDD VDD VSS VSS gf180mcu_as_sc_mcu7t3v3__fillcap_4
XFILLER_36_186 VDD VDD VSS VSS gf180mcu_as_sc_mcu7t3v3__fillcap_8
XFILLER_101_27 VDD VDD VSS VSS gf180mcu_as_sc_mcu7t3v3__fillcap_16
XFILLER_101_49 VDD VDD VSS VSS gf180mcu_as_sc_mcu7t3v3__fill_1
XPHY_EDGE_ROW_27_Right_27 VDD VSS gf180mcu_as_sc_mcu7t3v3__tap_2
X_4955_ VDD VDD VSS VSS _5192_/CLK _4955_/D _4955_/Q gf180mcu_as_sc_mcu7t3v3__dfxtp_2
XFILLER_189_180 VDD VDD VSS VSS gf180mcu_as_sc_mcu7t3v3__fillcap_16
XFILLER_196_139 VDD VDD VSS VSS gf180mcu_as_sc_mcu7t3v3__fillcap_16
XFILLER_51_156 VDD VDD VSS VSS gf180mcu_as_sc_mcu7t3v3__fillcap_4
X_3906_ VDD VDD VSS VSS _3906_/S _3906_/B _4947_/Q _4947_/D gf180mcu_as_sc_mcu7t3v3__mux2_2
XFILLER_127_1396 VDD VDD VSS VSS gf180mcu_as_sc_mcu7t3v3__fill_2
XFILLER_32_381 VDD VDD VSS VSS gf180mcu_as_sc_mcu7t3v3__fillcap_4
X_4886_ VDD VDD VSS VSS _4924_/CLK _4886_/D _4886_/Q gf180mcu_as_sc_mcu7t3v3__dfxtp_2
XFILLER_203_1240 VDD VDD VSS VSS gf180mcu_as_sc_mcu7t3v3__fillcap_16
X_3837_ VDD VDD VSS VSS _3838_/B _4911_/Q _3839_/A gf180mcu_as_sc_mcu7t3v3__or2_2
XFILLER_14_1566 VDD VDD VSS VSS gf180mcu_as_sc_mcu7t3v3__fill_2
XFILLER_203_1262 VDD VDD VSS VSS gf180mcu_as_sc_mcu7t3v3__fillcap_16
X_3768_ VDD VDD VSS VSS _3768_/B _3795_/A _4865_/D gf180mcu_as_sc_mcu7t3v3__and2_2
XFILLER_152_209 VDD VDD VSS VSS gf180mcu_as_sc_mcu7t3v3__fillcap_8
XFILLER_195_1030 VDD VDD VSS VSS gf180mcu_as_sc_mcu7t3v3__fillcap_16
X_2719_ VDD VDD VSS VSS _5162_/Q _4267_/S _4279_/S _5186_/Q _2720_/B gf180mcu_as_sc_mcu7t3v3__ao22_2
XFILLER_195_1052 VDD VDD VSS VSS gf180mcu_as_sc_mcu7t3v3__fillcap_16
XFILLER_84_1509 VDD VDD VSS VSS gf180mcu_as_sc_mcu7t3v3__fillcap_4
X_3699_ VDD VDD VSS VSS _4075_/A _3758_/D _3699_/C _3699_/Y _3714_/D gf180mcu_as_sc_mcu7t3v3__aoi211_2
XTAP_TAPCELL_ROW_189_2339 VDD VSS gf180mcu_as_sc_mcu7t3v3__tap_2
XTAP_TAPCELL_ROW_189_2328 VDD VSS gf180mcu_as_sc_mcu7t3v3__tap_2
XFILLER_105_136 VDD VDD VSS VSS gf180mcu_as_sc_mcu7t3v3__fillcap_4
XPHY_EDGE_ROW_36_Right_36 VDD VSS gf180mcu_as_sc_mcu7t3v3__tap_2
Xoutput362 VDD VDD VSS VSS _4783_/Q se_out[12] gf180mcu_as_sc_mcu7t3v3__buff_12
Xoutput351 VDD VDD VSS VSS _4872_/Q east_out[33] gf180mcu_as_sc_mcu7t3v3__buff_12
Xoutput340 VDD VDD VSS VSS _4862_/Q east_out[23] gf180mcu_as_sc_mcu7t3v3__buff_12
XFILLER_47_1364 VDD VDD VSS VSS gf180mcu_as_sc_mcu7t3v3__fill_1
XFILLER_59_201 VDD VDD VSS VSS gf180mcu_as_sc_mcu7t3v3__fillcap_8
XFILLER_59_212 VDD VDD VSS VSS gf180mcu_as_sc_mcu7t3v3__fillcap_8
Xoutput395 VDD VDD VSS VSS _4816_/Q south_out[11] gf180mcu_as_sc_mcu7t3v3__buff_12
Xoutput384 VDD VDD VSS VSS _4803_/Q se_out[32] gf180mcu_as_sc_mcu7t3v3__buff_12
Xoutput373 VDD VDD VSS VSS _4793_/Q se_out[22] gf180mcu_as_sc_mcu7t3v3__buff_12
XFILLER_210_1200 VDD VDD VSS VSS gf180mcu_as_sc_mcu7t3v3__fill_1
XFILLER_21_1504 VDD VDD VSS VSS gf180mcu_as_sc_mcu7t3v3__fillcap_16
XTAP_TAPCELL_ROW_73_1_1663 VDD VSS gf180mcu_as_sc_mcu7t3v3__tap_2
XFILLER_210_1255 VDD VDD VSS VSS gf180mcu_as_sc_mcu7t3v3__fill_2
XFILLER_27_131 VDD VDD VSS VSS gf180mcu_as_sc_mcu7t3v3__fillcap_8
XFILLER_27_142 VDD VDD VSS VSS gf180mcu_as_sc_mcu7t3v3__fillcap_16
XTAP_TAPCELL_ROW_3_797 VDD VSS gf180mcu_as_sc_mcu7t3v3__tap_2
XTAP_TAPCELL_ROW_3_786 VDD VSS gf180mcu_as_sc_mcu7t3v3__tap_2
XFILLER_15_326 VDD VDD VSS VSS gf180mcu_as_sc_mcu7t3v3__fillcap_16
XFILLER_28_687 VDD VDD VSS VSS gf180mcu_as_sc_mcu7t3v3__fill_1
XFILLER_35_43 VDD VDD VSS VSS gf180mcu_as_sc_mcu7t3v3__fillcap_4
XTAP_TAPCELL_ROW_83_3_2969 VDD VSS gf180mcu_as_sc_mcu7t3v3__tap_2
XFILLER_188_629 VDD VDD VSS VSS gf180mcu_as_sc_mcu7t3v3__fillcap_16
XFILLER_203_416 VDD VDD VSS VSS gf180mcu_as_sc_mcu7t3v3__fillcap_4
XFILLER_203_438 VDD VDD VSS VSS gf180mcu_as_sc_mcu7t3v3__fillcap_16
XFILLER_42_123 VDD VDD VSS VSS gf180mcu_as_sc_mcu7t3v3__fillcap_16
XFILLER_42_145 VDD VDD VSS VSS gf180mcu_as_sc_mcu7t3v3__fill_1
XFILLER_145_1485 VDD VDD VSS VSS gf180mcu_as_sc_mcu7t3v3__fill_1
XFILLER_180_1343 VDD VDD VSS VSS gf180mcu_as_sc_mcu7t3v3__fillcap_16
XFILLER_208_1173 VDD VDD VSS VSS gf180mcu_as_sc_mcu7t3v3__fillcap_16
XTAP_TAPCELL_ROW_159_1_1923 VDD VSS gf180mcu_as_sc_mcu7t3v3__tap_2
Xwire467 VDD VDD VSS VSS _3631_/Y _4847_/D gf180mcu_as_sc_mcu7t3v3__clkbuff_12
XFILLER_7_569 VDD VDD VSS VSS gf180mcu_as_sc_mcu7t3v3__fill_2
Xwire478 VDD VDD VSS VSS _2965_/Y _4772_/D gf180mcu_as_sc_mcu7t3v3__clkbuff_12
Xwire489 VDD VDD VSS VSS _3165_/Y _4796_/D gf180mcu_as_sc_mcu7t3v3__clkbuff_12
XFILLER_151_220 VDD VDD VSS VSS gf180mcu_as_sc_mcu7t3v3__fill_2
XFILLER_174_1158 VDD VDD VSS VSS gf180mcu_as_sc_mcu7t3v3__fillcap_8
XFILLER_191_1461 VDD VDD VSS VSS gf180mcu_as_sc_mcu7t3v3__fillcap_8
XFILLER_111_139 VDD VDD VSS VSS gf180mcu_as_sc_mcu7t3v3__fill_1
XFILLER_152_1445 VDD VDD VSS VSS gf180mcu_as_sc_mcu7t3v3__fillcap_4
XFILLER_191_1472 VDD VDD VSS VSS gf180mcu_as_sc_mcu7t3v3__fillcap_16
XFILLER_26_1437 VDD VDD VSS VSS gf180mcu_as_sc_mcu7t3v3__fillcap_16
XFILLER_113_1429 VDD VDD VSS VSS gf180mcu_as_sc_mcu7t3v3__fillcap_16
XTAP_TAPCELL_ROW_14_1037 VDD VSS gf180mcu_as_sc_mcu7t3v3__tap_2
XTAP_TAPCELL_ROW_14_1048 VDD VSS gf180mcu_as_sc_mcu7t3v3__tap_2
XFILLER_19_632 VDD VDD VSS VSS gf180mcu_as_sc_mcu7t3v3__fillcap_4
XFILLER_4_1222 VDD VDD VSS VSS gf180mcu_as_sc_mcu7t3v3__fill_2
XPHY_EDGE_ROW_87_1_Right_608 VDD VSS gf180mcu_as_sc_mcu7t3v3__tap_2
XFILLER_20_1014 VDD VDD VSS VSS gf180mcu_as_sc_mcu7t3v3__fill_1
XFILLER_202_37 VDD VDD VSS VSS gf180mcu_as_sc_mcu7t3v3__fillcap_16
XFILLER_207_766 VDD VDD VSS VSS gf180mcu_as_sc_mcu7t3v3__fillcap_4
XFILLER_34_613 VDD VDD VSS VSS gf180mcu_as_sc_mcu7t3v3__fillcap_8
XFILLER_179_607 VDD VDD VSS VSS gf180mcu_as_sc_mcu7t3v3__fillcap_4
XFILLER_179_629 VDD VDD VSS VSS gf180mcu_as_sc_mcu7t3v3__fill_1
XFILLER_207_788 VDD VDD VSS VSS gf180mcu_as_sc_mcu7t3v3__fillcap_16
XFILLER_178_139 VDD VDD VSS VSS gf180mcu_as_sc_mcu7t3v3__fillcap_16
XFILLER_92_93 VDD VDD VSS VSS gf180mcu_as_sc_mcu7t3v3__fill_1
XFILLER_14_381 VDD VDD VSS VSS gf180mcu_as_sc_mcu7t3v3__fillcap_4
XFILLER_37_1555 VDD VDD VSS VSS gf180mcu_as_sc_mcu7t3v3__fill_1
XFILLER_37_1566 VDD VDD VSS VSS gf180mcu_as_sc_mcu7t3v3__fill_2
X_4740_ VDD VDD VSS VSS _4740_/B _4750_/B _5271_/D gf180mcu_as_sc_mcu7t3v3__and2_2
XFILLER_30_874 VDD VDD VSS VSS gf180mcu_as_sc_mcu7t3v3__fill_1
XFILLER_72_1479 VDD VDD VSS VSS gf180mcu_as_sc_mcu7t3v3__fillcap_16
X_4671_ VDD VDD VSS VSS _5113_/Q _4731_/B _4681_/C _5244_/Q _4672_/C gf180mcu_as_sc_mcu7t3v3__ao22_2
XFILLER_179_1014 VDD VDD VSS VSS gf180mcu_as_sc_mcu7t3v3__fillcap_16
XFILLER_186_183 VDD VDD VSS VSS gf180mcu_as_sc_mcu7t3v3__fill_1
XFILLER_31_1132 VDD VDD VSS VSS gf180mcu_as_sc_mcu7t3v3__fill_1
X_3622_ VDD VDD VSS VSS _3623_/B _3993_/A _3675_/B _3622_/C gf180mcu_as_sc_mcu7t3v3__ao21_2
XFILLER_183_890 VDD VDD VSS VSS gf180mcu_as_sc_mcu7t3v3__fillcap_16
XFILLER_196_1361 VDD VDD VSS VSS gf180mcu_as_sc_mcu7t3v3__fillcap_4
X_3553_ VDD VDD VSS VSS _3801_/C _3814_/A _3553_/A gf180mcu_as_sc_mcu7t3v3__nor2b_2
XTAP_TAPCELL_ROW_78_1_1678 VDD VSS gf180mcu_as_sc_mcu7t3v3__tap_2
XFILLER_142_220 VDD VDD VSS VSS gf180mcu_as_sc_mcu7t3v3__fill_2
XFILLER_196_1383 VDD VDD VSS VSS gf180mcu_as_sc_mcu7t3v3__fillcap_16
X_3484_ VDD VDD VSS VSS _3484_/B _3525_/A _4830_/D gf180mcu_as_sc_mcu7t3v3__and2_2
X_2504_ VDD VDD VSS VSS _2546_/B _2546_/A _2745_/A gf180mcu_as_sc_mcu7t3v3__xnor2_2
X_5223_ VDD VDD VSS VSS _5233_/CLK _5223_/D _5223_/Q gf180mcu_as_sc_mcu7t3v3__dfxtp_2
X_2435_ VDD VDD VSS VSS _4043_/A _2435_/A gf180mcu_as_sc_mcu7t3v3__inv_2
XTAP_TAPCELL_ROW_184_2214 VDD VSS gf180mcu_as_sc_mcu7t3v3__tap_2
XFILLER_102_139 VDD VDD VSS VSS gf180mcu_as_sc_mcu7t3v3__fill_2
XFILLER_170_1523 VDD VDD VSS VSS gf180mcu_as_sc_mcu7t3v3__fillcap_16
XFILLER_29_1083 VDD VDD VSS VSS gf180mcu_as_sc_mcu7t3v3__fillcap_16
XFILLER_9_1133 VDD VDD VSS VSS gf180mcu_as_sc_mcu7t3v3__fillcap_16
XPHY_EDGE_ROW_121_1_Left_331 VDD VSS gf180mcu_as_sc_mcu7t3v3__tap_2
X_5154_ VDD VDD VSS VSS _5198_/CLK _5154_/D _5154_/Q gf180mcu_as_sc_mcu7t3v3__dfxtp_2
XTAP_TAPCELL_ROW_184_2225 VDD VSS gf180mcu_as_sc_mcu7t3v3__tap_2
X_4105_ VDD VDD VSS VSS _4105_/A _4105_/B _4105_/C _4105_/D _4106_/B gf180mcu_as_sc_mcu7t3v3__ao211_2
XFILLER_110_172 VDD VDD VSS VSS gf180mcu_as_sc_mcu7t3v3__fill_2
X_5085_ VDD VDD VSS VSS _5085_/CLK _5085_/D _5085_/Q gf180mcu_as_sc_mcu7t3v3__dfxtp_2
XTAP_TAPCELL_ROW_0_701 VDD VSS gf180mcu_as_sc_mcu7t3v3__tap_2
XTAP_TAPCELL_ROW_0_712 VDD VSS gf180mcu_as_sc_mcu7t3v3__tap_2
X_4036_ VDD VDD VSS VSS _4990_/Q _4166_/B _4241_/B _4166_/D _4990_/D gf180mcu_as_sc_mcu7t3v3__ao22_2
XFILLER_112_37 VDD VDD VSS VSS gf180mcu_as_sc_mcu7t3v3__fill_2
XFILLER_24_101 VDD VDD VSS VSS gf180mcu_as_sc_mcu7t3v3__fillcap_4
XFILLER_25_624 VDD VDD VSS VSS gf180mcu_as_sc_mcu7t3v3__fillcap_4
XTAP_TAPCELL_ROW_0_723 VDD VSS gf180mcu_as_sc_mcu7t3v3__tap_2
XTAP_TAPCELL_ROW_0_734 VDD VSS gf180mcu_as_sc_mcu7t3v3__tap_2
XFILLER_24_123 VDD VDD VSS VSS gf180mcu_as_sc_mcu7t3v3__fillcap_4
XFILLER_13_819 VDD VDD VSS VSS gf180mcu_as_sc_mcu7t3v3__fillcap_8
XFILLER_24_167 VDD VDD VSS VSS gf180mcu_as_sc_mcu7t3v3__fillcap_8
X_4938_ VDD VDD VSS VSS _5197_/CLK _4938_/D _4938_/Q gf180mcu_as_sc_mcu7t3v3__dfxtp_2
XANTENNA_30 VDD VDD VSS VSS _4539_/D gf180mcu_as_sc_mcu7t3v3__diode_2
XFILLER_193_610 VDD VDD VSS VSS gf180mcu_as_sc_mcu7t3v3__fillcap_16
XFILLER_36_1087 VDD VDD VSS VSS gf180mcu_as_sc_mcu7t3v3__fill_1
X_4869_ VDD VDD VSS VSS _4869_/CLK _4869_/D _4869_/Q gf180mcu_as_sc_mcu7t3v3__dfxtp_2
XFILLER_177_194 VDD VDD VSS VSS gf180mcu_as_sc_mcu7t3v3__fill_1
XFILLER_193_632 VDD VDD VSS VSS gf180mcu_as_sc_mcu7t3v3__fillcap_16
XFILLER_125_209 VDD VDD VSS VSS gf180mcu_as_sc_mcu7t3v3__fill_1
XFILLER_21_34 VDD VDD VSS VSS gf180mcu_as_sc_mcu7t3v3__fillcap_16
XFILLER_10_1227 VDD VDD VSS VSS gf180mcu_as_sc_mcu7t3v3__fillcap_16
XFILLER_192_197 VDD VDD VSS VSS gf180mcu_as_sc_mcu7t3v3__fill_2
XFILLER_49_1415 VDD VDD VSS VSS gf180mcu_as_sc_mcu7t3v3__fill_1
XFILLER_88_1464 VDD VDD VSS VSS gf180mcu_as_sc_mcu7t3v3__fill_2
XFILLER_101_1377 VDD VDD VSS VSS gf180mcu_as_sc_mcu7t3v3__fillcap_16
XFILLER_133_220 VDD VDD VSS VSS gf180mcu_as_sc_mcu7t3v3__fill_2
XFILLER_137_67 VDD VDD VSS VSS gf180mcu_as_sc_mcu7t3v3__fill_2
XFILLER_175_1434 VDD VDD VSS VSS gf180mcu_as_sc_mcu7t3v3__fillcap_16
XFILLER_97_27 VDD VDD VSS VSS gf180mcu_as_sc_mcu7t3v3__fillcap_16
XPHY_EDGE_ROW_53_1_Left_263 VDD VSS gf180mcu_as_sc_mcu7t3v3__tap_2
XFILLER_0_756 VDD VDD VSS VSS gf180mcu_as_sc_mcu7t3v3__fill_1
XFILLER_5_1542 VDD VDD VSS VSS gf180mcu_as_sc_mcu7t3v3__fill_2
XFILLER_60_1383 VDD VDD VSS VSS gf180mcu_as_sc_mcu7t3v3__fillcap_16
XFILLER_112_1484 VDD VDD VSS VSS gf180mcu_as_sc_mcu7t3v3__fill_1
XFILLER_210_1085 VDD VDD VSS VSS gf180mcu_as_sc_mcu7t3v3__fill_2
XFILLER_46_53 VDD VDD VSS VSS gf180mcu_as_sc_mcu7t3v3__fillcap_16
XFILLER_15_134 VDD VDD VSS VSS gf180mcu_as_sc_mcu7t3v3__fillcap_4
XFILLER_56_1408 VDD VDD VSS VSS gf180mcu_as_sc_mcu7t3v3__fillcap_16
XFILLER_147_1558 VDD VDD VSS VSS gf180mcu_as_sc_mcu7t3v3__fillcap_8
XFILLER_204_769 VDD VDD VSS VSS gf180mcu_as_sc_mcu7t3v3__fillcap_16
XFILLER_95_1479 VDD VDD VSS VSS gf180mcu_as_sc_mcu7t3v3__fillcap_4
XFILLER_197_960 VDD VDD VSS VSS gf180mcu_as_sc_mcu7t3v3__fillcap_16
XFILLER_30_104 VDD VDD VSS VSS gf180mcu_as_sc_mcu7t3v3__fill_1
XFILLER_11_340 VDD VDD VSS VSS gf180mcu_as_sc_mcu7t3v3__fillcap_8
XFILLER_12_874 VDD VDD VSS VSS gf180mcu_as_sc_mcu7t3v3__fill_1
XFILLER_15_1116 VDD VDD VSS VSS gf180mcu_as_sc_mcu7t3v3__fillcap_4
XFILLER_180_1151 VDD VDD VSS VSS gf180mcu_as_sc_mcu7t3v3__fillcap_4
XFILLER_180_1173 VDD VDD VSS VSS gf180mcu_as_sc_mcu7t3v3__fillcap_16
XFILLER_197_982 VDD VDD VSS VSS gf180mcu_as_sc_mcu7t3v3__fillcap_16
XFILLER_200_942 VDD VDD VSS VSS gf180mcu_as_sc_mcu7t3v3__fill_2
XFILLER_62_74 VDD VDD VSS VSS gf180mcu_as_sc_mcu7t3v3__fillcap_16
XFILLER_8_823 VDD VDD VSS VSS gf180mcu_as_sc_mcu7t3v3__fillcap_16
XFILLER_15_1149 VDD VDD VSS VSS gf180mcu_as_sc_mcu7t3v3__fillcap_16
XFILLER_178_85 VDD VDD VSS VSS gf180mcu_as_sc_mcu7t3v3__fillcap_16
XFILLER_183_120 VDD VDD VSS VSS gf180mcu_as_sc_mcu7t3v3__fillcap_16
XFILLER_183_153 VDD VDD VSS VSS gf180mcu_as_sc_mcu7t3v3__fill_2
XFILLER_183_164 VDD VDD VSS VSS gf180mcu_as_sc_mcu7t3v3__fill_1
XFILLER_32_1463 VDD VDD VSS VSS gf180mcu_as_sc_mcu7t3v3__fill_1
XFILLER_67_1504 VDD VDD VSS VSS gf180mcu_as_sc_mcu7t3v3__fill_2
XFILLER_124_220 VDD VDD VSS VSS gf180mcu_as_sc_mcu7t3v3__fill_2
XFILLER_180_893 VDD VDD VSS VSS gf180mcu_as_sc_mcu7t3v3__fillcap_16
XFILLER_97_104 VDD VDD VSS VSS gf180mcu_as_sc_mcu7t3v3__fillcap_16
Xclkbuf_leaf_1_clk_regs VDD VDD VSS VSS clkbuf_leaf_2_clk_regs/A _4904_/CLK gf180mcu_as_sc_mcu7t3v3__clkbuff_12
XTAP_TAPCELL_ROW_33_1446 VDD VSS gf180mcu_as_sc_mcu7t3v3__tap_2
XTAP_TAPCELL_ROW_33_1457 VDD VSS gf180mcu_as_sc_mcu7t3v3__tap_2
XPHY_EDGE_ROW_88_1_Right_609 VDD VSS gf180mcu_as_sc_mcu7t3v3__tap_2
XFILLER_53_207 VDD VDD VSS VSS gf180mcu_as_sc_mcu7t3v3__fill_2
XTAP_TAPCELL_ROW_53_3_2880 VDD VSS gf180mcu_as_sc_mcu7t3v3__tap_2
XFILLER_74_1519 VDD VDD VSS VSS gf180mcu_as_sc_mcu7t3v3__fill_2
XFILLER_185_1084 VDD VDD VSS VSS gf180mcu_as_sc_mcu7t3v3__fillcap_16
XFILLER_34_454 VDD VDD VSS VSS gf180mcu_as_sc_mcu7t3v3__fill_1
XFILLER_35_977 VDD VDD VSS VSS gf180mcu_as_sc_mcu7t3v3__fill_2
XFILLER_22_638 VDD VDD VSS VSS gf180mcu_as_sc_mcu7t3v3__fillcap_4
X_2984_ VDD VDD VSS VSS _3078_/B _4919_/Q _2987_/C gf180mcu_as_sc_mcu7t3v3__or2_2
XTAP_TAPCELL_ROW_177_2062 VDD VSS gf180mcu_as_sc_mcu7t3v3__tap_2
XFILLER_128_1491 VDD VDD VSS VSS gf180mcu_as_sc_mcu7t3v3__fillcap_4
XFILLER_210_739 VDD VDD VSS VSS gf180mcu_as_sc_mcu7t3v3__fill_2
XFILLER_21_137 VDD VDD VSS VSS gf180mcu_as_sc_mcu7t3v3__fill_2
X_4723_ VDD VDD VSS VSS _4723_/B _4723_/A _5262_/D gf180mcu_as_sc_mcu7t3v3__or2_2
XTAP_TAPCELL_ROW_177_2073 VDD VSS gf180mcu_as_sc_mcu7t3v3__tap_2
XFILLER_175_632 VDD VDD VSS VSS gf180mcu_as_sc_mcu7t3v3__fillcap_16
XFILLER_187_492 VDD VDD VSS VSS gf180mcu_as_sc_mcu7t3v3__fillcap_16
XFILLER_50_1530 VDD VDD VSS VSS gf180mcu_as_sc_mcu7t3v3__fill_1
XFILLER_159_1418 VDD VDD VSS VSS gf180mcu_as_sc_mcu7t3v3__fillcap_4
XFILLER_190_613 VDD VDD VSS VSS gf180mcu_as_sc_mcu7t3v3__fillcap_16
XFILLER_200_1221 VDD VDD VSS VSS gf180mcu_as_sc_mcu7t3v3__fillcap_4
X_4654_ VDD VDD VSS VSS _4659_/B _4654_/B _5237_/Q _5237_/D gf180mcu_as_sc_mcu7t3v3__mux2_2
XFILLER_200_1243 VDD VDD VSS VSS gf180mcu_as_sc_mcu7t3v3__fillcap_16
Xinput50 VDD VDD VSS VSS east_in[15] _4055_/A gf180mcu_as_sc_mcu7t3v3__buff_12
Xinput61 VDD VDD VSS VSS east_in[25] wire845/A gf180mcu_as_sc_mcu7t3v3__buff_12
Xinput72 VDD VDD VSS VSS east_in[4] _3968_/A gf180mcu_as_sc_mcu7t3v3__buff_12
X_4585_ VDD VDD VSS VSS _4588_/C _5001_/Q _4585_/A gf180mcu_as_sc_mcu7t3v3__nand2b_2
X_3605_ VDD VDD VSS VSS _3976_/A _3652_/B _3658_/B _3976_/D _3606_/D gf180mcu_as_sc_mcu7t3v3__ao22_2
XFILLER_115_220 VDD VDD VSS VSS gf180mcu_as_sc_mcu7t3v3__fill_2
XFILLER_192_1011 VDD VDD VSS VSS gf180mcu_as_sc_mcu7t3v3__fillcap_4
XPHY_EDGE_ROW_75_3_Left_460 VDD VSS gf180mcu_as_sc_mcu7t3v3__tap_2
XTAP_TAPCELL_ROW_122_1_1810 VDD VSS gf180mcu_as_sc_mcu7t3v3__tap_2
XTAP_TAPCELL_ROW_134_3_3122 VDD VSS gf180mcu_as_sc_mcu7t3v3__tap_2
Xinput83 VDD VDD VSS VSS ne_in[14] wire830/A gf180mcu_as_sc_mcu7t3v3__buff_12
Xinput94 VDD VDD VSS VSS ne_in[24] _4126_/A gf180mcu_as_sc_mcu7t3v3__buff_12
Xmax_cap542 VDD VDD VSS VSS _3367_/A _3408_/B gf180mcu_as_sc_mcu7t3v3__clkbuff_12
X_3536_ VDD VDD VSS VSS _3790_/C _3932_/B _3537_/A gf180mcu_as_sc_mcu7t3v3__nand2_2
XFILLER_192_1033 VDD VDD VSS VSS gf180mcu_as_sc_mcu7t3v3__fillcap_16
XFILLER_88_104 VDD VDD VSS VSS gf180mcu_as_sc_mcu7t3v3__fill_1
X_4892__1075 VDD VDD VSS VSS _4892_/D gf180mcu_as_sc_mcu7t3v3__tiel_4
XFILLER_48_1481 VDD VDD VSS VSS gf180mcu_as_sc_mcu7t3v3__fillcap_16
X_5206_ VDD VDD VSS VSS _5216_/CLK _5206_/D _5206_/Q gf180mcu_as_sc_mcu7t3v3__dfxtp_2
X_3467_ VDD VDD VSS VSS _4118_/A _3467_/B _3467_/C _4119_/A _3468_/D gf180mcu_as_sc_mcu7t3v3__ao22_2
X_3398_ VDD VDD VSS VSS _4048_/A _3453_/B _3398_/C _3398_/D _3399_/B gf180mcu_as_sc_mcu7t3v3__ao211_2
X_2418_ VDD VDD VSS VSS _3236_/A _3254_/A gf180mcu_as_sc_mcu7t3v3__inv_2
XTAP_TAPCELL_ROW_5_848 VDD VSS gf180mcu_as_sc_mcu7t3v3__tap_2
XTAP_TAPCELL_ROW_5_837 VDD VSS gf180mcu_as_sc_mcu7t3v3__tap_2
XFILLER_170_1364 VDD VDD VSS VSS gf180mcu_as_sc_mcu7t3v3__fillcap_8
XFILLER_44_1378 VDD VDD VSS VSS gf180mcu_as_sc_mcu7t3v3__fill_2
X_5137_ VDD VDD VSS VSS _5197_/CLK _5137_/D _5137_/Q gf180mcu_as_sc_mcu7t3v3__dfxtp_2
XTAP_TAPCELL_ROW_209_2773 VDD VSS gf180mcu_as_sc_mcu7t3v3__tap_2
XTAP_TAPCELL_ROW_209_2762 VDD VSS gf180mcu_as_sc_mcu7t3v3__tap_2
XFILLER_131_1348 VDD VDD VSS VSS gf180mcu_as_sc_mcu7t3v3__fillcap_8
XTAP_TAPCELL_ROW_102_1_1752 VDD VSS gf180mcu_as_sc_mcu7t3v3__tap_2
XTAP_TAPCELL_ROW_114_3_3064 VDD VSS gf180mcu_as_sc_mcu7t3v3__tap_2
X_5068_ VDD VDD VSS VSS _5068_/CLK _5068_/D _5068_/Q gf180mcu_as_sc_mcu7t3v3__dfxtp_2
XFILLER_123_69 VDD VDD VSS VSS gf180mcu_as_sc_mcu7t3v3__fill_1
X_4019_ VDD VDD VSS VSS _4019_/B _4107_/A _4239_/B gf180mcu_as_sc_mcu7t3v3__and2_2
XFILLER_0_1461 VDD VDD VSS VSS gf180mcu_as_sc_mcu7t3v3__fill_1
XFILLER_197_212 VDD VDD VSS VSS gf180mcu_as_sc_mcu7t3v3__fillcap_16
XPHY_EDGE_ROW_0_Right_0 VDD VSS gf180mcu_as_sc_mcu7t3v3__tap_2
XFILLER_16_1403 VDD VDD VSS VSS gf180mcu_as_sc_mcu7t3v3__fillcap_8
XFILLER_179_960 VDD VDD VSS VSS gf180mcu_as_sc_mcu7t3v3__fillcap_16
XFILLER_107_1553 VDD VDD VSS VSS gf180mcu_as_sc_mcu7t3v3__fill_2
XFILLER_142_1433 VDD VDD VSS VSS gf180mcu_as_sc_mcu7t3v3__fill_2
XFILLER_16_1425 VDD VDD VSS VSS gf180mcu_as_sc_mcu7t3v3__fillcap_8
XFILLER_179_982 VDD VDD VSS VSS gf180mcu_as_sc_mcu7t3v3__fillcap_16
XFILLER_205_1154 VDD VDD VSS VSS gf180mcu_as_sc_mcu7t3v3__fillcap_16
XFILLER_142_1499 VDD VDD VSS VSS gf180mcu_as_sc_mcu7t3v3__fillcap_4
XFILLER_165_142 VDD VDD VSS VSS gf180mcu_as_sc_mcu7t3v3__fillcap_4
XFILLER_194_963 VDD VDD VSS VSS gf180mcu_as_sc_mcu7t3v3__fillcap_16
XFILLER_20_181 VDD VDD VSS VSS gf180mcu_as_sc_mcu7t3v3__fill_1
XFILLER_32_77 VDD VDD VSS VSS gf180mcu_as_sc_mcu7t3v3__fillcap_4
XFILLER_165_175 VDD VDD VSS VSS gf180mcu_as_sc_mcu7t3v3__fill_2
XFILLER_180_101 VDD VDD VSS VSS gf180mcu_as_sc_mcu7t3v3__fillcap_4
XFILLER_180_123 VDD VDD VSS VSS gf180mcu_as_sc_mcu7t3v3__fillcap_16
XFILLER_193_484 VDD VDD VSS VSS gf180mcu_as_sc_mcu7t3v3__fillcap_4
XFILLER_4_303 VDD VDD VSS VSS gf180mcu_as_sc_mcu7t3v3__fillcap_4
XFILLER_5_837 VDD VDD VSS VSS gf180mcu_as_sc_mcu7t3v3__fill_2
XFILLER_10_1079 VDD VDD VSS VSS gf180mcu_as_sc_mcu7t3v3__fillcap_4
XFILLER_121_212 VDD VDD VSS VSS gf180mcu_as_sc_mcu7t3v3__fillcap_8
XFILLER_79_137 VDD VDD VSS VSS gf180mcu_as_sc_mcu7t3v3__fill_2
XTAP_TAPCELL_ROW_58_3_2895 VDD VSS gf180mcu_as_sc_mcu7t3v3__tap_2
XFILLER_153_1540 VDD VDD VSS VSS gf180mcu_as_sc_mcu7t3v3__fillcap_16
XFILLER_164_98 VDD VDD VSS VSS gf180mcu_as_sc_mcu7t3v3__fillcap_4
XFILLER_62_1423 VDD VDD VSS VSS gf180mcu_as_sc_mcu7t3v3__fill_2
XFILLER_94_107 VDD VDD VSS VSS gf180mcu_as_sc_mcu7t3v3__fillcap_16
XFILLER_0_586 VDD VDD VSS VSS gf180mcu_as_sc_mcu7t3v3__fill_1
XFILLER_23_1418 VDD VDD VSS VSS gf180mcu_as_sc_mcu7t3v3__fillcap_4
XFILLER_57_52 VDD VDD VSS VSS gf180mcu_as_sc_mcu7t3v3__fillcap_16
XFILLER_114_1568 VDD VDD VSS VSS gf180mcu_as_sc_mcu7t3v3__fill_1
XFILLER_180_53 VDD VDD VSS VSS gf180mcu_as_sc_mcu7t3v3__fillcap_16
XFILLER_97_1508 VDD VDD VSS VSS gf180mcu_as_sc_mcu7t3v3__fillcap_4
XTAP_TAPCELL_ROW_160_3_3201 VDD VSS gf180mcu_as_sc_mcu7t3v3__tap_2
XFILLER_5_1394 VDD VDD VSS VSS gf180mcu_as_sc_mcu7t3v3__fillcap_4
XFILLER_189_702 VDD VDD VSS VSS gf180mcu_as_sc_mcu7t3v3__fillcap_16
XFILLER_1_1258 VDD VDD VSS VSS gf180mcu_as_sc_mcu7t3v3__fill_2
XFILLER_16_465 VDD VDD VSS VSS gf180mcu_as_sc_mcu7t3v3__fillcap_4
XFILLER_17_999 VDD VDD VSS VSS gf180mcu_as_sc_mcu7t3v3__fillcap_16
XFILLER_186_1371 VDD VDD VSS VSS gf180mcu_as_sc_mcu7t3v3__fill_1
XFILLER_32_914 VDD VDD VSS VSS gf180mcu_as_sc_mcu7t3v3__fillcap_16
XFILLER_73_62 VDD VDD VSS VSS gf180mcu_as_sc_mcu7t3v3__fillcap_8
XFILLER_147_1355 VDD VDD VSS VSS gf180mcu_as_sc_mcu7t3v3__fillcap_16
XFILLER_16_498 VDD VDD VSS VSS gf180mcu_as_sc_mcu7t3v3__fillcap_16
XFILLER_32_947 VDD VDD VSS VSS gf180mcu_as_sc_mcu7t3v3__fillcap_16
XFILLER_176_418 VDD VDD VSS VSS gf180mcu_as_sc_mcu7t3v3__fill_1
XTAP_TAPCELL_ROW_127_1_1825 VDD VSS gf180mcu_as_sc_mcu7t3v3__tap_2
XTAP_TAPCELL_ROW_139_3_3137 VDD VSS gf180mcu_as_sc_mcu7t3v3__tap_2
XFILLER_160_1566 VDD VDD VSS VSS gf180mcu_as_sc_mcu7t3v3__fill_2
XTAP_TAPCELL_ROW_26_1294 VDD VSS gf180mcu_as_sc_mcu7t3v3__tap_2
XFILLER_8_664 VDD VDD VSS VSS gf180mcu_as_sc_mcu7t3v3__fill_1
XFILLER_171_112 VDD VDD VSS VSS gf180mcu_as_sc_mcu7t3v3__fillcap_4
XFILLER_176_1017 VDD VDD VSS VSS gf180mcu_as_sc_mcu7t3v3__fillcap_16
XFILLER_7_174 VDD VDD VSS VSS gf180mcu_as_sc_mcu7t3v3__fillcap_8
XFILLER_32_1293 VDD VDD VSS VSS gf180mcu_as_sc_mcu7t3v3__fill_2
X_4370_ VDD VDD VSS VSS _5161_/D _4370_/C _4378_/D _4370_/A gf180mcu_as_sc_mcu7t3v3__aoi21_2
XFILLER_119_1402 VDD VDD VSS VSS gf180mcu_as_sc_mcu7t3v3__fillcap_8
XFILLER_208_69 VDD VDD VSS VSS gf180mcu_as_sc_mcu7t3v3__fillcap_16
XTAP_TAPCELL_ROW_107_1_1767 VDD VSS gf180mcu_as_sc_mcu7t3v3__tap_2
XTAP_TAPCELL_ROW_119_3_3079 VDD VSS gf180mcu_as_sc_mcu7t3v3__tap_2
X_3321_ VDD VDD VSS VSS _3973_/D _3403_/S _3321_/C _3401_/B _3323_/C gf180mcu_as_sc_mcu7t3v3__ao211_2
XFILLER_154_1348 VDD VDD VSS VSS gf180mcu_as_sc_mcu7t3v3__fillcap_16
XFILLER_158_1484 VDD VDD VSS VSS gf180mcu_as_sc_mcu7t3v3__fillcap_8
XFILLER_193_1397 VDD VDD VSS VSS gf180mcu_as_sc_mcu7t3v3__fill_2
XFILLER_80_1501 VDD VDD VSS VSS gf180mcu_as_sc_mcu7t3v3__fillcap_16
XTAP_TAPCELL_ROW_35_1508 VDD VSS gf180mcu_as_sc_mcu7t3v3__tap_2
XFILLER_6_1103 VDD VDD VSS VSS gf180mcu_as_sc_mcu7t3v3__fillcap_16
XFILLER_80_1523 VDD VDD VSS VSS gf180mcu_as_sc_mcu7t3v3__fill_1
XFILLER_80_1534 VDD VDD VSS VSS gf180mcu_as_sc_mcu7t3v3__fillcap_8
X_3252_ VDD VDD VSS VSS _3255_/C _3787_/A _3818_/C gf180mcu_as_sc_mcu7t3v3__and2_2
XFILLER_21_2 VDD VDD VSS VSS gf180mcu_as_sc_mcu7t3v3__fillcap_16
XFILLER_41_1518 VDD VDD VSS VSS gf180mcu_as_sc_mcu7t3v3__fill_1
X_3183_ VDD VDD VSS VSS _3213_/A _3199_/B _4977_/Q gf180mcu_as_sc_mcu7t3v3__nand2_2
XFILLER_35_730 VDD VDD VSS VSS gf180mcu_as_sc_mcu7t3v3__fill_1
XTAP_TAPCELL_ROW_84_3_2974 VDD VSS gf180mcu_as_sc_mcu7t3v3__tap_2
XTAP_TAPCELL_ROW_204_2670 VDD VSS gf180mcu_as_sc_mcu7t3v3__tap_2
XTAP_TAPCELL_ROW_179_2113 VDD VSS gf180mcu_as_sc_mcu7t3v3__tap_2
XTAP_TAPCELL_ROW_179_2102 VDD VSS gf180mcu_as_sc_mcu7t3v3__tap_2
XFILLER_165_1422 VDD VDD VSS VSS gf180mcu_as_sc_mcu7t3v3__fill_2
XFILLER_35_763 VDD VDD VSS VSS gf180mcu_as_sc_mcu7t3v3__fillcap_4
XFILLER_78_1485 VDD VDD VSS VSS gf180mcu_as_sc_mcu7t3v3__fillcap_16
XFILLER_126_1428 VDD VDD VSS VSS gf180mcu_as_sc_mcu7t3v3__fillcap_8
XFILLER_34_273 VDD VDD VSS VSS gf180mcu_as_sc_mcu7t3v3__fillcap_8
XTAP_TAPCELL_ROW_200_2578 VDD VSS gf180mcu_as_sc_mcu7t3v3__tap_2
XTAP_TAPCELL_ROW_200_2567 VDD VSS gf180mcu_as_sc_mcu7t3v3__tap_2
XFILLER_165_1488 VDD VDD VSS VSS gf180mcu_as_sc_mcu7t3v3__fillcap_16
XFILLER_210_525 VDD VDD VSS VSS gf180mcu_as_sc_mcu7t3v3__fillcap_4
XFILLER_22_446 VDD VDD VSS VSS gf180mcu_as_sc_mcu7t3v3__fillcap_8
XTAP_TAPCELL_ROW_196_2493 VDD VSS gf180mcu_as_sc_mcu7t3v3__tap_2
XTAP_TAPCELL_ROW_196_2482 VDD VSS gf180mcu_as_sc_mcu7t3v3__tap_2
XFILLER_147_120 VDD VDD VSS VSS gf180mcu_as_sc_mcu7t3v3__fillcap_16
XFILLER_176_941 VDD VDD VSS VSS gf180mcu_as_sc_mcu7t3v3__fillcap_4
XFILLER_206_1485 VDD VDD VSS VSS gf180mcu_as_sc_mcu7t3v3__fillcap_16
XFILLER_210_569 VDD VDD VSS VSS gf180mcu_as_sc_mcu7t3v3__fill_2
X_2967_ VDD VDD VSS VSS _3008_/S _3947_/D _3951_/A _2969_/B gf180mcu_as_sc_mcu7t3v3__mux2_2
XFILLER_175_462 VDD VDD VSS VSS gf180mcu_as_sc_mcu7t3v3__fillcap_8
XFILLER_176_963 VDD VDD VSS VSS gf180mcu_as_sc_mcu7t3v3__fillcap_16
XFILLER_33_1068 VDD VDD VSS VSS gf180mcu_as_sc_mcu7t3v3__fillcap_4
X_4706_ VDD VDD VSS VSS _4749_/B _4706_/B _5484_/A _4707_/A gf180mcu_as_sc_mcu7t3v3__mux2_2
X_2898_ VDD VDD VSS VSS _4977_/Q _4943_/Q _3542_/A gf180mcu_as_sc_mcu7t3v3__or2_2
XFILLER_147_186 VDD VDD VSS VSS gf180mcu_as_sc_mcu7t3v3__fillcap_8
XFILLER_191_944 VDD VDD VSS VSS gf180mcu_as_sc_mcu7t3v3__fillcap_16
XFILLER_198_1275 VDD VDD VSS VSS gf180mcu_as_sc_mcu7t3v3__fillcap_16
X_4637_ VDD VDD VSS VSS _4642_/S _5114_/Q _4637_/A _5228_/D gf180mcu_as_sc_mcu7t3v3__mux2_2
XFILLER_102_1450 VDD VDD VSS VSS gf180mcu_as_sc_mcu7t3v3__fill_1
XFILLER_162_134 VDD VDD VSS VSS gf180mcu_as_sc_mcu7t3v3__fill_2
XFILLER_190_454 VDD VDD VSS VSS gf180mcu_as_sc_mcu7t3v3__fill_1
XFILLER_198_1297 VDD VDD VSS VSS gf180mcu_as_sc_mcu7t3v3__fillcap_16
XFILLER_46_1407 VDD VDD VSS VSS gf180mcu_as_sc_mcu7t3v3__fillcap_16
XFILLER_85_1434 VDD VDD VSS VSS gf180mcu_as_sc_mcu7t3v3__fillcap_16
XTAP_TAPCELL_ROW_153_1_1904 VDD VSS gf180mcu_as_sc_mcu7t3v3__tap_2
X_4568_ VDD VDD VSS VSS _4572_/B _5086_/Q _4570_/S gf180mcu_as_sc_mcu7t3v3__nand2_2
XFILLER_103_212 VDD VDD VSS VSS gf180mcu_as_sc_mcu7t3v3__fillcap_8
XFILLER_172_1415 VDD VDD VSS VSS gf180mcu_as_sc_mcu7t3v3__fillcap_4
X_4499_ VDD VDD VSS VSS _4502_/C _4991_/Q _4500_/S gf180mcu_as_sc_mcu7t3v3__nand2b_2
X_3519_ VDD VDD VSS VSS _3519_/D _3519_/A _3818_/B _3519_/C _3520_/D gf180mcu_as_sc_mcu7t3v3__ao31_2
XTAP_TAPCELL_ROW_165_3_3216 VDD VSS gf180mcu_as_sc_mcu7t3v3__tap_2
XFILLER_137_1568 VDD VDD VSS VSS gf180mcu_as_sc_mcu7t3v3__fill_1
XFILLER_172_1448 VDD VDD VSS VSS gf180mcu_as_sc_mcu7t3v3__fill_2
XFILLER_76_107 VDD VDD VSS VSS gf180mcu_as_sc_mcu7t3v3__fillcap_16
XFILLER_134_57 VDD VDD VSS VSS gf180mcu_as_sc_mcu7t3v3__fillcap_16
XFILLER_182_6 VDD VDD VSS VSS gf180mcu_as_sc_mcu7t3v3__fillcap_16
Xmesh_tile_1009 VDD VDD VSS VSS nw_out[16] gf180mcu_as_sc_mcu7t3v3__tiel_4
XFILLER_22_1462 VDD VDD VSS VSS gf180mcu_as_sc_mcu7t3v3__fillcap_8
XFILLER_150_45 VDD VDD VSS VSS gf180mcu_as_sc_mcu7t3v3__fillcap_4
XFILLER_150_78 VDD VDD VSS VSS gf180mcu_as_sc_mcu7t3v3__fillcap_16
XFILLER_183_1533 VDD VDD VSS VSS gf180mcu_as_sc_mcu7t3v3__fillcap_4
XFILLER_198_521 VDD VDD VSS VSS gf180mcu_as_sc_mcu7t3v3__fillcap_4
XFILLER_26_752 VDD VDD VSS VSS gf180mcu_as_sc_mcu7t3v3__fill_2
XFILLER_27_99 VDD VDD VSS VSS gf180mcu_as_sc_mcu7t3v3__fillcap_8
XFILLER_57_1536 VDD VDD VSS VSS gf180mcu_as_sc_mcu7t3v3__fillcap_16
XFILLER_14_947 VDD VDD VSS VSS gf180mcu_as_sc_mcu7t3v3__fillcap_4
XFILLER_198_543 VDD VDD VSS VSS gf180mcu_as_sc_mcu7t3v3__fillcap_16
XFILLER_57_1558 VDD VDD VSS VSS gf180mcu_as_sc_mcu7t3v3__fillcap_8
XTAP_TAPCELL_ROW_99_1_1741 VDD VSS gf180mcu_as_sc_mcu7t3v3__tap_2
XFILLER_0_1291 VDD VDD VSS VSS gf180mcu_as_sc_mcu7t3v3__fill_1
XFILLER_144_1539 VDD VDD VSS VSS gf180mcu_as_sc_mcu7t3v3__fill_2
XFILLER_16_1211 VDD VDD VSS VSS gf180mcu_as_sc_mcu7t3v3__fillcap_8
XFILLER_40_221 VDD VDD VSS VSS gf180mcu_as_sc_mcu7t3v3__fill_1
XFILLER_43_43 VDD VDD VSS VSS gf180mcu_as_sc_mcu7t3v3__fillcap_16
XFILLER_159_54 VDD VDD VSS VSS gf180mcu_as_sc_mcu7t3v3__fillcap_4
XFILLER_107_1372 VDD VDD VSS VSS gf180mcu_as_sc_mcu7t3v3__fillcap_4
XFILLER_159_76 VDD VDD VSS VSS gf180mcu_as_sc_mcu7t3v3__fill_2
XFILLER_177_1348 VDD VDD VSS VSS gf180mcu_as_sc_mcu7t3v3__fill_1
XTAP_TAPCELL_ROW_79_1_1683 VDD VSS gf180mcu_as_sc_mcu7t3v3__tap_2
XTAP_TAPCELL_ROW_21_1191 VDD VSS gf180mcu_as_sc_mcu7t3v3__tap_2
XFILLER_181_465 VDD VDD VSS VSS gf180mcu_as_sc_mcu7t3v3__fillcap_8
XFILLER_4_177 VDD VDD VSS VSS gf180mcu_as_sc_mcu7t3v3__fillcap_8
XFILLER_4_37 VDD VDD VSS VSS gf180mcu_as_sc_mcu7t3v3__fillcap_4
XFILLER_64_1518 VDD VDD VSS VSS gf180mcu_as_sc_mcu7t3v3__fill_2
XTAP_TAPCELL_ROW_89_3_2989 VDD VSS gf180mcu_as_sc_mcu7t3v3__tap_2
XFILLER_27_1395 VDD VDD VSS VSS gf180mcu_as_sc_mcu7t3v3__fillcap_4
Xinput240 VDD VDD VSS VSS south_in[32] _3254_/A gf180mcu_as_sc_mcu7t3v3__buff_12
Xinput251 VDD VDD VSS VSS sw_in[11] _2433_/A gf180mcu_as_sc_mcu7t3v3__buff_12
Xinput262 VDD VDD VSS VSS sw_in[21] _4106_/A gf180mcu_as_sc_mcu7t3v3__buff_12
XFILLER_124_90 VDD VDD VSS VSS gf180mcu_as_sc_mcu7t3v3__fillcap_4
XFILLER_149_1406 VDD VDD VSS VSS gf180mcu_as_sc_mcu7t3v3__fillcap_8
XFILLER_23_1259 VDD VDD VSS VSS gf180mcu_as_sc_mcu7t3v3__fill_1
XFILLER_40_1540 VDD VDD VSS VSS gf180mcu_as_sc_mcu7t3v3__fill_1
XFILLER_7_1489 VDD VDD VSS VSS gf180mcu_as_sc_mcu7t3v3__fill_1
Xinput273 VDD VDD VSS VSS sw_in[31] _3515_/A gf180mcu_as_sc_mcu7t3v3__buff_12
Xinput284 VDD VDD VSS VSS west_in[10] _4013_/A gf180mcu_as_sc_mcu7t3v3__buff_12
Xinput295 VDD VDD VSS VSS west_in[20] _4093_/D gf180mcu_as_sc_mcu7t3v3__buff_12
XFILLER_188_1499 VDD VDD VSS VSS gf180mcu_as_sc_mcu7t3v3__fillcap_4
XFILLER_205_820 VDD VDD VSS VSS gf180mcu_as_sc_mcu7t3v3__fillcap_16
XFILLER_205_842 VDD VDD VSS VSS gf180mcu_as_sc_mcu7t3v3__fillcap_16
XFILLER_16_262 VDD VDD VSS VSS gf180mcu_as_sc_mcu7t3v3__fill_2
XFILLER_32_722 VDD VDD VSS VSS gf180mcu_as_sc_mcu7t3v3__fill_2
XFILLER_90_187 VDD VDD VSS VSS gf180mcu_as_sc_mcu7t3v3__fill_2
XTAP_TAPCELL_ROW_28_1345 VDD VSS gf180mcu_as_sc_mcu7t3v3__tap_2
XFILLER_182_1065 VDD VDD VSS VSS gf180mcu_as_sc_mcu7t3v3__fillcap_16
XFILLER_20_906 VDD VDD VSS VSS gf180mcu_as_sc_mcu7t3v3__fill_2
X_3870_ VDD VDD VSS VSS _4914_/D _4339_/B _3913_/A gf180mcu_as_sc_mcu7t3v3__nor2_2
XTAP_TAPCELL_ROW_28_1356 VDD VSS gf180mcu_as_sc_mcu7t3v3__tap_2
XTAP_TAPCELL_ROW_174_2010 VDD VSS gf180mcu_as_sc_mcu7t3v3__tap_2
XFILLER_182_1087 VDD VDD VSS VSS gf180mcu_as_sc_mcu7t3v3__fillcap_16
XTAP_TAPCELL_ROW_158_1_1919 VDD VSS gf180mcu_as_sc_mcu7t3v3__tap_2
X_2821_ VDD VDD VSS VSS _5483_/A _2833_/A _2829_/B gf180mcu_as_sc_mcu7t3v3__and2_2
XFILLER_129_142 VDD VDD VSS VSS gf180mcu_as_sc_mcu7t3v3__fill_1
XFILLER_31_298 VDD VDD VSS VSS gf180mcu_as_sc_mcu7t3v3__fillcap_4
XFILLER_9_940 VDD VDD VSS VSS gf180mcu_as_sc_mcu7t3v3__fillcap_16
XPHY_EDGE_ROW_130_1_Left_340 VDD VSS gf180mcu_as_sc_mcu7t3v3__tap_2
X_2752_ VDD VDD VSS VSS _2754_/D _4975_/D _5279_/Q gf180mcu_as_sc_mcu7t3v3__nor2b_2
XFILLER_200_591 VDD VDD VSS VSS gf180mcu_as_sc_mcu7t3v3__fillcap_4
XFILLER_34_1399 VDD VDD VSS VSS gf180mcu_as_sc_mcu7t3v3__fillcap_16
XFILLER_8_450 VDD VDD VSS VSS gf180mcu_as_sc_mcu7t3v3__fillcap_4
XFILLER_144_123 VDD VDD VSS VSS gf180mcu_as_sc_mcu7t3v3__fillcap_16
XFILLER_184_292 VDD VDD VSS VSS gf180mcu_as_sc_mcu7t3v3__fill_2
XFILLER_69_2 VDD VDD VSS VSS gf180mcu_as_sc_mcu7t3v3__fill_2
X_4422_ VDD VDD VSS VSS _5170_/Q _4470_/B _4479_/C _5120_/Q _4423_/B gf180mcu_as_sc_mcu7t3v3__ao22_2
X_2683_ VDD VDD VSS VSS _2734_/S _2683_/B _2683_/A _2684_/C gf180mcu_as_sc_mcu7t3v3__mux2_2
XFILLER_98_221 VDD VDD VSS VSS gf180mcu_as_sc_mcu7t3v3__fill_1
X_4353_ VDD VDD VSS VSS _4357_/C _4512_/A _4353_/A gf180mcu_as_sc_mcu7t3v3__nor2b_2
XFILLER_8_1209 VDD VDD VSS VSS gf180mcu_as_sc_mcu7t3v3__fill_2
X_4284_ VDD VDD VSS VSS _4289_/S _5480_/A _5118_/Q _5118_/D gf180mcu_as_sc_mcu7t3v3__mux2_2
X_3304_ VDD VDD VSS VSS _4918_/Q _3402_/B _3402_/C _3959_/A _3306_/C gf180mcu_as_sc_mcu7t3v3__ao22_2
XFILLER_132_1410 VDD VDD VSS VSS gf180mcu_as_sc_mcu7t3v3__fillcap_4
XFILLER_58_107 VDD VDD VSS VSS gf180mcu_as_sc_mcu7t3v3__fillcap_4
X_3235_ VDD VDD VSS VSS _3236_/D _3235_/B _3517_/A gf180mcu_as_sc_mcu7t3v3__nor2_2
XFILLER_189_1208 VDD VDD VSS VSS gf180mcu_as_sc_mcu7t3v3__fillcap_16
XFILLER_45_1495 VDD VDD VSS VSS gf180mcu_as_sc_mcu7t3v3__fillcap_16
XTAP_TAPCELL_ROW_206_2710 VDD VSS gf180mcu_as_sc_mcu7t3v3__tap_2
XFILLER_41_1348 VDD VDD VSS VSS gf180mcu_as_sc_mcu7t3v3__fillcap_16
X_3166_ VDD VDD VSS VSS _3241_/B _4147_/A _3172_/C gf180mcu_as_sc_mcu7t3v3__and2_2
XFILLER_167_1506 VDD VDD VSS VSS gf180mcu_as_sc_mcu7t3v3__fill_1
X_3097_ VDD VDD VSS VSS _3691_/D _3115_/A _3097_/B _3097_/C _3098_/C gf180mcu_as_sc_mcu7t3v3__ao31_2
XTAP_TAPCELL_ROW_202_2618 VDD VSS gf180mcu_as_sc_mcu7t3v3__tap_2
XTAP_TAPCELL_ROW_202_2607 VDD VSS gf180mcu_as_sc_mcu7t3v3__tap_2
XTAP_TAPCELL_ROW_198_2533 VDD VSS gf180mcu_as_sc_mcu7t3v3__tap_2
XTAP_TAPCELL_ROW_198_2522 VDD VSS gf180mcu_as_sc_mcu7t3v3__tap_2
XFILLER_120_37 VDD VDD VSS VSS gf180mcu_as_sc_mcu7t3v3__fillcap_16
XFILLER_22_221 VDD VDD VSS VSS gf180mcu_as_sc_mcu7t3v3__fill_2
XFILLER_11_928 VDD VDD VSS VSS gf180mcu_as_sc_mcu7t3v3__fillcap_8
XFILLER_17_1542 VDD VDD VSS VSS gf180mcu_as_sc_mcu7t3v3__fill_2
XFILLER_195_524 VDD VDD VSS VSS gf180mcu_as_sc_mcu7t3v3__fillcap_16
XFILLER_23_788 VDD VDD VSS VSS gf180mcu_as_sc_mcu7t3v3__fill_2
XPHY_EDGE_ROW_62_1_Left_272 VDD VSS gf180mcu_as_sc_mcu7t3v3__tap_2
X_3999_ VDD VDD VSS VSS _3999_/A _4129_/B _4129_/C _4923_/Q _4001_/C gf180mcu_as_sc_mcu7t3v3__ao22_2
XFILLER_104_1523 VDD VDD VSS VSS gf180mcu_as_sc_mcu7t3v3__fillcap_16
XFILLER_13_1406 VDD VDD VSS VSS gf180mcu_as_sc_mcu7t3v3__fill_2
XFILLER_202_1135 VDD VDD VSS VSS gf180mcu_as_sc_mcu7t3v3__fillcap_16
XFILLER_202_1157 VDD VDD VSS VSS gf180mcu_as_sc_mcu7t3v3__fillcap_16
XFILLER_52_1499 VDD VDD VSS VSS gf180mcu_as_sc_mcu7t3v3__fillcap_8
XFILLER_135_189 VDD VDD VSS VSS gf180mcu_as_sc_mcu7t3v3__fill_1
XFILLER_145_67 VDD VDD VSS VSS gf180mcu_as_sc_mcu7t3v3__fill_2
XFILLER_49_129 VDD VDD VSS VSS gf180mcu_as_sc_mcu7t3v3__fillcap_8
XPHY_EDGE_ROW_38_3_Left_423 VDD VSS gf180mcu_as_sc_mcu7t3v3__tap_2
XFILLER_111_1516 VDD VDD VSS VSS gf180mcu_as_sc_mcu7t3v3__fill_2
Xhold1150 VDD VDD VSS VSS _4952_/Q hold1150/Y gf180mcu_as_sc_mcu7t3v3__clkbuff_4
XFILLER_161_66 VDD VDD VSS VSS gf180mcu_as_sc_mcu7t3v3__fillcap_4
XFILLER_161_88 VDD VDD VSS VSS gf180mcu_as_sc_mcu7t3v3__fill_1
XFILLER_18_527 VDD VDD VSS VSS gf180mcu_as_sc_mcu7t3v3__fillcap_16
XFILLER_22_1270 VDD VDD VSS VSS gf180mcu_as_sc_mcu7t3v3__fillcap_4
XFILLER_2_1364 VDD VDD VSS VSS gf180mcu_as_sc_mcu7t3v3__fill_1
XFILLER_148_1450 VDD VDD VSS VSS gf180mcu_as_sc_mcu7t3v3__fill_1
XFILLER_148_1461 VDD VDD VSS VSS gf180mcu_as_sc_mcu7t3v3__fillcap_4
XFILLER_202_801 VDD VDD VSS VSS gf180mcu_as_sc_mcu7t3v3__fillcap_4
XFILLER_54_53 VDD VDD VSS VSS gf180mcu_as_sc_mcu7t3v3__fill_1
XFILLER_54_75 VDD VDD VSS VSS gf180mcu_as_sc_mcu7t3v3__fillcap_16
XFILLER_199_874 VDD VDD VSS VSS gf180mcu_as_sc_mcu7t3v3__fillcap_16
XFILLER_202_823 VDD VDD VSS VSS gf180mcu_as_sc_mcu7t3v3__fillcap_16
XFILLER_207_1046 VDD VDD VSS VSS gf180mcu_as_sc_mcu7t3v3__fillcap_4
XFILLER_57_1388 VDD VDD VSS VSS gf180mcu_as_sc_mcu7t3v3__fill_2
XFILLER_14_799 VDD VDD VSS VSS gf180mcu_as_sc_mcu7t3v3__fillcap_4
XFILLER_186_535 VDD VDD VSS VSS gf180mcu_as_sc_mcu7t3v3__fill_2
XFILLER_70_1511 VDD VDD VSS VSS gf180mcu_as_sc_mcu7t3v3__fillcap_8
XFILLER_9_225 VDD VDD VSS VSS gf180mcu_as_sc_mcu7t3v3__fill_2
XFILLER_201_388 VDD VDD VSS VSS gf180mcu_as_sc_mcu7t3v3__fill_1
XTAP_TAPCELL_ROW_23_1242 VDD VSS gf180mcu_as_sc_mcu7t3v3__tap_2
XTAP_TAPCELL_ROW_23_1231 VDD VSS gf180mcu_as_sc_mcu7t3v3__tap_2
XFILLER_186_30 VDD VDD VSS VSS gf180mcu_as_sc_mcu7t3v3__fillcap_4
XFILLER_70_96 VDD VDD VSS VSS gf180mcu_as_sc_mcu7t3v3__fillcap_8
XTAP_TAPCELL_ROW_12_989 VDD VSS gf180mcu_as_sc_mcu7t3v3__tap_2
Xclkload17 VDD VDD VSS VSS _5276_/CLK clkload17/Y gf180mcu_as_sc_mcu7t3v3__clkbuff_4
XFILLER_126_123 VDD VDD VSS VSS gf180mcu_as_sc_mcu7t3v3__fillcap_16
XFILLER_186_85 VDD VDD VSS VSS gf180mcu_as_sc_mcu7t3v3__fillcap_16
Xclkload28 VDD VDD VSS VSS clkload28/Y _5198_/CLK gf180mcu_as_sc_mcu7t3v3__inv_6
XFILLER_120_1380 VDD VDD VSS VSS gf180mcu_as_sc_mcu7t3v3__fill_1
XFILLER_141_137 VDD VDD VSS VSS gf180mcu_as_sc_mcu7t3v3__fill_2
XFILLER_29_1402 VDD VDD VSS VSS gf180mcu_as_sc_mcu7t3v3__fillcap_16
XFILLER_79_72 VDD VDD VSS VSS gf180mcu_as_sc_mcu7t3v3__fillcap_16
XFILLER_155_1465 VDD VDD VSS VSS gf180mcu_as_sc_mcu7t3v3__fillcap_16
XFILLER_190_1345 VDD VDD VSS VSS gf180mcu_as_sc_mcu7t3v3__fillcap_16
XFILLER_29_1435 VDD VDD VSS VSS gf180mcu_as_sc_mcu7t3v3__fillcap_16
XFILLER_64_1348 VDD VDD VSS VSS gf180mcu_as_sc_mcu7t3v3__fillcap_8
XFILLER_68_1484 VDD VDD VSS VSS gf180mcu_as_sc_mcu7t3v3__fillcap_16
XPHY_EDGE_ROW_140_1_Right_661 VDD VSS gf180mcu_as_sc_mcu7t3v3__tap_2
XFILLER_190_1367 VDD VDD VSS VSS gf180mcu_as_sc_mcu7t3v3__fill_1
XFILLER_209_422 VDD VDD VSS VSS gf180mcu_as_sc_mcu7t3v3__fillcap_8
XFILLER_27_1192 VDD VDD VSS VSS gf180mcu_as_sc_mcu7t3v3__fillcap_16
XFILLER_48_162 VDD VDD VSS VSS gf180mcu_as_sc_mcu7t3v3__fillcap_8
X_3020_ VDD VDD VSS VSS _3129_/B _4923_/Q _3021_/D gf180mcu_as_sc_mcu7t3v3__or2_2
XFILLER_48_195 VDD VDD VSS VSS gf180mcu_as_sc_mcu7t3v3__fill_1
XFILLER_75_1422 VDD VDD VSS VSS gf180mcu_as_sc_mcu7t3v3__fill_1
XFILLER_75_1433 VDD VDD VSS VSS gf180mcu_as_sc_mcu7t3v3__fillcap_16
X_4971_ VDD VDD VSS VSS _5111_/CLK _4971_/D _4971_/Q gf180mcu_as_sc_mcu7t3v3__dfxtp_2
XFILLER_149_204 VDD VDD VSS VSS gf180mcu_as_sc_mcu7t3v3__fillcap_4
XFILLER_204_171 VDD VDD VSS VSS gf180mcu_as_sc_mcu7t3v3__fillcap_4
X_3922_ VDD VDD VSS VSS _3922_/A _3922_/B _3922_/C _3927_/B _4164_/S gf180mcu_as_sc_mcu7t3v3__ao211_2
XFILLER_123_1409 VDD VDD VSS VSS gf180mcu_as_sc_mcu7t3v3__fillcap_4
XFILLER_162_1447 VDD VDD VSS VSS gf180mcu_as_sc_mcu7t3v3__fillcap_4
XFILLER_177_546 VDD VDD VSS VSS gf180mcu_as_sc_mcu7t3v3__fill_1
XFILLER_204_193 VDD VDD VSS VSS gf180mcu_as_sc_mcu7t3v3__fillcap_16
XFILLER_75_1488 VDD VDD VSS VSS gf180mcu_as_sc_mcu7t3v3__fillcap_4
X_3853_ VDD VDD VSS VSS _5153_/Q _5154_/Q _3853_/C _3858_/B gf180mcu_as_sc_mcu7t3v3__nor3_2
XFILLER_162_1469 VDD VDD VSS VSS gf180mcu_as_sc_mcu7t3v3__fill_2
X_2804_ VDD VDD VSS VSS _2840_/D _5227_/Q _5226_/Q gf180mcu_as_sc_mcu7t3v3__nand2_2
XFILLER_192_527 VDD VDD VSS VSS gf180mcu_as_sc_mcu7t3v3__fillcap_16
XFILLER_203_1466 VDD VDD VSS VSS gf180mcu_as_sc_mcu7t3v3__fillcap_4
X_3784_ VDD VDD VSS VSS _3794_/S _3784_/B _4164_/A _3785_/B gf180mcu_as_sc_mcu7t3v3__mux2_2
XFILLER_203_1488 VDD VDD VSS VSS gf180mcu_as_sc_mcu7t3v3__fillcap_16
XFILLER_30_1049 VDD VDD VSS VSS gf180mcu_as_sc_mcu7t3v3__fillcap_16
XFILLER_9_792 VDD VDD VSS VSS gf180mcu_as_sc_mcu7t3v3__fill_2
X_2735_ VDD VDD VSS VSS _2735_/A _2735_/B _2735_/C _2735_/D _2737_/C gf180mcu_as_sc_mcu7t3v3__ao211_2
XFILLER_195_1256 VDD VDD VSS VSS gf180mcu_as_sc_mcu7t3v3__fillcap_4
X_2666_ VDD VDD VSS VSS _2666_/A _2666_/B _2666_/C _2666_/D _2667_/C gf180mcu_as_sc_mcu7t3v3__ao22_2
XFILLER_173_1510 VDD VDD VSS VSS gf180mcu_as_sc_mcu7t3v3__fill_1
XFILLER_195_1278 VDD VDD VSS VSS gf180mcu_as_sc_mcu7t3v3__fillcap_16
X_4405_ VDD VDD VSS VSS _4405_/D _4502_/A _4405_/B _4405_/C _4406_/B gf180mcu_as_sc_mcu7t3v3__ao31_2
XFILLER_173_1554 VDD VDD VSS VSS gf180mcu_as_sc_mcu7t3v3__fill_2
X_4336_ VDD VDD VSS VSS _4379_/B _4592_/B _4366_/S gf180mcu_as_sc_mcu7t3v3__nand2_2
X_2597_ VDD VDD VSS VSS _5227_/Q _2597_/B _2597_/C _2597_/D _2598_/B gf180mcu_as_sc_mcu7t3v3__ao22_2
XFILLER_115_37 VDD VDD VSS VSS gf180mcu_as_sc_mcu7t3v3__fillcap_16
XFILLER_47_1568 VDD VDD VSS VSS gf180mcu_as_sc_mcu7t3v3__fill_1
XFILLER_8_1017 VDD VDD VSS VSS gf180mcu_as_sc_mcu7t3v3__fillcap_16
XTAP_TAPCELL_ROW_187_2289 VDD VSS gf180mcu_as_sc_mcu7t3v3__tap_2
XTAP_TAPCELL_ROW_187_2278 VDD VSS gf180mcu_as_sc_mcu7t3v3__tap_2
X_4267_ VDD VDD VSS VSS _4267_/S _5479_/A _5101_/Q _5101_/D gf180mcu_as_sc_mcu7t3v3__mux2_2
XTAP_TAPCELL_ROW_42_1_1570 VDD VSS gf180mcu_as_sc_mcu7t3v3__tap_2
XFILLER_210_1415 VDD VDD VSS VSS gf180mcu_as_sc_mcu7t3v3__fillcap_4
XFILLER_28_803 VDD VDD VSS VSS gf180mcu_as_sc_mcu7t3v3__fill_2
X_4198_ VDD VDD VSS VSS _4198_/Y _4908_/Q _4198_/A gf180mcu_as_sc_mcu7t3v3__nor2b_2
X_3218_ VDD VDD VSS VSS _3219_/B _3218_/C _3218_/B _3803_/A gf180mcu_as_sc_mcu7t3v3__aoi21_2
X_3149_ VDD VDD VSS VSS _3746_/A _3181_/A _3149_/C _4794_/D _3831_/A gf180mcu_as_sc_mcu7t3v3__aoi211_2
XFILLER_15_508 VDD VDD VSS VSS gf180mcu_as_sc_mcu7t3v3__fillcap_16
XFILLER_199_104 VDD VDD VSS VSS gf180mcu_as_sc_mcu7t3v3__fillcap_16
XTAP_TAPCELL_ROW_52_3_2876 VDD VSS gf180mcu_as_sc_mcu7t3v3__tap_2
XFILLER_93_1522 VDD VDD VSS VSS gf180mcu_as_sc_mcu7t3v3__fillcap_8
XFILLER_93_1566 VDD VDD VSS VSS gf180mcu_as_sc_mcu7t3v3__fill_2
XFILLER_23_574 VDD VDD VSS VSS gf180mcu_as_sc_mcu7t3v3__fillcap_4
XFILLER_24_34 VDD VDD VSS VSS gf180mcu_as_sc_mcu7t3v3__fill_1
XTAP_TAPCELL_ROW_128_1_1830 VDD VSS gf180mcu_as_sc_mcu7t3v3__tap_2
XFILLER_196_877 VDD VDD VSS VSS gf180mcu_as_sc_mcu7t3v3__fillcap_16
XFILLER_208_1399 VDD VDD VSS VSS gf180mcu_as_sc_mcu7t3v3__fillcap_16
XFILLER_11_769 VDD VDD VSS VSS gf180mcu_as_sc_mcu7t3v3__fill_1
XFILLER_143_1380 VDD VDD VSS VSS gf180mcu_as_sc_mcu7t3v3__fill_2
XFILLER_155_207 VDD VDD VSS VSS gf180mcu_as_sc_mcu7t3v3__fill_2
XFILLER_13_1258 VDD VDD VSS VSS gf180mcu_as_sc_mcu7t3v3__fill_2
XFILLER_178_1410 VDD VDD VSS VSS gf180mcu_as_sc_mcu7t3v3__fillcap_16
XFILLER_156_22 VDD VDD VSS VSS gf180mcu_as_sc_mcu7t3v3__fillcap_8
XFILLER_87_1348 VDD VDD VSS VSS gf180mcu_as_sc_mcu7t3v3__fillcap_16
XFILLER_8_1540 VDD VDD VSS VSS gf180mcu_as_sc_mcu7t3v3__fill_1
Xfanout760 VDD VDD VSS VSS _2681_/Y _4281_/S gf180mcu_as_sc_mcu7t3v3__buff_12
Xfanout771 VDD VDD VSS VSS _4747_/D _4748_/A gf180mcu_as_sc_mcu7t3v3__buff_12
Xfanout782 VDD VDD VSS VSS _5223_/Q _2747_/A gf180mcu_as_sc_mcu7t3v3__buff_12
Xfanout793 VDD VDD VSS VSS _4581_/A _4510_/A gf180mcu_as_sc_mcu7t3v3__buff_12
XTAP_TAPCELL_ROW_16_1090 VDD VSS gf180mcu_as_sc_mcu7t3v3__tap_2
XFILLER_206_403 VDD VDD VSS VSS gf180mcu_as_sc_mcu7t3v3__fillcap_16
XTAP_TAPCELL_ROW_101_1_1748 VDD VSS gf180mcu_as_sc_mcu7t3v3__tap_2
XFILLER_185_1469 VDD VDD VSS VSS gf180mcu_as_sc_mcu7t3v3__fill_1
XFILLER_34_839 VDD VDD VSS VSS gf180mcu_as_sc_mcu7t3v3__fillcap_16
XFILLER_33_349 VDD VDD VSS VSS gf180mcu_as_sc_mcu7t3v3__fill_1
XFILLER_18_1136 VDD VDD VSS VSS gf180mcu_as_sc_mcu7t3v3__fillcap_4
XFILLER_18_1169 VDD VDD VSS VSS gf180mcu_as_sc_mcu7t3v3__fill_1
XFILLER_186_387 VDD VDD VSS VSS gf180mcu_as_sc_mcu7t3v3__fillcap_4
XFILLER_201_174 VDD VDD VSS VSS gf180mcu_as_sc_mcu7t3v3__fillcap_16
XFILLER_35_1472 VDD VDD VSS VSS gf180mcu_as_sc_mcu7t3v3__fillcap_4
XFILLER_122_1453 VDD VDD VSS VSS gf180mcu_as_sc_mcu7t3v3__fillcap_16
XFILLER_196_1543 VDD VDD VSS VSS gf180mcu_as_sc_mcu7t3v3__fill_1
X_2520_ VDD VDD VSS VSS _2797_/A _2545_/B gf180mcu_as_sc_mcu7t3v3__inv_2
XTAP_TAPCELL_ROW_47_1_1585 VDD VSS gf180mcu_as_sc_mcu7t3v3__tap_2
XFILLER_114_104 VDD VDD VSS VSS gf180mcu_as_sc_mcu7t3v3__fill_1
XFILLER_114_115 VDD VDD VSS VSS gf180mcu_as_sc_mcu7t3v3__fillcap_4
X_2451_ VDD VDD VSS VSS _2832_/B _2451_/A gf180mcu_as_sc_mcu7t3v3__inv_2
XFILLER_114_159 VDD VDD VSS VSS gf180mcu_as_sc_mcu7t3v3__fillcap_16
XFILLER_9_1348 VDD VDD VSS VSS gf180mcu_as_sc_mcu7t3v3__fillcap_16
X_5170_ VDD VDD VSS VSS clkload9/A _5170_/D _5170_/Q gf180mcu_as_sc_mcu7t3v3__dfxtp_2
XFILLER_122_181 VDD VDD VSS VSS gf180mcu_as_sc_mcu7t3v3__fill_2
XPHY_EDGE_ROW_141_1_Right_662 VDD VSS gf180mcu_as_sc_mcu7t3v3__tap_2
X_4121_ VDD VDD VSS VSS _4121_/A _4130_/B _4128_/B _4121_/D _4122_/D gf180mcu_as_sc_mcu7t3v3__ao22_2
X_4052_ VDD VDD VSS VSS _4992_/Q _4158_/B _4243_/B _4117_/D _4992_/D gf180mcu_as_sc_mcu7t3v3__ao22_2
Xinput4 VDD VDD VSS VSS boot_addr[2] input4/Y gf180mcu_as_sc_mcu7t3v3__buff_12
X_3003_ VDD VDD VSS VSS _3078_/B _4921_/Q _3004_/D gf180mcu_as_sc_mcu7t3v3__or2_2
XTAP_TAPCELL_ROW_182_2186 VDD VSS gf180mcu_as_sc_mcu7t3v3__tap_2
XTAP_TAPCELL_ROW_182_2175 VDD VSS gf180mcu_as_sc_mcu7t3v3__tap_2
XFILLER_77_1528 VDD VDD VSS VSS gf180mcu_as_sc_mcu7t3v3__fill_2
XFILLER_196_107 VDD VDD VSS VSS gf180mcu_as_sc_mcu7t3v3__fillcap_16
X_4954_ VDD VDD VSS VSS _5192_/CLK _4954_/D _4954_/Q gf180mcu_as_sc_mcu7t3v3__dfxtp_2
XFILLER_166_1391 VDD VDD VSS VSS gf180mcu_as_sc_mcu7t3v3__fillcap_4
X_3905_ VDD VDD VSS VSS _4946_/D _5164_/Q _4945_/D gf180mcu_as_sc_mcu7t3v3__and2_2
XFILLER_127_1364 VDD VDD VSS VSS gf180mcu_as_sc_mcu7t3v3__fillcap_16
XFILLER_178_877 VDD VDD VSS VSS gf180mcu_as_sc_mcu7t3v3__fillcap_16
X_4885_ VDD VDD VSS VSS _4924_/CLK _4885_/D _4885_/Q gf180mcu_as_sc_mcu7t3v3__dfxtp_2
XFILLER_137_207 VDD VDD VSS VSS gf180mcu_as_sc_mcu7t3v3__fill_2
XFILLER_14_1523 VDD VDD VSS VSS gf180mcu_as_sc_mcu7t3v3__fillcap_4
XFILLER_177_365 VDD VDD VSS VSS gf180mcu_as_sc_mcu7t3v3__fill_2
XFILLER_193_836 VDD VDD VSS VSS gf180mcu_as_sc_mcu7t3v3__fillcap_4
X_3836_ VDD VDD VSS VSS _3838_/B _3843_/B _3845_/A gf180mcu_as_sc_mcu7t3v3__nand2_2
XFILLER_192_335 VDD VDD VSS VSS gf180mcu_as_sc_mcu7t3v3__fill_2
XFILLER_193_858 VDD VDD VSS VSS gf180mcu_as_sc_mcu7t3v3__fillcap_16
X_3767_ VDD VDD VSS VSS _3794_/S _3767_/B _4148_/A _3768_/B gf180mcu_as_sc_mcu7t3v3__mux2_2
XFILLER_180_508 VDD VDD VSS VSS gf180mcu_as_sc_mcu7t3v3__fill_2
X_2718_ VDD VDD VSS VSS _2732_/S _4962_/Q _4971_/Q _2720_/A gf180mcu_as_sc_mcu7t3v3__mux2_2
XFILLER_105_104 VDD VDD VSS VSS gf180mcu_as_sc_mcu7t3v3__fillcap_16
XFILLER_12_1291 VDD VDD VSS VSS gf180mcu_as_sc_mcu7t3v3__fillcap_4
X_3698_ VDD VDD VSS VSS _3699_/C _3698_/C _3766_/B _4073_/A gf180mcu_as_sc_mcu7t3v3__aoi21_2
XTAP_TAPCELL_ROW_189_2329 VDD VSS gf180mcu_as_sc_mcu7t3v3__tap_2
XFILLER_105_148 VDD VDD VSS VSS gf180mcu_as_sc_mcu7t3v3__fill_1
XFILLER_10_69 VDD VDD VSS VSS gf180mcu_as_sc_mcu7t3v3__fillcap_16
XFILLER_160_221 VDD VDD VSS VSS gf180mcu_as_sc_mcu7t3v3__fill_1
Xoutput352 VDD VDD VSS VSS _4842_/Q east_out[3] gf180mcu_as_sc_mcu7t3v3__buff_12
Xoutput341 VDD VDD VSS VSS _4863_/Q east_out[24] gf180mcu_as_sc_mcu7t3v3__buff_12
Xoutput330 VDD VDD VSS VSS _4853_/Q east_out[14] gf180mcu_as_sc_mcu7t3v3__buff_12
X_2649_ VDD VDD VSS VSS _2666_/B _2649_/B _2649_/C _2735_/D _2650_/D gf180mcu_as_sc_mcu7t3v3__ao211_2
XFILLER_120_107 VDD VDD VSS VSS gf180mcu_as_sc_mcu7t3v3__fillcap_16
XFILLER_126_69 VDD VDD VSS VSS gf180mcu_as_sc_mcu7t3v3__fillcap_16
Xoutput396 VDD VDD VSS VSS _4817_/Q south_out[12] gf180mcu_as_sc_mcu7t3v3__buff_12
Xoutput385 VDD VDD VSS VSS _4804_/Q se_out[33] gf180mcu_as_sc_mcu7t3v3__buff_12
Xoutput374 VDD VDD VSS VSS _4794_/Q se_out[23] gf180mcu_as_sc_mcu7t3v3__buff_12
Xoutput363 VDD VDD VSS VSS _4784_/Q se_out[13] gf180mcu_as_sc_mcu7t3v3__buff_12
XFILLER_0_949 VDD VDD VSS VSS gf180mcu_as_sc_mcu7t3v3__fill_2
XFILLER_120_129 VDD VDD VSS VSS gf180mcu_as_sc_mcu7t3v3__fill_1
XFILLER_138_1493 VDD VDD VSS VSS gf180mcu_as_sc_mcu7t3v3__fillcap_4
XFILLER_173_1384 VDD VDD VSS VSS gf180mcu_as_sc_mcu7t3v3__fillcap_16
X_4319_ VDD VDD VSS VSS _4326_/S _5149_/Q _5148_/Q _5148_/D gf180mcu_as_sc_mcu7t3v3__mux2_2
XFILLER_134_1379 VDD VDD VSS VSS gf180mcu_as_sc_mcu7t3v3__fill_2
Xclkbuf_leaf_25_clk_regs VDD VDD VSS VSS clkload0/A clkload7/A gf180mcu_as_sc_mcu7t3v3__clkbuff_12
XTAP_TAPCELL_ROW_73_1_1664 VDD VSS gf180mcu_as_sc_mcu7t3v3__tap_2
XFILLER_142_57 VDD VDD VSS VSS gf180mcu_as_sc_mcu7t3v3__fill_1
XFILLER_19_67 VDD VDD VSS VSS gf180mcu_as_sc_mcu7t3v3__fill_2
XFILLER_210_1245 VDD VDD VSS VSS gf180mcu_as_sc_mcu7t3v3__fillcap_4
XFILLER_21_1527 VDD VDD VSS VSS gf180mcu_as_sc_mcu7t3v3__fill_1
XTAP_TAPCELL_ROW_3_798 VDD VSS gf180mcu_as_sc_mcu7t3v3__tap_2
XTAP_TAPCELL_ROW_3_787 VDD VSS gf180mcu_as_sc_mcu7t3v3__tap_2
XFILLER_27_187 VDD VDD VSS VSS gf180mcu_as_sc_mcu7t3v3__fillcap_16
XFILLER_58_1461 VDD VDD VSS VSS gf180mcu_as_sc_mcu7t3v3__fill_2
XFILLER_180_1311 VDD VDD VSS VSS gf180mcu_as_sc_mcu7t3v3__fillcap_16
XFILLER_184_1491 VDD VDD VSS VSS gf180mcu_as_sc_mcu7t3v3__fillcap_4
XFILLER_24_872 VDD VDD VSS VSS gf180mcu_as_sc_mcu7t3v3__fill_2
XFILLER_35_88 VDD VDD VSS VSS gf180mcu_as_sc_mcu7t3v3__fillcap_16
XFILLER_42_157 VDD VDD VSS VSS gf180mcu_as_sc_mcu7t3v3__fillcap_16
XFILLER_106_1426 VDD VDD VSS VSS gf180mcu_as_sc_mcu7t3v3__fill_1
XFILLER_11_500 VDD VDD VSS VSS gf180mcu_as_sc_mcu7t3v3__fill_2
XFILLER_93_1385 VDD VDD VSS VSS gf180mcu_as_sc_mcu7t3v3__fillcap_16
XFILLER_204_1049 VDD VDD VSS VSS gf180mcu_as_sc_mcu7t3v3__fillcap_16
XFILLER_51_43 VDD VDD VSS VSS gf180mcu_as_sc_mcu7t3v3__fill_1
XFILLER_13_1044 VDD VDD VSS VSS gf180mcu_as_sc_mcu7t3v3__fillcap_4
XFILLER_167_54 VDD VDD VSS VSS gf180mcu_as_sc_mcu7t3v3__fillcap_16
XFILLER_184_869 VDD VDD VSS VSS gf180mcu_as_sc_mcu7t3v3__fillcap_4
XFILLER_167_76 VDD VDD VSS VSS gf180mcu_as_sc_mcu7t3v3__fill_2
Xwire468 VDD VDD VSS VSS _3608_/Y _4844_/D gf180mcu_as_sc_mcu7t3v3__clkbuff_12
XFILLER_3_743 VDD VDD VSS VSS gf180mcu_as_sc_mcu7t3v3__fill_2
XTAP_TAPCELL_ROW_18_1130 VDD VSS gf180mcu_as_sc_mcu7t3v3__tap_2
XFILLER_104_181 VDD VDD VSS VSS gf180mcu_as_sc_mcu7t3v3__fill_2
XFILLER_111_129 VDD VDD VSS VSS gf180mcu_as_sc_mcu7t3v3__fillcap_8
XFILLER_117_1566 VDD VDD VSS VSS gf180mcu_as_sc_mcu7t3v3__fill_2
XTAP_TAPCELL_ROW_14_1038 VDD VSS gf180mcu_as_sc_mcu7t3v3__tap_2
XTAP_TAPCELL_ROW_14_1049 VDD VSS gf180mcu_as_sc_mcu7t3v3__tap_2
XFILLER_24_1151 VDD VDD VSS VSS gf180mcu_as_sc_mcu7t3v3__fillcap_4
XFILLER_24_1173 VDD VDD VSS VSS gf180mcu_as_sc_mcu7t3v3__fillcap_4
XFILLER_4_1212 VDD VDD VSS VSS gf180mcu_as_sc_mcu7t3v3__fill_1
XFILLER_0_1109 VDD VDD VSS VSS gf180mcu_as_sc_mcu7t3v3__fillcap_4
XFILLER_207_734 VDD VDD VSS VSS gf180mcu_as_sc_mcu7t3v3__fillcap_16
XFILLER_189_1380 VDD VDD VSS VSS gf180mcu_as_sc_mcu7t3v3__fillcap_16
XFILLER_19_699 VDD VDD VSS VSS gf180mcu_as_sc_mcu7t3v3__fill_1
XFILLER_33_135 VDD VDD VSS VSS gf180mcu_as_sc_mcu7t3v3__fillcap_4
XFILLER_34_658 VDD VDD VSS VSS gf180mcu_as_sc_mcu7t3v3__fillcap_4
XFILLER_15_850 VDD VDD VSS VSS gf180mcu_as_sc_mcu7t3v3__fill_2
XFILLER_178_107 VDD VDD VSS VSS gf180mcu_as_sc_mcu7t3v3__fillcap_16
XFILLER_37_1545 VDD VDD VSS VSS gf180mcu_as_sc_mcu7t3v3__fillcap_8
XFILLER_72_1425 VDD VDD VSS VSS gf180mcu_as_sc_mcu7t3v3__fillcap_8
XFILLER_175_836 VDD VDD VSS VSS gf180mcu_as_sc_mcu7t3v3__fillcap_4
XFILLER_186_151 VDD VDD VSS VSS gf180mcu_as_sc_mcu7t3v3__fillcap_16
XFILLER_187_696 VDD VDD VSS VSS gf180mcu_as_sc_mcu7t3v3__fillcap_4
XFILLER_30_864 VDD VDD VSS VSS gf180mcu_as_sc_mcu7t3v3__fill_2
X_4670_ VDD VDD VSS VSS _5242_/D _5242_/Q _4685_/C _4670_/C gf180mcu_as_sc_mcu7t3v3__ao21_2
XFILLER_174_324 VDD VDD VSS VSS gf180mcu_as_sc_mcu7t3v3__fillcap_16
XFILLER_31_1122 VDD VDD VSS VSS gf180mcu_as_sc_mcu7t3v3__fillcap_8
XPHY_EDGE_ROW_115_3_Left_500 VDD VSS gf180mcu_as_sc_mcu7t3v3__tap_2
X_3621_ VDD VDD VSS VSS _3992_/A _3652_/B _3621_/C _3621_/D _3622_/C gf180mcu_as_sc_mcu7t3v3__ao211_2
X_3552_ VDD VDD VSS VSS _3801_/B _3561_/A gf180mcu_as_sc_mcu7t3v3__inv_2
XFILLER_190_839 VDD VDD VSS VSS gf180mcu_as_sc_mcu7t3v3__fillcap_16
XFILLER_200_1469 VDD VDD VSS VSS gf180mcu_as_sc_mcu7t3v3__fillcap_16
XPHY_EDGE_ROW_37_3_Right_74 VDD VSS gf180mcu_as_sc_mcu7t3v3__tap_2
X_2503_ VDD VDD VSS VSS _2546_/B _2503_/B _5189_/Q gf180mcu_as_sc_mcu7t3v3__nand2_2
XTAP_TAPCELL_ROW_78_1_1679 VDD VSS gf180mcu_as_sc_mcu7t3v3__tap_2
X_3483_ VDD VDD VSS VSS _3505_/S _3483_/B _3483_/A _3484_/B gf180mcu_as_sc_mcu7t3v3__mux2_2
XFILLER_102_107 VDD VDD VSS VSS gf180mcu_as_sc_mcu7t3v3__fillcap_16
XFILLER_157_1379 VDD VDD VSS VSS gf180mcu_as_sc_mcu7t3v3__fill_2
XFILLER_192_1259 VDD VDD VSS VSS gf180mcu_as_sc_mcu7t3v3__fillcap_16
X_5222_ VDD VDD VSS VSS _5233_/CLK _5222_/D _5222_/Q gf180mcu_as_sc_mcu7t3v3__dfxtp_2
X_2434_ VDD VDD VSS VSS _3661_/A _4034_/A gf180mcu_as_sc_mcu7t3v3__inv_2
XTAP_TAPCELL_ROW_184_2215 VDD VSS gf180mcu_as_sc_mcu7t3v3__tap_2
XFILLER_83_1565 VDD VDD VSS VSS gf180mcu_as_sc_mcu7t3v3__fillcap_4
X_5153_ VDD VDD VSS VSS _5198_/CLK _5153_/D _5153_/Q gf180mcu_as_sc_mcu7t3v3__dfxtp_2
XTAP_TAPCELL_ROW_184_2226 VDD VSS gf180mcu_as_sc_mcu7t3v3__tap_2
XFILLER_131_1508 VDD VDD VSS VSS gf180mcu_as_sc_mcu7t3v3__fill_2
XFILLER_170_1568 VDD VDD VSS VSS gf180mcu_as_sc_mcu7t3v3__fill_1
XFILLER_9_1189 VDD VDD VSS VSS gf180mcu_as_sc_mcu7t3v3__fill_1
XPHY_EDGE_ROW_142_1_Right_663 VDD VSS gf180mcu_as_sc_mcu7t3v3__tap_2
XPHY_EDGE_ROW_71_1_Left_281 VDD VSS gf180mcu_as_sc_mcu7t3v3__tap_2
X_4104_ VDD VDD VSS VSS _4104_/A _4104_/B _4104_/C _4104_/D _4105_/D gf180mcu_as_sc_mcu7t3v3__ao22_2
X_5084_ VDD VDD VSS VSS _5085_/CLK _5084_/D _5084_/Q gf180mcu_as_sc_mcu7t3v3__dfxtp_2
XTAP_TAPCELL_ROW_0_702 VDD VSS gf180mcu_as_sc_mcu7t3v3__tap_2
XTAP_TAPCELL_ROW_0_713 VDD VSS gf180mcu_as_sc_mcu7t3v3__tap_2
X_4035_ VDD VDD VSS VSS _4035_/B _4107_/A _4241_/B gf180mcu_as_sc_mcu7t3v3__and2_2
XFILLER_112_27 VDD VDD VSS VSS gf180mcu_as_sc_mcu7t3v3__fillcap_8
XFILLER_168_1431 VDD VDD VSS VSS gf180mcu_as_sc_mcu7t3v3__fillcap_16
XFILLER_168_1453 VDD VDD VSS VSS gf180mcu_as_sc_mcu7t3v3__fillcap_16
XTAP_TAPCELL_ROW_0_724 VDD VSS gf180mcu_as_sc_mcu7t3v3__tap_2
XTAP_TAPCELL_ROW_0_735 VDD VSS gf180mcu_as_sc_mcu7t3v3__tap_2
XFILLER_129_1415 VDD VDD VSS VSS gf180mcu_as_sc_mcu7t3v3__fill_1
XFILLER_24_135 VDD VDD VSS VSS gf180mcu_as_sc_mcu7t3v3__fillcap_16
XFILLER_197_416 VDD VDD VSS VSS gf180mcu_as_sc_mcu7t3v3__fillcap_4
XFILLER_209_1450 VDD VDD VSS VSS gf180mcu_as_sc_mcu7t3v3__fillcap_16
XFILLER_12_319 VDD VDD VSS VSS gf180mcu_as_sc_mcu7t3v3__fill_1
XFILLER_209_1472 VDD VDD VSS VSS gf180mcu_as_sc_mcu7t3v3__fillcap_16
XFILLER_36_1022 VDD VDD VSS VSS gf180mcu_as_sc_mcu7t3v3__fillcap_16
X_4937_ VDD VDD VSS VSS _4977_/CLK _4937_/D _4937_/Q gf180mcu_as_sc_mcu7t3v3__dfxtp_2
XANTENNA_20 VDD VDD VSS VSS _4018_/B gf180mcu_as_sc_mcu7t3v3__diode_2
XANTENNA_31 VDD VDD VSS VSS _4023_/A gf180mcu_as_sc_mcu7t3v3__diode_2
XFILLER_21_842 VDD VDD VSS VSS gf180mcu_as_sc_mcu7t3v3__fillcap_16
XPHY_EDGE_ROW_47_3_Left_432 VDD VSS gf180mcu_as_sc_mcu7t3v3__tap_2
X_4868_ VDD VDD VSS VSS _5220_/CLK _4868_/D _4868_/Q gf180mcu_as_sc_mcu7t3v3__dfxtp_2
X_3819_ VDD VDD VSS VSS _3927_/A _3920_/B _3929_/B _3922_/C _3820_/B gf180mcu_as_sc_mcu7t3v3__nand4_2
XFILLER_14_1364 VDD VDD VSS VSS gf180mcu_as_sc_mcu7t3v3__fill_1
X_4799_ VDD VDD VSS VSS _5214_/CLK _4799_/D _4799_/Q gf180mcu_as_sc_mcu7t3v3__dfxtp_2
XFILLER_10_1217 VDD VDD VSS VSS gf180mcu_as_sc_mcu7t3v3__fillcap_8
XFILLER_140_1394 VDD VDD VSS VSS gf180mcu_as_sc_mcu7t3v3__fillcap_16
XFILLER_175_1402 VDD VDD VSS VSS gf180mcu_as_sc_mcu7t3v3__fillcap_16
XFILLER_181_839 VDD VDD VSS VSS gf180mcu_as_sc_mcu7t3v3__fill_1
XFILLER_49_1405 VDD VDD VSS VSS gf180mcu_as_sc_mcu7t3v3__fillcap_8
XFILLER_49_1449 VDD VDD VSS VSS gf180mcu_as_sc_mcu7t3v3__fillcap_16
XFILLER_101_173 VDD VDD VSS VSS gf180mcu_as_sc_mcu7t3v3__fill_1
XFILLER_112_1441 VDD VDD VSS VSS gf180mcu_as_sc_mcu7t3v3__fillcap_8
XFILLER_210_1053 VDD VDD VSS VSS gf180mcu_as_sc_mcu7t3v3__fill_1
XFILLER_28_485 VDD VDD VSS VSS gf180mcu_as_sc_mcu7t3v3__fill_1
XFILLER_29_986 VDD VDD VSS VSS gf180mcu_as_sc_mcu7t3v3__fillcap_16
XFILLER_95_1414 VDD VDD VSS VSS gf180mcu_as_sc_mcu7t3v3__fill_2
XFILLER_147_1515 VDD VDD VSS VSS gf180mcu_as_sc_mcu7t3v3__fillcap_16
XFILLER_16_647 VDD VDD VSS VSS gf180mcu_as_sc_mcu7t3v3__fillcap_4
XFILLER_182_1417 VDD VDD VSS VSS gf180mcu_as_sc_mcu7t3v3__fillcap_4
XFILLER_189_906 VDD VDD VSS VSS gf180mcu_as_sc_mcu7t3v3__fillcap_4
XFILLER_189_928 VDD VDD VSS VSS gf180mcu_as_sc_mcu7t3v3__fillcap_16
XFILLER_204_715 VDD VDD VSS VSS gf180mcu_as_sc_mcu7t3v3__fillcap_16
XFILLER_204_737 VDD VDD VSS VSS gf180mcu_as_sc_mcu7t3v3__fillcap_16
XFILLER_95_1469 VDD VDD VSS VSS gf180mcu_as_sc_mcu7t3v3__fill_2
XFILLER_102_93 VDD VDD VSS VSS gf180mcu_as_sc_mcu7t3v3__fill_1
XFILLER_188_449 VDD VDD VSS VSS gf180mcu_as_sc_mcu7t3v3__fillcap_4
XFILLER_31_628 VDD VDD VSS VSS gf180mcu_as_sc_mcu7t3v3__fill_2
XFILLER_62_53 VDD VDD VSS VSS gf180mcu_as_sc_mcu7t3v3__fillcap_8
XTAP_TAPCELL_ROW_108_3_3044 VDD VSS gf180mcu_as_sc_mcu7t3v3__tap_2
XFILLER_178_53 VDD VDD VSS VSS gf180mcu_as_sc_mcu7t3v3__fillcap_16
XFILLER_32_1453 VDD VDD VSS VSS gf180mcu_as_sc_mcu7t3v3__fillcap_8
XFILLER_184_699 VDD VDD VSS VSS gf180mcu_as_sc_mcu7t3v3__fillcap_16
XFILLER_178_1081 VDD VDD VSS VSS gf180mcu_as_sc_mcu7t3v3__fillcap_4
XFILLER_194_85 VDD VDD VSS VSS gf180mcu_as_sc_mcu7t3v3__fillcap_16
XFILLER_3_562 VDD VDD VSS VSS gf180mcu_as_sc_mcu7t3v3__fillcap_16
XFILLER_26_1224 VDD VDD VSS VSS gf180mcu_as_sc_mcu7t3v3__fill_1
XFILLER_87_72 VDD VDD VSS VSS gf180mcu_as_sc_mcu7t3v3__fillcap_4
XTAP_TAPCELL_ROW_33_1447 VDD VSS gf180mcu_as_sc_mcu7t3v3__tap_2
XTAP_TAPCELL_ROW_7_890 VDD VSS gf180mcu_as_sc_mcu7t3v3__tap_2
XTAP_TAPCELL_ROW_33_1458 VDD VSS gf180mcu_as_sc_mcu7t3v3__tap_2
XTAP_TAPCELL_ROW_151_1_1897 VDD VSS gf180mcu_as_sc_mcu7t3v3__tap_2
XFILLER_19_452 VDD VDD VSS VSS gf180mcu_as_sc_mcu7t3v3__fill_1
XTAP_TAPCELL_ROW_53_3_2881 VDD VSS gf180mcu_as_sc_mcu7t3v3__tap_2
XFILLER_185_1030 VDD VDD VSS VSS gf180mcu_as_sc_mcu7t3v3__fillcap_16
XFILLER_185_1052 VDD VDD VSS VSS gf180mcu_as_sc_mcu7t3v3__fillcap_16
XFILLER_19_496 VDD VDD VSS VSS gf180mcu_as_sc_mcu7t3v3__fill_1
XFILLER_15_680 VDD VDD VSS VSS gf180mcu_as_sc_mcu7t3v3__fillcap_16
XFILLER_210_729 VDD VDD VSS VSS gf180mcu_as_sc_mcu7t3v3__fill_2
XFILLER_76_1391 VDD VDD VSS VSS gf180mcu_as_sc_mcu7t3v3__fill_2
X_2983_ VDD VDD VSS VSS _3008_/S _3965_/D _3968_/A _2986_/B gf180mcu_as_sc_mcu7t3v3__mux2_2
XTAP_TAPCELL_ROW_177_2063 VDD VSS gf180mcu_as_sc_mcu7t3v3__tap_2
XFILLER_37_1364 VDD VDD VSS VSS gf180mcu_as_sc_mcu7t3v3__fillcap_8
X_4722_ VDD VDD VSS VSS _5263_/Q _4730_/B _4730_/C _5262_/Q _4723_/B gf180mcu_as_sc_mcu7t3v3__ao22_2
XTAP_TAPCELL_ROW_177_2074 VDD VSS gf180mcu_as_sc_mcu7t3v3__tap_2
XFILLER_50_1520 VDD VDD VSS VSS gf180mcu_as_sc_mcu7t3v3__fill_1
XFILLER_50_1564 VDD VDD VSS VSS gf180mcu_as_sc_mcu7t3v3__fillcap_4
Xinput40 VDD VDD VSS VSS dft_wdata[5] _2723_/B gf180mcu_as_sc_mcu7t3v3__buff_12
X_4653_ VDD VDD VSS VSS _4653_/B _4657_/B _4654_/B gf180mcu_as_sc_mcu7t3v3__or2_2
XFILLER_174_176 VDD VDD VSS VSS gf180mcu_as_sc_mcu7t3v3__fill_2
Xinput51 VDD VDD VSS VSS east_in[16] wire854/A gf180mcu_as_sc_mcu7t3v3__buff_12
Xinput62 VDD VDD VSS VSS east_in[26] wire844/A gf180mcu_as_sc_mcu7t3v3__buff_12
Xinput73 VDD VDD VSS VSS east_in[5] _3975_/A gf180mcu_as_sc_mcu7t3v3__buff_12
X_4584_ VDD VDD VSS VSS _4588_/B _5088_/Q _4586_/S gf180mcu_as_sc_mcu7t3v3__nand2_2
X_3604_ VDD VDD VSS VSS _3975_/A _3649_/B _3604_/C _3604_/D _3606_/C gf180mcu_as_sc_mcu7t3v3__ao211_2
XFILLER_7_890 VDD VDD VSS VSS gf180mcu_as_sc_mcu7t3v3__fillcap_16
XTAP_TAPCELL_ROW_122_1_1811 VDD VSS gf180mcu_as_sc_mcu7t3v3__tap_2
Xinput84 VDD VDD VSS VSS ne_in[15] wire829/A gf180mcu_as_sc_mcu7t3v3__buff_12
Xinput95 VDD VDD VSS VSS ne_in[25] _4135_/A gf180mcu_as_sc_mcu7t3v3__buff_12
X_3535_ VDD VDD VSS VSS _3799_/A _3932_/B _3535_/A gf180mcu_as_sc_mcu7t3v3__nand2_2
XTAP_TAPCELL_ROW_134_3_3123 VDD VSS gf180mcu_as_sc_mcu7t3v3__tap_2
Xmax_cap565 VDD VDD VSS VSS _3921_/Y fanout562/A gf180mcu_as_sc_mcu7t3v3__clkbuff_12
X_3466_ VDD VDD VSS VSS _4121_/D _3466_/B _3466_/C _3466_/D _3468_/C gf180mcu_as_sc_mcu7t3v3__ao211_2
X_5205_ VDD VDD VSS VSS _5216_/CLK _5205_/D _5205_/Q gf180mcu_as_sc_mcu7t3v3__dfxtp_2
X_2417_ VDD VDD VSS VSS _3224_/D _3510_/A gf180mcu_as_sc_mcu7t3v3__inv_2
X_3397_ VDD VDD VSS VSS _4048_/D _3452_/S _3453_/C _4049_/A _3398_/D gf180mcu_as_sc_mcu7t3v3__ao22_2
XTAP_TAPCELL_ROW_5_838 VDD VSS gf180mcu_as_sc_mcu7t3v3__tap_2
XFILLER_96_171 VDD VDD VSS VSS gf180mcu_as_sc_mcu7t3v3__fillcap_4
X_5136_ VDD VDD VSS VSS _5197_/CLK _5136_/D _5136_/Q gf180mcu_as_sc_mcu7t3v3__dfxtp_2
XTAP_TAPCELL_ROW_5_849 VDD VSS gf180mcu_as_sc_mcu7t3v3__tap_2
XTAP_TAPCELL_ROW_209_2774 VDD VSS gf180mcu_as_sc_mcu7t3v3__tap_2
XTAP_TAPCELL_ROW_209_2763 VDD VSS gf180mcu_as_sc_mcu7t3v3__tap_2
XFILLER_29_249 VDD VDD VSS VSS gf180mcu_as_sc_mcu7t3v3__fillcap_8
XFILLER_79_1409 VDD VDD VSS VSS gf180mcu_as_sc_mcu7t3v3__fillcap_4
XFILLER_96_193 VDD VDD VSS VSS gf180mcu_as_sc_mcu7t3v3__fillcap_16
XPHY_EDGE_ROW_143_1_Right_664 VDD VSS gf180mcu_as_sc_mcu7t3v3__tap_2
X_5067_ VDD VDD VSS VSS clkload2/A _5067_/D _5067_/Q gf180mcu_as_sc_mcu7t3v3__dfxtp_2
XFILLER_44_219 VDD VDD VSS VSS gf180mcu_as_sc_mcu7t3v3__fill_2
X_4018_ VDD VDD VSS VSS _4106_/S _4018_/B _4018_/A _4019_/B gf180mcu_as_sc_mcu7t3v3__mux2_2
XFILLER_25_422 VDD VDD VSS VSS gf180mcu_as_sc_mcu7t3v3__fillcap_8
XPHY_EDGE_ROW_9_Left_220 VDD VSS gf180mcu_as_sc_mcu7t3v3__tap_2
XFILLER_0_1495 VDD VDD VSS VSS gf180mcu_as_sc_mcu7t3v3__fill_1
XFILLER_186_909 VDD VDD VSS VSS gf180mcu_as_sc_mcu7t3v3__fillcap_16
XFILLER_201_718 VDD VDD VSS VSS gf180mcu_as_sc_mcu7t3v3__fillcap_16
XFILLER_205_1100 VDD VDD VSS VSS gf180mcu_as_sc_mcu7t3v3__fillcap_16
XFILLER_181_1472 VDD VDD VSS VSS gf180mcu_as_sc_mcu7t3v3__fillcap_8
XFILLER_185_408 VDD VDD VSS VSS gf180mcu_as_sc_mcu7t3v3__fillcap_8
XFILLER_205_1122 VDD VDD VSS VSS gf180mcu_as_sc_mcu7t3v3__fillcap_16
XFILLER_103_1418 VDD VDD VSS VSS gf180mcu_as_sc_mcu7t3v3__fillcap_16
XFILLER_193_430 VDD VDD VSS VSS gf180mcu_as_sc_mcu7t3v3__fillcap_4
XTAP_TAPCELL_ROW_78_3_2954 VDD VSS gf180mcu_as_sc_mcu7t3v3__tap_2
XFILLER_148_34 VDD VDD VSS VSS gf180mcu_as_sc_mcu7t3v3__fill_1
XFILLER_165_132 VDD VDD VSS VSS gf180mcu_as_sc_mcu7t3v3__fill_1
XFILLER_193_452 VDD VDD VSS VSS gf180mcu_as_sc_mcu7t3v3__fillcap_16
XFILLER_20_160 VDD VDD VSS VSS gf180mcu_as_sc_mcu7t3v3__fillcap_8
XFILLER_20_193 VDD VDD VSS VSS gf180mcu_as_sc_mcu7t3v3__fillcap_16
XFILLER_148_67 VDD VDD VSS VSS gf180mcu_as_sc_mcu7t3v3__fill_1
XFILLER_14_1183 VDD VDD VSS VSS gf180mcu_as_sc_mcu7t3v3__fill_1
XFILLER_181_614 VDD VDD VSS VSS gf180mcu_as_sc_mcu7t3v3__fillcap_16
XTAP_TAPCELL_ROW_48_1_1590 VDD VSS gf180mcu_as_sc_mcu7t3v3__tap_2
XFILLER_10_1047 VDD VDD VSS VSS gf180mcu_as_sc_mcu7t3v3__fillcap_16
Xclkbuf_leaf_40_clk_regs VDD VDD VSS VSS clkbuf_leaf_2_clk_regs/A _4916_/CLK gf180mcu_as_sc_mcu7t3v3__clkbuff_12
XTAP_TAPCELL_ROW_58_3_2896 VDD VSS gf180mcu_as_sc_mcu7t3v3__tap_2
XFILLER_208_317 VDD VDD VSS VSS gf180mcu_as_sc_mcu7t3v3__fillcap_4
XFILLER_21_1110 VDD VDD VSS VSS gf180mcu_as_sc_mcu7t3v3__fillcap_8
XFILLER_17_901 VDD VDD VSS VSS gf180mcu_as_sc_mcu7t3v3__fillcap_8
XFILLER_17_912 VDD VDD VSS VSS gf180mcu_as_sc_mcu7t3v3__fillcap_8
XFILLER_21_1154 VDD VDD VSS VSS gf180mcu_as_sc_mcu7t3v3__fillcap_16
XFILLER_29_772 VDD VDD VSS VSS gf180mcu_as_sc_mcu7t3v3__fillcap_16
XFILLER_5_1362 VDD VDD VSS VSS gf180mcu_as_sc_mcu7t3v3__fillcap_4
XTAP_TAPCELL_ROW_160_3_3202 VDD VSS gf180mcu_as_sc_mcu7t3v3__tap_2
XFILLER_186_1361 VDD VDD VSS VSS gf180mcu_as_sc_mcu7t3v3__fillcap_4
XFILLER_28_271 VDD VDD VSS VSS gf180mcu_as_sc_mcu7t3v3__fillcap_4
XFILLER_113_92 VDD VDD VSS VSS gf180mcu_as_sc_mcu7t3v3__fill_2
XFILLER_177_909 VDD VDD VSS VSS gf180mcu_as_sc_mcu7t3v3__fill_1
XTAP_TAPCELL_ROW_127_1_1826 VDD VSS gf180mcu_as_sc_mcu7t3v3__tap_2
XFILLER_12_661 VDD VDD VSS VSS gf180mcu_as_sc_mcu7t3v3__fillcap_4
XTAP_TAPCELL_ROW_139_3_3138 VDD VSS gf180mcu_as_sc_mcu7t3v3__tap_2
XTAP_TAPCELL_ROW_26_1295 VDD VSS gf180mcu_as_sc_mcu7t3v3__tap_2
XFILLER_12_683 VDD VDD VSS VSS gf180mcu_as_sc_mcu7t3v3__fillcap_4
XFILLER_201_1520 VDD VDD VSS VSS gf180mcu_as_sc_mcu7t3v3__fillcap_16
XFILLER_7_120 VDD VDD VSS VSS gf180mcu_as_sc_mcu7t3v3__fillcap_16
XFILLER_201_1542 VDD VDD VSS VSS gf180mcu_as_sc_mcu7t3v3__fill_2
XFILLER_7_142 VDD VDD VSS VSS gf180mcu_as_sc_mcu7t3v3__fillcap_16
XFILLER_193_1310 VDD VDD VSS VSS gf180mcu_as_sc_mcu7t3v3__fillcap_16
XFILLER_208_37 VDD VDD VSS VSS gf180mcu_as_sc_mcu7t3v3__fillcap_16
XFILLER_119_1414 VDD VDD VSS VSS gf180mcu_as_sc_mcu7t3v3__fill_2
XFILLER_193_1332 VDD VDD VSS VSS gf180mcu_as_sc_mcu7t3v3__fillcap_16
X_3320_ VDD VDD VSS VSS _4920_/Q _3402_/B _3402_/C _3974_/A _3321_/C gf180mcu_as_sc_mcu7t3v3__ao22_2
XTAP_TAPCELL_ROW_35_1509 VDD VSS gf180mcu_as_sc_mcu7t3v3__tap_2
X_3251_ VDD VDD VSS VSS _3518_/C _3268_/A _3486_/B gf180mcu_as_sc_mcu7t3v3__nand2b_2
XFILLER_26_1054 VDD VDD VSS VSS gf180mcu_as_sc_mcu7t3v3__fillcap_8
X_3182_ VDD VDD VSS VSS _3775_/A _3182_/B _3182_/C _4798_/D _3831_/A gf180mcu_as_sc_mcu7t3v3__aoi211_2
XFILLER_14_2 VDD VDD VSS VSS gf180mcu_as_sc_mcu7t3v3__fillcap_16
XFILLER_26_1076 VDD VDD VSS VSS gf180mcu_as_sc_mcu7t3v3__fillcap_8
XFILLER_26_1087 VDD VDD VSS VSS gf180mcu_as_sc_mcu7t3v3__fillcap_16
XFILLER_130_1393 VDD VDD VSS VSS gf180mcu_as_sc_mcu7t3v3__fillcap_8
XFILLER_19_282 VDD VDD VSS VSS gf180mcu_as_sc_mcu7t3v3__fillcap_16
XFILLER_78_1453 VDD VDD VSS VSS gf180mcu_as_sc_mcu7t3v3__fillcap_16
XFILLER_93_185 VDD VDD VSS VSS gf180mcu_as_sc_mcu7t3v3__fillcap_16
XTAP_TAPCELL_ROW_204_2660 VDD VSS gf180mcu_as_sc_mcu7t3v3__tap_2
XTAP_TAPCELL_ROW_179_2114 VDD VSS gf180mcu_as_sc_mcu7t3v3__tap_2
XTAP_TAPCELL_ROW_179_2103 VDD VSS gf180mcu_as_sc_mcu7t3v3__tap_2
XFILLER_165_1412 VDD VDD VSS VSS gf180mcu_as_sc_mcu7t3v3__fillcap_4
XFILLER_39_1415 VDD VDD VSS VSS gf180mcu_as_sc_mcu7t3v3__fill_1
XPHY_EDGE_ROW_102_1_Left_312 VDD VSS gf180mcu_as_sc_mcu7t3v3__tap_2
XTAP_TAPCELL_ROW_204_2671 VDD VSS gf180mcu_as_sc_mcu7t3v3__tap_2
XFILLER_22_414 VDD VDD VSS VSS gf180mcu_as_sc_mcu7t3v3__fillcap_16
XTAP_TAPCELL_ROW_200_2568 VDD VSS gf180mcu_as_sc_mcu7t3v3__tap_2
XFILLER_179_268 VDD VDD VSS VSS gf180mcu_as_sc_mcu7t3v3__fill_1
XFILLER_206_1431 VDD VDD VSS VSS gf180mcu_as_sc_mcu7t3v3__fillcap_4
XFILLER_34_296 VDD VDD VSS VSS gf180mcu_as_sc_mcu7t3v3__fillcap_16
XTAP_TAPCELL_ROW_200_2579 VDD VSS gf180mcu_as_sc_mcu7t3v3__tap_2
XTAP_TAPCELL_ROW_196_2494 VDD VSS gf180mcu_as_sc_mcu7t3v3__tap_2
XTAP_TAPCELL_ROW_196_2483 VDD VSS gf180mcu_as_sc_mcu7t3v3__tap_2
XFILLER_194_238 VDD VDD VSS VSS gf180mcu_as_sc_mcu7t3v3__fillcap_4
XFILLER_206_1453 VDD VDD VSS VSS gf180mcu_as_sc_mcu7t3v3__fillcap_16
XFILLER_210_559 VDD VDD VSS VSS gf180mcu_as_sc_mcu7t3v3__fill_2
X_2966_ VDD VDD VSS VSS _3948_/A _3042_/B _3042_/C _3947_/A _2972_/B gf180mcu_as_sc_mcu7t3v3__ao22_2
XFILLER_187_290 VDD VDD VSS VSS gf180mcu_as_sc_mcu7t3v3__fillcap_4
XFILLER_191_912 VDD VDD VSS VSS gf180mcu_as_sc_mcu7t3v3__fillcap_16
XFILLER_198_1221 VDD VDD VSS VSS gf180mcu_as_sc_mcu7t3v3__fillcap_4
X_4705_ VDD VDD VSS VSS _4705_/D _4705_/A _4705_/B _4705_/C _4706_/B gf180mcu_as_sc_mcu7t3v3__ao31_2
X_2897_ VDD VDD VSS VSS _3914_/A _4977_/Q _4943_/Q gf180mcu_as_sc_mcu7t3v3__nor2_2
XFILLER_102_1440 VDD VDD VSS VSS gf180mcu_as_sc_mcu7t3v3__fillcap_8
XFILLER_147_154 VDD VDD VSS VSS gf180mcu_as_sc_mcu7t3v3__fillcap_16
XFILLER_15_1492 VDD VDD VSS VSS gf180mcu_as_sc_mcu7t3v3__fillcap_4
XFILLER_175_474 VDD VDD VSS VSS gf180mcu_as_sc_mcu7t3v3__fill_2
XFILLER_198_1243 VDD VDD VSS VSS gf180mcu_as_sc_mcu7t3v3__fillcap_16
X_4636_ VDD VDD VSS VSS _4642_/S _5113_/Q _5227_/Q _5227_/D gf180mcu_as_sc_mcu7t3v3__mux2_2
XFILLER_118_37 VDD VDD VSS VSS gf180mcu_as_sc_mcu7t3v3__fillcap_4
XFILLER_11_1356 VDD VDD VSS VSS gf180mcu_as_sc_mcu7t3v3__fillcap_4
XFILLER_50_1383 VDD VDD VSS VSS gf180mcu_as_sc_mcu7t3v3__fillcap_16
XFILLER_190_477 VDD VDD VSS VSS gf180mcu_as_sc_mcu7t3v3__fill_2
XPHY_EDGE_ROW_205_Right_68 VDD VSS gf180mcu_as_sc_mcu7t3v3__tap_2
XTAP_TAPCELL_ROW_153_1_1905 VDD VSS gf180mcu_as_sc_mcu7t3v3__tap_2
X_4567_ VDD VDD VSS VSS _4567_/B _4591_/A _4574_/C gf180mcu_as_sc_mcu7t3v3__and2_2
XFILLER_137_1558 VDD VDD VSS VSS gf180mcu_as_sc_mcu7t3v3__fillcap_8
X_4498_ VDD VDD VSS VSS _4502_/B _5078_/Q _4500_/S gf180mcu_as_sc_mcu7t3v3__nand2_2
X_3518_ VDD VDD VSS VSS _3520_/C _3518_/C _3518_/B _3518_/A gf180mcu_as_sc_mcu7t3v3__aoi21_2
XTAP_TAPCELL_ROW_165_3_3217 VDD VSS gf180mcu_as_sc_mcu7t3v3__tap_2
XFILLER_170_190 VDD VDD VSS VSS gf180mcu_as_sc_mcu7t3v3__fillcap_4
X_3449_ VDD VDD VSS VSS _3451_/C _4101_/D _3449_/B _3449_/C gf180mcu_as_sc_mcu7t3v3__ao21_2
X_5119_ VDD VDD VSS VSS clkload7/A _5119_/D _5119_/Q gf180mcu_as_sc_mcu7t3v3__dfxtp_2
XPHY_EDGE_ROW_144_1_Right_665 VDD VSS gf180mcu_as_sc_mcu7t3v3__tap_2
XFILLER_175_6 VDD VDD VSS VSS gf180mcu_as_sc_mcu7t3v3__fillcap_16
XFILLER_22_1474 VDD VDD VSS VSS gf180mcu_as_sc_mcu7t3v3__fill_2
XFILLER_2_1557 VDD VDD VSS VSS gf180mcu_as_sc_mcu7t3v3__fillcap_8
XFILLER_96_1520 VDD VDD VSS VSS gf180mcu_as_sc_mcu7t3v3__fill_1
XFILLER_57_1504 VDD VDD VSS VSS gf180mcu_as_sc_mcu7t3v3__fillcap_4
XFILLER_14_926 VDD VDD VSS VSS gf180mcu_as_sc_mcu7t3v3__fillcap_8
XFILLER_92_1439 VDD VDD VSS VSS gf180mcu_as_sc_mcu7t3v3__fillcap_8
XTAP_TAPCELL_ROW_99_1_1742 VDD VSS gf180mcu_as_sc_mcu7t3v3__tap_2
XFILLER_159_22 VDD VDD VSS VSS gf180mcu_as_sc_mcu7t3v3__fillcap_16
XFILLER_16_1223 VDD VDD VSS VSS gf180mcu_as_sc_mcu7t3v3__fill_2
XPHY_EDGE_ROW_120_3_Right_157 VDD VSS gf180mcu_as_sc_mcu7t3v3__tap_2
XFILLER_138_187 VDD VDD VSS VSS gf180mcu_as_sc_mcu7t3v3__fill_1
XFILLER_181_422 VDD VDD VSS VSS gf180mcu_as_sc_mcu7t3v3__fillcap_4
XFILLER_193_282 VDD VDD VSS VSS gf180mcu_as_sc_mcu7t3v3__fillcap_4
XFILLER_5_646 VDD VDD VSS VSS gf180mcu_as_sc_mcu7t3v3__fill_2
XFILLER_175_54 VDD VDD VSS VSS gf180mcu_as_sc_mcu7t3v3__fillcap_16
XFILLER_181_477 VDD VDD VSS VSS gf180mcu_as_sc_mcu7t3v3__fill_2
XTAP_TAPCELL_ROW_21_1192 VDD VSS gf180mcu_as_sc_mcu7t3v3__tap_2
XTAP_TAPCELL_ROW_9_930 VDD VSS gf180mcu_as_sc_mcu7t3v3__tap_2
XFILLER_175_1084 VDD VDD VSS VSS gf180mcu_as_sc_mcu7t3v3__fillcap_16
XFILLER_7_1402 VDD VDD VSS VSS gf180mcu_as_sc_mcu7t3v3__fillcap_8
XFILLER_1_885 VDD VDD VSS VSS gf180mcu_as_sc_mcu7t3v3__fillcap_4
XFILLER_209_626 VDD VDD VSS VSS gf180mcu_as_sc_mcu7t3v3__fillcap_4
XFILLER_7_1468 VDD VDD VSS VSS gf180mcu_as_sc_mcu7t3v3__fill_2
Xinput230 VDD VDD VSS VSS south_in[23] _4121_/D gf180mcu_as_sc_mcu7t3v3__buff_12
Xinput241 VDD VDD VSS VSS south_in[33] wire865/A gf180mcu_as_sc_mcu7t3v3__buff_12
Xinput252 VDD VDD VSS VSS sw_in[12] _4034_/A gf180mcu_as_sc_mcu7t3v3__buff_12
Xinput263 VDD VDD VSS VSS sw_in[22] _2444_/A gf180mcu_as_sc_mcu7t3v3__buff_12
XFILLER_188_1434 VDD VDD VSS VSS gf180mcu_as_sc_mcu7t3v3__fill_1
XFILLER_208_136 VDD VDD VSS VSS gf180mcu_as_sc_mcu7t3v3__fillcap_4
XFILLER_209_648 VDD VDD VSS VSS gf180mcu_as_sc_mcu7t3v3__fillcap_16
Xinput274 VDD VDD VSS VSS sw_in[32] _3524_/A gf180mcu_as_sc_mcu7t3v3__buff_12
Xinput285 VDD VDD VSS VSS west_in[11] _4021_/D gf180mcu_as_sc_mcu7t3v3__buff_12
Xinput296 VDD VDD VSS VSS west_in[21] _4101_/A gf180mcu_as_sc_mcu7t3v3__buff_12
XFILLER_114_1399 VDD VDD VSS VSS gf180mcu_as_sc_mcu7t3v3__fillcap_8
XFILLER_149_1418 VDD VDD VSS VSS gf180mcu_as_sc_mcu7t3v3__fillcap_16
XFILLER_17_731 VDD VDD VSS VSS gf180mcu_as_sc_mcu7t3v3__fillcap_8
XFILLER_1_1034 VDD VDD VSS VSS gf180mcu_as_sc_mcu7t3v3__fillcap_16
XFILLER_36_539 VDD VDD VSS VSS gf180mcu_as_sc_mcu7t3v3__fillcap_4
XFILLER_5_1192 VDD VDD VSS VSS gf180mcu_as_sc_mcu7t3v3__fillcap_8
XFILLER_75_174 VDD VDD VSS VSS gf180mcu_as_sc_mcu7t3v3__fillcap_16
XFILLER_84_84 VDD VDD VSS VSS gf180mcu_as_sc_mcu7t3v3__fill_2
XFILLER_182_1011 VDD VDD VSS VSS gf180mcu_as_sc_mcu7t3v3__fillcap_4
XFILLER_182_1033 VDD VDD VSS VSS gf180mcu_as_sc_mcu7t3v3__fillcap_16
XFILLER_31_200 VDD VDD VSS VSS gf180mcu_as_sc_mcu7t3v3__fillcap_8
XPHY_EDGE_ROW_46_3_Right_83 VDD VSS gf180mcu_as_sc_mcu7t3v3__tap_2
XTAP_TAPCELL_ROW_28_1346 VDD VSS gf180mcu_as_sc_mcu7t3v3__tap_2
XTAP_TAPCELL_ROW_28_1357 VDD VSS gf180mcu_as_sc_mcu7t3v3__tap_2
XTAP_TAPCELL_ROW_174_2000 VDD VSS gf180mcu_as_sc_mcu7t3v3__tap_2
X_2820_ VDD VDD VSS VSS _4974_/D _2828_/B _4759_/Q _4758_/D gf180mcu_as_sc_mcu7t3v3__mux2_2
XTAP_TAPCELL_ROW_174_2011 VDD VSS gf180mcu_as_sc_mcu7t3v3__tap_2
XFILLER_12_480 VDD VDD VSS VSS gf180mcu_as_sc_mcu7t3v3__fill_1
XFILLER_185_750 VDD VDD VSS VSS gf180mcu_as_sc_mcu7t3v3__fillcap_16
XFILLER_34_1367 VDD VDD VSS VSS gf180mcu_as_sc_mcu7t3v3__fillcap_16
X_2751_ VDD VDD VSS VSS _5478_/A _2833_/A _2812_/B gf180mcu_as_sc_mcu7t3v3__and2_2
XFILLER_129_154 VDD VDD VSS VSS gf180mcu_as_sc_mcu7t3v3__fillcap_16
XFILLER_185_772 VDD VDD VSS VSS gf180mcu_as_sc_mcu7t3v3__fillcap_16
XFILLER_76_4 VDD VDD VSS VSS gf180mcu_as_sc_mcu7t3v3__fill_1
XPHY_EDGE_ROW_80_1_Left_290 VDD VSS gf180mcu_as_sc_mcu7t3v3__tap_2
X_2682_ VDD VDD VSS VSS _4590_/A _4267_/S _4279_/S _5181_/Q _2683_/B gf180mcu_as_sc_mcu7t3v3__ao22_2
XTAP_TAPCELL_ROW_191_2380 VDD VSS gf180mcu_as_sc_mcu7t3v3__tap_2
X_4421_ VDD VDD VSS VSS _4546_/A _4421_/B _4421_/C _4424_/C _4538_/D gf180mcu_as_sc_mcu7t3v3__aoi211_2
X_4352_ VDD VDD VSS VSS _4379_/B _4352_/B _5158_/Q _5158_/D gf180mcu_as_sc_mcu7t3v3__mux2_2
X_4283_ VDD VDD VSS VSS _4289_/S _5479_/A _5117_/Q _5117_/D gf180mcu_as_sc_mcu7t3v3__mux2_2
X_3303_ VDD VDD VSS VSS _3303_/B _3525_/A _4807_/D gf180mcu_as_sc_mcu7t3v3__and2_2
X_3234_ VDD VDD VSS VSS _3542_/A _3249_/B _3236_/B _3234_/D _3238_/A gf180mcu_as_sc_mcu7t3v3__ao22_2
XFILLER_45_1474 VDD VDD VSS VSS gf180mcu_as_sc_mcu7t3v3__fill_1
XTAP_TAPCELL_ROW_206_2711 VDD VSS gf180mcu_as_sc_mcu7t3v3__tap_2
XTAP_TAPCELL_ROW_206_2700 VDD VSS gf180mcu_as_sc_mcu7t3v3__tap_2
XPHY_EDGE_ROW_56_3_Left_441 VDD VSS gf180mcu_as_sc_mcu7t3v3__tap_2
X_3165_ VDD VDD VSS VSS _4141_/A _3182_/B _3165_/C _3165_/Y _3760_/D gf180mcu_as_sc_mcu7t3v3__aoi211_2
XFILLER_66_185 VDD VDD VSS VSS gf180mcu_as_sc_mcu7t3v3__fillcap_4
X_3096_ VDD VDD VSS VSS _3097_/C _3096_/C _3150_/C _4069_/A gf180mcu_as_sc_mcu7t3v3__aoi21_2
XTAP_TAPCELL_ROW_202_2619 VDD VSS gf180mcu_as_sc_mcu7t3v3__tap_2
XTAP_TAPCELL_ROW_202_2608 VDD VSS gf180mcu_as_sc_mcu7t3v3__tap_2
XTAP_TAPCELL_ROW_198_2534 VDD VSS gf180mcu_as_sc_mcu7t3v3__tap_2
XTAP_TAPCELL_ROW_198_2523 VDD VSS gf180mcu_as_sc_mcu7t3v3__tap_2
XFILLER_120_27 VDD VDD VSS VSS gf180mcu_as_sc_mcu7t3v3__fillcap_8
XFILLER_210_312 VDD VDD VSS VSS gf180mcu_as_sc_mcu7t3v3__fill_2
XFILLER_23_745 VDD VDD VSS VSS gf180mcu_as_sc_mcu7t3v3__fillcap_16
XFILLER_91_1461 VDD VDD VSS VSS gf180mcu_as_sc_mcu7t3v3__fillcap_4
X_3998_ VDD VDD VSS VSS _3998_/A _4119_/B _4115_/B _3998_/D _4002_/A gf180mcu_as_sc_mcu7t3v3__ao211_2
XFILLER_13_1418 VDD VDD VSS VSS gf180mcu_as_sc_mcu7t3v3__fillcap_4
XFILLER_202_1103 VDD VDD VSS VSS gf180mcu_as_sc_mcu7t3v3__fillcap_16
XFILLER_52_1445 VDD VDD VSS VSS gf180mcu_as_sc_mcu7t3v3__fillcap_4
XFILLER_91_1483 VDD VDD VSS VSS gf180mcu_as_sc_mcu7t3v3__fill_2
X_2949_ VDD VDD VSS VSS _3075_/S _3925_/D _3933_/A _2951_/B gf180mcu_as_sc_mcu7t3v3__mux2_2
XFILLER_104_1568 VDD VDD VSS VSS gf180mcu_as_sc_mcu7t3v3__fill_1
XFILLER_13_69 VDD VDD VSS VSS gf180mcu_as_sc_mcu7t3v3__fill_1
XFILLER_176_772 VDD VDD VSS VSS gf180mcu_as_sc_mcu7t3v3__fillcap_4
XFILLER_176_783 VDD VDD VSS VSS gf180mcu_as_sc_mcu7t3v3__fillcap_16
XFILLER_129_69 VDD VDD VSS VSS gf180mcu_as_sc_mcu7t3v3__fill_1
XFILLER_135_124 VDD VDD VSS VSS gf180mcu_as_sc_mcu7t3v3__fillcap_4
XFILLER_175_282 VDD VDD VSS VSS gf180mcu_as_sc_mcu7t3v3__fillcap_4
X_4619_ VDD VDD VSS VSS _5213_/Q _4624_/B _4620_/C _5214_/Q _5213_/D gf180mcu_as_sc_mcu7t3v3__ao22_2
XTAP_TAPCELL_ROW_172_1_1960 VDD VSS gf180mcu_as_sc_mcu7t3v3__tap_2
XFILLER_11_1186 VDD VDD VSS VSS gf180mcu_as_sc_mcu7t3v3__fillcap_4
XFILLER_135_179 VDD VDD VSS VSS gf180mcu_as_sc_mcu7t3v3__fillcap_8
XFILLER_150_138 VDD VDD VSS VSS gf180mcu_as_sc_mcu7t3v3__fill_2
XFILLER_190_296 VDD VDD VSS VSS gf180mcu_as_sc_mcu7t3v3__fillcap_4
XFILLER_143_190 VDD VDD VSS VSS gf180mcu_as_sc_mcu7t3v3__fillcap_16
XFILLER_24_1503 VDD VDD VSS VSS gf180mcu_as_sc_mcu7t3v3__fill_2
XFILLER_161_34 VDD VDD VSS VSS gf180mcu_as_sc_mcu7t3v3__fillcap_16
XFILLER_38_77 VDD VDD VSS VSS gf180mcu_as_sc_mcu7t3v3__fillcap_4
Xhold1140 VDD VDD VSS VSS _4972_/Q hold1140/Y gf180mcu_as_sc_mcu7t3v3__clkbuff_4
XFILLER_206_629 VDD VDD VSS VSS gf180mcu_as_sc_mcu7t3v3__fillcap_16
XPHY_EDGE_ROW_145_1_Right_666 VDD VSS gf180mcu_as_sc_mcu7t3v3__tap_2
XFILLER_199_820 VDD VDD VSS VSS gf180mcu_as_sc_mcu7t3v3__fillcap_16
XFILLER_72_133 VDD VDD VSS VSS gf180mcu_as_sc_mcu7t3v3__fill_2
XFILLER_199_842 VDD VDD VSS VSS gf180mcu_as_sc_mcu7t3v3__fillcap_16
XFILLER_26_572 VDD VDD VSS VSS gf180mcu_as_sc_mcu7t3v3__fillcap_16
XFILLER_72_177 VDD VDD VSS VSS gf180mcu_as_sc_mcu7t3v3__fill_1
XFILLER_72_188 VDD VDD VSS VSS gf180mcu_as_sc_mcu7t3v3__fillcap_4
XFILLER_96_1383 VDD VDD VSS VSS gf180mcu_as_sc_mcu7t3v3__fillcap_4
XFILLER_148_1495 VDD VDD VSS VSS gf180mcu_as_sc_mcu7t3v3__fill_1
XFILLER_183_1364 VDD VDD VSS VSS gf180mcu_as_sc_mcu7t3v3__fillcap_16
XFILLER_207_1014 VDD VDD VSS VSS gf180mcu_as_sc_mcu7t3v3__fillcap_16
XFILLER_26_594 VDD VDD VSS VSS gf180mcu_as_sc_mcu7t3v3__fill_1
XFILLER_109_1457 VDD VDD VSS VSS gf180mcu_as_sc_mcu7t3v3__fill_2
XFILLER_13_244 VDD VDD VSS VSS gf180mcu_as_sc_mcu7t3v3__fillcap_16
XFILLER_70_1523 VDD VDD VSS VSS gf180mcu_as_sc_mcu7t3v3__fillcap_16
XTAP_TAPCELL_ROW_23_1243 VDD VSS gf180mcu_as_sc_mcu7t3v3__tap_2
XTAP_TAPCELL_ROW_23_1232 VDD VSS gf180mcu_as_sc_mcu7t3v3__tap_2
XFILLER_186_53 VDD VDD VSS VSS gf180mcu_as_sc_mcu7t3v3__fillcap_16
XFILLER_70_64 VDD VDD VSS VSS gf180mcu_as_sc_mcu7t3v3__fillcap_16
XFILLER_194_591 VDD VDD VSS VSS gf180mcu_as_sc_mcu7t3v3__fillcap_4
XPHY_EDGE_ROW_121_3_Right_158 VDD VSS gf180mcu_as_sc_mcu7t3v3__tap_2
Xclkload18 VDD VDD VSS VSS _5277_/CLK clkload18/Y gf180mcu_as_sc_mcu7t3v3__clkbuff_12
Xclkload29 VDD VDD VSS VSS clkload29/Y _5192_/CLK gf180mcu_as_sc_mcu7t3v3__inv_2
X_4904__1063 VDD VDD VSS VSS _4904_/D gf180mcu_as_sc_mcu7t3v3__tiel_4
XFILLER_120_1392 VDD VDD VSS VSS gf180mcu_as_sc_mcu7t3v3__fillcap_4
XFILLER_190_1313 VDD VDD VSS VSS gf180mcu_as_sc_mcu7t3v3__fillcap_16
XFILLER_116_1417 VDD VDD VSS VSS gf180mcu_as_sc_mcu7t3v3__fill_2
XFILLER_155_1488 VDD VDD VSS VSS gf180mcu_as_sc_mcu7t3v3__fillcap_16
XFILLER_190_1379 VDD VDD VSS VSS gf180mcu_as_sc_mcu7t3v3__fillcap_16
XFILLER_29_1469 VDD VDD VSS VSS gf180mcu_as_sc_mcu7t3v3__fill_1
XFILLER_23_1002 VDD VDD VSS VSS gf180mcu_as_sc_mcu7t3v3__fillcap_16
XFILLER_3_1118 VDD VDD VSS VSS gf180mcu_as_sc_mcu7t3v3__fill_2
XFILLER_95_72 VDD VDD VSS VSS gf180mcu_as_sc_mcu7t3v3__fillcap_16
XFILLER_48_174 VDD VDD VSS VSS gf180mcu_as_sc_mcu7t3v3__fill_1
XFILLER_188_1275 VDD VDD VSS VSS gf180mcu_as_sc_mcu7t3v3__fillcap_16
XFILLER_188_1297 VDD VDD VSS VSS gf180mcu_as_sc_mcu7t3v3__fillcap_16
XFILLER_209_489 VDD VDD VSS VSS gf180mcu_as_sc_mcu7t3v3__fill_1
XFILLER_36_358 VDD VDD VSS VSS gf180mcu_as_sc_mcu7t3v3__fillcap_16
XFILLER_17_550 VDD VDD VSS VSS gf180mcu_as_sc_mcu7t3v3__fill_2
X_4970_ VDD VDD VSS VSS _5111_/CLK _4970_/D _4970_/Q gf180mcu_as_sc_mcu7t3v3__dfxtp_2
XFILLER_162_1415 VDD VDD VSS VSS gf180mcu_as_sc_mcu7t3v3__fillcap_16
XFILLER_189_352 VDD VDD VSS VSS gf180mcu_as_sc_mcu7t3v3__fillcap_16
XFILLER_63_199 VDD VDD VSS VSS gf180mcu_as_sc_mcu7t3v3__fillcap_8
X_3921_ VDD VDD VSS VSS _3922_/A _3922_/B _3922_/C _3921_/Y _3927_/B gf180mcu_as_sc_mcu7t3v3__aoi211_2
XFILLER_127_1568 VDD VDD VSS VSS gf180mcu_as_sc_mcu7t3v3__fill_1
XPHY_EDGE_ROW_83_3_Right_120 VDD VSS gf180mcu_as_sc_mcu7t3v3__tap_2
X_3852_ VDD VDD VSS VSS _5152_/Q _5151_/Q _3853_/C gf180mcu_as_sc_mcu7t3v3__or2_2
XTAP_TAPCELL_ROW_193_2420 VDD VSS gf180mcu_as_sc_mcu7t3v3__tap_2
XFILLER_20_737 VDD VDD VSS VSS gf180mcu_as_sc_mcu7t3v3__fillcap_16
XFILLER_32_597 VDD VDD VSS VSS gf180mcu_as_sc_mcu7t3v3__fillcap_16
XFILLER_81_2 VDD VDD VSS VSS gf180mcu_as_sc_mcu7t3v3__fill_2
X_2803_ VDD VDD VSS VSS _2806_/B _2803_/B _2806_/D gf180mcu_as_sc_mcu7t3v3__nand2_2
XFILLER_201_890 VDD VDD VSS VSS gf180mcu_as_sc_mcu7t3v3__fillcap_16
XFILLER_203_1434 VDD VDD VSS VSS gf180mcu_as_sc_mcu7t3v3__fillcap_16
XFILLER_30_1017 VDD VDD VSS VSS gf180mcu_as_sc_mcu7t3v3__fillcap_16
XFILLER_34_1153 VDD VDD VSS VSS gf180mcu_as_sc_mcu7t3v3__fill_2
X_3783_ VDD VDD VSS VSS _4163_/A _3802_/B _3783_/C _3783_/D _3784_/B gf180mcu_as_sc_mcu7t3v3__ao211_2
X_2734_ VDD VDD VSS VSS _2734_/S _2734_/B _2734_/A _2735_/C gf180mcu_as_sc_mcu7t3v3__mux2_2
XFILLER_195_1224 VDD VDD VSS VSS gf180mcu_as_sc_mcu7t3v3__fillcap_16
X_2665_ VDD VDD VSS VSS _2673_/B _5132_/Q _5196_/Q _2666_/C gf180mcu_as_sc_mcu7t3v3__mux2_2
XFILLER_12_1495 VDD VDD VSS VSS gf180mcu_as_sc_mcu7t3v3__fillcap_8
X_4404_ VDD VDD VSS VSS _4405_/D _4404_/B _4502_/A gf180mcu_as_sc_mcu7t3v3__nor2_2
X_2596_ VDD VDD VSS VSS _5126_/Q _5099_/Q _2597_/D gf180mcu_as_sc_mcu7t3v3__xnor2_2
X_4335_ VDD VDD VSS VSS _4592_/B _4366_/S _4378_/D gf180mcu_as_sc_mcu7t3v3__and2_2
XFILLER_173_1566 VDD VDD VSS VSS gf180mcu_as_sc_mcu7t3v3__fill_2
XFILLER_47_1558 VDD VDD VSS VSS gf180mcu_as_sc_mcu7t3v3__fillcap_8
XTAP_TAPCELL_ROW_187_2279 VDD VSS gf180mcu_as_sc_mcu7t3v3__tap_2
XFILLER_140_171 VDD VDD VSS VSS gf180mcu_as_sc_mcu7t3v3__fillcap_4
X_4266_ VDD VDD VSS VSS _4273_/S _5478_/A _5100_/Q _5100_/D gf180mcu_as_sc_mcu7t3v3__mux2_2
XTAP_TAPCELL_ROW_42_1_1571 VDD VSS gf180mcu_as_sc_mcu7t3v3__tap_2
XFILLER_210_1405 VDD VDD VSS VSS gf180mcu_as_sc_mcu7t3v3__fillcap_4
XFILLER_210_1427 VDD VDD VSS VSS gf180mcu_as_sc_mcu7t3v3__fill_1
X_4197_ VDD VDD VSS VSS _4257_/B _4197_/B _4197_/C _5035_/Q _5035_/D gf180mcu_as_sc_mcu7t3v3__ao22_2
X_3217_ VDD VDD VSS VSS _3241_/B _3802_/A _3217_/A _3218_/C gf180mcu_as_sc_mcu7t3v3__mux2_2
XFILLER_210_1449 VDD VDD VSS VSS gf180mcu_as_sc_mcu7t3v3__fill_2
XFILLER_39_174 VDD VDD VSS VSS gf180mcu_as_sc_mcu7t3v3__fillcap_16
X_3148_ VDD VDD VSS VSS _3181_/A _3148_/B _3148_/C _3149_/C gf180mcu_as_sc_mcu7t3v3__nor3_2
XTAP_TAPCELL_ROW_52_3_2877 VDD VSS gf180mcu_as_sc_mcu7t3v3__tap_2
XFILLER_167_1348 VDD VDD VSS VSS gf180mcu_as_sc_mcu7t3v3__fillcap_8
XFILLER_36_881 VDD VDD VSS VSS gf180mcu_as_sc_mcu7t3v3__fill_2
XFILLER_54_177 VDD VDD VSS VSS gf180mcu_as_sc_mcu7t3v3__fillcap_8
X_3079_ VDD VDD VSS VSS _4057_/A _3079_/B _3079_/C _3079_/D _3080_/C gf180mcu_as_sc_mcu7t3v3__ao22_2
XFILLER_196_801 VDD VDD VSS VSS gf180mcu_as_sc_mcu7t3v3__fillcap_4
XFILLER_208_1345 VDD VDD VSS VSS gf180mcu_as_sc_mcu7t3v3__fillcap_16
XFILLER_195_311 VDD VDD VSS VSS gf180mcu_as_sc_mcu7t3v3__fillcap_16
XFILLER_196_823 VDD VDD VSS VSS gf180mcu_as_sc_mcu7t3v3__fillcap_8
XFILLER_208_1367 VDD VDD VSS VSS gf180mcu_as_sc_mcu7t3v3__fillcap_16
XFILLER_196_856 VDD VDD VSS VSS gf180mcu_as_sc_mcu7t3v3__fillcap_16
XFILLER_210_142 VDD VDD VSS VSS gf180mcu_as_sc_mcu7t3v3__fill_2
XFILLER_23_586 VDD VDD VSS VSS gf180mcu_as_sc_mcu7t3v3__fillcap_16
XFILLER_10_247 VDD VDD VSS VSS gf180mcu_as_sc_mcu7t3v3__fillcap_8
XFILLER_183_528 VDD VDD VSS VSS gf180mcu_as_sc_mcu7t3v3__fillcap_16
Xwire628 VDD VDD VSS VSS _3924_/Y wire628/Y gf180mcu_as_sc_mcu7t3v3__clkbuff_12
XFILLER_156_34 VDD VDD VSS VSS gf180mcu_as_sc_mcu7t3v3__fill_1
XFILLER_178_1477 VDD VDD VSS VSS gf180mcu_as_sc_mcu7t3v3__fillcap_16
XFILLER_191_594 VDD VDD VSS VSS gf180mcu_as_sc_mcu7t3v3__fillcap_16
XFILLER_3_925 VDD VDD VSS VSS gf180mcu_as_sc_mcu7t3v3__fillcap_16
XTAP_TAPCELL_ROW_121_1_1807 VDD VSS gf180mcu_as_sc_mcu7t3v3__tap_2
XFILLER_2_457 VDD VDD VSS VSS gf180mcu_as_sc_mcu7t3v3__fillcap_16
XTAP_TAPCELL_ROW_133_3_3119 VDD VSS gf180mcu_as_sc_mcu7t3v3__tap_2
XFILLER_172_22 VDD VDD VSS VSS gf180mcu_as_sc_mcu7t3v3__fillcap_8
XFILLER_49_43 VDD VDD VSS VSS gf180mcu_as_sc_mcu7t3v3__fillcap_4
XFILLER_49_98 VDD VDD VSS VSS gf180mcu_as_sc_mcu7t3v3__fill_1
XFILLER_63_1360 VDD VDD VSS VSS gf180mcu_as_sc_mcu7t3v3__fill_2
Xfanout750 VDD VDD VSS VSS _3224_/C _3127_/B gf180mcu_as_sc_mcu7t3v3__buff_12
XFILLER_105_60 VDD VDD VSS VSS gf180mcu_as_sc_mcu7t3v3__fillcap_8
XFILLER_24_1355 VDD VDD VSS VSS gf180mcu_as_sc_mcu7t3v3__fillcap_8
Xfanout761 VDD VDD VSS VSS _2591_/Y _4974_/D gf180mcu_as_sc_mcu7t3v3__buff_12
Xfanout772 VDD VDD VSS VSS _4263_/A _4747_/D gf180mcu_as_sc_mcu7t3v3__buff_12
Xfanout783 VDD VDD VSS VSS _5221_/Q _4703_/B gf180mcu_as_sc_mcu7t3v3__buff_12
Xfanout794 VDD VDD VSS VSS _4588_/A _4581_/A gf180mcu_as_sc_mcu7t3v3__buff_12
XTAP_TAPCELL_ROW_16_1091 VDD VSS gf180mcu_as_sc_mcu7t3v3__tap_2
XTAP_TAPCELL_ROW_16_1080 VDD VSS gf180mcu_as_sc_mcu7t3v3__tap_2
XFILLER_115_1483 VDD VDD VSS VSS gf180mcu_as_sc_mcu7t3v3__fill_2
XFILLER_98_1423 VDD VDD VSS VSS gf180mcu_as_sc_mcu7t3v3__fillcap_4
XTAP_TAPCELL_ROW_101_1_1749 VDD VSS gf180mcu_as_sc_mcu7t3v3__tap_2
XFILLER_24_1399 VDD VDD VSS VSS gf180mcu_as_sc_mcu7t3v3__fillcap_4
XFILLER_34_807 VDD VDD VSS VSS gf180mcu_as_sc_mcu7t3v3__fillcap_16
XFILLER_59_1418 VDD VDD VSS VSS gf180mcu_as_sc_mcu7t3v3__fillcap_16
XFILLER_27_870 VDD VDD VSS VSS gf180mcu_as_sc_mcu7t3v3__fill_2
XFILLER_33_306 VDD VDD VSS VSS gf180mcu_as_sc_mcu7t3v3__fill_1
XPHY_EDGE_ROW_146_1_Right_667 VDD VSS gf180mcu_as_sc_mcu7t3v3__tap_2
XFILLER_198_171 VDD VDD VSS VSS gf180mcu_as_sc_mcu7t3v3__fillcap_4
XFILLER_201_120 VDD VDD VSS VSS gf180mcu_as_sc_mcu7t3v3__fillcap_16
XFILLER_81_52 VDD VDD VSS VSS gf180mcu_as_sc_mcu7t3v3__fillcap_16
XFILLER_14_597 VDD VDD VSS VSS gf180mcu_as_sc_mcu7t3v3__fillcap_16
XFILLER_186_333 VDD VDD VSS VSS gf180mcu_as_sc_mcu7t3v3__fillcap_4
XFILLER_198_193 VDD VDD VSS VSS gf180mcu_as_sc_mcu7t3v3__fillcap_16
XFILLER_201_142 VDD VDD VSS VSS gf180mcu_as_sc_mcu7t3v3__fillcap_16
XFILLER_179_1208 VDD VDD VSS VSS gf180mcu_as_sc_mcu7t3v3__fillcap_16
XFILLER_186_377 VDD VDD VSS VSS gf180mcu_as_sc_mcu7t3v3__fill_1
XFILLER_70_1364 VDD VDD VSS VSS gf180mcu_as_sc_mcu7t3v3__fillcap_16
XFILLER_122_1443 VDD VDD VSS VSS gf180mcu_as_sc_mcu7t3v3__fillcap_8
XTAP_TAPCELL_ROW_47_1_1586 VDD VSS gf180mcu_as_sc_mcu7t3v3__tap_2
XFILLER_157_1517 VDD VDD VSS VSS gf180mcu_as_sc_mcu7t3v3__fillcap_4
XFILLER_182_594 VDD VDD VSS VSS gf180mcu_as_sc_mcu7t3v3__fill_1
XPHY_EDGE_ROW_122_3_Right_159 VDD VSS gf180mcu_as_sc_mcu7t3v3__tap_2
X_2450_ VDD VDD VSS VSS _3192_/A _4162_/A gf180mcu_as_sc_mcu7t3v3__inv_2
XFILLER_29_1266 VDD VDD VSS VSS gf180mcu_as_sc_mcu7t3v3__fill_1
XPHY_EDGE_ROW_111_1_Left_321 VDD VSS gf180mcu_as_sc_mcu7t3v3__tap_2
XFILLER_25_1119 VDD VDD VSS VSS gf180mcu_as_sc_mcu7t3v3__fill_1
X_4120_ VDD VDD VSS VSS _4120_/A _4129_/B _4129_/C _4938_/Q _4122_/C gf180mcu_as_sc_mcu7t3v3__ao22_2
X_4051_ VDD VDD VSS VSS _4051_/B _4107_/A _4243_/B gf180mcu_as_sc_mcu7t3v3__and2_2
XFILLER_42_1477 VDD VDD VSS VSS gf180mcu_as_sc_mcu7t3v3__fillcap_4
Xinput5 VDD VDD VSS VSS boot_addr[3] input5/Y gf180mcu_as_sc_mcu7t3v3__buff_12
X_3002_ VDD VDD VSS VSS _3045_/A _3002_/B _3002_/C _3045_/D _3004_/C gf180mcu_as_sc_mcu7t3v3__ao211_2
XTAP_TAPCELL_ROW_182_2187 VDD VSS gf180mcu_as_sc_mcu7t3v3__tap_2
XTAP_TAPCELL_ROW_182_2176 VDD VSS gf180mcu_as_sc_mcu7t3v3__tap_2
XFILLER_24_317 VDD VDD VSS VSS gf180mcu_as_sc_mcu7t3v3__fillcap_16
X_4953_ VDD VDD VSS VSS _5256_/CLK _4953_/D _4953_/Q gf180mcu_as_sc_mcu7t3v3__dfxtp_2
XFILLER_205_470 VDD VDD VSS VSS gf180mcu_as_sc_mcu7t3v3__fillcap_16
XFILLER_205_492 VDD VDD VSS VSS gf180mcu_as_sc_mcu7t3v3__fillcap_16
X_3904_ VDD VDD VSS VSS _4946_/D _5163_/Q _4944_/D gf180mcu_as_sc_mcu7t3v3__and2_2
XFILLER_178_856 VDD VDD VSS VSS gf180mcu_as_sc_mcu7t3v3__fillcap_4
XFILLER_193_804 VDD VDD VSS VSS gf180mcu_as_sc_mcu7t3v3__fillcap_16
X_4884_ VDD VDD VSS VSS _4924_/CLK _4884_/D _4884_/Q gf180mcu_as_sc_mcu7t3v3__dfxtp_2
XFILLER_192_303 VDD VDD VSS VSS gf180mcu_as_sc_mcu7t3v3__fillcap_8
XPHY_EDGE_ROW_84_3_Right_121 VDD VSS gf180mcu_as_sc_mcu7t3v3__tap_2
X_3835_ VDD VDD VSS VSS _3843_/B _3835_/B _4168_/A gf180mcu_as_sc_mcu7t3v3__nand2_2
XFILLER_140_1565 VDD VDD VSS VSS gf180mcu_as_sc_mcu7t3v3__fillcap_4
XFILLER_14_1568 VDD VDD VSS VSS gf180mcu_as_sc_mcu7t3v3__fill_1
X_3766_ VDD VDD VSS VSS _3767_/B _4147_/A _3766_/B _3766_/C gf180mcu_as_sc_mcu7t3v3__ao21_2
XFILLER_101_1527 VDD VDD VSS VSS gf180mcu_as_sc_mcu7t3v3__fillcap_4
XFILLER_192_358 VDD VDD VSS VSS gf180mcu_as_sc_mcu7t3v3__fillcap_16
X_2717_ VDD VDD VSS VSS _2731_/S _5178_/Q _5170_/Q _2721_/B gf180mcu_as_sc_mcu7t3v3__mux2_2
XFILLER_10_37 VDD VDD VSS VSS gf180mcu_as_sc_mcu7t3v3__fillcap_16
XPHY_EDGE_ROW_18_Left_229 VDD VSS gf180mcu_as_sc_mcu7t3v3__tap_2
X_3697_ VDD VDD VSS VSS _4070_/A _3758_/B _3697_/C _3758_/D _3698_/C gf180mcu_as_sc_mcu7t3v3__ao211_2
XTAP_TAPCELL_ROW_93_1_1723 VDD VSS gf180mcu_as_sc_mcu7t3v3__tap_2
XFILLER_126_37 VDD VDD VSS VSS gf180mcu_as_sc_mcu7t3v3__fillcap_4
XPHY_EDGE_ROW_43_1_Left_253 VDD VSS gf180mcu_as_sc_mcu7t3v3__tap_2
Xoutput353 VDD VDD VSS VSS _4843_/Q east_out[4] gf180mcu_as_sc_mcu7t3v3__buff_12
Xoutput342 VDD VDD VSS VSS _4864_/Q east_out[25] gf180mcu_as_sc_mcu7t3v3__buff_12
Xoutput331 VDD VDD VSS VSS _4854_/Q east_out[15] gf180mcu_as_sc_mcu7t3v3__buff_12
Xoutput320 VDD VDD VSS VSS _5481_/Y dft_rdata[3] gf180mcu_as_sc_mcu7t3v3__buff_12
X_2648_ VDD VDD VSS VSS _2649_/C _2648_/B _4262_/B gf180mcu_as_sc_mcu7t3v3__nor2_2
XFILLER_0_917 VDD VDD VSS VSS gf180mcu_as_sc_mcu7t3v3__fill_1
Xoutput386 VDD VDD VSS VSS _4774_/Q se_out[3] gf180mcu_as_sc_mcu7t3v3__buff_12
Xoutput375 VDD VDD VSS VSS _4795_/Q se_out[24] gf180mcu_as_sc_mcu7t3v3__buff_12
Xoutput364 VDD VDD VSS VSS _4785_/Q se_out[14] gf180mcu_as_sc_mcu7t3v3__buff_12
X_2579_ VDD VDD VSS VSS _2666_/D _2674_/C gf180mcu_as_sc_mcu7t3v3__inv_2
XFILLER_113_171 VDD VDD VSS VSS gf180mcu_as_sc_mcu7t3v3__fill_2
XFILLER_47_1377 VDD VDD VSS VSS gf180mcu_as_sc_mcu7t3v3__fillcap_8
Xoutput397 VDD VDD VSS VSS _4818_/Q south_out[13] gf180mcu_as_sc_mcu7t3v3__buff_12
X_4318_ VDD VDD VSS VSS _4324_/S _5148_/Q _5147_/Q _5147_/D gf180mcu_as_sc_mcu7t3v3__mux2_2
X_4249_ VDD VDD VSS VSS _4256_/S _4249_/B _5085_/Q _5085_/D gf180mcu_as_sc_mcu7t3v3__mux2_2
XTAP_TAPCELL_ROW_73_1_1665 VDD VSS gf180mcu_as_sc_mcu7t3v3__tap_2
XFILLER_210_1235 VDD VDD VSS VSS gf180mcu_as_sc_mcu7t3v3__fillcap_4
XFILLER_74_217 VDD VDD VSS VSS gf180mcu_as_sc_mcu7t3v3__fillcap_4
XFILLER_142_69 VDD VDD VSS VSS gf180mcu_as_sc_mcu7t3v3__fillcap_16
XFILLER_16_807 VDD VDD VSS VSS gf180mcu_as_sc_mcu7t3v3__fillcap_16
XFILLER_210_1257 VDD VDD VSS VSS gf180mcu_as_sc_mcu7t3v3__fill_1
XFILLER_28_645 VDD VDD VSS VSS gf180mcu_as_sc_mcu7t3v3__fill_1
XFILLER_28_656 VDD VDD VSS VSS gf180mcu_as_sc_mcu7t3v3__fillcap_8
XFILLER_28_667 VDD VDD VSS VSS gf180mcu_as_sc_mcu7t3v3__fillcap_16
XPHY_EDGE_ROW_27_Left_238 VDD VSS gf180mcu_as_sc_mcu7t3v3__tap_2
XTAP_TAPCELL_ROW_3_788 VDD VSS gf180mcu_as_sc_mcu7t3v3__tap_2
XFILLER_210_1279 VDD VDD VSS VSS gf180mcu_as_sc_mcu7t3v3__fill_2
XTAP_TAPCELL_ROW_3_799 VDD VSS gf180mcu_as_sc_mcu7t3v3__tap_2
XFILLER_19_1402 VDD VDD VSS VSS gf180mcu_as_sc_mcu7t3v3__fillcap_8
XFILLER_208_1120 VDD VDD VSS VSS gf180mcu_as_sc_mcu7t3v3__fill_1
XFILLER_180_1301 VDD VDD VSS VSS gf180mcu_as_sc_mcu7t3v3__fill_2
XFILLER_19_1468 VDD VDD VSS VSS gf180mcu_as_sc_mcu7t3v3__fill_2
XFILLER_204_1017 VDD VDD VSS VSS gf180mcu_as_sc_mcu7t3v3__fillcap_16
XFILLER_54_1348 VDD VDD VSS VSS gf180mcu_as_sc_mcu7t3v3__fillcap_4
XPHY_EDGE_ROW_70_1_Right_591 VDD VSS gf180mcu_as_sc_mcu7t3v3__tap_2
XFILLER_11_545 VDD VDD VSS VSS gf180mcu_as_sc_mcu7t3v3__fill_2
XFILLER_180_1367 VDD VDD VSS VSS gf180mcu_as_sc_mcu7t3v3__fillcap_4
XFILLER_184_837 VDD VDD VSS VSS gf180mcu_as_sc_mcu7t3v3__fillcap_16
XFILLER_167_22 VDD VDD VSS VSS gf180mcu_as_sc_mcu7t3v3__fillcap_16
XFILLER_183_347 VDD VDD VSS VSS gf180mcu_as_sc_mcu7t3v3__fill_2
XFILLER_195_174 VDD VDD VSS VSS gf180mcu_as_sc_mcu7t3v3__fillcap_16
XPHY_EDGE_ROW_36_Left_247 VDD VSS gf180mcu_as_sc_mcu7t3v3__tap_2
Xwire469 VDD VDD VSS VSS _3601_/Y _4843_/D gf180mcu_as_sc_mcu7t3v3__clkbuff_12
XFILLER_183_54 VDD VDD VSS VSS gf180mcu_as_sc_mcu7t3v3__fillcap_16
XPHY_EDGE_ROW_55_3_Right_92 VDD VSS gf180mcu_as_sc_mcu7t3v3__tap_2
XTAP_TAPCELL_ROW_18_1131 VDD VSS gf180mcu_as_sc_mcu7t3v3__tap_2
XTAP_TAPCELL_ROW_18_1120 VDD VSS gf180mcu_as_sc_mcu7t3v3__tap_2
XFILLER_152_1414 VDD VDD VSS VSS gf180mcu_as_sc_mcu7t3v3__fillcap_4
XFILLER_65_1488 VDD VDD VSS VSS gf180mcu_as_sc_mcu7t3v3__fillcap_16
XFILLER_152_1469 VDD VDD VSS VSS gf180mcu_as_sc_mcu7t3v3__fillcap_16
XFILLER_191_1496 VDD VDD VSS VSS gf180mcu_as_sc_mcu7t3v3__fill_1
XTAP_TAPCELL_ROW_14_1028 VDD VSS gf180mcu_as_sc_mcu7t3v3__tap_2
XTAP_TAPCELL_ROW_14_1039 VDD VSS gf180mcu_as_sc_mcu7t3v3__tap_2
XFILLER_19_601 VDD VDD VSS VSS gf180mcu_as_sc_mcu7t3v3__fillcap_4
XFILLER_207_702 VDD VDD VSS VSS gf180mcu_as_sc_mcu7t3v3__fillcap_16
XFILLER_4_1224 VDD VDD VSS VSS gf180mcu_as_sc_mcu7t3v3__fill_1
XFILLER_76_85 VDD VDD VSS VSS gf180mcu_as_sc_mcu7t3v3__fillcap_4
Xfanout580 VDD VDD VSS VSS _3453_/B _3382_/B gf180mcu_as_sc_mcu7t3v3__buff_12
Xfanout591 VDD VDD VSS VSS _2945_/Y _3182_/B gf180mcu_as_sc_mcu7t3v3__buff_12
XFILLER_19_645 VDD VDD VSS VSS gf180mcu_as_sc_mcu7t3v3__fillcap_16
XFILLER_18_155 VDD VDD VSS VSS gf180mcu_as_sc_mcu7t3v3__fillcap_16
XFILLER_18_177 VDD VDD VSS VSS gf180mcu_as_sc_mcu7t3v3__fillcap_16
XFILLER_185_1256 VDD VDD VSS VSS gf180mcu_as_sc_mcu7t3v3__fillcap_4
XFILLER_185_1278 VDD VDD VSS VSS gf180mcu_as_sc_mcu7t3v3__fillcap_16
XFILLER_92_62 VDD VDD VSS VSS gf180mcu_as_sc_mcu7t3v3__fillcap_4
XPHY_EDGE_ROW_147_1_Right_668 VDD VSS gf180mcu_as_sc_mcu7t3v3__tap_2
XFILLER_33_158 VDD VDD VSS VSS gf180mcu_as_sc_mcu7t3v3__fillcap_16
XFILLER_37_1568 VDD VDD VSS VSS gf180mcu_as_sc_mcu7t3v3__fill_1
XFILLER_72_1437 VDD VDD VSS VSS gf180mcu_as_sc_mcu7t3v3__fill_2
XPHY_EDGE_ROW_182_Right_45 VDD VSS gf180mcu_as_sc_mcu7t3v3__tap_2
XTAP_TAPCELL_ROW_98_1_1738 VDD VSS gf180mcu_as_sc_mcu7t3v3__tap_2
XFILLER_174_303 VDD VDD VSS VSS gf180mcu_as_sc_mcu7t3v3__fill_2
XFILLER_175_804 VDD VDD VSS VSS gf180mcu_as_sc_mcu7t3v3__fillcap_16
XFILLER_187_664 VDD VDD VSS VSS gf180mcu_as_sc_mcu7t3v3__fillcap_16
XFILLER_202_473 VDD VDD VSS VSS gf180mcu_as_sc_mcu7t3v3__fillcap_16
XFILLER_31_1112 VDD VDD VSS VSS gf180mcu_as_sc_mcu7t3v3__fill_1
XFILLER_35_1270 VDD VDD VSS VSS gf180mcu_as_sc_mcu7t3v3__fill_1
X_3620_ VDD VDD VSS VSS _3989_/A _3650_/B _3620_/C _3620_/D _3621_/D gf180mcu_as_sc_mcu7t3v3__ao211_2
XFILLER_174_358 VDD VDD VSS VSS gf180mcu_as_sc_mcu7t3v3__fillcap_4
XFILLER_190_807 VDD VDD VSS VSS gf180mcu_as_sc_mcu7t3v3__fillcap_16
XFILLER_200_1415 VDD VDD VSS VSS gf180mcu_as_sc_mcu7t3v3__fillcap_16
XFILLER_200_1437 VDD VDD VSS VSS gf180mcu_as_sc_mcu7t3v3__fillcap_16
XPHY_EDGE_ROW_65_3_Left_450 VDD VSS gf180mcu_as_sc_mcu7t3v3__tap_2
X_3551_ VDD VDD VSS VSS _3561_/A _3728_/C _3551_/A gf180mcu_as_sc_mcu7t3v3__nand2_2
XFILLER_192_1205 VDD VDD VSS VSS gf180mcu_as_sc_mcu7t3v3__fillcap_16
XFILLER_31_1189 VDD VDD VSS VSS gf180mcu_as_sc_mcu7t3v3__fill_1
XTAP_TAPCELL_ROW_103_3_3030 VDD VSS gf180mcu_as_sc_mcu7t3v3__tap_2
X_2502_ VDD VDD VSS VSS _4746_/D _4691_/A _2502_/C _2502_/D _2503_/B gf180mcu_as_sc_mcu7t3v3__ao211_2
XFILLER_192_1227 VDD VDD VSS VSS gf180mcu_as_sc_mcu7t3v3__fillcap_16
X_3482_ VDD VDD VSS VSS _4139_/A _3522_/C _3482_/C _3482_/D _3483_/B gf180mcu_as_sc_mcu7t3v3__ao211_2
XFILLER_44_2 VDD VDD VSS VSS gf180mcu_as_sc_mcu7t3v3__fillcap_16
X_5221_ VDD VDD VSS VSS _5233_/CLK _5221_/D _5221_/Q gf180mcu_as_sc_mcu7t3v3__dfxtp_2
X_2433_ VDD VDD VSS VSS _4027_/A _2433_/A gf180mcu_as_sc_mcu7t3v3__inv_2
XFILLER_29_1052 VDD VDD VSS VSS gf180mcu_as_sc_mcu7t3v3__fillcap_16
XPHY_EDGE_ROW_191_Right_54 VDD VSS gf180mcu_as_sc_mcu7t3v3__tap_2
X_5152_ VDD VDD VSS VSS _5220_/CLK _5152_/D _5152_/Q gf180mcu_as_sc_mcu7t3v3__dfxtp_2
XTAP_TAPCELL_ROW_184_2227 VDD VSS gf180mcu_as_sc_mcu7t3v3__tap_2
XTAP_TAPCELL_ROW_184_2216 VDD VSS gf180mcu_as_sc_mcu7t3v3__tap_2
X_4103_ VDD VDD VSS VSS _4103_/A _4103_/B _4103_/C _4103_/D _4105_/C gf180mcu_as_sc_mcu7t3v3__ao211_2
XFILLER_110_174 VDD VDD VSS VSS gf180mcu_as_sc_mcu7t3v3__fill_1
X_5083_ VDD VDD VSS VSS clkload4/A _5083_/D _5083_/Q gf180mcu_as_sc_mcu7t3v3__dfxtp_2
XFILLER_133_1380 VDD VDD VSS VSS gf180mcu_as_sc_mcu7t3v3__fillcap_16
XTAP_TAPCELL_ROW_0_703 VDD VSS gf180mcu_as_sc_mcu7t3v3__tap_2
X_4034_ VDD VDD VSS VSS _4106_/S _4034_/B _4034_/A _4035_/B gf180mcu_as_sc_mcu7t3v3__mux2_2
XFILLER_129_1405 VDD VDD VSS VSS gf180mcu_as_sc_mcu7t3v3__fillcap_8
XFILLER_71_209 VDD VDD VSS VSS gf180mcu_as_sc_mcu7t3v3__fill_1
XTAP_TAPCELL_ROW_0_714 VDD VSS gf180mcu_as_sc_mcu7t3v3__tap_2
XTAP_TAPCELL_ROW_0_725 VDD VSS gf180mcu_as_sc_mcu7t3v3__tap_2
XTAP_TAPCELL_ROW_0_736 VDD VSS gf180mcu_as_sc_mcu7t3v3__tap_2
XFILLER_205_1326 VDD VDD VSS VSS gf180mcu_as_sc_mcu7t3v3__fillcap_4
X_4936_ VDD VDD VSS VSS _5095_/CLK _4936_/D _4936_/Q gf180mcu_as_sc_mcu7t3v3__dfxtp_2
XANTENNA_10 VDD VDD VSS VSS _4860_/D gf180mcu_as_sc_mcu7t3v3__diode_2
XANTENNA_21 VDD VDD VSS VSS _4780_/D gf180mcu_as_sc_mcu7t3v3__diode_2
XANTENNA_32 VDD VDD VSS VSS _4023_/A gf180mcu_as_sc_mcu7t3v3__diode_2
XFILLER_205_1348 VDD VDD VSS VSS gf180mcu_as_sc_mcu7t3v3__fillcap_16
XFILLER_36_1056 VDD VDD VSS VSS gf180mcu_as_sc_mcu7t3v3__fillcap_16
X_4867_ VDD VDD VSS VSS _5220_/CLK _4867_/D _4867_/Q gf180mcu_as_sc_mcu7t3v3__dfxtp_2
XTAP_TAPCELL_ROW_47_3_2861 VDD VSS gf180mcu_as_sc_mcu7t3v3__tap_2
XFILLER_14_1332 VDD VDD VSS VSS gf180mcu_as_sc_mcu7t3v3__fillcap_4
XFILLER_197_1116 VDD VDD VSS VSS gf180mcu_as_sc_mcu7t3v3__fillcap_4
XPHY_EDGE_ROW_85_3_Right_122 VDD VSS gf180mcu_as_sc_mcu7t3v3__tap_2
X_3818_ VDD VDD VSS VSS _3818_/A _3818_/B _3818_/C _3818_/D _3915_/A gf180mcu_as_sc_mcu7t3v3__ao22_2
XFILLER_105_1482 VDD VDD VSS VSS gf180mcu_as_sc_mcu7t3v3__fillcap_4
XFILLER_192_155 VDD VDD VSS VSS gf180mcu_as_sc_mcu7t3v3__fillcap_16
XFILLER_197_1138 VDD VDD VSS VSS gf180mcu_as_sc_mcu7t3v3__fillcap_16
X_4798_ VDD VDD VSS VSS _5214_/CLK _4798_/D _4798_/Q gf180mcu_as_sc_mcu7t3v3__dfxtp_2
XFILLER_174_881 VDD VDD VSS VSS gf180mcu_as_sc_mcu7t3v3__fill_1
XFILLER_180_317 VDD VDD VSS VSS gf180mcu_as_sc_mcu7t3v3__fillcap_16
XFILLER_192_177 VDD VDD VSS VSS gf180mcu_as_sc_mcu7t3v3__fillcap_8
XPHY_EDGE_ROW_109_1_Right_630 VDD VSS gf180mcu_as_sc_mcu7t3v3__tap_2
X_3749_ VDD VDD VSS VSS _4130_/A _3749_/B _3749_/C _3749_/D _3751_/C gf180mcu_as_sc_mcu7t3v3__ao211_2
XFILLER_137_69 VDD VDD VSS VSS gf180mcu_as_sc_mcu7t3v3__fill_1
XFILLER_192_199 VDD VDD VSS VSS gf180mcu_as_sc_mcu7t3v3__fill_1
XFILLER_99_180 VDD VDD VSS VSS gf180mcu_as_sc_mcu7t3v3__fill_2
XFILLER_21_1303 VDD VDD VSS VSS gf180mcu_as_sc_mcu7t3v3__fillcap_16
XFILLER_25_1472 VDD VDD VSS VSS gf180mcu_as_sc_mcu7t3v3__fillcap_16
XFILLER_5_1522 VDD VDD VSS VSS gf180mcu_as_sc_mcu7t3v3__fillcap_16
XFILLER_151_1480 VDD VDD VSS VSS gf180mcu_as_sc_mcu7t3v3__fillcap_4
XFILLER_210_1087 VDD VDD VSS VSS gf180mcu_as_sc_mcu7t3v3__fill_1
XFILLER_21_1358 VDD VDD VSS VSS gf180mcu_as_sc_mcu7t3v3__fillcap_4
XFILLER_29_976 VDD VDD VSS VSS gf180mcu_as_sc_mcu7t3v3__fillcap_4
XFILLER_188_417 VDD VDD VSS VSS gf180mcu_as_sc_mcu7t3v3__fillcap_16
XFILLER_62_32 VDD VDD VSS VSS gf180mcu_as_sc_mcu7t3v3__fill_2
XFILLER_12_843 VDD VDD VSS VSS gf180mcu_as_sc_mcu7t3v3__fill_2
XFILLER_24_692 VDD VDD VSS VSS gf180mcu_as_sc_mcu7t3v3__fillcap_16
XFILLER_30_139 VDD VDD VSS VSS gf180mcu_as_sc_mcu7t3v3__fillcap_4
XFILLER_62_98 VDD VDD VSS VSS gf180mcu_as_sc_mcu7t3v3__fillcap_4
XPHY_EDGE_ROW_71_1_Right_592 VDD VSS gf180mcu_as_sc_mcu7t3v3__tap_2
XTAP_TAPCELL_ROW_108_3_3045 VDD VSS gf180mcu_as_sc_mcu7t3v3__tap_2
XFILLER_168_185 VDD VDD VSS VSS gf180mcu_as_sc_mcu7t3v3__fill_2
XFILLER_200_944 VDD VDD VSS VSS gf180mcu_as_sc_mcu7t3v3__fill_1
XFILLER_184_667 VDD VDD VSS VSS gf180mcu_as_sc_mcu7t3v3__fillcap_16
XFILLER_7_346 VDD VDD VSS VSS gf180mcu_as_sc_mcu7t3v3__fillcap_4
XFILLER_183_188 VDD VDD VSS VSS gf180mcu_as_sc_mcu7t3v3__fillcap_8
XFILLER_67_1506 VDD VDD VSS VSS gf180mcu_as_sc_mcu7t3v3__fill_1
XFILLER_194_53 VDD VDD VSS VSS gf180mcu_as_sc_mcu7t3v3__fillcap_16
XFILLER_67_1539 VDD VDD VSS VSS gf180mcu_as_sc_mcu7t3v3__fillcap_16
XFILLER_180_873 VDD VDD VSS VSS gf180mcu_as_sc_mcu7t3v3__fill_2
XTAP_TAPCELL_ROW_73_3_2940 VDD VSS gf180mcu_as_sc_mcu7t3v3__tap_2
XFILLER_156_1380 VDD VDD VSS VSS gf180mcu_as_sc_mcu7t3v3__fill_1
XFILLER_97_128 VDD VDD VSS VSS gf180mcu_as_sc_mcu7t3v3__fill_1
XFILLER_117_1364 VDD VDD VSS VSS gf180mcu_as_sc_mcu7t3v3__fillcap_4
XFILLER_38_217 VDD VDD VSS VSS gf180mcu_as_sc_mcu7t3v3__fillcap_4
XTAP_TAPCELL_ROW_7_891 VDD VSS gf180mcu_as_sc_mcu7t3v3__tap_2
XTAP_TAPCELL_ROW_7_880 VDD VSS gf180mcu_as_sc_mcu7t3v3__tap_2
XTAP_TAPCELL_ROW_33_1459 VDD VSS gf180mcu_as_sc_mcu7t3v3__tap_2
XTAP_TAPCELL_ROW_33_1448 VDD VSS gf180mcu_as_sc_mcu7t3v3__tap_2
XFILLER_130_1520 VDD VDD VSS VSS gf180mcu_as_sc_mcu7t3v3__fill_1
XTAP_TAPCELL_ROW_151_1_1898 VDD VSS gf180mcu_as_sc_mcu7t3v3__tap_2
XFILLER_4_1076 VDD VDD VSS VSS gf180mcu_as_sc_mcu7t3v3__fillcap_8
XFILLER_53_209 VDD VDD VSS VSS gf180mcu_as_sc_mcu7t3v3__fill_1
XFILLER_34_412 VDD VDD VSS VSS gf180mcu_as_sc_mcu7t3v3__fillcap_16
XFILLER_4_1087 VDD VDD VSS VSS gf180mcu_as_sc_mcu7t3v3__fillcap_4
XFILLER_61_220 VDD VDD VSS VSS gf180mcu_as_sc_mcu7t3v3__fill_2
XFILLER_179_417 VDD VDD VSS VSS gf180mcu_as_sc_mcu7t3v3__fill_2
XFILLER_35_979 VDD VDD VSS VSS gf180mcu_as_sc_mcu7t3v3__fill_1
XFILLER_21_106 VDD VDD VSS VSS gf180mcu_as_sc_mcu7t3v3__fillcap_16
XPHY_EDGE_ROW_148_1_Right_669 VDD VSS gf180mcu_as_sc_mcu7t3v3__tap_2
X_2982_ VDD VDD VSS VSS _2989_/B _3079_/B _3969_/A gf180mcu_as_sc_mcu7t3v3__nand2_2
XFILLER_188_995 VDD VDD VSS VSS gf180mcu_as_sc_mcu7t3v3__fillcap_16
XFILLER_21_139 VDD VDD VSS VSS gf180mcu_as_sc_mcu7t3v3__fill_1
XFILLER_37_1376 VDD VDD VSS VSS gf180mcu_as_sc_mcu7t3v3__fill_2
X_4721_ VDD VDD VSS VSS _4721_/B _4721_/A _4730_/C gf180mcu_as_sc_mcu7t3v3__and2_2
XTAP_TAPCELL_ROW_177_2075 VDD VSS gf180mcu_as_sc_mcu7t3v3__tap_2
XTAP_TAPCELL_ROW_177_2064 VDD VSS gf180mcu_as_sc_mcu7t3v3__tap_2
XFILLER_159_185 VDD VDD VSS VSS gf180mcu_as_sc_mcu7t3v3__fillcap_16
X_4652_ VDD VDD VSS VSS _4746_/D _5224_/Q _5238_/Q _4733_/A _4653_/B gf180mcu_as_sc_mcu7t3v3__ao22_2
XFILLER_175_656 VDD VDD VSS VSS gf180mcu_as_sc_mcu7t3v3__fill_1
Xinput30 VDD VDD VSS VSS dft_addr[7] _2668_/A gf180mcu_as_sc_mcu7t3v3__buff_12
X_3603_ VDD VDD VSS VSS _4920_/Q _3648_/B _3648_/C _3974_/A _3604_/D gf180mcu_as_sc_mcu7t3v3__ao22_2
XFILLER_174_188 VDD VDD VSS VSS gf180mcu_as_sc_mcu7t3v3__fillcap_4
XFILLER_198_1469 VDD VDD VSS VSS gf180mcu_as_sc_mcu7t3v3__fillcap_16
Xinput41 VDD VDD VSS VSS dft_wdata[6] _2730_/B gf180mcu_as_sc_mcu7t3v3__buff_12
Xinput52 VDD VDD VSS VSS east_in[17] wire853/A gf180mcu_as_sc_mcu7t3v3__buff_12
Xinput63 VDD VDD VSS VSS east_in[27] wire843/A gf180mcu_as_sc_mcu7t3v3__buff_12
X_4583_ VDD VDD VSS VSS _5187_/Q _4592_/B _4583_/C _4583_/D _5187_/D gf180mcu_as_sc_mcu7t3v3__ao211_2
XTAP_TAPCELL_ROW_122_1_1812 VDD VSS gf180mcu_as_sc_mcu7t3v3__tap_2
Xinput74 VDD VDD VSS VSS east_in[6] wire836/A gf180mcu_as_sc_mcu7t3v3__buff_12
Xinput85 VDD VDD VSS VSS ne_in[16] _4064_/D gf180mcu_as_sc_mcu7t3v3__buff_12
Xinput96 VDD VDD VSS VSS ne_in[26] _4146_/D gf180mcu_as_sc_mcu7t3v3__buff_12
X_3534_ VDD VDD VSS VSS _3818_/A _3534_/A _3932_/B gf180mcu_as_sc_mcu7t3v3__and2_2
XTAP_TAPCELL_ROW_134_3_3124 VDD VSS gf180mcu_as_sc_mcu7t3v3__tap_2
X_3465_ VDD VDD VSS VSS _4938_/Q _3486_/B _3465_/C _4120_/A _3466_/D gf180mcu_as_sc_mcu7t3v3__ao22_2
X_5204_ VDD VDD VSS VSS _5216_/CLK _5204_/D _5204_/Q gf180mcu_as_sc_mcu7t3v3__dfxtp_2
X_2416_ VDD VDD VSS VSS _2695_/A _2732_/S gf180mcu_as_sc_mcu7t3v3__inv_2
X_3396_ VDD VDD VSS VSS _3451_/B _4046_/A _3396_/A _3398_/C gf180mcu_as_sc_mcu7t3v3__mux2_2
XTAP_TAPCELL_ROW_5_839 VDD VSS gf180mcu_as_sc_mcu7t3v3__tap_2
XFILLER_135_1475 VDD VDD VSS VSS gf180mcu_as_sc_mcu7t3v3__fillcap_4
X_5135_ VDD VDD VSS VSS _5197_/CLK _5135_/D _5135_/Q gf180mcu_as_sc_mcu7t3v3__dfxtp_2
XTAP_TAPCELL_ROW_209_2764 VDD VSS gf180mcu_as_sc_mcu7t3v3__tap_2
XFILLER_123_27 VDD VDD VSS VSS gf180mcu_as_sc_mcu7t3v3__fillcap_8
XFILLER_170_1399 VDD VDD VSS VSS gf180mcu_as_sc_mcu7t3v3__fillcap_8
X_5066_ VDD VDD VSS VSS clkload5/A _5066_/D _5066_/Q gf180mcu_as_sc_mcu7t3v3__dfxtp_2
XTAP_TAPCELL_ROW_209_2775 VDD VSS gf180mcu_as_sc_mcu7t3v3__tap_2
XFILLER_26_924 VDD VDD VSS VSS gf180mcu_as_sc_mcu7t3v3__fillcap_4
X_4017_ VDD VDD VSS VSS _4017_/A _4105_/B _4017_/C _4017_/D _4018_/B gf180mcu_as_sc_mcu7t3v3__ao211_2
XFILLER_25_434 VDD VDD VSS VSS gf180mcu_as_sc_mcu7t3v3__fill_1
XFILLER_198_715 VDD VDD VSS VSS gf180mcu_as_sc_mcu7t3v3__fillcap_16
XFILLER_198_737 VDD VDD VSS VSS gf180mcu_as_sc_mcu7t3v3__fillcap_16
XFILLER_13_618 VDD VDD VSS VSS gf180mcu_as_sc_mcu7t3v3__fillcap_8
XFILLER_25_478 VDD VDD VSS VSS gf180mcu_as_sc_mcu7t3v3__fillcap_8
XFILLER_12_139 VDD VDD VSS VSS gf180mcu_as_sc_mcu7t3v3__fillcap_16
XFILLER_181_1462 VDD VDD VSS VSS gf180mcu_as_sc_mcu7t3v3__fillcap_8
XPHY_EDGE_ROW_205_Left_415 VDD VSS gf180mcu_as_sc_mcu7t3v3__tap_2
X_4919_ VDD VDD VSS VSS _4919_/CLK _4919_/D _4919_/Q gf180mcu_as_sc_mcu7t3v3__dfxtp_2
XFILLER_107_1555 VDD VDD VSS VSS gf180mcu_as_sc_mcu7t3v3__fill_1
XFILLER_107_1566 VDD VDD VSS VSS gf180mcu_as_sc_mcu7t3v3__fill_2
XFILLER_16_1449 VDD VDD VSS VSS gf180mcu_as_sc_mcu7t3v3__fillcap_16
XFILLER_181_1484 VDD VDD VSS VSS gf180mcu_as_sc_mcu7t3v3__fill_1
XTAP_TAPCELL_ROW_78_3_2955 VDD VSS gf180mcu_as_sc_mcu7t3v3__tap_2
XFILLER_165_122 VDD VDD VSS VSS gf180mcu_as_sc_mcu7t3v3__fillcap_8
XFILLER_20_172 VDD VDD VSS VSS gf180mcu_as_sc_mcu7t3v3__fill_2
XFILLER_148_79 VDD VDD VSS VSS gf180mcu_as_sc_mcu7t3v3__fillcap_4
XFILLER_14_1173 VDD VDD VSS VSS gf180mcu_as_sc_mcu7t3v3__fillcap_8
XFILLER_5_839 VDD VDD VSS VSS gf180mcu_as_sc_mcu7t3v3__fill_1
XPHY_EDGE_ROW_86_3_Right_123 VDD VSS gf180mcu_as_sc_mcu7t3v3__tap_2
XFILLER_10_1037 VDD VDD VSS VSS gf180mcu_as_sc_mcu7t3v3__fill_2
XFILLER_14_1195 VDD VDD VSS VSS gf180mcu_as_sc_mcu7t3v3__fillcap_16
XFILLER_181_648 VDD VDD VSS VSS gf180mcu_as_sc_mcu7t3v3__fillcap_16
XFILLER_164_34 VDD VDD VSS VSS gf180mcu_as_sc_mcu7t3v3__fill_1
XFILLER_164_45 VDD VDD VSS VSS gf180mcu_as_sc_mcu7t3v3__fillcap_4
XFILLER_175_1266 VDD VDD VSS VSS gf180mcu_as_sc_mcu7t3v3__fill_1
XFILLER_27_1523 VDD VDD VSS VSS gf180mcu_as_sc_mcu7t3v3__fillcap_16
XFILLER_79_117 VDD VDD VSS VSS gf180mcu_as_sc_mcu7t3v3__fillcap_16
XFILLER_79_139 VDD VDD VSS VSS gf180mcu_as_sc_mcu7t3v3__fill_1
XFILLER_114_1504 VDD VDD VSS VSS gf180mcu_as_sc_mcu7t3v3__fillcap_16
XFILLER_62_1425 VDD VDD VSS VSS gf180mcu_as_sc_mcu7t3v3__fill_1
XFILLER_180_22 VDD VDD VSS VSS gf180mcu_as_sc_mcu7t3v3__fillcap_8
XFILLER_87_183 VDD VDD VSS VSS gf180mcu_as_sc_mcu7t3v3__fillcap_8
XTAP_TAPCELL_ROW_41_1_1567 VDD VSS gf180mcu_as_sc_mcu7t3v3__tap_2
XFILLER_21_1122 VDD VDD VSS VSS gf180mcu_as_sc_mcu7t3v3__fillcap_16
XFILLER_35_209 VDD VDD VSS VSS gf180mcu_as_sc_mcu7t3v3__fill_1
XFILLER_1_1238 VDD VDD VSS VSS gf180mcu_as_sc_mcu7t3v3__fillcap_16
XFILLER_17_979 VDD VDD VSS VSS gf180mcu_as_sc_mcu7t3v3__fill_1
XFILLER_43_220 VDD VDD VSS VSS gf180mcu_as_sc_mcu7t3v3__fill_2
XFILLER_188_225 VDD VDD VSS VSS gf180mcu_as_sc_mcu7t3v3__fillcap_16
XFILLER_188_247 VDD VDD VSS VSS gf180mcu_as_sc_mcu7t3v3__fillcap_16
XFILLER_31_404 VDD VDD VSS VSS gf180mcu_as_sc_mcu7t3v3__fill_1
XFILLER_160_1513 VDD VDD VSS VSS gf180mcu_as_sc_mcu7t3v3__fill_1
XFILLER_31_459 VDD VDD VSS VSS gf180mcu_as_sc_mcu7t3v3__fillcap_16
XPHY_EDGE_ROW_120_1_Left_330 VDD VSS gf180mcu_as_sc_mcu7t3v3__tap_2
XTAP_TAPCELL_ROW_127_1_1827 VDD VSS gf180mcu_as_sc_mcu7t3v3__tap_2
XFILLER_19_1084 VDD VDD VSS VSS gf180mcu_as_sc_mcu7t3v3__fillcap_4
XTAP_TAPCELL_ROW_139_3_3139 VDD VSS gf180mcu_as_sc_mcu7t3v3__tap_2
XFILLER_160_1568 VDD VDD VSS VSS gf180mcu_as_sc_mcu7t3v3__fill_1
XFILLER_185_976 VDD VDD VSS VSS gf180mcu_as_sc_mcu7t3v3__fillcap_4
XFILLER_200_785 VDD VDD VSS VSS gf180mcu_as_sc_mcu7t3v3__fillcap_16
XPHY_EDGE_ROW_72_1_Right_593 VDD VSS gf180mcu_as_sc_mcu7t3v3__tap_2
XTAP_TAPCELL_ROW_26_1296 VDD VSS gf180mcu_as_sc_mcu7t3v3__tap_2
XFILLER_156_177 VDD VDD VSS VSS gf180mcu_as_sc_mcu7t3v3__fillcap_16
XFILLER_184_464 VDD VDD VSS VSS gf180mcu_as_sc_mcu7t3v3__fillcap_16
XFILLER_185_998 VDD VDD VSS VSS gf180mcu_as_sc_mcu7t3v3__fillcap_16
XFILLER_158_1453 VDD VDD VSS VSS gf180mcu_as_sc_mcu7t3v3__fillcap_4
XFILLER_193_1377 VDD VDD VSS VSS gf180mcu_as_sc_mcu7t3v3__fillcap_16
XFILLER_193_1399 VDD VDD VSS VSS gf180mcu_as_sc_mcu7t3v3__fill_1
XFILLER_26_1000 VDD VDD VSS VSS gf180mcu_as_sc_mcu7t3v3__fillcap_8
XFILLER_3_393 VDD VDD VSS VSS gf180mcu_as_sc_mcu7t3v3__fill_2
X_3250_ VDD VDD VSS VSS _3250_/Y _3510_/C _3519_/C gf180mcu_as_sc_mcu7t3v3__nand2_2
XFILLER_26_1066 VDD VDD VSS VSS gf180mcu_as_sc_mcu7t3v3__fill_2
XFILLER_78_150 VDD VDD VSS VSS gf180mcu_as_sc_mcu7t3v3__fillcap_4
X_3181_ VDD VDD VSS VSS _3181_/A _3181_/B _3181_/C _3182_/C gf180mcu_as_sc_mcu7t3v3__nor3_2
XFILLER_43_1380 VDD VDD VSS VSS gf180mcu_as_sc_mcu7t3v3__fillcap_16
XFILLER_93_142 VDD VDD VSS VSS gf180mcu_as_sc_mcu7t3v3__fill_2
XFILLER_130_1383 VDD VDD VSS VSS gf180mcu_as_sc_mcu7t3v3__fillcap_4
XFILLER_78_1443 VDD VDD VSS VSS gf180mcu_as_sc_mcu7t3v3__fillcap_8
XTAP_TAPCELL_ROW_204_2661 VDD VSS gf180mcu_as_sc_mcu7t3v3__tap_2
XTAP_TAPCELL_ROW_204_2650 VDD VSS gf180mcu_as_sc_mcu7t3v3__tap_2
XTAP_TAPCELL_ROW_179_2104 VDD VSS gf180mcu_as_sc_mcu7t3v3__tap_2
XFILLER_165_1424 VDD VDD VSS VSS gf180mcu_as_sc_mcu7t3v3__fill_1
XTAP_TAPCELL_ROW_179_2115 VDD VSS gf180mcu_as_sc_mcu7t3v3__tap_2
XPHY_EDGE_ROW_52_1_Left_262 VDD VSS gf180mcu_as_sc_mcu7t3v3__tap_2
XTAP_TAPCELL_ROW_200_2569 VDD VSS gf180mcu_as_sc_mcu7t3v3__tap_2
XFILLER_195_718 VDD VDD VSS VSS gf180mcu_as_sc_mcu7t3v3__fillcap_16
XFILLER_210_505 VDD VDD VSS VSS gf180mcu_as_sc_mcu7t3v3__fillcap_4
XFILLER_210_516 VDD VDD VSS VSS gf180mcu_as_sc_mcu7t3v3__fillcap_4
XTAP_TAPCELL_ROW_196_2484 VDD VSS gf180mcu_as_sc_mcu7t3v3__tap_2
XFILLER_31_982 VDD VDD VSS VSS gf180mcu_as_sc_mcu7t3v3__fillcap_8
X_4704_ VDD VDD VSS VSS _4705_/C _4704_/A _4704_/B _5241_/Q gf180mcu_as_sc_mcu7t3v3__ao21_2
X_2965_ VDD VDD VSS VSS _2965_/Y _2965_/C _3005_/A _3944_/A gf180mcu_as_sc_mcu7t3v3__aoi21_2
XTAP_TAPCELL_ROW_196_2495 VDD VSS gf180mcu_as_sc_mcu7t3v3__tap_2
XFILLER_202_1329 VDD VDD VSS VSS gf180mcu_as_sc_mcu7t3v3__fillcap_16
X_2896_ VDD VDD VSS VSS _3143_/S _3227_/S _2948_/B gf180mcu_as_sc_mcu7t3v3__and2_2
XFILLER_50_1373 VDD VDD VSS VSS gf180mcu_as_sc_mcu7t3v3__fillcap_8
X_4635_ VDD VDD VSS VSS _4642_/S _5112_/Q _5226_/Q _5226_/D gf180mcu_as_sc_mcu7t3v3__mux2_2
XFILLER_194_1119 VDD VDD VSS VSS gf180mcu_as_sc_mcu7t3v3__fillcap_16
XFILLER_85_1414 VDD VDD VSS VSS gf180mcu_as_sc_mcu7t3v3__fill_2
X_4566_ VDD VDD VSS VSS _5187_/Q _4590_/B _4575_/C _5105_/Q _4567_/B gf180mcu_as_sc_mcu7t3v3__ao22_2
XFILLER_102_1485 VDD VDD VSS VSS gf180mcu_as_sc_mcu7t3v3__fillcap_16
XFILLER_162_147 VDD VDD VSS VSS gf180mcu_as_sc_mcu7t3v3__fillcap_16
X_3517_ VDD VDD VSS VSS _3517_/A _3533_/A _3812_/A _3517_/D _3518_/B gf180mcu_as_sc_mcu7t3v3__nand4_2
XFILLER_85_1458 VDD VDD VSS VSS gf180mcu_as_sc_mcu7t3v3__fillcap_16
X_4497_ VDD VDD VSS VSS _4497_/B _4497_/A _4504_/C gf180mcu_as_sc_mcu7t3v3__and2_2
X_3448_ VDD VDD VSS VSS _4936_/Q _3448_/B _3448_/C _4102_/A _3449_/C gf180mcu_as_sc_mcu7t3v3__ao22_2
XFILLER_134_37 VDD VDD VSS VSS gf180mcu_as_sc_mcu7t3v3__fillcap_8
X_3379_ VDD VDD VSS VSS _3449_/B _4031_/A _3379_/A _3380_/D gf180mcu_as_sc_mcu7t3v3__mux2_2
X_5118_ VDD VDD VSS VSS clkload7/A _5118_/D _5118_/Q gf180mcu_as_sc_mcu7t3v3__dfxtp_2
XFILLER_17_209 VDD VDD VSS VSS gf180mcu_as_sc_mcu7t3v3__fill_1
XFILLER_2_1503 VDD VDD VSS VSS gf180mcu_as_sc_mcu7t3v3__fill_2
X_5049_ VDD VDD VSS VSS clkload4/A _5049_/D _5049_/Q gf180mcu_as_sc_mcu7t3v3__dfxtp_2
XFILLER_26_754 VDD VDD VSS VSS gf180mcu_as_sc_mcu7t3v3__fill_1
XFILLER_92_1418 VDD VDD VSS VSS gf180mcu_as_sc_mcu7t3v3__fillcap_4
XTAP_TAPCELL_ROW_99_1_1743 VDD VSS gf180mcu_as_sc_mcu7t3v3__tap_2
XFILLER_185_228 VDD VDD VSS VSS gf180mcu_as_sc_mcu7t3v3__fillcap_4
XFILLER_43_67 VDD VDD VSS VSS gf180mcu_as_sc_mcu7t3v3__fill_2
XFILLER_159_89 VDD VDD VSS VSS gf180mcu_as_sc_mcu7t3v3__fillcap_16
XFILLER_138_155 VDD VDD VSS VSS gf180mcu_as_sc_mcu7t3v3__fillcap_16
XFILLER_138_177 VDD VDD VSS VSS gf180mcu_as_sc_mcu7t3v3__fillcap_8
XFILLER_21_492 VDD VDD VSS VSS gf180mcu_as_sc_mcu7t3v3__fillcap_16
XFILLER_175_22 VDD VDD VSS VSS gf180mcu_as_sc_mcu7t3v3__fillcap_16
XFILLER_177_1328 VDD VDD VSS VSS gf180mcu_as_sc_mcu7t3v3__fill_2
XFILLER_209_2 VDD VDD VSS VSS gf180mcu_as_sc_mcu7t3v3__fillcap_16
XPHY_EDGE_ROW_87_3_Right_124 VDD VSS gf180mcu_as_sc_mcu7t3v3__tap_2
Xclkbuf_2_0_0_clk_regs VDD VDD VSS VSS clkbuf_0_clk_regs/Y clkbuf_2_0_0_clk_regs/Y
+ gf180mcu_as_sc_mcu7t3v3__clkbuff_12
XTAP_TAPCELL_ROW_21_1182 VDD VSS gf180mcu_as_sc_mcu7t3v3__tap_2
XFILLER_153_158 VDD VDD VSS VSS gf180mcu_as_sc_mcu7t3v3__fillcap_16
XFILLER_175_1030 VDD VDD VSS VSS gf180mcu_as_sc_mcu7t3v3__fillcap_16
XFILLER_182_979 VDD VDD VSS VSS gf180mcu_as_sc_mcu7t3v3__fillcap_16
XTAP_TAPCELL_ROW_9_920 VDD VSS gf180mcu_as_sc_mcu7t3v3__tap_2
XTAP_TAPCELL_ROW_21_1193 VDD VSS gf180mcu_as_sc_mcu7t3v3__tap_2
XFILLER_175_1052 VDD VDD VSS VSS gf180mcu_as_sc_mcu7t3v3__fillcap_16
XFILLER_175_88 VDD VDD VSS VSS gf180mcu_as_sc_mcu7t3v3__fillcap_16
XTAP_TAPCELL_ROW_9_931 VDD VSS gf180mcu_as_sc_mcu7t3v3__tap_2
XFILLER_108_93 VDD VDD VSS VSS gf180mcu_as_sc_mcu7t3v3__fill_1
XFILLER_161_180 VDD VDD VSS VSS gf180mcu_as_sc_mcu7t3v3__fill_2
XFILLER_68_53 VDD VDD VSS VSS gf180mcu_as_sc_mcu7t3v3__fillcap_8
XFILLER_27_1364 VDD VDD VSS VSS gf180mcu_as_sc_mcu7t3v3__fill_2
Xinput220 VDD VDD VSS VSS south_in[14] _4047_/A gf180mcu_as_sc_mcu7t3v3__buff_12
Xinput231 VDD VDD VSS VSS south_in[24] _4128_/A gf180mcu_as_sc_mcu7t3v3__buff_12
Xinput242 VDD VDD VSS VSS south_in[3] _3958_/A gf180mcu_as_sc_mcu7t3v3__buff_12
Xinput253 VDD VDD VSS VSS sw_in[13] _2435_/A gf180mcu_as_sc_mcu7t3v3__buff_12
XFILLER_75_142 VDD VDD VSS VSS gf180mcu_as_sc_mcu7t3v3__fillcap_16
Xinput264 VDD VDD VSS VSS sw_in[23] _2445_/A gf180mcu_as_sc_mcu7t3v3__buff_12
Xinput275 VDD VDD VSS VSS sw_in[33] _3817_/A gf180mcu_as_sc_mcu7t3v3__buff_12
Xinput286 VDD VDD VSS VSS west_in[12] _4030_/A gf180mcu_as_sc_mcu7t3v3__buff_12
Xinput297 VDD VDD VSS VSS west_in[22] _4109_/D gf180mcu_as_sc_mcu7t3v3__buff_12
XFILLER_1_1002 VDD VDD VSS VSS gf180mcu_as_sc_mcu7t3v3__fillcap_16
XFILLER_90_123 VDD VDD VSS VSS gf180mcu_as_sc_mcu7t3v3__fillcap_16
XFILLER_1_1068 VDD VDD VSS VSS gf180mcu_as_sc_mcu7t3v3__fillcap_16
XFILLER_32_724 VDD VDD VSS VSS gf180mcu_as_sc_mcu7t3v3__fill_1
XFILLER_90_189 VDD VDD VSS VSS gf180mcu_as_sc_mcu7t3v3__fill_1
XTAP_TAPCELL_ROW_28_1336 VDD VSS gf180mcu_as_sc_mcu7t3v3__tap_2
XFILLER_16_297 VDD VDD VSS VSS gf180mcu_as_sc_mcu7t3v3__fillcap_4
XFILLER_189_578 VDD VDD VSS VSS gf180mcu_as_sc_mcu7t3v3__fillcap_16
XFILLER_204_365 VDD VDD VSS VSS gf180mcu_as_sc_mcu7t3v3__fillcap_16
XFILLER_204_387 VDD VDD VSS VSS gf180mcu_as_sc_mcu7t3v3__fillcap_16
XFILLER_20_908 VDD VDD VSS VSS gf180mcu_as_sc_mcu7t3v3__fill_1
XFILLER_31_212 VDD VDD VSS VSS gf180mcu_as_sc_mcu7t3v3__fillcap_8
XTAP_TAPCELL_ROW_146_1_1882 VDD VSS gf180mcu_as_sc_mcu7t3v3__tap_2
X_4891__1076 VDD VDD VSS VSS _4891_/D gf180mcu_as_sc_mcu7t3v3__tiel_4
XTAP_TAPCELL_ROW_28_1347 VDD VSS gf180mcu_as_sc_mcu7t3v3__tap_2
XTAP_TAPCELL_ROW_174_2001 VDD VSS gf180mcu_as_sc_mcu7t3v3__tap_2
XFILLER_176_239 VDD VDD VSS VSS gf180mcu_as_sc_mcu7t3v3__fillcap_4
XFILLER_31_256 VDD VDD VSS VSS gf180mcu_as_sc_mcu7t3v3__fillcap_16
XFILLER_34_1313 VDD VDD VSS VSS gf180mcu_as_sc_mcu7t3v3__fill_1
XTAP_TAPCELL_ROW_158_3_3194 VDD VSS gf180mcu_as_sc_mcu7t3v3__tap_2
XFILLER_13_982 VDD VDD VSS VSS gf180mcu_as_sc_mcu7t3v3__fillcap_4
XFILLER_199_1520 VDD VDD VSS VSS gf180mcu_as_sc_mcu7t3v3__fillcap_16
XFILLER_73_1395 VDD VDD VSS VSS gf180mcu_as_sc_mcu7t3v3__fillcap_4
X_2750_ VDD VDD VSS VSS _2764_/A _2810_/A gf180mcu_as_sc_mcu7t3v3__inv_2
XFILLER_160_1376 VDD VDD VSS VSS gf180mcu_as_sc_mcu7t3v3__fillcap_4
XFILLER_160_1387 VDD VDD VSS VSS gf180mcu_as_sc_mcu7t3v3__fillcap_4
XFILLER_191_209 VDD VDD VSS VSS gf180mcu_as_sc_mcu7t3v3__fill_1
XFILLER_199_1542 VDD VDD VSS VSS gf180mcu_as_sc_mcu7t3v3__fill_2
XPHY_EDGE_ROW_73_1_Right_594 VDD VSS gf180mcu_as_sc_mcu7t3v3__tap_2
X_2681_ VDD VDD VSS VSS _2681_/Y _4262_/A _2699_/A gf180mcu_as_sc_mcu7t3v3__nor2_2
XTAP_TAPCELL_ROW_191_2381 VDD VSS gf180mcu_as_sc_mcu7t3v3__tap_2
XTAP_TAPCELL_ROW_191_2370 VDD VSS gf180mcu_as_sc_mcu7t3v3__tap_2
XFILLER_184_283 VDD VDD VSS VSS gf180mcu_as_sc_mcu7t3v3__fill_1
XFILLER_32_1070 VDD VDD VSS VSS gf180mcu_as_sc_mcu7t3v3__fillcap_4
XFILLER_69_4 VDD VDD VSS VSS gf180mcu_as_sc_mcu7t3v3__fill_1
X_4420_ VDD VDD VSS VSS _4421_/B _4420_/A gf180mcu_as_sc_mcu7t3v3__inv_2
X_4351_ VDD VDD VSS VSS _4554_/B _4351_/B _4351_/A _4352_/B gf180mcu_as_sc_mcu7t3v3__mux2_2
X_4282_ VDD VDD VSS VSS _4289_/S _5478_/A _5116_/Q _5116_/D gf180mcu_as_sc_mcu7t3v3__mux2_2
X_3302_ VDD VDD VSS VSS _3505_/S _3302_/B _3302_/A _3303_/B gf180mcu_as_sc_mcu7t3v3__mux2_2
X_3233_ VDD VDD VSS VSS _3234_/D _3233_/C _3233_/B _3519_/A gf180mcu_as_sc_mcu7t3v3__aoi21b_2
XTAP_TAPCELL_ROW_206_2712 VDD VSS gf180mcu_as_sc_mcu7t3v3__tap_2
XTAP_TAPCELL_ROW_206_2701 VDD VSS gf180mcu_as_sc_mcu7t3v3__tap_2
XFILLER_27_507 VDD VDD VSS VSS gf180mcu_as_sc_mcu7t3v3__fill_2
X_3164_ VDD VDD VSS VSS _3181_/A _3164_/B _3164_/C _3165_/C gf180mcu_as_sc_mcu7t3v3__nor3_2
XFILLER_132_1489 VDD VDD VSS VSS gf180mcu_as_sc_mcu7t3v3__fillcap_16
X_3095_ VDD VDD VSS VSS _4070_/A _3229_/B _3095_/C _3095_/D _3096_/C gf180mcu_as_sc_mcu7t3v3__ao22_2
XTAP_TAPCELL_ROW_202_2609 VDD VSS gf180mcu_as_sc_mcu7t3v3__tap_2
XFILLER_207_170 VDD VDD VSS VSS gf180mcu_as_sc_mcu7t3v3__fill_1
XTAP_TAPCELL_ROW_198_2535 VDD VSS gf180mcu_as_sc_mcu7t3v3__tap_2
XTAP_TAPCELL_ROW_198_2524 VDD VSS gf180mcu_as_sc_mcu7t3v3__tap_2
XFILLER_23_713 VDD VDD VSS VSS gf180mcu_as_sc_mcu7t3v3__fillcap_16
XFILLER_35_562 VDD VDD VSS VSS gf180mcu_as_sc_mcu7t3v3__fillcap_4
XFILLER_81_167 VDD VDD VSS VSS gf180mcu_as_sc_mcu7t3v3__fillcap_4
XFILLER_210_346 VDD VDD VSS VSS gf180mcu_as_sc_mcu7t3v3__fill_2
XFILLER_52_1413 VDD VDD VSS VSS gf180mcu_as_sc_mcu7t3v3__fillcap_16
X_3997_ VDD VDD VSS VSS _3997_/A _4118_/B _4118_/C _3997_/D _3998_/D gf180mcu_as_sc_mcu7t3v3__ao22_2
XFILLER_13_1408 VDD VDD VSS VSS gf180mcu_as_sc_mcu7t3v3__fill_1
X_2948_ VDD VDD VSS VSS _2948_/Y _2948_/B _3201_/C gf180mcu_as_sc_mcu7t3v3__nor2b_2
XFILLER_13_59 VDD VDD VSS VSS gf180mcu_as_sc_mcu7t3v3__fillcap_8
XFILLER_182_209 VDD VDD VSS VSS gf180mcu_as_sc_mcu7t3v3__fillcap_16
XFILLER_129_59 VDD VDD VSS VSS gf180mcu_as_sc_mcu7t3v3__fillcap_8
XFILLER_87_1509 VDD VDD VSS VSS gf180mcu_as_sc_mcu7t3v3__fill_2
X_4618_ VDD VDD VSS VSS _5212_/Q _4624_/B _4620_/C _5213_/Q _5212_/D gf180mcu_as_sc_mcu7t3v3__ao22_2
X_2879_ VDD VDD VSS VSS _2880_/B _4719_/B _2879_/B _2879_/A gf180mcu_as_sc_mcu7t3v3__aoi21_2
XFILLER_11_1154 VDD VDD VSS VSS gf180mcu_as_sc_mcu7t3v3__fillcap_16
XFILLER_190_264 VDD VDD VSS VSS gf180mcu_as_sc_mcu7t3v3__fillcap_16
Xclkbuf_leaf_19_clk_regs VDD VDD VSS VSS clkload0/A clkload6/A gf180mcu_as_sc_mcu7t3v3__clkbuff_12
XTAP_TAPCELL_ROW_172_1_1961 VDD VSS gf180mcu_as_sc_mcu7t3v3__tap_2
XFILLER_2_617 VDD VDD VSS VSS gf180mcu_as_sc_mcu7t3v3__fill_2
XFILLER_89_212 VDD VDD VSS VSS gf180mcu_as_sc_mcu7t3v3__fillcap_8
XTAP_TAPCELL_ROW_102_3_3026 VDD VSS gf180mcu_as_sc_mcu7t3v3__tap_2
X_4549_ VDD VDD VSS VSS _4570_/S _5084_/Q _4997_/Q _4550_/A gf180mcu_as_sc_mcu7t3v3__mux2_2
XFILLER_137_1356 VDD VDD VSS VSS gf180mcu_as_sc_mcu7t3v3__fillcap_4
XFILLER_145_69 VDD VDD VSS VSS gf180mcu_as_sc_mcu7t3v3__fill_1
XFILLER_176_1383 VDD VDD VSS VSS gf180mcu_as_sc_mcu7t3v3__fillcap_4
XFILLER_63_1520 VDD VDD VSS VSS gf180mcu_as_sc_mcu7t3v3__fillcap_8
XFILLER_150_1512 VDD VDD VSS VSS gf180mcu_as_sc_mcu7t3v3__fillcap_8
XFILLER_38_34 VDD VDD VSS VSS gf180mcu_as_sc_mcu7t3v3__fill_1
XFILLER_111_1518 VDD VDD VSS VSS gf180mcu_as_sc_mcu7t3v3__fill_1
XFILLER_57_131 VDD VDD VSS VSS gf180mcu_as_sc_mcu7t3v3__fillcap_8
XFILLER_57_142 VDD VDD VSS VSS gf180mcu_as_sc_mcu7t3v3__fillcap_8
Xhold1130 VDD VDD VSS VSS _5274_/Q _4745_/A gf180mcu_as_sc_mcu7t3v3__clkbuff_4
Xhold1141 VDD VDD VSS VSS _4961_/Q hold1141/Y gf180mcu_as_sc_mcu7t3v3__clkbuff_4
XFILLER_183_1332 VDD VDD VSS VSS gf180mcu_as_sc_mcu7t3v3__fillcap_16
XFILLER_96_1373 VDD VDD VSS VSS gf180mcu_as_sc_mcu7t3v3__fillcap_8
XFILLER_109_1425 VDD VDD VSS VSS gf180mcu_as_sc_mcu7t3v3__fillcap_16
XFILLER_13_212 VDD VDD VSS VSS gf180mcu_as_sc_mcu7t3v3__fillcap_16
XFILLER_54_99 VDD VDD VSS VSS gf180mcu_as_sc_mcu7t3v3__fillcap_4
XFILLER_158_206 VDD VDD VSS VSS gf180mcu_as_sc_mcu7t3v3__fillcap_16
XFILLER_186_537 VDD VDD VSS VSS gf180mcu_as_sc_mcu7t3v3__fill_1
XFILLER_198_397 VDD VDD VSS VSS gf180mcu_as_sc_mcu7t3v3__fillcap_16
XFILLER_13_278 VDD VDD VSS VSS gf180mcu_as_sc_mcu7t3v3__fill_2
XFILLER_16_1032 VDD VDD VSS VSS gf180mcu_as_sc_mcu7t3v3__fillcap_8
XFILLER_201_346 VDD VDD VSS VSS gf180mcu_as_sc_mcu7t3v3__fillcap_4
XFILLER_201_368 VDD VDD VSS VSS gf180mcu_as_sc_mcu7t3v3__fillcap_16
XFILLER_9_227 VDD VDD VSS VSS gf180mcu_as_sc_mcu7t3v3__fill_1
XTAP_TAPCELL_ROW_23_1233 VDD VSS gf180mcu_as_sc_mcu7t3v3__tap_2
XFILLER_16_1087 VDD VDD VSS VSS gf180mcu_as_sc_mcu7t3v3__fillcap_16
XFILLER_173_209 VDD VDD VSS VSS gf180mcu_as_sc_mcu7t3v3__fill_1
XFILLER_70_1568 VDD VDD VSS VSS gf180mcu_as_sc_mcu7t3v3__fill_1
XTAP_TAPCELL_ROW_23_1244 VDD VSS gf180mcu_as_sc_mcu7t3v3__tap_2
XFILLER_5_422 VDD VDD VSS VSS gf180mcu_as_sc_mcu7t3v3__fillcap_4
Xclkload19 VDD VDD VSS VSS clkload19/Y _5256_/CLK gf180mcu_as_sc_mcu7t3v3__inv_4
XFILLER_181_286 VDD VDD VSS VSS gf180mcu_as_sc_mcu7t3v3__fill_1
XFILLER_68_1453 VDD VDD VSS VSS gf180mcu_as_sc_mcu7t3v3__fillcap_4
XPHY_EDGE_ROW_88_3_Right_125 VDD VSS gf180mcu_as_sc_mcu7t3v3__tap_2
XFILLER_141_139 VDD VDD VSS VSS gf180mcu_as_sc_mcu7t3v3__fill_1
XFILLER_155_1434 VDD VDD VSS VSS gf180mcu_as_sc_mcu7t3v3__fillcap_16
XFILLER_7_1200 VDD VDD VSS VSS gf180mcu_as_sc_mcu7t3v3__fillcap_4
XFILLER_7_1211 VDD VDD VSS VSS gf180mcu_as_sc_mcu7t3v3__fill_1
XFILLER_188_1221 VDD VDD VSS VSS gf180mcu_as_sc_mcu7t3v3__fillcap_4
XFILLER_188_1243 VDD VDD VSS VSS gf180mcu_as_sc_mcu7t3v3__fillcap_16
XFILLER_63_123 VDD VDD VSS VSS gf180mcu_as_sc_mcu7t3v3__fillcap_16
XFILLER_17_562 VDD VDD VSS VSS gf180mcu_as_sc_mcu7t3v3__fill_2
XFILLER_189_320 VDD VDD VSS VSS gf180mcu_as_sc_mcu7t3v3__fillcap_4
XPHY_EDGE_ROW_174_Left_384 VDD VSS gf180mcu_as_sc_mcu7t3v3__tap_2
X_3920_ VDD VDD VSS VSS _3927_/B _3920_/B _3920_/A gf180mcu_as_sc_mcu7t3v3__nand2b_2
XFILLER_32_521 VDD VDD VSS VSS gf180mcu_as_sc_mcu7t3v3__fillcap_4
XFILLER_127_1558 VDD VDD VSS VSS gf180mcu_as_sc_mcu7t3v3__fillcap_8
XFILLER_189_386 VDD VDD VSS VSS gf180mcu_as_sc_mcu7t3v3__fillcap_4
XFILLER_205_696 VDD VDD VSS VSS gf180mcu_as_sc_mcu7t3v3__fillcap_4
XFILLER_32_543 VDD VDD VSS VSS gf180mcu_as_sc_mcu7t3v3__fill_2
X_3851_ VDD VDD VSS VSS _5132_/Q _5133_/Q _3851_/C _3858_/A gf180mcu_as_sc_mcu7t3v3__nor3_2
XTAP_TAPCELL_ROW_193_2421 VDD VSS gf180mcu_as_sc_mcu7t3v3__tap_2
XTAP_TAPCELL_ROW_193_2410 VDD VSS gf180mcu_as_sc_mcu7t3v3__tap_2
XFILLER_203_1402 VDD VDD VSS VSS gf180mcu_as_sc_mcu7t3v3__fillcap_16
X_3782_ VDD VDD VSS VSS _4162_/A _3792_/B _3791_/B _4160_/A _3783_/D gf180mcu_as_sc_mcu7t3v3__ao22_2
X_2802_ VDD VDD VSS VSS _2805_/A _2802_/A _2803_/B gf180mcu_as_sc_mcu7t3v3__or2_2
XFILLER_9_772 VDD VDD VSS VSS gf180mcu_as_sc_mcu7t3v3__fillcap_16
X_2733_ VDD VDD VSS VSS _5164_/Q _4267_/S _4281_/S _5188_/Q _2734_/B gf180mcu_as_sc_mcu7t3v3__ao22_2
XFILLER_172_220 VDD VDD VSS VSS gf180mcu_as_sc_mcu7t3v3__fill_2
XFILLER_9_794 VDD VDD VSS VSS gf180mcu_as_sc_mcu7t3v3__fill_1
XFILLER_117_158 VDD VDD VSS VSS gf180mcu_as_sc_mcu7t3v3__fillcap_16
XFILLER_201_1170 VDD VDD VSS VSS gf180mcu_as_sc_mcu7t3v3__fillcap_16
XPHY_EDGE_ROW_74_1_Right_595 VDD VSS gf180mcu_as_sc_mcu7t3v3__tap_2
XTAP_TAPCELL_ROW_11_980 VDD VSS gf180mcu_as_sc_mcu7t3v3__tap_2
X_2664_ VDD VDD VSS VSS _2664_/Y _2668_/B _2664_/B _2664_/C gf180mcu_as_sc_mcu7t3v3__ao21_2
XTAP_TAPCELL_ROW_62_1_1630 VDD VSS gf180mcu_as_sc_mcu7t3v3__tap_2
XFILLER_132_117 VDD VDD VSS VSS gf180mcu_as_sc_mcu7t3v3__fillcap_16
XFILLER_201_1192 VDD VDD VSS VSS gf180mcu_as_sc_mcu7t3v3__fillcap_16
XPHY_EDGE_ROW_183_Left_393 VDD VSS gf180mcu_as_sc_mcu7t3v3__tap_2
X_4403_ VDD VDD VSS VSS _4500_/S _5009_/Q _5038_/Q _4404_/B gf180mcu_as_sc_mcu7t3v3__mux2_2
X_2595_ VDD VDD VSS VSS _5125_/Q _4264_/A _2595_/A _2597_/C gf180mcu_as_sc_mcu7t3v3__mux2_2
X_4334_ VDD VDD VSS VSS _4334_/Y _4334_/B _4590_/B gf180mcu_as_sc_mcu7t3v3__nand2_2
XFILLER_134_1507 VDD VDD VSS VSS gf180mcu_as_sc_mcu7t3v3__fillcap_8
XTAP_TAPCELL_ROW_72_3_2936 VDD VSS gf180mcu_as_sc_mcu7t3v3__tap_2
X_4265_ VDD VDD VSS VSS _4742_/C _4265_/B _4265_/C _5099_/D gf180mcu_as_sc_mcu7t3v3__nor3_2
XTAP_TAPCELL_ROW_42_1_1572 VDD VSS gf180mcu_as_sc_mcu7t3v3__tap_2
XFILLER_39_142 VDD VDD VSS VSS gf180mcu_as_sc_mcu7t3v3__fillcap_16
X_4196_ VDD VDD VSS VSS _4256_/B _4196_/B _4196_/C _5034_/Q _5034_/D gf180mcu_as_sc_mcu7t3v3__ao22_2
X_3216_ VDD VDD VSS VSS _3216_/D _3801_/A _3216_/B _3216_/C _3217_/A gf180mcu_as_sc_mcu7t3v3__ao31_2
XFILLER_210_1439 VDD VDD VSS VSS gf180mcu_as_sc_mcu7t3v3__fill_2
X_3147_ VDD VDD VSS VSS _4122_/A _3163_/B _3147_/C _3147_/D _3148_/C gf180mcu_as_sc_mcu7t3v3__ao22_2
XTAP_TAPCELL_ROW_52_3_2878 VDD VSS gf180mcu_as_sc_mcu7t3v3__tap_2
XFILLER_54_156 VDD VDD VSS VSS gf180mcu_as_sc_mcu7t3v3__fillcap_8
X_3078_ VDD VDD VSS VSS _3078_/B _4930_/Q _3079_/D gf180mcu_as_sc_mcu7t3v3__or2_2
XFILLER_208_1313 VDD VDD VSS VSS gf180mcu_as_sc_mcu7t3v3__fillcap_16
XFILLER_210_110 VDD VDD VSS VSS gf180mcu_as_sc_mcu7t3v3__fill_1
XFILLER_93_1568 VDD VDD VSS VSS gf180mcu_as_sc_mcu7t3v3__fill_1
XFILLER_24_69 VDD VDD VSS VSS gf180mcu_as_sc_mcu7t3v3__fillcap_16
XFILLER_108_1491 VDD VDD VSS VSS gf180mcu_as_sc_mcu7t3v3__fill_1
XFILLER_10_259 VDD VDD VSS VSS gf180mcu_as_sc_mcu7t3v3__fill_2
XFILLER_155_209 VDD VDD VSS VSS gf180mcu_as_sc_mcu7t3v3__fill_1
XFILLER_206_1081 VDD VDD VSS VSS gf180mcu_as_sc_mcu7t3v3__fillcap_4
XFILLER_210_176 VDD VDD VSS VSS gf180mcu_as_sc_mcu7t3v3__fill_2
XFILLER_104_1366 VDD VDD VSS VSS gf180mcu_as_sc_mcu7t3v3__fill_2
XFILLER_104_1399 VDD VDD VSS VSS gf180mcu_as_sc_mcu7t3v3__fillcap_8
XFILLER_163_220 VDD VDD VSS VSS gf180mcu_as_sc_mcu7t3v3__fill_2
XFILLER_178_1434 VDD VDD VSS VSS gf180mcu_as_sc_mcu7t3v3__fill_1
XFILLER_191_540 VDD VDD VSS VSS gf180mcu_as_sc_mcu7t3v3__fillcap_16
XFILLER_191_562 VDD VDD VSS VSS gf180mcu_as_sc_mcu7t3v3__fillcap_16
XFILLER_200_6 VDD VDD VSS VSS gf180mcu_as_sc_mcu7t3v3__fillcap_16
XFILLER_123_139 VDD VDD VSS VSS gf180mcu_as_sc_mcu7t3v3__fill_1
XTAP_TAPCELL_ROW_121_1_1808 VDD VSS gf180mcu_as_sc_mcu7t3v3__tap_2
XFILLER_131_150 VDD VDD VSS VSS gf180mcu_as_sc_mcu7t3v3__fill_2
XFILLER_172_34 VDD VDD VSS VSS gf180mcu_as_sc_mcu7t3v3__fill_1
Xfanout740 VDD VDD VSS VSS _2902_/Y _3178_/D gf180mcu_as_sc_mcu7t3v3__buff_12
Xfanout751 VDD VDD VSS VSS _3233_/B _3222_/D gf180mcu_as_sc_mcu7t3v3__buff_12
XFILLER_1_18 VDD VDD VSS VSS gf180mcu_as_sc_mcu7t3v3__fill_2
Xfanout762 VDD VDD VSS VSS _2591_/Y _2658_/S gf180mcu_as_sc_mcu7t3v3__buff_12
Xfanout773 VDD VDD VSS VSS _2564_/Y _4263_/A gf180mcu_as_sc_mcu7t3v3__buff_12
XTAP_TAPCELL_ROW_16_1081 VDD VSS gf180mcu_as_sc_mcu7t3v3__tap_2
XFILLER_105_72 VDD VDD VSS VSS gf180mcu_as_sc_mcu7t3v3__fillcap_16
XFILLER_150_1375 VDD VDD VSS VSS gf180mcu_as_sc_mcu7t3v3__fillcap_4
XFILLER_19_838 VDD VDD VSS VSS gf180mcu_as_sc_mcu7t3v3__fill_2
XFILLER_24_1367 VDD VDD VSS VSS gf180mcu_as_sc_mcu7t3v3__fillcap_16
Xfanout795 VDD VDD VSS VSS _5095_/Q _4588_/A gf180mcu_as_sc_mcu7t3v3__buff_12
XTAP_TAPCELL_ROW_16_1092 VDD VSS gf180mcu_as_sc_mcu7t3v3__tap_2
XFILLER_207_928 VDD VDD VSS VSS gf180mcu_as_sc_mcu7t3v3__fillcap_16
XFILLER_65_54 VDD VDD VSS VSS gf180mcu_as_sc_mcu7t3v3__fillcap_4
XFILLER_98_1457 VDD VDD VSS VSS gf180mcu_as_sc_mcu7t3v3__fill_2
XFILLER_14_521 VDD VDD VSS VSS gf180mcu_as_sc_mcu7t3v3__fillcap_4
XFILLER_33_329 VDD VDD VSS VSS gf180mcu_as_sc_mcu7t3v3__fillcap_16
XFILLER_60_115 VDD VDD VSS VSS gf180mcu_as_sc_mcu7t3v3__fill_1
XFILLER_186_312 VDD VDD VSS VSS gf180mcu_as_sc_mcu7t3v3__fill_2
XTAP_TAPCELL_ROW_67_1_1645 VDD VSS gf180mcu_as_sc_mcu7t3v3__tap_2
XFILLER_174_507 VDD VDD VSS VSS gf180mcu_as_sc_mcu7t3v3__fill_2
XFILLER_202_699 VDD VDD VSS VSS gf180mcu_as_sc_mcu7t3v3__fillcap_16
XFILLER_161_1482 VDD VDD VSS VSS gf180mcu_as_sc_mcu7t3v3__fillcap_4
XFILLER_195_890 VDD VDD VSS VSS gf180mcu_as_sc_mcu7t3v3__fillcap_16
XFILLER_196_1501 VDD VDD VSS VSS gf180mcu_as_sc_mcu7t3v3__fillcap_4
XFILLER_196_1523 VDD VDD VSS VSS gf180mcu_as_sc_mcu7t3v3__fillcap_16
XTAP_TAPCELL_ROW_47_1_1587 VDD VSS gf180mcu_as_sc_mcu7t3v3__tap_2
XFILLER_157_1529 VDD VDD VSS VSS gf180mcu_as_sc_mcu7t3v3__fill_2
XFILLER_6_786 VDD VDD VSS VSS gf180mcu_as_sc_mcu7t3v3__fillcap_16
XPHY_EDGE_ROW_89_3_Right_126 VDD VSS gf180mcu_as_sc_mcu7t3v3__tap_2
XFILLER_194_1291 VDD VDD VSS VSS gf180mcu_as_sc_mcu7t3v3__fillcap_4
XFILLER_29_1256 VDD VDD VSS VSS gf180mcu_as_sc_mcu7t3v3__fillcap_4
XFILLER_9_1317 VDD VDD VSS VSS gf180mcu_as_sc_mcu7t3v3__fill_2
XFILLER_25_1109 VDD VDD VSS VSS gf180mcu_as_sc_mcu7t3v3__fillcap_8
XPHY_EDGE_ROW_61_1_Left_271 VDD VSS gf180mcu_as_sc_mcu7t3v3__tap_2
XFILLER_122_194 VDD VDD VSS VSS gf180mcu_as_sc_mcu7t3v3__fillcap_16
XFILLER_133_1562 VDD VDD VSS VSS gf180mcu_as_sc_mcu7t3v3__fillcap_4
XFILLER_7_1052 VDD VDD VSS VSS gf180mcu_as_sc_mcu7t3v3__fillcap_16
XFILLER_81_1472 VDD VDD VSS VSS gf180mcu_as_sc_mcu7t3v3__fillcap_4
X_4050_ VDD VDD VSS VSS _4106_/S _4050_/B _4050_/A _4051_/B gf180mcu_as_sc_mcu7t3v3__mux2_2
XFILLER_36_101 VDD VDD VSS VSS gf180mcu_as_sc_mcu7t3v3__fill_1
Xinput6 VDD VDD VSS VSS boot_addr[4] input6/Y gf180mcu_as_sc_mcu7t3v3__buff_12
X_3001_ VDD VDD VSS VSS _3982_/A _3076_/B _3076_/C _3981_/D _3002_/C gf180mcu_as_sc_mcu7t3v3__ao22_2
XTAP_TAPCELL_ROW_182_2177 VDD VSS gf180mcu_as_sc_mcu7t3v3__tap_2
XTAP_TAPCELL_ROW_182_2166 VDD VSS gf180mcu_as_sc_mcu7t3v3__tap_2
XFILLER_209_298 VDD VDD VSS VSS gf180mcu_as_sc_mcu7t3v3__fill_2
XFILLER_206_983 VDD VDD VSS VSS gf180mcu_as_sc_mcu7t3v3__fillcap_16
X_4952_ VDD VDD VSS VSS clkload7/A _4952_/Q _4952_/RN _3624_/A _4952_/D gf180mcu_as_sc_mcu7t3v3__dfsrtp_2
XFILLER_189_150 VDD VDD VSS VSS gf180mcu_as_sc_mcu7t3v3__fillcap_4
X_4883_ VDD VDD VSS VSS _4924_/CLK _4883_/D _4883_/Q gf180mcu_as_sc_mcu7t3v3__dfxtp_2
X_3903_ VDD VDD VSS VSS _3903_/B _5162_/Q _4943_/D gf180mcu_as_sc_mcu7t3v3__and2_2
XPHY_EDGE_ROW_37_3_Left_422 VDD VSS gf180mcu_as_sc_mcu7t3v3__tap_2
X_3834_ VDD VDD VSS VSS _3835_/B _4168_/A _3845_/A gf180mcu_as_sc_mcu7t3v3__or2_2
XFILLER_137_209 VDD VDD VSS VSS gf180mcu_as_sc_mcu7t3v3__fill_1
XFILLER_177_367 VDD VDD VSS VSS gf180mcu_as_sc_mcu7t3v3__fill_1
XFILLER_32_395 VDD VDD VSS VSS gf180mcu_as_sc_mcu7t3v3__fillcap_4
XFILLER_20_568 VDD VDD VSS VSS gf180mcu_as_sc_mcu7t3v3__fillcap_16
XPHY_EDGE_ROW_191_Left_401 VDD VSS gf180mcu_as_sc_mcu7t3v3__tap_2
X_3765_ VDD VDD VSS VSS _4146_/A _3792_/B _3765_/C _3765_/D _3766_/C gf180mcu_as_sc_mcu7t3v3__ao211_2
XFILLER_145_220 VDD VDD VSS VSS gf180mcu_as_sc_mcu7t3v3__fill_2
XFILLER_9_591 VDD VDD VSS VSS gf180mcu_as_sc_mcu7t3v3__fill_2
X_3696_ VDD VDD VSS VSS _3697_/C _4069_/A _3761_/B _3696_/C gf180mcu_as_sc_mcu7t3v3__ao21_2
X_2716_ VDD VDD VSS VSS _2737_/A _2716_/B _2716_/C _2716_/D _2716_/Y gf180mcu_as_sc_mcu7t3v3__ao22_2
XFILLER_10_27 VDD VDD VSS VSS gf180mcu_as_sc_mcu7t3v3__fillcap_8
XFILLER_160_201 VDD VDD VSS VSS gf180mcu_as_sc_mcu7t3v3__fillcap_16
XPHY_EDGE_ROW_75_1_Right_596 VDD VSS gf180mcu_as_sc_mcu7t3v3__tap_2
X_2647_ VDD VDD VSS VSS _2852_/B _5129_/Q _5193_/Q _2648_/B gf180mcu_as_sc_mcu7t3v3__mux2_2
XTAP_TAPCELL_ROW_93_1_1724 VDD VSS gf180mcu_as_sc_mcu7t3v3__tap_2
XFILLER_126_27 VDD VDD VSS VSS gf180mcu_as_sc_mcu7t3v3__fillcap_8
Xoutput343 VDD VDD VSS VSS _4865_/Q east_out[26] gf180mcu_as_sc_mcu7t3v3__buff_12
Xoutput332 VDD VDD VSS VSS _4855_/Q east_out[16] gf180mcu_as_sc_mcu7t3v3__buff_12
Xoutput321 VDD VDD VSS VSS _5482_/Y dft_rdata[4] gf180mcu_as_sc_mcu7t3v3__buff_12
Xoutput387 VDD VDD VSS VSS _4775_/Q se_out[4] gf180mcu_as_sc_mcu7t3v3__buff_12
Xoutput376 VDD VDD VSS VSS _4796_/Q se_out[25] gf180mcu_as_sc_mcu7t3v3__buff_12
Xoutput365 VDD VDD VSS VSS _4786_/Q se_out[15] gf180mcu_as_sc_mcu7t3v3__buff_12
Xoutput354 VDD VDD VSS VSS _4844_/Q east_out[5] gf180mcu_as_sc_mcu7t3v3__buff_12
X_2578_ VDD VDD VSS VSS _2674_/C _4264_/B _2701_/A gf180mcu_as_sc_mcu7t3v3__nand2_2
XFILLER_173_1364 VDD VDD VSS VSS gf180mcu_as_sc_mcu7t3v3__fillcap_8
Xoutput398 VDD VDD VSS VSS _4819_/Q south_out[14] gf180mcu_as_sc_mcu7t3v3__buff_12
X_4317_ VDD VDD VSS VSS _4324_/S _5147_/Q _5146_/Q _5146_/D gf180mcu_as_sc_mcu7t3v3__mux2_2
XFILLER_134_1348 VDD VDD VSS VSS gf180mcu_as_sc_mcu7t3v3__fillcap_16
X_4248_ VDD VDD VSS VSS _4257_/S _4248_/B _5084_/Q _5084_/D gf180mcu_as_sc_mcu7t3v3__mux2_2
XFILLER_142_37 VDD VDD VSS VSS gf180mcu_as_sc_mcu7t3v3__fillcap_8
XFILLER_19_69 VDD VDD VSS VSS gf180mcu_as_sc_mcu7t3v3__fill_1
XFILLER_28_613 VDD VDD VSS VSS gf180mcu_as_sc_mcu7t3v3__fillcap_16
XFILLER_210_1269 VDD VDD VSS VSS gf180mcu_as_sc_mcu7t3v3__fill_2
X_4179_ VDD VDD VSS VSS _4239_/B _4191_/B _4191_/C _5017_/Q _5017_/D gf180mcu_as_sc_mcu7t3v3__ao22_2
XTAP_TAPCELL_ROW_3_789 VDD VSS gf180mcu_as_sc_mcu7t3v3__tap_2
XFILLER_204_909 VDD VDD VSS VSS gf180mcu_as_sc_mcu7t3v3__fillcap_16
XFILLER_3_1472 VDD VDD VSS VSS gf180mcu_as_sc_mcu7t3v3__fillcap_4
XFILLER_42_104 VDD VDD VSS VSS gf180mcu_as_sc_mcu7t3v3__fill_1
XFILLER_208_1154 VDD VDD VSS VSS gf180mcu_as_sc_mcu7t3v3__fill_1
XFILLER_24_874 VDD VDD VSS VSS gf180mcu_as_sc_mcu7t3v3__fill_1
XFILLER_58_1463 VDD VDD VSS VSS gf180mcu_as_sc_mcu7t3v3__fill_1
XFILLER_58_1474 VDD VDD VSS VSS gf180mcu_as_sc_mcu7t3v3__fillcap_16
XFILLER_145_1477 VDD VDD VSS VSS gf180mcu_as_sc_mcu7t3v3__fillcap_8
XFILLER_195_120 VDD VDD VSS VSS gf180mcu_as_sc_mcu7t3v3__fillcap_16
XFILLER_23_384 VDD VDD VSS VSS gf180mcu_as_sc_mcu7t3v3__fillcap_16
XFILLER_145_1488 VDD VDD VSS VSS gf180mcu_as_sc_mcu7t3v3__fillcap_16
XFILLER_183_304 VDD VDD VSS VSS gf180mcu_as_sc_mcu7t3v3__fill_2
XFILLER_195_142 VDD VDD VSS VSS gf180mcu_as_sc_mcu7t3v3__fillcap_16
XPHY_EDGE_ROW_14_Right_14 VDD VSS gf180mcu_as_sc_mcu7t3v3__tap_2
Xclkbuf_leaf_34_clk_regs VDD VDD VSS VSS clkbuf_3_0__f_clk_regs/Y clkload5/A gf180mcu_as_sc_mcu7t3v3__clkbuff_12
XFILLER_13_1013 VDD VDD VSS VSS gf180mcu_as_sc_mcu7t3v3__fillcap_16
XFILLER_51_67 VDD VDD VSS VSS gf180mcu_as_sc_mcu7t3v3__fill_2
XFILLER_13_1068 VDD VDD VSS VSS gf180mcu_as_sc_mcu7t3v3__fillcap_16
XFILLER_167_78 VDD VDD VSS VSS gf180mcu_as_sc_mcu7t3v3__fill_1
XFILLER_183_359 VDD VDD VSS VSS gf180mcu_as_sc_mcu7t3v3__fillcap_16
XFILLER_178_1275 VDD VDD VSS VSS gf180mcu_as_sc_mcu7t3v3__fillcap_16
XFILLER_192_871 VDD VDD VSS VSS gf180mcu_as_sc_mcu7t3v3__fillcap_4
XFILLER_192_893 VDD VDD VSS VSS gf180mcu_as_sc_mcu7t3v3__fillcap_16
XFILLER_30_1371 VDD VDD VSS VSS gf180mcu_as_sc_mcu7t3v3__fill_2
XFILLER_151_212 VDD VDD VSS VSS gf180mcu_as_sc_mcu7t3v3__fillcap_8
XFILLER_174_1117 VDD VDD VSS VSS gf180mcu_as_sc_mcu7t3v3__fillcap_4
XFILLER_178_1297 VDD VDD VSS VSS gf180mcu_as_sc_mcu7t3v3__fillcap_4
XFILLER_183_22 VDD VDD VSS VSS gf180mcu_as_sc_mcu7t3v3__fillcap_16
XFILLER_117_1502 VDD VDD VSS VSS gf180mcu_as_sc_mcu7t3v3__fillcap_16
XFILLER_4_2 VDD VDD VSS VSS gf180mcu_as_sc_mcu7t3v3__fillcap_16
XTAP_TAPCELL_ROW_18_1132 VDD VSS gf180mcu_as_sc_mcu7t3v3__tap_2
XTAP_TAPCELL_ROW_18_1121 VDD VSS gf180mcu_as_sc_mcu7t3v3__tap_2
XFILLER_104_172 VDD VDD VSS VSS gf180mcu_as_sc_mcu7t3v3__fill_2
XFILLER_183_88 VDD VDD VSS VSS gf180mcu_as_sc_mcu7t3v3__fillcap_16
XPHY_EDGE_ROW_23_Right_23 VDD VSS gf180mcu_as_sc_mcu7t3v3__tap_2
XFILLER_117_1568 VDD VDD VSS VSS gf180mcu_as_sc_mcu7t3v3__fill_1
XFILLER_8_1361 VDD VDD VSS VSS gf180mcu_as_sc_mcu7t3v3__fillcap_4
XTAP_TAPCELL_ROW_14_1029 VDD VSS gf180mcu_as_sc_mcu7t3v3__tap_2
XFILLER_65_207 VDD VDD VSS VSS gf180mcu_as_sc_mcu7t3v3__fill_2
XFILLER_76_53 VDD VDD VSS VSS gf180mcu_as_sc_mcu7t3v3__fillcap_16
XFILLER_8_1383 VDD VDD VSS VSS gf180mcu_as_sc_mcu7t3v3__fill_2
Xfanout570 VDD VDD VSS VSS _3825_/Y _4255_/S gf180mcu_as_sc_mcu7t3v3__buff_12
Xfanout581 VDD VDD VSS VSS _3278_/Y _3453_/B gf180mcu_as_sc_mcu7t3v3__buff_12
XTAP_TAPCELL_ROW_35_1490 VDD VSS gf180mcu_as_sc_mcu7t3v3__tap_2
XFILLER_18_101 VDD VDD VSS VSS gf180mcu_as_sc_mcu7t3v3__fillcap_4
XFILLER_18_123 VDD VDD VSS VSS gf180mcu_as_sc_mcu7t3v3__fillcap_16
XFILLER_20_1017 VDD VDD VSS VSS gf180mcu_as_sc_mcu7t3v3__fillcap_16
XFILLER_185_1224 VDD VDD VSS VSS gf180mcu_as_sc_mcu7t3v3__fillcap_16
XFILLER_206_279 VDD VDD VSS VSS gf180mcu_as_sc_mcu7t3v3__fillcap_16
XFILLER_33_104 VDD VDD VSS VSS gf180mcu_as_sc_mcu7t3v3__fillcap_4
XFILLER_187_610 VDD VDD VSS VSS gf180mcu_as_sc_mcu7t3v3__fillcap_16
XPHY_EDGE_ROW_32_Right_32 VDD VSS gf180mcu_as_sc_mcu7t3v3__tap_2
XFILLER_124_1517 VDD VDD VSS VSS gf180mcu_as_sc_mcu7t3v3__fillcap_4
XFILLER_163_1566 VDD VDD VSS VSS gf180mcu_as_sc_mcu7t3v3__fill_2
XFILLER_187_632 VDD VDD VSS VSS gf180mcu_as_sc_mcu7t3v3__fillcap_16
XFILLER_199_492 VDD VDD VSS VSS gf180mcu_as_sc_mcu7t3v3__fillcap_16
XFILLER_37_1558 VDD VDD VSS VSS gf180mcu_as_sc_mcu7t3v3__fillcap_8
XTAP_TAPCELL_ROW_98_1_1739 VDD VSS gf180mcu_as_sc_mcu7t3v3__tap_2
XFILLER_119_209 VDD VDD VSS VSS gf180mcu_as_sc_mcu7t3v3__fill_1
XFILLER_124_1539 VDD VDD VSS VSS gf180mcu_as_sc_mcu7t3v3__fill_2
XFILLER_186_131 VDD VDD VSS VSS gf180mcu_as_sc_mcu7t3v3__fillcap_4
XFILLER_30_866 VDD VDD VSS VSS gf180mcu_as_sc_mcu7t3v3__fill_1
XFILLER_30_877 VDD VDD VSS VSS gf180mcu_as_sc_mcu7t3v3__fillcap_4
XFILLER_127_220 VDD VDD VSS VSS gf180mcu_as_sc_mcu7t3v3__fill_2
X_3550_ VDD VDD VSS VSS _3562_/B _3562_/A _3550_/Y gf180mcu_as_sc_mcu7t3v3__and2_2
X_2501_ VDD VDD VSS VSS _4746_/A _4662_/C _5222_/Q _2502_/D gf180mcu_as_sc_mcu7t3v3__mux2_2
XTAP_TAPCELL_ROW_103_3_3031 VDD VSS gf180mcu_as_sc_mcu7t3v3__tap_2
X_5220_ VDD VDD VSS VSS _5220_/CLK _5220_/D _5220_/Q gf180mcu_as_sc_mcu7t3v3__dfxtp_2
X_3481_ VDD VDD VSS VSS _4135_/A _3502_/B _3504_/B _4136_/A _3482_/D gf180mcu_as_sc_mcu7t3v3__ao22_2
XFILLER_9_1103 VDD VDD VSS VSS gf180mcu_as_sc_mcu7t3v3__fillcap_16
X_2432_ VDD VDD VSS VSS _3647_/A _4018_/A gf180mcu_as_sc_mcu7t3v3__inv_2
XFILLER_170_1504 VDD VDD VSS VSS gf180mcu_as_sc_mcu7t3v3__fillcap_16
XFILLER_44_1518 VDD VDD VSS VSS gf180mcu_as_sc_mcu7t3v3__fill_2
X_5151_ VDD VDD VSS VSS _5216_/CLK _5151_/D _5151_/Q gf180mcu_as_sc_mcu7t3v3__dfxtp_2
XTAP_TAPCELL_ROW_184_2228 VDD VSS gf180mcu_as_sc_mcu7t3v3__tap_2
XTAP_TAPCELL_ROW_184_2217 VDD VSS gf180mcu_as_sc_mcu7t3v3__tap_2
XFILLER_110_131 VDD VDD VSS VSS gf180mcu_as_sc_mcu7t3v3__fillcap_4
X_5082_ VDD VDD VSS VSS _5082_/CLK _5082_/D _5082_/Q gf180mcu_as_sc_mcu7t3v3__dfxtp_2
X_4102_ VDD VDD VSS VSS _4102_/A _4102_/B _4102_/C _4936_/Q _4103_/D gf180mcu_as_sc_mcu7t3v3__ao22_2
XFILLER_110_164 VDD VDD VSS VSS gf180mcu_as_sc_mcu7t3v3__fillcap_8
X_4033_ VDD VDD VSS VSS _4033_/A _4033_/B _4033_/C _4033_/D _4034_/B gf180mcu_as_sc_mcu7t3v3__ao211_2
XTAP_TAPCELL_ROW_0_704 VDD VSS gf180mcu_as_sc_mcu7t3v3__tap_2
XTAP_TAPCELL_ROW_0_715 VDD VSS gf180mcu_as_sc_mcu7t3v3__tap_2
XTAP_TAPCELL_ROW_0_726 VDD VSS gf180mcu_as_sc_mcu7t3v3__tap_2
XTAP_TAPCELL_ROW_0_737 VDD VSS gf180mcu_as_sc_mcu7t3v3__tap_2
XFILLER_177_120 VDD VDD VSS VSS gf180mcu_as_sc_mcu7t3v3__fill_1
X_4935_ VDD VDD VSS VSS _4977_/CLK _4935_/D _4935_/Q gf180mcu_as_sc_mcu7t3v3__dfxtp_2
XANTENNA_11 VDD VDD VSS VSS _4860_/D gf180mcu_as_sc_mcu7t3v3__diode_2
XANTENNA_22 VDD VDD VSS VSS _4775_/D gf180mcu_as_sc_mcu7t3v3__diode_2
XFILLER_177_142 VDD VDD VSS VSS gf180mcu_as_sc_mcu7t3v3__fillcap_16
XFILLER_20_310 VDD VDD VSS VSS gf180mcu_as_sc_mcu7t3v3__fillcap_4
X_4866_ VDD VDD VSS VSS _4869_/CLK _4866_/D _4866_/Q gf180mcu_as_sc_mcu7t3v3__dfxtp_2
XTAP_TAPCELL_ROW_47_3_2862 VDD VSS gf180mcu_as_sc_mcu7t3v3__tap_2
XANTENNA_33 VDD VDD VSS VSS _3675_/B gf180mcu_as_sc_mcu7t3v3__diode_2
XFILLER_192_101 VDD VDD VSS VSS gf180mcu_as_sc_mcu7t3v3__fillcap_4
XFILLER_21_888 VDD VDD VSS VSS gf180mcu_as_sc_mcu7t3v3__fillcap_16
X_4797_ VDD VDD VSS VSS _5214_/CLK _4797_/D _4797_/Q gf180mcu_as_sc_mcu7t3v3__dfxtp_2
X_3817_ VDD VDD VSS VSS _3817_/A _3817_/B _3817_/C _3922_/C gf180mcu_as_sc_mcu7t3v3__nand3_2
XFILLER_192_123 VDD VDD VSS VSS gf180mcu_as_sc_mcu7t3v3__fillcap_16
XFILLER_203_1084 VDD VDD VSS VSS gf180mcu_as_sc_mcu7t3v3__fillcap_16
XFILLER_20_387 VDD VDD VSS VSS gf180mcu_as_sc_mcu7t3v3__fillcap_4
X_3748_ VDD VDD VSS VSS _4939_/Q _3799_/B _3770_/C _4129_/A _3749_/D gf180mcu_as_sc_mcu7t3v3__ao22_2
XFILLER_180_307 VDD VDD VSS VSS gf180mcu_as_sc_mcu7t3v3__fillcap_8
XFILLER_133_212 VDD VDD VSS VSS gf180mcu_as_sc_mcu7t3v3__fillcap_8
XFILLER_137_59 VDD VDD VSS VSS gf180mcu_as_sc_mcu7t3v3__fillcap_8
XFILLER_49_1418 VDD VDD VSS VSS gf180mcu_as_sc_mcu7t3v3__fillcap_4
XFILLER_88_1478 VDD VDD VSS VSS gf180mcu_as_sc_mcu7t3v3__fill_1
XPHY_EDGE_ROW_76_1_Right_597 VDD VSS gf180mcu_as_sc_mcu7t3v3__tap_2
X_3679_ VDD VDD VSS VSS _3683_/B _3679_/C _3726_/B _4056_/A gf180mcu_as_sc_mcu7t3v3__aoi21_2
XFILLER_101_142 VDD VDD VSS VSS gf180mcu_as_sc_mcu7t3v3__fill_2
XFILLER_151_1492 VDD VDD VSS VSS gf180mcu_as_sc_mcu7t3v3__fill_1
XFILLER_29_944 VDD VDD VSS VSS gf180mcu_as_sc_mcu7t3v3__fillcap_16
XFILLER_60_1364 VDD VDD VSS VSS gf180mcu_as_sc_mcu7t3v3__fillcap_16
XFILLER_99_1530 VDD VDD VSS VSS gf180mcu_as_sc_mcu7t3v3__fill_1
XTAP_TAPCELL_ROW_128_3_3104 VDD VSS gf180mcu_as_sc_mcu7t3v3__tap_2
XFILLER_21_1348 VDD VDD VSS VSS gf180mcu_as_sc_mcu7t3v3__fillcap_4
XFILLER_15_104 VDD VDD VSS VSS gf180mcu_as_sc_mcu7t3v3__fill_2
XFILLER_186_1566 VDD VDD VSS VSS gf180mcu_as_sc_mcu7t3v3__fill_2
XFILLER_28_498 VDD VDD VSS VSS gf180mcu_as_sc_mcu7t3v3__fillcap_8
XFILLER_30_107 VDD VDD VSS VSS gf180mcu_as_sc_mcu7t3v3__fillcap_16
XFILLER_11_310 VDD VDD VSS VSS gf180mcu_as_sc_mcu7t3v3__fillcap_4
XFILLER_141_2 VDD VDD VSS VSS gf180mcu_as_sc_mcu7t3v3__fillcap_16
XFILLER_15_1108 VDD VDD VSS VSS gf180mcu_as_sc_mcu7t3v3__fillcap_8
XFILLER_200_934 VDD VDD VSS VSS gf180mcu_as_sc_mcu7t3v3__fillcap_8
XTAP_TAPCELL_ROW_108_3_3046 VDD VSS gf180mcu_as_sc_mcu7t3v3__tap_2
XFILLER_12_877 VDD VDD VSS VSS gf180mcu_as_sc_mcu7t3v3__fillcap_16
XFILLER_196_473 VDD VDD VSS VSS gf180mcu_as_sc_mcu7t3v3__fillcap_16
XFILLER_109_220 VDD VDD VSS VSS gf180mcu_as_sc_mcu7t3v3__fill_2
XFILLER_71_1482 VDD VDD VSS VSS gf180mcu_as_sc_mcu7t3v3__fillcap_4
XFILLER_32_1499 VDD VDD VSS VSS gf180mcu_as_sc_mcu7t3v3__fillcap_4
XFILLER_124_212 VDD VDD VSS VSS gf180mcu_as_sc_mcu7t3v3__fillcap_8
XFILLER_193_1537 VDD VDD VSS VSS gf180mcu_as_sc_mcu7t3v3__fill_2
XTAP_TAPCELL_ROW_73_3_2941 VDD VSS gf180mcu_as_sc_mcu7t3v3__tap_2
XTAP_TAPCELL_ROW_171_1_1957 VDD VSS gf180mcu_as_sc_mcu7t3v3__tap_2
XFILLER_191_1294 VDD VDD VSS VSS gf180mcu_as_sc_mcu7t3v3__fillcap_16
XTAP_TAPCELL_ROW_7_892 VDD VSS gf180mcu_as_sc_mcu7t3v3__tap_2
XTAP_TAPCELL_ROW_7_881 VDD VSS gf180mcu_as_sc_mcu7t3v3__tap_2
XTAP_TAPCELL_ROW_33_1449 VDD VSS gf180mcu_as_sc_mcu7t3v3__tap_2
XFILLER_143_80 VDD VDD VSS VSS gf180mcu_as_sc_mcu7t3v3__fill_1
XTAP_TAPCELL_ROW_151_1_1899 VDD VSS gf180mcu_as_sc_mcu7t3v3__tap_2
XFILLER_34_457 VDD VDD VSS VSS gf180mcu_as_sc_mcu7t3v3__fillcap_16
XFILLER_35_969 VDD VDD VSS VSS gf180mcu_as_sc_mcu7t3v3__fillcap_8
XFILLER_188_941 VDD VDD VSS VSS gf180mcu_as_sc_mcu7t3v3__fillcap_4
XFILLER_203_750 VDD VDD VSS VSS gf180mcu_as_sc_mcu7t3v3__fillcap_16
XFILLER_210_709 VDD VDD VSS VSS gf180mcu_as_sc_mcu7t3v3__fill_1
XFILLER_76_1393 VDD VDD VSS VSS gf180mcu_as_sc_mcu7t3v3__fill_1
X_2981_ VDD VDD VSS VSS _3962_/A _3005_/A _2981_/C _2981_/Y _3594_/D gf180mcu_as_sc_mcu7t3v3__aoi211_2
XFILLER_128_1483 VDD VDD VSS VSS gf180mcu_as_sc_mcu7t3v3__fillcap_8
XFILLER_159_153 VDD VDD VSS VSS gf180mcu_as_sc_mcu7t3v3__fillcap_16
XFILLER_188_963 VDD VDD VSS VSS gf180mcu_as_sc_mcu7t3v3__fillcap_16
XFILLER_203_772 VDD VDD VSS VSS gf180mcu_as_sc_mcu7t3v3__fillcap_16
X_4720_ VDD VDD VSS VSS _4730_/B _4721_/B _4733_/C gf180mcu_as_sc_mcu7t3v3__nor2_2
XTAP_TAPCELL_ROW_177_2076 VDD VSS gf180mcu_as_sc_mcu7t3v3__tap_2
XTAP_TAPCELL_ROW_177_2065 VDD VSS gf180mcu_as_sc_mcu7t3v3__tap_2
XFILLER_174_112 VDD VDD VSS VSS gf180mcu_as_sc_mcu7t3v3__fillcap_4
XFILLER_175_624 VDD VDD VSS VSS gf180mcu_as_sc_mcu7t3v3__fillcap_4
XFILLER_198_1415 VDD VDD VSS VSS gf180mcu_as_sc_mcu7t3v3__fillcap_16
X_4651_ VDD VDD VSS VSS _4659_/B _4651_/B _5236_/Q _5236_/D gf180mcu_as_sc_mcu7t3v3__mux2_2
XFILLER_198_1437 VDD VDD VSS VSS gf180mcu_as_sc_mcu7t3v3__fillcap_16
Xinput20 VDD VDD VSS VSS boot_mode _4952_/D gf180mcu_as_sc_mcu7t3v3__buff_12
Xinput31 VDD VDD VSS VSS dft_addr[8] _2672_/B gf180mcu_as_sc_mcu7t3v3__buff_12
X_3602_ VDD VDD VSS VSS _3656_/C _3973_/D _3604_/C gf180mcu_as_sc_mcu7t3v3__and2_2
XFILLER_174_167 VDD VDD VSS VSS gf180mcu_as_sc_mcu7t3v3__fill_2
Xinput42 VDD VDD VSS VSS dft_wdata[7] _2737_/B gf180mcu_as_sc_mcu7t3v3__buff_12
Xinput53 VDD VDD VSS VSS east_in[18] wire852/A gf180mcu_as_sc_mcu7t3v3__buff_12
Xinput64 VDD VDD VSS VSS east_in[28] wire842/A gf180mcu_as_sc_mcu7t3v3__buff_12
X_4582_ VDD VDD VSS VSS _4583_/D _4582_/B _4582_/A gf180mcu_as_sc_mcu7t3v3__nor2_2
XFILLER_115_212 VDD VDD VSS VSS gf180mcu_as_sc_mcu7t3v3__fillcap_8
Xinput75 VDD VDD VSS VSS east_in[7] _3991_/A gf180mcu_as_sc_mcu7t3v3__buff_12
Xinput86 VDD VDD VSS VSS ne_in[17] _4069_/A gf180mcu_as_sc_mcu7t3v3__buff_12
Xinput97 VDD VDD VSS VSS ne_in[27] _4154_/D gf180mcu_as_sc_mcu7t3v3__buff_12
X_3533_ VDD VDD VSS VSS _3533_/A _3533_/B _3533_/C _3563_/A gf180mcu_as_sc_mcu7t3v3__nand3_2
XFILLER_6_391 VDD VDD VSS VSS gf180mcu_as_sc_mcu7t3v3__fill_2
X_3464_ VDD VDD VSS VSS _3479_/C _4121_/A _3466_/C gf180mcu_as_sc_mcu7t3v3__and2_2
XFILLER_130_215 VDD VDD VSS VSS gf180mcu_as_sc_mcu7t3v3__fillcap_4
XFILLER_88_107 VDD VDD VSS VSS gf180mcu_as_sc_mcu7t3v3__fillcap_16
X_5203_ VDD VDD VSS VSS _5216_/CLK _5203_/D _5203_/Q gf180mcu_as_sc_mcu7t3v3__dfxtp_2
X_2415_ VDD VDD VSS VSS _4750_/A _5278_/Q gf180mcu_as_sc_mcu7t3v3__inv_2
X_5134_ VDD VDD VSS VSS _5198_/CLK _5134_/D _5134_/Q gf180mcu_as_sc_mcu7t3v3__dfxtp_2
X_3395_ VDD VDD VSS VSS _4047_/A _3449_/B _3395_/C _3395_/D _3396_/A gf180mcu_as_sc_mcu7t3v3__ao211_2
XFILLER_44_1348 VDD VDD VSS VSS gf180mcu_as_sc_mcu7t3v3__fillcap_4
XTAP_TAPCELL_ROW_209_2765 VDD VSS gf180mcu_as_sc_mcu7t3v3__tap_2
XFILLER_123_39 VDD VDD VSS VSS gf180mcu_as_sc_mcu7t3v3__fill_1
X_5065_ VDD VDD VSS VSS _5068_/CLK _5065_/D _5065_/Q gf180mcu_as_sc_mcu7t3v3__dfxtp_2
XTAP_TAPCELL_ROW_209_2776 VDD VSS gf180mcu_as_sc_mcu7t3v3__tap_2
X_4016_ VDD VDD VSS VSS _4016_/A _4104_/B _4104_/C _4016_/D _4017_/D gf180mcu_as_sc_mcu7t3v3__ao22_2
XFILLER_203_50 VDD VDD VSS VSS gf180mcu_as_sc_mcu7t3v3__fillcap_16
XFILLER_203_72 VDD VDD VSS VSS gf180mcu_as_sc_mcu7t3v3__fillcap_16
XFILLER_26_947 VDD VDD VSS VSS gf180mcu_as_sc_mcu7t3v3__fillcap_16
XFILLER_16_37 VDD VDD VSS VSS gf180mcu_as_sc_mcu7t3v3__fillcap_16
XFILLER_20_1392 VDD VDD VSS VSS gf180mcu_as_sc_mcu7t3v3__fillcap_16
XFILLER_25_446 VDD VDD VSS VSS gf180mcu_as_sc_mcu7t3v3__fillcap_16
XFILLER_12_107 VDD VDD VSS VSS gf180mcu_as_sc_mcu7t3v3__fillcap_16
XTAP_TAPCELL_ROW_68_1_1650 VDD VSS gf180mcu_as_sc_mcu7t3v3__tap_2
X_4918_ VDD VDD VSS VSS _4919_/CLK _4918_/D _4918_/Q gf180mcu_as_sc_mcu7t3v3__dfxtp_2
XFILLER_107_1545 VDD VDD VSS VSS gf180mcu_as_sc_mcu7t3v3__fillcap_8
XFILLER_142_1425 VDD VDD VSS VSS gf180mcu_as_sc_mcu7t3v3__fillcap_8
XFILLER_142_1447 VDD VDD VSS VSS gf180mcu_as_sc_mcu7t3v3__fillcap_4
XFILLER_55_1488 VDD VDD VSS VSS gf180mcu_as_sc_mcu7t3v3__fillcap_16
XFILLER_142_1469 VDD VDD VSS VSS gf180mcu_as_sc_mcu7t3v3__fill_2
XFILLER_32_69 VDD VDD VSS VSS gf180mcu_as_sc_mcu7t3v3__fillcap_8
X_4849_ VDD VDD VSS VSS _5256_/CLK _4849_/D _4849_/Q gf180mcu_as_sc_mcu7t3v3__dfxtp_2
XTAP_TAPCELL_ROW_78_3_2956 VDD VSS gf180mcu_as_sc_mcu7t3v3__tap_2
XFILLER_175_1256 VDD VDD VSS VSS gf180mcu_as_sc_mcu7t3v3__fillcap_4
XFILLER_0_512 VDD VDD VSS VSS gf180mcu_as_sc_mcu7t3v3__fillcap_4
XPHY_EDGE_ROW_77_1_Right_598 VDD VSS gf180mcu_as_sc_mcu7t3v3__tap_2
XFILLER_180_34 VDD VDD VSS VSS gf180mcu_as_sc_mcu7t3v3__fill_1
XFILLER_29_730 VDD VDD VSS VSS gf180mcu_as_sc_mcu7t3v3__fill_2
XTAP_TAPCELL_ROW_41_1_1568 VDD VSS gf180mcu_as_sc_mcu7t3v3__tap_2
XFILLER_57_99 VDD VDD VSS VSS gf180mcu_as_sc_mcu7t3v3__fillcap_16
XFILLER_113_72 VDD VDD VSS VSS gf180mcu_as_sc_mcu7t3v3__fillcap_16
XFILLER_17_947 VDD VDD VSS VSS gf180mcu_as_sc_mcu7t3v3__fillcap_16
XFILLER_113_94 VDD VDD VSS VSS gf180mcu_as_sc_mcu7t3v3__fill_1
XFILLER_16_435 VDD VDD VSS VSS gf180mcu_as_sc_mcu7t3v3__fillcap_16
XFILLER_16_457 VDD VDD VSS VSS gf180mcu_as_sc_mcu7t3v3__fillcap_8
XFILLER_182_1205 VDD VDD VSS VSS gf180mcu_as_sc_mcu7t3v3__fillcap_16
XFILLER_73_32 VDD VDD VSS VSS gf180mcu_as_sc_mcu7t3v3__fill_1
XFILLER_182_1227 VDD VDD VSS VSS gf180mcu_as_sc_mcu7t3v3__fillcap_16
XFILLER_189_54 VDD VDD VSS VSS gf180mcu_as_sc_mcu7t3v3__fillcap_16
XFILLER_31_416 VDD VDD VSS VSS gf180mcu_as_sc_mcu7t3v3__fillcap_4
XFILLER_19_1052 VDD VDD VSS VSS gf180mcu_as_sc_mcu7t3v3__fillcap_16
XFILLER_34_1517 VDD VDD VSS VSS gf180mcu_as_sc_mcu7t3v3__fill_2
XFILLER_73_1566 VDD VDD VSS VSS gf180mcu_as_sc_mcu7t3v3__fill_2
XFILLER_156_101 VDD VDD VSS VSS gf180mcu_as_sc_mcu7t3v3__fillcap_4
XFILLER_185_944 VDD VDD VSS VSS gf180mcu_as_sc_mcu7t3v3__fillcap_16
XFILLER_19_1096 VDD VDD VSS VSS gf180mcu_as_sc_mcu7t3v3__fillcap_16
XFILLER_200_731 VDD VDD VSS VSS gf180mcu_as_sc_mcu7t3v3__fillcap_4
XPHY_EDGE_ROW_70_1_Left_280 VDD VSS gf180mcu_as_sc_mcu7t3v3__tap_2
XFILLER_184_454 VDD VDD VSS VSS gf180mcu_as_sc_mcu7t3v3__fill_1
XFILLER_196_292 VDD VDD VSS VSS gf180mcu_as_sc_mcu7t3v3__fillcap_16
XFILLER_200_753 VDD VDD VSS VSS gf180mcu_as_sc_mcu7t3v3__fillcap_16
XTAP_TAPCELL_ROW_26_1297 VDD VSS gf180mcu_as_sc_mcu7t3v3__tap_2
XFILLER_11_195 VDD VDD VSS VSS gf180mcu_as_sc_mcu7t3v3__fillcap_8
XFILLER_171_104 VDD VDD VSS VSS gf180mcu_as_sc_mcu7t3v3__fillcap_8
XFILLER_8_667 VDD VDD VSS VSS gf180mcu_as_sc_mcu7t3v3__fillcap_4
XPHY_EDGE_ROW_109_3_Left_494 VDD VSS gf180mcu_as_sc_mcu7t3v3__tap_2
XFILLER_4_873 VDD VDD VSS VSS gf180mcu_as_sc_mcu7t3v3__fill_2
XFILLER_26_1012 VDD VDD VSS VSS gf180mcu_as_sc_mcu7t3v3__fill_2
XPHY_EDGE_ROW_46_3_Left_431 VDD VSS gf180mcu_as_sc_mcu7t3v3__tap_2
X_3180_ VDD VDD VSS VSS _4155_/A _3241_/B _3180_/C _3180_/D _3181_/C gf180mcu_as_sc_mcu7t3v3__ao22_2
XFILLER_187_1116 VDD VDD VSS VSS gf180mcu_as_sc_mcu7t3v3__fillcap_4
XFILLER_187_1138 VDD VDD VSS VSS gf180mcu_as_sc_mcu7t3v3__fillcap_16
XFILLER_19_240 VDD VDD VSS VSS gf180mcu_as_sc_mcu7t3v3__fill_2
XFILLER_207_352 VDD VDD VSS VSS gf180mcu_as_sc_mcu7t3v3__fillcap_16
XTAP_TAPCELL_ROW_204_2651 VDD VSS gf180mcu_as_sc_mcu7t3v3__tap_2
XTAP_TAPCELL_ROW_179_2105 VDD VSS gf180mcu_as_sc_mcu7t3v3__tap_2
XPHY_EDGE_ROW_39_1_Right_560 VDD VSS gf180mcu_as_sc_mcu7t3v3__tap_2
XTAP_TAPCELL_ROW_204_2662 VDD VSS gf180mcu_as_sc_mcu7t3v3__tap_2
XTAP_TAPCELL_ROW_179_2116 VDD VSS gf180mcu_as_sc_mcu7t3v3__tap_2
XFILLER_207_396 VDD VDD VSS VSS gf180mcu_as_sc_mcu7t3v3__fillcap_16
XFILLER_23_928 VDD VDD VSS VSS gf180mcu_as_sc_mcu7t3v3__fill_2
X_2964_ VDD VDD VSS VSS _3594_/D _3115_/A _2964_/B _2964_/C _2965_/C gf180mcu_as_sc_mcu7t3v3__ao31_2
XTAP_TAPCELL_ROW_196_2485 VDD VSS gf180mcu_as_sc_mcu7t3v3__tap_2
XTAP_TAPCELL_ROW_196_2474 VDD VSS gf180mcu_as_sc_mcu7t3v3__tap_2
XFILLER_210_539 VDD VDD VSS VSS gf180mcu_as_sc_mcu7t3v3__fill_1
X_4703_ VDD VDD VSS VSS _4703_/A _4703_/B _5222_/Q _4703_/D _4705_/B gf180mcu_as_sc_mcu7t3v3__ao211_2
XFILLER_33_1049 VDD VDD VSS VSS gf180mcu_as_sc_mcu7t3v3__fill_1
X_2895_ VDD VDD VSS VSS _3533_/C _3257_/A _3223_/B gf180mcu_as_sc_mcu7t3v3__and2_2
XFILLER_11_1314 VDD VDD VSS VSS gf180mcu_as_sc_mcu7t3v3__fillcap_16
XFILLER_141_1480 VDD VDD VSS VSS gf180mcu_as_sc_mcu7t3v3__fillcap_4
XFILLER_15_1472 VDD VDD VSS VSS gf180mcu_as_sc_mcu7t3v3__fill_2
X_4634_ VDD VDD VSS VSS _4725_/B _5122_/Q _4684_/A _5225_/D gf180mcu_as_sc_mcu7t3v3__mux2_2
XFILLER_102_1453 VDD VDD VSS VSS gf180mcu_as_sc_mcu7t3v3__fillcap_16
XFILLER_200_1065 VDD VDD VSS VSS gf180mcu_as_sc_mcu7t3v3__fillcap_16
X_4565_ VDD VDD VSS VSS _5185_/Q _4574_/B _4565_/C _4565_/D _5185_/D gf180mcu_as_sc_mcu7t3v3__ao211_2
XFILLER_176_1543 VDD VDD VSS VSS gf180mcu_as_sc_mcu7t3v3__fill_1
XFILLER_190_457 VDD VDD VSS VSS gf180mcu_as_sc_mcu7t3v3__fillcap_16
XFILLER_200_1087 VDD VDD VSS VSS gf180mcu_as_sc_mcu7t3v3__fillcap_16
XTAP_TAPCELL_ROW_153_3_3180 VDD VSS gf180mcu_as_sc_mcu7t3v3__tap_2
X_3516_ VDD VDD VSS VSS _3516_/B _3525_/A _4836_/D gf180mcu_as_sc_mcu7t3v3__and2_2
XPHY_EDGE_ROW_4_Right_4 VDD VSS gf180mcu_as_sc_mcu7t3v3__tap_2
X_4496_ VDD VDD VSS VSS _5179_/Q _4554_/B _4540_/C _5113_/Q _4497_/B gf180mcu_as_sc_mcu7t3v3__ao22_2
X_3447_ VDD VDD VSS VSS _4099_/A _3477_/B _3447_/C _4825_/D _3608_/D gf180mcu_as_sc_mcu7t3v3__aoi211_2
XFILLER_134_49 VDD VDD VSS VSS gf180mcu_as_sc_mcu7t3v3__fill_1
X_3378_ VDD VDD VSS VSS _4927_/Q _3448_/B _3448_/C _4029_/A _3379_/A gf180mcu_as_sc_mcu7t3v3__ao22_2
X_5117_ VDD VDD VSS VSS clkload9/A _5117_/D _5117_/Q gf180mcu_as_sc_mcu7t3v3__dfxtp_2
XFILLER_61_1492 VDD VDD VSS VSS gf180mcu_as_sc_mcu7t3v3__fill_2
X_5048_ VDD VDD VSS VSS clkload5/A _5048_/D _5048_/Q gf180mcu_as_sc_mcu7t3v3__dfxtp_2
XFILLER_150_37 VDD VDD VSS VSS gf180mcu_as_sc_mcu7t3v3__fillcap_8
XFILLER_22_1476 VDD VDD VSS VSS gf180mcu_as_sc_mcu7t3v3__fill_1
XFILLER_22_1487 VDD VDD VSS VSS gf180mcu_as_sc_mcu7t3v3__fillcap_16
XFILLER_27_47 VDD VDD VSS VSS gf180mcu_as_sc_mcu7t3v3__fill_2
XFILLER_27_69 VDD VDD VSS VSS gf180mcu_as_sc_mcu7t3v3__fill_1
XFILLER_26_733 VDD VDD VSS VSS gf180mcu_as_sc_mcu7t3v3__fill_2
XFILLER_207_1208 VDD VDD VSS VSS gf180mcu_as_sc_mcu7t3v3__fillcap_16
XFILLER_25_276 VDD VDD VSS VSS gf180mcu_as_sc_mcu7t3v3__fillcap_4
XFILLER_13_438 VDD VDD VSS VSS gf180mcu_as_sc_mcu7t3v3__fill_2
XFILLER_146_1380 VDD VDD VSS VSS gf180mcu_as_sc_mcu7t3v3__fill_1
XFILLER_181_1282 VDD VDD VSS VSS gf180mcu_as_sc_mcu7t3v3__fill_1
XFILLER_185_207 VDD VDD VSS VSS gf180mcu_as_sc_mcu7t3v3__fill_2
XFILLER_107_1364 VDD VDD VSS VSS gf180mcu_as_sc_mcu7t3v3__fillcap_8
XFILLER_138_123 VDD VDD VSS VSS gf180mcu_as_sc_mcu7t3v3__fillcap_16
XFILLER_120_1520 VDD VDD VSS VSS gf180mcu_as_sc_mcu7t3v3__fill_1
XFILLER_182_925 VDD VDD VSS VSS gf180mcu_as_sc_mcu7t3v3__fillcap_16
XFILLER_194_785 VDD VDD VSS VSS gf180mcu_as_sc_mcu7t3v3__fillcap_16
XFILLER_153_137 VDD VDD VSS VSS gf180mcu_as_sc_mcu7t3v3__fill_2
XFILLER_182_947 VDD VDD VSS VSS gf180mcu_as_sc_mcu7t3v3__fillcap_16
XFILLER_5_615 VDD VDD VSS VSS gf180mcu_as_sc_mcu7t3v3__fill_2
XFILLER_104_2 VDD VDD VSS VSS gf180mcu_as_sc_mcu7t3v3__fill_2
XFILLER_181_479 VDD VDD VSS VSS gf180mcu_as_sc_mcu7t3v3__fill_1
XTAP_TAPCELL_ROW_21_1194 VDD VSS gf180mcu_as_sc_mcu7t3v3__tap_2
XTAP_TAPCELL_ROW_21_1183 VDD VSS gf180mcu_as_sc_mcu7t3v3__tap_2
XFILLER_190_1507 VDD VDD VSS VSS gf180mcu_as_sc_mcu7t3v3__fillcap_16
XFILLER_4_18 VDD VDD VSS VSS gf180mcu_as_sc_mcu7t3v3__fillcap_16
XTAP_TAPCELL_ROW_9_932 VDD VSS gf180mcu_as_sc_mcu7t3v3__tap_2
XTAP_TAPCELL_ROW_9_921 VDD VSS gf180mcu_as_sc_mcu7t3v3__tap_2
XFILLER_27_1310 VDD VDD VSS VSS gf180mcu_as_sc_mcu7t3v3__fillcap_16
XPHY_EDGE_ROW_78_1_Right_599 VDD VSS gf180mcu_as_sc_mcu7t3v3__tap_2
XFILLER_0_342 VDD VDD VSS VSS gf180mcu_as_sc_mcu7t3v3__fillcap_4
XFILLER_27_1332 VDD VDD VSS VSS gf180mcu_as_sc_mcu7t3v3__fillcap_16
Xinput210 VDD VDD VSS VSS se_in[5] wire869/A gf180mcu_as_sc_mcu7t3v3__buff_12
XFILLER_191_66 VDD VDD VSS VSS gf180mcu_as_sc_mcu7t3v3__fillcap_4
XFILLER_191_88 VDD VDD VSS VSS gf180mcu_as_sc_mcu7t3v3__fillcap_16
Xinput221 VDD VDD VSS VSS south_in[15] _4053_/D gf180mcu_as_sc_mcu7t3v3__buff_12
Xinput232 VDD VDD VSS VSS south_in[25] _4138_/D gf180mcu_as_sc_mcu7t3v3__buff_12
Xinput243 VDD VDD VSS VSS south_in[4] _3968_/D gf180mcu_as_sc_mcu7t3v3__buff_12
Xinput254 VDD VDD VSS VSS sw_in[14] _4050_/A gf180mcu_as_sc_mcu7t3v3__buff_12
XFILLER_124_82 VDD VDD VSS VSS gf180mcu_as_sc_mcu7t3v3__fillcap_8
Xinput265 VDD VDD VSS VSS sw_in[24] _2446_/A gf180mcu_as_sc_mcu7t3v3__buff_12
Xinput276 VDD VDD VSS VSS sw_in[3] _2426_/A gf180mcu_as_sc_mcu7t3v3__buff_12
Xinput287 VDD VDD VSS VSS west_in[13] _4037_/D gf180mcu_as_sc_mcu7t3v3__buff_12
XFILLER_188_1469 VDD VDD VSS VSS gf180mcu_as_sc_mcu7t3v3__fill_2
XFILLER_84_64 VDD VDD VSS VSS gf180mcu_as_sc_mcu7t3v3__fillcap_16
Xinput298 VDD VDD VSS VSS west_in[23] _4118_/D gf180mcu_as_sc_mcu7t3v3__buff_12
XFILLER_204_311 VDD VDD VSS VSS gf180mcu_as_sc_mcu7t3v3__fillcap_4
XFILLER_75_198 VDD VDD VSS VSS gf180mcu_as_sc_mcu7t3v3__fill_2
XFILLER_84_86 VDD VDD VSS VSS gf180mcu_as_sc_mcu7t3v3__fill_1
XFILLER_84_97 VDD VDD VSS VSS gf180mcu_as_sc_mcu7t3v3__fillcap_8
XFILLER_17_788 VDD VDD VSS VSS gf180mcu_as_sc_mcu7t3v3__fillcap_16
XFILLER_189_535 VDD VDD VSS VSS gf180mcu_as_sc_mcu7t3v3__fillcap_16
XFILLER_204_333 VDD VDD VSS VSS gf180mcu_as_sc_mcu7t3v3__fillcap_16
XFILLER_210_18 VDD VDD VSS VSS gf180mcu_as_sc_mcu7t3v3__fillcap_16
XFILLER_90_168 VDD VDD VSS VSS gf180mcu_as_sc_mcu7t3v3__fillcap_4
XTAP_TAPCELL_ROW_28_1337 VDD VSS gf180mcu_as_sc_mcu7t3v3__tap_2
XFILLER_140_81 VDD VDD VSS VSS gf180mcu_as_sc_mcu7t3v3__fillcap_4
XFILLER_31_224 VDD VDD VSS VSS gf180mcu_as_sc_mcu7t3v3__fillcap_16
XTAP_TAPCELL_ROW_146_1_1883 VDD VSS gf180mcu_as_sc_mcu7t3v3__tap_2
XTAP_TAPCELL_ROW_28_1348 VDD VSS gf180mcu_as_sc_mcu7t3v3__tap_2
XTAP_TAPCELL_ROW_158_3_3195 VDD VSS gf180mcu_as_sc_mcu7t3v3__tap_2
XTAP_TAPCELL_ROW_174_2002 VDD VSS gf180mcu_as_sc_mcu7t3v3__tap_2
X_2680_ VDD VDD VSS VSS _2732_/S _4957_/Q _4966_/Q _2683_/A gf180mcu_as_sc_mcu7t3v3__mux2_2
XTAP_TAPCELL_ROW_191_2371 VDD VSS gf180mcu_as_sc_mcu7t3v3__tap_2
XFILLER_129_178 VDD VDD VSS VSS gf180mcu_as_sc_mcu7t3v3__fillcap_4
XFILLER_195_1418 VDD VDD VSS VSS gf180mcu_as_sc_mcu7t3v3__fillcap_16
XTAP_TAPCELL_ROW_191_2382 VDD VSS gf180mcu_as_sc_mcu7t3v3__tap_2
XFILLER_201_1396 VDD VDD VSS VSS gf180mcu_as_sc_mcu7t3v3__fillcap_4
X_4350_ VDD VDD VSS VSS _4350_/A _5479_/A _4350_/C _4350_/D _4351_/A gf180mcu_as_sc_mcu7t3v3__ao22_2
X_3301_ VDD VDD VSS VSS _3952_/A _3382_/C _3301_/C _3301_/D _3302_/B gf180mcu_as_sc_mcu7t3v3__ao211_2
XFILLER_193_1186 VDD VDD VSS VSS gf180mcu_as_sc_mcu7t3v3__fillcap_4
X_4281_ VDD VDD VSS VSS _4281_/S _5485_/A _5115_/Q _5115_/D gf180mcu_as_sc_mcu7t3v3__mux2_2
XTAP_TAPCELL_ROW_41_3_2843 VDD VSS gf180mcu_as_sc_mcu7t3v3__tap_2
X_3232_ VDD VDD VSS VSS _3232_/B _3907_/A _4802_/D gf180mcu_as_sc_mcu7t3v3__and2_2
XFILLER_132_1435 VDD VDD VSS VSS gf180mcu_as_sc_mcu7t3v3__fillcap_16
X_3163_ VDD VDD VSS VSS _4139_/A _3163_/B _3163_/C _3163_/D _3164_/C gf180mcu_as_sc_mcu7t3v3__ao22_2
XTAP_TAPCELL_ROW_206_2702 VDD VSS gf180mcu_as_sc_mcu7t3v3__tap_2
XTAP_TAPCELL_ROW_206_2713 VDD VSS gf180mcu_as_sc_mcu7t3v3__tap_2
XFILLER_81_102 VDD VDD VSS VSS gf180mcu_as_sc_mcu7t3v3__fillcap_16
X_3094_ VDD VDD VSS VSS _3145_/A _3094_/B _3094_/C _3145_/D _3095_/D gf180mcu_as_sc_mcu7t3v3__ao211_2
XFILLER_208_661 VDD VDD VSS VSS gf180mcu_as_sc_mcu7t3v3__fillcap_4
XFILLER_208_683 VDD VDD VSS VSS gf180mcu_as_sc_mcu7t3v3__fillcap_16
XTAP_TAPCELL_ROW_198_2536 VDD VSS gf180mcu_as_sc_mcu7t3v3__tap_2
XTAP_TAPCELL_ROW_198_2525 VDD VSS gf180mcu_as_sc_mcu7t3v3__tap_2
XFILLER_208_1539 VDD VDD VSS VSS gf180mcu_as_sc_mcu7t3v3__fillcap_16
XFILLER_91_1430 VDD VDD VSS VSS gf180mcu_as_sc_mcu7t3v3__fill_1
XFILLER_17_1512 VDD VDD VSS VSS gf180mcu_as_sc_mcu7t3v3__fill_2
XFILLER_210_314 VDD VDD VSS VSS gf180mcu_as_sc_mcu7t3v3__fill_1
XFILLER_23_769 VDD VDD VSS VSS gf180mcu_as_sc_mcu7t3v3__fill_1
X_3996_ VDD VDD VSS VSS _4985_/Q _4158_/B _4236_/B _4117_/D _4985_/D gf180mcu_as_sc_mcu7t3v3__ao22_2
XFILLER_13_27 VDD VDD VSS VSS gf180mcu_as_sc_mcu7t3v3__fillcap_16
XFILLER_31_780 VDD VDD VSS VSS gf180mcu_as_sc_mcu7t3v3__fillcap_4
XFILLER_91_1485 VDD VDD VSS VSS gf180mcu_as_sc_mcu7t3v3__fill_1
X_2947_ VDD VDD VSS VSS _2947_/Y _2947_/B _2947_/A gf180mcu_as_sc_mcu7t3v3__nor2_2
XFILLER_129_27 VDD VDD VSS VSS gf180mcu_as_sc_mcu7t3v3__fillcap_16
XFILLER_52_1469 VDD VDD VSS VSS gf180mcu_as_sc_mcu7t3v3__fill_2
XFILLER_11_1122 VDD VDD VSS VSS gf180mcu_as_sc_mcu7t3v3__fillcap_16
X_4617_ VDD VDD VSS VSS _5211_/Q _4624_/B _4620_/C _5212_/Q _5211_/D gf180mcu_as_sc_mcu7t3v3__ao22_2
X_2878_ VDD VDD VSS VSS _5265_/Q _5264_/Q _5266_/Q _2879_/B gf180mcu_as_sc_mcu7t3v3__nor3_2
XFILLER_190_243 VDD VDD VSS VSS gf180mcu_as_sc_mcu7t3v3__fill_2
XFILLER_191_766 VDD VDD VSS VSS gf180mcu_as_sc_mcu7t3v3__fillcap_4
XTAP_TAPCELL_ROW_172_1_1962 VDD VSS gf180mcu_as_sc_mcu7t3v3__tap_2
XFILLER_150_118 VDD VDD VSS VSS gf180mcu_as_sc_mcu7t3v3__fillcap_16
XFILLER_191_788 VDD VDD VSS VSS gf180mcu_as_sc_mcu7t3v3__fillcap_16
XTAP_TAPCELL_ROW_102_3_3027 VDD VSS gf180mcu_as_sc_mcu7t3v3__tap_2
X_4548_ VDD VDD VSS VSS _5183_/Q _4574_/B _4548_/C _4548_/D _5183_/D gf180mcu_as_sc_mcu7t3v3__ao211_2
XFILLER_145_59 VDD VDD VSS VSS gf180mcu_as_sc_mcu7t3v3__fillcap_8
X_4479_ VDD VDD VSS VSS _5177_/Q _4493_/B _4479_/C _5111_/Q _4480_/B gf180mcu_as_sc_mcu7t3v3__ao22_2
XFILLER_150_1535 VDD VDD VSS VSS gf180mcu_as_sc_mcu7t3v3__fillcap_4
XFILLER_150_1568 VDD VDD VSS VSS gf180mcu_as_sc_mcu7t3v3__fill_1
XFILLER_180_6 VDD VDD VSS VSS gf180mcu_as_sc_mcu7t3v3__fillcap_16
Xhold1120 VDD VDD VSS VSS hold1145/Y _4958_/D gf180mcu_as_sc_mcu7t3v3__clkbuff_4
Xhold1131 VDD VDD VSS VSS _5096_/Q _4258_/C gf180mcu_as_sc_mcu7t3v3__clkbuff_4
Xhold1142 VDD VDD VSS VSS _4962_/Q hold1142/Y gf180mcu_as_sc_mcu7t3v3__clkbuff_4
XFILLER_57_154 VDD VDD VSS VSS gf180mcu_as_sc_mcu7t3v3__fill_1
XFILLER_57_187 VDD VDD VSS VSS gf180mcu_as_sc_mcu7t3v3__fillcap_16
XFILLER_22_1262 VDD VDD VSS VSS gf180mcu_as_sc_mcu7t3v3__fillcap_8
XFILLER_72_135 VDD VDD VSS VSS gf180mcu_as_sc_mcu7t3v3__fill_1
XFILLER_148_1453 VDD VDD VSS VSS gf180mcu_as_sc_mcu7t3v3__fillcap_8
XFILLER_187_1491 VDD VDD VSS VSS gf180mcu_as_sc_mcu7t3v3__fillcap_4
XFILLER_16_1000 VDD VDD VSS VSS gf180mcu_as_sc_mcu7t3v3__fillcap_8
XFILLER_183_1399 VDD VDD VSS VSS gf180mcu_as_sc_mcu7t3v3__fill_1
XFILLER_186_527 VDD VDD VSS VSS gf180mcu_as_sc_mcu7t3v3__fillcap_8
XFILLER_198_387 VDD VDD VSS VSS gf180mcu_as_sc_mcu7t3v3__fill_2
XFILLER_201_314 VDD VDD VSS VSS gf180mcu_as_sc_mcu7t3v3__fillcap_16
XFILLER_9_217 VDD VDD VSS VSS gf180mcu_as_sc_mcu7t3v3__fillcap_8
XTAP_TAPCELL_ROW_23_1234 VDD VSS gf180mcu_as_sc_mcu7t3v3__tap_2
XFILLER_186_22 VDD VDD VSS VSS gf180mcu_as_sc_mcu7t3v3__fillcap_8
XFILLER_210_881 VDD VDD VSS VSS gf180mcu_as_sc_mcu7t3v3__fill_2
XTAP_TAPCELL_ROW_46_3_2858 VDD VSS gf180mcu_as_sc_mcu7t3v3__tap_2
XTAP_TAPCELL_ROW_23_1245 VDD VSS gf180mcu_as_sc_mcu7t3v3__tap_2
XFILLER_10_975 VDD VDD VSS VSS gf180mcu_as_sc_mcu7t3v3__fillcap_4
XFILLER_126_104 VDD VDD VSS VSS gf180mcu_as_sc_mcu7t3v3__fill_1
XFILLER_126_148 VDD VDD VSS VSS gf180mcu_as_sc_mcu7t3v3__fillcap_16
XFILLER_6_968 VDD VDD VSS VSS gf180mcu_as_sc_mcu7t3v3__fillcap_16
XFILLER_155_1413 VDD VDD VSS VSS gf180mcu_as_sc_mcu7t3v3__fill_2
XFILLER_181_276 VDD VDD VSS VSS gf180mcu_as_sc_mcu7t3v3__fillcap_4
XFILLER_5_478 VDD VDD VSS VSS gf180mcu_as_sc_mcu7t3v3__fillcap_4
XFILLER_79_31 VDD VDD VSS VSS gf180mcu_as_sc_mcu7t3v3__fill_2
XPHY_EDGE_ROW_101_1_Left_311 VDD VSS gf180mcu_as_sc_mcu7t3v3__tap_2
XFILLER_134_181 VDD VDD VSS VSS gf180mcu_as_sc_mcu7t3v3__fill_2
XFILLER_205_18 VDD VDD VSS VSS gf180mcu_as_sc_mcu7t3v3__fillcap_16
XFILLER_0_172 VDD VDD VSS VSS gf180mcu_as_sc_mcu7t3v3__fillcap_4
XFILLER_27_1173 VDD VDD VSS VSS gf180mcu_as_sc_mcu7t3v3__fill_2
XFILLER_23_1026 VDD VDD VSS VSS gf180mcu_as_sc_mcu7t3v3__fillcap_4
XFILLER_7_1278 VDD VDD VSS VSS gf180mcu_as_sc_mcu7t3v3__fill_1
XFILLER_36_316 VDD VDD VSS VSS gf180mcu_as_sc_mcu7t3v3__fillcap_4
XFILLER_184_1119 VDD VDD VSS VSS gf180mcu_as_sc_mcu7t3v3__fillcap_16
XFILLER_36_338 VDD VDD VSS VSS gf180mcu_as_sc_mcu7t3v3__fill_2
XFILLER_63_113 VDD VDD VSS VSS gf180mcu_as_sc_mcu7t3v3__fill_2
XFILLER_166_1531 VDD VDD VSS VSS gf180mcu_as_sc_mcu7t3v3__fillcap_4
XFILLER_17_552 VDD VDD VSS VSS gf180mcu_as_sc_mcu7t3v3__fill_1
XFILLER_75_1414 VDD VDD VSS VSS gf180mcu_as_sc_mcu7t3v3__fill_2
XFILLER_127_1526 VDD VDD VSS VSS gf180mcu_as_sc_mcu7t3v3__fillcap_4
XFILLER_189_343 VDD VDD VSS VSS gf180mcu_as_sc_mcu7t3v3__fillcap_4
XFILLER_205_664 VDD VDD VSS VSS gf180mcu_as_sc_mcu7t3v3__fillcap_16
XFILLER_75_1469 VDD VDD VSS VSS gf180mcu_as_sc_mcu7t3v3__fill_1
X_3850_ VDD VDD VSS VSS _3850_/A _5156_/Q _3850_/C _3851_/C gf180mcu_as_sc_mcu7t3v3__nand3_2
XTAP_TAPCELL_ROW_193_2422 VDD VSS gf180mcu_as_sc_mcu7t3v3__tap_2
XTAP_TAPCELL_ROW_193_2411 VDD VSS gf180mcu_as_sc_mcu7t3v3__tap_2
XFILLER_32_588 VDD VDD VSS VSS gf180mcu_as_sc_mcu7t3v3__fillcap_4
XFILLER_81_4 VDD VDD VSS VSS gf180mcu_as_sc_mcu7t3v3__fill_1
X_3781_ VDD VDD VSS VSS _3781_/S _3781_/B _3781_/A _3783_/C gf180mcu_as_sc_mcu7t3v3__mux2_2
X_2801_ VDD VDD VSS VSS _4637_/A _5245_/Q _4754_/Q _2805_/A gf180mcu_as_sc_mcu7t3v3__mux2_2
X_2732_ VDD VDD VSS VSS _2732_/S _4964_/Q _4973_/Q _2734_/A gf180mcu_as_sc_mcu7t3v3__mux2_2
XFILLER_117_115 VDD VDD VSS VSS gf180mcu_as_sc_mcu7t3v3__fillcap_16
XFILLER_200_380 VDD VDD VSS VSS gf180mcu_as_sc_mcu7t3v3__fillcap_4
XFILLER_200_391 VDD VDD VSS VSS gf180mcu_as_sc_mcu7t3v3__fill_1
XFILLER_67_2 VDD VDD VSS VSS gf180mcu_as_sc_mcu7t3v3__fill_2
XPHY_EDGE_ROW_143_3_Right_180 VDD VSS gf180mcu_as_sc_mcu7t3v3__tap_2
XTAP_TAPCELL_ROW_11_970 VDD VSS gf180mcu_as_sc_mcu7t3v3__tap_2
XTAP_TAPCELL_ROW_11_981 VDD VSS gf180mcu_as_sc_mcu7t3v3__tap_2
X_2663_ VDD VDD VSS VSS _2663_/A _2722_/B _2663_/C _2664_/C _2729_/C gf180mcu_as_sc_mcu7t3v3__aoi211_2
XTAP_TAPCELL_ROW_62_1_1631 VDD VSS gf180mcu_as_sc_mcu7t3v3__tap_2
XFILLER_86_1543 VDD VDD VSS VSS gf180mcu_as_sc_mcu7t3v3__fill_1
X_4402_ VDD VDD VSS VSS _4405_/C _4980_/Q _4500_/S gf180mcu_as_sc_mcu7t3v3__nand2b_2
X_2594_ VDD VDD VSS VSS _2595_/A _2767_/A _4264_/A gf180mcu_as_sc_mcu7t3v3__nand2_2
XFILLER_5_50 VDD VDD VSS VSS gf180mcu_as_sc_mcu7t3v3__fillcap_16
XFILLER_5_72 VDD VDD VSS VSS gf180mcu_as_sc_mcu7t3v3__fillcap_16
XFILLER_82_1429 VDD VDD VSS VSS gf180mcu_as_sc_mcu7t3v3__fillcap_8
X_4333_ VDD VDD VSS VSS _4334_/B _4590_/B _4539_/B gf180mcu_as_sc_mcu7t3v3__and2_2
XFILLER_134_1519 VDD VDD VSS VSS gf180mcu_as_sc_mcu7t3v3__fill_2
XFILLER_173_1568 VDD VDD VSS VSS gf180mcu_as_sc_mcu7t3v3__fill_1
X_4264_ VDD VDD VSS VSS _4265_/C _5099_/Q _4264_/B _4264_/A gf180mcu_as_sc_mcu7t3v3__aoi21_2
XTAP_TAPCELL_ROW_72_3_2937 VDD VSS gf180mcu_as_sc_mcu7t3v3__tap_2
XFILLER_86_216 VDD VDD VSS VSS gf180mcu_as_sc_mcu7t3v3__fillcap_4
X_3215_ VDD VDD VSS VSS _3228_/A _3215_/B _3215_/A _3216_/D gf180mcu_as_sc_mcu7t3v3__mux2_2
X_4195_ VDD VDD VSS VSS _4255_/B _4197_/B _4197_/C _5033_/Q _5033_/D gf180mcu_as_sc_mcu7t3v3__ao22_2
XFILLER_27_316 VDD VDD VSS VSS gf180mcu_as_sc_mcu7t3v3__fill_2
XFILLER_28_839 VDD VDD VSS VSS gf180mcu_as_sc_mcu7t3v3__fillcap_16
X_3146_ VDD VDD VSS VSS _3179_/B _4938_/Q _3147_/D gf180mcu_as_sc_mcu7t3v3__or2_2
XFILLER_27_349 VDD VDD VSS VSS gf180mcu_as_sc_mcu7t3v3__fill_1
X_3077_ VDD VDD VSS VSS _3128_/A _3077_/B _3077_/C _3128_/D _3079_/C gf180mcu_as_sc_mcu7t3v3__ao211_2
XFILLER_35_371 VDD VDD VSS VSS gf180mcu_as_sc_mcu7t3v3__fillcap_16
XFILLER_36_883 VDD VDD VSS VSS gf180mcu_as_sc_mcu7t3v3__fill_1
XFILLER_54_1509 VDD VDD VSS VSS gf180mcu_as_sc_mcu7t3v3__fillcap_4
XFILLER_93_1558 VDD VDD VSS VSS gf180mcu_as_sc_mcu7t3v3__fillcap_8
XFILLER_24_37 VDD VDD VSS VSS gf180mcu_as_sc_mcu7t3v3__fillcap_16
XFILLER_195_335 VDD VDD VSS VSS gf180mcu_as_sc_mcu7t3v3__fillcap_4
XFILLER_210_144 VDD VDD VSS VSS gf180mcu_as_sc_mcu7t3v3__fill_1
XFILLER_10_227 VDD VDD VSS VSS gf180mcu_as_sc_mcu7t3v3__fillcap_4
XFILLER_17_1364 VDD VDD VSS VSS gf180mcu_as_sc_mcu7t3v3__fill_2
X_3979_ VDD VDD VSS VSS _3979_/B _4107_/A _4234_/B gf180mcu_as_sc_mcu7t3v3__and2_2
XFILLER_176_593 VDD VDD VSS VSS gf180mcu_as_sc_mcu7t3v3__fill_2
XFILLER_17_1397 VDD VDD VSS VSS gf180mcu_as_sc_mcu7t3v3__fill_2
XFILLER_123_107 VDD VDD VSS VSS gf180mcu_as_sc_mcu7t3v3__fillcap_16
XFILLER_156_69 VDD VDD VSS VSS gf180mcu_as_sc_mcu7t3v3__fillcap_16
XFILLER_116_170 VDD VDD VSS VSS gf180mcu_as_sc_mcu7t3v3__fillcap_4
XFILLER_3_949 VDD VDD VSS VSS gf180mcu_as_sc_mcu7t3v3__fillcap_4
XPHY_EDGE_ROW_45_3_Right_82 VDD VSS gf180mcu_as_sc_mcu7t3v3__tap_2
XTAP_TAPCELL_ROW_121_1_1809 VDD VSS gf180mcu_as_sc_mcu7t3v3__tap_2
XFILLER_116_192 VDD VDD VSS VSS gf180mcu_as_sc_mcu7t3v3__fillcap_4
XFILLER_176_1192 VDD VDD VSS VSS gf180mcu_as_sc_mcu7t3v3__fillcap_16
XFILLER_24_1313 VDD VDD VSS VSS gf180mcu_as_sc_mcu7t3v3__fillcap_4
XFILLER_63_1362 VDD VDD VSS VSS gf180mcu_as_sc_mcu7t3v3__fill_1
Xfanout730 VDD VDD VSS VSS _2931_/Y _3169_/C gf180mcu_as_sc_mcu7t3v3__buff_12
Xfanout741 VDD VDD VSS VSS _4749_/B _4721_/A gf180mcu_as_sc_mcu7t3v3__buff_12
Xfanout752 VDD VDD VSS VSS _3224_/C _3233_/B gf180mcu_as_sc_mcu7t3v3__buff_12
Xfanout763 VDD VDD VSS VSS _2673_/B _2852_/B gf180mcu_as_sc_mcu7t3v3__buff_12
Xfanout774 VDD VDD VSS VSS _2815_/A _2833_/A gf180mcu_as_sc_mcu7t3v3__buff_12
Xfanout785 VDD VDD VSS VSS _4264_/A _2731_/S gf180mcu_as_sc_mcu7t3v3__buff_12
XFILLER_115_1485 VDD VDD VSS VSS gf180mcu_as_sc_mcu7t3v3__fill_1
Xfanout796 VDD VDD VSS VSS _4585_/A _4456_/S gf180mcu_as_sc_mcu7t3v3__buff_12
XTAP_TAPCELL_ROW_16_1093 VDD VSS gf180mcu_as_sc_mcu7t3v3__tap_2
XTAP_TAPCELL_ROW_16_1082 VDD VSS gf180mcu_as_sc_mcu7t3v3__tap_2
XFILLER_171_2 VDD VDD VSS VSS gf180mcu_as_sc_mcu7t3v3__fillcap_16
XFILLER_18_349 VDD VDD VSS VSS gf180mcu_as_sc_mcu7t3v3__fill_1
XFILLER_45_124 VDD VDD VSS VSS gf180mcu_as_sc_mcu7t3v3__fill_2
XFILLER_98_1447 VDD VDD VSS VSS gf180mcu_as_sc_mcu7t3v3__fillcap_4
XFILLER_2_1153 VDD VDD VSS VSS gf180mcu_as_sc_mcu7t3v3__fill_2
XFILLER_65_88 VDD VDD VSS VSS gf180mcu_as_sc_mcu7t3v3__fill_1
XFILLER_121_50 VDD VDD VSS VSS gf180mcu_as_sc_mcu7t3v3__fillcap_16
XFILLER_60_127 VDD VDD VSS VSS gf180mcu_as_sc_mcu7t3v3__fillcap_16
XFILLER_121_72 VDD VDD VSS VSS gf180mcu_as_sc_mcu7t3v3__fillcap_16
XFILLER_187_836 VDD VDD VSS VSS gf180mcu_as_sc_mcu7t3v3__fillcap_4
XFILLER_18_1106 VDD VDD VSS VSS gf180mcu_as_sc_mcu7t3v3__fillcap_4
XFILLER_199_696 VDD VDD VSS VSS gf180mcu_as_sc_mcu7t3v3__fillcap_4
XTAP_TAPCELL_ROW_67_1_1646 VDD VSS gf180mcu_as_sc_mcu7t3v3__tap_2
XFILLER_187_858 VDD VDD VSS VSS gf180mcu_as_sc_mcu7t3v3__fillcap_16
XFILLER_197_54 VDD VDD VSS VSS gf180mcu_as_sc_mcu7t3v3__fillcap_16
XFILLER_202_645 VDD VDD VSS VSS gf180mcu_as_sc_mcu7t3v3__fillcap_16
XFILLER_202_667 VDD VDD VSS VSS gf180mcu_as_sc_mcu7t3v3__fillcap_16
XFILLER_74_1491 VDD VDD VSS VSS gf180mcu_as_sc_mcu7t3v3__fillcap_16
XFILLER_186_357 VDD VDD VSS VSS gf180mcu_as_sc_mcu7t3v3__fillcap_16
XFILLER_35_1453 VDD VDD VSS VSS gf180mcu_as_sc_mcu7t3v3__fillcap_4
XFILLER_31_1317 VDD VDD VSS VSS gf180mcu_as_sc_mcu7t3v3__fillcap_4
XPHY_EDGE_ROW_55_3_Left_440 VDD VSS gf180mcu_as_sc_mcu7t3v3__tap_2
XFILLER_154_221 VDD VDD VSS VSS gf180mcu_as_sc_mcu7t3v3__fill_1
XFILLER_5_220 VDD VDD VSS VSS gf180mcu_as_sc_mcu7t3v3__fillcap_4
XFILLER_70_1399 VDD VDD VSS VSS gf180mcu_as_sc_mcu7t3v3__fillcap_8
XFILLER_114_107 VDD VDD VSS VSS gf180mcu_as_sc_mcu7t3v3__fillcap_8
XFILLER_5_253 VDD VDD VSS VSS gf180mcu_as_sc_mcu7t3v3__fill_2
XFILLER_107_170 VDD VDD VSS VSS gf180mcu_as_sc_mcu7t3v3__fillcap_4
XFILLER_29_1224 VDD VDD VSS VSS gf180mcu_as_sc_mcu7t3v3__fillcap_16
XFILLER_122_151 VDD VDD VSS VSS gf180mcu_as_sc_mcu7t3v3__fillcap_16
XFILLER_2_982 VDD VDD VSS VSS gf180mcu_as_sc_mcu7t3v3__fillcap_4
XFILLER_81_1440 VDD VDD VSS VSS gf180mcu_as_sc_mcu7t3v3__fill_1
XFILLER_81_1451 VDD VDD VSS VSS gf180mcu_as_sc_mcu7t3v3__fillcap_8
XTAP_TAPCELL_ROW_186_2270 VDD VSS gf180mcu_as_sc_mcu7t3v3__tap_2
XFILLER_190_1189 VDD VDD VSS VSS gf180mcu_as_sc_mcu7t3v3__fillcap_16
XFILLER_1_492 VDD VDD VSS VSS gf180mcu_as_sc_mcu7t3v3__fillcap_16
XFILLER_7_1031 VDD VDD VSS VSS gf180mcu_as_sc_mcu7t3v3__fillcap_16
XFILLER_81_1484 VDD VDD VSS VSS gf180mcu_as_sc_mcu7t3v3__fill_2
Xclkbuf_leaf_4_clk_regs VDD VDD VSS VSS clkbuf_leaf_9_clk_regs/A _4977_/CLK gf180mcu_as_sc_mcu7t3v3__clkbuff_12
Xinput7 VDD VDD VSS VSS boot_addr[5] input7/Y gf180mcu_as_sc_mcu7t3v3__buff_12
X_3000_ VDD VDD VSS VSS _3075_/S _3981_/A _3983_/A _3002_/B gf180mcu_as_sc_mcu7t3v3__mux2_2
XTAP_TAPCELL_ROW_182_2178 VDD VSS gf180mcu_as_sc_mcu7t3v3__tap_2
XTAP_TAPCELL_ROW_182_2167 VDD VSS gf180mcu_as_sc_mcu7t3v3__tap_2
XFILLER_36_168 VDD VDD VSS VSS gf180mcu_as_sc_mcu7t3v3__fill_2
X_4951_ VDD VDD VSS VSS _4977_/CLK _4951_/D _4951_/Q gf180mcu_as_sc_mcu7t3v3__dfxtp_2
XFILLER_166_1383 VDD VDD VSS VSS gf180mcu_as_sc_mcu7t3v3__fillcap_8
XFILLER_178_814 VDD VDD VSS VSS gf180mcu_as_sc_mcu7t3v3__fill_1
XFILLER_33_842 VDD VDD VSS VSS gf180mcu_as_sc_mcu7t3v3__fill_2
XFILLER_51_138 VDD VDD VSS VSS gf180mcu_as_sc_mcu7t3v3__fill_2
X_4882_ VDD VDD VSS VSS _4924_/CLK _4882_/D _4882_/Q gf180mcu_as_sc_mcu7t3v3__dfxtp_2
X_3902_ VDD VDD VSS VSS _3902_/B _5160_/Q _4942_/D gf180mcu_as_sc_mcu7t3v3__and2_2
XFILLER_177_324 VDD VDD VSS VSS gf180mcu_as_sc_mcu7t3v3__fill_1
X_3833_ VDD VDD VSS VSS _4910_/D _4753_/B _4753_/A gf180mcu_as_sc_mcu7t3v3__nor2_2
XFILLER_207_1380 VDD VDD VSS VSS gf180mcu_as_sc_mcu7t3v3__fillcap_16
XFILLER_140_1523 VDD VDD VSS VSS gf180mcu_as_sc_mcu7t3v3__fill_2
X_3764_ VDD VDD VSS VSS _4143_/A _3781_/S _3764_/C _3764_/D _3765_/D gf180mcu_as_sc_mcu7t3v3__ao211_2
XFILLER_199_1170 VDD VDD VSS VSS gf180mcu_as_sc_mcu7t3v3__fillcap_16
XFILLER_199_1192 VDD VDD VSS VSS gf180mcu_as_sc_mcu7t3v3__fillcap_16
X_3695_ VDD VDD VSS VSS _4069_/D _3751_/B _3695_/C _3695_/D _3696_/C gf180mcu_as_sc_mcu7t3v3__ao211_2
X_2715_ VDD VDD VSS VSS _2716_/D _2729_/C _2722_/B _2715_/A gf180mcu_as_sc_mcu7t3v3__aoi21b_2
X_2646_ VDD VDD VSS VSS _2831_/A _2646_/B _5264_/Q _2649_/B gf180mcu_as_sc_mcu7t3v3__mux2_2
XTAP_TAPCELL_ROW_93_1_1725 VDD VSS gf180mcu_as_sc_mcu7t3v3__tap_2
XPHY_EDGE_ROW_144_3_Right_181 VDD VSS gf180mcu_as_sc_mcu7t3v3__tap_2
Xoutput344 VDD VDD VSS VSS _4866_/Q east_out[27] gf180mcu_as_sc_mcu7t3v3__buff_12
Xoutput333 VDD VDD VSS VSS _4856_/Q east_out[17] gf180mcu_as_sc_mcu7t3v3__buff_12
Xoutput322 VDD VDD VSS VSS _5483_/Y dft_rdata[5] gf180mcu_as_sc_mcu7t3v3__buff_12
Xoutput377 VDD VDD VSS VSS _4797_/Q se_out[26] gf180mcu_as_sc_mcu7t3v3__buff_12
Xoutput366 VDD VDD VSS VSS _4787_/Q se_out[16] gf180mcu_as_sc_mcu7t3v3__buff_12
Xoutput355 VDD VDD VSS VSS _4845_/Q east_out[6] gf180mcu_as_sc_mcu7t3v3__buff_12
X_2577_ VDD VDD VSS VSS _2599_/A _2601_/D _4262_/B gf180mcu_as_sc_mcu7t3v3__or2_2
Xoutput399 VDD VDD VSS VSS _4820_/Q south_out[15] gf180mcu_as_sc_mcu7t3v3__buff_12
Xoutput388 VDD VDD VSS VSS _4776_/Q se_out[5] gf180mcu_as_sc_mcu7t3v3__buff_12
X_4316_ VDD VDD VSS VSS _4324_/S _5146_/Q _5145_/Q _5145_/D gf180mcu_as_sc_mcu7t3v3__mux2_2
X_4247_ VDD VDD VSS VSS _4253_/S _4247_/B _5083_/Q _5083_/D gf180mcu_as_sc_mcu7t3v3__mux2_2
XFILLER_142_27 VDD VDD VSS VSS gf180mcu_as_sc_mcu7t3v3__fillcap_8
XFILLER_19_59 VDD VDD VSS VSS gf180mcu_as_sc_mcu7t3v3__fillcap_8
XFILLER_210_1215 VDD VDD VSS VSS gf180mcu_as_sc_mcu7t3v3__fillcap_4
XFILLER_210_1226 VDD VDD VSS VSS gf180mcu_as_sc_mcu7t3v3__fillcap_4
XFILLER_60_1568 VDD VDD VSS VSS gf180mcu_as_sc_mcu7t3v3__fill_1
X_4178_ VDD VDD VSS VSS _4238_/B _4191_/B _4191_/C _5016_/Q _5016_/D gf180mcu_as_sc_mcu7t3v3__ao22_2
X_3129_ VDD VDD VSS VSS _3129_/B _4936_/Q _3130_/D gf180mcu_as_sc_mcu7t3v3__or2_2
XFILLER_35_47 VDD VDD VSS VSS gf180mcu_as_sc_mcu7t3v3__fill_1
XFILLER_58_1431 VDD VDD VSS VSS gf180mcu_as_sc_mcu7t3v3__fillcap_16
X_4903__1064 VDD VDD VSS VSS _4903_/D gf180mcu_as_sc_mcu7t3v3__tiel_4
XFILLER_145_1412 VDD VDD VSS VSS gf180mcu_as_sc_mcu7t3v3__fillcap_4
XFILLER_180_1303 VDD VDD VSS VSS gf180mcu_as_sc_mcu7t3v3__fill_1
XFILLER_24_864 VDD VDD VSS VSS gf180mcu_as_sc_mcu7t3v3__fillcap_8
XFILLER_58_1453 VDD VDD VSS VSS gf180mcu_as_sc_mcu7t3v3__fillcap_8
XFILLER_145_1445 VDD VDD VSS VSS gf180mcu_as_sc_mcu7t3v3__fillcap_16
XFILLER_23_352 VDD VDD VSS VSS gf180mcu_as_sc_mcu7t3v3__fillcap_16
XFILLER_11_547 VDD VDD VSS VSS gf180mcu_as_sc_mcu7t3v3__fill_1
XFILLER_50_193 VDD VDD VSS VSS gf180mcu_as_sc_mcu7t3v3__fillcap_4
XFILLER_196_699 VDD VDD VSS VSS gf180mcu_as_sc_mcu7t3v3__fillcap_16
XFILLER_13_1036 VDD VDD VSS VSS gf180mcu_as_sc_mcu7t3v3__fillcap_8
XFILLER_183_349 VDD VDD VSS VSS gf180mcu_as_sc_mcu7t3v3__fill_1
XFILLER_178_1243 VDD VDD VSS VSS gf180mcu_as_sc_mcu7t3v3__fillcap_16
XFILLER_3_702 VDD VDD VSS VSS gf180mcu_as_sc_mcu7t3v3__fillcap_4
XTAP_TAPCELL_ROW_140_1_1864 VDD VSS gf180mcu_as_sc_mcu7t3v3__tap_2
XTAP_TAPCELL_ROW_152_3_3176 VDD VSS gf180mcu_as_sc_mcu7t3v3__tap_2
XTAP_TAPCELL_ROW_18_1133 VDD VSS gf180mcu_as_sc_mcu7t3v3__tap_2
XTAP_TAPCELL_ROW_18_1122 VDD VSS gf180mcu_as_sc_mcu7t3v3__tap_2
XFILLER_65_1468 VDD VDD VSS VSS gf180mcu_as_sc_mcu7t3v3__fillcap_16
XFILLER_117_1558 VDD VDD VSS VSS gf180mcu_as_sc_mcu7t3v3__fillcap_8
XFILLER_152_1449 VDD VDD VSS VSS gf180mcu_as_sc_mcu7t3v3__fill_2
XFILLER_76_32 VDD VDD VSS VSS gf180mcu_as_sc_mcu7t3v3__fill_2
Xfanout560 VDD VDD VSS VSS _4043_/B _4027_/B gf180mcu_as_sc_mcu7t3v3__buff_12
Xfanout571 VDD VDD VSS VSS _3726_/B _3652_/B gf180mcu_as_sc_mcu7t3v3__buff_12
Xfanout582 VDD VDD VSS VSS _3278_/Y _3467_/C gf180mcu_as_sc_mcu7t3v3__buff_12
Xfanout593 VDD VDD VSS VSS _4196_/C _4193_/C gf180mcu_as_sc_mcu7t3v3__buff_12
XTAP_TAPCELL_ROW_35_1491 VDD VSS gf180mcu_as_sc_mcu7t3v3__tap_2
XFILLER_19_636 VDD VDD VSS VSS gf180mcu_as_sc_mcu7t3v3__fill_2
XFILLER_19_669 VDD VDD VSS VSS gf180mcu_as_sc_mcu7t3v3__fillcap_4
XFILLER_206_225 VDD VDD VSS VSS gf180mcu_as_sc_mcu7t3v3__fillcap_16
XFILLER_24_1198 VDD VDD VSS VSS gf180mcu_as_sc_mcu7t3v3__fillcap_16
XFILLER_15_820 VDD VDD VSS VSS gf180mcu_as_sc_mcu7t3v3__fillcap_16
XFILLER_206_247 VDD VDD VSS VSS gf180mcu_as_sc_mcu7t3v3__fillcap_16
XFILLER_27_680 VDD VDD VSS VSS gf180mcu_as_sc_mcu7t3v3__fillcap_16
XFILLER_76_1520 VDD VDD VSS VSS gf180mcu_as_sc_mcu7t3v3__fill_1
XFILLER_92_31 VDD VDD VSS VSS gf180mcu_as_sc_mcu7t3v3__fillcap_4
XFILLER_15_842 VDD VDD VSS VSS gf180mcu_as_sc_mcu7t3v3__fillcap_8
XFILLER_37_1504 VDD VDD VSS VSS gf180mcu_as_sc_mcu7t3v3__fill_2
XFILLER_203_976 VDD VDD VSS VSS gf180mcu_as_sc_mcu7t3v3__fillcap_4
XFILLER_186_143 VDD VDD VSS VSS gf180mcu_as_sc_mcu7t3v3__fill_1
XFILLER_202_453 VDD VDD VSS VSS gf180mcu_as_sc_mcu7t3v3__fill_2
XFILLER_203_998 VDD VDD VSS VSS gf180mcu_as_sc_mcu7t3v3__fillcap_16
XFILLER_30_856 VDD VDD VSS VSS gf180mcu_as_sc_mcu7t3v3__fillcap_8
XFILLER_174_305 VDD VDD VSS VSS gf180mcu_as_sc_mcu7t3v3__fill_1
XFILLER_35_1283 VDD VDD VSS VSS gf180mcu_as_sc_mcu7t3v3__fillcap_16
XFILLER_31_1169 VDD VDD VSS VSS gf180mcu_as_sc_mcu7t3v3__fillcap_16
X_3480_ VDD VDD VSS VSS _4135_/D _3500_/B _3480_/C _3480_/D _3482_/C gf180mcu_as_sc_mcu7t3v3__ao211_2
X_2500_ VDD VDD VSS VSS _2525_/A _5229_/Q _2502_/C gf180mcu_as_sc_mcu7t3v3__and2_2
X_2431_ VDD VDD VSS VSS _3639_/A _4010_/A gf180mcu_as_sc_mcu7t3v3__inv_2
XTAP_TAPCELL_ROW_188_2310 VDD VSS gf180mcu_as_sc_mcu7t3v3__tap_2
X_5150_ VDD VDD VSS VSS _5216_/CLK _5150_/D _5150_/Q gf180mcu_as_sc_mcu7t3v3__dfxtp_2
XTAP_TAPCELL_ROW_184_2229 VDD VSS gf180mcu_as_sc_mcu7t3v3__tap_2
XTAP_TAPCELL_ROW_184_2218 VDD VSS gf180mcu_as_sc_mcu7t3v3__tap_2
X_5081_ VDD VDD VSS VSS _5095_/CLK _5081_/D _5081_/Q gf180mcu_as_sc_mcu7t3v3__dfxtp_2
X_4101_ VDD VDD VSS VSS _4101_/A _4101_/B _4101_/C _4101_/D _4103_/C gf180mcu_as_sc_mcu7t3v3__ao22_2
X_4032_ VDD VDD VSS VSS _4032_/A _4032_/B _4032_/C _4032_/D _4033_/D gf180mcu_as_sc_mcu7t3v3__ao22_2
XTAP_TAPCELL_ROW_0_705 VDD VSS gf180mcu_as_sc_mcu7t3v3__tap_2
XTAP_TAPCELL_ROW_0_716 VDD VSS gf180mcu_as_sc_mcu7t3v3__tap_2
XTAP_TAPCELL_ROW_0_727 VDD VSS gf180mcu_as_sc_mcu7t3v3__tap_2
XTAP_TAPCELL_ROW_0_738 VDD VSS gf180mcu_as_sc_mcu7t3v3__tap_2
XTAP_TAPCELL_ROW_67_3_2921 VDD VSS gf180mcu_as_sc_mcu7t3v3__tap_2
XFILLER_198_909 VDD VDD VSS VSS gf180mcu_as_sc_mcu7t3v3__fillcap_16
XFILLER_25_628 VDD VDD VSS VSS gf180mcu_as_sc_mcu7t3v3__fill_2
XFILLER_17_190 VDD VDD VSS VSS gf180mcu_as_sc_mcu7t3v3__fill_2
XFILLER_24_127 VDD VDD VSS VSS gf180mcu_as_sc_mcu7t3v3__fill_1
X_4934_ VDD VDD VSS VSS _5278_/CLK _4934_/D _4934_/Q gf180mcu_as_sc_mcu7t3v3__dfxtp_2
XFILLER_21_812 VDD VDD VSS VSS gf180mcu_as_sc_mcu7t3v3__fillcap_4
XPHY_EDGE_ROW_169_1_Right_690 VDD VSS gf180mcu_as_sc_mcu7t3v3__tap_2
XANTENNA_12 VDD VDD VSS VSS _4861_/D gf180mcu_as_sc_mcu7t3v3__diode_2
XANTENNA_23 VDD VDD VSS VSS _4772_/D gf180mcu_as_sc_mcu7t3v3__diode_2
XFILLER_20_333 VDD VDD VSS VSS gf180mcu_as_sc_mcu7t3v3__fill_1
XFILLER_32_193 VDD VDD VSS VSS gf180mcu_as_sc_mcu7t3v3__fill_1
XTAP_TAPCELL_ROW_145_1_1879 VDD VSS gf180mcu_as_sc_mcu7t3v3__tap_2
X_4865_ VDD VDD VSS VSS _5197_/CLK _4865_/D _4865_/Q gf180mcu_as_sc_mcu7t3v3__dfxtp_2
XANTENNA_34 VDD VDD VSS VSS _4023_/A gf180mcu_as_sc_mcu7t3v3__diode_2
XFILLER_177_176 VDD VDD VSS VSS gf180mcu_as_sc_mcu7t3v3__fillcap_16
XFILLER_203_1030 VDD VDD VSS VSS gf180mcu_as_sc_mcu7t3v3__fillcap_16
X_4796_ VDD VDD VSS VSS _5214_/CLK _4796_/D _4796_/Q gf180mcu_as_sc_mcu7t3v3__dfxtp_2
X_3816_ VDD VDD VSS VSS _3928_/A _3818_/B _3818_/A gf180mcu_as_sc_mcu7t3v3__nand2_2
XTAP_TAPCELL_ROW_47_3_2863 VDD VSS gf180mcu_as_sc_mcu7t3v3__tap_2
XFILLER_105_1473 VDD VDD VSS VSS gf180mcu_as_sc_mcu7t3v3__fill_2
XFILLER_118_221 VDD VDD VSS VSS gf180mcu_as_sc_mcu7t3v3__fill_1
XFILLER_140_1364 VDD VDD VSS VSS gf180mcu_as_sc_mcu7t3v3__fillcap_8
XFILLER_14_1367 VDD VDD VSS VSS gf180mcu_as_sc_mcu7t3v3__fillcap_8
XFILLER_203_1052 VDD VDD VSS VSS gf180mcu_as_sc_mcu7t3v3__fillcap_16
X_3747_ VDD VDD VSS VSS _3778_/B _4128_/A _3749_/C gf180mcu_as_sc_mcu7t3v3__and2_2
XFILLER_105_1495 VDD VDD VSS VSS gf180mcu_as_sc_mcu7t3v3__fillcap_8
XFILLER_137_27 VDD VDD VSS VSS gf180mcu_as_sc_mcu7t3v3__fillcap_16
XFILLER_12_1091 VDD VDD VSS VSS gf180mcu_as_sc_mcu7t3v3__fill_2
X_3678_ VDD VDD VSS VSS _3679_/C _4053_/A _3725_/B _3678_/C gf180mcu_as_sc_mcu7t3v3__ao21_2
XPHY_EDGE_ROW_145_3_Right_182 VDD VSS gf180mcu_as_sc_mcu7t3v3__tap_2
X_2629_ VDD VDD VSS VSS _2668_/B _2629_/B _2629_/A _2629_/Y gf180mcu_as_sc_mcu7t3v3__mux2_2
XFILLER_0_716 VDD VDD VSS VSS gf180mcu_as_sc_mcu7t3v3__fill_2
XFILLER_99_182 VDD VDD VSS VSS gf180mcu_as_sc_mcu7t3v3__fill_1
XFILLER_29_901 VDD VDD VSS VSS gf180mcu_as_sc_mcu7t3v3__fillcap_8
XFILLER_29_912 VDD VDD VSS VSS gf180mcu_as_sc_mcu7t3v3__fillcap_16
X_5279_ VDD VDD VSS VSS _5280_/CLK _5279_/D _5279_/Q gf180mcu_as_sc_mcu7t3v3__dfxtp_2
XFILLER_21_1327 VDD VDD VSS VSS gf180mcu_as_sc_mcu7t3v3__fill_2
XTAP_TAPCELL_ROW_128_3_3105 VDD VSS gf180mcu_as_sc_mcu7t3v3__tap_2
XFILLER_16_639 VDD VDD VSS VSS gf180mcu_as_sc_mcu7t3v3__fillcap_8
XFILLER_15_138 VDD VDD VSS VSS gf180mcu_as_sc_mcu7t3v3__fill_2
XFILLER_182_1409 VDD VDD VSS VSS gf180mcu_as_sc_mcu7t3v3__fillcap_8
XFILLER_203_206 VDD VDD VSS VSS gf180mcu_as_sc_mcu7t3v3__fillcap_4
XFILLER_203_228 VDD VDD VSS VSS gf180mcu_as_sc_mcu7t3v3__fillcap_16
XFILLER_102_85 VDD VDD VSS VSS gf180mcu_as_sc_mcu7t3v3__fillcap_8
XFILLER_62_34 VDD VDD VSS VSS gf180mcu_as_sc_mcu7t3v3__fill_1
XPHY_EDGE_ROW_110_1_Left_320 VDD VSS gf180mcu_as_sc_mcu7t3v3__tap_2
XFILLER_178_34 VDD VDD VSS VSS gf180mcu_as_sc_mcu7t3v3__fill_1
XFILLER_19_1278 VDD VDD VSS VSS gf180mcu_as_sc_mcu7t3v3__fillcap_16
XFILLER_200_902 VDD VDD VSS VSS gf180mcu_as_sc_mcu7t3v3__fillcap_16
XFILLER_134_2 VDD VDD VSS VSS gf180mcu_as_sc_mcu7t3v3__fillcap_16
XFILLER_184_614 VDD VDD VSS VSS gf180mcu_as_sc_mcu7t3v3__fillcap_4
XFILLER_71_1450 VDD VDD VSS VSS gf180mcu_as_sc_mcu7t3v3__fillcap_16
XFILLER_7_18 VDD VDD VSS VSS gf180mcu_as_sc_mcu7t3v3__fillcap_16
XFILLER_200_979 VDD VDD VSS VSS gf180mcu_as_sc_mcu7t3v3__fillcap_16
XFILLER_191_190 VDD VDD VSS VSS gf180mcu_as_sc_mcu7t3v3__fill_1
XTAP_TAPCELL_ROW_171_1_1958 VDD VSS gf180mcu_as_sc_mcu7t3v3__tap_2
XFILLER_191_1240 VDD VDD VSS VSS gf180mcu_as_sc_mcu7t3v3__fillcap_16
XFILLER_191_1262 VDD VDD VSS VSS gf180mcu_as_sc_mcu7t3v3__fillcap_16
XFILLER_87_64 VDD VDD VSS VSS gf180mcu_as_sc_mcu7t3v3__fillcap_4
XFILLER_130_1500 VDD VDD VSS VSS gf180mcu_as_sc_mcu7t3v3__fillcap_16
XFILLER_43_1530 VDD VDD VSS VSS gf180mcu_as_sc_mcu7t3v3__fill_1
XTAP_TAPCELL_ROW_7_893 VDD VSS gf180mcu_as_sc_mcu7t3v3__tap_2
XTAP_TAPCELL_ROW_7_882 VDD VSS gf180mcu_as_sc_mcu7t3v3__tap_2
XFILLER_19_422 VDD VDD VSS VSS gf180mcu_as_sc_mcu7t3v3__fill_2
XFILLER_207_556 VDD VDD VSS VSS gf180mcu_as_sc_mcu7t3v3__fillcap_4
XFILLER_207_578 VDD VDD VSS VSS gf180mcu_as_sc_mcu7t3v3__fillcap_16
XFILLER_35_937 VDD VDD VSS VSS gf180mcu_as_sc_mcu7t3v3__fillcap_16
XFILLER_179_419 VDD VDD VSS VSS gf180mcu_as_sc_mcu7t3v3__fill_1
XPHY_EDGE_ROW_42_1_Left_252 VDD VSS gf180mcu_as_sc_mcu7t3v3__tap_2
XFILLER_76_1383 VDD VDD VSS VSS gf180mcu_as_sc_mcu7t3v3__fillcap_8
X_2980_ VDD VDD VSS VSS _3005_/A _2980_/B _2980_/C _2981_/C gf180mcu_as_sc_mcu7t3v3__nor3_2
XFILLER_159_121 VDD VDD VSS VSS gf180mcu_as_sc_mcu7t3v3__fillcap_16
XFILLER_30_631 VDD VDD VSS VSS gf180mcu_as_sc_mcu7t3v3__fillcap_4
XTAP_TAPCELL_ROW_177_2077 VDD VSS gf180mcu_as_sc_mcu7t3v3__tap_2
XTAP_TAPCELL_ROW_177_2066 VDD VSS gf180mcu_as_sc_mcu7t3v3__tap_2
XFILLER_124_1348 VDD VDD VSS VSS gf180mcu_as_sc_mcu7t3v3__fillcap_16
XFILLER_128_1495 VDD VDD VSS VSS gf180mcu_as_sc_mcu7t3v3__fill_1
XFILLER_14_193 VDD VDD VSS VSS gf180mcu_as_sc_mcu7t3v3__fillcap_8
X_4650_ VDD VDD VSS VSS _4651_/B _4733_/A _5237_/Q _4657_/B gf180mcu_as_sc_mcu7t3v3__ao21_2
XFILLER_175_669 VDD VDD VSS VSS gf180mcu_as_sc_mcu7t3v3__fillcap_4
XFILLER_204_1361 VDD VDD VSS VSS gf180mcu_as_sc_mcu7t3v3__fillcap_4
XFILLER_204_1383 VDD VDD VSS VSS gf180mcu_as_sc_mcu7t3v3__fillcap_16
XFILLER_30_675 VDD VDD VSS VSS gf180mcu_as_sc_mcu7t3v3__fillcap_4
Xinput10 VDD VDD VSS VSS boot_addr[8] _2671_/A gf180mcu_as_sc_mcu7t3v3__buff_12
Xinput21 VDD VDD VSS VSS boot_wen _2831_/B gf180mcu_as_sc_mcu7t3v3__buff_12
X_3601_ VDD VDD VSS VSS _3971_/A _3608_/B _3601_/C _3601_/Y _3608_/D gf180mcu_as_sc_mcu7t3v3__aoi211_2
XFILLER_50_1556 VDD VDD VSS VSS gf180mcu_as_sc_mcu7t3v3__fillcap_8
Xinput32 VDD VDD VSS VSS dft_addr[9] _2676_/B gf180mcu_as_sc_mcu7t3v3__buff_12
Xinput43 VDD VDD VSS VSS dft_we _2451_/A gf180mcu_as_sc_mcu7t3v3__buff_12
Xinput54 VDD VDD VSS VSS east_in[19] wire851/A gf180mcu_as_sc_mcu7t3v3__buff_12
X_4581_ VDD VDD VSS VSS _4581_/D _4581_/A _4581_/B _4581_/C _4582_/B gf180mcu_as_sc_mcu7t3v3__ao31_2
XFILLER_196_1151 VDD VDD VSS VSS gf180mcu_as_sc_mcu7t3v3__fillcap_4
XFILLER_196_1173 VDD VDD VSS VSS gf180mcu_as_sc_mcu7t3v3__fillcap_16
XFILLER_6_370 VDD VDD VSS VSS gf180mcu_as_sc_mcu7t3v3__fillcap_8
Xinput65 VDD VDD VSS VSS east_in[29] wire841/A gf180mcu_as_sc_mcu7t3v3__buff_12
Xinput76 VDD VDD VSS VSS east_in[8] wire835/A gf180mcu_as_sc_mcu7t3v3__buff_12
Xinput87 VDD VDD VSS VSS ne_in[18] _4077_/A gf180mcu_as_sc_mcu7t3v3__buff_12
Xinput98 VDD VDD VSS VSS ne_in[28] _4160_/A gf180mcu_as_sc_mcu7t3v3__buff_12
X_3532_ VDD VDD VSS VSS _3736_/B _3551_/A gf180mcu_as_sc_mcu7t3v3__inv_2
Xmax_cap579 VDD VDD VSS VSS _3523_/B _3445_/C gf180mcu_as_sc_mcu7t3v3__clkbuff_12
X_3463_ VDD VDD VSS VSS _4115_/A _3463_/B _3463_/C _4827_/D _3463_/D gf180mcu_as_sc_mcu7t3v3__aoi211_2
X_5202_ VDD VDD VSS VSS _5216_/CLK _5202_/D _5202_/Q gf180mcu_as_sc_mcu7t3v3__dfxtp_2
X_2414_ VDD VDD VSS VSS _3850_/A _5155_/Q gf180mcu_as_sc_mcu7t3v3__inv_2
X_5133_ VDD VDD VSS VSS _5198_/CLK _5133_/D _5133_/Q gf180mcu_as_sc_mcu7t3v3__dfxtp_2
X_3394_ VDD VDD VSS VSS _3450_/B _4046_/D _3395_/D gf180mcu_as_sc_mcu7t3v3__and2_2
XFILLER_135_1488 VDD VDD VSS VSS gf180mcu_as_sc_mcu7t3v3__fillcap_16
XFILLER_29_208 VDD VDD VSS VSS gf180mcu_as_sc_mcu7t3v3__fill_2
XFILLER_83_1398 VDD VDD VSS VSS gf180mcu_as_sc_mcu7t3v3__fillcap_16
X_5064_ VDD VDD VSS VSS _5095_/CLK _5064_/D _5064_/Q gf180mcu_as_sc_mcu7t3v3__dfxtp_2
XTAP_TAPCELL_ROW_209_2777 VDD VSS gf180mcu_as_sc_mcu7t3v3__tap_2
XTAP_TAPCELL_ROW_209_2766 VDD VSS gf180mcu_as_sc_mcu7t3v3__tap_2
X_4015_ VDD VDD VSS VSS _4015_/A _4103_/B _4015_/C _4015_/D _4017_/C gf180mcu_as_sc_mcu7t3v3__ao211_2
XFILLER_16_27 VDD VDD VSS VSS gf180mcu_as_sc_mcu7t3v3__fillcap_8
XFILLER_0_1498 VDD VDD VSS VSS gf180mcu_as_sc_mcu7t3v3__fill_1
XFILLER_146_1540 VDD VDD VSS VSS gf180mcu_as_sc_mcu7t3v3__fill_1
XFILLER_55_1434 VDD VDD VSS VSS gf180mcu_as_sc_mcu7t3v3__fill_2
XPHY_EDGE_ROW_54_3_Right_91 VDD VSS gf180mcu_as_sc_mcu7t3v3__tap_2
XFILLER_200_209 VDD VDD VSS VSS gf180mcu_as_sc_mcu7t3v3__fillcap_16
XFILLER_209_1294 VDD VDD VSS VSS gf180mcu_as_sc_mcu7t3v3__fillcap_16
XFILLER_55_1456 VDD VDD VSS VSS gf180mcu_as_sc_mcu7t3v3__fillcap_4
X_4917_ VDD VDD VSS VSS _4919_/CLK _4917_/D _4917_/Q gf180mcu_as_sc_mcu7t3v3__dfxtp_2
XFILLER_107_1568 VDD VDD VSS VSS gf180mcu_as_sc_mcu7t3v3__fill_1
XFILLER_21_664 VDD VDD VSS VSS gf180mcu_as_sc_mcu7t3v3__fill_2
XFILLER_32_37 VDD VDD VSS VSS gf180mcu_as_sc_mcu7t3v3__fillcap_16
X_4848_ VDD VDD VSS VSS _5241_/CLK _4848_/D _4848_/Q gf180mcu_as_sc_mcu7t3v3__dfxtp_2
XFILLER_148_37 VDD VDD VSS VSS gf180mcu_as_sc_mcu7t3v3__fillcap_16
XFILLER_193_422 VDD VDD VSS VSS gf180mcu_as_sc_mcu7t3v3__fillcap_8
XFILLER_20_174 VDD VDD VSS VSS gf180mcu_as_sc_mcu7t3v3__fill_1
XFILLER_193_488 VDD VDD VSS VSS gf180mcu_as_sc_mcu7t3v3__fill_2
XFILLER_4_307 VDD VDD VSS VSS gf180mcu_as_sc_mcu7t3v3__fill_1
X_4779_ VDD VDD VSS VSS _5142_/CLK _4779_/D _4779_/Q gf180mcu_as_sc_mcu7t3v3__dfxtp_2
XFILLER_10_1017 VDD VDD VSS VSS gf180mcu_as_sc_mcu7t3v3__fillcap_16
XFILLER_10_1039 VDD VDD VSS VSS gf180mcu_as_sc_mcu7t3v3__fill_1
XFILLER_179_1382 VDD VDD VSS VSS gf180mcu_as_sc_mcu7t3v3__fillcap_16
XTAP_TAPCELL_ROW_61_1_1627 VDD VSS gf180mcu_as_sc_mcu7t3v3__tap_2
XFILLER_175_1224 VDD VDD VSS VSS gf180mcu_as_sc_mcu7t3v3__fillcap_16
XFILLER_66_1530 VDD VDD VSS VSS gf180mcu_as_sc_mcu7t3v3__fillcap_8
XFILLER_0_546 VDD VDD VSS VSS gf180mcu_as_sc_mcu7t3v3__fillcap_4
XPHY_EDGE_ROW_146_3_Right_183 VDD VSS gf180mcu_as_sc_mcu7t3v3__tap_2
XFILLER_153_1566 VDD VDD VSS VSS gf180mcu_as_sc_mcu7t3v3__fill_2
XFILLER_5_1332 VDD VDD VSS VSS gf180mcu_as_sc_mcu7t3v3__fillcap_4
XTAP_TAPCELL_ROW_41_1_1569 VDD VSS gf180mcu_as_sc_mcu7t3v3__tap_2
XFILLER_16_403 VDD VDD VSS VSS gf180mcu_as_sc_mcu7t3v3__fillcap_16
XFILLER_28_263 VDD VDD VSS VSS gf180mcu_as_sc_mcu7t3v3__fillcap_8
XFILLER_5_1398 VDD VDD VSS VSS gf180mcu_as_sc_mcu7t3v3__fill_2
XFILLER_189_22 VDD VDD VSS VSS gf180mcu_as_sc_mcu7t3v3__fillcap_16
XFILLER_16_469 VDD VDD VSS VSS gf180mcu_as_sc_mcu7t3v3__fill_2
XFILLER_204_559 VDD VDD VSS VSS gf180mcu_as_sc_mcu7t3v3__fillcap_16
XFILLER_73_88 VDD VDD VSS VSS gf180mcu_as_sc_mcu7t3v3__fillcap_16
XTAP_TAPCELL_ROW_115_1_1790 VDD VSS gf180mcu_as_sc_mcu7t3v3__tap_2
XFILLER_189_88 VDD VDD VSS VSS gf180mcu_as_sc_mcu7t3v3__fillcap_16
XFILLER_185_912 VDD VDD VSS VSS gf180mcu_as_sc_mcu7t3v3__fillcap_16
XFILLER_197_772 VDD VDD VSS VSS gf180mcu_as_sc_mcu7t3v3__fillcap_16
XFILLER_32_1231 VDD VDD VSS VSS gf180mcu_as_sc_mcu7t3v3__fill_2
XTAP_TAPCELL_ROW_26_1298 VDD VSS gf180mcu_as_sc_mcu7t3v3__tap_2
XFILLER_156_146 VDD VDD VSS VSS gf180mcu_as_sc_mcu7t3v3__fillcap_16
XFILLER_171_116 VDD VDD VSS VSS gf180mcu_as_sc_mcu7t3v3__fill_2
XFILLER_184_488 VDD VDD VSS VSS gf180mcu_as_sc_mcu7t3v3__fillcap_4
XFILLER_208_18 VDD VDD VSS VSS gf180mcu_as_sc_mcu7t3v3__fillcap_16
XFILLER_22_81 VDD VDD VSS VSS gf180mcu_as_sc_mcu7t3v3__fillcap_4
XFILLER_32_1297 VDD VDD VSS VSS gf180mcu_as_sc_mcu7t3v3__fillcap_16
XFILLER_138_81 VDD VDD VSS VSS gf180mcu_as_sc_mcu7t3v3__fill_2
XFILLER_119_1428 VDD VDD VSS VSS gf180mcu_as_sc_mcu7t3v3__fillcap_16
XFILLER_180_683 VDD VDD VSS VSS gf180mcu_as_sc_mcu7t3v3__fill_2
XFILLER_98_85 VDD VDD VSS VSS gf180mcu_as_sc_mcu7t3v3__fillcap_16
XFILLER_26_1068 VDD VDD VSS VSS gf180mcu_as_sc_mcu7t3v3__fill_1
XFILLER_78_185 VDD VDD VSS VSS gf180mcu_as_sc_mcu7t3v3__fill_1
XFILLER_93_133 VDD VDD VSS VSS gf180mcu_as_sc_mcu7t3v3__fillcap_4
XPHY_EDGE_ROW_179_Right_42 VDD VSS gf180mcu_as_sc_mcu7t3v3__tap_2
XTAP_TAPCELL_ROW_204_2652 VDD VSS gf180mcu_as_sc_mcu7t3v3__tap_2
XFILLER_23_907 VDD VDD VSS VSS gf180mcu_as_sc_mcu7t3v3__fill_2
XFILLER_35_756 VDD VDD VSS VSS gf180mcu_as_sc_mcu7t3v3__fill_2
XFILLER_39_1407 VDD VDD VSS VSS gf180mcu_as_sc_mcu7t3v3__fillcap_8
XFILLER_39_1418 VDD VDD VSS VSS gf180mcu_as_sc_mcu7t3v3__fillcap_16
XTAP_TAPCELL_ROW_204_2663 VDD VSS gf180mcu_as_sc_mcu7t3v3__tap_2
XTAP_TAPCELL_ROW_179_2117 VDD VSS gf180mcu_as_sc_mcu7t3v3__tap_2
XTAP_TAPCELL_ROW_179_2106 VDD VSS gf180mcu_as_sc_mcu7t3v3__tap_2
XFILLER_179_205 VDD VDD VSS VSS gf180mcu_as_sc_mcu7t3v3__fillcap_4
XFILLER_179_238 VDD VDD VSS VSS gf180mcu_as_sc_mcu7t3v3__fillcap_16
XFILLER_34_244 VDD VDD VSS VSS gf180mcu_as_sc_mcu7t3v3__fill_1
XFILLER_35_767 VDD VDD VSS VSS gf180mcu_as_sc_mcu7t3v3__fill_2
X_2963_ VDD VDD VSS VSS _2964_/C _2963_/C _3042_/C _3938_/A gf180mcu_as_sc_mcu7t3v3__aoi21_2
XTAP_TAPCELL_ROW_196_2475 VDD VSS gf180mcu_as_sc_mcu7t3v3__tap_2
XFILLER_210_529 VDD VDD VSS VSS gf180mcu_as_sc_mcu7t3v3__fill_2
X_4702_ VDD VDD VSS VSS _4705_/D _4705_/A _5250_/Q gf180mcu_as_sc_mcu7t3v3__nor2b_2
XTAP_TAPCELL_ROW_196_2486 VDD VSS gf180mcu_as_sc_mcu7t3v3__tap_2
XFILLER_175_422 VDD VDD VSS VSS gf180mcu_as_sc_mcu7t3v3__fillcap_4
XFILLER_187_282 VDD VDD VSS VSS gf180mcu_as_sc_mcu7t3v3__fillcap_8
X_2894_ VDD VDD VSS VSS _2894_/Y _3533_/C _3257_/A gf180mcu_as_sc_mcu7t3v3__nand2_2
XFILLER_15_1462 VDD VDD VSS VSS gf180mcu_as_sc_mcu7t3v3__fillcap_8
XFILLER_190_403 VDD VDD VSS VSS gf180mcu_as_sc_mcu7t3v3__fillcap_16
XFILLER_200_1011 VDD VDD VSS VSS gf180mcu_as_sc_mcu7t3v3__fillcap_4
X_4633_ VDD VDD VSS VSS _4642_/S _5121_/Q _4633_/A _5224_/D gf180mcu_as_sc_mcu7t3v3__mux2_2
XFILLER_118_18 VDD VDD VSS VSS gf180mcu_as_sc_mcu7t3v3__fillcap_16
XFILLER_11_1348 VDD VDD VSS VSS gf180mcu_as_sc_mcu7t3v3__fillcap_8
XFILLER_15_1484 VDD VDD VSS VSS gf180mcu_as_sc_mcu7t3v3__fillcap_8
XFILLER_200_1033 VDD VDD VSS VSS gf180mcu_as_sc_mcu7t3v3__fillcap_16
XPHY_EDGE_ROW_188_Right_51 VDD VSS gf180mcu_as_sc_mcu7t3v3__tap_2
X_4564_ VDD VDD VSS VSS _4564_/B _4591_/A _4565_/D gf180mcu_as_sc_mcu7t3v3__and2_2
XTAP_TAPCELL_ROW_153_3_3181 VDD VSS gf180mcu_as_sc_mcu7t3v3__tap_2
X_3515_ VDD VDD VSS VSS _3515_/D _3515_/A _3817_/A _3524_/C _3516_/B gf180mcu_as_sc_mcu7t3v3__ao31_2
XFILLER_172_1419 VDD VDD VSS VSS gf180mcu_as_sc_mcu7t3v3__fill_2
X_4495_ VDD VDD VSS VSS _5177_/Q _4592_/B _4495_/C _4495_/D _5177_/D gf180mcu_as_sc_mcu7t3v3__ao211_2
X_3446_ VDD VDD VSS VSS _3455_/B _3446_/B _3446_/C _3447_/C gf180mcu_as_sc_mcu7t3v3__nor3_2
XFILLER_174_1290 VDD VDD VSS VSS gf180mcu_as_sc_mcu7t3v3__fill_2
X_3377_ VDD VDD VSS VSS _3450_/B _4030_/D _3380_/C gf180mcu_as_sc_mcu7t3v3__and2_2
X_5116_ VDD VDD VSS VSS clkload9/A _5116_/D _5116_/Q gf180mcu_as_sc_mcu7t3v3__dfxtp_2
XFILLER_84_155 VDD VDD VSS VSS gf180mcu_as_sc_mcu7t3v3__fillcap_16
XPHY_EDGE_ROW_197_Right_60 VDD VSS gf180mcu_as_sc_mcu7t3v3__tap_2
X_5047_ VDD VDD VSS VSS clkload2/A _5047_/D _5047_/Q gf180mcu_as_sc_mcu7t3v3__dfxtp_2
XFILLER_150_27 VDD VDD VSS VSS gf180mcu_as_sc_mcu7t3v3__fillcap_8
XFILLER_84_177 VDD VDD VSS VSS gf180mcu_as_sc_mcu7t3v3__fillcap_16
XFILLER_96_1523 VDD VDD VSS VSS gf180mcu_as_sc_mcu7t3v3__fill_2
XFILLER_150_49 VDD VDD VSS VSS gf180mcu_as_sc_mcu7t3v3__fill_2
XFILLER_13_406 VDD VDD VSS VSS gf180mcu_as_sc_mcu7t3v3__fill_2
XFILLER_183_1537 VDD VDD VSS VSS gf180mcu_as_sc_mcu7t3v3__fill_2
XFILLER_25_244 VDD VDD VSS VSS gf180mcu_as_sc_mcu7t3v3__fillcap_16
XFILLER_179_783 VDD VDD VSS VSS gf180mcu_as_sc_mcu7t3v3__fillcap_4
XFILLER_43_69 VDD VDD VSS VSS gf180mcu_as_sc_mcu7t3v3__fill_1
XFILLER_159_58 VDD VDD VSS VSS gf180mcu_as_sc_mcu7t3v3__fill_1
XFILLER_194_731 VDD VDD VSS VSS gf180mcu_as_sc_mcu7t3v3__fillcap_4
XFILLER_194_753 VDD VDD VSS VSS gf180mcu_as_sc_mcu7t3v3__fillcap_16
XFILLER_22_995 VDD VDD VSS VSS gf180mcu_as_sc_mcu7t3v3__fillcap_16
XFILLER_21_483 VDD VDD VSS VSS gf180mcu_as_sc_mcu7t3v3__fillcap_4
XFILLER_153_105 VDD VDD VSS VSS gf180mcu_as_sc_mcu7t3v3__fillcap_16
XFILLER_193_274 VDD VDD VSS VSS gf180mcu_as_sc_mcu7t3v3__fillcap_4
XFILLER_193_296 VDD VDD VSS VSS gf180mcu_as_sc_mcu7t3v3__fillcap_16
XTAP_TAPCELL_ROW_21_1195 VDD VSS gf180mcu_as_sc_mcu7t3v3__tap_2
XTAP_TAPCELL_ROW_21_1184 VDD VSS gf180mcu_as_sc_mcu7t3v3__tap_2
XTAP_TAPCELL_ROW_9_933 VDD VSS gf180mcu_as_sc_mcu7t3v3__tap_2
XTAP_TAPCELL_ROW_9_922 VDD VSS gf180mcu_as_sc_mcu7t3v3__tap_2
XFILLER_161_182 VDD VDD VSS VSS gf180mcu_as_sc_mcu7t3v3__fill_1
XFILLER_191_34 VDD VDD VSS VSS gf180mcu_as_sc_mcu7t3v3__fillcap_16
XFILLER_1_877 VDD VDD VSS VSS gf180mcu_as_sc_mcu7t3v3__fillcap_8
XPHY_EDGE_ROW_147_3_Right_184 VDD VSS gf180mcu_as_sc_mcu7t3v3__tap_2
Xinput200 VDD VDD VSS VSS se_in[27] _4155_/A gf180mcu_as_sc_mcu7t3v3__buff_12
Xinput211 VDD VDD VSS VSS se_in[6] wire868/A gf180mcu_as_sc_mcu7t3v3__buff_12
XFILLER_0_376 VDD VDD VSS VSS gf180mcu_as_sc_mcu7t3v3__fillcap_4
XFILLER_27_1366 VDD VDD VSS VSS gf180mcu_as_sc_mcu7t3v3__fill_1
Xinput222 VDD VDD VSS VSS south_in[16] _4062_/A gf180mcu_as_sc_mcu7t3v3__buff_12
Xinput233 VDD VDD VSS VSS south_in[26] _4143_/D gf180mcu_as_sc_mcu7t3v3__buff_12
Xinput244 VDD VDD VSS VSS south_in[5] _3973_/D gf180mcu_as_sc_mcu7t3v3__buff_12
XFILLER_188_1426 VDD VDD VSS VSS gf180mcu_as_sc_mcu7t3v3__fillcap_8
XFILLER_188_1437 VDD VDD VSS VSS gf180mcu_as_sc_mcu7t3v3__fillcap_16
XFILLER_27_1399 VDD VDD VSS VSS gf180mcu_as_sc_mcu7t3v3__fill_1
Xinput255 VDD VDD VSS VSS sw_in[15] _4058_/A gf180mcu_as_sc_mcu7t3v3__buff_12
Xinput266 VDD VDD VSS VSS sw_in[25] _3483_/A gf180mcu_as_sc_mcu7t3v3__buff_12
Xinput277 VDD VDD VSS VSS sw_in[4] _2427_/A gf180mcu_as_sc_mcu7t3v3__buff_12
Xinput288 VDD VDD VSS VSS west_in[14] _4046_/A gf180mcu_as_sc_mcu7t3v3__buff_12
XTAP_TAPCELL_ROW_166_1_1942 VDD VSS gf180mcu_as_sc_mcu7t3v3__tap_2
XFILLER_5_1184 VDD VDD VSS VSS gf180mcu_as_sc_mcu7t3v3__fillcap_4
Xinput299 VDD VDD VSS VSS west_in[24] _4126_/D gf180mcu_as_sc_mcu7t3v3__buff_12
XFILLER_189_503 VDD VDD VSS VSS gf180mcu_as_sc_mcu7t3v3__fillcap_16
XFILLER_29_594 VDD VDD VSS VSS gf180mcu_as_sc_mcu7t3v3__fill_2
XFILLER_90_147 VDD VDD VSS VSS gf180mcu_as_sc_mcu7t3v3__fill_2
XFILLER_16_244 VDD VDD VSS VSS gf180mcu_as_sc_mcu7t3v3__fill_1
XPHY_EDGE_ROW_201_Right_64 VDD VSS gf180mcu_as_sc_mcu7t3v3__tap_2
XTAP_TAPCELL_ROW_28_1349 VDD VSS gf180mcu_as_sc_mcu7t3v3__tap_2
XTAP_TAPCELL_ROW_28_1338 VDD VSS gf180mcu_as_sc_mcu7t3v3__tap_2
XTAP_TAPCELL_ROW_146_1_1884 VDD VSS gf180mcu_as_sc_mcu7t3v3__tap_2
XTAP_TAPCELL_ROW_158_3_3196 VDD VSS gf180mcu_as_sc_mcu7t3v3__tap_2
XTAP_TAPCELL_ROW_174_2003 VDD VSS gf180mcu_as_sc_mcu7t3v3__tap_2
XFILLER_125_1465 VDD VDD VSS VSS gf180mcu_as_sc_mcu7t3v3__fill_2
XFILLER_12_461 VDD VDD VSS VSS gf180mcu_as_sc_mcu7t3v3__fill_2
XFILLER_8_421 VDD VDD VSS VSS gf180mcu_as_sc_mcu7t3v3__fillcap_16
XFILLER_129_135 VDD VDD VSS VSS gf180mcu_as_sc_mcu7t3v3__fillcap_4
XFILLER_149_80 VDD VDD VSS VSS gf180mcu_as_sc_mcu7t3v3__fillcap_4
XFILLER_184_230 VDD VDD VSS VSS gf180mcu_as_sc_mcu7t3v3__fillcap_4
XFILLER_8_454 VDD VDD VSS VSS gf180mcu_as_sc_mcu7t3v3__fill_1
XTAP_TAPCELL_ROW_191_2372 VDD VSS gf180mcu_as_sc_mcu7t3v3__tap_2
XFILLER_201_1364 VDD VDD VSS VSS gf180mcu_as_sc_mcu7t3v3__fillcap_16
XTAP_TAPCELL_ROW_191_2383 VDD VSS gf180mcu_as_sc_mcu7t3v3__tap_2
XFILLER_32_1094 VDD VDD VSS VSS gf180mcu_as_sc_mcu7t3v3__fillcap_16
XFILLER_193_1154 VDD VDD VSS VSS gf180mcu_as_sc_mcu7t3v3__fillcap_16
XFILLER_4_671 VDD VDD VSS VSS gf180mcu_as_sc_mcu7t3v3__fill_2
XPHY_EDGE_ROW_210_Right_73 VDD VSS gf180mcu_as_sc_mcu7t3v3__tap_2
X_3300_ VDD VDD VSS VSS _3947_/A _3381_/S _3382_/B _3948_/A _3301_/D gf180mcu_as_sc_mcu7t3v3__ao22_2
XFILLER_152_171 VDD VDD VSS VSS gf180mcu_as_sc_mcu7t3v3__fillcap_4
XFILLER_152_193 VDD VDD VSS VSS gf180mcu_as_sc_mcu7t3v3__fillcap_16
XFILLER_28_1119 VDD VDD VSS VSS gf180mcu_as_sc_mcu7t3v3__fillcap_4
XFILLER_3_170 VDD VDD VSS VSS gf180mcu_as_sc_mcu7t3v3__fillcap_8
X_4280_ VDD VDD VSS VSS _4281_/S _5484_/A _5114_/Q _5114_/D gf180mcu_as_sc_mcu7t3v3__mux2_2
XTAP_TAPCELL_ROW_41_3_2844 VDD VSS gf180mcu_as_sc_mcu7t3v3__tap_2
XFILLER_171_1430 VDD VDD VSS VSS gf180mcu_as_sc_mcu7t3v3__fillcap_16
XFILLER_45_1444 VDD VDD VSS VSS gf180mcu_as_sc_mcu7t3v3__fillcap_16
XFILLER_84_1493 VDD VDD VSS VSS gf180mcu_as_sc_mcu7t3v3__fillcap_16
X_3231_ VDD VDD VSS VSS _3232_/B _3515_/A _3241_/C _3231_/C gf180mcu_as_sc_mcu7t3v3__ao21_2
XFILLER_100_219 VDD VDD VSS VSS gf180mcu_as_sc_mcu7t3v3__fill_2
XFILLER_132_1414 VDD VDD VSS VSS gf180mcu_as_sc_mcu7t3v3__fill_2
XFILLER_66_111 VDD VDD VSS VSS gf180mcu_as_sc_mcu7t3v3__fill_1
X_3162_ VDD VDD VSS VSS _3179_/B _4940_/Q _3163_/D gf180mcu_as_sc_mcu7t3v3__or2_2
XTAP_TAPCELL_ROW_206_2703 VDD VSS gf180mcu_as_sc_mcu7t3v3__tap_2
XFILLER_132_1469 VDD VDD VSS VSS gf180mcu_as_sc_mcu7t3v3__fillcap_4
XFILLER_27_509 VDD VDD VSS VSS gf180mcu_as_sc_mcu7t3v3__fill_1
XTAP_TAPCELL_ROW_206_2714 VDD VSS gf180mcu_as_sc_mcu7t3v3__tap_2
XFILLER_66_177 VDD VDD VSS VSS gf180mcu_as_sc_mcu7t3v3__fillcap_8
X_3093_ VDD VDD VSS VSS _4071_/A _3233_/B _3169_/C _4072_/D _3094_/C gf180mcu_as_sc_mcu7t3v3__ao22_2
XTAP_TAPCELL_ROW_198_2526 VDD VSS gf180mcu_as_sc_mcu7t3v3__tap_2
XFILLER_208_1507 VDD VDD VSS VSS gf180mcu_as_sc_mcu7t3v3__fillcap_16
XTAP_TAPCELL_ROW_198_2537 VDD VSS gf180mcu_as_sc_mcu7t3v3__tap_2
XFILLER_143_1532 VDD VDD VSS VSS gf180mcu_as_sc_mcu7t3v3__fillcap_16
XFILLER_200_30 VDD VDD VSS VSS gf180mcu_as_sc_mcu7t3v3__fillcap_4
XFILLER_22_247 VDD VDD VSS VSS gf180mcu_as_sc_mcu7t3v3__fillcap_16
X_3995_ VDD VDD VSS VSS _3995_/B _4107_/A _4236_/B gf180mcu_as_sc_mcu7t3v3__and2_2
XFILLER_188_591 VDD VDD VSS VSS gf180mcu_as_sc_mcu7t3v3__fillcap_4
XFILLER_200_85 VDD VDD VSS VSS gf180mcu_as_sc_mcu7t3v3__fillcap_16
XFILLER_206_1275 VDD VDD VSS VSS gf180mcu_as_sc_mcu7t3v3__fillcap_16
XFILLER_210_348 VDD VDD VSS VSS gf180mcu_as_sc_mcu7t3v3__fill_1
X_2946_ VDD VDD VSS VSS _3194_/S _3218_/B _3283_/A gf180mcu_as_sc_mcu7t3v3__nand2_2
XFILLER_175_241 VDD VDD VSS VSS gf180mcu_as_sc_mcu7t3v3__fillcap_16
XFILLER_206_1297 VDD VDD VSS VSS gf180mcu_as_sc_mcu7t3v3__fillcap_16
X_2877_ VDD VDD VSS VSS _2879_/A _5262_/Q _5263_/Q gf180mcu_as_sc_mcu7t3v3__nor2_2
XFILLER_135_116 VDD VDD VSS VSS gf180mcu_as_sc_mcu7t3v3__fillcap_8
XFILLER_15_1292 VDD VDD VSS VSS gf180mcu_as_sc_mcu7t3v3__fillcap_8
XFILLER_191_734 VDD VDD VSS VSS gf180mcu_as_sc_mcu7t3v3__fillcap_16
XFILLER_198_1065 VDD VDD VSS VSS gf180mcu_as_sc_mcu7t3v3__fillcap_16
X_4616_ VDD VDD VSS VSS _5210_/Q _4624_/B _4620_/C _5211_/Q _5210_/D gf180mcu_as_sc_mcu7t3v3__ao22_2
XFILLER_190_255 VDD VDD VSS VSS gf180mcu_as_sc_mcu7t3v3__fill_2
XFILLER_198_1087 VDD VDD VSS VSS gf180mcu_as_sc_mcu7t3v3__fillcap_16
XFILLER_209_50 VDD VDD VSS VSS gf180mcu_as_sc_mcu7t3v3__fillcap_16
XFILLER_209_72 VDD VDD VSS VSS gf180mcu_as_sc_mcu7t3v3__fillcap_16
XFILLER_145_27 VDD VDD VSS VSS gf180mcu_as_sc_mcu7t3v3__fillcap_16
XFILLER_176_1363 VDD VDD VSS VSS gf180mcu_as_sc_mcu7t3v3__fill_2
XTAP_TAPCELL_ROW_102_3_3028 VDD VSS gf180mcu_as_sc_mcu7t3v3__tap_2
X_4547_ VDD VDD VSS VSS _4548_/D _4547_/B _4589_/A gf180mcu_as_sc_mcu7t3v3__nor2_2
X_4478_ VDD VDD VSS VSS _5175_/Q _4504_/B _4478_/C _4478_/D _5175_/D gf180mcu_as_sc_mcu7t3v3__ao211_2
X_3429_ VDD VDD VSS VSS _3467_/B _4077_/A _3429_/A _3431_/B gf180mcu_as_sc_mcu7t3v3__mux2_2
XFILLER_63_1555 VDD VDD VSS VSS gf180mcu_as_sc_mcu7t3v3__fill_1
XFILLER_63_1566 VDD VDD VSS VSS gf180mcu_as_sc_mcu7t3v3__fill_2
XFILLER_38_69 VDD VDD VSS VSS gf180mcu_as_sc_mcu7t3v3__fillcap_8
Xhold1110 VDD VDD VSS VSS hold1137/Y _4964_/D gf180mcu_as_sc_mcu7t3v3__clkbuff_4
Xhold1121 VDD VDD VSS VSS hold1149/Y _4970_/D gf180mcu_as_sc_mcu7t3v3__clkbuff_4
Xhold1132 VDD VDD VSS VSS _4769_/Q _2882_/B gf180mcu_as_sc_mcu7t3v3__clkbuff_4
Xclkbuf_leaf_28_clk_regs VDD VDD VSS VSS clkbuf_3_0__f_clk_regs/Y clkload1/A gf180mcu_as_sc_mcu7t3v3__clkbuff_12
Xhold1143 VDD VDD VSS VSS _4960_/Q hold1143/Y gf180mcu_as_sc_mcu7t3v3__clkbuff_4
XFILLER_148_1410 VDD VDD VSS VSS gf180mcu_as_sc_mcu7t3v3__fillcap_8
XFILLER_173_6 VDD VDD VSS VSS gf180mcu_as_sc_mcu7t3v3__fillcap_16
XFILLER_22_1274 VDD VDD VSS VSS gf180mcu_as_sc_mcu7t3v3__fill_2
XFILLER_26_531 VDD VDD VSS VSS gf180mcu_as_sc_mcu7t3v3__fill_2
XFILLER_148_1432 VDD VDD VSS VSS gf180mcu_as_sc_mcu7t3v3__fillcap_16
XFILLER_14_715 VDD VDD VSS VSS gf180mcu_as_sc_mcu7t3v3__fillcap_16
XFILLER_183_1301 VDD VDD VSS VSS gf180mcu_as_sc_mcu7t3v3__fillcap_16
XFILLER_72_147 VDD VDD VSS VSS gf180mcu_as_sc_mcu7t3v3__fillcap_16
XFILLER_148_1465 VDD VDD VSS VSS gf180mcu_as_sc_mcu7t3v3__fill_1
XFILLER_14_737 VDD VDD VSS VSS gf180mcu_as_sc_mcu7t3v3__fill_2
XFILLER_26_597 VDD VDD VSS VSS gf180mcu_as_sc_mcu7t3v3__fillcap_16
XFILLER_14_759 VDD VDD VSS VSS gf180mcu_as_sc_mcu7t3v3__fillcap_16
XFILLER_110_85 VDD VDD VSS VSS gf180mcu_as_sc_mcu7t3v3__fillcap_16
XFILLER_16_1012 VDD VDD VSS VSS gf180mcu_as_sc_mcu7t3v3__fill_2
XFILLER_186_34 VDD VDD VSS VSS gf180mcu_as_sc_mcu7t3v3__fill_1
XTAP_TAPCELL_ROW_46_3_2859 VDD VSS gf180mcu_as_sc_mcu7t3v3__tap_2
XTAP_TAPCELL_ROW_23_1246 VDD VSS gf180mcu_as_sc_mcu7t3v3__tap_2
XTAP_TAPCELL_ROW_23_1235 VDD VSS gf180mcu_as_sc_mcu7t3v3__tap_2
XFILLER_177_1116 VDD VDD VSS VSS gf180mcu_as_sc_mcu7t3v3__fillcap_4
XFILLER_182_734 VDD VDD VSS VSS gf180mcu_as_sc_mcu7t3v3__fill_1
XFILLER_6_925 VDD VDD VSS VSS gf180mcu_as_sc_mcu7t3v3__fillcap_16
XFILLER_119_72 VDD VDD VSS VSS gf180mcu_as_sc_mcu7t3v3__fillcap_16
XFILLER_177_1138 VDD VDD VSS VSS gf180mcu_as_sc_mcu7t3v3__fillcap_16
XFILLER_181_244 VDD VDD VSS VSS gf180mcu_as_sc_mcu7t3v3__fillcap_16
XFILLER_182_778 VDD VDD VSS VSS gf180mcu_as_sc_mcu7t3v3__fillcap_16
XFILLER_68_1411 VDD VDD VSS VSS gf180mcu_as_sc_mcu7t3v3__fill_2
XFILLER_194_1485 VDD VDD VSS VSS gf180mcu_as_sc_mcu7t3v3__fillcap_16
XPHY_EDGE_ROW_51_1_Left_261 VDD VSS gf180mcu_as_sc_mcu7t3v3__tap_2
XFILLER_116_1409 VDD VDD VSS VSS gf180mcu_as_sc_mcu7t3v3__fillcap_8
XFILLER_135_60 VDD VDD VSS VSS gf180mcu_as_sc_mcu7t3v3__fillcap_8
XFILLER_27_1163 VDD VDD VSS VSS gf180mcu_as_sc_mcu7t3v3__fill_2
XFILLER_48_122 VDD VDD VSS VSS gf180mcu_as_sc_mcu7t3v3__fillcap_16
XPHY_EDGE_ROW_148_3_Right_185 VDD VSS gf180mcu_as_sc_mcu7t3v3__tap_2
XFILLER_40_1352 VDD VDD VSS VSS gf180mcu_as_sc_mcu7t3v3__fill_2
XTAP_TAPCELL_ROW_201_2600 VDD VSS gf180mcu_as_sc_mcu7t3v3__tap_2
XFILLER_17_542 VDD VDD VSS VSS gf180mcu_as_sc_mcu7t3v3__fillcap_8
XFILLER_205_610 VDD VDD VSS VSS gf180mcu_as_sc_mcu7t3v3__fillcap_16
XFILLER_205_632 VDD VDD VSS VSS gf180mcu_as_sc_mcu7t3v3__fillcap_16
XFILLER_63_158 VDD VDD VSS VSS gf180mcu_as_sc_mcu7t3v3__fillcap_4
XFILLER_17_597 VDD VDD VSS VSS gf180mcu_as_sc_mcu7t3v3__fillcap_4
XFILLER_149_208 VDD VDD VSS VSS gf180mcu_as_sc_mcu7t3v3__fill_2
XTAP_TAPCELL_ROW_94_3_3002 VDD VSS gf180mcu_as_sc_mcu7t3v3__tap_2
XTAP_TAPCELL_ROW_193_2423 VDD VSS gf180mcu_as_sc_mcu7t3v3__tap_2
XTAP_TAPCELL_ROW_193_2412 VDD VSS gf180mcu_as_sc_mcu7t3v3__tap_2
XFILLER_189_399 VDD VDD VSS VSS gf180mcu_as_sc_mcu7t3v3__fillcap_16
XFILLER_44_90 VDD VDD VSS VSS gf180mcu_as_sc_mcu7t3v3__fill_2
X_3780_ VDD VDD VSS VSS _3781_/B _3780_/A _3811_/A _3780_/C gf180mcu_as_sc_mcu7t3v3__ao21_2
X_2800_ VDD VDD VSS VSS _2800_/B _2800_/A _4973_/D gf180mcu_as_sc_mcu7t3v3__and2_2
X_2731_ VDD VDD VSS VSS _2731_/S _5180_/Q _5172_/Q _2735_/B gf180mcu_as_sc_mcu7t3v3__mux2_2
XFILLER_185_594 VDD VDD VSS VSS gf180mcu_as_sc_mcu7t3v3__fillcap_16
XFILLER_8_251 VDD VDD VSS VSS gf180mcu_as_sc_mcu7t3v3__fill_2
XFILLER_199_1396 VDD VDD VSS VSS gf180mcu_as_sc_mcu7t3v3__fillcap_4
XTAP_TAPCELL_ROW_11_971 VDD VSS gf180mcu_as_sc_mcu7t3v3__tap_2
XTAP_TAPCELL_ROW_11_982 VDD VSS gf180mcu_as_sc_mcu7t3v3__tap_2
X_4401_ VDD VDD VSS VSS _4405_/B _5067_/Q _4500_/S gf180mcu_as_sc_mcu7t3v3__nand2_2
X_2662_ VDD VDD VSS VSS _2662_/D _2701_/A _2666_/B _2662_/C _2663_/C gf180mcu_as_sc_mcu7t3v3__ao31_2
XTAP_TAPCELL_ROW_62_1_1632 VDD VSS gf180mcu_as_sc_mcu7t3v3__tap_2
X_2593_ VDD VDD VSS VSS _4264_/A _5099_/Q _2597_/B gf180mcu_as_sc_mcu7t3v3__or2_2
XFILLER_125_182 VDD VDD VSS VSS gf180mcu_as_sc_mcu7t3v3__fill_1
X_4332_ VDD VDD VSS VSS _4332_/D _5270_/Q _5125_/Q _4332_/C _4334_/B gf180mcu_as_sc_mcu7t3v3__ao31_2
XFILLER_125_193 VDD VDD VSS VSS gf180mcu_as_sc_mcu7t3v3__fillcap_16
XFILLER_173_1558 VDD VDD VSS VSS gf180mcu_as_sc_mcu7t3v3__fillcap_8
X_4263_ VDD VDD VSS VSS _4263_/B _4263_/A _5098_/D gf180mcu_as_sc_mcu7t3v3__and2_2
XTAP_TAPCELL_ROW_72_3_2938 VDD VSS gf180mcu_as_sc_mcu7t3v3__tap_2
XFILLER_136_1380 VDD VDD VSS VSS gf180mcu_as_sc_mcu7t3v3__fill_1
XFILLER_140_185 VDD VDD VSS VSS gf180mcu_as_sc_mcu7t3v3__fillcap_4
X_3214_ VDD VDD VSS VSS _3227_/S _3800_/A _3796_/A _3215_/A gf180mcu_as_sc_mcu7t3v3__mux2_2
XFILLER_28_807 VDD VDD VSS VSS gf180mcu_as_sc_mcu7t3v3__fillcap_16
X_4194_ VDD VDD VSS VSS _4254_/B _4196_/B _4196_/C _5032_/Q _5032_/D gf180mcu_as_sc_mcu7t3v3__ao22_2
XFILLER_210_1419 VDD VDD VSS VSS gf180mcu_as_sc_mcu7t3v3__fill_2
X_3145_ VDD VDD VSS VSS _3145_/A _3145_/B _3145_/C _3145_/D _3147_/C gf180mcu_as_sc_mcu7t3v3__ao211_2
XFILLER_131_18 VDD VDD VSS VSS gf180mcu_as_sc_mcu7t3v3__fillcap_16
XFILLER_54_103 VDD VDD VSS VSS gf180mcu_as_sc_mcu7t3v3__fill_2
X_3076_ VDD VDD VSS VSS _4054_/A _3076_/B _3076_/C _4053_/D _3077_/C gf180mcu_as_sc_mcu7t3v3__ao22_2
XFILLER_93_1504 VDD VDD VSS VSS gf180mcu_as_sc_mcu7t3v3__fillcap_4
XFILLER_180_1507 VDD VDD VSS VSS gf180mcu_as_sc_mcu7t3v3__fillcap_16
XFILLER_23_556 VDD VDD VSS VSS gf180mcu_as_sc_mcu7t3v3__fillcap_4
XFILLER_10_206 VDD VDD VSS VSS gf180mcu_as_sc_mcu7t3v3__fillcap_16
XFILLER_11_729 VDD VDD VSS VSS gf180mcu_as_sc_mcu7t3v3__fillcap_16
XFILLER_17_1332 VDD VDD VSS VSS gf180mcu_as_sc_mcu7t3v3__fillcap_16
XFILLER_23_578 VDD VDD VSS VSS gf180mcu_as_sc_mcu7t3v3__fill_1
XFILLER_56_1392 VDD VDD VSS VSS gf180mcu_as_sc_mcu7t3v3__fillcap_16
X_3978_ VDD VDD VSS VSS _4106_/S _3978_/B _3978_/A _3979_/B gf180mcu_as_sc_mcu7t3v3__mux2_2
XFILLER_210_178 VDD VDD VSS VSS gf180mcu_as_sc_mcu7t3v3__fill_1
X_2929_ VDD VDD VSS VSS _3143_/S _3179_/B _3201_/C _3204_/C gf180mcu_as_sc_mcu7t3v3__nand3_2
XFILLER_104_1368 VDD VDD VSS VSS gf180mcu_as_sc_mcu7t3v3__fill_1
XFILLER_30_1543 VDD VDD VSS VSS gf180mcu_as_sc_mcu7t3v3__fill_1
XFILLER_40_37 VDD VDD VSS VSS gf180mcu_as_sc_mcu7t3v3__fillcap_16
XFILLER_156_37 VDD VDD VSS VSS gf180mcu_as_sc_mcu7t3v3__fillcap_16
XTAP_TAPCELL_ROW_121_3_3083 VDD VSS gf180mcu_as_sc_mcu7t3v3__tap_2
XFILLER_131_163 VDD VDD VSS VSS gf180mcu_as_sc_mcu7t3v3__fillcap_16
XFILLER_28_1461 VDD VDD VSS VSS gf180mcu_as_sc_mcu7t3v3__fill_1
Xfanout720 VDD VDD VSS VSS _3542_/Y _3727_/B gf180mcu_as_sc_mcu7t3v3__buff_12
Xfanout731 VDD VDD VSS VSS _2931_/Y _3236_/C gf180mcu_as_sc_mcu7t3v3__buff_12
Xfanout742 VDD VDD VSS VSS _2858_/Y _4749_/B gf180mcu_as_sc_mcu7t3v3__buff_12
X_4890__1077 VDD VDD VSS VSS _4890_/D gf180mcu_as_sc_mcu7t3v3__tiel_4
XFILLER_172_69 VDD VDD VSS VSS gf180mcu_as_sc_mcu7t3v3__fillcap_16
Xfanout753 VDD VDD VSS VSS _3126_/S _3075_/S gf180mcu_as_sc_mcu7t3v3__buff_12
Xfanout764 VDD VDD VSS VSS _4196_/B _4193_/B gf180mcu_as_sc_mcu7t3v3__buff_12
Xfanout775 VDD VDD VSS VSS _5271_/Q _4331_/A gf180mcu_as_sc_mcu7t3v3__buff_12
XTAP_TAPCELL_ROW_87_1_1705 VDD VSS gf180mcu_as_sc_mcu7t3v3__tap_2
XTAP_TAPCELL_ROW_16_1072 VDD VSS gf180mcu_as_sc_mcu7t3v3__tap_2
XFILLER_115_1475 VDD VDD VSS VSS gf180mcu_as_sc_mcu7t3v3__fillcap_8
XFILLER_18_317 VDD VDD VSS VSS gf180mcu_as_sc_mcu7t3v3__fillcap_16
Xfanout786 VDD VDD VSS VSS _4264_/A _4262_/A gf180mcu_as_sc_mcu7t3v3__buff_12
Xfanout797 VDD VDD VSS VSS _4585_/A _4536_/S gf180mcu_as_sc_mcu7t3v3__buff_12
XTAP_TAPCELL_ROW_99_3_3017 VDD VSS gf180mcu_as_sc_mcu7t3v3__tap_2
XTAP_TAPCELL_ROW_16_1083 VDD VSS gf180mcu_as_sc_mcu7t3v3__tap_2
XFILLER_185_1418 VDD VDD VSS VSS gf180mcu_as_sc_mcu7t3v3__fillcap_4
XFILLER_98_1459 VDD VDD VSS VSS gf180mcu_as_sc_mcu7t3v3__fill_1
XFILLER_22_1082 VDD VDD VSS VSS gf180mcu_as_sc_mcu7t3v3__fill_2
XFILLER_45_158 VDD VDD VSS VSS gf180mcu_as_sc_mcu7t3v3__fillcap_16
XFILLER_164_2 VDD VDD VSS VSS gf180mcu_as_sc_mcu7t3v3__fillcap_16
XFILLER_187_804 VDD VDD VSS VSS gf180mcu_as_sc_mcu7t3v3__fillcap_16
XFILLER_199_664 VDD VDD VSS VSS gf180mcu_as_sc_mcu7t3v3__fillcap_16
XFILLER_202_613 VDD VDD VSS VSS gf180mcu_as_sc_mcu7t3v3__fillcap_16
XTAP_TAPCELL_ROW_67_1_1647 VDD VSS gf180mcu_as_sc_mcu7t3v3__tap_2
XFILLER_14_578 VDD VDD VSS VSS gf180mcu_as_sc_mcu7t3v3__fillcap_16
XFILLER_183_1186 VDD VDD VSS VSS gf180mcu_as_sc_mcu7t3v3__fillcap_4
XFILLER_186_314 VDD VDD VSS VSS gf180mcu_as_sc_mcu7t3v3__fill_1
XFILLER_197_22 VDD VDD VSS VSS gf180mcu_as_sc_mcu7t3v3__fillcap_16
XFILLER_174_509 VDD VDD VSS VSS gf180mcu_as_sc_mcu7t3v3__fill_1
XFILLER_197_88 VDD VDD VSS VSS gf180mcu_as_sc_mcu7t3v3__fillcap_16
XFILLER_210_690 VDD VDD VSS VSS gf180mcu_as_sc_mcu7t3v3__fill_1
XFILLER_35_1487 VDD VDD VSS VSS gf180mcu_as_sc_mcu7t3v3__fillcap_16
XFILLER_114_119 VDD VDD VSS VSS gf180mcu_as_sc_mcu7t3v3__fill_2
XFILLER_159_1380 VDD VDD VSS VSS gf180mcu_as_sc_mcu7t3v3__fillcap_16
XFILLER_182_597 VDD VDD VSS VSS gf180mcu_as_sc_mcu7t3v3__fillcap_16
XFILLER_5_298 VDD VDD VSS VSS gf180mcu_as_sc_mcu7t3v3__fill_2
XFILLER_146_92 VDD VDD VSS VSS gf180mcu_as_sc_mcu7t3v3__fill_2
XFILLER_190_1135 VDD VDD VSS VSS gf180mcu_as_sc_mcu7t3v3__fillcap_16
XFILLER_190_1157 VDD VDD VSS VSS gf180mcu_as_sc_mcu7t3v3__fillcap_16
XTAP_TAPCELL_ROW_186_2271 VDD VSS gf180mcu_as_sc_mcu7t3v3__tap_2
XTAP_TAPCELL_ROW_186_2260 VDD VSS gf180mcu_as_sc_mcu7t3v3__tap_2
XFILLER_81_1463 VDD VDD VSS VSS gf180mcu_as_sc_mcu7t3v3__fill_2
XFILLER_209_212 VDD VDD VSS VSS gf180mcu_as_sc_mcu7t3v3__fillcap_16
XFILLER_42_1469 VDD VDD VSS VSS gf180mcu_as_sc_mcu7t3v3__fillcap_8
XFILLER_7_1076 VDD VDD VSS VSS gf180mcu_as_sc_mcu7t3v3__fillcap_4
XPHY_EDGE_ROW_149_3_Right_186 VDD VSS gf180mcu_as_sc_mcu7t3v3__tap_2
Xinput8 VDD VDD VSS VSS boot_addr[6] input8/Y gf180mcu_as_sc_mcu7t3v3__buff_12
XTAP_TAPCELL_ROW_182_2179 VDD VSS gf180mcu_as_sc_mcu7t3v3__tap_2
XTAP_TAPCELL_ROW_182_2168 VDD VSS gf180mcu_as_sc_mcu7t3v3__tap_2
XFILLER_162_91 VDD VDD VSS VSS gf180mcu_as_sc_mcu7t3v3__fill_2
XFILLER_91_220 VDD VDD VSS VSS gf180mcu_as_sc_mcu7t3v3__fill_2
XFILLER_206_941 VDD VDD VSS VSS gf180mcu_as_sc_mcu7t3v3__fillcap_4
X_4950_ VDD VDD VSS VSS _4977_/CLK _4950_/D _4950_/Q gf180mcu_as_sc_mcu7t3v3__dfxtp_2
X_4881_ VDD VDD VSS VSS _4924_/CLK _4881_/D _4881_/Q gf180mcu_as_sc_mcu7t3v3__dfxtp_2
X_3901_ VDD VDD VSS VSS _3908_/B _5159_/Q _4941_/D gf180mcu_as_sc_mcu7t3v3__and2_2
XFILLER_189_196 VDD VDD VSS VSS gf180mcu_as_sc_mcu7t3v3__fillcap_4
XTAP_TAPCELL_ROW_114_1_1786 VDD VSS gf180mcu_as_sc_mcu7t3v3__tap_2
XTAP_TAPCELL_ROW_126_3_3098 VDD VSS gf180mcu_as_sc_mcu7t3v3__tap_2
X_3832_ VDD VDD VSS VSS _4752_/C _4910_/Q _4753_/B gf180mcu_as_sc_mcu7t3v3__xnor2_2
XFILLER_192_317 VDD VDD VSS VSS gf180mcu_as_sc_mcu7t3v3__fillcap_4
XFILLER_203_1256 VDD VDD VSS VSS gf180mcu_as_sc_mcu7t3v3__fillcap_4
X_3763_ VDD VDD VSS VSS _4145_/A _3779_/B _3778_/B _4143_/D _3764_/D gf180mcu_as_sc_mcu7t3v3__ao22_2
XFILLER_203_1278 VDD VDD VSS VSS gf180mcu_as_sc_mcu7t3v3__fillcap_16
X_3694_ VDD VDD VSS VSS _4072_/A _3749_/B _3741_/C _4072_/D _3695_/D gf180mcu_as_sc_mcu7t3v3__ao22_2
X_2714_ VDD VDD VSS VSS _2735_/A _2714_/B _2714_/C _2736_/B _2716_/C gf180mcu_as_sc_mcu7t3v3__ao211_2
XFILLER_195_1046 VDD VDD VSS VSS gf180mcu_as_sc_mcu7t3v3__fillcap_4
X_2645_ VDD VDD VSS VSS _2658_/S _5259_/Q _5247_/Q _2646_/B gf180mcu_as_sc_mcu7t3v3__mux2_2
XFILLER_177_1480 VDD VDD VSS VSS gf180mcu_as_sc_mcu7t3v3__fillcap_4
XFILLER_195_1068 VDD VDD VSS VSS gf180mcu_as_sc_mcu7t3v3__fillcap_16
Xoutput334 VDD VDD VSS VSS _4857_/Q east_out[18] gf180mcu_as_sc_mcu7t3v3__buff_12
Xoutput323 VDD VDD VSS VSS _5484_/Y dft_rdata[6] gf180mcu_as_sc_mcu7t3v3__buff_12
XFILLER_0_909 VDD VDD VSS VSS gf180mcu_as_sc_mcu7t3v3__fillcap_4
XFILLER_138_1453 VDD VDD VSS VSS gf180mcu_as_sc_mcu7t3v3__fillcap_16
Xoutput378 VDD VDD VSS VSS _4798_/Q se_out[27] gf180mcu_as_sc_mcu7t3v3__buff_12
Xoutput367 VDD VDD VSS VSS _4788_/Q se_out[17] gf180mcu_as_sc_mcu7t3v3__buff_12
Xoutput356 VDD VDD VSS VSS _4846_/Q east_out[7] gf180mcu_as_sc_mcu7t3v3__buff_12
Xoutput345 VDD VDD VSS VSS _4867_/Q east_out[28] gf180mcu_as_sc_mcu7t3v3__buff_12
X_4315_ VDD VDD VSS VSS _4324_/S _5145_/Q _5144_/Q _5144_/D gf180mcu_as_sc_mcu7t3v3__mux2_2
X_2576_ VDD VDD VSS VSS _2576_/Y _2599_/A _2601_/D gf180mcu_as_sc_mcu7t3v3__nor2_2
XTAP_TAPCELL_ROW_91_3_2993 VDD VSS gf180mcu_as_sc_mcu7t3v3__tap_2
XFILLER_138_1497 VDD VDD VSS VSS gf180mcu_as_sc_mcu7t3v3__fill_2
Xoutput389 VDD VDD VSS VSS _4777_/Q se_out[6] gf180mcu_as_sc_mcu7t3v3__buff_12
XFILLER_113_185 VDD VDD VSS VSS gf180mcu_as_sc_mcu7t3v3__fillcap_4
XFILLER_19_27 VDD VDD VSS VSS gf180mcu_as_sc_mcu7t3v3__fillcap_16
XFILLER_60_1503 VDD VDD VSS VSS gf180mcu_as_sc_mcu7t3v3__fillcap_16
X_4246_ VDD VDD VSS VSS _4253_/S _4246_/B _5082_/Q _5082_/D gf180mcu_as_sc_mcu7t3v3__mux2_2
XFILLER_210_1205 VDD VDD VSS VSS gf180mcu_as_sc_mcu7t3v3__fillcap_4
X_4177_ VDD VDD VSS VSS _4237_/B _4193_/B _4193_/C _5015_/Q _5015_/D gf180mcu_as_sc_mcu7t3v3__ao22_2
XFILLER_210_1249 VDD VDD VSS VSS gf180mcu_as_sc_mcu7t3v3__fill_2
X_3128_ VDD VDD VSS VSS _3128_/A _3128_/B _3128_/C _3128_/D _3130_/C gf180mcu_as_sc_mcu7t3v3__ao211_2
XFILLER_27_158 VDD VDD VSS VSS gf180mcu_as_sc_mcu7t3v3__fillcap_16
XFILLER_110_1383 VDD VDD VSS VSS gf180mcu_as_sc_mcu7t3v3__fillcap_16
X_3059_ VDD VDD VSS VSS _3059_/S _4037_/D _4040_/A _3061_/B gf180mcu_as_sc_mcu7t3v3__mux2_2
XFILLER_42_139 VDD VDD VSS VSS gf180mcu_as_sc_mcu7t3v3__fillcap_4
XFILLER_184_1495 VDD VDD VSS VSS gf180mcu_as_sc_mcu7t3v3__fill_2
XFILLER_196_645 VDD VDD VSS VSS gf180mcu_as_sc_mcu7t3v3__fillcap_16
XFILLER_180_1359 VDD VDD VSS VSS gf180mcu_as_sc_mcu7t3v3__fillcap_4
XFILLER_184_807 VDD VDD VSS VSS gf180mcu_as_sc_mcu7t3v3__fillcap_4
XFILLER_196_667 VDD VDD VSS VSS gf180mcu_as_sc_mcu7t3v3__fillcap_16
XFILLER_208_1189 VDD VDD VSS VSS gf180mcu_as_sc_mcu7t3v3__fillcap_16
XFILLER_50_172 VDD VDD VSS VSS gf180mcu_as_sc_mcu7t3v3__fill_2
XFILLER_136_200 VDD VDD VSS VSS gf180mcu_as_sc_mcu7t3v3__fillcap_8
XFILLER_17_1173 VDD VDD VSS VSS gf180mcu_as_sc_mcu7t3v3__fillcap_4
XFILLER_183_306 VDD VDD VSS VSS gf180mcu_as_sc_mcu7t3v3__fill_1
XFILLER_51_69 VDD VDD VSS VSS gf180mcu_as_sc_mcu7t3v3__fill_1
XFILLER_7_508 VDD VDD VSS VSS gf180mcu_as_sc_mcu7t3v3__fill_2
XFILLER_13_1048 VDD VDD VSS VSS gf180mcu_as_sc_mcu7t3v3__fill_2
XTAP_TAPCELL_ROW_140_1_1865 VDD VSS gf180mcu_as_sc_mcu7t3v3__tap_2
XTAP_TAPCELL_ROW_152_3_3177 VDD VSS gf180mcu_as_sc_mcu7t3v3__tap_2
XFILLER_191_1433 VDD VDD VSS VSS gf180mcu_as_sc_mcu7t3v3__fill_1
XFILLER_65_1414 VDD VDD VSS VSS gf180mcu_as_sc_mcu7t3v3__fill_2
XFILLER_65_1436 VDD VDD VSS VSS gf180mcu_as_sc_mcu7t3v3__fillcap_16
XTAP_TAPCELL_ROW_18_1123 VDD VSS gf180mcu_as_sc_mcu7t3v3__tap_2
XFILLER_104_174 VDD VDD VSS VSS gf180mcu_as_sc_mcu7t3v3__fill_1
XFILLER_117_1526 VDD VDD VSS VSS gf180mcu_as_sc_mcu7t3v3__fillcap_4
XFILLER_152_1406 VDD VDD VSS VSS gf180mcu_as_sc_mcu7t3v3__fillcap_8
XTAP_TAPCELL_ROW_18_1134 VDD VSS gf180mcu_as_sc_mcu7t3v3__tap_2
XFILLER_191_1488 VDD VDD VSS VSS gf180mcu_as_sc_mcu7t3v3__fillcap_8
Xfanout550 VDD VDD VSS VSS _4533_/A _4591_/A gf180mcu_as_sc_mcu7t3v3__buff_12
XFILLER_65_209 VDD VDD VSS VSS gf180mcu_as_sc_mcu7t3v3__fill_1
Xfanout561 VDD VDD VSS VSS _4141_/B _4043_/B gf180mcu_as_sc_mcu7t3v3__buff_12
Xfanout572 VDD VDD VSS VSS _3561_/Y _3726_/B gf180mcu_as_sc_mcu7t3v3__buff_12
Xfanout583 VDD VDD VSS VSS _3278_/Y _3504_/B gf180mcu_as_sc_mcu7t3v3__buff_12
XTAP_TAPCELL_ROW_35_1492 VDD VSS gf180mcu_as_sc_mcu7t3v3__tap_2
XFILLER_24_1177 VDD VDD VSS VSS gf180mcu_as_sc_mcu7t3v3__fill_1
XFILLER_76_99 VDD VDD VSS VSS gf180mcu_as_sc_mcu7t3v3__fillcap_4
XPHY_EDGE_ROW_90_1_Right_611 VDD VSS gf180mcu_as_sc_mcu7t3v3__tap_2
Xfanout594 VDD VDD VSS VSS _4196_/C _4191_/C gf180mcu_as_sc_mcu7t3v3__buff_12
XFILLER_73_220 VDD VDD VSS VSS gf180mcu_as_sc_mcu7t3v3__fill_2
XTAP_TAPCELL_ROW_2_780 VDD VSS gf180mcu_as_sc_mcu7t3v3__tap_2
XFILLER_33_139 VDD VDD VSS VSS gf180mcu_as_sc_mcu7t3v3__fill_1
XFILLER_92_87 VDD VDD VSS VSS gf180mcu_as_sc_mcu7t3v3__fillcap_4
XPHY_EDGE_ROW_14_Left_225 VDD VSS gf180mcu_as_sc_mcu7t3v3__tap_2
XFILLER_203_944 VDD VDD VSS VSS gf180mcu_as_sc_mcu7t3v3__fillcap_16
XFILLER_30_802 VDD VDD VSS VSS gf180mcu_as_sc_mcu7t3v3__fill_2
XFILLER_163_1568 VDD VDD VSS VSS gf180mcu_as_sc_mcu7t3v3__fill_1
XFILLER_35_1240 VDD VDD VSS VSS gf180mcu_as_sc_mcu7t3v3__fillcap_16
XFILLER_126_1390 VDD VDD VSS VSS gf180mcu_as_sc_mcu7t3v3__fillcap_8
XFILLER_186_177 VDD VDD VSS VSS gf180mcu_as_sc_mcu7t3v3__fillcap_4
XFILLER_204_1543 VDD VDD VSS VSS gf180mcu_as_sc_mcu7t3v3__fill_1
XFILLER_31_1104 VDD VDD VSS VSS gf180mcu_as_sc_mcu7t3v3__fillcap_8
XFILLER_35_1262 VDD VDD VSS VSS gf180mcu_as_sc_mcu7t3v3__fillcap_8
XFILLER_10_570 VDD VDD VSS VSS gf180mcu_as_sc_mcu7t3v3__fillcap_16
XFILLER_182_361 VDD VDD VSS VSS gf180mcu_as_sc_mcu7t3v3__fillcap_16
XPHY_EDGE_ROW_23_Left_234 VDD VSS gf180mcu_as_sc_mcu7t3v3__tap_2
X_2430_ VDD VDD VSS VSS _4003_/A _2430_/A gf180mcu_as_sc_mcu7t3v3__inv_2
XTAP_TAPCELL_ROW_188_2311 VDD VSS gf180mcu_as_sc_mcu7t3v3__tap_2
XTAP_TAPCELL_ROW_188_2300 VDD VSS gf180mcu_as_sc_mcu7t3v3__tap_2
XFILLER_196_1399 VDD VDD VSS VSS gf180mcu_as_sc_mcu7t3v3__fillcap_16
XTAP_TAPCELL_ROW_184_2219 VDD VSS gf180mcu_as_sc_mcu7t3v3__tap_2
XFILLER_170_1539 VDD VDD VSS VSS gf180mcu_as_sc_mcu7t3v3__fill_2
XFILLER_29_1099 VDD VDD VSS VSS gf180mcu_as_sc_mcu7t3v3__fillcap_16
XFILLER_9_1149 VDD VDD VSS VSS gf180mcu_as_sc_mcu7t3v3__fillcap_16
X_5080_ VDD VDD VSS VSS clkload2/A _5080_/D _5080_/Q gf180mcu_as_sc_mcu7t3v3__dfxtp_2
X_4100_ VDD VDD VSS VSS _4998_/Q _4158_/B _4249_/B _4117_/D _4998_/D gf180mcu_as_sc_mcu7t3v3__ao22_2
XFILLER_1_290 VDD VDD VSS VSS gf180mcu_as_sc_mcu7t3v3__fill_2
XFILLER_46_1380 VDD VDD VSS VSS gf180mcu_as_sc_mcu7t3v3__fill_1
X_4031_ VDD VDD VSS VSS _4031_/A _4031_/B _4031_/C _4031_/D _4033_/C gf180mcu_as_sc_mcu7t3v3__ao211_2
XFILLER_110_177 VDD VDD VSS VSS gf180mcu_as_sc_mcu7t3v3__fillcap_4
XFILLER_64_220 VDD VDD VSS VSS gf180mcu_as_sc_mcu7t3v3__fill_2
XPHY_EDGE_ROW_32_Left_243 VDD VSS gf180mcu_as_sc_mcu7t3v3__tap_2
XTAP_TAPCELL_ROW_0_706 VDD VSS gf180mcu_as_sc_mcu7t3v3__tap_2
XTAP_TAPCELL_ROW_0_717 VDD VSS gf180mcu_as_sc_mcu7t3v3__tap_2
XTAP_TAPCELL_ROW_0_728 VDD VSS gf180mcu_as_sc_mcu7t3v3__tap_2
XTAP_TAPCELL_ROW_67_3_2922 VDD VSS gf180mcu_as_sc_mcu7t3v3__tap_2
XTAP_TAPCELL_ROW_0_739 VDD VSS gf180mcu_as_sc_mcu7t3v3__tap_2
XFILLER_178_601 VDD VDD VSS VSS gf180mcu_as_sc_mcu7t3v3__fill_2
X_4933_ VDD VDD VSS VSS _4933_/CLK _4933_/D _4933_/Q gf180mcu_as_sc_mcu7t3v3__dfxtp_2
XFILLER_36_1004 VDD VDD VSS VSS gf180mcu_as_sc_mcu7t3v3__fillcap_16
XFILLER_90_1518 VDD VDD VSS VSS gf180mcu_as_sc_mcu7t3v3__fill_2
XANTENNA_13 VDD VDD VSS VSS _4861_/D gf180mcu_as_sc_mcu7t3v3__diode_2
XFILLER_178_667 VDD VDD VSS VSS gf180mcu_as_sc_mcu7t3v3__fillcap_4
XFILLER_32_172 VDD VDD VSS VSS gf180mcu_as_sc_mcu7t3v3__fill_2
X_4864_ VDD VDD VSS VSS _5197_/CLK _4864_/D _4864_/Q gf180mcu_as_sc_mcu7t3v3__dfxtp_2
XANTENNA_24 VDD VDD VSS VSS _3015_/B gf180mcu_as_sc_mcu7t3v3__diode_2
XFILLER_144_1490 VDD VDD VSS VSS gf180mcu_as_sc_mcu7t3v3__fillcap_4
XFILLER_14_1313 VDD VDD VSS VSS gf180mcu_as_sc_mcu7t3v3__fill_1
XFILLER_14_1324 VDD VDD VSS VSS gf180mcu_as_sc_mcu7t3v3__fillcap_8
XFILLER_177_166 VDD VDD VSS VSS gf180mcu_as_sc_mcu7t3v3__fill_2
XFILLER_193_626 VDD VDD VSS VSS gf180mcu_as_sc_mcu7t3v3__fillcap_4
X_4795_ VDD VDD VSS VSS _4869_/CLK _4795_/D _4795_/Q gf180mcu_as_sc_mcu7t3v3__dfxtp_2
X_3815_ VDD VDD VSS VSS _3929_/B _3914_/B _3914_/A gf180mcu_as_sc_mcu7t3v3__nand2_2
XFILLER_177_199 VDD VDD VSS VSS gf180mcu_as_sc_mcu7t3v3__fillcap_4
XFILLER_193_648 VDD VDD VSS VSS gf180mcu_as_sc_mcu7t3v3__fillcap_16
X_3746_ VDD VDD VSS VSS _3746_/A _3758_/D _3746_/C _3746_/Y _3746_/D gf180mcu_as_sc_mcu7t3v3__aoi211_2
XFILLER_179_1542 VDD VDD VSS VSS gf180mcu_as_sc_mcu7t3v3__fill_2
XFILLER_12_1070 VDD VDD VSS VSS gf180mcu_as_sc_mcu7t3v3__fillcap_4
X_3677_ VDD VDD VSS VSS _4055_/A _3724_/B _3724_/C _4054_/A _3678_/C gf180mcu_as_sc_mcu7t3v3__ao22_2
X_2628_ VDD VDD VSS VSS _2701_/A _2628_/B input4/Y _2629_/A gf180mcu_as_sc_mcu7t3v3__mux2_2
X_2559_ VDD VDD VSS VSS _2559_/B _4328_/A _4956_/D gf180mcu_as_sc_mcu7t3v3__and2_2
XFILLER_101_100 VDD VDD VSS VSS gf180mcu_as_sc_mcu7t3v3__fill_1
XFILLER_153_27 VDD VDD VSS VSS gf180mcu_as_sc_mcu7t3v3__fillcap_16
X_5278_ VDD VDD VSS VSS _5278_/CLK _5278_/D _5278_/Q gf180mcu_as_sc_mcu7t3v3__dfxtp_2
XFILLER_99_1510 VDD VDD VSS VSS gf180mcu_as_sc_mcu7t3v3__fill_1
XTAP_TAPCELL_ROW_13_1020 VDD VSS gf180mcu_as_sc_mcu7t3v3__tap_2
X_4229_ VDD VDD VSS VSS _4253_/S _4229_/B _5065_/Q _5065_/D gf180mcu_as_sc_mcu7t3v3__mux2_2
XFILLER_101_199 VDD VDD VSS VSS gf180mcu_as_sc_mcu7t3v3__fill_1
XFILLER_210_1013 VDD VDD VSS VSS gf180mcu_as_sc_mcu7t3v3__fillcap_4
XTAP_TAPCELL_ROW_128_3_3106 VDD VSS gf180mcu_as_sc_mcu7t3v3__tap_2
XFILLER_112_1478 VDD VDD VSS VSS gf180mcu_as_sc_mcu7t3v3__fillcap_4
XFILLER_60_1399 VDD VDD VSS VSS gf180mcu_as_sc_mcu7t3v3__fill_2
XFILLER_95_1418 VDD VDD VSS VSS gf180mcu_as_sc_mcu7t3v3__fillcap_4
XFILLER_15_106 VDD VDD VSS VSS gf180mcu_as_sc_mcu7t3v3__fill_1
XFILLER_186_1568 VDD VDD VSS VSS gf180mcu_as_sc_mcu7t3v3__fill_1
XFILLER_46_69 VDD VDD VSS VSS gf180mcu_as_sc_mcu7t3v3__fillcap_16
XFILLER_95_1429 VDD VDD VSS VSS gf180mcu_as_sc_mcu7t3v3__fillcap_16
XFILLER_102_53 VDD VDD VSS VSS gf180mcu_as_sc_mcu7t3v3__fillcap_16
XFILLER_149_1390 VDD VDD VSS VSS gf180mcu_as_sc_mcu7t3v3__fillcap_16
XFILLER_19_1224 VDD VDD VSS VSS gf180mcu_as_sc_mcu7t3v3__fill_2
XFILLER_196_453 VDD VDD VSS VSS gf180mcu_as_sc_mcu7t3v3__fill_2
XFILLER_197_976 VDD VDD VSS VSS gf180mcu_as_sc_mcu7t3v3__fillcap_4
XFILLER_19_1246 VDD VDD VSS VSS gf180mcu_as_sc_mcu7t3v3__fillcap_4
XPHY_EDGE_ROW_60_1_Left_270 VDD VSS gf180mcu_as_sc_mcu7t3v3__tap_2
XFILLER_123_1530 VDD VDD VSS VSS gf180mcu_as_sc_mcu7t3v3__fill_1
XFILLER_168_177 VDD VDD VSS VSS gf180mcu_as_sc_mcu7t3v3__fillcap_8
XFILLER_180_1189 VDD VDD VSS VSS gf180mcu_as_sc_mcu7t3v3__fillcap_16
XFILLER_197_998 VDD VDD VSS VSS gf180mcu_as_sc_mcu7t3v3__fillcap_16
XFILLER_200_947 VDD VDD VSS VSS gf180mcu_as_sc_mcu7t3v3__fillcap_16
XFILLER_183_136 VDD VDD VSS VSS gf180mcu_as_sc_mcu7t3v3__fillcap_4
XFILLER_7_338 VDD VDD VSS VSS gf180mcu_as_sc_mcu7t3v3__fillcap_8
XFILLER_8_839 VDD VDD VSS VSS gf180mcu_as_sc_mcu7t3v3__fillcap_16
XFILLER_11_50 VDD VDD VSS VSS gf180mcu_as_sc_mcu7t3v3__fillcap_16
XFILLER_194_34 VDD VDD VSS VSS gf180mcu_as_sc_mcu7t3v3__fill_1
XFILLER_11_72 VDD VDD VSS VSS gf180mcu_as_sc_mcu7t3v3__fillcap_16
XFILLER_191_180 VDD VDD VSS VSS gf180mcu_as_sc_mcu7t3v3__fillcap_8
XFILLER_193_1539 VDD VDD VSS VSS gf180mcu_as_sc_mcu7t3v3__fill_1
XTAP_TAPCELL_ROW_171_1_1959 VDD VSS gf180mcu_as_sc_mcu7t3v3__tap_2
XFILLER_127_72 VDD VDD VSS VSS gf180mcu_as_sc_mcu7t3v3__fillcap_16
XFILLER_87_32 VDD VDD VSS VSS gf180mcu_as_sc_mcu7t3v3__fillcap_16
XFILLER_156_1383 VDD VDD VSS VSS gf180mcu_as_sc_mcu7t3v3__fill_1
XFILLER_87_76 VDD VDD VSS VSS gf180mcu_as_sc_mcu7t3v3__fill_1
XFILLER_38_209 VDD VDD VSS VSS gf180mcu_as_sc_mcu7t3v3__fillcap_8
XTAP_TAPCELL_ROW_7_894 VDD VSS gf180mcu_as_sc_mcu7t3v3__tap_2
XTAP_TAPCELL_ROW_7_883 VDD VSS gf180mcu_as_sc_mcu7t3v3__tap_2
XFILLER_189_1170 VDD VDD VSS VSS gf180mcu_as_sc_mcu7t3v3__fillcap_16
XFILLER_207_524 VDD VDD VSS VSS gf180mcu_as_sc_mcu7t3v3__fillcap_16
XFILLER_35_905 VDD VDD VSS VSS gf180mcu_as_sc_mcu7t3v3__fillcap_4
XPHY_EDGE_ROW_91_1_Right_612 VDD VSS gf180mcu_as_sc_mcu7t3v3__tap_2
XFILLER_189_1192 VDD VDD VSS VSS gf180mcu_as_sc_mcu7t3v3__fillcap_16
XFILLER_19_489 VDD VDD VSS VSS gf180mcu_as_sc_mcu7t3v3__fill_1
XFILLER_61_212 VDD VDD VSS VSS gf180mcu_as_sc_mcu7t3v3__fillcap_8
XFILLER_76_1373 VDD VDD VSS VSS gf180mcu_as_sc_mcu7t3v3__fillcap_8
XFILLER_14_172 VDD VDD VSS VSS gf180mcu_as_sc_mcu7t3v3__fill_2
XTAP_TAPCELL_ROW_177_2067 VDD VSS gf180mcu_as_sc_mcu7t3v3__tap_2
XTAP_TAPCELL_ROW_177_2056 VDD VSS gf180mcu_as_sc_mcu7t3v3__tap_2
XFILLER_163_1387 VDD VDD VSS VSS gf180mcu_as_sc_mcu7t3v3__fillcap_16
XFILLER_175_648 VDD VDD VSS VSS gf180mcu_as_sc_mcu7t3v3__fillcap_8
XFILLER_202_295 VDD VDD VSS VSS gf180mcu_as_sc_mcu7t3v3__fillcap_16
Xinput11 VDD VDD VSS VSS boot_addr[9] _2675_/A gf180mcu_as_sc_mcu7t3v3__buff_12
Xinput22 VDD VDD VSS VSS dft_addr[0] _2604_/B gf180mcu_as_sc_mcu7t3v3__buff_12
X_4580_ VDD VDD VSS VSS _4581_/D _4580_/B _4581_/A gf180mcu_as_sc_mcu7t3v3__nor2_2
X_3600_ VDD VDD VSS VSS _3601_/C _3600_/C _3660_/B _3969_/A gf180mcu_as_sc_mcu7t3v3__aoi21_2
XFILLER_174_169 VDD VDD VSS VSS gf180mcu_as_sc_mcu7t3v3__fill_1
XFILLER_190_629 VDD VDD VSS VSS gf180mcu_as_sc_mcu7t3v3__fillcap_16
XFILLER_50_1568 VDD VDD VSS VSS gf180mcu_as_sc_mcu7t3v3__fill_1
Xinput33 VDD VDD VSS VSS dft_ce _2586_/B gf180mcu_as_sc_mcu7t3v3__buff_12
Xinput44 VDD VDD VSS VSS east_in[0] wire857/A gf180mcu_as_sc_mcu7t3v3__buff_12
Xinput55 VDD VDD VSS VSS east_in[1] _3942_/A gf180mcu_as_sc_mcu7t3v3__buff_12
X_3531_ VDD VDD VSS VSS _3551_/A _3807_/B _3531_/A gf180mcu_as_sc_mcu7t3v3__nand2_2
XFILLER_200_1259 VDD VDD VSS VSS gf180mcu_as_sc_mcu7t3v3__fillcap_16
Xinput66 VDD VDD VSS VSS east_in[2] _3951_/A gf180mcu_as_sc_mcu7t3v3__buff_12
Xinput77 VDD VDD VSS VSS east_in[9] wire834/A gf180mcu_as_sc_mcu7t3v3__buff_12
Xinput88 VDD VDD VSS VSS ne_in[19] _4085_/A gf180mcu_as_sc_mcu7t3v3__buff_12
Xinput99 VDD VDD VSS VSS ne_in[29] _3791_/A gf180mcu_as_sc_mcu7t3v3__buff_12
X_3462_ VDD VDD VSS VSS _3476_/D _3462_/B _3462_/C _3463_/C gf180mcu_as_sc_mcu7t3v3__nor3_2
XFILLER_192_1049 VDD VDD VSS VSS gf180mcu_as_sc_mcu7t3v3__fillcap_16
X_5201_ VDD VDD VSS VSS _5216_/CLK _5201_/D _5201_/Q gf180mcu_as_sc_mcu7t3v3__dfxtp_2
X_3393_ VDD VDD VSS VSS _4929_/Q _3448_/B _3448_/C _4045_/A _3395_/C gf180mcu_as_sc_mcu7t3v3__ao22_2
X_2413_ VDD VDD VSS VSS _2844_/C _5126_/Q gf180mcu_as_sc_mcu7t3v3__inv_2
XFILLER_135_1434 VDD VDD VSS VSS gf180mcu_as_sc_mcu7t3v3__fillcap_4
XFILLER_48_1497 VDD VDD VSS VSS gf180mcu_as_sc_mcu7t3v3__fillcap_16
X_5132_ VDD VDD VSS VSS _5198_/CLK _5132_/D _5132_/Q gf180mcu_as_sc_mcu7t3v3__dfxtp_2
Xclkbuf_1_0__f_clk VDD VDD VSS VSS clkbuf_0_clk/Y clkbuf_1_0__f_clk/Y gf180mcu_as_sc_mcu7t3v3__clkbuff_12
XFILLER_135_1467 VDD VDD VSS VSS gf180mcu_as_sc_mcu7t3v3__fillcap_8
XTAP_TAPCELL_ROW_88_1_1710 VDD VSS gf180mcu_as_sc_mcu7t3v3__tap_2
X_5063_ VDD VDD VSS VSS clkload3/A _5063_/D _5063_/Q gf180mcu_as_sc_mcu7t3v3__dfxtp_2
XTAP_TAPCELL_ROW_209_2778 VDD VSS gf180mcu_as_sc_mcu7t3v3__tap_2
XTAP_TAPCELL_ROW_209_2767 VDD VSS gf180mcu_as_sc_mcu7t3v3__tap_2
XFILLER_37_220 VDD VDD VSS VSS gf180mcu_as_sc_mcu7t3v3__fill_2
X_4014_ VDD VDD VSS VSS _4014_/A _4102_/B _4102_/C _4925_/Q _4015_/D gf180mcu_as_sc_mcu7t3v3__ao22_2
XFILLER_26_916 VDD VDD VSS VSS gf180mcu_as_sc_mcu7t3v3__fillcap_8
XFILLER_0_1455 VDD VDD VSS VSS gf180mcu_as_sc_mcu7t3v3__fillcap_4
XFILLER_146_1530 VDD VDD VSS VSS gf180mcu_as_sc_mcu7t3v3__fillcap_8
XFILLER_197_206 VDD VDD VSS VSS gf180mcu_as_sc_mcu7t3v3__fillcap_4
XFILLER_197_228 VDD VDD VSS VSS gf180mcu_as_sc_mcu7t3v3__fillcap_16
XFILLER_209_1240 VDD VDD VSS VSS gf180mcu_as_sc_mcu7t3v3__fillcap_16
XFILLER_34_971 VDD VDD VSS VSS gf180mcu_as_sc_mcu7t3v3__fillcap_4
XFILLER_179_976 VDD VDD VSS VSS gf180mcu_as_sc_mcu7t3v3__fillcap_4
XFILLER_209_1262 VDD VDD VSS VSS gf180mcu_as_sc_mcu7t3v3__fillcap_16
XFILLER_33_470 VDD VDD VSS VSS gf180mcu_as_sc_mcu7t3v3__fillcap_8
X_4916_ VDD VDD VSS VSS _4916_/CLK _4916_/D _4916_/Q gf180mcu_as_sc_mcu7t3v3__dfxtp_2
XFILLER_107_1558 VDD VDD VSS VSS gf180mcu_as_sc_mcu7t3v3__fillcap_8
XFILLER_179_998 VDD VDD VSS VSS gf180mcu_as_sc_mcu7t3v3__fillcap_16
XFILLER_193_412 VDD VDD VSS VSS gf180mcu_as_sc_mcu7t3v3__fillcap_8
XFILLER_194_913 VDD VDD VSS VSS gf180mcu_as_sc_mcu7t3v3__fillcap_16
XFILLER_20_131 VDD VDD VSS VSS gf180mcu_as_sc_mcu7t3v3__fill_2
XFILLER_21_632 VDD VDD VSS VSS gf180mcu_as_sc_mcu7t3v3__fillcap_16
XFILLER_32_27 VDD VDD VSS VSS gf180mcu_as_sc_mcu7t3v3__fillcap_8
XFILLER_33_492 VDD VDD VSS VSS gf180mcu_as_sc_mcu7t3v3__fillcap_8
XPHY_EDGE_ROW_164_3_Left_549 VDD VSS gf180mcu_as_sc_mcu7t3v3__tap_2
X_4847_ VDD VDD VSS VSS _5276_/CLK _4847_/D _4847_/Q gf180mcu_as_sc_mcu7t3v3__dfxtp_2
XFILLER_193_434 VDD VDD VSS VSS gf180mcu_as_sc_mcu7t3v3__fill_1
XFILLER_14_1154 VDD VDD VSS VSS gf180mcu_as_sc_mcu7t3v3__fill_1
XFILLER_194_979 VDD VDD VSS VSS gf180mcu_as_sc_mcu7t3v3__fillcap_16
X_4778_ VDD VDD VSS VSS _5142_/CLK _4778_/D _4778_/Q gf180mcu_as_sc_mcu7t3v3__dfxtp_2
X_3729_ VDD VDD VSS VSS _3730_/C _3729_/C _3729_/B _4105_/A gf180mcu_as_sc_mcu7t3v3__aoi21_2
XTAP_TAPCELL_ROW_61_1_1628 VDD VSS gf180mcu_as_sc_mcu7t3v3__tap_2
XFILLER_180_139 VDD VDD VSS VSS gf180mcu_as_sc_mcu7t3v3__fillcap_16
XFILLER_66_1520 VDD VDD VSS VSS gf180mcu_as_sc_mcu7t3v3__fill_1
XFILLER_164_37 VDD VDD VSS VSS gf180mcu_as_sc_mcu7t3v3__fillcap_8
XFILLER_192_1550 VDD VDD VSS VSS gf180mcu_as_sc_mcu7t3v3__fillcap_16
XFILLER_87_120 VDD VDD VSS VSS gf180mcu_as_sc_mcu7t3v3__fillcap_8
XFILLER_57_68 VDD VDD VSS VSS gf180mcu_as_sc_mcu7t3v3__fill_2
XFILLER_9_1491 VDD VDD VSS VSS gf180mcu_as_sc_mcu7t3v3__fill_1
XTAP_TAPCELL_ROW_147_3_3161 VDD VSS gf180mcu_as_sc_mcu7t3v3__tap_2
XTAP_TAPCELL_ROW_4_820 VDD VSS gf180mcu_as_sc_mcu7t3v3__tap_2
XTAP_TAPCELL_ROW_32_1440 VDD VSS gf180mcu_as_sc_mcu7t3v3__tap_2
XFILLER_180_69 VDD VDD VSS VSS gf180mcu_as_sc_mcu7t3v3__fillcap_16
XFILLER_25_1294 VDD VDD VSS VSS gf180mcu_as_sc_mcu7t3v3__fillcap_16
XFILLER_29_732 VDD VDD VSS VSS gf180mcu_as_sc_mcu7t3v3__fill_1
XFILLER_5_1366 VDD VDD VSS VSS gf180mcu_as_sc_mcu7t3v3__fill_2
XFILLER_1_1208 VDD VDD VSS VSS gf180mcu_as_sc_mcu7t3v3__fill_2
XFILLER_28_275 VDD VDD VSS VSS gf180mcu_as_sc_mcu7t3v3__fill_1
XFILLER_189_718 VDD VDD VSS VSS gf180mcu_as_sc_mcu7t3v3__fillcap_16
XFILLER_204_505 VDD VDD VSS VSS gf180mcu_as_sc_mcu7t3v3__fillcap_16
XFILLER_204_527 VDD VDD VSS VSS gf180mcu_as_sc_mcu7t3v3__fillcap_16
XFILLER_43_212 VDD VDD VSS VSS gf180mcu_as_sc_mcu7t3v3__fillcap_8
XFILLER_19_1043 VDD VDD VSS VSS gf180mcu_as_sc_mcu7t3v3__fillcap_4
XTAP_TAPCELL_ROW_115_1_1791 VDD VSS gf180mcu_as_sc_mcu7t3v3__tap_2
XFILLER_11_120 VDD VDD VSS VSS gf180mcu_as_sc_mcu7t3v3__fillcap_4
XFILLER_34_1519 VDD VDD VSS VSS gf180mcu_as_sc_mcu7t3v3__fill_1
XFILLER_73_1568 VDD VDD VSS VSS gf180mcu_as_sc_mcu7t3v3__fill_1
XFILLER_11_142 VDD VDD VSS VSS gf180mcu_as_sc_mcu7t3v3__fillcap_16
XFILLER_12_687 VDD VDD VSS VSS gf180mcu_as_sc_mcu7t3v3__fill_2
XFILLER_156_114 VDD VDD VSS VSS gf180mcu_as_sc_mcu7t3v3__fillcap_16
XFILLER_196_283 VDD VDD VSS VSS gf180mcu_as_sc_mcu7t3v3__fill_2
XFILLER_32_1221 VDD VDD VSS VSS gf180mcu_as_sc_mcu7t3v3__fillcap_4
XTAP_TAPCELL_ROW_26_1299 VDD VSS gf180mcu_as_sc_mcu7t3v3__tap_2
XFILLER_8_658 VDD VDD VSS VSS gf180mcu_as_sc_mcu7t3v3__fillcap_4
XFILLER_123_1393 VDD VDD VSS VSS gf180mcu_as_sc_mcu7t3v3__fillcap_16
XFILLER_197_1450 VDD VDD VSS VSS gf180mcu_as_sc_mcu7t3v3__fillcap_16
XFILLER_197_1472 VDD VDD VSS VSS gf180mcu_as_sc_mcu7t3v3__fillcap_16
XFILLER_171_139 VDD VDD VSS VSS gf180mcu_as_sc_mcu7t3v3__fill_1
XFILLER_180_651 VDD VDD VSS VSS gf180mcu_as_sc_mcu7t3v3__fillcap_8
XFILLER_98_53 VDD VDD VSS VSS gf180mcu_as_sc_mcu7t3v3__fillcap_16
XFILLER_26_1014 VDD VDD VSS VSS gf180mcu_as_sc_mcu7t3v3__fill_1
XFILLER_80_1517 VDD VDD VSS VSS gf180mcu_as_sc_mcu7t3v3__fillcap_4
XFILLER_154_81 VDD VDD VSS VSS gf180mcu_as_sc_mcu7t3v3__fill_2
XFILLER_26_1025 VDD VDD VSS VSS gf180mcu_as_sc_mcu7t3v3__fillcap_4
XFILLER_6_1119 VDD VDD VSS VSS gf180mcu_as_sc_mcu7t3v3__fillcap_16
XFILLER_78_142 VDD VDD VSS VSS gf180mcu_as_sc_mcu7t3v3__fillcap_8
XPHY_EDGE_ROW_201_Left_411 VDD VSS gf180mcu_as_sc_mcu7t3v3__tap_2
XFILLER_130_1364 VDD VDD VSS VSS gf180mcu_as_sc_mcu7t3v3__fill_2
XFILLER_19_242 VDD VDD VSS VSS gf180mcu_as_sc_mcu7t3v3__fill_1
XFILLER_35_702 VDD VDD VSS VSS gf180mcu_as_sc_mcu7t3v3__fill_1
XFILLER_208_877 VDD VDD VSS VSS gf180mcu_as_sc_mcu7t3v3__fillcap_4
XFILLER_34_212 VDD VDD VSS VSS gf180mcu_as_sc_mcu7t3v3__fillcap_16
XPHY_EDGE_ROW_92_1_Right_613 VDD VSS gf180mcu_as_sc_mcu7t3v3__tap_2
XTAP_TAPCELL_ROW_204_2664 VDD VSS gf180mcu_as_sc_mcu7t3v3__tap_2
XTAP_TAPCELL_ROW_204_2653 VDD VSS gf180mcu_as_sc_mcu7t3v3__tap_2
XTAP_TAPCELL_ROW_179_2118 VDD VSS gf180mcu_as_sc_mcu7t3v3__tap_2
XTAP_TAPCELL_ROW_179_2107 VDD VSS gf180mcu_as_sc_mcu7t3v3__tap_2
X_2962_ VDD VDD VSS VSS _3939_/A _3042_/B _2962_/C _2962_/D _2963_/C gf180mcu_as_sc_mcu7t3v3__ao22_2
XTAP_TAPCELL_ROW_196_2476 VDD VSS gf180mcu_as_sc_mcu7t3v3__tap_2
XTAP_TAPCELL_ROW_173_3_3240 VDD VSS gf180mcu_as_sc_mcu7t3v3__tap_2
XFILLER_15_492 VDD VDD VSS VSS gf180mcu_as_sc_mcu7t3v3__fillcap_16
XPHY_EDGE_ROW_210_Left_420 VDD VSS gf180mcu_as_sc_mcu7t3v3__tap_2
X_4701_ VDD VDD VSS VSS _4707_/S _5255_/Q _4701_/A _5255_/D gf180mcu_as_sc_mcu7t3v3__mux2_2
XTAP_TAPCELL_ROW_196_2487 VDD VSS gf180mcu_as_sc_mcu7t3v3__tap_2
XFILLER_187_294 VDD VDD VSS VSS gf180mcu_as_sc_mcu7t3v3__fill_1
XFILLER_30_451 VDD VDD VSS VSS gf180mcu_as_sc_mcu7t3v3__fillcap_4
XFILLER_33_1018 VDD VDD VSS VSS gf180mcu_as_sc_mcu7t3v3__fillcap_4
XFILLER_33_1029 VDD VDD VSS VSS gf180mcu_as_sc_mcu7t3v3__fillcap_16
X_4632_ VDD VDD VSS VSS _4683_/C _5120_/Q _4703_/A _5223_/D gf180mcu_as_sc_mcu7t3v3__mux2_2
X_2893_ VDD VDD VSS VSS _3789_/A _3797_/A _3533_/C gf180mcu_as_sc_mcu7t3v3__or2_2
XFILLER_147_136 VDD VDD VSS VSS gf180mcu_as_sc_mcu7t3v3__fillcap_4
XFILLER_15_1474 VDD VDD VSS VSS gf180mcu_as_sc_mcu7t3v3__fill_1
XFILLER_176_979 VDD VDD VSS VSS gf180mcu_as_sc_mcu7t3v3__fillcap_16
XFILLER_176_1501 VDD VDD VSS VSS gf180mcu_as_sc_mcu7t3v3__fillcap_4
X_4563_ VDD VDD VSS VSS _5186_/Q _4590_/B _4575_/C _5104_/Q _4564_/B gf180mcu_as_sc_mcu7t3v3__ao22_2
X_4494_ VDD VDD VSS VSS _4494_/B _4533_/A _4495_/D gf180mcu_as_sc_mcu7t3v3__and2_2
X_3514_ VDD VDD VSS VSS _3515_/D _3514_/C _3514_/B _3514_/A gf180mcu_as_sc_mcu7t3v3__aoi21b_2
X_3445_ VDD VDD VSS VSS _4094_/A _3467_/C _3445_/C _4097_/A _3446_/C gf180mcu_as_sc_mcu7t3v3__ao22_2
XFILLER_170_194 VDD VDD VSS VSS gf180mcu_as_sc_mcu7t3v3__fill_2
XFILLER_134_18 VDD VDD VSS VSS gf180mcu_as_sc_mcu7t3v3__fillcap_16
XFILLER_69_142 VDD VDD VSS VSS gf180mcu_as_sc_mcu7t3v3__fillcap_16
X_3376_ VDD VDD VSS VSS _4027_/A _3463_/B _3376_/C _4816_/D _3608_/D gf180mcu_as_sc_mcu7t3v3__aoi211_2
X_5115_ VDD VDD VSS VSS _5260_/CLK _5115_/D _5115_/Q gf180mcu_as_sc_mcu7t3v3__dfxtp_2
XFILLER_22_1434 VDD VDD VSS VSS gf180mcu_as_sc_mcu7t3v3__fill_1
XFILLER_27_27 VDD VDD VSS VSS gf180mcu_as_sc_mcu7t3v3__fillcap_16
XFILLER_84_123 VDD VDD VSS VSS gf180mcu_as_sc_mcu7t3v3__fillcap_16
X_5046_ VDD VDD VSS VSS clkload1/A _5046_/D _5046_/Q gf180mcu_as_sc_mcu7t3v3__dfxtp_2
XFILLER_61_1494 VDD VDD VSS VSS gf180mcu_as_sc_mcu7t3v3__fill_1
XFILLER_0_1230 VDD VDD VSS VSS gf180mcu_as_sc_mcu7t3v3__fill_2
XFILLER_25_212 VDD VDD VSS VSS gf180mcu_as_sc_mcu7t3v3__fillcap_16
XFILLER_57_1508 VDD VDD VSS VSS gf180mcu_as_sc_mcu7t3v3__fill_1
XFILLER_96_1568 VDD VDD VSS VSS gf180mcu_as_sc_mcu7t3v3__fill_1
XFILLER_198_559 VDD VDD VSS VSS gf180mcu_as_sc_mcu7t3v3__fillcap_16
XFILLER_201_508 VDD VDD VSS VSS gf180mcu_as_sc_mcu7t3v3__fillcap_16
XFILLER_181_1240 VDD VDD VSS VSS gf180mcu_as_sc_mcu7t3v3__fillcap_16
XFILLER_181_1262 VDD VDD VSS VSS gf180mcu_as_sc_mcu7t3v3__fillcap_16
XFILLER_185_209 VDD VDD VSS VSS gf180mcu_as_sc_mcu7t3v3__fill_1
XFILLER_22_963 VDD VDD VSS VSS gf180mcu_as_sc_mcu7t3v3__fillcap_16
XFILLER_43_59 VDD VDD VSS VSS gf180mcu_as_sc_mcu7t3v3__fillcap_8
XFILLER_16_1238 VDD VDD VSS VSS gf180mcu_as_sc_mcu7t3v3__fillcap_16
XFILLER_21_462 VDD VDD VSS VSS gf180mcu_as_sc_mcu7t3v3__fill_1
XFILLER_181_404 VDD VDD VSS VSS gf180mcu_as_sc_mcu7t3v3__fillcap_16
XFILLER_181_426 VDD VDD VSS VSS gf180mcu_as_sc_mcu7t3v3__fill_2
XFILLER_153_139 VDD VDD VSS VSS gf180mcu_as_sc_mcu7t3v3__fill_1
XTAP_TAPCELL_ROW_21_1196 VDD VSS gf180mcu_as_sc_mcu7t3v3__tap_2
XTAP_TAPCELL_ROW_21_1185 VDD VSS gf180mcu_as_sc_mcu7t3v3__tap_2
XFILLER_104_4 VDD VDD VSS VSS gf180mcu_as_sc_mcu7t3v3__fill_1
XTAP_TAPCELL_ROW_9_934 VDD VSS gf180mcu_as_sc_mcu7t3v3__tap_2
XTAP_TAPCELL_ROW_9_923 VDD VSS gf180mcu_as_sc_mcu7t3v3__tap_2
XFILLER_108_85 VDD VDD VSS VSS gf180mcu_as_sc_mcu7t3v3__fillcap_8
XFILLER_118_1473 VDD VDD VSS VSS gf180mcu_as_sc_mcu7t3v3__fill_1
XFILLER_66_1383 VDD VDD VSS VSS gf180mcu_as_sc_mcu7t3v3__fillcap_16
Xinput201 VDD VDD VSS VSS se_in[28] _4163_/A gf180mcu_as_sc_mcu7t3v3__buff_12
XFILLER_153_1364 VDD VDD VSS VSS gf180mcu_as_sc_mcu7t3v3__fillcap_4
XFILLER_194_2 VDD VDD VSS VSS gf180mcu_as_sc_mcu7t3v3__fillcap_16
Xinput212 VDD VDD VSS VSS se_in[7] wire867/A gf180mcu_as_sc_mcu7t3v3__buff_12
Xinput223 VDD VDD VSS VSS south_in[17] _4072_/D gf180mcu_as_sc_mcu7t3v3__buff_12
Xinput234 VDD VDD VSS VSS south_in[27] _4151_/D gf180mcu_as_sc_mcu7t3v3__buff_12
Xinput245 VDD VDD VSS VSS south_in[6] _3981_/D gf180mcu_as_sc_mcu7t3v3__buff_12
XFILLER_208_107 VDD VDD VSS VSS gf180mcu_as_sc_mcu7t3v3__fillcap_4
XFILLER_40_1523 VDD VDD VSS VSS gf180mcu_as_sc_mcu7t3v3__fill_1
XFILLER_75_123 VDD VDD VSS VSS gf180mcu_as_sc_mcu7t3v3__fill_2
Xinput256 VDD VDD VSS VSS sw_in[16] _2438_/A gf180mcu_as_sc_mcu7t3v3__buff_12
Xinput267 VDD VDD VSS VSS sw_in[26] wire864/A gf180mcu_as_sc_mcu7t3v3__buff_12
Xinput278 VDD VDD VSS VSS sw_in[5] _3978_/A gf180mcu_as_sc_mcu7t3v3__buff_12
XTAP_TAPCELL_ROW_166_1_1943 VDD VSS gf180mcu_as_sc_mcu7t3v3__tap_2
XFILLER_17_702 VDD VDD VSS VSS gf180mcu_as_sc_mcu7t3v3__fill_2
XFILLER_29_562 VDD VDD VSS VSS gf180mcu_as_sc_mcu7t3v3__fillcap_16
XFILLER_90_104 VDD VDD VSS VSS gf180mcu_as_sc_mcu7t3v3__fill_1
Xinput289 VDD VDD VSS VSS west_in[15] _4053_/A gf180mcu_as_sc_mcu7t3v3__buff_12
XFILLER_16_212 VDD VDD VSS VSS gf180mcu_as_sc_mcu7t3v3__fillcap_16
XFILLER_186_1151 VDD VDD VSS VSS gf180mcu_as_sc_mcu7t3v3__fillcap_4
XFILLER_17_768 VDD VDD VSS VSS gf180mcu_as_sc_mcu7t3v3__fill_2
XFILLER_186_1173 VDD VDD VSS VSS gf180mcu_as_sc_mcu7t3v3__fillcap_16
XFILLER_205_836 VDD VDD VSS VSS gf180mcu_as_sc_mcu7t3v3__fillcap_4
XFILLER_205_858 VDD VDD VSS VSS gf180mcu_as_sc_mcu7t3v3__fillcap_16
XFILLER_16_289 VDD VDD VSS VSS gf180mcu_as_sc_mcu7t3v3__fillcap_8
XFILLER_189_559 VDD VDD VSS VSS gf180mcu_as_sc_mcu7t3v3__fill_1
XTAP_TAPCELL_ROW_28_1339 VDD VSS gf180mcu_as_sc_mcu7t3v3__tap_2
XFILLER_13_930 VDD VDD VSS VSS gf180mcu_as_sc_mcu7t3v3__fillcap_16
XFILLER_176_209 VDD VDD VSS VSS gf180mcu_as_sc_mcu7t3v3__fillcap_4
XTAP_TAPCELL_ROW_174_2004 VDD VSS gf180mcu_as_sc_mcu7t3v3__tap_2
XFILLER_34_1349 VDD VDD VSS VSS gf180mcu_as_sc_mcu7t3v3__fillcap_4
XFILLER_73_1387 VDD VDD VSS VSS gf180mcu_as_sc_mcu7t3v3__fillcap_8
XTAP_TAPCELL_ROW_61_3_2903 VDD VSS gf180mcu_as_sc_mcu7t3v3__tap_2
XFILLER_125_1488 VDD VDD VSS VSS gf180mcu_as_sc_mcu7t3v3__fillcap_16
XFILLER_201_1310 VDD VDD VSS VSS gf180mcu_as_sc_mcu7t3v3__fillcap_16
XFILLER_9_956 VDD VDD VSS VSS gf180mcu_as_sc_mcu7t3v3__fillcap_16
XFILLER_201_1332 VDD VDD VSS VSS gf180mcu_as_sc_mcu7t3v3__fillcap_16
XFILLER_32_1062 VDD VDD VSS VSS gf180mcu_as_sc_mcu7t3v3__fillcap_8
XFILLER_9_989 VDD VDD VSS VSS gf180mcu_as_sc_mcu7t3v3__fill_2
XTAP_TAPCELL_ROW_191_2384 VDD VSS gf180mcu_as_sc_mcu7t3v3__tap_2
XTAP_TAPCELL_ROW_191_2373 VDD VSS gf180mcu_as_sc_mcu7t3v3__tap_2
XFILLER_144_139 VDD VDD VSS VSS gf180mcu_as_sc_mcu7t3v3__fillcap_16
XFILLER_193_1100 VDD VDD VSS VSS gf180mcu_as_sc_mcu7t3v3__fillcap_16
XFILLER_10_1360 VDD VDD VSS VSS gf180mcu_as_sc_mcu7t3v3__fillcap_4
XFILLER_10_1371 VDD VDD VSS VSS gf180mcu_as_sc_mcu7t3v3__fill_2
XFILLER_181_960 VDD VDD VSS VSS gf180mcu_as_sc_mcu7t3v3__fillcap_16
XFILLER_181_982 VDD VDD VSS VSS gf180mcu_as_sc_mcu7t3v3__fillcap_16
XFILLER_193_1122 VDD VDD VSS VSS gf180mcu_as_sc_mcu7t3v3__fillcap_16
XFILLER_4_661 VDD VDD VSS VSS gf180mcu_as_sc_mcu7t3v3__fillcap_4
XTAP_TAPCELL_ROW_41_3_2845 VDD VSS gf180mcu_as_sc_mcu7t3v3__tap_2
X_3230_ VDD VDD VSS VSS _3241_/B _3514_/A _3230_/A _3231_/C gf180mcu_as_sc_mcu7t3v3__mux2_2
X_3161_ VDD VDD VSS VSS _3178_/A _3161_/B _3161_/C _3178_/D _3163_/C gf180mcu_as_sc_mcu7t3v3__ao211_2
XTAP_TAPCELL_ROW_206_2715 VDD VSS gf180mcu_as_sc_mcu7t3v3__tap_2
XTAP_TAPCELL_ROW_206_2704 VDD VSS gf180mcu_as_sc_mcu7t3v3__tap_2
XPHY_EDGE_ROW_6_Left_217 VDD VSS gf180mcu_as_sc_mcu7t3v3__tap_2
X_3092_ VDD VDD VSS VSS _3121_/B _4932_/Q _3095_/C gf180mcu_as_sc_mcu7t3v3__or2_2
XFILLER_169_1360 VDD VDD VSS VSS gf180mcu_as_sc_mcu7t3v3__fill_1
XFILLER_66_189 VDD VDD VSS VSS gf180mcu_as_sc_mcu7t3v3__fill_1
XFILLER_81_126 VDD VDD VSS VSS gf180mcu_as_sc_mcu7t3v3__fill_2
XTAP_TAPCELL_ROW_198_2527 VDD VSS gf180mcu_as_sc_mcu7t3v3__tap_2
XPHY_EDGE_ROW_93_1_Right_614 VDD VSS gf180mcu_as_sc_mcu7t3v3__tap_2
XTAP_TAPCELL_ROW_198_2538 VDD VSS gf180mcu_as_sc_mcu7t3v3__tap_2
XFILLER_91_1410 VDD VDD VSS VSS gf180mcu_as_sc_mcu7t3v3__fill_2
XFILLER_17_1514 VDD VDD VSS VSS gf180mcu_as_sc_mcu7t3v3__fill_1
XFILLER_200_53 VDD VDD VSS VSS gf180mcu_as_sc_mcu7t3v3__fillcap_16
XFILLER_206_1221 VDD VDD VSS VSS gf180mcu_as_sc_mcu7t3v3__fillcap_4
X_3994_ VDD VDD VSS VSS _4106_/S _3994_/B _3994_/A _3995_/B gf180mcu_as_sc_mcu7t3v3__mux2_2
XFILLER_206_1243 VDD VDD VSS VSS gf180mcu_as_sc_mcu7t3v3__fillcap_16
XFILLER_52_1449 VDD VDD VSS VSS gf180mcu_as_sc_mcu7t3v3__fill_2
X_2945_ VDD VDD VSS VSS _3218_/B _3283_/A _2945_/Y gf180mcu_as_sc_mcu7t3v3__and2_2
XFILLER_104_1517 VDD VDD VSS VSS gf180mcu_as_sc_mcu7t3v3__fillcap_4
XFILLER_104_1539 VDD VDD VSS VSS gf180mcu_as_sc_mcu7t3v3__fill_2
XFILLER_143_1566 VDD VDD VSS VSS gf180mcu_as_sc_mcu7t3v3__fill_2
XFILLER_191_702 VDD VDD VSS VSS gf180mcu_as_sc_mcu7t3v3__fillcap_16
XFILLER_198_1011 VDD VDD VSS VSS gf180mcu_as_sc_mcu7t3v3__fillcap_4
XFILLER_198_1033 VDD VDD VSS VSS gf180mcu_as_sc_mcu7t3v3__fillcap_16
XFILLER_30_281 VDD VDD VSS VSS gf180mcu_as_sc_mcu7t3v3__fillcap_16
X_2876_ VDD VDD VSS VSS _4719_/B _4633_/A _2876_/B _4691_/C gf180mcu_as_sc_mcu7t3v3__ao21_2
XFILLER_15_1282 VDD VDD VSS VSS gf180mcu_as_sc_mcu7t3v3__fill_2
X_4615_ VDD VDD VSS VSS _5209_/Q _4621_/B _4620_/C _5210_/Q _5209_/D gf180mcu_as_sc_mcu7t3v3__ao22_2
XFILLER_135_128 VDD VDD VSS VSS gf180mcu_as_sc_mcu7t3v3__fill_1
X_4546_ VDD VDD VSS VSS _4546_/D _4546_/A _4546_/B _4546_/C _4547_/B gf180mcu_as_sc_mcu7t3v3__ao31_2
XFILLER_2_609 VDD VDD VSS VSS gf180mcu_as_sc_mcu7t3v3__fillcap_8
XFILLER_137_1348 VDD VDD VSS VSS gf180mcu_as_sc_mcu7t3v3__fillcap_8
X_4477_ VDD VDD VSS VSS _4478_/D _4477_/B _4521_/A gf180mcu_as_sc_mcu7t3v3__nor2_2
X_3428_ VDD VDD VSS VSS _4077_/D _3468_/B _3428_/C _3428_/D _3429_/A gf180mcu_as_sc_mcu7t3v3__ao211_2
XFILLER_24_1507 VDD VDD VSS VSS gf180mcu_as_sc_mcu7t3v3__fillcap_16
X_3359_ VDD VDD VSS VSS _3408_/B _3359_/B _3359_/C _3360_/C gf180mcu_as_sc_mcu7t3v3__nor3_2
XTAP_TAPCELL_ROW_56_1_1612 VDD VSS gf180mcu_as_sc_mcu7t3v3__tap_2
XFILLER_38_37 VDD VDD VSS VSS gf180mcu_as_sc_mcu7t3v3__fillcap_16
XPHY_EDGE_ROW_99_1_Left_309 VDD VSS gf180mcu_as_sc_mcu7t3v3__tap_2
Xhold1111 VDD VDD VSS VSS hold1139/Y _4967_/D gf180mcu_as_sc_mcu7t3v3__clkbuff_4
Xhold1122 VDD VDD VSS VSS hold1148/Y _4962_/D gf180mcu_as_sc_mcu7t3v3__clkbuff_4
Xhold1133 VDD VDD VSS VSS _4964_/Q _4963_/D gf180mcu_as_sc_mcu7t3v3__clkbuff_4
Xhold1144 VDD VDD VSS VSS _4970_/Q hold1144/Y gf180mcu_as_sc_mcu7t3v3__clkbuff_4
XFILLER_2_1347 VDD VDD VSS VSS gf180mcu_as_sc_mcu7t3v3__fill_2
XFILLER_72_104 VDD VDD VSS VSS gf180mcu_as_sc_mcu7t3v3__fill_1
XFILLER_72_115 VDD VDD VSS VSS gf180mcu_as_sc_mcu7t3v3__fillcap_4
X_5029_ VDD VDD VSS VSS _5085_/CLK _5029_/D _5029_/Q gf180mcu_as_sc_mcu7t3v3__dfxtp_2
XTAP_TAPCELL_ROW_66_3_2918 VDD VSS gf180mcu_as_sc_mcu7t3v3__tap_2
XFILLER_148_1422 VDD VDD VSS VSS gf180mcu_as_sc_mcu7t3v3__fill_2
XFILLER_166_6 VDD VDD VSS VSS gf180mcu_as_sc_mcu7t3v3__fillcap_16
XPHY_EDGE_ROW_108_3_Left_493 VDD VSS gf180mcu_as_sc_mcu7t3v3__tap_2
XFILLER_96_1387 VDD VDD VSS VSS gf180mcu_as_sc_mcu7t3v3__fill_1
XFILLER_96_1398 VDD VDD VSS VSS gf180mcu_as_sc_mcu7t3v3__fillcap_16
XFILLER_110_31 VDD VDD VSS VSS gf180mcu_as_sc_mcu7t3v3__fillcap_4
XFILLER_110_53 VDD VDD VSS VSS gf180mcu_as_sc_mcu7t3v3__fillcap_16
XFILLER_198_367 VDD VDD VSS VSS gf180mcu_as_sc_mcu7t3v3__fillcap_16
XFILLER_202_839 VDD VDD VSS VSS gf180mcu_as_sc_mcu7t3v3__fillcap_16
XFILLER_198_389 VDD VDD VSS VSS gf180mcu_as_sc_mcu7t3v3__fill_1
XPHY_EDGE_ROW_45_3_Left_430 VDD VSS gf180mcu_as_sc_mcu7t3v3__tap_2
XFILLER_210_883 VDD VDD VSS VSS gf180mcu_as_sc_mcu7t3v3__fill_1
XTAP_TAPCELL_ROW_23_1247 VDD VSS gf180mcu_as_sc_mcu7t3v3__tap_2
XTAP_TAPCELL_ROW_23_1236 VDD VSS gf180mcu_as_sc_mcu7t3v3__tap_2
XFILLER_119_62 VDD VDD VSS VSS gf180mcu_as_sc_mcu7t3v3__fillcap_8
XFILLER_126_139 VDD VDD VSS VSS gf180mcu_as_sc_mcu7t3v3__fill_2
XFILLER_181_212 VDD VDD VSS VSS gf180mcu_as_sc_mcu7t3v3__fillcap_16
XFILLER_120_1396 VDD VDD VSS VSS gf180mcu_as_sc_mcu7t3v3__fill_2
XFILLER_194_1431 VDD VDD VSS VSS gf180mcu_as_sc_mcu7t3v3__fillcap_4
XFILLER_194_1453 VDD VDD VSS VSS gf180mcu_as_sc_mcu7t3v3__fillcap_16
XFILLER_207_2 VDD VDD VSS VSS gf180mcu_as_sc_mcu7t3v3__fillcap_16
XFILLER_155_1415 VDD VDD VSS VSS gf180mcu_as_sc_mcu7t3v3__fill_1
XFILLER_29_1418 VDD VDD VSS VSS gf180mcu_as_sc_mcu7t3v3__fillcap_4
XFILLER_79_88 VDD VDD VSS VSS gf180mcu_as_sc_mcu7t3v3__fill_2
XFILLER_95_43 VDD VDD VSS VSS gf180mcu_as_sc_mcu7t3v3__fillcap_16
XFILLER_28_70 VDD VDD VSS VSS gf180mcu_as_sc_mcu7t3v3__fillcap_4
XFILLER_63_115 VDD VDD VSS VSS gf180mcu_as_sc_mcu7t3v3__fill_1
XFILLER_189_301 VDD VDD VSS VSS gf180mcu_as_sc_mcu7t3v3__fillcap_4
XFILLER_189_312 VDD VDD VSS VSS gf180mcu_as_sc_mcu7t3v3__fillcap_8
XTAP_TAPCELL_ROW_201_2601 VDD VSS gf180mcu_as_sc_mcu7t3v3__tap_2
XFILLER_127_1506 VDD VDD VSS VSS gf180mcu_as_sc_mcu7t3v3__fill_2
XFILLER_75_1449 VDD VDD VSS VSS gf180mcu_as_sc_mcu7t3v3__fillcap_16
XTAP_TAPCELL_ROW_94_3_3003 VDD VSS gf180mcu_as_sc_mcu7t3v3__tap_2
XTAP_TAPCELL_ROW_193_2424 VDD VSS gf180mcu_as_sc_mcu7t3v3__tap_2
XTAP_TAPCELL_ROW_193_2413 VDD VSS gf180mcu_as_sc_mcu7t3v3__tap_2
XFILLER_157_220 VDD VDD VSS VSS gf180mcu_as_sc_mcu7t3v3__fill_2
XFILLER_34_1157 VDD VDD VSS VSS gf180mcu_as_sc_mcu7t3v3__fillcap_16
XFILLER_9_742 VDD VDD VSS VSS gf180mcu_as_sc_mcu7t3v3__fill_1
X_2730_ VDD VDD VSS VSS _2737_/A _2730_/B _2730_/C _2730_/D _2730_/Y gf180mcu_as_sc_mcu7t3v3__ao22_2
XFILLER_185_562 VDD VDD VSS VSS gf180mcu_as_sc_mcu7t3v3__fillcap_16
XFILLER_199_1364 VDD VDD VSS VSS gf180mcu_as_sc_mcu7t3v3__fillcap_16
X_2661_ VDD VDD VSS VSS _2662_/D _2661_/B _2674_/C gf180mcu_as_sc_mcu7t3v3__nor2_2
XFILLER_117_139 VDD VDD VSS VSS gf180mcu_as_sc_mcu7t3v3__fill_1
XFILLER_67_4 VDD VDD VSS VSS gf180mcu_as_sc_mcu7t3v3__fill_1
XFILLER_86_1501 VDD VDD VSS VSS gf180mcu_as_sc_mcu7t3v3__fillcap_16
XTAP_TAPCELL_ROW_11_972 VDD VSS gf180mcu_as_sc_mcu7t3v3__tap_2
XTAP_TAPCELL_ROW_11_983 VDD VSS gf180mcu_as_sc_mcu7t3v3__tap_2
X_4400_ VDD VDD VSS VSS _4400_/B _4497_/A _4407_/C gf180mcu_as_sc_mcu7t3v3__and2_2
XFILLER_86_1523 VDD VDD VSS VSS gf180mcu_as_sc_mcu7t3v3__fillcap_16
X_2592_ VDD VDD VSS VSS _2852_/B _4633_/A _2598_/A gf180mcu_as_sc_mcu7t3v3__and2_2
XFILLER_173_1504 VDD VDD VSS VSS gf180mcu_as_sc_mcu7t3v3__fillcap_4
X_4331_ VDD VDD VSS VSS _4331_/A _5126_/Q _4708_/C _4331_/D _4332_/D gf180mcu_as_sc_mcu7t3v3__ao211_2
X_4262_ VDD VDD VSS VSS _4262_/B _4262_/A _4263_/B gf180mcu_as_sc_mcu7t3v3__xnor2_2
X_3213_ VDD VDD VSS VSS _3213_/D _3213_/A _3213_/B _3213_/C _3215_/B gf180mcu_as_sc_mcu7t3v3__ao31_2
XFILLER_210_1409 VDD VDD VSS VSS gf180mcu_as_sc_mcu7t3v3__fill_2
XFILLER_39_112 VDD VDD VSS VSS gf180mcu_as_sc_mcu7t3v3__fillcap_16
X_4193_ VDD VDD VSS VSS _4253_/B _4193_/B _4193_/C _5031_/Q _5031_/D gf180mcu_as_sc_mcu7t3v3__ao22_2
XPHY_EDGE_ROW_173_3_Left_558 VDD VSS gf180mcu_as_sc_mcu7t3v3__tap_2
X_3144_ VDD VDD VSS VSS _4120_/A _3233_/B _3169_/C _4121_/D _3145_/C gf180mcu_as_sc_mcu7t3v3__ao22_2
XFILLER_110_1510 VDD VDD VSS VSS gf180mcu_as_sc_mcu7t3v3__fill_1
XFILLER_27_318 VDD VDD VSS VSS gf180mcu_as_sc_mcu7t3v3__fill_1
XFILLER_54_126 VDD VDD VSS VSS gf180mcu_as_sc_mcu7t3v3__fill_1
X_3075_ VDD VDD VSS VSS _3075_/S _4053_/A _4055_/A _3077_/B gf180mcu_as_sc_mcu7t3v3__mux2_2
XFILLER_23_524 VDD VDD VSS VSS gf180mcu_as_sc_mcu7t3v3__fillcap_16
XPHY_EDGE_ROW_94_1_Right_615 VDD VSS gf180mcu_as_sc_mcu7t3v3__tap_2
XFILLER_189_890 VDD VDD VSS VSS gf180mcu_as_sc_mcu7t3v3__fillcap_16
XFILLER_56_1371 VDD VDD VSS VSS gf180mcu_as_sc_mcu7t3v3__fillcap_8
X_3977_ VDD VDD VSS VSS _3977_/A _4033_/B _3977_/C _3977_/D _3978_/B gf180mcu_as_sc_mcu7t3v3__ao211_2
XFILLER_13_1208 VDD VDD VSS VSS gf180mcu_as_sc_mcu7t3v3__fillcap_4
X_2928_ VDD VDD VSS VSS _3216_/C _3216_/B _2928_/Y gf180mcu_as_sc_mcu7t3v3__and2_2
XFILLER_17_1399 VDD VDD VSS VSS gf180mcu_as_sc_mcu7t3v3__fill_1
XFILLER_40_27 VDD VDD VSS VSS gf180mcu_as_sc_mcu7t3v3__fillcap_8
XFILLER_163_212 VDD VDD VSS VSS gf180mcu_as_sc_mcu7t3v3__fillcap_8
XFILLER_178_1426 VDD VDD VSS VSS gf180mcu_as_sc_mcu7t3v3__fillcap_8
XFILLER_178_1437 VDD VDD VSS VSS gf180mcu_as_sc_mcu7t3v3__fill_2
X_2859_ VDD VDD VSS VSS _4721_/A _4263_/A _2861_/B gf180mcu_as_sc_mcu7t3v3__and2_2
XTAP_TAPCELL_ROW_121_3_3084 VDD VSS gf180mcu_as_sc_mcu7t3v3__tap_2
XPHY_EDGE_ROW_70_3_Right_107 VDD VSS gf180mcu_as_sc_mcu7t3v3__tap_2
X_4529_ VDD VDD VSS VSS _4529_/D _4572_/A _4529_/B _4529_/C _4530_/B gf180mcu_as_sc_mcu7t3v3__ao31_2
XFILLER_8_1501 VDD VDD VSS VSS gf180mcu_as_sc_mcu7t3v3__fillcap_4
XFILLER_131_142 VDD VDD VSS VSS gf180mcu_as_sc_mcu7t3v3__fillcap_8
XFILLER_172_37 VDD VDD VSS VSS gf180mcu_as_sc_mcu7t3v3__fillcap_16
XFILLER_49_47 VDD VDD VSS VSS gf180mcu_as_sc_mcu7t3v3__fill_2
Xfanout710 VDD VDD VSS VSS _3270_/Y _3501_/C gf180mcu_as_sc_mcu7t3v3__buff_12
Xfanout721 VDD VDD VSS VSS _3542_/Y _3740_/B gf180mcu_as_sc_mcu7t3v3__buff_12
Xfanout732 VDD VDD VSS VSS _3129_/B _3078_/B gf180mcu_as_sc_mcu7t3v3__buff_12
XFILLER_105_31 VDD VDD VSS VSS gf180mcu_as_sc_mcu7t3v3__fillcap_16
XFILLER_115_1443 VDD VDD VSS VSS gf180mcu_as_sc_mcu7t3v3__fillcap_16
Xfanout743 VDD VDD VSS VSS _4731_/B _4725_/B gf180mcu_as_sc_mcu7t3v3__buff_12
Xfanout765 VDD VDD VSS VSS _4196_/B _4191_/B gf180mcu_as_sc_mcu7t3v3__buff_12
Xfanout776 VDD VDD VSS VSS _5228_/Q _4637_/A gf180mcu_as_sc_mcu7t3v3__buff_12
XTAP_TAPCELL_ROW_87_1_1706 VDD VSS gf180mcu_as_sc_mcu7t3v3__tap_2
XFILLER_98_1427 VDD VDD VSS VSS gf180mcu_as_sc_mcu7t3v3__fill_2
Xfanout787 VDD VDD VSS VSS _5098_/Q _4264_/A gf180mcu_as_sc_mcu7t3v3__buff_12
Xfanout798 VDD VDD VSS VSS _4542_/A _4586_/S gf180mcu_as_sc_mcu7t3v3__buff_12
XTAP_TAPCELL_ROW_99_3_3018 VDD VSS gf180mcu_as_sc_mcu7t3v3__tap_2
XTAP_TAPCELL_ROW_16_1084 VDD VSS gf180mcu_as_sc_mcu7t3v3__tap_2
XTAP_TAPCELL_ROW_16_1073 VDD VSS gf180mcu_as_sc_mcu7t3v3__tap_2
XFILLER_206_419 VDD VDD VSS VSS gf180mcu_as_sc_mcu7t3v3__fillcap_16
XFILLER_45_104 VDD VDD VSS VSS gf180mcu_as_sc_mcu7t3v3__fillcap_16
XFILLER_65_46 VDD VDD VSS VSS gf180mcu_as_sc_mcu7t3v3__fillcap_8
XFILLER_199_610 VDD VDD VSS VSS gf180mcu_as_sc_mcu7t3v3__fillcap_16
XFILLER_199_632 VDD VDD VSS VSS gf180mcu_as_sc_mcu7t3v3__fillcap_16
XFILLER_60_107 VDD VDD VSS VSS gf180mcu_as_sc_mcu7t3v3__fillcap_8
XFILLER_183_1154 VDD VDD VSS VSS gf180mcu_as_sc_mcu7t3v3__fillcap_16
XFILLER_186_337 VDD VDD VSS VSS gf180mcu_as_sc_mcu7t3v3__fill_2
XFILLER_35_1411 VDD VDD VSS VSS gf180mcu_as_sc_mcu7t3v3__fillcap_8
XFILLER_139_220 VDD VDD VSS VSS gf180mcu_as_sc_mcu7t3v3__fill_2
XFILLER_161_1474 VDD VDD VSS VSS gf180mcu_as_sc_mcu7t3v3__fill_1
XFILLER_122_1469 VDD VDD VSS VSS gf180mcu_as_sc_mcu7t3v3__fillcap_16
XFILLER_182_543 VDD VDD VSS VSS gf180mcu_as_sc_mcu7t3v3__fillcap_16
XFILLER_190_1103 VDD VDD VSS VSS gf180mcu_as_sc_mcu7t3v3__fillcap_16
XFILLER_46_1562 VDD VDD VSS VSS gf180mcu_as_sc_mcu7t3v3__fillcap_4
XTAP_TAPCELL_ROW_186_2272 VDD VSS gf180mcu_as_sc_mcu7t3v3__tap_2
XTAP_TAPCELL_ROW_186_2261 VDD VSS gf180mcu_as_sc_mcu7t3v3__tap_2
XTAP_TAPCELL_ROW_182_2169 VDD VSS gf180mcu_as_sc_mcu7t3v3__tap_2
XFILLER_36_104 VDD VDD VSS VSS gf180mcu_as_sc_mcu7t3v3__fillcap_16
Xinput9 VDD VDD VSS VSS boot_addr[7] input9/Y gf180mcu_as_sc_mcu7t3v3__buff_12
XFILLER_188_1065 VDD VDD VSS VSS gf180mcu_as_sc_mcu7t3v3__fillcap_16
XFILLER_188_1087 VDD VDD VSS VSS gf180mcu_as_sc_mcu7t3v3__fillcap_16
XFILLER_189_120 VDD VDD VSS VSS gf180mcu_as_sc_mcu7t3v3__fillcap_16
XFILLER_51_107 VDD VDD VSS VSS gf180mcu_as_sc_mcu7t3v3__fillcap_4
XFILLER_79_1393 VDD VDD VSS VSS gf180mcu_as_sc_mcu7t3v3__fillcap_16
XFILLER_178_827 VDD VDD VSS VSS gf180mcu_as_sc_mcu7t3v3__fillcap_4
XFILLER_17_384 VDD VDD VSS VSS gf180mcu_as_sc_mcu7t3v3__fillcap_4
XFILLER_17_395 VDD VDD VSS VSS gf180mcu_as_sc_mcu7t3v3__fillcap_16
XFILLER_189_142 VDD VDD VSS VSS gf180mcu_as_sc_mcu7t3v3__fillcap_8
XFILLER_36_1208 VDD VDD VSS VSS gf180mcu_as_sc_mcu7t3v3__fillcap_16
XFILLER_44_181 VDD VDD VSS VSS gf180mcu_as_sc_mcu7t3v3__fill_2
X_4880_ VDD VDD VSS VSS _4924_/CLK _4880_/D _4880_/Q gf180mcu_as_sc_mcu7t3v3__dfxtp_2
X_3900_ VDD VDD VSS VSS _3903_/B _5158_/Q _4940_/D gf180mcu_as_sc_mcu7t3v3__and2_2
XFILLER_189_164 VDD VDD VSS VSS gf180mcu_as_sc_mcu7t3v3__fillcap_16
XFILLER_20_505 VDD VDD VSS VSS gf180mcu_as_sc_mcu7t3v3__fillcap_4
XFILLER_32_365 VDD VDD VSS VSS gf180mcu_as_sc_mcu7t3v3__fillcap_16
XTAP_TAPCELL_ROW_114_1_1787 VDD VSS gf180mcu_as_sc_mcu7t3v3__tap_2
XTAP_TAPCELL_ROW_126_3_3099 VDD VSS gf180mcu_as_sc_mcu7t3v3__tap_2
X_3831_ VDD VDD VSS VSS _3831_/A _4752_/B _4752_/C _4909_/D gf180mcu_as_sc_mcu7t3v3__nor3_2
XFILLER_203_1224 VDD VDD VSS VSS gf180mcu_as_sc_mcu7t3v3__fillcap_16
XFILLER_32_387 VDD VDD VSS VSS gf180mcu_as_sc_mcu7t3v3__fillcap_8
X_3762_ VDD VDD VSS VSS _4941_/Q _3799_/B _3770_/C _4144_/A _3764_/C gf180mcu_as_sc_mcu7t3v3__ao22_2
XFILLER_140_1525 VDD VDD VSS VSS gf180mcu_as_sc_mcu7t3v3__fill_1
XFILLER_140_1536 VDD VDD VSS VSS gf180mcu_as_sc_mcu7t3v3__fillcap_4
XFILLER_186_871 VDD VDD VSS VSS gf180mcu_as_sc_mcu7t3v3__fillcap_4
XFILLER_186_893 VDD VDD VSS VSS gf180mcu_as_sc_mcu7t3v3__fillcap_16
XFILLER_201_680 VDD VDD VSS VSS gf180mcu_as_sc_mcu7t3v3__fillcap_16
XFILLER_53_1566 VDD VDD VSS VSS gf180mcu_as_sc_mcu7t3v3__fill_2
XFILLER_145_212 VDD VDD VSS VSS gf180mcu_as_sc_mcu7t3v3__fillcap_8
XFILLER_195_1014 VDD VDD VSS VSS gf180mcu_as_sc_mcu7t3v3__fillcap_16
X_3693_ VDD VDD VSS VSS _4932_/Q _3740_/B _3740_/C _4071_/A _3695_/C gf180mcu_as_sc_mcu7t3v3__ao22_2
X_2713_ VDD VDD VSS VSS _2734_/S _2713_/B _2713_/A _2714_/C gf180mcu_as_sc_mcu7t3v3__mux2_2
X_2644_ VDD VDD VSS VSS _2666_/B _2644_/C _2644_/B _2659_/S gf180mcu_as_sc_mcu7t3v3__aoi21b_2
XFILLER_138_1410 VDD VDD VSS VSS gf180mcu_as_sc_mcu7t3v3__fillcap_4
Xoutput335 VDD VDD VSS VSS _4858_/Q east_out[19] gf180mcu_as_sc_mcu7t3v3__buff_12
Xoutput324 VDD VDD VSS VSS _5485_/Y dft_rdata[7] gf180mcu_as_sc_mcu7t3v3__buff_12
X_2575_ VDD VDD VSS VSS _2599_/A _2852_/B _2575_/B _5097_/Q gf180mcu_as_sc_mcu7t3v3__ao21_2
XFILLER_47_1348 VDD VDD VSS VSS gf180mcu_as_sc_mcu7t3v3__fillcap_16
XFILLER_86_1364 VDD VDD VSS VSS gf180mcu_as_sc_mcu7t3v3__fillcap_4
Xoutput368 VDD VDD VSS VSS _4789_/Q se_out[18] gf180mcu_as_sc_mcu7t3v3__buff_12
Xoutput357 VDD VDD VSS VSS _4847_/Q east_out[8] gf180mcu_as_sc_mcu7t3v3__buff_12
Xoutput346 VDD VDD VSS VSS _4868_/Q east_out[29] gf180mcu_as_sc_mcu7t3v3__buff_12
X_4314_ VDD VDD VSS VSS _4314_/S _5144_/Q _5143_/Q _5143_/D gf180mcu_as_sc_mcu7t3v3__mux2_2
XTAP_TAPCELL_ROW_91_3_2994 VDD VSS gf180mcu_as_sc_mcu7t3v3__tap_2
XFILLER_113_142 VDD VDD VSS VSS gf180mcu_as_sc_mcu7t3v3__fillcap_4
Xoutput379 VDD VDD VSS VSS _4799_/Q se_out[28] gf180mcu_as_sc_mcu7t3v3__buff_12
XFILLER_206_85 VDD VDD VSS VSS gf180mcu_as_sc_mcu7t3v3__fillcap_16
X_4245_ VDD VDD VSS VSS _4257_/S _4245_/B _5081_/Q _5081_/D gf180mcu_as_sc_mcu7t3v3__mux2_2
X_4176_ VDD VDD VSS VSS _4236_/B _4191_/B _4191_/C _5014_/Q _5014_/D gf180mcu_as_sc_mcu7t3v3__ao22_2
XFILLER_210_1239 VDD VDD VSS VSS gf180mcu_as_sc_mcu7t3v3__fill_2
X_3127_ VDD VDD VSS VSS _4102_/A _3127_/B _3127_/C _4101_/D _3128_/C gf180mcu_as_sc_mcu7t3v3__ao22_2
XFILLER_35_27 VDD VDD VSS VSS gf180mcu_as_sc_mcu7t3v3__fillcap_16
XFILLER_36_682 VDD VDD VSS VSS gf180mcu_as_sc_mcu7t3v3__fill_2
XFILLER_42_107 VDD VDD VSS VSS gf180mcu_as_sc_mcu7t3v3__fillcap_16
XPHY_EDGE_ROW_100_1_Left_310 VDD VSS gf180mcu_as_sc_mcu7t3v3__tap_2
X_3058_ VDD VDD VSS VSS _4038_/A _3229_/B _3150_/C _4037_/A _3064_/B gf180mcu_as_sc_mcu7t3v3__ao22_2
XFILLER_180_1327 VDD VDD VSS VSS gf180mcu_as_sc_mcu7t3v3__fillcap_16
XFILLER_196_613 VDD VDD VSS VSS gf180mcu_as_sc_mcu7t3v3__fillcap_16
XFILLER_208_1146 VDD VDD VSS VSS gf180mcu_as_sc_mcu7t3v3__fillcap_8
XFILLER_208_1157 VDD VDD VSS VSS gf180mcu_as_sc_mcu7t3v3__fillcap_16
XFILLER_24_877 VDD VDD VSS VSS gf180mcu_as_sc_mcu7t3v3__fill_1
XPHY_EDGE_ROW_95_1_Right_616 VDD VSS gf180mcu_as_sc_mcu7t3v3__tap_2
XTAP_TAPCELL_ROW_160_1_1924 VDD VSS gf180mcu_as_sc_mcu7t3v3__tap_2
XFILLER_17_1141 VDD VDD VSS VSS gf180mcu_as_sc_mcu7t3v3__fillcap_16
XTAP_TAPCELL_ROW_172_3_3236 VDD VSS gf180mcu_as_sc_mcu7t3v3__tap_2
XFILLER_177_871 VDD VDD VSS VSS gf180mcu_as_sc_mcu7t3v3__fillcap_16
XFILLER_176_381 VDD VDD VSS VSS gf180mcu_as_sc_mcu7t3v3__fillcap_4
XFILLER_178_1201 VDD VDD VSS VSS gf180mcu_as_sc_mcu7t3v3__fillcap_16
XFILLER_191_384 VDD VDD VSS VSS gf180mcu_as_sc_mcu7t3v3__fillcap_16
XTAP_TAPCELL_ROW_140_1_1866 VDD VSS gf180mcu_as_sc_mcu7t3v3__tap_2
XTAP_TAPCELL_ROW_152_3_3178 VDD VSS gf180mcu_as_sc_mcu7t3v3__tap_2
XFILLER_65_1426 VDD VDD VSS VSS gf180mcu_as_sc_mcu7t3v3__fillcap_4
XTAP_TAPCELL_ROW_18_1124 VDD VSS gf180mcu_as_sc_mcu7t3v3__tap_2
XPHY_EDGE_ROW_71_3_Right_108 VDD VSS gf180mcu_as_sc_mcu7t3v3__tap_2
XTAP_TAPCELL_ROW_18_1135 VDD VSS gf180mcu_as_sc_mcu7t3v3__tap_2
XFILLER_116_85 VDD VDD VSS VSS gf180mcu_as_sc_mcu7t3v3__fillcap_16
XFILLER_76_34 VDD VDD VSS VSS gf180mcu_as_sc_mcu7t3v3__fill_1
Xfanout540 VDD VDD VSS VSS _3408_/B _3477_/B gf180mcu_as_sc_mcu7t3v3__buff_12
Xfanout551 VDD VDD VSS VSS _4334_/Y _4533_/A gf180mcu_as_sc_mcu7t3v3__buff_12
XFILLER_28_1292 VDD VDD VSS VSS gf180mcu_as_sc_mcu7t3v3__fill_2
Xfanout562 VDD VDD VSS VSS fanout562/A _4141_/B gf180mcu_as_sc_mcu7t3v3__buff_12
Xfanout573 VDD VDD VSS VSS _3561_/Y _3758_/B gf180mcu_as_sc_mcu7t3v3__buff_12
Xfanout584 VDD VDD VSS VSS _3194_/S _3115_/A gf180mcu_as_sc_mcu7t3v3__buff_12
XTAP_TAPCELL_ROW_35_1493 VDD VSS gf180mcu_as_sc_mcu7t3v3__tap_2
Xfanout595 VDD VDD VSS VSS _4196_/C _4197_/C gf180mcu_as_sc_mcu7t3v3__buff_12
XFILLER_41_1470 VDD VDD VSS VSS gf180mcu_as_sc_mcu7t3v3__fillcap_16
Xclkbuf_leaf_12_clk_regs VDD VDD VSS VSS clkbuf_3_4__f_clk_regs/Y _5278_/CLK gf180mcu_as_sc_mcu7t3v3__clkbuff_12
XFILLER_132_95 VDD VDD VSS VSS gf180mcu_as_sc_mcu7t3v3__fillcap_8
XFILLER_189_1396 VDD VDD VSS VSS gf180mcu_as_sc_mcu7t3v3__fillcap_4
XTAP_TAPCELL_ROW_2_781 VDD VSS gf180mcu_as_sc_mcu7t3v3__tap_2
XTAP_TAPCELL_ROW_2_770 VDD VSS gf180mcu_as_sc_mcu7t3v3__tap_2
XFILLER_199_462 VDD VDD VSS VSS gf180mcu_as_sc_mcu7t3v3__fillcap_16
XFILLER_203_912 VDD VDD VSS VSS gf180mcu_as_sc_mcu7t3v3__fillcap_16
XFILLER_92_66 VDD VDD VSS VSS gf180mcu_as_sc_mcu7t3v3__fill_2
XFILLER_14_365 VDD VDD VSS VSS gf180mcu_as_sc_mcu7t3v3__fillcap_16
XFILLER_186_101 VDD VDD VSS VSS gf180mcu_as_sc_mcu7t3v3__fillcap_4
XFILLER_163_1558 VDD VDD VSS VSS gf180mcu_as_sc_mcu7t3v3__fillcap_8
XFILLER_186_123 VDD VDD VSS VSS gf180mcu_as_sc_mcu7t3v3__fillcap_8
XFILLER_126_1380 VDD VDD VSS VSS gf180mcu_as_sc_mcu7t3v3__fill_1
XFILLER_186_167 VDD VDD VSS VSS gf180mcu_as_sc_mcu7t3v3__fillcap_8
XFILLER_127_212 VDD VDD VSS VSS gf180mcu_as_sc_mcu7t3v3__fillcap_8
XFILLER_100_1520 VDD VDD VSS VSS gf180mcu_as_sc_mcu7t3v3__fill_1
XFILLER_183_874 VDD VDD VSS VSS gf180mcu_as_sc_mcu7t3v3__fillcap_16
XFILLER_196_1345 VDD VDD VSS VSS gf180mcu_as_sc_mcu7t3v3__fillcap_16
XFILLER_142_204 VDD VDD VSS VSS gf180mcu_as_sc_mcu7t3v3__fillcap_16
XFILLER_196_1367 VDD VDD VSS VSS gf180mcu_as_sc_mcu7t3v3__fillcap_16
XTAP_TAPCELL_ROW_188_2312 VDD VSS gf180mcu_as_sc_mcu7t3v3__tap_2
XTAP_TAPCELL_ROW_188_2301 VDD VSS gf180mcu_as_sc_mcu7t3v3__tap_2
XFILLER_83_1504 VDD VDD VSS VSS gf180mcu_as_sc_mcu7t3v3__fill_2
XFILLER_29_1045 VDD VDD VSS VSS gf180mcu_as_sc_mcu7t3v3__fillcap_4
XFILLER_110_101 VDD VDD VSS VSS gf180mcu_as_sc_mcu7t3v3__fillcap_4
XFILLER_110_123 VDD VDD VSS VSS gf180mcu_as_sc_mcu7t3v3__fillcap_8
XFILLER_2_792 VDD VDD VSS VSS gf180mcu_as_sc_mcu7t3v3__fill_1
XFILLER_2_53 VDD VDD VSS VSS gf180mcu_as_sc_mcu7t3v3__fill_2
XPHY_EDGE_ROW_10_Right_10 VDD VSS gf180mcu_as_sc_mcu7t3v3__tap_2
X_4030_ VDD VDD VSS VSS _4030_/A _4030_/B _4030_/C _4030_/D _4031_/D gf180mcu_as_sc_mcu7t3v3__ao22_2
XTAP_TAPCELL_ROW_165_1_1939 VDD VSS gf180mcu_as_sc_mcu7t3v3__tap_2
XTAP_TAPCELL_ROW_0_707 VDD VSS gf180mcu_as_sc_mcu7t3v3__tap_2
XTAP_TAPCELL_ROW_0_718 VDD VSS gf180mcu_as_sc_mcu7t3v3__tap_2
XTAP_TAPCELL_ROW_0_729 VDD VSS gf180mcu_as_sc_mcu7t3v3__tap_2
XTAP_TAPCELL_ROW_67_3_2923 VDD VSS gf180mcu_as_sc_mcu7t3v3__tap_2
XFILLER_168_1447 VDD VDD VSS VSS gf180mcu_as_sc_mcu7t3v3__fillcap_4
XFILLER_168_1469 VDD VDD VSS VSS gf180mcu_as_sc_mcu7t3v3__fill_2
XFILLER_24_107 VDD VDD VSS VSS gf180mcu_as_sc_mcu7t3v3__fillcap_16
XFILLER_17_170 VDD VDD VSS VSS gf180mcu_as_sc_mcu7t3v3__fillcap_16
XFILLER_205_260 VDD VDD VSS VSS gf180mcu_as_sc_mcu7t3v3__fillcap_16
XPHY_EDGE_ROW_44_3_Right_81 VDD VSS gf180mcu_as_sc_mcu7t3v3__tap_2
X_4932_ VDD VDD VSS VSS _5277_/CLK _4932_/D _4932_/Q gf180mcu_as_sc_mcu7t3v3__dfxtp_2
XFILLER_17_192 VDD VDD VSS VSS gf180mcu_as_sc_mcu7t3v3__fill_1
XFILLER_205_282 VDD VDD VSS VSS gf180mcu_as_sc_mcu7t3v3__fillcap_16
XFILLER_209_1466 VDD VDD VSS VSS gf180mcu_as_sc_mcu7t3v3__fillcap_4
XANTENNA_14 VDD VDD VSS VSS _4917_/D gf180mcu_as_sc_mcu7t3v3__diode_2
XFILLER_209_1488 VDD VDD VSS VSS gf180mcu_as_sc_mcu7t3v3__fillcap_16
XFILLER_20_302 VDD VDD VSS VSS gf180mcu_as_sc_mcu7t3v3__fillcap_8
XFILLER_21_836 VDD VDD VSS VSS gf180mcu_as_sc_mcu7t3v3__fillcap_4
XFILLER_36_1038 VDD VDD VSS VSS gf180mcu_as_sc_mcu7t3v3__fillcap_4
X_4863_ VDD VDD VSS VSS _5220_/CLK _4863_/D _4863_/Q gf180mcu_as_sc_mcu7t3v3__dfxtp_2
XANTENNA_25 VDD VDD VSS VSS _3913_/A gf180mcu_as_sc_mcu7t3v3__diode_2
XFILLER_21_858 VDD VDD VSS VSS gf180mcu_as_sc_mcu7t3v3__fillcap_4
XFILLER_53_1352 VDD VDD VSS VSS gf180mcu_as_sc_mcu7t3v3__fill_2
X_4794_ VDD VDD VSS VSS _4869_/CLK _4794_/D _4794_/Q gf180mcu_as_sc_mcu7t3v3__dfxtp_2
X_3814_ VDD VDD VSS VSS _3814_/B _3814_/A _3920_/B gf180mcu_as_sc_mcu7t3v3__or2_2
XFILLER_14_1336 VDD VDD VSS VSS gf180mcu_as_sc_mcu7t3v3__fill_2
XFILLER_14_1358 VDD VDD VSS VSS gf180mcu_as_sc_mcu7t3v3__fillcap_4
XFILLER_21_18 VDD VDD VSS VSS gf180mcu_as_sc_mcu7t3v3__fillcap_16
X_3745_ VDD VDD VSS VSS _3746_/C _3745_/C _3766_/B _4122_/A gf180mcu_as_sc_mcu7t3v3__aoi21_2
XFILLER_174_852 VDD VDD VSS VSS gf180mcu_as_sc_mcu7t3v3__fill_2
XFILLER_175_1418 VDD VDD VSS VSS gf180mcu_as_sc_mcu7t3v3__fillcap_16
X_3676_ VDD VDD VSS VSS _3676_/A _3676_/B _3676_/C _3676_/Y _4199_/A gf180mcu_as_sc_mcu7t3v3__aoi211_2
X_2627_ VDD VDD VSS VSS _2627_/D _4262_/B _2627_/B _2627_/C _2628_/B gf180mcu_as_sc_mcu7t3v3__ao31_2
X_2558_ VDD VDD VSS VSS _2558_/D _2558_/A _2558_/B _2558_/C _2559_/B gf180mcu_as_sc_mcu7t3v3__ao31_2
XFILLER_25_1410 VDD VDD VSS VSS gf180mcu_as_sc_mcu7t3v3__fillcap_4
XFILLER_99_195 VDD VDD VSS VSS gf180mcu_as_sc_mcu7t3v3__fillcap_8
X_5277_ VDD VDD VSS VSS _5277_/CLK _5277_/D _5277_/Q gf180mcu_as_sc_mcu7t3v3__dfxtp_2
X_2489_ VDD VDD VSS VSS _4594_/A _4329_/A _4719_/A gf180mcu_as_sc_mcu7t3v3__nand2_2
XFILLER_25_1443 VDD VDD VSS VSS gf180mcu_as_sc_mcu7t3v3__fillcap_16
XTAP_TAPCELL_ROW_13_1010 VDD VSS gf180mcu_as_sc_mcu7t3v3__tap_2
X_4228_ VDD VDD VSS VSS _4257_/B _4228_/B _4228_/C _5064_/Q _5064_/D gf180mcu_as_sc_mcu7t3v3__ao22_2
XFILLER_151_1484 VDD VDD VSS VSS gf180mcu_as_sc_mcu7t3v3__fill_2
XTAP_TAPCELL_ROW_13_1021 VDD VSS gf180mcu_as_sc_mcu7t3v3__tap_2
XFILLER_186_1503 VDD VDD VSS VSS gf180mcu_as_sc_mcu7t3v3__fill_2
XFILLER_210_1047 VDD VDD VSS VSS gf180mcu_as_sc_mcu7t3v3__fillcap_4
XFILLER_21_1329 VDD VDD VSS VSS gf180mcu_as_sc_mcu7t3v3__fill_1
XFILLER_28_435 VDD VDD VSS VSS gf180mcu_as_sc_mcu7t3v3__fillcap_4
XFILLER_28_457 VDD VDD VSS VSS gf180mcu_as_sc_mcu7t3v3__fill_1
XFILLER_46_37 VDD VDD VSS VSS gf180mcu_as_sc_mcu7t3v3__fillcap_16
XFILLER_55_221 VDD VDD VSS VSS gf180mcu_as_sc_mcu7t3v3__fill_1
XFILLER_99_1566 VDD VDD VSS VSS gf180mcu_as_sc_mcu7t3v3__fill_2
X_4159_ VDD VDD VSS VSS _4159_/A _4159_/B _4159_/C _4159_/D _4161_/C gf180mcu_as_sc_mcu7t3v3__ao22_2
XTAP_TAPCELL_ROW_30_1390 VDD VSS gf180mcu_as_sc_mcu7t3v3__tap_2
XFILLER_102_32 VDD VDD VSS VSS gf180mcu_as_sc_mcu7t3v3__fill_2
XFILLER_15_118 VDD VDD VSS VSS gf180mcu_as_sc_mcu7t3v3__fillcap_16
XFILLER_197_944 VDD VDD VSS VSS gf180mcu_as_sc_mcu7t3v3__fillcap_16
XFILLER_168_123 VDD VDD VSS VSS gf180mcu_as_sc_mcu7t3v3__fillcap_16
XFILLER_180_1135 VDD VDD VSS VSS gf180mcu_as_sc_mcu7t3v3__fillcap_16
XFILLER_184_1293 VDD VDD VSS VSS gf180mcu_as_sc_mcu7t3v3__fill_2
XFILLER_196_443 VDD VDD VSS VSS gf180mcu_as_sc_mcu7t3v3__fill_2
XFILLER_19_1258 VDD VDD VSS VSS gf180mcu_as_sc_mcu7t3v3__fill_2
XFILLER_23_162 VDD VDD VSS VSS gf180mcu_as_sc_mcu7t3v3__fill_1
XPHY_EDGE_ROW_96_1_Right_617 VDD VSS gf180mcu_as_sc_mcu7t3v3__tap_2
XFILLER_11_324 VDD VDD VSS VSS gf180mcu_as_sc_mcu7t3v3__fillcap_16
XFILLER_123_1520 VDD VDD VSS VSS gf180mcu_as_sc_mcu7t3v3__fillcap_8
XFILLER_178_69 VDD VDD VSS VSS gf180mcu_as_sc_mcu7t3v3__fillcap_16
XFILLER_180_1157 VDD VDD VSS VSS gf180mcu_as_sc_mcu7t3v3__fillcap_16
XFILLER_183_104 VDD VDD VSS VSS gf180mcu_as_sc_mcu7t3v3__fillcap_16
XFILLER_36_1561 VDD VDD VSS VSS gf180mcu_as_sc_mcu7t3v3__fill_2
XFILLER_8_807 VDD VDD VSS VSS gf180mcu_as_sc_mcu7t3v3__fillcap_16
XFILLER_109_212 VDD VDD VSS VSS gf180mcu_as_sc_mcu7t3v3__fillcap_8
XFILLER_11_379 VDD VDD VSS VSS gf180mcu_as_sc_mcu7t3v3__fillcap_8
XFILLER_180_811 VDD VDD VSS VSS gf180mcu_as_sc_mcu7t3v3__fill_1
XFILLER_69_1370 VDD VDD VSS VSS gf180mcu_as_sc_mcu7t3v3__fill_1
XFILLER_180_877 VDD VDD VSS VSS gf180mcu_as_sc_mcu7t3v3__fillcap_16
XFILLER_2_2 VDD VDD VSS VSS gf180mcu_as_sc_mcu7t3v3__fillcap_8
XFILLER_3_578 VDD VDD VSS VSS gf180mcu_as_sc_mcu7t3v3__fill_2
XPHY_EDGE_ROW_72_3_Right_109 VDD VSS gf180mcu_as_sc_mcu7t3v3__tap_2
XFILLER_117_1368 VDD VDD VSS VSS gf180mcu_as_sc_mcu7t3v3__fill_2
XFILLER_87_88 VDD VDD VSS VSS gf180mcu_as_sc_mcu7t3v3__fillcap_16
XFILLER_8_1150 VDD VDD VSS VSS gf180mcu_as_sc_mcu7t3v3__fillcap_4
XTAP_TAPCELL_ROW_7_895 VDD VSS gf180mcu_as_sc_mcu7t3v3__tap_2
XTAP_TAPCELL_ROW_7_884 VDD VSS gf180mcu_as_sc_mcu7t3v3__tap_2
XFILLER_143_72 VDD VDD VSS VSS gf180mcu_as_sc_mcu7t3v3__fillcap_8
XFILLER_4_1025 VDD VDD VSS VSS gf180mcu_as_sc_mcu7t3v3__fillcap_4
XFILLER_130_1535 VDD VDD VSS VSS gf180mcu_as_sc_mcu7t3v3__fillcap_4
XFILLER_19_424 VDD VDD VSS VSS gf180mcu_as_sc_mcu7t3v3__fill_1
XFILLER_130_1568 VDD VDD VSS VSS gf180mcu_as_sc_mcu7t3v3__fill_1
XFILLER_185_1046 VDD VDD VSS VSS gf180mcu_as_sc_mcu7t3v3__fillcap_4
XFILLER_185_1068 VDD VDD VSS VSS gf180mcu_as_sc_mcu7t3v3__fillcap_16
XFILLER_36_81 VDD VDD VSS VSS gf180mcu_as_sc_mcu7t3v3__fillcap_16
XFILLER_15_652 VDD VDD VSS VSS gf180mcu_as_sc_mcu7t3v3__fill_1
XFILLER_128_1453 VDD VDD VSS VSS gf180mcu_as_sc_mcu7t3v3__fillcap_4
XFILLER_15_696 VDD VDD VSS VSS gf180mcu_as_sc_mcu7t3v3__fillcap_4
XFILLER_202_241 VDD VDD VSS VSS gf180mcu_as_sc_mcu7t3v3__fillcap_4
XTAP_TAPCELL_ROW_177_2068 VDD VSS gf180mcu_as_sc_mcu7t3v3__tap_2
XTAP_TAPCELL_ROW_177_2057 VDD VSS gf180mcu_as_sc_mcu7t3v3__tap_2
XFILLER_187_476 VDD VDD VSS VSS gf180mcu_as_sc_mcu7t3v3__fillcap_4
XFILLER_187_487 VDD VDD VSS VSS gf180mcu_as_sc_mcu7t3v3__fill_2
XFILLER_202_263 VDD VDD VSS VSS gf180mcu_as_sc_mcu7t3v3__fillcap_16
XFILLER_174_104 VDD VDD VSS VSS gf180mcu_as_sc_mcu7t3v3__fillcap_8
XFILLER_200_1205 VDD VDD VSS VSS gf180mcu_as_sc_mcu7t3v3__fillcap_16
XFILLER_52_80 VDD VDD VSS VSS gf180mcu_as_sc_mcu7t3v3__fillcap_16
Xinput12 VDD VDD VSS VSS boot_data[0] _2685_/A gf180mcu_as_sc_mcu7t3v3__buff_12
XFILLER_11_1509 VDD VDD VSS VSS gf180mcu_as_sc_mcu7t3v3__fillcap_4
XFILLER_200_1227 VDD VDD VSS VSS gf180mcu_as_sc_mcu7t3v3__fillcap_16
Xinput23 VDD VDD VSS VSS dft_addr[10] _2583_/B gf180mcu_as_sc_mcu7t3v3__buff_12
Xinput34 VDD VDD VSS VSS dft_mode input34/Y gf180mcu_as_sc_mcu7t3v3__buff_12
Xinput45 VDD VDD VSS VSS east_in[10] wire856/A gf180mcu_as_sc_mcu7t3v3__buff_12
X_3530_ VDD VDD VSS VSS _3530_/B _3530_/A _3807_/B gf180mcu_as_sc_mcu7t3v3__and2_2
XFILLER_183_671 VDD VDD VSS VSS gf180mcu_as_sc_mcu7t3v3__fillcap_4
XTAP_TAPCELL_ROW_109_1_1771 VDD VSS gf180mcu_as_sc_mcu7t3v3__tap_2
Xinput56 VDD VDD VSS VSS east_in[20] wire850/A gf180mcu_as_sc_mcu7t3v3__buff_12
Xinput67 VDD VDD VSS VSS east_in[30] wire840/A gf180mcu_as_sc_mcu7t3v3__buff_12
Xinput78 VDD VDD VSS VSS ne_in[0] wire833/A gf180mcu_as_sc_mcu7t3v3__buff_12
Xinput89 VDD VDD VSS VSS ne_in[1] wire828/A gf180mcu_as_sc_mcu7t3v3__buff_12
XFILLER_192_1017 VDD VDD VSS VSS gf180mcu_as_sc_mcu7t3v3__fillcap_16
X_4902__1065 VDD VDD VSS VSS _4902_/D gf180mcu_as_sc_mcu7t3v3__tiel_4
X_3461_ VDD VDD VSS VSS _4110_/A _3467_/C _3522_/C _4114_/A _3462_/C gf180mcu_as_sc_mcu7t3v3__ao22_2
XFILLER_100_1383 VDD VDD VSS VSS gf180mcu_as_sc_mcu7t3v3__fillcap_16
X_5200_ VDD VDD VSS VSS _5216_/CLK _5200_/D _5200_/Q gf180mcu_as_sc_mcu7t3v3__dfxtp_2
X_3392_ VDD VDD VSS VSS _4043_/A _3463_/B _3392_/C _4818_/D _3463_/D gf180mcu_as_sc_mcu7t3v3__aoi211_2
X_2412_ VDD VDD VSS VSS _2511_/C _5257_/Q gf180mcu_as_sc_mcu7t3v3__inv_2
XFILLER_135_1413 VDD VDD VSS VSS gf180mcu_as_sc_mcu7t3v3__fill_2
XFILLER_48_1465 VDD VDD VSS VSS gf180mcu_as_sc_mcu7t3v3__fillcap_16
XFILLER_83_1356 VDD VDD VSS VSS gf180mcu_as_sc_mcu7t3v3__fill_2
X_5131_ VDD VDD VSS VSS _5198_/CLK _5131_/D _5131_/Q gf180mcu_as_sc_mcu7t3v3__dfxtp_2
XFILLER_170_1348 VDD VDD VSS VSS gf180mcu_as_sc_mcu7t3v3__fillcap_16
XFILLER_96_143 VDD VDD VSS VSS gf180mcu_as_sc_mcu7t3v3__fill_2
X_5062_ VDD VDD VSS VSS clkload4/A _5062_/D _5062_/Q gf180mcu_as_sc_mcu7t3v3__dfxtp_2
X_4013_ VDD VDD VSS VSS _4013_/A _4101_/B _4101_/C _4013_/D _4015_/C gf180mcu_as_sc_mcu7t3v3__ao22_2
XTAP_TAPCELL_ROW_209_2779 VDD VSS gf180mcu_as_sc_mcu7t3v3__tap_2
XTAP_TAPCELL_ROW_209_2768 VDD VSS gf180mcu_as_sc_mcu7t3v3__tap_2
XFILLER_26_928 VDD VDD VSS VSS gf180mcu_as_sc_mcu7t3v3__fill_2
XFILLER_0_1489 VDD VDD VSS VSS gf180mcu_as_sc_mcu7t3v3__fillcap_4
XFILLER_206_591 VDD VDD VSS VSS gf180mcu_as_sc_mcu7t3v3__fillcap_4
XFILLER_55_1414 VDD VDD VSS VSS gf180mcu_as_sc_mcu7t3v3__fill_2
XFILLER_178_421 VDD VDD VSS VSS gf180mcu_as_sc_mcu7t3v3__fill_2
XFILLER_179_944 VDD VDD VSS VSS gf180mcu_as_sc_mcu7t3v3__fillcap_16
XFILLER_205_1116 VDD VDD VSS VSS gf180mcu_as_sc_mcu7t3v3__fillcap_4
XFILLER_21_622 VDD VDD VSS VSS gf180mcu_as_sc_mcu7t3v3__fillcap_8
XFILLER_94_1485 VDD VDD VSS VSS gf180mcu_as_sc_mcu7t3v3__fillcap_16
X_4915_ VDD VDD VSS VSS _4916_/CLK _4915_/D _4915_/Q gf180mcu_as_sc_mcu7t3v3__dfxtp_2
XFILLER_205_1138 VDD VDD VSS VSS gf180mcu_as_sc_mcu7t3v3__fillcap_16
X_4846_ VDD VDD VSS VSS _5241_/CLK _4846_/D _4846_/Q gf180mcu_as_sc_mcu7t3v3__dfxtp_2
XFILLER_14_1111 VDD VDD VSS VSS gf180mcu_as_sc_mcu7t3v3__fill_1
XFILLER_14_1133 VDD VDD VSS VSS gf180mcu_as_sc_mcu7t3v3__fill_2
XFILLER_18_1291 VDD VDD VSS VSS gf180mcu_as_sc_mcu7t3v3__fillcap_4
XFILLER_194_947 VDD VDD VSS VSS gf180mcu_as_sc_mcu7t3v3__fillcap_16
XFILLER_193_468 VDD VDD VSS VSS gf180mcu_as_sc_mcu7t3v3__fillcap_16
XFILLER_21_699 VDD VDD VSS VSS gf180mcu_as_sc_mcu7t3v3__fill_1
X_4777_ VDD VDD VSS VSS _5142_/CLK _4777_/D _4777_/Q gf180mcu_as_sc_mcu7t3v3__dfxtp_2
XFILLER_174_682 VDD VDD VSS VSS gf180mcu_as_sc_mcu7t3v3__fillcap_4
XFILLER_180_107 VDD VDD VSS VSS gf180mcu_as_sc_mcu7t3v3__fillcap_16
X_3728_ VDD VDD VSS VSS _3728_/D _4104_/D _3728_/B _3728_/C _3729_/C gf180mcu_as_sc_mcu7t3v3__ao31_2
XTAP_TAPCELL_ROW_61_1_1629 VDD VSS gf180mcu_as_sc_mcu7t3v3__tap_2
X_3659_ VDD VDD VSS VSS _4032_/A _3726_/B _3659_/C _3661_/B _3660_/C gf180mcu_as_sc_mcu7t3v3__ao211_2
XFILLER_121_207 VDD VDD VSS VSS gf180mcu_as_sc_mcu7t3v3__fill_2
XFILLER_153_1502 VDD VDD VSS VSS gf180mcu_as_sc_mcu7t3v3__fill_1
XFILLER_164_49 VDD VDD VSS VSS gf180mcu_as_sc_mcu7t3v3__fill_2
XFILLER_153_1568 VDD VDD VSS VSS gf180mcu_as_sc_mcu7t3v3__fill_1
XTAP_TAPCELL_ROW_4_810 VDD VSS gf180mcu_as_sc_mcu7t3v3__tap_2
XFILLER_180_37 VDD VDD VSS VSS gf180mcu_as_sc_mcu7t3v3__fillcap_16
XFILLER_196_6 VDD VDD VSS VSS gf180mcu_as_sc_mcu7t3v3__fillcap_16
XFILLER_25_1240 VDD VDD VSS VSS gf180mcu_as_sc_mcu7t3v3__fill_2
XFILLER_25_1262 VDD VDD VSS VSS gf180mcu_as_sc_mcu7t3v3__fillcap_16
XTAP_TAPCELL_ROW_135_1_1850 VDD VSS gf180mcu_as_sc_mcu7t3v3__tap_2
XTAP_TAPCELL_ROW_147_3_3162 VDD VSS gf180mcu_as_sc_mcu7t3v3__tap_2
XTAP_TAPCELL_ROW_4_821 VDD VSS gf180mcu_as_sc_mcu7t3v3__tap_2
XTAP_TAPCELL_ROW_32_1441 VDD VSS gf180mcu_as_sc_mcu7t3v3__tap_2
XTAP_TAPCELL_ROW_32_1430 VDD VSS gf180mcu_as_sc_mcu7t3v3__tap_2
XFILLER_29_766 VDD VDD VSS VSS gf180mcu_as_sc_mcu7t3v3__fillcap_4
XFILLER_29_788 VDD VDD VSS VSS gf180mcu_as_sc_mcu7t3v3__fillcap_16
XFILLER_28_298 VDD VDD VSS VSS gf180mcu_as_sc_mcu7t3v3__fillcap_16
XFILLER_73_46 VDD VDD VSS VSS gf180mcu_as_sc_mcu7t3v3__fillcap_16
XFILLER_186_1399 VDD VDD VSS VSS gf180mcu_as_sc_mcu7t3v3__fillcap_16
XFILLER_19_1011 VDD VDD VSS VSS gf180mcu_as_sc_mcu7t3v3__fill_1
XFILLER_197_730 VDD VDD VSS VSS gf180mcu_as_sc_mcu7t3v3__fill_1
XFILLER_73_1558 VDD VDD VSS VSS gf180mcu_as_sc_mcu7t3v3__fillcap_8
XFILLER_19_1088 VDD VDD VSS VSS gf180mcu_as_sc_mcu7t3v3__fill_1
XPHY_EDGE_ROW_97_1_Right_618 VDD VSS gf180mcu_as_sc_mcu7t3v3__tap_2
XFILLER_201_1536 VDD VDD VSS VSS gf180mcu_as_sc_mcu7t3v3__fillcap_4
XFILLER_22_61 VDD VDD VSS VSS gf180mcu_as_sc_mcu7t3v3__fill_2
XFILLER_32_1233 VDD VDD VSS VSS gf180mcu_as_sc_mcu7t3v3__fill_1
XFILLER_7_136 VDD VDD VSS VSS gf180mcu_as_sc_mcu7t3v3__fillcap_4
XFILLER_171_118 VDD VDD VSS VSS gf180mcu_as_sc_mcu7t3v3__fill_1
XFILLER_7_158 VDD VDD VSS VSS gf180mcu_as_sc_mcu7t3v3__fillcap_16
XFILLER_10_1531 VDD VDD VSS VSS gf180mcu_as_sc_mcu7t3v3__fill_1
XFILLER_158_1446 VDD VDD VSS VSS gf180mcu_as_sc_mcu7t3v3__fillcap_4
XFILLER_180_641 VDD VDD VSS VSS gf180mcu_as_sc_mcu7t3v3__fill_2
XFILLER_193_1326 VDD VDD VSS VSS gf180mcu_as_sc_mcu7t3v3__fillcap_4
XFILLER_4_821 VDD VDD VSS VSS gf180mcu_as_sc_mcu7t3v3__fillcap_16
XFILLER_158_1468 VDD VDD VSS VSS gf180mcu_as_sc_mcu7t3v3__fillcap_16
XFILLER_180_663 VDD VDD VSS VSS gf180mcu_as_sc_mcu7t3v3__fill_2
XFILLER_180_685 VDD VDD VSS VSS gf180mcu_as_sc_mcu7t3v3__fill_1
XFILLER_193_1348 VDD VDD VSS VSS gf180mcu_as_sc_mcu7t3v3__fill_2
XFILLER_3_331 VDD VDD VSS VSS gf180mcu_as_sc_mcu7t3v3__fillcap_16
XFILLER_208_801 VDD VDD VSS VSS gf180mcu_as_sc_mcu7t3v3__fillcap_4
XFILLER_130_1387 VDD VDD VSS VSS gf180mcu_as_sc_mcu7t3v3__fill_2
XFILLER_169_1553 VDD VDD VSS VSS gf180mcu_as_sc_mcu7t3v3__fill_2
XFILLER_19_276 VDD VDD VSS VSS gf180mcu_as_sc_mcu7t3v3__fillcap_4
XFILLER_19_298 VDD VDD VSS VSS gf180mcu_as_sc_mcu7t3v3__fillcap_16
XFILLER_78_1469 VDD VDD VSS VSS gf180mcu_as_sc_mcu7t3v3__fillcap_16
XTAP_TAPCELL_ROW_204_2665 VDD VSS gf180mcu_as_sc_mcu7t3v3__tap_2
XTAP_TAPCELL_ROW_204_2654 VDD VSS gf180mcu_as_sc_mcu7t3v3__tap_2
XTAP_TAPCELL_ROW_179_2119 VDD VSS gf180mcu_as_sc_mcu7t3v3__tap_2
XTAP_TAPCELL_ROW_179_2108 VDD VSS gf180mcu_as_sc_mcu7t3v3__tap_2
XFILLER_23_909 VDD VDD VSS VSS gf180mcu_as_sc_mcu7t3v3__fill_1
XFILLER_35_758 VDD VDD VSS VSS gf180mcu_as_sc_mcu7t3v3__fill_1
XFILLER_35_769 VDD VDD VSS VSS gf180mcu_as_sc_mcu7t3v3__fill_1
XFILLER_210_509 VDD VDD VSS VSS gf180mcu_as_sc_mcu7t3v3__fill_1
XFILLER_31_920 VDD VDD VSS VSS gf180mcu_as_sc_mcu7t3v3__fillcap_4
X_2961_ VDD VDD VSS VSS _3045_/A _2961_/B _2961_/C _3045_/D _2962_/D gf180mcu_as_sc_mcu7t3v3__ao211_2
XTAP_TAPCELL_ROW_173_3_3241 VDD VSS gf180mcu_as_sc_mcu7t3v3__tap_2
XFILLER_176_925 VDD VDD VSS VSS gf180mcu_as_sc_mcu7t3v3__fillcap_16
XFILLER_188_785 VDD VDD VSS VSS gf180mcu_as_sc_mcu7t3v3__fillcap_16
XFILLER_30_430 VDD VDD VSS VSS gf180mcu_as_sc_mcu7t3v3__fillcap_4
X_4700_ VDD VDD VSS VSS _4733_/C _5483_/A _5256_/Q _4701_/A gf180mcu_as_sc_mcu7t3v3__mux2_2
XTAP_TAPCELL_ROW_196_2488 VDD VSS gf180mcu_as_sc_mcu7t3v3__tap_2
XTAP_TAPCELL_ROW_196_2477 VDD VSS gf180mcu_as_sc_mcu7t3v3__tap_2
XFILLER_147_104 VDD VDD VSS VSS gf180mcu_as_sc_mcu7t3v3__fillcap_16
XFILLER_176_947 VDD VDD VSS VSS gf180mcu_as_sc_mcu7t3v3__fillcap_16
XFILLER_203_594 VDD VDD VSS VSS gf180mcu_as_sc_mcu7t3v3__fillcap_16
XFILLER_206_1469 VDD VDD VSS VSS gf180mcu_as_sc_mcu7t3v3__fillcap_16
X_4631_ VDD VDD VSS VSS _4683_/C _5119_/Q _5222_/Q _5222_/D gf180mcu_as_sc_mcu7t3v3__mux2_2
X_2892_ VDD VDD VSS VSS _3812_/A _3789_/A _3797_/A gf180mcu_as_sc_mcu7t3v3__nor2_2
XFILLER_191_906 VDD VDD VSS VSS gf180mcu_as_sc_mcu7t3v3__fillcap_4
XFILLER_8_85 VDD VDD VSS VSS gf180mcu_as_sc_mcu7t3v3__fillcap_16
XFILLER_162_118 VDD VDD VSS VSS gf180mcu_as_sc_mcu7t3v3__fillcap_16
XFILLER_190_427 VDD VDD VSS VSS gf180mcu_as_sc_mcu7t3v3__fill_2
XFILLER_191_928 VDD VDD VSS VSS gf180mcu_as_sc_mcu7t3v3__fillcap_16
XFILLER_198_1259 VDD VDD VSS VSS gf180mcu_as_sc_mcu7t3v3__fillcap_16
X_4562_ VDD VDD VSS VSS _4565_/C _4562_/B _4589_/A gf180mcu_as_sc_mcu7t3v3__nor2_2
XFILLER_50_1399 VDD VDD VSS VSS gf180mcu_as_sc_mcu7t3v3__fillcap_16
XFILLER_85_1418 VDD VDD VSS VSS gf180mcu_as_sc_mcu7t3v3__fillcap_16
X_4493_ VDD VDD VSS VSS _5178_/Q _4493_/B _4540_/C _5112_/Q _4494_/B gf180mcu_as_sc_mcu7t3v3__ao22_2
X_3513_ VDD VDD VSS VSS _3513_/A _3522_/B _3522_/C _3514_/C _3513_/D gf180mcu_as_sc_mcu7t3v3__aoi211_2
X_3444_ VDD VDD VSS VSS _3467_/B _4093_/A _3444_/A _3446_/B gf180mcu_as_sc_mcu7t3v3__mux2_2
XFILLER_174_1270 VDD VDD VSS VSS gf180mcu_as_sc_mcu7t3v3__fill_1
X_3375_ VDD VDD VSS VSS _3416_/B _3375_/B _3375_/C _3376_/C gf180mcu_as_sc_mcu7t3v3__nor3_2
X_5114_ VDD VDD VSS VSS _5280_/CLK _5114_/D _5114_/Q gf180mcu_as_sc_mcu7t3v3__dfxtp_2
XFILLER_22_1402 VDD VDD VSS VSS gf180mcu_as_sc_mcu7t3v3__fillcap_16
XFILLER_61_1473 VDD VDD VSS VSS gf180mcu_as_sc_mcu7t3v3__fill_2
X_5045_ VDD VDD VSS VSS _5085_/CLK _5045_/D _5045_/Q gf180mcu_as_sc_mcu7t3v3__dfxtp_2
XFILLER_96_1514 VDD VDD VSS VSS gf180mcu_as_sc_mcu7t3v3__fillcap_4
XFILLER_26_725 VDD VDD VSS VSS gf180mcu_as_sc_mcu7t3v3__fillcap_8
XFILLER_183_1539 VDD VDD VSS VSS gf180mcu_as_sc_mcu7t3v3__fill_1
XFILLER_198_505 VDD VDD VSS VSS gf180mcu_as_sc_mcu7t3v3__fillcap_16
XFILLER_198_527 VDD VDD VSS VSS gf180mcu_as_sc_mcu7t3v3__fillcap_16
XFILLER_13_408 VDD VDD VSS VSS gf180mcu_as_sc_mcu7t3v3__fill_1
XFILLER_40_205 VDD VDD VSS VSS gf180mcu_as_sc_mcu7t3v3__fillcap_16
XFILLER_43_27 VDD VDD VSS VSS gf180mcu_as_sc_mcu7t3v3__fillcap_16
XFILLER_146_1383 VDD VDD VSS VSS gf180mcu_as_sc_mcu7t3v3__fillcap_16
XFILLER_159_38 VDD VDD VSS VSS gf180mcu_as_sc_mcu7t3v3__fillcap_16
XFILLER_178_251 VDD VDD VSS VSS gf180mcu_as_sc_mcu7t3v3__fill_2
XFILLER_22_942 VDD VDD VSS VSS gf180mcu_as_sc_mcu7t3v3__fill_2
XFILLER_120_1501 VDD VDD VSS VSS gf180mcu_as_sc_mcu7t3v3__fill_2
XFILLER_193_232 VDD VDD VSS VSS gf180mcu_as_sc_mcu7t3v3__fill_2
XFILLER_33_1542 VDD VDD VSS VSS gf180mcu_as_sc_mcu7t3v3__fill_2
X_4829_ VDD VDD VSS VSS _5073_/CLK _4829_/D _4829_/Q gf180mcu_as_sc_mcu7t3v3__dfxtp_2
XFILLER_120_1523 VDD VDD VSS VSS gf180mcu_as_sc_mcu7t3v3__fillcap_4
XFILLER_5_607 VDD VDD VSS VSS gf180mcu_as_sc_mcu7t3v3__fillcap_8
XTAP_TAPCELL_ROW_80_1_1684 VDD VSS gf180mcu_as_sc_mcu7t3v3__tap_2
XFILLER_120_1567 VDD VDD VSS VSS gf180mcu_as_sc_mcu7t3v3__fill_2
XFILLER_179_1170 VDD VDD VSS VSS gf180mcu_as_sc_mcu7t3v3__fillcap_16
XTAP_TAPCELL_ROW_21_1197 VDD VSS gf180mcu_as_sc_mcu7t3v3__tap_2
XTAP_TAPCELL_ROW_21_1186 VDD VSS gf180mcu_as_sc_mcu7t3v3__tap_2
XFILLER_108_53 VDD VDD VSS VSS gf180mcu_as_sc_mcu7t3v3__fillcap_16
XFILLER_179_1192 VDD VDD VSS VSS gf180mcu_as_sc_mcu7t3v3__fillcap_16
XPHY_EDGE_ROW_41_1_Left_251 VDD VSS gf180mcu_as_sc_mcu7t3v3__tap_2
XTAP_TAPCELL_ROW_9_935 VDD VSS gf180mcu_as_sc_mcu7t3v3__tap_2
XTAP_TAPCELL_ROW_9_924 VDD VSS gf180mcu_as_sc_mcu7t3v3__tap_2
XFILLER_0_312 VDD VDD VSS VSS gf180mcu_as_sc_mcu7t3v3__fill_2
XFILLER_1_835 VDD VDD VSS VSS gf180mcu_as_sc_mcu7t3v3__fillcap_4
Xinput202 VDD VDD VSS VSS se_in[29] _3793_/A gf180mcu_as_sc_mcu7t3v3__buff_12
XFILLER_27_1379 VDD VDD VSS VSS gf180mcu_as_sc_mcu7t3v3__fillcap_16
Xinput213 VDD VDD VSS VSS se_in[8] _4001_/A gf180mcu_as_sc_mcu7t3v3__buff_12
Xinput224 VDD VDD VSS VSS south_in[18] _4080_/D gf180mcu_as_sc_mcu7t3v3__buff_12
Xinput235 VDD VDD VSS VSS south_in[28] _4159_/D gf180mcu_as_sc_mcu7t3v3__buff_12
XFILLER_25_1070 VDD VDD VSS VSS gf180mcu_as_sc_mcu7t3v3__fill_1
Xinput246 VDD VDD VSS VSS south_in[7] _3989_/D gf180mcu_as_sc_mcu7t3v3__buff_12
Xinput257 VDD VDD VSS VSS sw_in[17] _2439_/A gf180mcu_as_sc_mcu7t3v3__buff_12
Xinput268 VDD VDD VSS VSS sw_in[27] _4156_/A gf180mcu_as_sc_mcu7t3v3__buff_12
Xinput279 VDD VDD VSS VSS sw_in[6] _3986_/A gf180mcu_as_sc_mcu7t3v3__buff_12
XTAP_TAPCELL_ROW_166_1_1944 VDD VSS gf180mcu_as_sc_mcu7t3v3__tap_2
XPHY_EDGE_ROW_198_Left_408 VDD VSS gf180mcu_as_sc_mcu7t3v3__tap_2
XFILLER_205_804 VDD VDD VSS VSS gf180mcu_as_sc_mcu7t3v3__fillcap_16
XFILLER_29_596 VDD VDD VSS VSS gf180mcu_as_sc_mcu7t3v3__fill_1
XFILLER_40_1568 VDD VDD VSS VSS gf180mcu_as_sc_mcu7t3v3__fill_1
XFILLER_17_72 VDD VDD VSS VSS gf180mcu_as_sc_mcu7t3v3__fillcap_4
XFILLER_140_73 VDD VDD VSS VSS gf180mcu_as_sc_mcu7t3v3__fillcap_8
XFILLER_182_1049 VDD VDD VSS VSS gf180mcu_as_sc_mcu7t3v3__fillcap_16
XFILLER_25_780 VDD VDD VSS VSS gf180mcu_as_sc_mcu7t3v3__fillcap_4
XTAP_TAPCELL_ROW_174_2005 VDD VSS gf180mcu_as_sc_mcu7t3v3__tap_2
XFILLER_12_463 VDD VDD VSS VSS gf180mcu_as_sc_mcu7t3v3__fill_1
XFILLER_73_1399 VDD VDD VSS VSS gf180mcu_as_sc_mcu7t3v3__fill_2
XFILLER_9_924 VDD VDD VSS VSS gf180mcu_as_sc_mcu7t3v3__fillcap_16
XTAP_TAPCELL_ROW_61_3_2904 VDD VSS gf180mcu_as_sc_mcu7t3v3__tap_2
XFILLER_125_1478 VDD VDD VSS VSS gf180mcu_as_sc_mcu7t3v3__fillcap_8
XFILLER_185_766 VDD VDD VSS VSS gf180mcu_as_sc_mcu7t3v3__fillcap_4
XFILLER_200_575 VDD VDD VSS VSS gf180mcu_as_sc_mcu7t3v3__fillcap_16
XPHY_EDGE_ROW_98_1_Right_619 VDD VSS gf180mcu_as_sc_mcu7t3v3__tap_2
XFILLER_144_107 VDD VDD VSS VSS gf180mcu_as_sc_mcu7t3v3__fillcap_16
XFILLER_185_788 VDD VDD VSS VSS gf180mcu_as_sc_mcu7t3v3__fillcap_16
XFILLER_200_597 VDD VDD VSS VSS gf180mcu_as_sc_mcu7t3v3__fillcap_16
XTAP_TAPCELL_ROW_191_2385 VDD VSS gf180mcu_as_sc_mcu7t3v3__tap_2
XTAP_TAPCELL_ROW_191_2374 VDD VSS gf180mcu_as_sc_mcu7t3v3__tap_2
XFILLER_98_205 VDD VDD VSS VSS gf180mcu_as_sc_mcu7t3v3__fillcap_16
XFILLER_4_673 VDD VDD VSS VSS gf180mcu_as_sc_mcu7t3v3__fill_1
XPHY_EDGE_ROW_53_3_Right_90 VDD VSS gf180mcu_as_sc_mcu7t3v3__tap_2
XFILLER_3_183 VDD VDD VSS VSS gf180mcu_as_sc_mcu7t3v3__fill_2
XFILLER_132_1405 VDD VDD VSS VSS gf180mcu_as_sc_mcu7t3v3__fill_1
XFILLER_171_1454 VDD VDD VSS VSS gf180mcu_as_sc_mcu7t3v3__fillcap_4
XFILLER_45_1468 VDD VDD VSS VSS gf180mcu_as_sc_mcu7t3v3__fillcap_4
XFILLER_66_102 VDD VDD VSS VSS gf180mcu_as_sc_mcu7t3v3__fill_2
X_3160_ VDD VDD VSS VSS _4137_/A _3222_/D _3236_/C _4138_/D _3161_/C gf180mcu_as_sc_mcu7t3v3__ao22_2
X_3091_ VDD VDD VSS VSS _3143_/S _4069_/D _4072_/A _3094_/B gf180mcu_as_sc_mcu7t3v3__mux2_2
XTAP_TAPCELL_ROW_206_2705 VDD VSS gf180mcu_as_sc_mcu7t3v3__tap_2
XTAP_TAPCELL_ROW_198_2539 VDD VSS gf180mcu_as_sc_mcu7t3v3__tap_2
XTAP_TAPCELL_ROW_198_2528 VDD VSS gf180mcu_as_sc_mcu7t3v3__tap_2
XFILLER_207_196 VDD VDD VSS VSS gf180mcu_as_sc_mcu7t3v3__fillcap_8
XFILLER_22_205 VDD VDD VSS VSS gf180mcu_as_sc_mcu7t3v3__fillcap_16
XPHY_EDGE_ROW_8_Right_8 VDD VSS gf180mcu_as_sc_mcu7t3v3__tap_2
XTAP_TAPCELL_ROW_85_1_1699 VDD VSS gf180mcu_as_sc_mcu7t3v3__tap_2
XFILLER_17_1504 VDD VDD VSS VSS gf180mcu_as_sc_mcu7t3v3__fillcap_8
XFILLER_182_1561 VDD VDD VSS VSS gf180mcu_as_sc_mcu7t3v3__fillcap_8
XFILLER_195_508 VDD VDD VSS VSS gf180mcu_as_sc_mcu7t3v3__fillcap_16
X_3993_ VDD VDD VSS VSS _3993_/A _4033_/B _3993_/C _3993_/D _3994_/B gf180mcu_as_sc_mcu7t3v3__ao211_2
XFILLER_31_772 VDD VDD VSS VSS gf180mcu_as_sc_mcu7t3v3__fillcap_8
X_2944_ VDD VDD VSS VSS _3526_/B _3243_/A _3218_/B gf180mcu_as_sc_mcu7t3v3__and2_2
XFILLER_202_1119 VDD VDD VSS VSS gf180mcu_as_sc_mcu7t3v3__fillcap_16
X_2875_ VDD VDD VSS VSS _2875_/B _4703_/B _4691_/C gf180mcu_as_sc_mcu7t3v3__and2_2
XFILLER_11_1114 VDD VDD VSS VSS gf180mcu_as_sc_mcu7t3v3__fillcap_4
XFILLER_175_265 VDD VDD VSS VSS gf180mcu_as_sc_mcu7t3v3__fillcap_4
XFILLER_176_799 VDD VDD VSS VSS gf180mcu_as_sc_mcu7t3v3__fillcap_4
X_4614_ VDD VDD VSS VSS _5208_/Q _4621_/B _4620_/C _5209_/Q _5208_/D gf180mcu_as_sc_mcu7t3v3__ao22_2
XFILLER_190_235 VDD VDD VSS VSS gf180mcu_as_sc_mcu7t3v3__fillcap_8
X_4545_ VDD VDD VSS VSS _4546_/D _4545_/B _4546_/A gf180mcu_as_sc_mcu7t3v3__nor2_2
XFILLER_176_1343 VDD VDD VSS VSS gf180mcu_as_sc_mcu7t3v3__fillcap_16
XFILLER_176_1387 VDD VDD VSS VSS gf180mcu_as_sc_mcu7t3v3__fill_1
X_4476_ VDD VDD VSS VSS _4476_/D _4510_/A _4476_/B _4476_/C _4477_/B gf180mcu_as_sc_mcu7t3v3__ao31_2
X_3427_ VDD VDD VSS VSS _3479_/C _4080_/A _3428_/D gf180mcu_as_sc_mcu7t3v3__and2_2
XFILLER_63_1568 VDD VDD VSS VSS gf180mcu_as_sc_mcu7t3v3__fill_1
X_3358_ VDD VDD VSS VSS _4008_/A _3453_/B _3453_/C _4009_/A _3359_/C gf180mcu_as_sc_mcu7t3v3__ao22_2
XTAP_TAPCELL_ROW_56_1_1613 VDD VSS gf180mcu_as_sc_mcu7t3v3__tap_2
XFILLER_22_1210 VDD VDD VSS VSS gf180mcu_as_sc_mcu7t3v3__fill_1
Xhold1101 VDD VDD VSS VSS hold1150/Y _2584_/B gf180mcu_as_sc_mcu7t3v3__clkbuff_4
Xhold1112 VDD VDD VSS VSS hold1138/Y _4966_/D gf180mcu_as_sc_mcu7t3v3__clkbuff_4
Xhold1123 VDD VDD VSS VSS _4950_/Q _3907_/B gf180mcu_as_sc_mcu7t3v3__clkbuff_4
XFILLER_22_1221 VDD VDD VSS VSS gf180mcu_as_sc_mcu7t3v3__fillcap_4
Xhold1134 VDD VDD VSS VSS _5135_/Q _2580_/A gf180mcu_as_sc_mcu7t3v3__clkbuff_4
Xhold1145 VDD VDD VSS VSS _4959_/Q hold1145/Y gf180mcu_as_sc_mcu7t3v3__clkbuff_4
X_3289_ VDD VDD VSS VSS _3936_/A _3408_/B _3289_/C _4805_/D _3594_/D gf180mcu_as_sc_mcu7t3v3__aoi211_2
XFILLER_113_1393 VDD VDD VSS VSS gf180mcu_as_sc_mcu7t3v3__fillcap_16
XFILLER_187_1450 VDD VDD VSS VSS gf180mcu_as_sc_mcu7t3v3__fillcap_16
XFILLER_22_1276 VDD VDD VSS VSS gf180mcu_as_sc_mcu7t3v3__fill_1
X_5028_ VDD VDD VSS VSS clkload4/A _5028_/D _5028_/Q gf180mcu_as_sc_mcu7t3v3__dfxtp_2
XTAP_TAPCELL_ROW_66_3_2919 VDD VSS gf180mcu_as_sc_mcu7t3v3__tap_2
XFILLER_187_1483 VDD VDD VSS VSS gf180mcu_as_sc_mcu7t3v3__fillcap_8
XFILLER_199_836 VDD VDD VSS VSS gf180mcu_as_sc_mcu7t3v3__fillcap_4
XFILLER_26_533 VDD VDD VSS VSS gf180mcu_as_sc_mcu7t3v3__fill_1
XFILLER_54_37 VDD VDD VSS VSS gf180mcu_as_sc_mcu7t3v3__fillcap_16
XFILLER_0_1061 VDD VDD VSS VSS gf180mcu_as_sc_mcu7t3v3__fillcap_4
XFILLER_159_6 VDD VDD VSS VSS gf180mcu_as_sc_mcu7t3v3__fillcap_16
XFILLER_183_1325 VDD VDD VSS VSS gf180mcu_as_sc_mcu7t3v3__fillcap_4
XFILLER_198_313 VDD VDD VSS VSS gf180mcu_as_sc_mcu7t3v3__fill_2
XFILLER_199_858 VDD VDD VSS VSS gf180mcu_as_sc_mcu7t3v3__fillcap_16
XFILLER_202_807 VDD VDD VSS VSS gf180mcu_as_sc_mcu7t3v3__fillcap_16
XFILLER_26_588 VDD VDD VSS VSS gf180mcu_as_sc_mcu7t3v3__fillcap_4
XFILLER_0_1094 VDD VDD VSS VSS gf180mcu_as_sc_mcu7t3v3__fill_2
XFILLER_10_901 VDD VDD VSS VSS gf180mcu_as_sc_mcu7t3v3__fill_1
XFILLER_16_1014 VDD VDD VSS VSS gf180mcu_as_sc_mcu7t3v3__fill_1
XFILLER_179_593 VDD VDD VSS VSS gf180mcu_as_sc_mcu7t3v3__fillcap_4
XFILLER_16_1069 VDD VDD VSS VSS gf180mcu_as_sc_mcu7t3v3__fillcap_16
XTAP_TAPCELL_ROW_23_1237 VDD VSS gf180mcu_as_sc_mcu7t3v3__tap_2
XTAP_TAPCELL_ROW_23_1226 VDD VSS gf180mcu_as_sc_mcu7t3v3__tap_2
XFILLER_126_107 VDD VDD VSS VSS gf180mcu_as_sc_mcu7t3v3__fillcap_16
XFILLER_186_69 VDD VDD VSS VSS gf180mcu_as_sc_mcu7t3v3__fillcap_16
Xclkbuf_leaf_37_clk_regs VDD VDD VSS VSS clkbuf_3_3__f_clk_regs/Y _5090_/CLK gf180mcu_as_sc_mcu7t3v3__clkbuff_12
XFILLER_33_1394 VDD VDD VSS VSS gf180mcu_as_sc_mcu7t3v3__fillcap_4
XFILLER_5_426 VDD VDD VSS VSS gf180mcu_as_sc_mcu7t3v3__fill_2
XFILLER_68_1413 VDD VDD VSS VSS gf180mcu_as_sc_mcu7t3v3__fill_1
XFILLER_102_2 VDD VDD VSS VSS gf180mcu_as_sc_mcu7t3v3__fill_2
XFILLER_120_1364 VDD VDD VSS VSS gf180mcu_as_sc_mcu7t3v3__fillcap_16
XFILLER_159_1541 VDD VDD VSS VSS gf180mcu_as_sc_mcu7t3v3__fillcap_8
XFILLER_190_1329 VDD VDD VSS VSS gf180mcu_as_sc_mcu7t3v3__fillcap_16
XFILLER_1_632 VDD VDD VSS VSS gf180mcu_as_sc_mcu7t3v3__fill_2
XFILLER_0_142 VDD VDD VSS VSS gf180mcu_as_sc_mcu7t3v3__fill_2
XFILLER_135_84 VDD VDD VSS VSS gf180mcu_as_sc_mcu7t3v3__fillcap_4
XFILLER_23_1018 VDD VDD VSS VSS gf180mcu_as_sc_mcu7t3v3__fillcap_8
XFILLER_27_1165 VDD VDD VSS VSS gf180mcu_as_sc_mcu7t3v3__fill_1
XFILLER_36_308 VDD VDD VSS VSS gf180mcu_as_sc_mcu7t3v3__fillcap_8
XFILLER_95_88 VDD VDD VSS VSS gf180mcu_as_sc_mcu7t3v3__fillcap_4
XFILLER_151_72 VDD VDD VSS VSS gf180mcu_as_sc_mcu7t3v3__fillcap_16
XFILLER_166_1523 VDD VDD VSS VSS gf180mcu_as_sc_mcu7t3v3__fillcap_8
XFILLER_56_190 VDD VDD VSS VSS gf180mcu_as_sc_mcu7t3v3__fillcap_4
XTAP_TAPCELL_ROW_201_2602 VDD VSS gf180mcu_as_sc_mcu7t3v3__tap_2
XFILLER_189_324 VDD VDD VSS VSS gf180mcu_as_sc_mcu7t3v3__fill_1
XFILLER_189_335 VDD VDD VSS VSS gf180mcu_as_sc_mcu7t3v3__fillcap_8
XFILLER_189_368 VDD VDD VSS VSS gf180mcu_as_sc_mcu7t3v3__fillcap_8
XFILLER_204_155 VDD VDD VSS VSS gf180mcu_as_sc_mcu7t3v3__fillcap_16
XFILLER_204_177 VDD VDD VSS VSS gf180mcu_as_sc_mcu7t3v3__fillcap_16
XFILLER_207_1520 VDD VDD VSS VSS gf180mcu_as_sc_mcu7t3v3__fillcap_16
XTAP_TAPCELL_ROW_94_3_3004 VDD VSS gf180mcu_as_sc_mcu7t3v3__tap_2
XTAP_TAPCELL_ROW_193_2414 VDD VSS gf180mcu_as_sc_mcu7t3v3__tap_2
XFILLER_207_1542 VDD VDD VSS VSS gf180mcu_as_sc_mcu7t3v3__fillcap_16
XFILLER_34_1125 VDD VDD VSS VSS gf180mcu_as_sc_mcu7t3v3__fill_1
XFILLER_44_92 VDD VDD VSS VSS gf180mcu_as_sc_mcu7t3v3__fill_1
XTAP_TAPCELL_ROW_193_2425 VDD VSS gf180mcu_as_sc_mcu7t3v3__tap_2
XFILLER_13_772 VDD VDD VSS VSS gf180mcu_as_sc_mcu7t3v3__fillcap_16
XFILLER_199_1310 VDD VDD VSS VSS gf180mcu_as_sc_mcu7t3v3__fillcap_16
XFILLER_199_1332 VDD VDD VSS VSS gf180mcu_as_sc_mcu7t3v3__fillcap_16
XFILLER_8_242 VDD VDD VSS VSS gf180mcu_as_sc_mcu7t3v3__fill_2
X_2660_ VDD VDD VSS VSS _2852_/B _5131_/Q _5195_/Q _2661_/B gf180mcu_as_sc_mcu7t3v3__mux2_2
XFILLER_103_1562 VDD VDD VSS VSS gf180mcu_as_sc_mcu7t3v3__fillcap_4
XFILLER_51_1472 VDD VDD VSS VSS gf180mcu_as_sc_mcu7t3v3__fill_2
XTAP_TAPCELL_ROW_11_962 VDD VSS gf180mcu_as_sc_mcu7t3v3__tap_2
XTAP_TAPCELL_ROW_11_973 VDD VSS gf180mcu_as_sc_mcu7t3v3__tap_2
X_2591_ VDD VDD VSS VSS _2882_/A _4767_/Q _4764_/Q _2591_/Y gf180mcu_as_sc_mcu7t3v3__nor3_2
XFILLER_125_162 VDD VDD VSS VSS gf180mcu_as_sc_mcu7t3v3__fill_2
XFILLER_5_982 VDD VDD VSS VSS gf180mcu_as_sc_mcu7t3v3__fillcap_4
X_4330_ VDD VDD VSS VSS _5126_/Q _4331_/A _4332_/C gf180mcu_as_sc_mcu7t3v3__or2_2
XFILLER_173_1538 VDD VDD VSS VSS gf180mcu_as_sc_mcu7t3v3__fillcap_16
X_4261_ VDD VDD VSS VSS _4265_/B _4748_/A _5097_/D gf180mcu_as_sc_mcu7t3v3__and2_2
X_3212_ VDD VDD VSS VSS _3212_/D _3797_/A _3223_/B _3223_/C _3213_/C gf180mcu_as_sc_mcu7t3v3__ao31_2
X_4192_ VDD VDD VSS VSS _4252_/B _4196_/B _4193_/C _5030_/Q _5030_/D gf180mcu_as_sc_mcu7t3v3__ao22_2
X_3143_ VDD VDD VSS VSS _3143_/S _4118_/D _4121_/A _3145_/B gf180mcu_as_sc_mcu7t3v3__mux2_2
XFILLER_209_962 VDD VDD VSS VSS gf180mcu_as_sc_mcu7t3v3__fillcap_16
X_3074_ VDD VDD VSS VSS _4056_/A _3125_/B _3125_/C _4056_/D _3080_/B gf180mcu_as_sc_mcu7t3v3__ao22_2
XFILLER_110_1566 VDD VDD VSS VSS gf180mcu_as_sc_mcu7t3v3__fill_2
XFILLER_47_190 VDD VDD VSS VSS gf180mcu_as_sc_mcu7t3v3__fillcap_4
XFILLER_35_352 VDD VDD VSS VSS gf180mcu_as_sc_mcu7t3v3__fillcap_4
XFILLER_24_18 VDD VDD VSS VSS gf180mcu_as_sc_mcu7t3v3__fillcap_16
XPHY_EDGE_ROW_163_3_Right_200 VDD VSS gf180mcu_as_sc_mcu7t3v3__tap_2
XFILLER_195_327 VDD VDD VSS VSS gf180mcu_as_sc_mcu7t3v3__fillcap_8
XTAP_TAPCELL_ROW_141_3_3143 VDD VSS gf180mcu_as_sc_mcu7t3v3__tap_2
X_3976_ VDD VDD VSS VSS _3976_/A _4032_/B _4032_/C _3976_/D _3977_/D gf180mcu_as_sc_mcu7t3v3__ao22_2
XFILLER_143_1364 VDD VDD VSS VSS gf180mcu_as_sc_mcu7t3v3__fillcap_16
XFILLER_148_221 VDD VDD VSS VSS gf180mcu_as_sc_mcu7t3v3__fill_1
X_2927_ VDD VDD VSS VSS _3216_/C _2932_/C _2930_/A gf180mcu_as_sc_mcu7t3v3__nor2_2
XFILLER_104_1348 VDD VDD VSS VSS gf180mcu_as_sc_mcu7t3v3__fillcap_4
XFILLER_176_585 VDD VDD VSS VSS gf180mcu_as_sc_mcu7t3v3__fillcap_8
XFILLER_30_1523 VDD VDD VSS VSS gf180mcu_as_sc_mcu7t3v3__fillcap_16
X_2858_ VDD VDD VSS VSS _2858_/Y _2858_/B _5097_/Q gf180mcu_as_sc_mcu7t3v3__nand2_2
XTAP_TAPCELL_ROW_121_3_3085 VDD VSS gf180mcu_as_sc_mcu7t3v3__tap_2
X_2789_ VDD VDD VSS VSS _5125_/Q _2789_/B _2789_/A _2791_/A gf180mcu_as_sc_mcu7t3v3__mux2_2
XFILLER_176_1151 VDD VDD VSS VSS gf180mcu_as_sc_mcu7t3v3__fillcap_4
X_4528_ VDD VDD VSS VSS _4529_/D _4528_/B _4572_/A gf180mcu_as_sc_mcu7t3v3__nor2_2
Xfanout700 VDD VDD VSS VSS _3928_/Y _4129_/B gf180mcu_as_sc_mcu7t3v3__buff_12
X_4459_ VDD VDD VSS VSS _4460_/D _4459_/B _4512_/A gf180mcu_as_sc_mcu7t3v3__nor2_2
XFILLER_8_1524 VDD VDD VSS VSS gf180mcu_as_sc_mcu7t3v3__fillcap_4
Xfanout711 VDD VDD VSS VSS _3448_/C _3402_/C gf180mcu_as_sc_mcu7t3v3__buff_12
Xfanout722 VDD VDD VSS VSS _3542_/Y _3799_/B gf180mcu_as_sc_mcu7t3v3__buff_12
Xfanout733 VDD VDD VSS VSS _2903_/Y _3129_/B gf180mcu_as_sc_mcu7t3v3__buff_12
XFILLER_131_187 VDD VDD VSS VSS gf180mcu_as_sc_mcu7t3v3__fillcap_4
XFILLER_131_198 VDD VDD VSS VSS gf180mcu_as_sc_mcu7t3v3__fillcap_8
XFILLER_189_1501 VDD VDD VSS VSS gf180mcu_as_sc_mcu7t3v3__fillcap_8
XFILLER_8_1568 VDD VDD VSS VSS gf180mcu_as_sc_mcu7t3v3__fill_1
Xfanout744 VDD VDD VSS VSS _4733_/C _4731_/B gf180mcu_as_sc_mcu7t3v3__buff_12
Xfanout755 VDD VDD VSS VSS _2894_/Y _3059_/S gf180mcu_as_sc_mcu7t3v3__buff_12
Xfanout766 VDD VDD VSS VSS _4196_/B _4197_/B gf180mcu_as_sc_mcu7t3v3__buff_12
Xfanout777 VDD VDD VSS VSS _4683_/B _2795_/A gf180mcu_as_sc_mcu7t3v3__buff_12
Xfanout788 VDD VDD VSS VSS _4588_/A _4546_/A gf180mcu_as_sc_mcu7t3v3__buff_12
Xfanout799 VDD VDD VSS VSS _4585_/A _4542_/A gf180mcu_as_sc_mcu7t3v3__buff_12
XTAP_TAPCELL_ROW_99_3_3019 VDD VSS gf180mcu_as_sc_mcu7t3v3__tap_2
XTAP_TAPCELL_ROW_87_1_1707 VDD VSS gf180mcu_as_sc_mcu7t3v3__tap_2
XTAP_TAPCELL_ROW_16_1085 VDD VSS gf180mcu_as_sc_mcu7t3v3__tap_2
XTAP_TAPCELL_ROW_16_1074 VDD VSS gf180mcu_as_sc_mcu7t3v3__tap_2
XFILLER_115_1488 VDD VDD VSS VSS gf180mcu_as_sc_mcu7t3v3__fillcap_16
XFILLER_150_1379 VDD VDD VSS VSS gf180mcu_as_sc_mcu7t3v3__fill_2
XFILLER_65_58 VDD VDD VSS VSS gf180mcu_as_sc_mcu7t3v3__fill_2
XFILLER_22_1084 VDD VDD VSS VSS gf180mcu_as_sc_mcu7t3v3__fill_1
XFILLER_27_842 VDD VDD VSS VSS gf180mcu_as_sc_mcu7t3v3__fillcap_16
XFILLER_183_1100 VDD VDD VSS VSS gf180mcu_as_sc_mcu7t3v3__fillcap_16
XFILLER_183_1122 VDD VDD VSS VSS gf180mcu_as_sc_mcu7t3v3__fillcap_16
XFILLER_53_193 VDD VDD VSS VSS gf180mcu_as_sc_mcu7t3v3__fill_2
XFILLER_201_136 VDD VDD VSS VSS gf180mcu_as_sc_mcu7t3v3__fillcap_4
XFILLER_74_1461 VDD VDD VSS VSS gf180mcu_as_sc_mcu7t3v3__fill_2
XFILLER_81_68 VDD VDD VSS VSS gf180mcu_as_sc_mcu7t3v3__fill_2
XFILLER_179_390 VDD VDD VSS VSS gf180mcu_as_sc_mcu7t3v3__fill_2
XFILLER_201_158 VDD VDD VSS VSS gf180mcu_as_sc_mcu7t3v3__fillcap_16
XFILLER_22_580 VDD VDD VSS VSS gf180mcu_as_sc_mcu7t3v3__fillcap_8
XFILLER_182_522 VDD VDD VSS VSS gf180mcu_as_sc_mcu7t3v3__fill_2
XFILLER_194_371 VDD VDD VSS VSS gf180mcu_as_sc_mcu7t3v3__fillcap_8
XFILLER_5_212 VDD VDD VSS VSS gf180mcu_as_sc_mcu7t3v3__fillcap_8
XFILLER_182_588 VDD VDD VSS VSS gf180mcu_as_sc_mcu7t3v3__fillcap_4
XFILLER_29_1216 VDD VDD VSS VSS gf180mcu_as_sc_mcu7t3v3__fill_1
XFILLER_146_72 VDD VDD VSS VSS gf180mcu_as_sc_mcu7t3v3__fillcap_16
XFILLER_2_974 VDD VDD VSS VSS gf180mcu_as_sc_mcu7t3v3__fillcap_8
XTAP_TAPCELL_ROW_186_2262 VDD VSS gf180mcu_as_sc_mcu7t3v3__tap_2
XFILLER_81_1476 VDD VDD VSS VSS gf180mcu_as_sc_mcu7t3v3__fill_1
XTAP_TAPCELL_ROW_186_2273 VDD VSS gf180mcu_as_sc_mcu7t3v3__tap_2
XFILLER_133_1566 VDD VDD VSS VSS gf180mcu_as_sc_mcu7t3v3__fill_2
XFILLER_188_1011 VDD VDD VSS VSS gf180mcu_as_sc_mcu7t3v3__fillcap_4
XFILLER_42_1449 VDD VDD VSS VSS gf180mcu_as_sc_mcu7t3v3__fill_2
XTAP_TAPCELL_ROW_134_1_1846 VDD VSS gf180mcu_as_sc_mcu7t3v3__tap_2
XFILLER_162_93 VDD VDD VSS VSS gf180mcu_as_sc_mcu7t3v3__fill_1
XFILLER_188_1033 VDD VDD VSS VSS gf180mcu_as_sc_mcu7t3v3__fillcap_16
XFILLER_7_1089 VDD VDD VSS VSS gf180mcu_as_sc_mcu7t3v3__fill_2
XTAP_TAPCELL_ROW_146_3_3158 VDD VSS gf180mcu_as_sc_mcu7t3v3__tap_2
XFILLER_18_842 VDD VDD VSS VSS gf180mcu_as_sc_mcu7t3v3__fillcap_4
XFILLER_36_138 VDD VDD VSS VSS gf180mcu_as_sc_mcu7t3v3__fillcap_4
XFILLER_17_352 VDD VDD VSS VSS gf180mcu_as_sc_mcu7t3v3__fillcap_16
XFILLER_166_1364 VDD VDD VSS VSS gf180mcu_as_sc_mcu7t3v3__fill_1
XFILLER_189_154 VDD VDD VSS VSS gf180mcu_as_sc_mcu7t3v3__fill_2
XFILLER_127_1348 VDD VDD VSS VSS gf180mcu_as_sc_mcu7t3v3__fillcap_16
XFILLER_205_486 VDD VDD VSS VSS gf180mcu_as_sc_mcu7t3v3__fillcap_4
XFILLER_32_333 VDD VDD VSS VSS gf180mcu_as_sc_mcu7t3v3__fillcap_16
XTAP_TAPCELL_ROW_114_1_1788 VDD VSS gf180mcu_as_sc_mcu7t3v3__tap_2
X_3830_ VDD VDD VSS VSS _3835_/B _4909_/Q _4752_/C gf180mcu_as_sc_mcu7t3v3__and2_2
XFILLER_14_1507 VDD VDD VSS VSS gf180mcu_as_sc_mcu7t3v3__fillcap_16
XFILLER_32_399 VDD VDD VSS VSS gf180mcu_as_sc_mcu7t3v3__fill_2
X_3761_ VDD VDD VSS VSS _3761_/B _4146_/D _3765_/C gf180mcu_as_sc_mcu7t3v3__and2_2
XFILLER_185_360 VDD VDD VSS VSS gf180mcu_as_sc_mcu7t3v3__fillcap_4
XFILLER_9_562 VDD VDD VSS VSS gf180mcu_as_sc_mcu7t3v3__fillcap_16
XPHY_EDGE_ROW_207_Right_70 VDD VSS gf180mcu_as_sc_mcu7t3v3__tap_2
X_2712_ VDD VDD VSS VSS _5161_/Q _4267_/S _4279_/S _5185_/Q _2713_/B gf180mcu_as_sc_mcu7t3v3__ao22_2
XFILLER_12_1220 VDD VDD VSS VSS gf180mcu_as_sc_mcu7t3v3__fillcap_4
XFILLER_12_1231 VDD VDD VSS VSS gf180mcu_as_sc_mcu7t3v3__fill_1
XFILLER_185_382 VDD VDD VSS VSS gf180mcu_as_sc_mcu7t3v3__fillcap_4
X_3692_ VDD VDD VSS VSS _4855_/D _3692_/C _3758_/D _4067_/A gf180mcu_as_sc_mcu7t3v3__aoi21_2
XFILLER_65_2 VDD VDD VSS VSS gf180mcu_as_sc_mcu7t3v3__fillcap_16
X_2643_ VDD VDD VSS VSS _4264_/B _2658_/S _2831_/A _2643_/C _2644_/C gf180mcu_as_sc_mcu7t3v3__ao31_2
XFILLER_12_1275 VDD VDD VSS VSS gf180mcu_as_sc_mcu7t3v3__fillcap_16
XFILLER_12_1297 VDD VDD VSS VSS gf180mcu_as_sc_mcu7t3v3__fillcap_16
Xoutput325 VDD VDD VSS VSS _4839_/Q east_out[0] gf180mcu_as_sc_mcu7t3v3__buff_12
X_2574_ VDD VDD VSS VSS _2575_/B _4350_/A _2849_/A gf180mcu_as_sc_mcu7t3v3__nand2_2
Xoutput369 VDD VDD VSS VSS _4790_/Q se_out[19] gf180mcu_as_sc_mcu7t3v3__buff_12
Xoutput358 VDD VDD VSS VSS _4848_/Q east_out[9] gf180mcu_as_sc_mcu7t3v3__buff_12
Xoutput347 VDD VDD VSS VSS _4841_/Q east_out[2] gf180mcu_as_sc_mcu7t3v3__buff_12
Xoutput336 VDD VDD VSS VSS _4840_/Q east_out[1] gf180mcu_as_sc_mcu7t3v3__buff_12
X_4313_ VDD VDD VSS VSS _4314_/S _5143_/Q _5142_/Q _5142_/D gf180mcu_as_sc_mcu7t3v3__mux2_2
XTAP_TAPCELL_ROW_91_3_2995 VDD VSS gf180mcu_as_sc_mcu7t3v3__tap_2
XFILLER_138_1499 VDD VDD VSS VSS gf180mcu_as_sc_mcu7t3v3__fill_1
XFILLER_206_53 VDD VDD VSS VSS gf180mcu_as_sc_mcu7t3v3__fillcap_16
X_4244_ VDD VDD VSS VSS _4257_/S _4244_/B _5080_/Q _5080_/D gf180mcu_as_sc_mcu7t3v3__mux2_2
X_4175_ VDD VDD VSS VSS _4235_/B _4197_/B _4197_/C _5013_/Q _5013_/D gf180mcu_as_sc_mcu7t3v3__ao22_2
X_3126_ VDD VDD VSS VSS _3126_/S _4101_/A _4103_/A _3128_/B gf180mcu_as_sc_mcu7t3v3__mux2_2
XFILLER_110_1352 VDD VDD VSS VSS gf180mcu_as_sc_mcu7t3v3__fill_2
XFILLER_184_1420 VDD VDD VSS VSS gf180mcu_as_sc_mcu7t3v3__fillcap_4
XFILLER_3_1476 VDD VDD VSS VSS gf180mcu_as_sc_mcu7t3v3__fill_2
X_3057_ VDD VDD VSS VSS _3661_/A _3057_/B _3057_/C _3057_/Y _3608_/D gf180mcu_as_sc_mcu7t3v3__aoi211_2
XFILLER_24_823 VDD VDD VSS VSS gf180mcu_as_sc_mcu7t3v3__fill_2
XPHY_EDGE_ROW_50_1_Left_260 VDD VSS gf180mcu_as_sc_mcu7t3v3__tap_2
XFILLER_184_1497 VDD VDD VSS VSS gf180mcu_as_sc_mcu7t3v3__fill_1
XFILLER_23_333 VDD VDD VSS VSS gf180mcu_as_sc_mcu7t3v3__fillcap_4
XTAP_TAPCELL_ROW_160_1_1925 VDD VSS gf180mcu_as_sc_mcu7t3v3__tap_2
XFILLER_50_152 VDD VDD VSS VSS gf180mcu_as_sc_mcu7t3v3__fillcap_16
XFILLER_50_174 VDD VDD VSS VSS gf180mcu_as_sc_mcu7t3v3__fill_1
XFILLER_51_27 VDD VDD VSS VSS gf180mcu_as_sc_mcu7t3v3__fillcap_16
XPHY_EDGE_ROW_164_3_Right_201 VDD VSS gf180mcu_as_sc_mcu7t3v3__tap_2
XTAP_TAPCELL_ROW_172_3_3237 VDD VSS gf180mcu_as_sc_mcu7t3v3__tap_2
X_3959_ VDD VDD VSS VSS _3959_/A _4023_/B _4023_/C _4918_/Q _3960_/D gf180mcu_as_sc_mcu7t3v3__ao22_2
XFILLER_167_38 VDD VDD VSS VSS gf180mcu_as_sc_mcu7t3v3__fillcap_16
XFILLER_191_330 VDD VDD VSS VSS gf180mcu_as_sc_mcu7t3v3__fillcap_16
XFILLER_191_352 VDD VDD VSS VSS gf180mcu_as_sc_mcu7t3v3__fillcap_16
XFILLER_69_1530 VDD VDD VSS VSS gf180mcu_as_sc_mcu7t3v3__fill_1
XFILLER_191_1402 VDD VDD VSS VSS gf180mcu_as_sc_mcu7t3v3__fillcap_4
XFILLER_2_259 VDD VDD VSS VSS gf180mcu_as_sc_mcu7t3v3__fill_2
XTAP_TAPCELL_ROW_18_1136 VDD VSS gf180mcu_as_sc_mcu7t3v3__tap_2
XTAP_TAPCELL_ROW_18_1125 VDD VSS gf180mcu_as_sc_mcu7t3v3__tap_2
XFILLER_116_53 VDD VDD VSS VSS gf180mcu_as_sc_mcu7t3v3__fillcap_16
Xfanout530 VDD VDD VSS VSS _3559_/Y _3803_/B gf180mcu_as_sc_mcu7t3v3__buff_12
Xfanout541 VDD VDD VSS VSS _3476_/D _3367_/A gf180mcu_as_sc_mcu7t3v3__buff_12
XFILLER_24_1135 VDD VDD VSS VSS gf180mcu_as_sc_mcu7t3v3__fillcap_16
Xfanout552 VDD VDD VSS VSS _4574_/B _4504_/B gf180mcu_as_sc_mcu7t3v3__buff_12
Xfanout563 VDD VDD VSS VSS _3921_/Y _4115_/B gf180mcu_as_sc_mcu7t3v3__buff_12
Xfanout574 VDD VDD VSS VSS _3561_/Y _3792_/B gf180mcu_as_sc_mcu7t3v3__buff_12
XTAP_TAPCELL_ROW_35_1494 VDD VSS gf180mcu_as_sc_mcu7t3v3__tap_2
XFILLER_207_718 VDD VDD VSS VSS gf180mcu_as_sc_mcu7t3v3__fillcap_16
XFILLER_24_1157 VDD VDD VSS VSS gf180mcu_as_sc_mcu7t3v3__fillcap_16
Xfanout585 VDD VDD VSS VSS _3057_/B _3005_/A gf180mcu_as_sc_mcu7t3v3__buff_12
Xfanout596 VDD VDD VSS VSS _4168_/Y _4196_/C gf180mcu_as_sc_mcu7t3v3__buff_12
XFILLER_189_1364 VDD VDD VSS VSS gf180mcu_as_sc_mcu7t3v3__fillcap_16
XFILLER_33_108 VDD VDD VSS VSS gf180mcu_as_sc_mcu7t3v3__fill_1
XFILLER_76_1523 VDD VDD VSS VSS gf180mcu_as_sc_mcu7t3v3__fillcap_16
XTAP_TAPCELL_ROW_2_782 VDD VSS gf180mcu_as_sc_mcu7t3v3__tap_2
XTAP_TAPCELL_ROW_2_771 VDD VSS gf180mcu_as_sc_mcu7t3v3__tap_2
XFILLER_199_430 VDD VDD VSS VSS gf180mcu_as_sc_mcu7t3v3__fill_2
XFILLER_33_119 VDD VDD VSS VSS gf180mcu_as_sc_mcu7t3v3__fillcap_16
XPHY_EDGE_ROW_150_1_Right_671 VDD VSS gf180mcu_as_sc_mcu7t3v3__tap_2
XFILLER_14_333 VDD VDD VSS VSS gf180mcu_as_sc_mcu7t3v3__fillcap_16
XFILLER_25_72 VDD VDD VSS VSS gf180mcu_as_sc_mcu7t3v3__fillcap_16
XFILLER_30_804 VDD VDD VSS VSS gf180mcu_as_sc_mcu7t3v3__fill_1
XFILLER_14_399 VDD VDD VSS VSS gf180mcu_as_sc_mcu7t3v3__fillcap_4
XFILLER_186_135 VDD VDD VSS VSS gf180mcu_as_sc_mcu7t3v3__fill_1
XFILLER_204_1501 VDD VDD VSS VSS gf180mcu_as_sc_mcu7t3v3__fillcap_4
XFILLER_30_826 VDD VDD VSS VSS gf180mcu_as_sc_mcu7t3v3__fill_2
XFILLER_41_174 VDD VDD VSS VSS gf180mcu_as_sc_mcu7t3v3__fill_1
XFILLER_174_308 VDD VDD VSS VSS gf180mcu_as_sc_mcu7t3v3__fillcap_16
XFILLER_202_489 VDD VDD VSS VSS gf180mcu_as_sc_mcu7t3v3__fillcap_16
XFILLER_204_1523 VDD VDD VSS VSS gf180mcu_as_sc_mcu7t3v3__fillcap_16
XFILLER_10_550 VDD VDD VSS VSS gf180mcu_as_sc_mcu7t3v3__fillcap_8
XFILLER_183_842 VDD VDD VSS VSS gf180mcu_as_sc_mcu7t3v3__fillcap_16
XFILLER_195_680 VDD VDD VSS VSS gf180mcu_as_sc_mcu7t3v3__fillcap_16
XFILLER_196_1313 VDD VDD VSS VSS gf180mcu_as_sc_mcu7t3v3__fillcap_16
XFILLER_10_594 VDD VDD VSS VSS gf180mcu_as_sc_mcu7t3v3__fill_1
XFILLER_202_1291 VDD VDD VSS VSS gf180mcu_as_sc_mcu7t3v3__fillcap_4
XFILLER_6_565 VDD VDD VSS VSS gf180mcu_as_sc_mcu7t3v3__fillcap_4
XTAP_TAPCELL_ROW_188_2313 VDD VSS gf180mcu_as_sc_mcu7t3v3__tap_2
XTAP_TAPCELL_ROW_188_2302 VDD VSS gf180mcu_as_sc_mcu7t3v3__tap_2
XFILLER_29_1002 VDD VDD VSS VSS gf180mcu_as_sc_mcu7t3v3__fillcap_16
XFILLER_194_1081 VDD VDD VSS VSS gf180mcu_as_sc_mcu7t3v3__fillcap_4
XFILLER_29_1068 VDD VDD VSS VSS gf180mcu_as_sc_mcu7t3v3__fillcap_8
XFILLER_110_135 VDD VDD VSS VSS gf180mcu_as_sc_mcu7t3v3__fill_2
XFILLER_1_292 VDD VDD VSS VSS gf180mcu_as_sc_mcu7t3v3__fill_1
XFILLER_133_1396 VDD VDD VSS VSS gf180mcu_as_sc_mcu7t3v3__fillcap_16
XFILLER_168_1415 VDD VDD VSS VSS gf180mcu_as_sc_mcu7t3v3__fillcap_16
XTAP_TAPCELL_ROW_0_708 VDD VSS gf180mcu_as_sc_mcu7t3v3__tap_2
XTAP_TAPCELL_ROW_0_719 VDD VSS gf180mcu_as_sc_mcu7t3v3__tap_2
XFILLER_209_1434 VDD VDD VSS VSS gf180mcu_as_sc_mcu7t3v3__fillcap_16
X_4931_ VDD VDD VSS VSS _5277_/CLK _4931_/D _4931_/Q gf180mcu_as_sc_mcu7t3v3__dfxtp_2
XFILLER_21_804 VDD VDD VSS VSS gf180mcu_as_sc_mcu7t3v3__fillcap_8
X_4862_ VDD VDD VSS VSS _5192_/CLK _4862_/D _4862_/Q gf180mcu_as_sc_mcu7t3v3__dfxtp_2
XFILLER_20_314 VDD VDD VSS VSS gf180mcu_as_sc_mcu7t3v3__fill_1
XFILLER_32_174 VDD VDD VSS VSS gf180mcu_as_sc_mcu7t3v3__fill_1
XFILLER_33_697 VDD VDD VSS VSS gf180mcu_as_sc_mcu7t3v3__fill_2
XPHY_EDGE_ROW_154_3_Left_539 VDD VSS gf180mcu_as_sc_mcu7t3v3__tap_2
X_3813_ VDD VDD VSS VSS _3917_/A _3931_/A _3924_/A gf180mcu_as_sc_mcu7t3v3__nor2b_2
XANTENNA_15 VDD VDD VSS VSS _4918_/D gf180mcu_as_sc_mcu7t3v3__diode_2
XANTENNA_26 VDD VDD VSS VSS _2583_/C gf180mcu_as_sc_mcu7t3v3__diode_2
XFILLER_177_168 VDD VDD VSS VSS gf180mcu_as_sc_mcu7t3v3__fill_1
X_4793_ VDD VDD VSS VSS _5214_/CLK _4793_/D _4793_/Q gf180mcu_as_sc_mcu7t3v3__dfxtp_2
XFILLER_179_1511 VDD VDD VSS VSS gf180mcu_as_sc_mcu7t3v3__fillcap_4
X_3744_ VDD VDD VSS VSS _4119_/A _3758_/B _3744_/C _3758_/D _3745_/C gf180mcu_as_sc_mcu7t3v3__ao211_2
X_3675_ VDD VDD VSS VSS _4049_/A _3675_/B _3676_/B _3676_/C _3675_/D gf180mcu_as_sc_mcu7t3v3__aoi211_2
X_2626_ VDD VDD VSS VSS _2626_/B _4264_/B _2627_/D gf180mcu_as_sc_mcu7t3v3__and2_2
X_2557_ VDD VDD VSS VSS _2558_/C _2557_/A _4294_/B gf180mcu_as_sc_mcu7t3v3__and2_2
X_5276_ VDD VDD VSS VSS _5276_/CLK _5276_/D _5276_/Q gf180mcu_as_sc_mcu7t3v3__dfxtp_2
X_2488_ VDD VDD VSS VSS _4329_/A _2534_/B _2534_/A gf180mcu_as_sc_mcu7t3v3__nand2_2
XFILLER_101_135 VDD VDD VSS VSS gf180mcu_as_sc_mcu7t3v3__fillcap_4
XTAP_TAPCELL_ROW_13_1011 VDD VSS gf180mcu_as_sc_mcu7t3v3__tap_2
X_4227_ VDD VDD VSS VSS _4256_/B _4227_/B _4227_/C _5063_/Q _5063_/D gf180mcu_as_sc_mcu7t3v3__ao22_2
XFILLER_112_1425 VDD VDD VSS VSS gf180mcu_as_sc_mcu7t3v3__fillcap_4
XFILLER_21_1319 VDD VDD VSS VSS gf180mcu_as_sc_mcu7t3v3__fillcap_8
XFILLER_28_403 VDD VDD VSS VSS gf180mcu_as_sc_mcu7t3v3__fillcap_16
XFILLER_5_1538 VDD VDD VSS VSS gf180mcu_as_sc_mcu7t3v3__fill_2
XTAP_TAPCELL_ROW_13_1022 VDD VSS gf180mcu_as_sc_mcu7t3v3__tap_2
XFILLER_25_1488 VDD VDD VSS VSS gf180mcu_as_sc_mcu7t3v3__fillcap_16
XFILLER_46_27 VDD VDD VSS VSS gf180mcu_as_sc_mcu7t3v3__fillcap_8
X_4158_ VDD VDD VSS VSS _5005_/Q _4158_/B _4256_/B _4158_/D _5005_/D gf180mcu_as_sc_mcu7t3v3__ao22_2
X_4089_ VDD VDD VSS VSS _4089_/A _4122_/B _4089_/C _4089_/D _4090_/B gf180mcu_as_sc_mcu7t3v3__ao211_2
X_3109_ VDD VDD VSS VSS _3143_/S _4085_/D _4088_/A _3112_/B gf180mcu_as_sc_mcu7t3v3__mux2_2
XTAP_TAPCELL_ROW_30_1391 VDD VSS gf180mcu_as_sc_mcu7t3v3__tap_2
XTAP_TAPCELL_ROW_30_1380 VDD VSS gf180mcu_as_sc_mcu7t3v3__tap_2
XFILLER_12_804 VDD VDD VSS VSS gf180mcu_as_sc_mcu7t3v3__fill_1
XFILLER_180_1103 VDD VDD VSS VSS gf180mcu_as_sc_mcu7t3v3__fillcap_16
XFILLER_184_1261 VDD VDD VSS VSS gf180mcu_as_sc_mcu7t3v3__fillcap_16
XFILLER_197_912 VDD VDD VSS VSS gf180mcu_as_sc_mcu7t3v3__fillcap_16
XFILLER_62_37 VDD VDD VSS VSS gf180mcu_as_sc_mcu7t3v3__fillcap_16
XFILLER_11_314 VDD VDD VSS VSS gf180mcu_as_sc_mcu7t3v3__fill_2
XFILLER_178_37 VDD VDD VSS VSS gf180mcu_as_sc_mcu7t3v3__fillcap_16
XFILLER_23_185 VDD VDD VSS VSS gf180mcu_as_sc_mcu7t3v3__fillcap_16
XPHY_EDGE_ROW_165_3_Right_202 VDD VSS gf180mcu_as_sc_mcu7t3v3__tap_2
XFILLER_32_1415 VDD VDD VSS VSS gf180mcu_as_sc_mcu7t3v3__fillcap_4
XFILLER_32_1437 VDD VDD VSS VSS gf180mcu_as_sc_mcu7t3v3__fillcap_16
XFILLER_183_149 VDD VDD VSS VSS gf180mcu_as_sc_mcu7t3v3__fillcap_4
XFILLER_178_1065 VDD VDD VSS VSS gf180mcu_as_sc_mcu7t3v3__fillcap_16
XFILLER_192_661 VDD VDD VSS VSS gf180mcu_as_sc_mcu7t3v3__fillcap_4
XFILLER_192_683 VDD VDD VSS VSS gf180mcu_as_sc_mcu7t3v3__fillcap_16
XFILLER_127_52 VDD VDD VSS VSS gf180mcu_as_sc_mcu7t3v3__fillcap_16
XFILLER_178_1087 VDD VDD VSS VSS gf180mcu_as_sc_mcu7t3v3__fillcap_16
XFILLER_194_69 VDD VDD VSS VSS gf180mcu_as_sc_mcu7t3v3__fillcap_16
XFILLER_26_1208 VDD VDD VSS VSS gf180mcu_as_sc_mcu7t3v3__fillcap_16
XFILLER_43_1500 VDD VDD VSS VSS gf180mcu_as_sc_mcu7t3v3__fill_2
XTAP_TAPCELL_ROW_7_885 VDD VSS gf180mcu_as_sc_mcu7t3v3__tap_2
XTAP_TAPCELL_ROW_7_874 VDD VSS gf180mcu_as_sc_mcu7t3v3__tap_2
XFILLER_43_1566 VDD VDD VSS VSS gf180mcu_as_sc_mcu7t3v3__fill_2
XFILLER_8_1173 VDD VDD VSS VSS gf180mcu_as_sc_mcu7t3v3__fillcap_16
XTAP_TAPCELL_ROW_55_1_1609 VDD VSS gf180mcu_as_sc_mcu7t3v3__tap_2
XFILLER_185_1014 VDD VDD VSS VSS gf180mcu_as_sc_mcu7t3v3__fillcap_16
XFILLER_34_428 VDD VDD VSS VSS gf180mcu_as_sc_mcu7t3v3__fill_1
XFILLER_128_1443 VDD VDD VSS VSS gf180mcu_as_sc_mcu7t3v3__fillcap_8
XFILLER_199_260 VDD VDD VSS VSS gf180mcu_as_sc_mcu7t3v3__fillcap_16
XFILLER_163_1356 VDD VDD VSS VSS gf180mcu_as_sc_mcu7t3v3__fillcap_4
XFILLER_187_422 VDD VDD VSS VSS gf180mcu_as_sc_mcu7t3v3__fillcap_8
XFILLER_199_282 VDD VDD VSS VSS gf180mcu_as_sc_mcu7t3v3__fill_1
XFILLER_37_1348 VDD VDD VSS VSS gf180mcu_as_sc_mcu7t3v3__fillcap_16
XPHY_EDGE_ROW_151_1_Right_672 VDD VSS gf180mcu_as_sc_mcu7t3v3__tap_2
XTAP_TAPCELL_ROW_177_2069 VDD VSS gf180mcu_as_sc_mcu7t3v3__tap_2
XTAP_TAPCELL_ROW_177_2058 VDD VSS gf180mcu_as_sc_mcu7t3v3__tap_2
XFILLER_14_174 VDD VDD VSS VSS gf180mcu_as_sc_mcu7t3v3__fill_1
XFILLER_174_116 VDD VDD VSS VSS gf180mcu_as_sc_mcu7t3v3__fill_2
XFILLER_175_628 VDD VDD VSS VSS gf180mcu_as_sc_mcu7t3v3__fill_2
XFILLER_30_667 VDD VDD VSS VSS gf180mcu_as_sc_mcu7t3v3__fillcap_8
Xinput13 VDD VDD VSS VSS boot_data[1] _2692_/A gf180mcu_as_sc_mcu7t3v3__buff_12
XFILLER_10_380 VDD VDD VSS VSS gf180mcu_as_sc_mcu7t3v3__fillcap_4
XFILLER_183_650 VDD VDD VSS VSS gf180mcu_as_sc_mcu7t3v3__fill_1
XFILLER_7_830 VDD VDD VSS VSS gf180mcu_as_sc_mcu7t3v3__fillcap_8
Xinput24 VDD VDD VSS VSS dft_addr[1] _2610_/B gf180mcu_as_sc_mcu7t3v3__buff_12
Xinput35 VDD VDD VSS VSS dft_wdata[0] _2686_/B gf180mcu_as_sc_mcu7t3v3__buff_12
Xinput46 VDD VDD VSS VSS east_in[11] _4024_/A gf180mcu_as_sc_mcu7t3v3__buff_12
XFILLER_7_874 VDD VDD VSS VSS gf180mcu_as_sc_mcu7t3v3__fillcap_16
XTAP_TAPCELL_ROW_109_1_1772 VDD VSS gf180mcu_as_sc_mcu7t3v3__tap_2
Xinput57 VDD VDD VSS VSS east_in[21] wire849/A gf180mcu_as_sc_mcu7t3v3__buff_12
Xinput68 VDD VDD VSS VSS east_in[31] wire839/A gf180mcu_as_sc_mcu7t3v3__buff_12
Xinput79 VDD VDD VSS VSS ne_in[10] _4016_/D gf180mcu_as_sc_mcu7t3v3__buff_12
XFILLER_182_171 VDD VDD VSS VSS gf180mcu_as_sc_mcu7t3v3__fillcap_4
XFILLER_182_193 VDD VDD VSS VSS gf180mcu_as_sc_mcu7t3v3__fillcap_16
XFILLER_183_694 VDD VDD VSS VSS gf180mcu_as_sc_mcu7t3v3__fillcap_4
XFILLER_87_1471 VDD VDD VSS VSS gf180mcu_as_sc_mcu7t3v3__fillcap_4
X_3460_ VDD VDD VSS VSS _3467_/B _4109_/A _3460_/A _3462_/B gf180mcu_as_sc_mcu7t3v3__mux2_2
XFILLER_100_1373 VDD VDD VSS VSS gf180mcu_as_sc_mcu7t3v3__fillcap_8
XFILLER_174_1430 VDD VDD VSS VSS gf180mcu_as_sc_mcu7t3v3__fillcap_16
XFILLER_48_1433 VDD VDD VSS VSS gf180mcu_as_sc_mcu7t3v3__fillcap_4
X_3391_ VDD VDD VSS VSS _3455_/B _3391_/B _3391_/C _3392_/C gf180mcu_as_sc_mcu7t3v3__nor3_2
X_2411_ VDD VDD VSS VSS _2538_/A _5162_/Q gf180mcu_as_sc_mcu7t3v3__inv_2
XFILLER_130_219 VDD VDD VSS VSS gf180mcu_as_sc_mcu7t3v3__fill_2
X_5130_ VDD VDD VSS VSS _5198_/CLK _5130_/D _5130_/Q gf180mcu_as_sc_mcu7t3v3__dfxtp_2
XFILLER_28_2 VDD VDD VSS VSS gf180mcu_as_sc_mcu7t3v3__fillcap_16
X_5061_ VDD VDD VSS VSS _5090_/CLK _5061_/D _5061_/Q gf180mcu_as_sc_mcu7t3v3__dfxtp_2
XFILLER_96_177 VDD VDD VSS VSS gf180mcu_as_sc_mcu7t3v3__fillcap_16
X_4012_ VDD VDD VSS VSS _4987_/Q _4158_/B _4238_/B _4117_/D _4987_/D gf180mcu_as_sc_mcu7t3v3__ao22_2
XTAP_TAPCELL_ROW_209_2769 VDD VSS gf180mcu_as_sc_mcu7t3v3__tap_2
XFILLER_19_992 VDD VDD VSS VSS gf180mcu_as_sc_mcu7t3v3__fillcap_4
XFILLER_94_1431 VDD VDD VSS VSS gf180mcu_as_sc_mcu7t3v3__fillcap_4
XFILLER_179_912 VDD VDD VSS VSS gf180mcu_as_sc_mcu7t3v3__fillcap_16
XFILLER_94_1453 VDD VDD VSS VSS gf180mcu_as_sc_mcu7t3v3__fillcap_16
X_4914_ VDD VDD VSS VSS _4946_/CLK _4914_/D _4914_/Q gf180mcu_as_sc_mcu7t3v3__dfxtp_2
XFILLER_181_1434 VDD VDD VSS VSS gf180mcu_as_sc_mcu7t3v3__fill_2
XFILLER_55_1448 VDD VDD VSS VSS gf180mcu_as_sc_mcu7t3v3__fillcap_8
X_4845_ VDD VDD VSS VSS _5241_/CLK _4845_/D _4845_/Q gf180mcu_as_sc_mcu7t3v3__dfxtp_2
XFILLER_148_18 VDD VDD VSS VSS gf180mcu_as_sc_mcu7t3v3__fillcap_16
XFILLER_20_133 VDD VDD VSS VSS gf180mcu_as_sc_mcu7t3v3__fill_1
XFILLER_20_144 VDD VDD VSS VSS gf180mcu_as_sc_mcu7t3v3__fillcap_16
X_4776_ VDD VDD VSS VSS _5142_/CLK _4776_/D _4776_/Q gf180mcu_as_sc_mcu7t3v3__dfxtp_2
XFILLER_20_177 VDD VDD VSS VSS gf180mcu_as_sc_mcu7t3v3__fillcap_4
X_3727_ VDD VDD VSS VSS _4936_/Q _3727_/B _3727_/C _4101_/D _3728_/D gf180mcu_as_sc_mcu7t3v3__ao22_2
XFILLER_179_1352 VDD VDD VSS VSS gf180mcu_as_sc_mcu7t3v3__fill_2
XFILLER_173_171 VDD VDD VSS VSS gf180mcu_as_sc_mcu7t3v3__fill_2
X_3658_ VDD VDD VSS VSS _3659_/C _4032_/D _3658_/B _3658_/C gf180mcu_as_sc_mcu7t3v3__ao21_2
XTAP_TAPCELL_ROW_167_3_3221 VDD VSS gf180mcu_as_sc_mcu7t3v3__tap_2
X_3589_ VDD VDD VSS VSS _4918_/Q _3648_/B _3648_/C _3959_/A _3590_/D gf180mcu_as_sc_mcu7t3v3__ao22_2
X_2609_ VDD VDD VSS VSS _2701_/A _2609_/B input3/Y _2610_/A gf180mcu_as_sc_mcu7t3v3__mux2_2
XFILLER_0_505 VDD VDD VSS VSS gf180mcu_as_sc_mcu7t3v3__fillcap_4
XFILLER_0_516 VDD VDD VSS VSS gf180mcu_as_sc_mcu7t3v3__fill_2
XFILLER_62_1419 VDD VDD VSS VSS gf180mcu_as_sc_mcu7t3v3__fillcap_4
XFILLER_153_1558 VDD VDD VSS VSS gf180mcu_as_sc_mcu7t3v3__fillcap_8
XFILLER_27_1539 VDD VDD VSS VSS gf180mcu_as_sc_mcu7t3v3__fill_1
XTAP_TAPCELL_ROW_135_1_1851 VDD VSS gf180mcu_as_sc_mcu7t3v3__tap_2
X_5259_ VDD VDD VSS VSS _5262_/CLK _5259_/D _5259_/Q gf180mcu_as_sc_mcu7t3v3__dfxtp_2
XTAP_TAPCELL_ROW_4_822 VDD VSS gf180mcu_as_sc_mcu7t3v3__tap_2
XTAP_TAPCELL_ROW_4_811 VDD VSS gf180mcu_as_sc_mcu7t3v3__tap_2
XTAP_TAPCELL_ROW_32_1442 VDD VSS gf180mcu_as_sc_mcu7t3v3__tap_2
XTAP_TAPCELL_ROW_32_1431 VDD VSS gf180mcu_as_sc_mcu7t3v3__tap_2
XFILLER_189_6 VDD VDD VSS VSS gf180mcu_as_sc_mcu7t3v3__fillcap_16
XTAP_TAPCELL_ROW_147_3_3163 VDD VSS gf180mcu_as_sc_mcu7t3v3__tap_2
XFILLER_21_1138 VDD VDD VSS VSS gf180mcu_as_sc_mcu7t3v3__fillcap_16
XFILLER_5_1368 VDD VDD VSS VSS gf180mcu_as_sc_mcu7t3v3__fill_1
XFILLER_113_65 VDD VDD VSS VSS gf180mcu_as_sc_mcu7t3v3__fillcap_4
XFILLER_186_1345 VDD VDD VSS VSS gf180mcu_as_sc_mcu7t3v3__fillcap_16
XFILLER_186_1367 VDD VDD VSS VSS gf180mcu_as_sc_mcu7t3v3__fillcap_4
XFILLER_73_1504 VDD VDD VSS VSS gf180mcu_as_sc_mcu7t3v3__fill_2
XFILLER_12_612 VDD VDD VSS VSS gf180mcu_as_sc_mcu7t3v3__fillcap_4
XFILLER_12_645 VDD VDD VSS VSS gf180mcu_as_sc_mcu7t3v3__fillcap_16
XFILLER_196_241 VDD VDD VSS VSS gf180mcu_as_sc_mcu7t3v3__fillcap_4
XFILLER_197_764 VDD VDD VSS VSS gf180mcu_as_sc_mcu7t3v3__fillcap_4
XFILLER_12_667 VDD VDD VSS VSS gf180mcu_as_sc_mcu7t3v3__fillcap_16
XFILLER_12_689 VDD VDD VSS VSS gf180mcu_as_sc_mcu7t3v3__fill_1
XFILLER_184_425 VDD VDD VSS VSS gf180mcu_as_sc_mcu7t3v3__fillcap_8
XFILLER_196_263 VDD VDD VSS VSS gf180mcu_as_sc_mcu7t3v3__fillcap_16
XFILLER_201_1504 VDD VDD VSS VSS gf180mcu_as_sc_mcu7t3v3__fillcap_16
XFILLER_36_1370 VDD VDD VSS VSS gf180mcu_as_sc_mcu7t3v3__fillcap_4
XFILLER_7_104 VDD VDD VSS VSS gf180mcu_as_sc_mcu7t3v3__fillcap_16
XFILLER_32_1245 VDD VDD VSS VSS gf180mcu_as_sc_mcu7t3v3__fillcap_4
XPHY_EDGE_ROW_166_3_Right_203 VDD VSS gf180mcu_as_sc_mcu7t3v3__tap_2
XFILLER_4_877 VDD VDD VSS VSS gf180mcu_as_sc_mcu7t3v3__fillcap_16
XFILLER_191_1084 VDD VDD VSS VSS gf180mcu_as_sc_mcu7t3v3__fillcap_16
XFILLER_26_1038 VDD VDD VSS VSS gf180mcu_as_sc_mcu7t3v3__fillcap_16
XFILLER_78_177 VDD VDD VSS VSS gf180mcu_as_sc_mcu7t3v3__fillcap_8
XFILLER_134_1491 VDD VDD VSS VSS gf180mcu_as_sc_mcu7t3v3__fillcap_16
XFILLER_130_1366 VDD VDD VSS VSS gf180mcu_as_sc_mcu7t3v3__fill_1
XFILLER_207_323 VDD VDD VSS VSS gf180mcu_as_sc_mcu7t3v3__fillcap_16
XFILLER_208_846 VDD VDD VSS VSS gf180mcu_as_sc_mcu7t3v3__fillcap_4
XFILLER_43_1396 VDD VDD VSS VSS gf180mcu_as_sc_mcu7t3v3__fillcap_8
XFILLER_93_169 VDD VDD VSS VSS gf180mcu_as_sc_mcu7t3v3__fillcap_16
XTAP_TAPCELL_ROW_204_2666 VDD VSS gf180mcu_as_sc_mcu7t3v3__tap_2
XTAP_TAPCELL_ROW_204_2655 VDD VSS gf180mcu_as_sc_mcu7t3v3__tap_2
XTAP_TAPCELL_ROW_179_2109 VDD VSS gf180mcu_as_sc_mcu7t3v3__tap_2
XFILLER_165_1418 VDD VDD VSS VSS gf180mcu_as_sc_mcu7t3v3__fillcap_4
XFILLER_16_940 VDD VDD VSS VSS gf180mcu_as_sc_mcu7t3v3__fillcap_4
XFILLER_34_247 VDD VDD VSS VSS gf180mcu_as_sc_mcu7t3v3__fillcap_16
XFILLER_16_984 VDD VDD VSS VSS gf180mcu_as_sc_mcu7t3v3__fillcap_16
XFILLER_188_731 VDD VDD VSS VSS gf180mcu_as_sc_mcu7t3v3__fillcap_4
XFILLER_203_540 VDD VDD VSS VSS gf180mcu_as_sc_mcu7t3v3__fillcap_16
XFILLER_206_1415 VDD VDD VSS VSS gf180mcu_as_sc_mcu7t3v3__fillcap_16
X_2960_ VDD VDD VSS VSS _3940_/A _3076_/B _3076_/C _3941_/A _2961_/C gf180mcu_as_sc_mcu7t3v3__ao22_2
XFILLER_187_230 VDD VDD VSS VSS gf180mcu_as_sc_mcu7t3v3__fill_2
XFILLER_188_753 VDD VDD VSS VSS gf180mcu_as_sc_mcu7t3v3__fillcap_16
XFILLER_203_562 VDD VDD VSS VSS gf180mcu_as_sc_mcu7t3v3__fillcap_16
XFILLER_206_1437 VDD VDD VSS VSS gf180mcu_as_sc_mcu7t3v3__fillcap_16
XPHY_EDGE_ROW_152_1_Right_673 VDD VSS gf180mcu_as_sc_mcu7t3v3__tap_2
X_2891_ VDD VDD VSS VSS _3257_/A _3533_/B _3533_/A gf180mcu_as_sc_mcu7t3v3__nor2b_2
XTAP_TAPCELL_ROW_196_2489 VDD VSS gf180mcu_as_sc_mcu7t3v3__tap_2
XTAP_TAPCELL_ROW_196_2478 VDD VSS gf180mcu_as_sc_mcu7t3v3__tap_2
XFILLER_15_1410 VDD VDD VSS VSS gf180mcu_as_sc_mcu7t3v3__fillcap_4
XFILLER_187_274 VDD VDD VSS VSS gf180mcu_as_sc_mcu7t3v3__fillcap_4
XFILLER_198_1205 VDD VDD VSS VSS gf180mcu_as_sc_mcu7t3v3__fillcap_16
XFILLER_31_965 VDD VDD VSS VSS gf180mcu_as_sc_mcu7t3v3__fillcap_4
X_4630_ VDD VDD VSS VSS _4683_/C _5118_/Q _4703_/B _5221_/D gf180mcu_as_sc_mcu7t3v3__mux2_2
XFILLER_198_1227 VDD VDD VSS VSS gf180mcu_as_sc_mcu7t3v3__fillcap_16
XFILLER_8_53 VDD VDD VSS VSS gf180mcu_as_sc_mcu7t3v3__fillcap_16
XFILLER_102_1424 VDD VDD VSS VSS gf180mcu_as_sc_mcu7t3v3__fillcap_16
XFILLER_141_1484 VDD VDD VSS VSS gf180mcu_as_sc_mcu7t3v3__fill_2
X_4561_ VDD VDD VSS VSS _4561_/D _4561_/A _4561_/B _4561_/C _4562_/B gf180mcu_as_sc_mcu7t3v3__ao31_2
XFILLER_89_1566 VDD VDD VSS VSS gf180mcu_as_sc_mcu7t3v3__fill_2
X_4492_ VDD VDD VSS VSS _4495_/C _4492_/B _4512_/A gf180mcu_as_sc_mcu7t3v3__nor2_2
X_3512_ VDD VDD VSS VSS _3513_/D _3512_/A _3521_/B _3512_/C gf180mcu_as_sc_mcu7t3v3__ao21_2
X_3443_ VDD VDD VSS VSS _4093_/D _3468_/B _3443_/C _3443_/D _3444_/A gf180mcu_as_sc_mcu7t3v3__ao22_2
XFILLER_139_1380 VDD VDD VSS VSS gf180mcu_as_sc_mcu7t3v3__fill_1
XFILLER_170_174 VDD VDD VSS VSS gf180mcu_as_sc_mcu7t3v3__fill_1
XFILLER_174_1260 VDD VDD VSS VSS gf180mcu_as_sc_mcu7t3v3__fillcap_8
XFILLER_170_196 VDD VDD VSS VSS gf180mcu_as_sc_mcu7t3v3__fill_1
XFILLER_69_133 VDD VDD VSS VSS gf180mcu_as_sc_mcu7t3v3__fillcap_4
XPHY_EDGE_ROW_29_Left_240 VDD VSS gf180mcu_as_sc_mcu7t3v3__tap_2
X_5113_ VDD VDD VSS VSS clkload8/A _5113_/D _5113_/Q gf180mcu_as_sc_mcu7t3v3__dfxtp_2
X_3374_ VDD VDD VSS VSS _4022_/A _3382_/B _3382_/C _4025_/A _3375_/C gf180mcu_as_sc_mcu7t3v3__ao22_2
X_5044_ VDD VDD VSS VSS _5082_/CLK _5044_/D _5044_/Q gf180mcu_as_sc_mcu7t3v3__dfxtp_2
XFILLER_26_737 VDD VDD VSS VSS gf180mcu_as_sc_mcu7t3v3__fillcap_4
XFILLER_92_191 VDD VDD VSS VSS gf180mcu_as_sc_mcu7t3v3__fillcap_4
XFILLER_178_230 VDD VDD VSS VSS gf180mcu_as_sc_mcu7t3v3__fill_1
X_4828_ VDD VDD VSS VSS _5082_/CLK _4828_/D _4828_/Q gf180mcu_as_sc_mcu7t3v3__dfxtp_2
XTAP_TAPCELL_ROW_25_1290 VDD VSS gf180mcu_as_sc_mcu7t3v3__tap_2
XFILLER_181_428 VDD VDD VSS VSS gf180mcu_as_sc_mcu7t3v3__fill_1
X_4759_ VDD VDD VSS VSS _5285_/CLK _4759_/D _4759_/Q gf180mcu_as_sc_mcu7t3v3__dfxtp_2
XTAP_TAPCELL_ROW_80_1_1685 VDD VSS gf180mcu_as_sc_mcu7t3v3__tap_2
XFILLER_175_38 VDD VDD VSS VSS gf180mcu_as_sc_mcu7t3v3__fillcap_16
XFILLER_4_107 VDD VDD VSS VSS gf180mcu_as_sc_mcu7t3v3__fillcap_4
XTAP_TAPCELL_ROW_21_1198 VDD VSS gf180mcu_as_sc_mcu7t3v3__tap_2
XTAP_TAPCELL_ROW_21_1187 VDD VSS gf180mcu_as_sc_mcu7t3v3__tap_2
XFILLER_108_32 VDD VDD VSS VSS gf180mcu_as_sc_mcu7t3v3__fill_2
XFILLER_175_1046 VDD VDD VSS VSS gf180mcu_as_sc_mcu7t3v3__fillcap_4
XTAP_TAPCELL_ROW_9_936 VDD VSS gf180mcu_as_sc_mcu7t3v3__tap_2
XTAP_TAPCELL_ROW_9_925 VDD VSS gf180mcu_as_sc_mcu7t3v3__tap_2
XFILLER_118_1420 VDD VDD VSS VSS gf180mcu_as_sc_mcu7t3v3__fillcap_4
XFILLER_175_1068 VDD VDD VSS VSS gf180mcu_as_sc_mcu7t3v3__fillcap_16
XFILLER_190_995 VDD VDD VSS VSS gf180mcu_as_sc_mcu7t3v3__fillcap_16
XFILLER_66_1352 VDD VDD VSS VSS gf180mcu_as_sc_mcu7t3v3__fill_2
XFILLER_0_346 VDD VDD VSS VSS gf180mcu_as_sc_mcu7t3v3__fill_2
Xinput203 VDD VDD VSS VSS se_in[2] wire872/A gf180mcu_as_sc_mcu7t3v3__buff_12
Xinput214 VDD VDD VSS VSS se_in[9] wire866/A gf180mcu_as_sc_mcu7t3v3__buff_12
Xinput225 VDD VDD VSS VSS south_in[19] _4088_/D gf180mcu_as_sc_mcu7t3v3__buff_12
Xinput236 VDD VDD VSS VSS south_in[29] _3788_/D gf180mcu_as_sc_mcu7t3v3__buff_12
XFILLER_124_53 VDD VDD VSS VSS gf180mcu_as_sc_mcu7t3v3__fillcap_16
XFILLER_75_125 VDD VDD VSS VSS gf180mcu_as_sc_mcu7t3v3__fill_1
XFILLER_75_136 VDD VDD VSS VSS gf180mcu_as_sc_mcu7t3v3__fillcap_4
Xinput247 VDD VDD VSS VSS south_in[8] _4000_/D gf180mcu_as_sc_mcu7t3v3__buff_12
Xinput258 VDD VDD VSS VSS sw_in[18] _2440_/A gf180mcu_as_sc_mcu7t3v3__buff_12
Xinput269 VDD VDD VSS VSS sw_in[28] _4164_/A gf180mcu_as_sc_mcu7t3v3__buff_12
XFILLER_40_1536 VDD VDD VSS VSS gf180mcu_as_sc_mcu7t3v3__fillcap_4
XFILLER_75_158 VDD VDD VSS VSS gf180mcu_as_sc_mcu7t3v3__fillcap_16
XFILLER_1_1018 VDD VDD VSS VSS gf180mcu_as_sc_mcu7t3v3__fillcap_16
XFILLER_5_1176 VDD VDD VSS VSS gf180mcu_as_sc_mcu7t3v3__fillcap_8
XFILLER_90_139 VDD VDD VSS VSS gf180mcu_as_sc_mcu7t3v3__fillcap_8
XFILLER_140_85 VDD VDD VSS VSS gf180mcu_as_sc_mcu7t3v3__fill_2
XFILLER_16_258 VDD VDD VSS VSS gf180mcu_as_sc_mcu7t3v3__fillcap_4
XFILLER_182_1017 VDD VDD VSS VSS gf180mcu_as_sc_mcu7t3v3__fillcap_16
XFILLER_13_954 VDD VDD VSS VSS gf180mcu_as_sc_mcu7t3v3__fill_1
XFILLER_164_1440 VDD VDD VSS VSS gf180mcu_as_sc_mcu7t3v3__fillcap_4
XFILLER_38_1465 VDD VDD VSS VSS gf180mcu_as_sc_mcu7t3v3__fillcap_8
XFILLER_73_1356 VDD VDD VSS VSS gf180mcu_as_sc_mcu7t3v3__fillcap_4
XFILLER_77_1492 VDD VDD VSS VSS gf180mcu_as_sc_mcu7t3v3__fill_2
XTAP_TAPCELL_ROW_174_2006 VDD VSS gf180mcu_as_sc_mcu7t3v3__tap_2
XFILLER_125_1457 VDD VDD VSS VSS gf180mcu_as_sc_mcu7t3v3__fillcap_8
XFILLER_185_734 VDD VDD VSS VSS gf180mcu_as_sc_mcu7t3v3__fillcap_16
XFILLER_197_594 VDD VDD VSS VSS gf180mcu_as_sc_mcu7t3v3__fillcap_16
XFILLER_200_521 VDD VDD VSS VSS gf180mcu_as_sc_mcu7t3v3__fillcap_4
XTAP_TAPCELL_ROW_61_3_2905 VDD VSS gf180mcu_as_sc_mcu7t3v3__tap_2
XFILLER_160_1348 VDD VDD VSS VSS gf180mcu_as_sc_mcu7t3v3__fillcap_16
XFILLER_199_1536 VDD VDD VSS VSS gf180mcu_as_sc_mcu7t3v3__fillcap_4
XFILLER_200_543 VDD VDD VSS VSS gf180mcu_as_sc_mcu7t3v3__fillcap_16
XFILLER_33_72 VDD VDD VSS VSS gf180mcu_as_sc_mcu7t3v3__fillcap_16
XFILLER_149_72 VDD VDD VSS VSS gf180mcu_as_sc_mcu7t3v3__fillcap_8
XPHY_EDGE_ROW_167_3_Right_204 VDD VSS gf180mcu_as_sc_mcu7t3v3__tap_2
XTAP_TAPCELL_ROW_191_2375 VDD VSS gf180mcu_as_sc_mcu7t3v3__tap_2
XTAP_TAPCELL_ROW_191_2364 VDD VSS gf180mcu_as_sc_mcu7t3v3__tap_2
XFILLER_184_288 VDD VDD VSS VSS gf180mcu_as_sc_mcu7t3v3__fillcap_4
XFILLER_10_1373 VDD VDD VSS VSS gf180mcu_as_sc_mcu7t3v3__fill_1
XFILLER_180_472 VDD VDD VSS VSS gf180mcu_as_sc_mcu7t3v3__fillcap_4
XFILLER_45_1414 VDD VDD VSS VSS gf180mcu_as_sc_mcu7t3v3__fill_2
XPHY_EDGE_ROW_163_3_Left_548 VDD VSS gf180mcu_as_sc_mcu7t3v3__tap_2
XFILLER_171_1488 VDD VDD VSS VSS gf180mcu_as_sc_mcu7t3v3__fillcap_8
X_3090_ VDD VDD VSS VSS _3097_/B _3163_/B _4073_/A gf180mcu_as_sc_mcu7t3v3__nand2_2
XTAP_TAPCELL_ROW_206_2706 VDD VSS gf180mcu_as_sc_mcu7t3v3__tap_2
XFILLER_207_120 VDD VDD VSS VSS gf180mcu_as_sc_mcu7t3v3__fillcap_16
XFILLER_207_142 VDD VDD VSS VSS gf180mcu_as_sc_mcu7t3v3__fillcap_16
XFILLER_81_128 VDD VDD VSS VSS gf180mcu_as_sc_mcu7t3v3__fill_1
Xclkbuf_leaf_7_clk_regs VDD VDD VSS VSS clkbuf_leaf_7_clk_regs/A _4869_/CLK gf180mcu_as_sc_mcu7t3v3__clkbuff_12
XTAP_TAPCELL_ROW_198_2518 VDD VSS gf180mcu_as_sc_mcu7t3v3__tap_2
XTAP_TAPCELL_ROW_198_2529 VDD VSS gf180mcu_as_sc_mcu7t3v3__tap_2
XFILLER_23_729 VDD VDD VSS VSS gf180mcu_as_sc_mcu7t3v3__fillcap_16
X_3992_ VDD VDD VSS VSS _3992_/A _4032_/B _4032_/C _3992_/D _3993_/D gf180mcu_as_sc_mcu7t3v3__ao22_2
XFILLER_200_22 VDD VDD VSS VSS gf180mcu_as_sc_mcu7t3v3__fillcap_8
XFILLER_204_871 VDD VDD VSS VSS gf180mcu_as_sc_mcu7t3v3__fillcap_4
XFILLER_91_1445 VDD VDD VSS VSS gf180mcu_as_sc_mcu7t3v3__fillcap_16
XFILLER_95_2 VDD VDD VSS VSS gf180mcu_as_sc_mcu7t3v3__fill_1
XTAP_TAPCELL_ROW_110_3_3050 VDD VSS gf180mcu_as_sc_mcu7t3v3__tap_2
X_2943_ VDD VDD VSS VSS _3243_/B _3526_/B _3283_/A gf180mcu_as_sc_mcu7t3v3__nand2_2
XFILLER_204_893 VDD VDD VSS VSS gf180mcu_as_sc_mcu7t3v3__fillcap_16
XFILLER_52_1429 VDD VDD VSS VSS gf180mcu_as_sc_mcu7t3v3__fillcap_16
XFILLER_143_1568 VDD VDD VSS VSS gf180mcu_as_sc_mcu7t3v3__fill_1
XPHY_EDGE_ROW_153_1_Right_674 VDD VSS gf180mcu_as_sc_mcu7t3v3__tap_2
X_2874_ VDD VDD VSS VSS _4768_/D _4742_/C _4749_/B _4733_/B gf180mcu_as_sc_mcu7t3v3__aoi21_2
XFILLER_15_1262 VDD VDD VSS VSS gf180mcu_as_sc_mcu7t3v3__fillcap_16
XFILLER_190_203 VDD VDD VSS VSS gf180mcu_as_sc_mcu7t3v3__fillcap_16
X_4613_ VDD VDD VSS VSS _5207_/Q _4621_/B _4620_/C _5208_/Q _5207_/D gf180mcu_as_sc_mcu7t3v3__ao22_2
XFILLER_15_1284 VDD VDD VSS VSS gf180mcu_as_sc_mcu7t3v3__fill_1
X_4544_ VDD VDD VSS VSS _4586_/S _5025_/Q _5054_/Q _4545_/B gf180mcu_as_sc_mcu7t3v3__mux2_2
XFILLER_128_193 VDD VDD VSS VSS gf180mcu_as_sc_mcu7t3v3__fillcap_4
XFILLER_190_247 VDD VDD VSS VSS gf180mcu_as_sc_mcu7t3v3__fillcap_8
XFILLER_143_174 VDD VDD VSS VSS gf180mcu_as_sc_mcu7t3v3__fillcap_16
X_4475_ VDD VDD VSS VSS _4476_/D _4475_/B _4510_/A gf180mcu_as_sc_mcu7t3v3__nor2_2
X_3426_ VDD VDD VSS VSS _3428_/C _4080_/D _3466_/B _3426_/C gf180mcu_as_sc_mcu7t3v3__ao21_2
XFILLER_63_1558 VDD VDD VSS VSS gf180mcu_as_sc_mcu7t3v3__fillcap_8
X_3357_ VDD VDD VSS VSS _3452_/S _4008_/D _3357_/A _3359_/B gf180mcu_as_sc_mcu7t3v3__mux2_2
XFILLER_150_1539 VDD VDD VSS VSS gf180mcu_as_sc_mcu7t3v3__fill_2
XFILLER_161_18 VDD VDD VSS VSS gf180mcu_as_sc_mcu7t3v3__fillcap_16
Xhold1102 VDD VDD VSS VSS _2584_/Y _2585_/B gf180mcu_as_sc_mcu7t3v3__clkbuff_4
Xhold1113 VDD VDD VSS VSS hold1140/Y _4971_/D gf180mcu_as_sc_mcu7t3v3__clkbuff_4
Xhold1124 VDD VDD VSS VSS _2589_/Y _2590_/B gf180mcu_as_sc_mcu7t3v3__clkbuff_4
XTAP_TAPCELL_ROW_56_1_1614 VDD VSS gf180mcu_as_sc_mcu7t3v3__tap_2
X_5027_ VDD VDD VSS VSS _5085_/CLK _5027_/D _5027_/Q gf180mcu_as_sc_mcu7t3v3__dfxtp_2
Xhold1135 VDD VDD VSS VSS _2581_/Y hold1135/Y gf180mcu_as_sc_mcu7t3v3__clkbuff_4
Xhold1146 VDD VDD VSS VSS _4969_/Q hold1146/Y gf180mcu_as_sc_mcu7t3v3__clkbuff_4
X_3288_ VDD VDD VSS VSS _3288_/A _3408_/B _3288_/C _3289_/C gf180mcu_as_sc_mcu7t3v3__nor3_2
XFILLER_113_1383 VDD VDD VSS VSS gf180mcu_as_sc_mcu7t3v3__fill_2
XFILLER_148_1424 VDD VDD VSS VSS gf180mcu_as_sc_mcu7t3v3__fill_1
XFILLER_199_804 VDD VDD VSS VSS gf180mcu_as_sc_mcu7t3v3__fillcap_16
XFILLER_2_1349 VDD VDD VSS VSS gf180mcu_as_sc_mcu7t3v3__fill_1
XFILLER_54_27 VDD VDD VSS VSS gf180mcu_as_sc_mcu7t3v3__fillcap_8
XFILLER_13_206 VDD VDD VSS VSS gf180mcu_as_sc_mcu7t3v3__fillcap_4
XFILLER_183_1348 VDD VDD VSS VSS gf180mcu_as_sc_mcu7t3v3__fillcap_16
XFILLER_187_1495 VDD VDD VSS VSS gf180mcu_as_sc_mcu7t3v3__fill_2
XFILLER_13_228 VDD VDD VSS VSS gf180mcu_as_sc_mcu7t3v3__fillcap_16
XFILLER_186_509 VDD VDD VSS VSS gf180mcu_as_sc_mcu7t3v3__fillcap_16
XTAP_TAPCELL_ROW_27_1330 VDD VSS gf180mcu_as_sc_mcu7t3v3__tap_2
XTAP_TAPCELL_ROW_23_1238 VDD VSS gf180mcu_as_sc_mcu7t3v3__tap_2
XTAP_TAPCELL_ROW_23_1227 VDD VSS gf180mcu_as_sc_mcu7t3v3__tap_2
XFILLER_182_726 VDD VDD VSS VSS gf180mcu_as_sc_mcu7t3v3__fillcap_8
XFILLER_186_37 VDD VDD VSS VSS gf180mcu_as_sc_mcu7t3v3__fillcap_16
XFILLER_194_575 VDD VDD VSS VSS gf180mcu_as_sc_mcu7t3v3__fillcap_16
XFILLER_194_597 VDD VDD VSS VSS gf180mcu_as_sc_mcu7t3v3__fillcap_16
XFILLER_159_1553 VDD VDD VSS VSS gf180mcu_as_sc_mcu7t3v3__fill_2
XFILLER_68_1447 VDD VDD VSS VSS gf180mcu_as_sc_mcu7t3v3__fillcap_4
XFILLER_134_174 VDD VDD VSS VSS gf180mcu_as_sc_mcu7t3v3__fill_1
XFILLER_79_68 VDD VDD VSS VSS gf180mcu_as_sc_mcu7t3v3__fill_2
XFILLER_0_110 VDD VDD VSS VSS gf180mcu_as_sc_mcu7t3v3__fill_1
XFILLER_1_644 VDD VDD VSS VSS gf180mcu_as_sc_mcu7t3v3__fillcap_4
XFILLER_95_209 VDD VDD VSS VSS gf180mcu_as_sc_mcu7t3v3__fill_1
XFILLER_0_176 VDD VDD VSS VSS gf180mcu_as_sc_mcu7t3v3__fill_2
XFILLER_7_1238 VDD VDD VSS VSS gf180mcu_as_sc_mcu7t3v3__fill_2
XFILLER_95_34 VDD VDD VSS VSS gf180mcu_as_sc_mcu7t3v3__fillcap_4
XTAP_TAPCELL_ROW_103_1_1753 VDD VSS gf180mcu_as_sc_mcu7t3v3__tap_2
XFILLER_131_1450 VDD VDD VSS VSS gf180mcu_as_sc_mcu7t3v3__fill_2
XFILLER_95_67 VDD VDD VSS VSS gf180mcu_as_sc_mcu7t3v3__fill_2
XTAP_TAPCELL_ROW_115_3_3065 VDD VSS gf180mcu_as_sc_mcu7t3v3__tap_2
XFILLER_131_1483 VDD VDD VSS VSS gf180mcu_as_sc_mcu7t3v3__fill_2
XFILLER_188_1259 VDD VDD VSS VSS gf180mcu_as_sc_mcu7t3v3__fillcap_16
XFILLER_204_101 VDD VDD VSS VSS gf180mcu_as_sc_mcu7t3v3__fillcap_4
XFILLER_63_139 VDD VDD VSS VSS gf180mcu_as_sc_mcu7t3v3__fill_1
XTAP_TAPCELL_ROW_201_2603 VDD VSS gf180mcu_as_sc_mcu7t3v3__tap_2
XFILLER_127_1508 VDD VDD VSS VSS gf180mcu_as_sc_mcu7t3v3__fill_1
XFILLER_166_1535 VDD VDD VSS VSS gf180mcu_as_sc_mcu7t3v3__fill_2
XFILLER_204_123 VDD VDD VSS VSS gf180mcu_as_sc_mcu7t3v3__fillcap_16
XFILLER_75_1418 VDD VDD VSS VSS gf180mcu_as_sc_mcu7t3v3__fillcap_4
XFILLER_166_1568 VDD VDD VSS VSS gf180mcu_as_sc_mcu7t3v3__fill_1
XFILLER_189_347 VDD VDD VSS VSS gf180mcu_as_sc_mcu7t3v3__fill_2
XTAP_TAPCELL_ROW_193_2415 VDD VSS gf180mcu_as_sc_mcu7t3v3__tap_2
XFILLER_44_82 VDD VDD VSS VSS gf180mcu_as_sc_mcu7t3v3__fillcap_8
XTAP_TAPCELL_ROW_80_3_2960 VDD VSS gf180mcu_as_sc_mcu7t3v3__tap_2
XTAP_TAPCELL_ROW_193_2426 VDD VSS gf180mcu_as_sc_mcu7t3v3__tap_2
XFILLER_201_874 VDD VDD VSS VSS gf180mcu_as_sc_mcu7t3v3__fillcap_16
XFILLER_203_1418 VDD VDD VSS VSS gf180mcu_as_sc_mcu7t3v3__fillcap_16
XFILLER_103_1530 VDD VDD VSS VSS gf180mcu_as_sc_mcu7t3v3__fill_1
XFILLER_200_384 VDD VDD VSS VSS gf180mcu_as_sc_mcu7t3v3__fill_1
XFILLER_12_1446 VDD VDD VSS VSS gf180mcu_as_sc_mcu7t3v3__fill_1
XFILLER_195_1208 VDD VDD VSS VSS gf180mcu_as_sc_mcu7t3v3__fillcap_16
XFILLER_9_788 VDD VDD VSS VSS gf180mcu_as_sc_mcu7t3v3__fillcap_4
XTAP_TAPCELL_ROW_11_963 VDD VSS gf180mcu_as_sc_mcu7t3v3__tap_2
XTAP_TAPCELL_ROW_11_974 VDD VSS gf180mcu_as_sc_mcu7t3v3__tap_2
XFILLER_201_1186 VDD VDD VSS VSS gf180mcu_as_sc_mcu7t3v3__fillcap_4
XPHY_EDGE_ROW_168_3_Right_205 VDD VSS gf180mcu_as_sc_mcu7t3v3__tap_2
X_2590_ VDD VDD VSS VSS _4949_/D _2590_/B _3907_/A gf180mcu_as_sc_mcu7t3v3__nand2_2
XFILLER_125_174 VDD VDD VSS VSS gf180mcu_as_sc_mcu7t3v3__fillcap_8
X_4260_ VDD VDD VSS VSS _5096_/D _4260_/B _4260_/A gf180mcu_as_sc_mcu7t3v3__nor2_2
XFILLER_140_155 VDD VDD VSS VSS gf180mcu_as_sc_mcu7t3v3__fillcap_16
X_4191_ VDD VDD VSS VSS _4251_/B _4191_/B _4191_/C _5029_/Q _5029_/D gf180mcu_as_sc_mcu7t3v3__ao22_2
X_3211_ VDD VDD VSS VSS _3222_/D _3796_/D _3787_/A _3255_/B _3212_/D gf180mcu_as_sc_mcu7t3v3__ao31_2
XFILLER_136_1383 VDD VDD VSS VSS gf180mcu_as_sc_mcu7t3v3__fillcap_16
XFILLER_140_177 VDD VDD VSS VSS gf180mcu_as_sc_mcu7t3v3__fillcap_8
XFILLER_94_220 VDD VDD VSS VSS gf180mcu_as_sc_mcu7t3v3__fill_2
X_3142_ VDD VDD VSS VSS _4119_/A _3240_/B _3150_/C _4118_/A _3148_/B gf180mcu_as_sc_mcu7t3v3__ao22_2
XFILLER_39_136 VDD VDD VSS VSS gf180mcu_as_sc_mcu7t3v3__fillcap_4
XFILLER_39_158 VDD VDD VSS VSS gf180mcu_as_sc_mcu7t3v3__fillcap_16
XFILLER_110_1523 VDD VDD VSS VSS gf180mcu_as_sc_mcu7t3v3__fillcap_16
X_3073_ VDD VDD VSS VSS _3676_/A _3073_/B _3073_/C _3073_/Y _4199_/A gf180mcu_as_sc_mcu7t3v3__aoi211_2
XFILLER_208_473 VDD VDD VSS VSS gf180mcu_as_sc_mcu7t3v3__fillcap_16
XFILLER_36_898 VDD VDD VSS VSS gf180mcu_as_sc_mcu7t3v3__fillcap_16
XFILLER_196_807 VDD VDD VSS VSS gf180mcu_as_sc_mcu7t3v3__fillcap_16
XFILLER_208_1329 VDD VDD VSS VSS gf180mcu_as_sc_mcu7t3v3__fillcap_16
XFILLER_210_104 VDD VDD VSS VSS gf180mcu_as_sc_mcu7t3v3__fillcap_4
XTAP_TAPCELL_ROW_141_3_3144 VDD VSS gf180mcu_as_sc_mcu7t3v3__tap_2
X_3975_ VDD VDD VSS VSS _3975_/A _4030_/C _3975_/C _3975_/D _3977_/C gf180mcu_as_sc_mcu7t3v3__ao211_2
XFILLER_176_542 VDD VDD VSS VSS gf180mcu_as_sc_mcu7t3v3__fillcap_4
XFILLER_188_391 VDD VDD VSS VSS gf180mcu_as_sc_mcu7t3v3__fill_1
XFILLER_195_339 VDD VDD VSS VSS gf180mcu_as_sc_mcu7t3v3__fill_1
X_2926_ VDD VDD VSS VSS _3216_/B _3266_/B _3531_/A gf180mcu_as_sc_mcu7t3v3__nand2_2
XFILLER_108_1485 VDD VDD VSS VSS gf180mcu_as_sc_mcu7t3v3__fillcap_4
XFILLER_30_1502 VDD VDD VSS VSS gf180mcu_as_sc_mcu7t3v3__fill_2
XPHY_EDGE_ROW_154_1_Right_675 VDD VSS gf180mcu_as_sc_mcu7t3v3__tap_2
X_2857_ VDD VDD VSS VSS _2858_/B _5097_/Q _2857_/Y gf180mcu_as_sc_mcu7t3v3__and2_2
XFILLER_176_597 VDD VDD VSS VSS gf180mcu_as_sc_mcu7t3v3__fillcap_16
XFILLER_191_556 VDD VDD VSS VSS gf180mcu_as_sc_mcu7t3v3__fillcap_4
XFILLER_191_578 VDD VDD VSS VSS gf180mcu_as_sc_mcu7t3v3__fillcap_16
XFILLER_3_909 VDD VDD VSS VSS gf180mcu_as_sc_mcu7t3v3__fill_1
XTAP_TAPCELL_ROW_108_1_1768 VDD VSS gf180mcu_as_sc_mcu7t3v3__tap_2
X_2788_ VDD VDD VSS VSS _5126_/Q _5181_/Q _5165_/Q _2789_/A gf180mcu_as_sc_mcu7t3v3__mux2_2
X_4527_ VDD VDD VSS VSS _4527_/S _5023_/Q _5052_/Q _4528_/B gf180mcu_as_sc_mcu7t3v3__mux2_2
XFILLER_116_174 VDD VDD VSS VSS gf180mcu_as_sc_mcu7t3v3__fill_1
XFILLER_116_196 VDD VDD VSS VSS gf180mcu_as_sc_mcu7t3v3__fill_2
XFILLER_49_27 VDD VDD VSS VSS gf180mcu_as_sc_mcu7t3v3__fillcap_16
X_4458_ VDD VDD VSS VSS _4458_/D _4538_/A _4458_/B _4458_/C _4459_/B gf180mcu_as_sc_mcu7t3v3__ao31_2
XFILLER_154_1450 VDD VDD VSS VSS gf180mcu_as_sc_mcu7t3v3__fill_1
XFILLER_28_1453 VDD VDD VSS VSS gf180mcu_as_sc_mcu7t3v3__fillcap_8
XFILLER_67_1480 VDD VDD VSS VSS gf180mcu_as_sc_mcu7t3v3__fillcap_4
XFILLER_8_1514 VDD VDD VSS VSS gf180mcu_as_sc_mcu7t3v3__fill_2
Xfanout701 VDD VDD VSS VSS _3928_/Y _4160_/C gf180mcu_as_sc_mcu7t3v3__buff_12
Xfanout712 VDD VDD VSS VSS _3268_/Y _3448_/C gf180mcu_as_sc_mcu7t3v3__buff_12
Xfanout723 VDD VDD VSS VSS _3736_/B _3728_/B gf180mcu_as_sc_mcu7t3v3__buff_12
X_3409_ VDD VDD VSS VSS _4931_/Q _3486_/B _3465_/C _4061_/A _3410_/C gf180mcu_as_sc_mcu7t3v3__ao22_2
XFILLER_24_1317 VDD VDD VSS VSS gf180mcu_as_sc_mcu7t3v3__fill_2
Xfanout734 VDD VDD VSS VSS _3121_/B _3179_/B gf180mcu_as_sc_mcu7t3v3__buff_12
Xfanout745 VDD VDD VSS VSS _4640_/S _4683_/C gf180mcu_as_sc_mcu7t3v3__buff_12
Xfanout767 VDD VDD VSS VSS _4167_/Y _4196_/B gf180mcu_as_sc_mcu7t3v3__buff_12
X_4389_ VDD VDD VSS VSS _5165_/Q _4504_/B _4389_/C _4389_/D _5165_/D gf180mcu_as_sc_mcu7t3v3__ao211_2
XFILLER_115_1467 VDD VDD VSS VSS gf180mcu_as_sc_mcu7t3v3__fill_1
XFILLER_189_1513 VDD VDD VSS VSS gf180mcu_as_sc_mcu7t3v3__fill_2
XFILLER_85_220 VDD VDD VSS VSS gf180mcu_as_sc_mcu7t3v3__fill_2
XFILLER_98_1407 VDD VDD VSS VSS gf180mcu_as_sc_mcu7t3v3__fillcap_16
XPHY_EDGE_ROW_130_3_Right_167 VDD VSS gf180mcu_as_sc_mcu7t3v3__tap_2
Xfanout778 VDD VDD VSS VSS _4684_/A _4683_/B gf180mcu_as_sc_mcu7t3v3__buff_12
Xfanout789 VDD VDD VSS VSS _4588_/A _4538_/A gf180mcu_as_sc_mcu7t3v3__buff_12
XTAP_TAPCELL_ROW_16_1086 VDD VSS gf180mcu_as_sc_mcu7t3v3__tap_2
XTAP_TAPCELL_ROW_16_1075 VDD VSS gf180mcu_as_sc_mcu7t3v3__tap_2
XFILLER_105_88 VDD VDD VSS VSS gf180mcu_as_sc_mcu7t3v3__fillcap_16
XFILLER_98_1429 VDD VDD VSS VSS gf180mcu_as_sc_mcu7t3v3__fill_1
XTAP_TAPCELL_ROW_85_3_2975 VDD VSS gf180mcu_as_sc_mcu7t3v3__tap_2
XFILLER_26_364 VDD VDD VSS VSS gf180mcu_as_sc_mcu7t3v3__fill_2
XFILLER_27_876 VDD VDD VSS VSS gf180mcu_as_sc_mcu7t3v3__fill_1
XFILLER_81_36 VDD VDD VSS VSS gf180mcu_as_sc_mcu7t3v3__fillcap_16
XFILLER_186_317 VDD VDD VSS VSS gf180mcu_as_sc_mcu7t3v3__fillcap_16
XFILLER_198_155 VDD VDD VSS VSS gf180mcu_as_sc_mcu7t3v3__fillcap_16
XFILLER_198_177 VDD VDD VSS VSS gf180mcu_as_sc_mcu7t3v3__fillcap_16
XFILLER_201_104 VDD VDD VSS VSS gf180mcu_as_sc_mcu7t3v3__fillcap_16
XFILLER_35_1402 VDD VDD VSS VSS gf180mcu_as_sc_mcu7t3v3__fill_2
XFILLER_35_1457 VDD VDD VSS VSS gf180mcu_as_sc_mcu7t3v3__fill_1
XFILLER_14_85 VDD VDD VSS VSS gf180mcu_as_sc_mcu7t3v3__fillcap_16
XFILLER_22_592 VDD VDD VSS VSS gf180mcu_as_sc_mcu7t3v3__fill_2
XFILLER_70_1348 VDD VDD VSS VSS gf180mcu_as_sc_mcu7t3v3__fillcap_16
XFILLER_154_203 VDD VDD VSS VSS gf180mcu_as_sc_mcu7t3v3__fillcap_16
XFILLER_194_383 VDD VDD VSS VSS gf180mcu_as_sc_mcu7t3v3__fill_2
XFILLER_10_798 VDD VDD VSS VSS gf180mcu_as_sc_mcu7t3v3__fillcap_4
XFILLER_182_567 VDD VDD VSS VSS gf180mcu_as_sc_mcu7t3v3__fill_2
XFILLER_196_1539 VDD VDD VSS VSS gf180mcu_as_sc_mcu7t3v3__fillcap_4
XFILLER_5_224 VDD VDD VSS VSS gf180mcu_as_sc_mcu7t3v3__fill_2
XFILLER_6_747 VDD VDD VSS VSS gf180mcu_as_sc_mcu7t3v3__fill_2
XFILLER_30_73 VDD VDD VSS VSS gf180mcu_as_sc_mcu7t3v3__fill_2
XFILLER_107_174 VDD VDD VSS VSS gf180mcu_as_sc_mcu7t3v3__fill_1
XFILLER_46_1531 VDD VDD VSS VSS gf180mcu_as_sc_mcu7t3v3__fillcap_4
XTAP_TAPCELL_ROW_186_2263 VDD VSS gf180mcu_as_sc_mcu7t3v3__tap_2
XFILLER_122_177 VDD VDD VSS VSS gf180mcu_as_sc_mcu7t3v3__fillcap_4
XFILLER_2_986 VDD VDD VSS VSS gf180mcu_as_sc_mcu7t3v3__fill_2
XTAP_TAPCELL_ROW_186_2274 VDD VSS gf180mcu_as_sc_mcu7t3v3__tap_2
XFILLER_7_1068 VDD VDD VSS VSS gf180mcu_as_sc_mcu7t3v3__fillcap_8
XFILLER_81_1488 VDD VDD VSS VSS gf180mcu_as_sc_mcu7t3v3__fillcap_16
XTAP_TAPCELL_ROW_134_1_1847 VDD VSS gf180mcu_as_sc_mcu7t3v3__tap_2
XFILLER_162_83 VDD VDD VSS VSS gf180mcu_as_sc_mcu7t3v3__fillcap_8
XTAP_TAPCELL_ROW_146_3_3159 VDD VSS gf180mcu_as_sc_mcu7t3v3__tap_2
XFILLER_91_212 VDD VDD VSS VSS gf180mcu_as_sc_mcu7t3v3__fillcap_8
XFILLER_17_342 VDD VDD VSS VSS gf180mcu_as_sc_mcu7t3v3__fillcap_8
XFILLER_206_955 VDD VDD VSS VSS gf180mcu_as_sc_mcu7t3v3__fill_2
XFILLER_205_454 VDD VDD VSS VSS gf180mcu_as_sc_mcu7t3v3__fillcap_16
XFILLER_206_999 VDD VDD VSS VSS gf180mcu_as_sc_mcu7t3v3__fillcap_16
XFILLER_33_835 VDD VDD VSS VSS gf180mcu_as_sc_mcu7t3v3__fillcap_4
XFILLER_44_183 VDD VDD VSS VSS gf180mcu_as_sc_mcu7t3v3__fill_1
XFILLER_55_92 VDD VDD VSS VSS gf180mcu_as_sc_mcu7t3v3__fill_2
XFILLER_13_570 VDD VDD VSS VSS gf180mcu_as_sc_mcu7t3v3__fillcap_4
X_3760_ VDD VDD VSS VSS _4141_/A _3802_/C _3760_/C _3760_/Y _3760_/D gf180mcu_as_sc_mcu7t3v3__aoi211_2
XFILLER_53_1568 VDD VDD VSS VSS gf180mcu_as_sc_mcu7t3v3__fill_1
XPHY_EDGE_ROW_98_1_Left_308 VDD VSS gf180mcu_as_sc_mcu7t3v3__tap_2
X_2711_ VDD VDD VSS VSS _2732_/S _4961_/Q _4970_/Q _2713_/A gf180mcu_as_sc_mcu7t3v3__mux2_2
X_3691_ VDD VDD VSS VSS _3691_/D _3730_/A _3691_/B _3691_/C _3692_/C gf180mcu_as_sc_mcu7t3v3__ao31_2
XFILLER_12_1243 VDD VDD VSS VSS gf180mcu_as_sc_mcu7t3v3__fillcap_16
X_2642_ VDD VDD VSS VSS _2650_/C _2737_/A _2736_/B input6/Y gf180mcu_as_sc_mcu7t3v3__aoi21_2
XFILLER_160_217 VDD VDD VSS VSS gf180mcu_as_sc_mcu7t3v3__fillcap_4
XFILLER_58_2 VDD VDD VSS VSS gf180mcu_as_sc_mcu7t3v3__fill_2
XPHY_EDGE_ROW_169_3_Right_206 VDD VSS gf180mcu_as_sc_mcu7t3v3__tap_2
Xoutput326 VDD VDD VSS VSS _4849_/Q east_out[10] gf180mcu_as_sc_mcu7t3v3__buff_12
X_2573_ VDD VDD VSS VSS _5156_/Q _5155_/Q _4338_/A gf180mcu_as_sc_mcu7t3v3__or2_2
XFILLER_113_122 VDD VDD VSS VSS gf180mcu_as_sc_mcu7t3v3__fill_2
XFILLER_177_1472 VDD VDD VSS VSS gf180mcu_as_sc_mcu7t3v3__fillcap_8
XPHY_EDGE_ROW_107_3_Left_492 VDD VSS gf180mcu_as_sc_mcu7t3v3__tap_2
Xoutput359 VDD VDD VSS VSS _4771_/Q se_out[0] gf180mcu_as_sc_mcu7t3v3__buff_12
Xoutput348 VDD VDD VSS VSS _4869_/Q east_out[30] gf180mcu_as_sc_mcu7t3v3__buff_12
Xoutput337 VDD VDD VSS VSS _4859_/Q east_out[20] gf180mcu_as_sc_mcu7t3v3__buff_12
X_4312_ VDD VDD VSS VSS _4314_/S _5142_/Q _5141_/Q _5141_/D gf180mcu_as_sc_mcu7t3v3__mux2_2
XFILLER_59_209 VDD VDD VSS VSS gf180mcu_as_sc_mcu7t3v3__fill_1
X_4243_ VDD VDD VSS VSS _4256_/S _4243_/B _5079_/Q _5079_/D gf180mcu_as_sc_mcu7t3v3__mux2_2
XFILLER_67_220 VDD VDD VSS VSS gf180mcu_as_sc_mcu7t3v3__fill_2
X_4174_ VDD VDD VSS VSS _4234_/B _4191_/B _4191_/C _5012_/Q _5012_/D gf180mcu_as_sc_mcu7t3v3__ao22_2
XFILLER_210_1219 VDD VDD VSS VSS gf180mcu_as_sc_mcu7t3v3__fill_1
XFILLER_28_629 VDD VDD VSS VSS gf180mcu_as_sc_mcu7t3v3__fillcap_16
X_3125_ VDD VDD VSS VSS _4104_/A _3125_/B _3125_/C _4104_/D _3131_/B gf180mcu_as_sc_mcu7t3v3__ao22_2
XFILLER_27_139 VDD VDD VSS VSS gf180mcu_as_sc_mcu7t3v3__fill_1
X_3056_ VDD VDD VSS VSS _3057_/B _3056_/B _3056_/C _3057_/C gf180mcu_as_sc_mcu7t3v3__nor3_2
XFILLER_97_1451 VDD VDD VSS VSS gf180mcu_as_sc_mcu7t3v3__fillcap_8
XFILLER_23_301 VDD VDD VSS VSS gf180mcu_as_sc_mcu7t3v3__fillcap_4
XFILLER_35_150 VDD VDD VSS VSS gf180mcu_as_sc_mcu7t3v3__fill_1
XFILLER_36_684 VDD VDD VSS VSS gf180mcu_as_sc_mcu7t3v3__fill_1
XFILLER_184_1476 VDD VDD VSS VSS gf180mcu_as_sc_mcu7t3v3__fillcap_8
XFILLER_50_120 VDD VDD VSS VSS gf180mcu_as_sc_mcu7t3v3__fillcap_16
XTAP_TAPCELL_ROW_160_1_1926 VDD VSS gf180mcu_as_sc_mcu7t3v3__tap_2
XFILLER_11_529 VDD VDD VSS VSS gf180mcu_as_sc_mcu7t3v3__fillcap_16
XFILLER_195_136 VDD VDD VSS VSS gf180mcu_as_sc_mcu7t3v3__fillcap_4
XTAP_TAPCELL_ROW_172_3_3238 VDD VSS gf180mcu_as_sc_mcu7t3v3__tap_2
XFILLER_177_862 VDD VDD VSS VSS gf180mcu_as_sc_mcu7t3v3__fill_2
XFILLER_195_158 VDD VDD VSS VSS gf180mcu_as_sc_mcu7t3v3__fillcap_16
X_3958_ VDD VDD VSS VSS _4031_/B _3958_/A _3960_/C gf180mcu_as_sc_mcu7t3v3__and2_2
X_3889_ VDD VDD VSS VSS _3890_/B _5179_/Q _4929_/D gf180mcu_as_sc_mcu7t3v3__and2_2
X_2909_ VDD VDD VSS VSS _3202_/B _3537_/A _3224_/C gf180mcu_as_sc_mcu7t3v3__and2_2
XPHY_EDGE_ROW_155_1_Right_676 VDD VSS gf180mcu_as_sc_mcu7t3v3__tap_2
XFILLER_151_206 VDD VDD VSS VSS gf180mcu_as_sc_mcu7t3v3__fillcap_4
XFILLER_3_706 VDD VDD VSS VSS gf180mcu_as_sc_mcu7t3v3__fill_1
XFILLER_156_1523 VDD VDD VSS VSS gf180mcu_as_sc_mcu7t3v3__fillcap_16
XFILLER_183_38 VDD VDD VSS VSS gf180mcu_as_sc_mcu7t3v3__fillcap_16
XFILLER_117_1518 VDD VDD VSS VSS gf180mcu_as_sc_mcu7t3v3__fillcap_8
XTAP_TAPCELL_ROW_18_1137 VDD VSS gf180mcu_as_sc_mcu7t3v3__tap_2
XTAP_TAPCELL_ROW_18_1126 VDD VSS gf180mcu_as_sc_mcu7t3v3__tap_2
XFILLER_104_177 VDD VDD VSS VSS gf180mcu_as_sc_mcu7t3v3__fillcap_4
XFILLER_191_1469 VDD VDD VSS VSS gf180mcu_as_sc_mcu7t3v3__fill_1
XFILLER_24_1103 VDD VDD VSS VSS gf180mcu_as_sc_mcu7t3v3__fillcap_16
XFILLER_28_1272 VDD VDD VSS VSS gf180mcu_as_sc_mcu7t3v3__fillcap_16
Xfanout520 VDD VDD VSS VSS _4158_/D _4117_/D gf180mcu_as_sc_mcu7t3v3__buff_12
XFILLER_189_1310 VDD VDD VSS VSS gf180mcu_as_sc_mcu7t3v3__fillcap_16
XFILLER_28_1294 VDD VDD VSS VSS gf180mcu_as_sc_mcu7t3v3__fill_1
Xfanout553 VDD VDD VSS VSS _4592_/B _4574_/B gf180mcu_as_sc_mcu7t3v3__buff_12
Xfanout564 VDD VDD VSS VSS _3921_/Y _4136_/C gf180mcu_as_sc_mcu7t3v3__buff_12
Xfanout575 VDD VDD VSS VSS _3453_/C _3382_/C gf180mcu_as_sc_mcu7t3v3__buff_12
XTAP_TAPCELL_ROW_35_1495 VDD VSS gf180mcu_as_sc_mcu7t3v3__tap_2
XFILLER_189_1332 VDD VDD VSS VSS gf180mcu_as_sc_mcu7t3v3__fillcap_16
XFILLER_76_69 VDD VDD VSS VSS gf180mcu_as_sc_mcu7t3v3__fillcap_4
XPHY_EDGE_ROW_131_3_Right_168 VDD VSS gf180mcu_as_sc_mcu7t3v3__tap_2
Xfanout586 VDD VDD VSS VSS _3132_/B _3057_/B gf180mcu_as_sc_mcu7t3v3__buff_12
Xfanout597 VDD VDD VSS VSS _4104_/B _4032_/B gf180mcu_as_sc_mcu7t3v3__buff_12
XFILLER_132_53 VDD VDD VSS VSS gf180mcu_as_sc_mcu7t3v3__fillcap_16
XFILLER_18_139 VDD VDD VSS VSS gf180mcu_as_sc_mcu7t3v3__fillcap_16
XFILLER_73_212 VDD VDD VSS VSS gf180mcu_as_sc_mcu7t3v3__fillcap_8
Xmesh_tile_990 VDD VDD VSS VSS north_out[31] gf180mcu_as_sc_mcu7t3v3__tiel_4
XTAP_TAPCELL_ROW_181_2160 VDD VSS gf180mcu_as_sc_mcu7t3v3__tap_2
XTAP_TAPCELL_ROW_2_783 VDD VSS gf180mcu_as_sc_mcu7t3v3__tap_2
XTAP_TAPCELL_ROW_2_772 VDD VSS gf180mcu_as_sc_mcu7t3v3__tap_2
XFILLER_26_172 VDD VDD VSS VSS gf180mcu_as_sc_mcu7t3v3__fill_2
XFILLER_92_79 VDD VDD VSS VSS gf180mcu_as_sc_mcu7t3v3__fillcap_8
XFILLER_187_626 VDD VDD VSS VSS gf180mcu_as_sc_mcu7t3v3__fillcap_4
XFILLER_199_486 VDD VDD VSS VSS gf180mcu_as_sc_mcu7t3v3__fillcap_4
XFILLER_41_120 VDD VDD VSS VSS gf180mcu_as_sc_mcu7t3v3__fillcap_16
XFILLER_76_1568 VDD VDD VSS VSS gf180mcu_as_sc_mcu7t3v3__fill_1
XFILLER_187_648 VDD VDD VSS VSS gf180mcu_as_sc_mcu7t3v3__fillcap_16
XFILLER_202_457 VDD VDD VSS VSS gf180mcu_as_sc_mcu7t3v3__fillcap_16
XFILLER_39_1390 VDD VDD VSS VSS gf180mcu_as_sc_mcu7t3v3__fillcap_4
XFILLER_41_142 VDD VDD VSS VSS gf180mcu_as_sc_mcu7t3v3__fill_2
XFILLER_23_890 VDD VDD VSS VSS gf180mcu_as_sc_mcu7t3v3__fillcap_4
XPHY_EDGE_ROW_172_3_Left_557 VDD VSS gf180mcu_as_sc_mcu7t3v3__tap_2
XFILLER_41_72 VDD VDD VSS VSS gf180mcu_as_sc_mcu7t3v3__fillcap_16
Xclkbuf_leaf_21_clk_regs VDD VDD VSS VSS clkbuf_3_5__f_clk_regs/Y _5262_/CLK gf180mcu_as_sc_mcu7t3v3__clkbuff_12
XFILLER_157_72 VDD VDD VSS VSS gf180mcu_as_sc_mcu7t3v3__fillcap_16
XTAP_TAPCELL_ROW_188_2314 VDD VSS gf180mcu_as_sc_mcu7t3v3__tap_2
XTAP_TAPCELL_ROW_188_2303 VDD VSS gf180mcu_as_sc_mcu7t3v3__tap_2
XFILLER_9_1119 VDD VDD VSS VSS gf180mcu_as_sc_mcu7t3v3__fill_1
XPHY_EDGE_ROW_93_3_Right_130 VDD VSS gf180mcu_as_sc_mcu7t3v3__tap_2
XFILLER_46_1383 VDD VDD VSS VSS gf180mcu_as_sc_mcu7t3v3__fill_2
XFILLER_49_220 VDD VDD VSS VSS gf180mcu_as_sc_mcu7t3v3__fill_2
XFILLER_133_1364 VDD VDD VSS VSS gf180mcu_as_sc_mcu7t3v3__fillcap_16
XFILLER_64_201 VDD VDD VSS VSS gf180mcu_as_sc_mcu7t3v3__fillcap_4
XFILLER_66_80 VDD VDD VSS VSS gf180mcu_as_sc_mcu7t3v3__fillcap_4
XTAP_TAPCELL_ROW_0_709 VDD VSS gf180mcu_as_sc_mcu7t3v3__tap_2
XFILLER_209_1402 VDD VDD VSS VSS gf180mcu_as_sc_mcu7t3v3__fillcap_16
X_4930_ VDD VDD VSS VSS clkload8/A _4930_/D _4930_/Q gf180mcu_as_sc_mcu7t3v3__dfxtp_2
XFILLER_206_785 VDD VDD VSS VSS gf180mcu_as_sc_mcu7t3v3__fillcap_16
X_4861_ VDD VDD VSS VSS _5142_/CLK _4861_/D _4861_/Q gf180mcu_as_sc_mcu7t3v3__dfxtp_2
XFILLER_177_136 VDD VDD VSS VSS gf180mcu_as_sc_mcu7t3v3__fillcap_4
XFILLER_21_816 VDD VDD VSS VSS gf180mcu_as_sc_mcu7t3v3__fill_2
XFILLER_32_164 VDD VDD VSS VSS gf180mcu_as_sc_mcu7t3v3__fillcap_8
X_3812_ VDD VDD VSS VSS _3812_/B _3812_/A _3931_/A gf180mcu_as_sc_mcu7t3v3__and2_2
XANTENNA_16 VDD VDD VSS VSS _4924_/D gf180mcu_as_sc_mcu7t3v3__diode_2
XANTENNA_27 VDD VDD VSS VSS _4915_/D gf180mcu_as_sc_mcu7t3v3__diode_2
XFILLER_177_158 VDD VDD VSS VSS gf180mcu_as_sc_mcu7t3v3__fillcap_8
XFILLER_207_1170 VDD VDD VSS VSS gf180mcu_as_sc_mcu7t3v3__fillcap_16
XFILLER_207_1192 VDD VDD VSS VSS gf180mcu_as_sc_mcu7t3v3__fillcap_16
XFILLER_53_1354 VDD VDD VSS VSS gf180mcu_as_sc_mcu7t3v3__fill_1
X_4792_ VDD VDD VSS VSS _4869_/CLK _4792_/D _4792_/Q gf180mcu_as_sc_mcu7t3v3__dfxtp_2
XFILLER_118_203 VDD VDD VSS VSS gf180mcu_as_sc_mcu7t3v3__fillcap_16
X_3743_ VDD VDD VSS VSS _3744_/C _4118_/A _3761_/B _3743_/C gf180mcu_as_sc_mcu7t3v3__ao21_2
XFILLER_140_1379 VDD VDD VSS VSS gf180mcu_as_sc_mcu7t3v3__fill_2
XFILLER_192_139 VDD VDD VSS VSS gf180mcu_as_sc_mcu7t3v3__fillcap_16
X_3674_ VDD VDD VSS VSS _4046_/A _3725_/B _3674_/C _3674_/D _3675_/D gf180mcu_as_sc_mcu7t3v3__ao211_2
XFILLER_12_1062 VDD VDD VSS VSS gf180mcu_as_sc_mcu7t3v3__fillcap_8
XFILLER_133_206 VDD VDD VSS VSS gf180mcu_as_sc_mcu7t3v3__fillcap_4
X_2625_ VDD VDD VSS VSS _2852_/B _5127_/Q _5191_/Q _2626_/B gf180mcu_as_sc_mcu7t3v3__mux2_2
XFILLER_177_1280 VDD VDD VSS VSS gf180mcu_as_sc_mcu7t3v3__fillcap_16
XFILLER_99_142 VDD VDD VSS VSS gf180mcu_as_sc_mcu7t3v3__fillcap_4
XPHY_EDGE_ROW_10_Left_221 VDD VSS gf180mcu_as_sc_mcu7t3v3__tap_2
X_2556_ VDD VDD VSS VSS _4956_/Q _4754_/Q _2556_/B _4705_/A _2558_/C gf180mcu_as_sc_mcu7t3v3__ao31_2
X_5275_ VDD VDD VSS VSS _5278_/CLK _5275_/D _5275_/Q gf180mcu_as_sc_mcu7t3v3__dfxtp_2
X_2487_ VDD VDD VSS VSS _2558_/A _2747_/B _2840_/A _2806_/D _2534_/B gf180mcu_as_sc_mcu7t3v3__ao31_2
XFILLER_64_1494 VDD VDD VSS VSS gf180mcu_as_sc_mcu7t3v3__fillcap_16
X_4226_ VDD VDD VSS VSS _4255_/B _4227_/B _4227_/C _5062_/Q _5062_/D gf180mcu_as_sc_mcu7t3v3__ao22_2
XFILLER_101_169 VDD VDD VSS VSS gf180mcu_as_sc_mcu7t3v3__fillcap_4
XFILLER_151_1464 VDD VDD VSS VSS gf180mcu_as_sc_mcu7t3v3__fillcap_16
XTAP_TAPCELL_ROW_116_3_3070 VDD VSS gf180mcu_as_sc_mcu7t3v3__tap_2
XTAP_TAPCELL_ROW_13_1012 VDD VSS gf180mcu_as_sc_mcu7t3v3__tap_2
XTAP_TAPCELL_ROW_13_1023 VDD VSS gf180mcu_as_sc_mcu7t3v3__tap_2
X_4157_ VDD VDD VSS VSS _4157_/B _4165_/A _4256_/B gf180mcu_as_sc_mcu7t3v3__and2_2
XFILLER_55_212 VDD VDD VSS VSS gf180mcu_as_sc_mcu7t3v3__fillcap_4
XFILLER_99_1568 VDD VDD VSS VSS gf180mcu_as_sc_mcu7t3v3__fill_1
X_3108_ VDD VDD VSS VSS _3115_/B _3163_/B _4089_/A gf180mcu_as_sc_mcu7t3v3__nand2_2
X_4088_ VDD VDD VSS VSS _4088_/A _4130_/B _4128_/B _4088_/D _4089_/D gf180mcu_as_sc_mcu7t3v3__ao22_2
XTAP_TAPCELL_ROW_30_1381 VDD VSS gf180mcu_as_sc_mcu7t3v3__tap_2
XFILLER_102_34 VDD VDD VSS VSS gf180mcu_as_sc_mcu7t3v3__fill_1
X_3039_ VDD VDD VSS VSS _3040_/C _3039_/C _3125_/C _4016_/D gf180mcu_as_sc_mcu7t3v3__aoi21_2
XTAP_TAPCELL_ROW_30_1392 VDD VSS gf180mcu_as_sc_mcu7t3v3__tap_2
XFILLER_12_827 VDD VDD VSS VSS gf180mcu_as_sc_mcu7t3v3__fillcap_16
XFILLER_19_1238 VDD VDD VSS VSS gf180mcu_as_sc_mcu7t3v3__fillcap_8
XFILLER_23_142 VDD VDD VSS VSS gf180mcu_as_sc_mcu7t3v3__fillcap_16
XFILLER_11_348 VDD VDD VSS VSS gf180mcu_as_sc_mcu7t3v3__fill_2
XFILLER_184_618 VDD VDD VSS VSS gf180mcu_as_sc_mcu7t3v3__fill_2
XFILLER_196_445 VDD VDD VSS VSS gf180mcu_as_sc_mcu7t3v3__fill_1
XFILLER_36_1563 VDD VDD VSS VSS gf180mcu_as_sc_mcu7t3v3__fill_1
XFILLER_196_489 VDD VDD VSS VSS gf180mcu_as_sc_mcu7t3v3__fillcap_16
XFILLER_123_1566 VDD VDD VSS VSS gf180mcu_as_sc_mcu7t3v3__fill_2
XFILLER_178_1011 VDD VDD VSS VSS gf180mcu_as_sc_mcu7t3v3__fillcap_4
XFILLER_178_1033 VDD VDD VSS VSS gf180mcu_as_sc_mcu7t3v3__fillcap_16
XFILLER_180_802 VDD VDD VSS VSS gf180mcu_as_sc_mcu7t3v3__fill_2
XFILLER_194_37 VDD VDD VSS VSS gf180mcu_as_sc_mcu7t3v3__fillcap_16
XPHY_EDGE_ROW_156_1_Right_677 VDD VSS gf180mcu_as_sc_mcu7t3v3__tap_2
XFILLER_195_1380 VDD VDD VSS VSS gf180mcu_as_sc_mcu7t3v3__fillcap_16
XFILLER_156_1364 VDD VDD VSS VSS gf180mcu_as_sc_mcu7t3v3__fillcap_16
XFILLER_87_68 VDD VDD VSS VSS gf180mcu_as_sc_mcu7t3v3__fill_2
XTAP_TAPCELL_ROW_183_2200 VDD VSS gf180mcu_as_sc_mcu7t3v3__tap_2
XFILLER_117_1348 VDD VDD VSS VSS gf180mcu_as_sc_mcu7t3v3__fillcap_16
XFILLER_28_1080 VDD VDD VSS VSS gf180mcu_as_sc_mcu7t3v3__fillcap_4
XTAP_TAPCELL_ROW_7_875 VDD VSS gf180mcu_as_sc_mcu7t3v3__tap_2
XTAP_TAPCELL_ROW_7_886 VDD VSS gf180mcu_as_sc_mcu7t3v3__tap_2
XFILLER_19_415 VDD VDD VSS VSS gf180mcu_as_sc_mcu7t3v3__fillcap_4
XPHY_EDGE_ROW_132_3_Right_169 VDD VSS gf180mcu_as_sc_mcu7t3v3__tap_2
XFILLER_61_204 VDD VDD VSS VSS gf180mcu_as_sc_mcu7t3v3__fillcap_4
XFILLER_15_632 VDD VDD VSS VSS gf180mcu_as_sc_mcu7t3v3__fillcap_16
XFILLER_27_492 VDD VDD VSS VSS gf180mcu_as_sc_mcu7t3v3__fillcap_4
XTAP_TAPCELL_ROW_129_1_1831 VDD VSS gf180mcu_as_sc_mcu7t3v3__tap_2
XFILLER_203_766 VDD VDD VSS VSS gf180mcu_as_sc_mcu7t3v3__fillcap_4
XTAP_TAPCELL_ROW_177_2059 VDD VSS gf180mcu_as_sc_mcu7t3v3__tap_2
XFILLER_159_169 VDD VDD VSS VSS gf180mcu_as_sc_mcu7t3v3__fillcap_16
XFILLER_188_979 VDD VDD VSS VSS gf180mcu_as_sc_mcu7t3v3__fillcap_16
XFILLER_203_788 VDD VDD VSS VSS gf180mcu_as_sc_mcu7t3v3__fillcap_16
XFILLER_30_635 VDD VDD VSS VSS gf180mcu_as_sc_mcu7t3v3__fill_2
XFILLER_187_489 VDD VDD VSS VSS gf180mcu_as_sc_mcu7t3v3__fill_1
XFILLER_168_93 VDD VDD VSS VSS gf180mcu_as_sc_mcu7t3v3__fill_1
XFILLER_7_842 VDD VDD VSS VSS gf180mcu_as_sc_mcu7t3v3__fillcap_16
Xinput14 VDD VDD VSS VSS boot_data[2] _2700_/A gf180mcu_as_sc_mcu7t3v3__buff_12
Xinput25 VDD VDD VSS VSS dft_addr[2] _2629_/B gf180mcu_as_sc_mcu7t3v3__buff_12
Xinput36 VDD VDD VSS VSS dft_wdata[1] _2693_/B gf180mcu_as_sc_mcu7t3v3__buff_12
XFILLER_13_1360 VDD VDD VSS VSS gf180mcu_as_sc_mcu7t3v3__fillcap_8
XTAP_TAPCELL_ROW_109_1_1773 VDD VSS gf180mcu_as_sc_mcu7t3v3__tap_2
Xinput47 VDD VDD VSS VSS east_in[12] _4030_/D gf180mcu_as_sc_mcu7t3v3__buff_12
Xinput58 VDD VDD VSS VSS east_in[22] wire848/A gf180mcu_as_sc_mcu7t3v3__buff_12
Xinput69 VDD VDD VSS VSS east_in[32] wire838/A gf180mcu_as_sc_mcu7t3v3__buff_12
XFILLER_87_1450 VDD VDD VSS VSS gf180mcu_as_sc_mcu7t3v3__fillcap_4
X_2410_ VDD VDD VSS VSS _4370_/A _5161_/Q gf180mcu_as_sc_mcu7t3v3__inv_2
X_3390_ VDD VDD VSS VSS _4038_/A _3467_/C _3445_/C _4041_/A _3391_/C gf180mcu_as_sc_mcu7t3v3__ao22_2
XFILLER_135_1415 VDD VDD VSS VSS gf180mcu_as_sc_mcu7t3v3__fill_1
XFILLER_174_1464 VDD VDD VSS VSS gf180mcu_as_sc_mcu7t3v3__fillcap_4
XFILLER_83_1358 VDD VDD VSS VSS gf180mcu_as_sc_mcu7t3v3__fill_1
XFILLER_96_123 VDD VDD VSS VSS gf180mcu_as_sc_mcu7t3v3__fillcap_16
XFILLER_96_145 VDD VDD VSS VSS gf180mcu_as_sc_mcu7t3v3__fill_1
XPHY_EDGE_ROW_94_3_Right_131 VDD VSS gf180mcu_as_sc_mcu7t3v3__tap_2
X_5060_ VDD VDD VSS VSS _5090_/CLK _5060_/D _5060_/Q gf180mcu_as_sc_mcu7t3v3__dfxtp_2
X_4011_ VDD VDD VSS VSS _4011_/B _4107_/A _4238_/B gf180mcu_as_sc_mcu7t3v3__and2_2
XFILLER_37_212 VDD VDD VSS VSS gf180mcu_as_sc_mcu7t3v3__fillcap_8
XTAP_TAPCELL_ROW_86_3_2980 VDD VSS gf180mcu_as_sc_mcu7t3v3__tap_2
XFILLER_0_1425 VDD VDD VSS VSS gf180mcu_as_sc_mcu7t3v3__fill_2
XFILLER_203_66 VDD VDD VSS VSS gf180mcu_as_sc_mcu7t3v3__fillcap_4
XFILLER_203_88 VDD VDD VSS VSS gf180mcu_as_sc_mcu7t3v3__fillcap_16
XFILLER_20_1364 VDD VDD VSS VSS gf180mcu_as_sc_mcu7t3v3__fill_1
XFILLER_25_418 VDD VDD VSS VSS gf180mcu_as_sc_mcu7t3v3__fill_2
XFILLER_181_1402 VDD VDD VSS VSS gf180mcu_as_sc_mcu7t3v3__fillcap_16
XFILLER_34_941 VDD VDD VSS VSS gf180mcu_as_sc_mcu7t3v3__fillcap_4
XFILLER_34_963 VDD VDD VSS VSS gf180mcu_as_sc_mcu7t3v3__fillcap_8
X_4913_ VDD VDD VSS VSS _4946_/CLK _4913_/D _4913_/Q gf180mcu_as_sc_mcu7t3v3__dfxtp_2
XFILLER_33_440 VDD VDD VSS VSS gf180mcu_as_sc_mcu7t3v3__fill_2
XFILLER_20_101 VDD VDD VSS VSS gf180mcu_as_sc_mcu7t3v3__fillcap_4
XFILLER_20_123 VDD VDD VSS VSS gf180mcu_as_sc_mcu7t3v3__fillcap_8
X_4844_ VDD VDD VSS VSS _5241_/CLK _4844_/D _4844_/Q gf180mcu_as_sc_mcu7t3v3__dfxtp_2
XFILLER_14_1124 VDD VDD VSS VSS gf180mcu_as_sc_mcu7t3v3__fill_2
XFILLER_165_106 VDD VDD VSS VSS gf180mcu_as_sc_mcu7t3v3__fillcap_16
X_4775_ VDD VDD VSS VSS _5142_/CLK _4775_/D _4775_/Q gf180mcu_as_sc_mcu7t3v3__dfxtp_2
XFILLER_14_1146 VDD VDD VSS VSS gf180mcu_as_sc_mcu7t3v3__fillcap_8
XFILLER_14_1157 VDD VDD VSS VSS gf180mcu_as_sc_mcu7t3v3__fillcap_16
X_3726_ VDD VDD VSS VSS _3730_/B _3726_/C _3726_/B _4104_/A gf180mcu_as_sc_mcu7t3v3__aoi21_2
XFILLER_174_673 VDD VDD VSS VSS gf180mcu_as_sc_mcu7t3v3__fillcap_4
XTAP_TAPCELL_ROW_155_1_1910 VDD VSS gf180mcu_as_sc_mcu7t3v3__tap_2
XFILLER_66_1501 VDD VDD VSS VSS gf180mcu_as_sc_mcu7t3v3__fillcap_4
X_3657_ VDD VDD VSS VSS _4030_/A _3725_/B _3657_/C _3657_/D _3658_/C gf180mcu_as_sc_mcu7t3v3__ao211_2
XTAP_TAPCELL_ROW_167_3_3222 VDD VSS gf180mcu_as_sc_mcu7t3v3__tap_2
XFILLER_164_18 VDD VDD VSS VSS gf180mcu_as_sc_mcu7t3v3__fillcap_16
X_3588_ VDD VDD VSS VSS _3656_/C _3958_/A _3590_/C gf180mcu_as_sc_mcu7t3v3__and2_2
X_2608_ VDD VDD VSS VSS _4262_/B _2608_/B _5099_/Q _2609_/B gf180mcu_as_sc_mcu7t3v3__mux2_2
XFILLER_121_209 VDD VDD VSS VSS gf180mcu_as_sc_mcu7t3v3__fill_1
XFILLER_27_1507 VDD VDD VSS VSS gf180mcu_as_sc_mcu7t3v3__fillcap_16
X_2539_ VDD VDD VSS VSS _4366_/S _2539_/B _2539_/A _4372_/D gf180mcu_as_sc_mcu7t3v3__mux2_2
XFILLER_25_1242 VDD VDD VSS VSS gf180mcu_as_sc_mcu7t3v3__fill_1
XFILLER_29_702 VDD VDD VSS VSS gf180mcu_as_sc_mcu7t3v3__fillcap_16
XFILLER_87_167 VDD VDD VSS VSS gf180mcu_as_sc_mcu7t3v3__fillcap_16
XFILLER_9_1461 VDD VDD VSS VSS gf180mcu_as_sc_mcu7t3v3__fillcap_8
XFILLER_9_1472 VDD VDD VSS VSS gf180mcu_as_sc_mcu7t3v3__fill_2
X_5258_ VDD VDD VSS VSS _5262_/CLK _5258_/D _5258_/Q gf180mcu_as_sc_mcu7t3v3__dfxtp_2
XTAP_TAPCELL_ROW_4_823 VDD VSS gf180mcu_as_sc_mcu7t3v3__tap_2
XTAP_TAPCELL_ROW_4_812 VDD VSS gf180mcu_as_sc_mcu7t3v3__tap_2
XTAP_TAPCELL_ROW_32_1432 VDD VSS gf180mcu_as_sc_mcu7t3v3__tap_2
XFILLER_113_22 VDD VDD VSS VSS gf180mcu_as_sc_mcu7t3v3__fill_2
XFILLER_5_1325 VDD VDD VSS VSS gf180mcu_as_sc_mcu7t3v3__fillcap_4
XFILLER_5_1336 VDD VDD VSS VSS gf180mcu_as_sc_mcu7t3v3__fill_1
X_5189_ VDD VDD VSS VSS _5192_/CLK _5189_/D _5189_/Q gf180mcu_as_sc_mcu7t3v3__dfxtp_2
X_4209_ VDD VDD VSS VSS _4238_/B _4222_/B _4222_/C _5045_/Q _5045_/D gf180mcu_as_sc_mcu7t3v3__ao22_2
XTAP_TAPCELL_ROW_32_1443 VDD VSS gf180mcu_as_sc_mcu7t3v3__tap_2
XFILLER_186_1313 VDD VDD VSS VSS gf180mcu_as_sc_mcu7t3v3__fillcap_16
XFILLER_113_88 VDD VDD VSS VSS gf180mcu_as_sc_mcu7t3v3__fillcap_4
XFILLER_188_209 VDD VDD VSS VSS gf180mcu_as_sc_mcu7t3v3__fillcap_16
XFILLER_184_1081 VDD VDD VSS VSS gf180mcu_as_sc_mcu7t3v3__fillcap_4
XFILLER_19_1035 VDD VDD VSS VSS gf180mcu_as_sc_mcu7t3v3__fillcap_8
XFILLER_19_1068 VDD VDD VSS VSS gf180mcu_as_sc_mcu7t3v3__fillcap_16
XFILLER_200_769 VDD VDD VSS VSS gf180mcu_as_sc_mcu7t3v3__fillcap_16
XFILLER_193_960 VDD VDD VSS VSS gf180mcu_as_sc_mcu7t3v3__fillcap_16
XFILLER_193_982 VDD VDD VSS VSS gf180mcu_as_sc_mcu7t3v3__fillcap_16
XFILLER_22_85 VDD VDD VSS VSS gf180mcu_as_sc_mcu7t3v3__fill_2
XFILLER_164_172 VDD VDD VSS VSS gf180mcu_as_sc_mcu7t3v3__fill_2
XFILLER_98_34 VDD VDD VSS VSS gf180mcu_as_sc_mcu7t3v3__fill_1
XFILLER_180_643 VDD VDD VSS VSS gf180mcu_as_sc_mcu7t3v3__fill_1
XPHY_EDGE_ROW_157_1_Right_678 VDD VSS gf180mcu_as_sc_mcu7t3v3__tap_2
XPHY_EDGE_ROW_43_3_Right_80 VDD VSS gf180mcu_as_sc_mcu7t3v3__tap_2
XFILLER_191_1030 VDD VDD VSS VSS gf180mcu_as_sc_mcu7t3v3__fillcap_16
XFILLER_78_101 VDD VDD VSS VSS gf180mcu_as_sc_mcu7t3v3__fillcap_4
XFILLER_191_1052 VDD VDD VSS VSS gf180mcu_as_sc_mcu7t3v3__fillcap_16
XFILLER_26_1017 VDD VDD VSS VSS gf180mcu_as_sc_mcu7t3v3__fillcap_8
XFILLER_19_212 VDD VDD VSS VSS gf180mcu_as_sc_mcu7t3v3__fillcap_16
XFILLER_43_1364 VDD VDD VSS VSS gf180mcu_as_sc_mcu7t3v3__fillcap_16
XFILLER_93_137 VDD VDD VSS VSS gf180mcu_as_sc_mcu7t3v3__fill_2
XFILLER_169_1533 VDD VDD VSS VSS gf180mcu_as_sc_mcu7t3v3__fillcap_16
XFILLER_78_1416 VDD VDD VSS VSS gf180mcu_as_sc_mcu7t3v3__fill_1
XFILLER_169_1555 VDD VDD VSS VSS gf180mcu_as_sc_mcu7t3v3__fill_1
XFILLER_169_1566 VDD VDD VSS VSS gf180mcu_as_sc_mcu7t3v3__fill_2
XFILLER_207_368 VDD VDD VSS VSS gf180mcu_as_sc_mcu7t3v3__fill_2
XFILLER_78_1427 VDD VDD VSS VSS gf180mcu_as_sc_mcu7t3v3__fillcap_16
XTAP_TAPCELL_ROW_204_2667 VDD VSS gf180mcu_as_sc_mcu7t3v3__tap_2
XTAP_TAPCELL_ROW_204_2656 VDD VSS gf180mcu_as_sc_mcu7t3v3__tap_2
XFILLER_179_209 VDD VDD VSS VSS gf180mcu_as_sc_mcu7t3v3__fill_1
XFILLER_15_484 VDD VDD VSS VSS gf180mcu_as_sc_mcu7t3v3__fillcap_4
X_2890_ VDD VDD VSS VSS _3533_/B _3508_/A _3517_/A gf180mcu_as_sc_mcu7t3v3__nor2_2
XTAP_TAPCELL_ROW_196_2479 VDD VSS gf180mcu_as_sc_mcu7t3v3__tap_2
XFILLER_30_443 VDD VDD VSS VSS gf180mcu_as_sc_mcu7t3v3__fillcap_8
XFILLER_30_465 VDD VDD VSS VSS gf180mcu_as_sc_mcu7t3v3__fillcap_4
XFILLER_204_1151 VDD VDD VSS VSS gf180mcu_as_sc_mcu7t3v3__fillcap_4
XFILLER_204_1173 VDD VDD VSS VSS gf180mcu_as_sc_mcu7t3v3__fillcap_16
XFILLER_30_498 VDD VDD VSS VSS gf180mcu_as_sc_mcu7t3v3__fillcap_16
XFILLER_54_1493 VDD VDD VSS VSS gf180mcu_as_sc_mcu7t3v3__fillcap_16
X_4560_ VDD VDD VSS VSS _4561_/D _4560_/B _4561_/A gf180mcu_as_sc_mcu7t3v3__nor2_2
XFILLER_102_1469 VDD VDD VSS VSS gf180mcu_as_sc_mcu7t3v3__fillcap_16
XFILLER_176_1515 VDD VDD VSS VSS gf180mcu_as_sc_mcu7t3v3__fill_1
XFILLER_183_492 VDD VDD VSS VSS gf180mcu_as_sc_mcu7t3v3__fillcap_4
XFILLER_190_429 VDD VDD VSS VSS gf180mcu_as_sc_mcu7t3v3__fill_1
Xwire592 VDD VDD VSS VSS _3182_/B _3073_/B gf180mcu_as_sc_mcu7t3v3__clkbuff_12
X_4491_ VDD VDD VSS VSS _4491_/D _4502_/A _4491_/B _4491_/C _4492_/B gf180mcu_as_sc_mcu7t3v3__ao31_2
X_3511_ VDD VDD VSS VSS _3511_/A _3520_/B _3511_/C _3511_/D _3512_/C gf180mcu_as_sc_mcu7t3v3__ao211_2
XFILLER_155_194 VDD VDD VSS VSS gf180mcu_as_sc_mcu7t3v3__fill_2
XFILLER_170_131 VDD VDD VSS VSS gf180mcu_as_sc_mcu7t3v3__fillcap_4
XFILLER_6_193 VDD VDD VSS VSS gf180mcu_as_sc_mcu7t3v3__fill_2
X_3442_ VDD VDD VSS VSS _3442_/B _4096_/A _3443_/D gf180mcu_as_sc_mcu7t3v3__or2_2
X_3373_ VDD VDD VSS VSS _3381_/S _4021_/A _3373_/A _3375_/B gf180mcu_as_sc_mcu7t3v3__mux2_2
XFILLER_111_220 VDD VDD VSS VSS gf180mcu_as_sc_mcu7t3v3__fill_2
XFILLER_174_1294 VDD VDD VSS VSS gf180mcu_as_sc_mcu7t3v3__fillcap_16
X_5112_ VDD VDD VSS VSS _5280_/CLK _5112_/D _5112_/Q gf180mcu_as_sc_mcu7t3v3__dfxtp_2
XFILLER_61_1475 VDD VDD VSS VSS gf180mcu_as_sc_mcu7t3v3__fill_1
XPHY_EDGE_ROW_95_3_Right_132 VDD VSS gf180mcu_as_sc_mcu7t3v3__tap_2
X_5043_ VDD VDD VSS VSS _5085_/CLK _5043_/D _5043_/Q gf180mcu_as_sc_mcu7t3v3__dfxtp_2
XPHY_EDGE_ROW_119_1_Right_640 VDD VSS gf180mcu_as_sc_mcu7t3v3__tap_2
XFILLER_20_1161 VDD VDD VSS VSS gf180mcu_as_sc_mcu7t3v3__fill_2
XFILLER_179_765 VDD VDD VSS VSS gf180mcu_as_sc_mcu7t3v3__fillcap_4
XFILLER_22_944 VDD VDD VSS VSS gf180mcu_as_sc_mcu7t3v3__fill_1
XFILLER_16_1219 VDD VDD VSS VSS gf180mcu_as_sc_mcu7t3v3__fillcap_4
XFILLER_178_253 VDD VDD VSS VSS gf180mcu_as_sc_mcu7t3v3__fill_1
XFILLER_21_454 VDD VDD VSS VSS gf180mcu_as_sc_mcu7t3v3__fillcap_8
X_4827_ VDD VDD VSS VSS _4919_/CLK _4827_/D _4827_/Q gf180mcu_as_sc_mcu7t3v3__dfxtp_2
XFILLER_138_139 VDD VDD VSS VSS gf180mcu_as_sc_mcu7t3v3__fillcap_16
XFILLER_193_212 VDD VDD VSS VSS gf180mcu_as_sc_mcu7t3v3__fillcap_16
XFILLER_193_234 VDD VDD VSS VSS gf180mcu_as_sc_mcu7t3v3__fill_1
XFILLER_21_487 VDD VDD VSS VSS gf180mcu_as_sc_mcu7t3v3__fill_2
XTAP_TAPCELL_ROW_25_1280 VDD VSS gf180mcu_as_sc_mcu7t3v3__tap_2
XFILLER_175_982 VDD VDD VSS VSS gf180mcu_as_sc_mcu7t3v3__fillcap_16
XFILLER_193_278 VDD VDD VSS VSS gf180mcu_as_sc_mcu7t3v3__fill_2
X_4758_ VDD VDD VSS VSS _5285_/CLK _4758_/D _4758_/Q gf180mcu_as_sc_mcu7t3v3__dfxtp_2
XTAP_TAPCELL_ROW_25_1291 VDD VSS gf180mcu_as_sc_mcu7t3v3__tap_2
XFILLER_190_941 VDD VDD VSS VSS gf180mcu_as_sc_mcu7t3v3__fillcap_4
X_4689_ VDD VDD VSS VSS _4723_/A _4719_/A _4703_/D _4749_/B _4690_/C gf180mcu_as_sc_mcu7t3v3__ao31_2
X_3709_ VDD VDD VSS VSS _3710_/C _4085_/D _3751_/B _3709_/C gf180mcu_as_sc_mcu7t3v3__ao21_2
XTAP_TAPCELL_ROW_80_1_1686 VDD VSS gf180mcu_as_sc_mcu7t3v3__tap_2
XTAP_TAPCELL_ROW_21_1188 VDD VSS gf180mcu_as_sc_mcu7t3v3__tap_2
XFILLER_175_1014 VDD VDD VSS VSS gf180mcu_as_sc_mcu7t3v3__fillcap_16
XFILLER_190_963 VDD VDD VSS VSS gf180mcu_as_sc_mcu7t3v3__fillcap_16
XTAP_TAPCELL_ROW_9_926 VDD VSS gf180mcu_as_sc_mcu7t3v3__tap_2
XTAP_TAPCELL_ROW_21_1199 VDD VSS gf180mcu_as_sc_mcu7t3v3__tap_2
XFILLER_161_164 VDD VDD VSS VSS gf180mcu_as_sc_mcu7t3v3__fillcap_16
XTAP_TAPCELL_ROW_9_937 VDD VSS gf180mcu_as_sc_mcu7t3v3__tap_2
XFILLER_0_314 VDD VDD VSS VSS gf180mcu_as_sc_mcu7t3v3__fill_1
XFILLER_192_1361 VDD VDD VSS VSS gf180mcu_as_sc_mcu7t3v3__fillcap_4
XFILLER_192_1383 VDD VDD VSS VSS gf180mcu_as_sc_mcu7t3v3__fillcap_4
XFILLER_27_1326 VDD VDD VSS VSS gf180mcu_as_sc_mcu7t3v3__fillcap_4
XFILLER_68_37 VDD VDD VSS VSS gf180mcu_as_sc_mcu7t3v3__fillcap_16
XFILLER_27_1348 VDD VDD VSS VSS gf180mcu_as_sc_mcu7t3v3__fillcap_16
Xinput204 VDD VDD VSS VSS se_in[30] _3802_/A gf180mcu_as_sc_mcu7t3v3__buff_12
Xinput215 VDD VDD VSS VSS south_in[0] _3933_/D gf180mcu_as_sc_mcu7t3v3__buff_12
Xinput226 VDD VDD VSS VSS south_in[1] _3941_/A gf180mcu_as_sc_mcu7t3v3__buff_12
XFILLER_40_1515 VDD VDD VSS VSS gf180mcu_as_sc_mcu7t3v3__fillcap_4
XFILLER_5_1111 VDD VDD VSS VSS gf180mcu_as_sc_mcu7t3v3__fillcap_8
XFILLER_5_1122 VDD VDD VSS VSS gf180mcu_as_sc_mcu7t3v3__fillcap_16
XFILLER_75_104 VDD VDD VSS VSS gf180mcu_as_sc_mcu7t3v3__fillcap_4
Xinput237 VDD VDD VSS VSS south_in[2] _3949_/A gf180mcu_as_sc_mcu7t3v3__buff_12
Xinput248 VDD VDD VSS VSS south_in[9] _4007_/A gf180mcu_as_sc_mcu7t3v3__buff_12
Xinput259 VDD VDD VSS VSS sw_in[19] _2441_/A gf180mcu_as_sc_mcu7t3v3__buff_12
XTAP_TAPCELL_ROW_37_1_2828 VDD VSS gf180mcu_as_sc_mcu7t3v3__tap_2
XFILLER_5_1188 VDD VDD VSS VSS gf180mcu_as_sc_mcu7t3v3__fill_2
XFILLER_90_107 VDD VDD VSS VSS gf180mcu_as_sc_mcu7t3v3__fillcap_16
XFILLER_204_349 VDD VDD VSS VSS gf180mcu_as_sc_mcu7t3v3__fillcap_16
XFILLER_38_1422 VDD VDD VSS VSS gf180mcu_as_sc_mcu7t3v3__fill_2
X_4901__1066 VDD VDD VSS VSS _4901_/D gf180mcu_as_sc_mcu7t3v3__tiel_4
XFILLER_169_220 VDD VDD VSS VSS gf180mcu_as_sc_mcu7t3v3__fill_2
XFILLER_197_540 VDD VDD VSS VSS gf180mcu_as_sc_mcu7t3v3__fillcap_16
XTAP_TAPCELL_ROW_174_2007 VDD VSS gf180mcu_as_sc_mcu7t3v3__tap_2
XFILLER_12_443 VDD VDD VSS VSS gf180mcu_as_sc_mcu7t3v3__fill_1
XFILLER_185_702 VDD VDD VSS VSS gf180mcu_as_sc_mcu7t3v3__fillcap_16
XFILLER_197_562 VDD VDD VSS VSS gf180mcu_as_sc_mcu7t3v3__fillcap_16
XFILLER_199_1504 VDD VDD VSS VSS gf180mcu_as_sc_mcu7t3v3__fillcap_16
XFILLER_129_139 VDD VDD VSS VSS gf180mcu_as_sc_mcu7t3v3__fill_1
XFILLER_12_476 VDD VDD VSS VSS gf180mcu_as_sc_mcu7t3v3__fillcap_4
XFILLER_184_234 VDD VDD VSS VSS gf180mcu_as_sc_mcu7t3v3__fill_1
XFILLER_149_84 VDD VDD VSS VSS gf180mcu_as_sc_mcu7t3v3__fill_2
XTAP_TAPCELL_ROW_191_2376 VDD VSS gf180mcu_as_sc_mcu7t3v3__tap_2
XTAP_TAPCELL_ROW_191_2365 VDD VSS gf180mcu_as_sc_mcu7t3v3__tap_2
XFILLER_10_1330 VDD VDD VSS VSS gf180mcu_as_sc_mcu7t3v3__fillcap_8
XFILLER_10_1352 VDD VDD VSS VSS gf180mcu_as_sc_mcu7t3v3__fillcap_8
XFILLER_197_1294 VDD VDD VSS VSS gf180mcu_as_sc_mcu7t3v3__fillcap_16
XFILLER_84_1431 VDD VDD VSS VSS gf180mcu_as_sc_mcu7t3v3__fillcap_16
XPHY_EDGE_ROW_158_1_Right_679 VDD VSS gf180mcu_as_sc_mcu7t3v3__tap_2
XFILLER_165_83 VDD VDD VSS VSS gf180mcu_as_sc_mcu7t3v3__fillcap_16
XFILLER_84_1453 VDD VDD VSS VSS gf180mcu_as_sc_mcu7t3v3__fillcap_16
XFILLER_0_881 VDD VDD VSS VSS gf180mcu_as_sc_mcu7t3v3__fill_2
XFILLER_66_104 VDD VDD VSS VSS gf180mcu_as_sc_mcu7t3v3__fill_1
XTAP_TAPCELL_ROW_206_2707 VDD VSS gf180mcu_as_sc_mcu7t3v3__tap_2
XFILLER_66_148 VDD VDD VSS VSS gf180mcu_as_sc_mcu7t3v3__fill_2
XFILLER_81_118 VDD VDD VSS VSS gf180mcu_as_sc_mcu7t3v3__fillcap_8
XFILLER_208_699 VDD VDD VSS VSS gf180mcu_as_sc_mcu7t3v3__fillcap_16
XFILLER_35_524 VDD VDD VSS VSS gf180mcu_as_sc_mcu7t3v3__fillcap_4
XFILLER_35_557 VDD VDD VSS VSS gf180mcu_as_sc_mcu7t3v3__fill_2
XFILLER_74_181 VDD VDD VSS VSS gf180mcu_as_sc_mcu7t3v3__fill_2
XTAP_TAPCELL_ROW_198_2519 VDD VSS gf180mcu_as_sc_mcu7t3v3__tap_2
X_3991_ VDD VDD VSS VSS _3991_/A _4030_/C _3991_/C _3991_/D _3993_/C gf180mcu_as_sc_mcu7t3v3__ao211_2
XFILLER_200_34 VDD VDD VSS VSS gf180mcu_as_sc_mcu7t3v3__fill_1
XFILLER_210_308 VDD VDD VSS VSS gf180mcu_as_sc_mcu7t3v3__fillcap_4
XTAP_TAPCELL_ROW_110_3_3051 VDD VSS gf180mcu_as_sc_mcu7t3v3__tap_2
X_2942_ VDD VDD VSS VSS _3526_/B _3817_/C _3817_/A gf180mcu_as_sc_mcu7t3v3__nor2b_2
XFILLER_30_240 VDD VDD VSS VSS gf180mcu_as_sc_mcu7t3v3__fillcap_4
XFILLER_104_1509 VDD VDD VSS VSS gf180mcu_as_sc_mcu7t3v3__fillcap_8
XFILLER_143_1558 VDD VDD VSS VSS gf180mcu_as_sc_mcu7t3v3__fillcap_8
XFILLER_15_1230 VDD VDD VSS VSS gf180mcu_as_sc_mcu7t3v3__fill_2
XFILLER_175_212 VDD VDD VSS VSS gf180mcu_as_sc_mcu7t3v3__fillcap_4
XFILLER_30_251 VDD VDD VSS VSS gf180mcu_as_sc_mcu7t3v3__fill_2
XFILLER_88_2 VDD VDD VSS VSS gf180mcu_as_sc_mcu7t3v3__fill_2
X_2873_ VDD VDD VSS VSS _4263_/A _4742_/A _2873_/C _2873_/D _4767_/D gf180mcu_as_sc_mcu7t3v3__ao22_2
X_4612_ VDD VDD VSS VSS _5206_/Q _4622_/B _4622_/C _5207_/Q _5206_/D gf180mcu_as_sc_mcu7t3v3__ao22_2
XFILLER_11_1138 VDD VDD VSS VSS gf180mcu_as_sc_mcu7t3v3__fillcap_16
X_4543_ VDD VDD VSS VSS _4546_/C _4996_/Q _4586_/S gf180mcu_as_sc_mcu7t3v3__nand2b_2
XFILLER_143_142 VDD VDD VSS VSS gf180mcu_as_sc_mcu7t3v3__fillcap_16
XFILLER_176_1367 VDD VDD VSS VSS gf180mcu_as_sc_mcu7t3v3__fillcap_16
X_4474_ VDD VDD VSS VSS _4509_/S _5017_/Q _5046_/Q _4475_/B gf180mcu_as_sc_mcu7t3v3__mux2_2
XFILLER_63_1504 VDD VDD VSS VSS gf180mcu_as_sc_mcu7t3v3__fillcap_16
X_3425_ VDD VDD VSS VSS _4933_/Q _3486_/B _3465_/C _4079_/A _3426_/C gf180mcu_as_sc_mcu7t3v3__ao22_2
XFILLER_38_18 VDD VDD VSS VSS gf180mcu_as_sc_mcu7t3v3__fillcap_16
Xsram2048.u_bank0 _2672_/Y _2668_/Y _2664_/Y _2657_/Y _2650_/Y _2641_/Y _2629_/Y _2610_/Y
+ _2604_/Y hold1109/Y clkbuf_1_0__f_clk/Y _2737_/Y _2730_/Y _2723_/Y _2716_/Y _2709_/Y
+ _2702_/Y _2693_/Y _2686_/Y _2832_/Y _2744_/A _2743_/A _2742_/A _2741_/A _2740_/A
+ _2739_/A _2738_/A _2478_/A VDD VSS sram2048.u_bank0/WEN[7] sram2048.u_bank0/WEN[6]
+ sram2048.u_bank0/WEN[5] sram2048.u_bank0/WEN[4] sram2048.u_bank0/WEN[3] sram2048.u_bank0/WEN[2]
+ sram2048.u_bank0/WEN[1] sram2048.u_bank0/WEN[0] _2676_/Y gf180mcu_ocd_ip_sram__sram1024x8m8wm1
X_3356_ VDD VDD VSS VSS _4006_/A _3451_/B _3356_/C _3356_/D _3357_/A gf180mcu_as_sc_mcu7t3v3__ao211_2
XFILLER_57_115 VDD VDD VSS VSS gf180mcu_as_sc_mcu7t3v3__fillcap_16
Xhold1103 VDD VDD VSS VSS _2585_/Y _2586_/A gf180mcu_as_sc_mcu7t3v3__clkbuff_4
Xhold1114 VDD VDD VSS VSS hold1141/Y _4960_/D gf180mcu_as_sc_mcu7t3v3__clkbuff_4
X_3287_ VDD VDD VSS VSS _3926_/A _3382_/B _3382_/C _3934_/A _3288_/C gf180mcu_as_sc_mcu7t3v3__ao22_2
XPHY_EDGE_ROW_96_3_Right_133 VDD VSS gf180mcu_as_sc_mcu7t3v3__tap_2
X_5026_ VDD VDD VSS VSS _5085_/CLK _5026_/D _5026_/Q gf180mcu_as_sc_mcu7t3v3__dfxtp_2
Xhold1125 VDD VDD VSS VSS _4973_/Q _4972_/D gf180mcu_as_sc_mcu7t3v3__clkbuff_4
Xhold1136 VDD VDD VSS VSS _2587_/Y hold1136/Y gf180mcu_as_sc_mcu7t3v3__clkbuff_4
Xhold1147 VDD VDD VSS VSS _4958_/Q hold1147/Y gf180mcu_as_sc_mcu7t3v3__clkbuff_4
XTAP_TAPCELL_ROW_54_3_2882 VDD VSS gf180mcu_as_sc_mcu7t3v3__tap_2
XFILLER_113_1373 VDD VDD VSS VSS gf180mcu_as_sc_mcu7t3v3__fill_2
XFILLER_72_107 VDD VDD VSS VSS gf180mcu_as_sc_mcu7t3v3__fillcap_8
XFILLER_26_524 VDD VDD VSS VSS gf180mcu_as_sc_mcu7t3v3__fill_1
XFILLER_0_1085 VDD VDD VSS VSS gf180mcu_as_sc_mcu7t3v3__fill_2
XFILLER_0_1096 VDD VDD VSS VSS gf180mcu_as_sc_mcu7t3v3__fill_1
XTAP_TAPCELL_ROW_27_1331 VDD VSS gf180mcu_as_sc_mcu7t3v3__tap_2
XTAP_TAPCELL_ROW_27_1320 VDD VSS gf180mcu_as_sc_mcu7t3v3__tap_2
XFILLER_179_551 VDD VDD VSS VSS gf180mcu_as_sc_mcu7t3v3__fill_2
XFILLER_179_562 VDD VDD VSS VSS gf180mcu_as_sc_mcu7t3v3__fill_2
XFILLER_179_584 VDD VDD VSS VSS gf180mcu_as_sc_mcu7t3v3__fill_2
XFILLER_70_1519 VDD VDD VSS VSS gf180mcu_as_sc_mcu7t3v3__fill_2
XFILLER_181_1084 VDD VDD VSS VSS gf180mcu_as_sc_mcu7t3v3__fillcap_16
XFILLER_194_521 VDD VDD VSS VSS gf180mcu_as_sc_mcu7t3v3__fillcap_4
XFILLER_194_543 VDD VDD VSS VSS gf180mcu_as_sc_mcu7t3v3__fillcap_16
XFILLER_22_785 VDD VDD VSS VSS gf180mcu_as_sc_mcu7t3v3__fillcap_16
XFILLER_70_27 VDD VDD VSS VSS gf180mcu_as_sc_mcu7t3v3__fillcap_8
XTAP_TAPCELL_ROW_23_1239 VDD VSS gf180mcu_as_sc_mcu7t3v3__tap_2
XTAP_TAPCELL_ROW_23_1228 VDD VSS gf180mcu_as_sc_mcu7t3v3__tap_2
XFILLER_10_947 VDD VDD VSS VSS gf180mcu_as_sc_mcu7t3v3__fill_1
XFILLER_119_150 VDD VDD VSS VSS gf180mcu_as_sc_mcu7t3v3__fill_2
XFILLER_119_43 VDD VDD VSS VSS gf180mcu_as_sc_mcu7t3v3__fillcap_8
XPHY_EDGE_ROW_2_Left_213 VDD VSS gf180mcu_as_sc_mcu7t3v3__tap_2
XFILLER_102_4 VDD VDD VSS VSS gf180mcu_as_sc_mcu7t3v3__fill_1
XFILLER_155_1418 VDD VDD VSS VSS gf180mcu_as_sc_mcu7t3v3__fillcap_16
XFILLER_0_144 VDD VDD VSS VSS gf180mcu_as_sc_mcu7t3v3__fill_1
XFILLER_27_1189 VDD VDD VSS VSS gf180mcu_as_sc_mcu7t3v3__fill_1
XFILLER_48_104 VDD VDD VSS VSS gf180mcu_as_sc_mcu7t3v3__fill_1
XTAP_TAPCELL_ROW_103_1_1754 VDD VSS gf180mcu_as_sc_mcu7t3v3__tap_2
XFILLER_188_1205 VDD VDD VSS VSS gf180mcu_as_sc_mcu7t3v3__fillcap_16
XFILLER_188_1227 VDD VDD VSS VSS gf180mcu_as_sc_mcu7t3v3__fillcap_16
XPHY_EDGE_ROW_176_Right_39 VDD VSS gf180mcu_as_sc_mcu7t3v3__tap_2
XTAP_TAPCELL_ROW_115_3_3066 VDD VSS gf180mcu_as_sc_mcu7t3v3__tap_2
XFILLER_29_384 VDD VDD VSS VSS gf180mcu_as_sc_mcu7t3v3__fillcap_4
XFILLER_79_1566 VDD VDD VSS VSS gf180mcu_as_sc_mcu7t3v3__fill_2
XTAP_TAPCELL_ROW_201_2604 VDD VSS gf180mcu_as_sc_mcu7t3v3__tap_2
XFILLER_32_505 VDD VDD VSS VSS gf180mcu_as_sc_mcu7t3v3__fillcap_16
XFILLER_32_527 VDD VDD VSS VSS gf180mcu_as_sc_mcu7t3v3__fillcap_16
XFILLER_71_162 VDD VDD VSS VSS gf180mcu_as_sc_mcu7t3v3__fill_2
XFILLER_198_871 VDD VDD VSS VSS gf180mcu_as_sc_mcu7t3v3__fillcap_4
XFILLER_207_1566 VDD VDD VSS VSS gf180mcu_as_sc_mcu7t3v3__fill_2
XTAP_TAPCELL_ROW_193_2427 VDD VSS gf180mcu_as_sc_mcu7t3v3__tap_2
XTAP_TAPCELL_ROW_193_2416 VDD VSS gf180mcu_as_sc_mcu7t3v3__tap_2
XFILLER_12_240 VDD VDD VSS VSS gf180mcu_as_sc_mcu7t3v3__fillcap_4
XFILLER_13_796 VDD VDD VSS VSS gf180mcu_as_sc_mcu7t3v3__fillcap_4
XFILLER_157_212 VDD VDD VSS VSS gf180mcu_as_sc_mcu7t3v3__fillcap_8
XFILLER_197_392 VDD VDD VSS VSS gf180mcu_as_sc_mcu7t3v3__fill_1
XFILLER_198_893 VDD VDD VSS VSS gf180mcu_as_sc_mcu7t3v3__fillcap_16
XFILLER_201_842 VDD VDD VSS VSS gf180mcu_as_sc_mcu7t3v3__fillcap_16
XFILLER_9_734 VDD VDD VSS VSS gf180mcu_as_sc_mcu7t3v3__fillcap_8
XTAP_TAPCELL_ROW_80_3_2961 VDD VSS gf180mcu_as_sc_mcu7t3v3__tap_2
XFILLER_103_1520 VDD VDD VSS VSS gf180mcu_as_sc_mcu7t3v3__fillcap_8
XFILLER_12_295 VDD VDD VSS VSS gf180mcu_as_sc_mcu7t3v3__fillcap_16
XFILLER_51_1452 VDD VDD VSS VSS gf180mcu_as_sc_mcu7t3v3__fillcap_16
XFILLER_8_244 VDD VDD VSS VSS gf180mcu_as_sc_mcu7t3v3__fill_1
XPHY_EDGE_ROW_185_Right_48 VDD VSS gf180mcu_as_sc_mcu7t3v3__tap_2
XFILLER_201_1154 VDD VDD VSS VSS gf180mcu_as_sc_mcu7t3v3__fillcap_16
XFILLER_51_1485 VDD VDD VSS VSS gf180mcu_as_sc_mcu7t3v3__fill_1
XFILLER_51_1496 VDD VDD VSS VSS gf180mcu_as_sc_mcu7t3v3__fillcap_4
XFILLER_60_71 VDD VDD VSS VSS gf180mcu_as_sc_mcu7t3v3__fill_1
XTAP_TAPCELL_ROW_11_964 VDD VSS gf180mcu_as_sc_mcu7t3v3__tap_2
XTAP_TAPCELL_ROW_11_975 VDD VSS gf180mcu_as_sc_mcu7t3v3__tap_2
XTAP_TAPCELL_ROW_49_1_1591 VDD VSS gf180mcu_as_sc_mcu7t3v3__tap_2
XFILLER_125_142 VDD VDD VSS VSS gf180mcu_as_sc_mcu7t3v3__fillcap_16
XFILLER_140_123 VDD VDD VSS VSS gf180mcu_as_sc_mcu7t3v3__fillcap_16
XFILLER_180_281 VDD VDD VSS VSS gf180mcu_as_sc_mcu7t3v3__fill_1
XFILLER_5_66 VDD VDD VSS VSS gf180mcu_as_sc_mcu7t3v3__fillcap_4
XFILLER_5_88 VDD VDD VSS VSS gf180mcu_as_sc_mcu7t3v3__fillcap_16
XTAP_TAPCELL_ROW_59_3_2897 VDD VSS gf180mcu_as_sc_mcu7t3v3__tap_2
X_4190_ VDD VDD VSS VSS _4250_/B _4197_/B _4197_/C _5028_/Q _5028_/D gf180mcu_as_sc_mcu7t3v3__ao22_2
X_3210_ VDD VDD VSS VSS _3210_/B _3535_/A _3213_/B gf180mcu_as_sc_mcu7t3v3__or2_2
XPHY_EDGE_ROW_194_Right_57 VDD VSS gf180mcu_as_sc_mcu7t3v3__tap_2
X_3141_ VDD VDD VSS VSS _4793_/D _3141_/C _3141_/B _4115_/A gf180mcu_as_sc_mcu7t3v3__aoi21_2
XFILLER_23_1521 VDD VDD VSS VSS gf180mcu_as_sc_mcu7t3v3__fillcap_16
XTAP_TAPCELL_ROW_161_3_3203 VDD VSS gf180mcu_as_sc_mcu7t3v3__tap_2
XFILLER_36_822 VDD VDD VSS VSS gf180mcu_as_sc_mcu7t3v3__fill_2
XFILLER_54_118 VDD VDD VSS VSS gf180mcu_as_sc_mcu7t3v3__fillcap_8
X_3072_ VDD VDD VSS VSS _3073_/B _3072_/B _3072_/C _3073_/C gf180mcu_as_sc_mcu7t3v3__nor3_2
XFILLER_208_452 VDD VDD VSS VSS gf180mcu_as_sc_mcu7t3v3__fill_2
XFILLER_110_1568 VDD VDD VSS VSS gf180mcu_as_sc_mcu7t3v3__fill_1
XFILLER_62_151 VDD VDD VSS VSS gf180mcu_as_sc_mcu7t3v3__fill_2
XPHY_EDGE_ROW_40_1_Left_250 VDD VSS gf180mcu_as_sc_mcu7t3v3__tap_2
XFILLER_1_1394 VDD VDD VSS VSS gf180mcu_as_sc_mcu7t3v3__fillcap_4
XFILLER_35_387 VDD VDD VSS VSS gf180mcu_as_sc_mcu7t3v3__fillcap_16
XFILLER_16_590 VDD VDD VSS VSS gf180mcu_as_sc_mcu7t3v3__fillcap_4
XFILLER_17_1303 VDD VDD VSS VSS gf180mcu_as_sc_mcu7t3v3__fillcap_4
XTAP_TAPCELL_ROW_141_3_3145 VDD VSS gf180mcu_as_sc_mcu7t3v3__tap_2
X_3974_ VDD VDD VSS VSS _3974_/A _4023_/B _4023_/C _4920_/Q _3975_/D gf180mcu_as_sc_mcu7t3v3__ao22_2
XFILLER_108_1453 VDD VDD VSS VSS gf180mcu_as_sc_mcu7t3v3__fillcap_16
XFILLER_182_1393 VDD VDD VSS VSS gf180mcu_as_sc_mcu7t3v3__fillcap_16
XFILLER_203_190 VDD VDD VSS VSS gf180mcu_as_sc_mcu7t3v3__fillcap_16
XFILLER_206_1065 VDD VDD VSS VSS gf180mcu_as_sc_mcu7t3v3__fillcap_16
XFILLER_210_138 VDD VDD VSS VSS gf180mcu_as_sc_mcu7t3v3__fillcap_4
X_2925_ VDD VDD VSS VSS _3266_/B _3530_/B _3530_/A gf180mcu_as_sc_mcu7t3v3__nor2b_2
XFILLER_206_1087 VDD VDD VSS VSS gf180mcu_as_sc_mcu7t3v3__fillcap_16
XFILLER_31_582 VDD VDD VSS VSS gf180mcu_as_sc_mcu7t3v3__fill_2
X_2856_ VDD VDD VSS VSS _4733_/B _2856_/A _2856_/B _4746_/C gf180mcu_as_sc_mcu7t3v3__ao21_2
XFILLER_191_524 VDD VDD VSS VSS gf180mcu_as_sc_mcu7t3v3__fillcap_16
X_2787_ VDD VDD VSS VSS _5126_/Q _4590_/A _5173_/Q _2789_/B gf180mcu_as_sc_mcu7t3v3__mux2_2
XTAP_TAPCELL_ROW_108_1_1769 VDD VSS gf180mcu_as_sc_mcu7t3v3__tap_2
X_4526_ VDD VDD VSS VSS _4529_/C _4994_/Q _4527_/S gf180mcu_as_sc_mcu7t3v3__nand2b_2
X_4457_ VDD VDD VSS VSS _4458_/D _4457_/B _4538_/A gf180mcu_as_sc_mcu7t3v3__nor2_2
Xfanout702 VDD VDD VSS VSS _3724_/C _3648_/C gf180mcu_as_sc_mcu7t3v3__buff_12
Xfanout713 VDD VDD VSS VSS _3268_/Y _3465_/C gf180mcu_as_sc_mcu7t3v3__buff_12
Xfanout724 VDD VDD VSS VSS _3448_/B _3402_/B gf180mcu_as_sc_mcu7t3v3__buff_12
X_3408_ VDD VDD VSS VSS _3684_/A _3408_/B _3408_/C _4820_/D _3615_/D gf180mcu_as_sc_mcu7t3v3__aoi211_2
XFILLER_115_1413 VDD VDD VSS VSS gf180mcu_as_sc_mcu7t3v3__fill_2
XFILLER_63_1356 VDD VDD VSS VSS gf180mcu_as_sc_mcu7t3v3__fillcap_4
Xfanout735 VDD VDD VSS VSS _3121_/B _3236_/B gf180mcu_as_sc_mcu7t3v3__buff_12
Xfanout746 VDD VDD VSS VSS _4640_/S _4642_/S gf180mcu_as_sc_mcu7t3v3__buff_12
Xfanout757 VDD VDD VSS VSS _2894_/Y _3143_/S gf180mcu_as_sc_mcu7t3v3__buff_12
X_4388_ VDD VDD VSS VSS _4388_/B _4497_/A _4389_/D gf180mcu_as_sc_mcu7t3v3__and2_2
XTAP_TAPCELL_ROW_75_1_1670 VDD VSS gf180mcu_as_sc_mcu7t3v3__tap_2
Xfanout768 VDD VDD VSS VSS _4273_/S _4267_/S gf180mcu_as_sc_mcu7t3v3__buff_12
Xfanout779 VDD VDD VSS VSS _5225_/Q _4684_/A gf180mcu_as_sc_mcu7t3v3__buff_12
X_3339_ VDD VDD VSS VSS _3340_/A _3989_/A _3404_/B _3339_/C gf180mcu_as_sc_mcu7t3v3__ao21_2
XTAP_TAPCELL_ROW_16_1087 VDD VSS gf180mcu_as_sc_mcu7t3v3__tap_2
XTAP_TAPCELL_ROW_16_1076 VDD VSS gf180mcu_as_sc_mcu7t3v3__tap_2
XFILLER_27_811 VDD VDD VSS VSS gf180mcu_as_sc_mcu7t3v3__fillcap_16
XFILLER_6_1261 VDD VDD VSS VSS gf180mcu_as_sc_mcu7t3v3__fill_1
XFILLER_6_1272 VDD VDD VSS VSS gf180mcu_as_sc_mcu7t3v3__fill_2
XFILLER_2_1125 VDD VDD VSS VSS gf180mcu_as_sc_mcu7t3v3__fillcap_4
XPHY_EDGE_ROW_97_3_Right_134 VDD VSS gf180mcu_as_sc_mcu7t3v3__tap_2
X_5009_ VDD VDD VSS VSS clkload5/A _5009_/D _5009_/Q gf180mcu_as_sc_mcu7t3v3__dfxtp_2
XTAP_TAPCELL_ROW_85_3_2976 VDD VSS gf180mcu_as_sc_mcu7t3v3__tap_2
XFILLER_14_505 VDD VDD VSS VSS gf180mcu_as_sc_mcu7t3v3__fillcap_16
XFILLER_198_101 VDD VDD VSS VSS gf180mcu_as_sc_mcu7t3v3__fillcap_4
XFILLER_27_866 VDD VDD VSS VSS gf180mcu_as_sc_mcu7t3v3__fillcap_4
XFILLER_27_888 VDD VDD VSS VSS gf180mcu_as_sc_mcu7t3v3__fillcap_16
XFILLER_121_66 VDD VDD VSS VSS gf180mcu_as_sc_mcu7t3v3__fillcap_4
XFILLER_14_527 VDD VDD VSS VSS gf180mcu_as_sc_mcu7t3v3__fillcap_8
XFILLER_198_123 VDD VDD VSS VSS gf180mcu_as_sc_mcu7t3v3__fillcap_16
XFILLER_26_387 VDD VDD VSS VSS gf180mcu_as_sc_mcu7t3v3__fillcap_16
XFILLER_121_88 VDD VDD VSS VSS gf180mcu_as_sc_mcu7t3v3__fillcap_16
XFILLER_74_1463 VDD VDD VSS VSS gf180mcu_as_sc_mcu7t3v3__fill_1
XFILLER_139_212 VDD VDD VSS VSS gf180mcu_as_sc_mcu7t3v3__fillcap_8
XFILLER_14_53 VDD VDD VSS VSS gf180mcu_as_sc_mcu7t3v3__fillcap_16
XFILLER_10_733 VDD VDD VSS VSS gf180mcu_as_sc_mcu7t3v3__fill_2
XFILLER_122_1406 VDD VDD VSS VSS gf180mcu_as_sc_mcu7t3v3__fill_2
XFILLER_161_1466 VDD VDD VSS VSS gf180mcu_as_sc_mcu7t3v3__fillcap_8
XFILLER_161_1488 VDD VDD VSS VSS gf180mcu_as_sc_mcu7t3v3__fill_2
XFILLER_195_874 VDD VDD VSS VSS gf180mcu_as_sc_mcu7t3v3__fillcap_16
XFILLER_210_650 VDD VDD VSS VSS gf180mcu_as_sc_mcu7t3v3__fill_1
XFILLER_182_524 VDD VDD VSS VSS gf180mcu_as_sc_mcu7t3v3__fill_1
XFILLER_196_1507 VDD VDD VSS VSS gf180mcu_as_sc_mcu7t3v3__fillcap_16
XFILLER_202_1485 VDD VDD VSS VSS gf180mcu_as_sc_mcu7t3v3__fillcap_16
XFILLER_107_142 VDD VDD VSS VSS gf180mcu_as_sc_mcu7t3v3__fill_2
XFILLER_146_41 VDD VDD VSS VSS gf180mcu_as_sc_mcu7t3v3__fill_2
XFILLER_205_2 VDD VDD VSS VSS gf180mcu_as_sc_mcu7t3v3__fillcap_16
XTAP_TAPCELL_ROW_154_1_1906 VDD VSS gf180mcu_as_sc_mcu7t3v3__tap_2
XTAP_TAPCELL_ROW_166_3_3218 VDD VSS gf180mcu_as_sc_mcu7t3v3__tap_2
XFILLER_122_123 VDD VDD VSS VSS gf180mcu_as_sc_mcu7t3v3__fillcap_16
XFILLER_194_1275 VDD VDD VSS VSS gf180mcu_as_sc_mcu7t3v3__fillcap_16
XFILLER_194_1297 VDD VDD VSS VSS gf180mcu_as_sc_mcu7t3v3__fillcap_16
XFILLER_122_167 VDD VDD VSS VSS gf180mcu_as_sc_mcu7t3v3__fillcap_8
XTAP_TAPCELL_ROW_186_2275 VDD VSS gf180mcu_as_sc_mcu7t3v3__tap_2
XTAP_TAPCELL_ROW_186_2264 VDD VSS gf180mcu_as_sc_mcu7t3v3__tap_2
XFILLER_133_1568 VDD VDD VSS VSS gf180mcu_as_sc_mcu7t3v3__fill_1
XFILLER_39_61 VDD VDD VSS VSS gf180mcu_as_sc_mcu7t3v3__fillcap_8
XFILLER_39_72 VDD VDD VSS VSS gf180mcu_as_sc_mcu7t3v3__fillcap_16
XFILLER_76_221 VDD VDD VSS VSS gf180mcu_as_sc_mcu7t3v3__fill_1
XFILLER_7_1047 VDD VDD VSS VSS gf180mcu_as_sc_mcu7t3v3__fill_2
XTAP_TAPCELL_ROW_134_1_1848 VDD VSS gf180mcu_as_sc_mcu7t3v3__tap_2
XFILLER_205_400 VDD VDD VSS VSS gf180mcu_as_sc_mcu7t3v3__fillcap_16
XFILLER_205_422 VDD VDD VSS VSS gf180mcu_as_sc_mcu7t3v3__fillcap_16
XFILLER_29_192 VDD VDD VSS VSS gf180mcu_as_sc_mcu7t3v3__fillcap_16
XFILLER_79_1352 VDD VDD VSS VSS gf180mcu_as_sc_mcu7t3v3__fill_2
XFILLER_32_302 VDD VDD VSS VSS gf180mcu_as_sc_mcu7t3v3__fill_2
XFILLER_44_173 VDD VDD VSS VSS gf180mcu_as_sc_mcu7t3v3__fill_2
XPHY_EDGE_ROW_144_3_Left_529 VDD VSS gf180mcu_as_sc_mcu7t3v3__tap_2
XFILLER_166_1377 VDD VDD VSS VSS gf180mcu_as_sc_mcu7t3v3__fillcap_4
XFILLER_189_156 VDD VDD VSS VSS gf180mcu_as_sc_mcu7t3v3__fill_1
XFILLER_44_195 VDD VDD VSS VSS gf180mcu_as_sc_mcu7t3v3__fillcap_16
XFILLER_13_593 VDD VDD VSS VSS gf180mcu_as_sc_mcu7t3v3__fill_2
XFILLER_185_340 VDD VDD VSS VSS gf180mcu_as_sc_mcu7t3v3__fill_2
XFILLER_207_1396 VDD VDD VSS VSS gf180mcu_as_sc_mcu7t3v3__fillcap_4
XFILLER_53_1558 VDD VDD VSS VSS gf180mcu_as_sc_mcu7t3v3__fillcap_8
X_2710_ VDD VDD VSS VSS _2731_/S _5177_/Q _5169_/Q _2714_/B gf180mcu_as_sc_mcu7t3v3__mux2_2
XFILLER_200_171 VDD VDD VSS VSS gf180mcu_as_sc_mcu7t3v3__fillcap_4
X_3690_ VDD VDD VSS VSS _3691_/C _3690_/C _3766_/B _4066_/A gf180mcu_as_sc_mcu7t3v3__aoi21_2
XFILLER_199_1186 VDD VDD VSS VSS gf180mcu_as_sc_mcu7t3v3__fillcap_4
XFILLER_200_193 VDD VDD VSS VSS gf180mcu_as_sc_mcu7t3v3__fillcap_16
X_2641_ VDD VDD VSS VSS _2668_/B _2641_/B _2641_/A _2641_/Y gf180mcu_as_sc_mcu7t3v3__mux2_2
X_2572_ VDD VDD VSS VSS _4350_/A _5156_/Q _5155_/Q gf180mcu_as_sc_mcu7t3v3__nor2_2
XFILLER_177_1484 VDD VDD VSS VSS gf180mcu_as_sc_mcu7t3v3__fill_1
Xoutput349 VDD VDD VSS VSS _4870_/Q east_out[31] gf180mcu_as_sc_mcu7t3v3__buff_12
Xoutput338 VDD VDD VSS VSS _4860_/Q east_out[21] gf180mcu_as_sc_mcu7t3v3__buff_12
Xoutput327 VDD VDD VSS VSS _4850_/Q east_out[11] gf180mcu_as_sc_mcu7t3v3__buff_12
X_4311_ VDD VDD VSS VSS _4314_/S _5141_/Q _5140_/Q _5140_/D gf180mcu_as_sc_mcu7t3v3__mux2_2
XFILLER_173_1348 VDD VDD VSS VSS gf180mcu_as_sc_mcu7t3v3__fillcap_16
X_4242_ VDD VDD VSS VSS _4257_/S _4242_/B _5078_/Q _5078_/D gf180mcu_as_sc_mcu7t3v3__mux2_2
XFILLER_113_167 VDD VDD VSS VSS gf180mcu_as_sc_mcu7t3v3__fillcap_4
XFILLER_113_189 VDD VDD VSS VSS gf180mcu_as_sc_mcu7t3v3__fill_1
XFILLER_210_1209 VDD VDD VSS VSS gf180mcu_as_sc_mcu7t3v3__fill_2
X_4173_ VDD VDD VSS VSS _4233_/B _4193_/B _4193_/C _5011_/Q _5011_/D gf180mcu_as_sc_mcu7t3v3__ao22_2
XFILLER_27_107 VDD VDD VSS VSS gf180mcu_as_sc_mcu7t3v3__fill_1
X_3124_ VDD VDD VSS VSS _3723_/A _3124_/B _3124_/C _4791_/D _3831_/A gf180mcu_as_sc_mcu7t3v3__aoi211_2
XFILLER_209_750 VDD VDD VSS VSS gf180mcu_as_sc_mcu7t3v3__fillcap_16
XFILLER_209_772 VDD VDD VSS VSS gf180mcu_as_sc_mcu7t3v3__fillcap_16
X_3055_ VDD VDD VSS VSS _4033_/A _3130_/B _3055_/C _3055_/D _3056_/C gf180mcu_as_sc_mcu7t3v3__ao22_2
XFILLER_36_641 VDD VDD VSS VSS gf180mcu_as_sc_mcu7t3v3__fillcap_4
XFILLER_149_1553 VDD VDD VSS VSS gf180mcu_as_sc_mcu7t3v3__fill_2
XFILLER_208_1116 VDD VDD VSS VSS gf180mcu_as_sc_mcu7t3v3__fillcap_4
XFILLER_58_1447 VDD VDD VSS VSS gf180mcu_as_sc_mcu7t3v3__fillcap_4
XFILLER_97_1496 VDD VDD VSS VSS gf180mcu_as_sc_mcu7t3v3__fillcap_8
XFILLER_17_1100 VDD VDD VSS VSS gf180mcu_as_sc_mcu7t3v3__fillcap_16
XFILLER_195_104 VDD VDD VSS VSS gf180mcu_as_sc_mcu7t3v3__fillcap_16
XFILLER_23_368 VDD VDD VSS VSS gf180mcu_as_sc_mcu7t3v3__fillcap_16
X_3957_ VDD VDD VSS VSS _3957_/A _4032_/B _4027_/B _3962_/C _3957_/D gf180mcu_as_sc_mcu7t3v3__aoi211_2
XPHY_EDGE_ROW_208_Left_418 VDD VSS gf180mcu_as_sc_mcu7t3v3__tap_2
Xclkbuf_0_clk_regs VDD VDD VSS VSS clkbuf_regs_0_clk/Y clkbuf_0_clk_regs/Y gf180mcu_as_sc_mcu7t3v3__clkbuff_12
X_2908_ VDD VDD VSS VSS _3245_/C _3534_/A _3202_/B gf180mcu_as_sc_mcu7t3v3__and2_2
XFILLER_17_1177 VDD VDD VSS VSS gf180mcu_as_sc_mcu7t3v3__fill_2
X_3888_ VDD VDD VSS VSS _3890_/B _5178_/Q _4928_/D gf180mcu_as_sc_mcu7t3v3__and2_2
XFILLER_192_855 VDD VDD VSS VSS gf180mcu_as_sc_mcu7t3v3__fillcap_16
XFILLER_30_1322 VDD VDD VSS VSS gf180mcu_as_sc_mcu7t3v3__fill_2
X_2839_ VDD VDD VSS VSS _2842_/B _2839_/B _2842_/D gf180mcu_as_sc_mcu7t3v3__nor2_2
XFILLER_121_1483 VDD VDD VSS VSS gf180mcu_as_sc_mcu7t3v3__fill_2
XFILLER_178_1259 VDD VDD VSS VSS gf180mcu_as_sc_mcu7t3v3__fillcap_16
XFILLER_192_877 VDD VDD VSS VSS gf180mcu_as_sc_mcu7t3v3__fillcap_16
XFILLER_104_101 VDD VDD VSS VSS gf180mcu_as_sc_mcu7t3v3__fillcap_4
XFILLER_2_206 VDD VDD VSS VSS gf180mcu_as_sc_mcu7t3v3__fillcap_8
XFILLER_65_1418 VDD VDD VSS VSS gf180mcu_as_sc_mcu7t3v3__fillcap_8
X_4509_ VDD VDD VSS VSS _4509_/S _5021_/Q _5050_/Q _4510_/B gf180mcu_as_sc_mcu7t3v3__mux2_2
XFILLER_104_123 VDD VDD VSS VSS gf180mcu_as_sc_mcu7t3v3__fillcap_8
XFILLER_156_1568 VDD VDD VSS VSS gf180mcu_as_sc_mcu7t3v3__fill_1
XTAP_TAPCELL_ROW_18_1127 VDD VSS gf180mcu_as_sc_mcu7t3v3__tap_2
XTAP_TAPCELL_ROW_18_1116 VDD VSS gf180mcu_as_sc_mcu7t3v3__tap_2
Xfanout521 VDD VDD VSS VSS _4158_/D _4166_/D gf180mcu_as_sc_mcu7t3v3__buff_12
Xfanout532 VDD VDD VSS VSS _3675_/B _3660_/B gf180mcu_as_sc_mcu7t3v3__buff_12
XFILLER_76_37 VDD VDD VSS VSS gf180mcu_as_sc_mcu7t3v3__fillcap_16
XFILLER_8_1345 VDD VDD VSS VSS gf180mcu_as_sc_mcu7t3v3__fillcap_16
XFILLER_8_1367 VDD VDD VSS VSS gf180mcu_as_sc_mcu7t3v3__fillcap_16
Xfanout543 VDD VDD VSS VSS _3476_/D _3455_/B gf180mcu_as_sc_mcu7t3v3__buff_12
Xfanout554 VDD VDD VSS VSS _4539_/B _4592_/B gf180mcu_as_sc_mcu7t3v3__buff_12
XFILLER_18_107 VDD VDD VSS VSS gf180mcu_as_sc_mcu7t3v3__fillcap_16
Xfanout576 VDD VDD VSS VSS _3514_/B _3453_/C gf180mcu_as_sc_mcu7t3v3__buff_12
Xfanout587 VDD VDD VSS VSS _3073_/B _3132_/B gf180mcu_as_sc_mcu7t3v3__buff_12
Xfanout598 VDD VDD VSS VSS _3919_/Y _4104_/B gf180mcu_as_sc_mcu7t3v3__buff_12
XTAP_TAPCELL_ROW_35_1496 VDD VSS gf180mcu_as_sc_mcu7t3v3__tap_2
XTAP_TAPCELL_ROW_181_2150 VDD VSS gf180mcu_as_sc_mcu7t3v3__tap_2
XFILLER_185_1208 VDD VDD VSS VSS gf180mcu_as_sc_mcu7t3v3__fillcap_16
Xmesh_tile_980 VDD VDD VSS VSS north_out[21] gf180mcu_as_sc_mcu7t3v3__tiel_4
XTAP_TAPCELL_ROW_181_2161 VDD VSS gf180mcu_as_sc_mcu7t3v3__tap_2
XPHY_EDGE_ROW_98_3_Right_135 VDD VSS gf180mcu_as_sc_mcu7t3v3__tap_2
Xmesh_tile_991 VDD VDD VSS VSS north_out[32] gf180mcu_as_sc_mcu7t3v3__tiel_4
XTAP_TAPCELL_ROW_2_784 VDD VSS gf180mcu_as_sc_mcu7t3v3__tap_2
XTAP_TAPCELL_ROW_2_773 VDD VSS gf180mcu_as_sc_mcu7t3v3__tap_2
XFILLER_15_836 VDD VDD VSS VSS gf180mcu_as_sc_mcu7t3v3__fillcap_4
XFILLER_27_696 VDD VDD VSS VSS gf180mcu_as_sc_mcu7t3v3__fillcap_4
XFILLER_202_403 VDD VDD VSS VSS gf180mcu_as_sc_mcu7t3v3__fillcap_16
XFILLER_30_828 VDD VDD VSS VSS gf180mcu_as_sc_mcu7t3v3__fill_1
Xwire900 VDD VDD VSS VSS _2851_/A wire900/Y gf180mcu_as_sc_mcu7t3v3__clkbuff_12
XFILLER_127_204 VDD VDD VSS VSS gf180mcu_as_sc_mcu7t3v3__fillcap_4
XFILLER_210_480 VDD VDD VSS VSS gf180mcu_as_sc_mcu7t3v3__fill_1
XFILLER_35_1299 VDD VDD VSS VSS gf180mcu_as_sc_mcu7t3v3__fillcap_16
XFILLER_6_534 VDD VDD VSS VSS gf180mcu_as_sc_mcu7t3v3__fillcap_4
XFILLER_100_1523 VDD VDD VSS VSS gf180mcu_as_sc_mcu7t3v3__fillcap_16
XTAP_TAPCELL_ROW_188_2304 VDD VSS gf180mcu_as_sc_mcu7t3v3__tap_2
XFILLER_182_398 VDD VDD VSS VSS gf180mcu_as_sc_mcu7t3v3__fillcap_4
XTAP_TAPCELL_ROW_188_2315 VDD VSS gf180mcu_as_sc_mcu7t3v3__tap_2
XFILLER_2_784 VDD VDD VSS VSS gf180mcu_as_sc_mcu7t3v3__fillcap_8
XFILLER_110_137 VDD VDD VSS VSS gf180mcu_as_sc_mcu7t3v3__fill_1
XFILLER_110_148 VDD VDD VSS VSS gf180mcu_as_sc_mcu7t3v3__fillcap_16
XFILLER_173_72 VDD VDD VSS VSS gf180mcu_as_sc_mcu7t3v3__fillcap_16
XFILLER_46_1395 VDD VDD VSS VSS gf180mcu_as_sc_mcu7t3v3__fill_1
XFILLER_18_663 VDD VDD VSS VSS gf180mcu_as_sc_mcu7t3v3__fill_2
XFILLER_206_731 VDD VDD VSS VSS gf180mcu_as_sc_mcu7t3v3__fillcap_4
XFILLER_206_753 VDD VDD VSS VSS gf180mcu_as_sc_mcu7t3v3__fillcap_16
XFILLER_32_132 VDD VDD VSS VSS gf180mcu_as_sc_mcu7t3v3__fillcap_16
XFILLER_33_644 VDD VDD VSS VSS gf180mcu_as_sc_mcu7t3v3__fillcap_4
X_4860_ VDD VDD VSS VSS _5256_/CLK _4860_/D _4860_/Q gf180mcu_as_sc_mcu7t3v3__dfxtp_2
XFILLER_177_104 VDD VDD VSS VSS gf180mcu_as_sc_mcu7t3v3__fillcap_16
XFILLER_178_649 VDD VDD VSS VSS gf180mcu_as_sc_mcu7t3v3__fill_2
XFILLER_21_828 VDD VDD VSS VSS gf180mcu_as_sc_mcu7t3v3__fillcap_8
XFILLER_57_1480 VDD VDD VSS VSS gf180mcu_as_sc_mcu7t3v3__fillcap_4
X_3811_ VDD VDD VSS VSS _3924_/A _3811_/B _3811_/A gf180mcu_as_sc_mcu7t3v3__nand2_2
XANTENNA_17 VDD VDD VSS VSS _3470_/C gf180mcu_as_sc_mcu7t3v3__diode_2
XANTENNA_28 VDD VDD VSS VSS _4919_/D gf180mcu_as_sc_mcu7t3v3__diode_2
XFILLER_144_1450 VDD VDD VSS VSS gf180mcu_as_sc_mcu7t3v3__fill_1
XFILLER_144_1461 VDD VDD VSS VSS gf180mcu_as_sc_mcu7t3v3__fill_2
XFILLER_33_699 VDD VDD VSS VSS gf180mcu_as_sc_mcu7t3v3__fill_1
X_4791_ VDD VDD VSS VSS _4869_/CLK _4791_/D _4791_/Q gf180mcu_as_sc_mcu7t3v3__dfxtp_2
XFILLER_105_1456 VDD VDD VSS VSS gf180mcu_as_sc_mcu7t3v3__fill_2
XFILLER_144_1494 VDD VDD VSS VSS gf180mcu_as_sc_mcu7t3v3__fill_2
XFILLER_174_800 VDD VDD VSS VSS gf180mcu_as_sc_mcu7t3v3__fillcap_16
XFILLER_192_107 VDD VDD VSS VSS gf180mcu_as_sc_mcu7t3v3__fillcap_16
XFILLER_201_480 VDD VDD VSS VSS gf180mcu_as_sc_mcu7t3v3__fillcap_8
XFILLER_203_1046 VDD VDD VSS VSS gf180mcu_as_sc_mcu7t3v3__fillcap_4
X_3742_ VDD VDD VSS VSS _4118_/D _3751_/B _3742_/C _3742_/D _3743_/C gf180mcu_as_sc_mcu7t3v3__ao211_2
XFILLER_203_1068 VDD VDD VSS VSS gf180mcu_as_sc_mcu7t3v3__fillcap_16
X_3673_ VDD VDD VSS VSS _4048_/A _3726_/B _3761_/B _4048_/D _3674_/D gf180mcu_as_sc_mcu7t3v3__ao22_2
X_2624_ VDD VDD VSS VSS _4975_/Q _2624_/B _2624_/C _2831_/A _2627_/C gf180mcu_as_sc_mcu7t3v3__ao211_2
X_2555_ VDD VDD VSS VSS _2558_/B _2558_/A _4294_/A gf180mcu_as_sc_mcu7t3v3__and2_2
XFILLER_25_1402 VDD VDD VSS VSS gf180mcu_as_sc_mcu7t3v3__fillcap_8
X_5274_ VDD VDD VSS VSS _5278_/CLK _5274_/D _5274_/Q gf180mcu_as_sc_mcu7t3v3__dfxtp_2
X_2486_ VDD VDD VSS VSS _2790_/C _2806_/D gf180mcu_as_sc_mcu7t3v3__inv_2
XFILLER_151_1432 VDD VDD VSS VSS gf180mcu_as_sc_mcu7t3v3__fillcap_16
X_4225_ VDD VDD VSS VSS _4254_/B _4227_/B _4227_/C _5061_/Q _5061_/D gf180mcu_as_sc_mcu7t3v3__ao22_2
XFILLER_210_1017 VDD VDD VSS VSS gf180mcu_as_sc_mcu7t3v3__fill_2
XFILLER_29_928 VDD VDD VSS VSS gf180mcu_as_sc_mcu7t3v3__fillcap_16
XFILLER_60_1348 VDD VDD VSS VSS gf180mcu_as_sc_mcu7t3v3__fillcap_16
XTAP_TAPCELL_ROW_13_1013 VDD VSS gf180mcu_as_sc_mcu7t3v3__tap_2
XTAP_TAPCELL_ROW_13_1024 VDD VSS gf180mcu_as_sc_mcu7t3v3__tap_2
X_4156_ VDD VDD VSS VSS _4164_/S _4156_/B _4156_/A _4157_/B gf180mcu_as_sc_mcu7t3v3__mux2_2
XFILLER_112_1449 VDD VDD VSS VSS gf180mcu_as_sc_mcu7t3v3__fill_2
XFILLER_99_1558 VDD VDD VSS VSS gf180mcu_as_sc_mcu7t3v3__fillcap_8
X_3107_ VDD VDD VSS VSS _4789_/D _3107_/C _3124_/B _4083_/A gf180mcu_as_sc_mcu7t3v3__aoi21_2
XFILLER_23_1192 VDD VDD VSS VSS gf180mcu_as_sc_mcu7t3v3__fill_1
X_4087_ VDD VDD VSS VSS _4087_/A _4129_/B _4129_/C _4934_/Q _4089_/C gf180mcu_as_sc_mcu7t3v3__ao22_2
XTAP_TAPCELL_ROW_30_1382 VDD VSS gf180mcu_as_sc_mcu7t3v3__tap_2
XFILLER_36_460 VDD VDD VSS VSS gf180mcu_as_sc_mcu7t3v3__fillcap_16
X_3038_ VDD VDD VSS VSS _4016_/A _3125_/B _3038_/C _3038_/D _3039_/C gf180mcu_as_sc_mcu7t3v3__ao22_2
XTAP_TAPCELL_ROW_30_1393 VDD VSS gf180mcu_as_sc_mcu7t3v3__tap_2
XFILLER_196_435 VDD VDD VSS VSS gf180mcu_as_sc_mcu7t3v3__fillcap_8
XFILLER_11_316 VDD VDD VSS VSS gf180mcu_as_sc_mcu7t3v3__fill_1
XFILLER_196_457 VDD VDD VSS VSS gf180mcu_as_sc_mcu7t3v3__fillcap_16
XFILLER_200_918 VDD VDD VSS VSS gf180mcu_as_sc_mcu7t3v3__fillcap_16
X_4989_ VDD VDD VSS VSS clkload1/A _4989_/D _4989_/Q gf180mcu_as_sc_mcu7t3v3__dfxtp_2
XFILLER_71_1466 VDD VDD VSS VSS gf180mcu_as_sc_mcu7t3v3__fillcap_16
XFILLER_71_1488 VDD VDD VSS VSS gf180mcu_as_sc_mcu7t3v3__fillcap_16
XFILLER_20_872 VDD VDD VSS VSS gf180mcu_as_sc_mcu7t3v3__fill_2
XFILLER_30_1141 VDD VDD VSS VSS gf180mcu_as_sc_mcu7t3v3__fill_1
XFILLER_191_162 VDD VDD VSS VSS gf180mcu_as_sc_mcu7t3v3__fill_1
XFILLER_30_1185 VDD VDD VSS VSS gf180mcu_as_sc_mcu7t3v3__fill_2
XFILLER_191_1256 VDD VDD VSS VSS gf180mcu_as_sc_mcu7t3v3__fillcap_4
Xdelaybuf_1_clk VDD VDD VSS VSS delaybuf_1_clk/A delaybuf_2_clk/A gf180mcu_as_sc_mcu7t3v3__clkbuff_12
XTAP_TAPCELL_ROW_183_2201 VDD VSS gf180mcu_as_sc_mcu7t3v3__tap_2
XFILLER_191_1278 VDD VDD VSS VSS gf180mcu_as_sc_mcu7t3v3__fillcap_16
XFILLER_43_1502 VDD VDD VSS VSS gf180mcu_as_sc_mcu7t3v3__fill_1
XTAP_TAPCELL_ROW_7_876 VDD VSS gf180mcu_as_sc_mcu7t3v3__tap_2
XFILLER_130_1516 VDD VDD VSS VSS gf180mcu_as_sc_mcu7t3v3__fillcap_4
XFILLER_43_1568 VDD VDD VSS VSS gf180mcu_as_sc_mcu7t3v3__fill_1
XTAP_TAPCELL_ROW_7_887 VDD VSS gf180mcu_as_sc_mcu7t3v3__tap_2
XFILLER_100_170 VDD VDD VSS VSS gf180mcu_as_sc_mcu7t3v3__fillcap_4
XFILLER_4_1017 VDD VDD VSS VSS gf180mcu_as_sc_mcu7t3v3__fillcap_8
XFILLER_35_909 VDD VDD VSS VSS gf180mcu_as_sc_mcu7t3v3__fill_1
XFILLER_15_611 VDD VDD VSS VSS gf180mcu_as_sc_mcu7t3v3__fillcap_16
XFILLER_167_1483 VDD VDD VSS VSS gf180mcu_as_sc_mcu7t3v3__fill_2
XFILLER_188_925 VDD VDD VSS VSS gf180mcu_as_sc_mcu7t3v3__fillcap_16
XPHY_EDGE_ROW_99_3_Right_136 VDD VSS gf180mcu_as_sc_mcu7t3v3__tap_2
XFILLER_128_1467 VDD VDD VSS VSS gf180mcu_as_sc_mcu7t3v3__fillcap_16
XFILLER_187_402 VDD VDD VSS VSS gf180mcu_as_sc_mcu7t3v3__fillcap_16
XFILLER_188_947 VDD VDD VSS VSS gf180mcu_as_sc_mcu7t3v3__fillcap_16
XFILLER_203_734 VDD VDD VSS VSS gf180mcu_as_sc_mcu7t3v3__fillcap_16
XTAP_TAPCELL_ROW_129_1_1832 VDD VSS gf180mcu_as_sc_mcu7t3v3__tap_2
XFILLER_159_137 VDD VDD VSS VSS gf180mcu_as_sc_mcu7t3v3__fill_2
XFILLER_175_608 VDD VDD VSS VSS gf180mcu_as_sc_mcu7t3v3__fillcap_16
XFILLER_187_468 VDD VDD VSS VSS gf180mcu_as_sc_mcu7t3v3__fillcap_8
XFILLER_35_1030 VDD VDD VSS VSS gf180mcu_as_sc_mcu7t3v3__fillcap_16
XFILLER_35_1052 VDD VDD VSS VSS gf180mcu_as_sc_mcu7t3v3__fillcap_16
XFILLER_11_872 VDD VDD VSS VSS gf180mcu_as_sc_mcu7t3v3__fillcap_16
Xinput15 VDD VDD VSS VSS boot_data[3] _2708_/A gf180mcu_as_sc_mcu7t3v3__buff_12
Xinput26 VDD VDD VSS VSS dft_addr[3] _2641_/B gf180mcu_as_sc_mcu7t3v3__buff_12
Xinput37 VDD VDD VSS VSS dft_wdata[2] _2702_/B gf180mcu_as_sc_mcu7t3v3__buff_12
XFILLER_183_663 VDD VDD VSS VSS gf180mcu_as_sc_mcu7t3v3__fillcap_8
XFILLER_204_1399 VDD VDD VSS VSS gf180mcu_as_sc_mcu7t3v3__fillcap_16
Xinput48 VDD VDD VSS VSS east_in[13] wire855/A gf180mcu_as_sc_mcu7t3v3__buff_12
Xinput59 VDD VDD VSS VSS east_in[23] wire847/A gf180mcu_as_sc_mcu7t3v3__buff_12
Xmax_cap529 VDD VDD VSS VSS _3775_/B _3802_/C gf180mcu_as_sc_mcu7t3v3__clkbuff_12
XFILLER_196_1189 VDD VDD VSS VSS gf180mcu_as_sc_mcu7t3v3__fillcap_16
XFILLER_87_1495 VDD VDD VSS VSS gf180mcu_as_sc_mcu7t3v3__fill_2
XFILLER_83_1348 VDD VDD VSS VSS gf180mcu_as_sc_mcu7t3v3__fillcap_8
XFILLER_135_1438 VDD VDD VSS VSS gf180mcu_as_sc_mcu7t3v3__fill_2
XFILLER_174_1498 VDD VDD VSS VSS gf180mcu_as_sc_mcu7t3v3__fillcap_16
XFILLER_2_592 VDD VDD VSS VSS gf180mcu_as_sc_mcu7t3v3__fill_2
X_4010_ VDD VDD VSS VSS _4106_/S _4010_/B _4010_/A _4011_/B gf180mcu_as_sc_mcu7t3v3__mux2_2
XFILLER_203_34 VDD VDD VSS VSS gf180mcu_as_sc_mcu7t3v3__fillcap_16
XFILLER_4_1540 VDD VDD VSS VSS gf180mcu_as_sc_mcu7t3v3__fill_2
XFILLER_111_1482 VDD VDD VSS VSS gf180mcu_as_sc_mcu7t3v3__fillcap_4
XFILLER_0_1459 VDD VDD VSS VSS gf180mcu_as_sc_mcu7t3v3__fill_2
X_4912_ VDD VDD VSS VSS _4946_/CLK _4912_/D _4912_/Q gf180mcu_as_sc_mcu7t3v3__dfxtp_2
XFILLER_107_1507 VDD VDD VSS VSS gf180mcu_as_sc_mcu7t3v3__fillcap_4
XFILLER_181_1436 VDD VDD VSS VSS gf180mcu_as_sc_mcu7t3v3__fill_1
XFILLER_142_1409 VDD VDD VSS VSS gf180mcu_as_sc_mcu7t3v3__fillcap_16
X_4843_ VDD VDD VSS VSS clkload6/A _4843_/D _4843_/Q gf180mcu_as_sc_mcu7t3v3__dfxtp_2
XFILLER_14_1103 VDD VDD VSS VSS gf180mcu_as_sc_mcu7t3v3__fillcap_8
XFILLER_18_1283 VDD VDD VSS VSS gf180mcu_as_sc_mcu7t3v3__fillcap_8
X_4774_ VDD VDD VSS VSS _5142_/CLK _4774_/D _4774_/Q gf180mcu_as_sc_mcu7t3v3__dfxtp_2
XFILLER_174_630 VDD VDD VSS VSS gf180mcu_as_sc_mcu7t3v3__fillcap_16
XFILLER_179_1310 VDD VDD VSS VSS gf180mcu_as_sc_mcu7t3v3__fillcap_16
XFILLER_20_168 VDD VDD VSS VSS gf180mcu_as_sc_mcu7t3v3__fillcap_4
X_3725_ VDD VDD VSS VSS _3726_/C _4101_/A _3725_/B _3725_/C gf180mcu_as_sc_mcu7t3v3__ao21_2
XFILLER_179_1332 VDD VDD VSS VSS gf180mcu_as_sc_mcu7t3v3__fillcap_16
XFILLER_179_1354 VDD VDD VSS VSS gf180mcu_as_sc_mcu7t3v3__fill_1
XFILLER_179_1398 VDD VDD VSS VSS gf180mcu_as_sc_mcu7t3v3__fill_2
XFILLER_31_1472 VDD VDD VSS VSS gf180mcu_as_sc_mcu7t3v3__fillcap_4
XTAP_TAPCELL_ROW_155_1_1911 VDD VSS gf180mcu_as_sc_mcu7t3v3__tap_2
X_3656_ VDD VDD VSS VSS _4030_/D _3724_/B _3656_/C _4031_/A _3657_/D gf180mcu_as_sc_mcu7t3v3__ao22_2
XTAP_TAPCELL_ROW_167_3_3223 VDD VSS gf180mcu_as_sc_mcu7t3v3__tap_2
X_3587_ VDD VDD VSS VSS _3953_/A _3652_/D _3587_/C _3587_/Y _3615_/D gf180mcu_as_sc_mcu7t3v3__aoi211_2
X_2607_ VDD VDD VSS VSS _2734_/S _2699_/A _2735_/A gf180mcu_as_sc_mcu7t3v3__and2_2
XFILLER_0_518 VDD VDD VSS VSS gf180mcu_as_sc_mcu7t3v3__fill_1
XFILLER_66_1568 VDD VDD VSS VSS gf180mcu_as_sc_mcu7t3v3__fill_1
X_2538_ VDD VDD VSS VSS _4365_/A _2538_/A _2539_/A gf180mcu_as_sc_mcu7t3v3__xnor2_2
X_5257_ VDD VDD VSS VSS clkload6/A _5257_/D _5257_/Q gf180mcu_as_sc_mcu7t3v3__dfxtp_2
XFILLER_9_1451 VDD VDD VSS VSS gf180mcu_as_sc_mcu7t3v3__fill_1
X_4208_ VDD VDD VSS VSS _4237_/B _4224_/B _4224_/C _5044_/Q _5044_/D gf180mcu_as_sc_mcu7t3v3__ao22_2
X_2469_ VDD VDD VSS VSS _2472_/C _2469_/C _5063_/Q _4559_/S gf180mcu_as_sc_mcu7t3v3__aoi21b_2
XTAP_TAPCELL_ROW_4_824 VDD VSS gf180mcu_as_sc_mcu7t3v3__tap_2
XTAP_TAPCELL_ROW_4_813 VDD VSS gf180mcu_as_sc_mcu7t3v3__tap_2
XTAP_TAPCELL_ROW_32_1433 VDD VSS gf180mcu_as_sc_mcu7t3v3__tap_2
XFILLER_116_1393 VDD VDD VSS VSS gf180mcu_as_sc_mcu7t3v3__fillcap_16
XFILLER_21_1118 VDD VDD VSS VSS gf180mcu_as_sc_mcu7t3v3__fill_2
X_5188_ VDD VDD VSS VSS clkload8/A _5188_/D _5188_/Q gf180mcu_as_sc_mcu7t3v3__dfxtp_2
XTAP_TAPCELL_ROW_32_1444 VDD VSS gf180mcu_as_sc_mcu7t3v3__tap_2
XFILLER_17_909 VDD VDD VSS VSS gf180mcu_as_sc_mcu7t3v3__fill_1
XFILLER_29_758 VDD VDD VSS VSS gf180mcu_as_sc_mcu7t3v3__fillcap_8
X_4139_ VDD VDD VSS VSS _4139_/A _4163_/B _4139_/C _4139_/D _4140_/B gf180mcu_as_sc_mcu7t3v3__ao211_2
XFILLER_16_419 VDD VDD VSS VSS gf180mcu_as_sc_mcu7t3v3__fillcap_16
XFILLER_25_920 VDD VDD VSS VSS gf180mcu_as_sc_mcu7t3v3__fillcap_4
XFILLER_189_38 VDD VDD VSS VSS gf180mcu_as_sc_mcu7t3v3__fillcap_16
XFILLER_19_1003 VDD VDD VSS VSS gf180mcu_as_sc_mcu7t3v3__fillcap_8
XFILLER_36_290 VDD VDD VSS VSS gf180mcu_as_sc_mcu7t3v3__fillcap_16
XFILLER_185_906 VDD VDD VSS VSS gf180mcu_as_sc_mcu7t3v3__fillcap_4
XFILLER_19_1047 VDD VDD VSS VSS gf180mcu_as_sc_mcu7t3v3__fill_2
XFILLER_200_715 VDD VDD VSS VSS gf180mcu_as_sc_mcu7t3v3__fillcap_16
XFILLER_11_124 VDD VDD VSS VSS gf180mcu_as_sc_mcu7t3v3__fill_2
XFILLER_185_928 VDD VDD VSS VSS gf180mcu_as_sc_mcu7t3v3__fillcap_16
XFILLER_197_788 VDD VDD VSS VSS gf180mcu_as_sc_mcu7t3v3__fillcap_16
XFILLER_200_737 VDD VDD VSS VSS gf180mcu_as_sc_mcu7t3v3__fillcap_16
XFILLER_123_1364 VDD VDD VSS VSS gf180mcu_as_sc_mcu7t3v3__fill_2
XFILLER_149_181 VDD VDD VSS VSS gf180mcu_as_sc_mcu7t3v3__fillcap_4
XFILLER_20_691 VDD VDD VSS VSS gf180mcu_as_sc_mcu7t3v3__fill_2
XFILLER_22_53 VDD VDD VSS VSS gf180mcu_as_sc_mcu7t3v3__fillcap_8
XFILLER_4_802 VDD VDD VSS VSS gf180mcu_as_sc_mcu7t3v3__fill_2
XFILLER_10_1523 VDD VDD VSS VSS gf180mcu_as_sc_mcu7t3v3__fillcap_8
XFILLER_118_2 VDD VDD VSS VSS gf180mcu_as_sc_mcu7t3v3__fillcap_16
XFILLER_138_53 VDD VDD VSS VSS gf180mcu_as_sc_mcu7t3v3__fillcap_16
XFILLER_158_1416 VDD VDD VSS VSS gf180mcu_as_sc_mcu7t3v3__fill_2
XTAP_TAPCELL_ROW_210_2820 VDD VSS gf180mcu_as_sc_mcu7t3v3__tap_2
XFILLER_0_2 VDD VDD VSS VSS gf180mcu_as_sc_mcu7t3v3__fillcap_16
XFILLER_120_221 VDD VDD VSS VSS gf180mcu_as_sc_mcu7t3v3__fill_1
XFILLER_26_1029 VDD VDD VSS VSS gf180mcu_as_sc_mcu7t3v3__fill_2
XPHY_EDGE_ROW_153_3_Left_538 VDD VSS gf180mcu_as_sc_mcu7t3v3__tap_2
XTAP_TAPCELL_ROW_74_1_1666 VDD VSS gf180mcu_as_sc_mcu7t3v3__tap_2
XFILLER_208_815 VDD VDD VSS VSS gf180mcu_as_sc_mcu7t3v3__fillcap_4
XFILLER_47_72 VDD VDD VSS VSS gf180mcu_as_sc_mcu7t3v3__fillcap_16
XFILLER_19_268 VDD VDD VSS VSS gf180mcu_as_sc_mcu7t3v3__fillcap_8
XFILLER_207_347 VDD VDD VSS VSS gf180mcu_as_sc_mcu7t3v3__fill_2
XFILLER_210_1370 VDD VDD VSS VSS gf180mcu_as_sc_mcu7t3v3__fill_1
XFILLER_35_728 VDD VDD VSS VSS gf180mcu_as_sc_mcu7t3v3__fill_2
XTAP_TAPCELL_ROW_204_2668 VDD VSS gf180mcu_as_sc_mcu7t3v3__tap_2
XTAP_TAPCELL_ROW_204_2657 VDD VSS gf180mcu_as_sc_mcu7t3v3__tap_2
XFILLER_31_912 VDD VDD VSS VSS gf180mcu_as_sc_mcu7t3v3__fillcap_8
XPHY_EDGE_ROW_177_Left_387 VDD VSS gf180mcu_as_sc_mcu7t3v3__tap_2
XFILLER_187_232 VDD VDD VSS VSS gf180mcu_as_sc_mcu7t3v3__fill_1
XFILLER_30_422 VDD VDD VSS VSS gf180mcu_as_sc_mcu7t3v3__fillcap_8
XFILLER_175_416 VDD VDD VSS VSS gf180mcu_as_sc_mcu7t3v3__fillcap_4
XFILLER_54_1461 VDD VDD VSS VSS gf180mcu_as_sc_mcu7t3v3__fillcap_4
XFILLER_141_1464 VDD VDD VSS VSS gf180mcu_as_sc_mcu7t3v3__fillcap_4
XFILLER_190_419 VDD VDD VSS VSS gf180mcu_as_sc_mcu7t3v3__fillcap_8
X_3510_ VDD VDD VSS VSS _3510_/D _3510_/A _3818_/B _3510_/C _3511_/D gf180mcu_as_sc_mcu7t3v3__ao31_2
XFILLER_102_1448 VDD VDD VSS VSS gf180mcu_as_sc_mcu7t3v3__fill_2
XFILLER_200_1049 VDD VDD VSS VSS gf180mcu_as_sc_mcu7t3v3__fillcap_16
XFILLER_89_1568 VDD VDD VSS VSS gf180mcu_as_sc_mcu7t3v3__fill_1
X_4490_ VDD VDD VSS VSS _4491_/D _4490_/B _4502_/A gf180mcu_as_sc_mcu7t3v3__nor2_2
X_3441_ VDD VDD VSS VSS _4096_/D _3466_/B _3441_/C _3479_/C _3443_/C gf180mcu_as_sc_mcu7t3v3__ao211_2
XPHY_EDGE_ROW_186_Left_396 VDD VSS gf180mcu_as_sc_mcu7t3v3__tap_2
X_3372_ VDD VDD VSS VSS _4021_/D _3451_/B _3372_/C _3372_/D _3373_/A gf180mcu_as_sc_mcu7t3v3__ao22_2
X_5111_ VDD VDD VSS VSS _5111_/CLK _5111_/D _5111_/Q gf180mcu_as_sc_mcu7t3v3__dfxtp_2
XFILLER_26_1541 VDD VDD VSS VSS gf180mcu_as_sc_mcu7t3v3__fill_2
X_5042_ VDD VDD VSS VSS clkload5/A _5042_/D _5042_/Q gf180mcu_as_sc_mcu7t3v3__dfxtp_2
XFILLER_113_1566 VDD VDD VSS VSS gf180mcu_as_sc_mcu7t3v3__fill_2
XFILLER_96_1506 VDD VDD VSS VSS gf180mcu_as_sc_mcu7t3v3__fillcap_8
XFILLER_92_160 VDD VDD VSS VSS gf180mcu_as_sc_mcu7t3v3__fillcap_8
XFILLER_19_791 VDD VDD VSS VSS gf180mcu_as_sc_mcu7t3v3__fill_1
XFILLER_20_1173 VDD VDD VSS VSS gf180mcu_as_sc_mcu7t3v3__fillcap_16
XFILLER_59_1383 VDD VDD VSS VSS gf180mcu_as_sc_mcu7t3v3__fillcap_16
XFILLER_146_1364 VDD VDD VSS VSS gf180mcu_as_sc_mcu7t3v3__fillcap_16
XFILLER_21_422 VDD VDD VSS VSS gf180mcu_as_sc_mcu7t3v3__fillcap_16
XFILLER_22_934 VDD VDD VSS VSS gf180mcu_as_sc_mcu7t3v3__fillcap_8
XFILLER_107_1348 VDD VDD VSS VSS gf180mcu_as_sc_mcu7t3v3__fillcap_16
XFILLER_138_107 VDD VDD VSS VSS gf180mcu_as_sc_mcu7t3v3__fillcap_16
X_4826_ VDD VDD VSS VSS _4919_/CLK _4826_/D _4826_/Q gf180mcu_as_sc_mcu7t3v3__dfxtp_2
XFILLER_182_909 VDD VDD VSS VSS gf180mcu_as_sc_mcu7t3v3__fillcap_16
XTAP_TAPCELL_ROW_25_1281 VDD VSS gf180mcu_as_sc_mcu7t3v3__tap_2
XTAP_TAPCELL_ROW_25_1270 VDD VSS gf180mcu_as_sc_mcu7t3v3__tap_2
XFILLER_194_769 VDD VDD VSS VSS gf180mcu_as_sc_mcu7t3v3__fillcap_16
X_4757_ VDD VDD VSS VSS _5285_/CLK _4757_/D _4757_/Q gf180mcu_as_sc_mcu7t3v3__dfxtp_2
XFILLER_146_173 VDD VDD VSS VSS gf180mcu_as_sc_mcu7t3v3__fill_2
XFILLER_174_460 VDD VDD VSS VSS gf180mcu_as_sc_mcu7t3v3__fillcap_4
X_4688_ VDD VDD VSS VSS _4725_/B _5123_/Q _4723_/A gf180mcu_as_sc_mcu7t3v3__and2_2
X_3708_ VDD VDD VSS VSS _4088_/A _3749_/B _3740_/C _4087_/A _3709_/C gf180mcu_as_sc_mcu7t3v3__ao22_2
XTAP_TAPCELL_ROW_21_1189 VDD VSS gf180mcu_as_sc_mcu7t3v3__tap_2
XFILLER_108_34 VDD VDD VSS VSS gf180mcu_as_sc_mcu7t3v3__fill_1
X_3639_ VDD VDD VSS VSS _4848_/D _3639_/C _3731_/B _3639_/A gf180mcu_as_sc_mcu7t3v3__aoi21_2
XTAP_TAPCELL_ROW_9_927 VDD VSS gf180mcu_as_sc_mcu7t3v3__tap_2
XFILLER_1_827 VDD VDD VSS VSS gf180mcu_as_sc_mcu7t3v3__fillcap_8
XTAP_TAPCELL_ROW_9_938 VDD VSS gf180mcu_as_sc_mcu7t3v3__tap_2
XFILLER_0_348 VDD VDD VSS VSS gf180mcu_as_sc_mcu7t3v3__fill_1
XFILLER_153_1368 VDD VDD VSS VSS gf180mcu_as_sc_mcu7t3v3__fill_2
Xinput205 VDD VDD VSS VSS se_in[31] _3514_/A gf180mcu_as_sc_mcu7t3v3__buff_12
Xinput216 VDD VDD VSS VSS south_in[10] _4013_/D gf180mcu_as_sc_mcu7t3v3__buff_12
Xinput227 VDD VDD VSS VSS south_in[20] _4096_/D gf180mcu_as_sc_mcu7t3v3__buff_12
XFILLER_118_1499 VDD VDD VSS VSS gf180mcu_as_sc_mcu7t3v3__fillcap_16
Xinput238 VDD VDD VSS VSS south_in[30] _3796_/D gf180mcu_as_sc_mcu7t3v3__buff_12
Xinput249 VDD VDD VSS VSS sw_in[0] _2955_/A gf180mcu_as_sc_mcu7t3v3__buff_12
XFILLER_29_533 VDD VDD VSS VSS gf180mcu_as_sc_mcu7t3v3__fillcap_16
XTAP_TAPCELL_ROW_37_1_2829 VDD VSS gf180mcu_as_sc_mcu7t3v3__tap_2
XFILLER_17_739 VDD VDD VSS VSS gf180mcu_as_sc_mcu7t3v3__fillcap_4
XFILLER_189_519 VDD VDD VSS VSS gf180mcu_as_sc_mcu7t3v3__fillcap_16
XFILLER_204_317 VDD VDD VSS VSS gf180mcu_as_sc_mcu7t3v3__fillcap_16
XFILLER_31_208 VDD VDD VSS VSS gf180mcu_as_sc_mcu7t3v3__fill_2
XFILLER_125_1415 VDD VDD VSS VSS gf180mcu_as_sc_mcu7t3v3__fill_1
XFILLER_13_912 VDD VDD VSS VSS gf180mcu_as_sc_mcu7t3v3__fillcap_4
XFILLER_140_98 VDD VDD VSS VSS gf180mcu_as_sc_mcu7t3v3__fillcap_4
XFILLER_164_1453 VDD VDD VSS VSS gf180mcu_as_sc_mcu7t3v3__fillcap_16
XFILLER_25_772 VDD VDD VSS VSS gf180mcu_as_sc_mcu7t3v3__fillcap_8
XTAP_TAPCELL_ROW_174_2008 VDD VSS gf180mcu_as_sc_mcu7t3v3__tap_2
XFILLER_205_1450 VDD VDD VSS VSS gf180mcu_as_sc_mcu7t3v3__fillcap_16
XFILLER_205_1472 VDD VDD VSS VSS gf180mcu_as_sc_mcu7t3v3__fillcap_16
XFILLER_8_437 VDD VDD VSS VSS gf180mcu_as_sc_mcu7t3v3__fill_1
XFILLER_32_1033 VDD VDD VSS VSS gf180mcu_as_sc_mcu7t3v3__fill_2
XTAP_TAPCELL_ROW_191_2377 VDD VSS gf180mcu_as_sc_mcu7t3v3__tap_2
XTAP_TAPCELL_ROW_191_2366 VDD VSS gf180mcu_as_sc_mcu7t3v3__tap_2
XFILLER_197_1240 VDD VDD VSS VSS gf180mcu_as_sc_mcu7t3v3__fillcap_16
XFILLER_197_1262 VDD VDD VSS VSS gf180mcu_as_sc_mcu7t3v3__fillcap_16
XFILLER_137_184 VDD VDD VSS VSS gf180mcu_as_sc_mcu7t3v3__fill_1
XFILLER_137_195 VDD VDD VSS VSS gf180mcu_as_sc_mcu7t3v3__fillcap_8
XFILLER_192_290 VDD VDD VSS VSS gf180mcu_as_sc_mcu7t3v3__fill_2
XFILLER_101_1492 VDD VDD VSS VSS gf180mcu_as_sc_mcu7t3v3__fill_2
XFILLER_10_1364 VDD VDD VSS VSS gf180mcu_as_sc_mcu7t3v3__fill_1
XFILLER_3_142 VDD VDD VSS VSS gf180mcu_as_sc_mcu7t3v3__fill_1
XFILLER_171_1446 VDD VDD VSS VSS gf180mcu_as_sc_mcu7t3v3__fillcap_8
XFILLER_181_50 VDD VDD VSS VSS gf180mcu_as_sc_mcu7t3v3__fillcap_16
XFILLER_58_82 VDD VDD VSS VSS gf180mcu_as_sc_mcu7t3v3__fillcap_16
XTAP_TAPCELL_ROW_130_3_3110 VDD VSS gf180mcu_as_sc_mcu7t3v3__tap_2
XTAP_TAPCELL_ROW_206_2708 VDD VSS gf180mcu_as_sc_mcu7t3v3__tap_2
XFILLER_181_72 VDD VDD VSS VSS gf180mcu_as_sc_mcu7t3v3__fillcap_16
XFILLER_208_645 VDD VDD VSS VSS gf180mcu_as_sc_mcu7t3v3__fillcap_16
XFILLER_207_166 VDD VDD VSS VSS gf180mcu_as_sc_mcu7t3v3__fillcap_4
XFILLER_208_667 VDD VDD VSS VSS gf180mcu_as_sc_mcu7t3v3__fillcap_16
XFILLER_74_92 VDD VDD VSS VSS gf180mcu_as_sc_mcu7t3v3__fillcap_8
X_3990_ VDD VDD VSS VSS _3990_/A _4023_/B _4023_/C _4922_/Q _3991_/D gf180mcu_as_sc_mcu7t3v3__ao22_2
XFILLER_31_720 VDD VDD VSS VSS gf180mcu_as_sc_mcu7t3v3__fill_1
XTAP_TAPCELL_ROW_110_3_3052 VDD VSS gf180mcu_as_sc_mcu7t3v3__tap_2
X_2941_ VDD VDD VSS VSS _3817_/C _3515_/A _3524_/A gf180mcu_as_sc_mcu7t3v3__nor2_2
XFILLER_15_282 VDD VDD VSS VSS gf180mcu_as_sc_mcu7t3v3__fillcap_16
XFILLER_143_1548 VDD VDD VSS VSS gf180mcu_as_sc_mcu7t3v3__fillcap_8
X_4611_ VDD VDD VSS VSS _5205_/Q _4622_/B _4622_/C _5206_/Q _5205_/D gf180mcu_as_sc_mcu7t3v3__ao22_2
X_2872_ VDD VDD VSS VSS _4767_/Q _2882_/A _2873_/D gf180mcu_as_sc_mcu7t3v3__xnor2_2
XFILLER_175_257 VDD VDD VSS VSS gf180mcu_as_sc_mcu7t3v3__fillcap_8
XFILLER_11_1106 VDD VDD VSS VSS gf180mcu_as_sc_mcu7t3v3__fillcap_8
X_4542_ VDD VDD VSS VSS _4546_/B _5083_/Q _4542_/A gf180mcu_as_sc_mcu7t3v3__nand2_2
XFILLER_143_121 VDD VDD VSS VSS gf180mcu_as_sc_mcu7t3v3__fill_1
XFILLER_143_132 VDD VDD VSS VSS gf180mcu_as_sc_mcu7t3v3__fillcap_8
XFILLER_183_290 VDD VDD VSS VSS gf180mcu_as_sc_mcu7t3v3__fillcap_4
XFILLER_209_66 VDD VDD VSS VSS gf180mcu_as_sc_mcu7t3v3__fillcap_4
XFILLER_209_88 VDD VDD VSS VSS gf180mcu_as_sc_mcu7t3v3__fillcap_16
XFILLER_7_492 VDD VDD VSS VSS gf180mcu_as_sc_mcu7t3v3__fillcap_8
XFILLER_89_1387 VDD VDD VSS VSS gf180mcu_as_sc_mcu7t3v3__fillcap_16
XPHY_EDGE_ROW_194_Left_404 VDD VSS gf180mcu_as_sc_mcu7t3v3__tap_2
X_4473_ VDD VDD VSS VSS _4476_/C _4988_/Q _4483_/S gf180mcu_as_sc_mcu7t3v3__nand2b_2
XFILLER_89_208 VDD VDD VSS VSS gf180mcu_as_sc_mcu7t3v3__fill_2
X_3424_ VDD VDD VSS VSS _4075_/A _3463_/B _3424_/C _4822_/D _3463_/D gf180mcu_as_sc_mcu7t3v3__aoi211_2
Xsram2048.u_bank1 _2672_/Y _2668_/Y _2664_/Y _2657_/Y _2650_/Y _2641_/Y _2629_/Y _2610_/Y
+ _2604_/Y hold1105/Y clkbuf_1_1__f_clk/Y _2737_/Y _2730_/Y _2723_/Y _2716_/Y _2709_/Y
+ _2702_/Y _2693_/Y _2686_/Y _2832_/Y _2744_/B _2743_/B _2742_/B _2741_/B _2740_/B
+ _2739_/B _2738_/B _2478_/B VDD VSS sram2048.u_bank1/WEN[7] sram2048.u_bank1/WEN[6]
+ sram2048.u_bank1/WEN[5] sram2048.u_bank1/WEN[4] sram2048.u_bank1/WEN[3] sram2048.u_bank1/WEN[2]
+ sram2048.u_bank1/WEN[1] sram2048.u_bank1/WEN[0] _2676_/Y gf180mcu_ocd_ip_sram__sram1024x8m8wm1
X_3355_ VDD VDD VSS VSS _3450_/B _4006_/D _3356_/D gf180mcu_as_sc_mcu7t3v3__and2_2
XFILLER_6_1421 VDD VDD VSS VSS gf180mcu_as_sc_mcu7t3v3__fill_1
Xhold1104 VDD VDD VSS VSS _3906_/S _2588_/B gf180mcu_as_sc_mcu7t3v3__clkbuff_4
Xhold1115 VDD VDD VSS VSS hold1142/Y _4961_/D gf180mcu_as_sc_mcu7t3v3__clkbuff_4
X_3286_ VDD VDD VSS VSS _3514_/B _3286_/B _3526_/C gf180mcu_as_sc_mcu7t3v3__nor2_2
XFILLER_152_1390 VDD VDD VSS VSS gf180mcu_as_sc_mcu7t3v3__fillcap_16
X_5025_ VDD VDD VSS VSS _5073_/CLK _5025_/D _5025_/Q gf180mcu_as_sc_mcu7t3v3__dfxtp_2
Xhold1126 VDD VDD VSS VSS _4768_/Q _2835_/A gf180mcu_as_sc_mcu7t3v3__clkbuff_4
Xhold1137 VDD VDD VSS VSS _4965_/Q hold1137/Y gf180mcu_as_sc_mcu7t3v3__clkbuff_4
Xhold1148 VDD VDD VSS VSS _4963_/Q hold1148/Y gf180mcu_as_sc_mcu7t3v3__clkbuff_4
XFILLER_113_1385 VDD VDD VSS VSS gf180mcu_as_sc_mcu7t3v3__fill_1
XFILLER_22_1246 VDD VDD VSS VSS gf180mcu_as_sc_mcu7t3v3__fillcap_16
XFILLER_72_119 VDD VDD VSS VSS gf180mcu_as_sc_mcu7t3v3__fill_2
XTAP_TAPCELL_ROW_54_3_2883 VDD VSS gf180mcu_as_sc_mcu7t3v3__tap_2
XFILLER_0_1053 VDD VDD VSS VSS gf180mcu_as_sc_mcu7t3v3__fill_1
XFILLER_148_1448 VDD VDD VSS VSS gf180mcu_as_sc_mcu7t3v3__fill_2
XFILLER_183_1317 VDD VDD VSS VSS gf180mcu_as_sc_mcu7t3v3__fillcap_8
XFILLER_179_530 VDD VDD VSS VSS gf180mcu_as_sc_mcu7t3v3__fill_1
XTAP_TAPCELL_ROW_27_1332 VDD VSS gf180mcu_as_sc_mcu7t3v3__tap_2
XTAP_TAPCELL_ROW_27_1321 VDD VSS gf180mcu_as_sc_mcu7t3v3__tap_2
XFILLER_16_1017 VDD VDD VSS VSS gf180mcu_as_sc_mcu7t3v3__fill_1
XFILLER_181_1030 VDD VDD VSS VSS gf180mcu_as_sc_mcu7t3v3__fillcap_16
XFILLER_181_1052 VDD VDD VSS VSS gf180mcu_as_sc_mcu7t3v3__fillcap_16
XFILLER_22_753 VDD VDD VSS VSS gf180mcu_as_sc_mcu7t3v3__fillcap_16
XFILLER_210_843 VDD VDD VSS VSS gf180mcu_as_sc_mcu7t3v3__fillcap_4
XTAP_TAPCELL_ROW_23_1229 VDD VSS gf180mcu_as_sc_mcu7t3v3__tap_2
XFILLER_10_959 VDD VDD VSS VSS gf180mcu_as_sc_mcu7t3v3__fillcap_16
XFILLER_72_1391 VDD VDD VSS VSS gf180mcu_as_sc_mcu7t3v3__fillcap_4
XPHY_EDGE_ROW_17_Right_17 VDD VSS gf180mcu_as_sc_mcu7t3v3__tap_2
X_4809_ VDD VDD VSS VSS _4919_/CLK _4809_/D _4809_/Q gf180mcu_as_sc_mcu7t3v3__dfxtp_2
XFILLER_33_1386 VDD VDD VSS VSS gf180mcu_as_sc_mcu7t3v3__fillcap_8
XFILLER_159_1555 VDD VDD VSS VSS gf180mcu_as_sc_mcu7t3v3__fill_1
XTAP_TAPCELL_ROW_123_1_1813 VDD VSS gf180mcu_as_sc_mcu7t3v3__tap_2
XTAP_TAPCELL_ROW_135_3_3125 VDD VSS gf180mcu_as_sc_mcu7t3v3__tap_2
XFILLER_119_88 VDD VDD VSS VSS gf180mcu_as_sc_mcu7t3v3__fill_1
XFILLER_159_1566 VDD VDD VSS VSS gf180mcu_as_sc_mcu7t3v3__fill_2
XFILLER_135_43 VDD VDD VSS VSS gf180mcu_as_sc_mcu7t3v3__fillcap_4
XFILLER_0_178 VDD VDD VSS VSS gf180mcu_as_sc_mcu7t3v3__fill_1
XPHY_EDGE_ROW_26_Right_26 VDD VSS gf180mcu_as_sc_mcu7t3v3__tap_2
XFILLER_131_1430 VDD VDD VSS VSS gf180mcu_as_sc_mcu7t3v3__fillcap_16
XFILLER_48_138 VDD VDD VSS VSS gf180mcu_as_sc_mcu7t3v3__fill_2
XFILLER_95_69 VDD VDD VSS VSS gf180mcu_as_sc_mcu7t3v3__fill_1
XTAP_TAPCELL_ROW_103_1_1755 VDD VSS gf180mcu_as_sc_mcu7t3v3__tap_2
XTAP_TAPCELL_ROW_115_3_3067 VDD VSS gf180mcu_as_sc_mcu7t3v3__tap_2
XFILLER_151_42 VDD VDD VSS VSS gf180mcu_as_sc_mcu7t3v3__fillcap_4
XFILLER_28_74 VDD VDD VSS VSS gf180mcu_as_sc_mcu7t3v3__fill_1
XFILLER_29_352 VDD VDD VSS VSS gf180mcu_as_sc_mcu7t3v3__fillcap_4
XFILLER_131_1485 VDD VDD VSS VSS gf180mcu_as_sc_mcu7t3v3__fill_1
XFILLER_56_171 VDD VDD VSS VSS gf180mcu_as_sc_mcu7t3v3__fillcap_4
XTAP_TAPCELL_ROW_201_2605 VDD VSS gf180mcu_as_sc_mcu7t3v3__tap_2
XFILLER_189_305 VDD VDD VSS VSS gf180mcu_as_sc_mcu7t3v3__fill_2
XFILLER_205_626 VDD VDD VSS VSS gf180mcu_as_sc_mcu7t3v3__fillcap_4
XFILLER_205_648 VDD VDD VSS VSS gf180mcu_as_sc_mcu7t3v3__fillcap_16
Xclkbuf_leaf_15_clk_regs VDD VDD VSS VSS clkbuf_3_4__f_clk_regs/Y _5277_/CLK gf180mcu_as_sc_mcu7t3v3__clkbuff_12
XFILLER_189_349 VDD VDD VSS VSS gf180mcu_as_sc_mcu7t3v3__fill_1
XFILLER_71_174 VDD VDD VSS VSS gf180mcu_as_sc_mcu7t3v3__fillcap_4
XFILLER_13_742 VDD VDD VSS VSS gf180mcu_as_sc_mcu7t3v3__fillcap_16
XFILLER_201_821 VDD VDD VSS VSS gf180mcu_as_sc_mcu7t3v3__fillcap_16
XFILLER_34_1106 VDD VDD VSS VSS gf180mcu_as_sc_mcu7t3v3__fill_1
XFILLER_9_702 VDD VDD VSS VSS gf180mcu_as_sc_mcu7t3v3__fillcap_16
XTAP_TAPCELL_ROW_193_2428 VDD VSS gf180mcu_as_sc_mcu7t3v3__tap_2
XTAP_TAPCELL_ROW_193_2417 VDD VSS gf180mcu_as_sc_mcu7t3v3__tap_2
XFILLER_12_263 VDD VDD VSS VSS gf180mcu_as_sc_mcu7t3v3__fillcap_16
XFILLER_185_533 VDD VDD VSS VSS gf180mcu_as_sc_mcu7t3v3__fill_1
XFILLER_34_1117 VDD VDD VSS VSS gf180mcu_as_sc_mcu7t3v3__fillcap_8
XPHY_EDGE_ROW_35_Right_35 VDD VSS gf180mcu_as_sc_mcu7t3v3__tap_2
XTAP_TAPCELL_ROW_80_3_2962 VDD VSS gf180mcu_as_sc_mcu7t3v3__tap_2
XFILLER_200_364 VDD VDD VSS VSS gf180mcu_as_sc_mcu7t3v3__fillcap_16
XFILLER_201_1100 VDD VDD VSS VSS gf180mcu_as_sc_mcu7t3v3__fillcap_16
XFILLER_8_234 VDD VDD VSS VSS gf180mcu_as_sc_mcu7t3v3__fillcap_8
XFILLER_201_1122 VDD VDD VSS VSS gf180mcu_as_sc_mcu7t3v3__fillcap_16
XTAP_TAPCELL_ROW_11_965 VDD VSS gf180mcu_as_sc_mcu7t3v3__tap_2
XTAP_TAPCELL_ROW_11_976 VDD VSS gf180mcu_as_sc_mcu7t3v3__tap_2
XTAP_TAPCELL_ROW_49_1_1592 VDD VSS gf180mcu_as_sc_mcu7t3v3__tap_2
XPHY_EDGE_ROW_49_1_Right_570 VDD VSS gf180mcu_as_sc_mcu7t3v3__tap_2
XFILLER_10_1150 VDD VDD VSS VSS gf180mcu_as_sc_mcu7t3v3__fillcap_4
XFILLER_173_1508 VDD VDD VSS VSS gf180mcu_as_sc_mcu7t3v3__fill_2
XFILLER_181_772 VDD VDD VSS VSS gf180mcu_as_sc_mcu7t3v3__fillcap_16
XFILLER_5_34 VDD VDD VSS VSS gf180mcu_as_sc_mcu7t3v3__fillcap_16
XFILLER_10_1183 VDD VDD VSS VSS gf180mcu_as_sc_mcu7t3v3__fillcap_16
XFILLER_140_102 VDD VDD VSS VSS gf180mcu_as_sc_mcu7t3v3__fill_2
XTAP_TAPCELL_ROW_59_3_2898 VDD VSS gf180mcu_as_sc_mcu7t3v3__tap_2
X_3140_ VDD VDD VSS VSS _3746_/D _3194_/S _3140_/B _3140_/C _3141_/C gf180mcu_as_sc_mcu7t3v3__ao31_2
XTAP_TAPCELL_ROW_161_3_3204 VDD VSS gf180mcu_as_sc_mcu7t3v3__tap_2
XFILLER_85_80 VDD VDD VSS VSS gf180mcu_as_sc_mcu7t3v3__fill_1
X_3071_ VDD VDD VSS VSS _4049_/A _3071_/B _3071_/C _3071_/D _3072_/C gf180mcu_as_sc_mcu7t3v3__ao22_2
XFILLER_35_322 VDD VDD VSS VSS gf180mcu_as_sc_mcu7t3v3__fill_2
XFILLER_47_182 VDD VDD VSS VSS gf180mcu_as_sc_mcu7t3v3__fillcap_8
XFILLER_108_1421 VDD VDD VSS VSS gf180mcu_as_sc_mcu7t3v3__fill_2
XFILLER_182_1361 VDD VDD VSS VSS gf180mcu_as_sc_mcu7t3v3__fillcap_4
XFILLER_206_1033 VDD VDD VSS VSS gf180mcu_as_sc_mcu7t3v3__fillcap_16
XFILLER_62_185 VDD VDD VSS VSS gf180mcu_as_sc_mcu7t3v3__fill_1
XTAP_TAPCELL_ROW_128_1_1828 VDD VSS gf180mcu_as_sc_mcu7t3v3__tap_2
X_3973_ VDD VDD VSS VSS _3973_/A _4030_/B _4031_/B _3973_/D _3975_/C gf180mcu_as_sc_mcu7t3v3__ao22_2
XFILLER_17_1326 VDD VDD VSS VSS gf180mcu_as_sc_mcu7t3v3__fillcap_4
XFILLER_17_1348 VDD VDD VSS VSS gf180mcu_as_sc_mcu7t3v3__fillcap_16
XFILLER_188_360 VDD VDD VSS VSS gf180mcu_as_sc_mcu7t3v3__fillcap_4
X_2924_ VDD VDD VSS VSS _3530_/B _3512_/A _3521_/A gf180mcu_as_sc_mcu7t3v3__nor2_2
XFILLER_143_1389 VDD VDD VSS VSS gf180mcu_as_sc_mcu7t3v3__fillcap_16
X_2855_ VDD VDD VSS VSS _2856_/B _2875_/B _2855_/A gf180mcu_as_sc_mcu7t3v3__nand2_2
XFILLER_30_1504 VDD VDD VSS VSS gf180mcu_as_sc_mcu7t3v3__fill_1
X_4525_ VDD VDD VSS VSS _4529_/B _5081_/Q _4527_/S gf180mcu_as_sc_mcu7t3v3__nand2_2
X_2786_ VDD VDD VSS VSS _4649_/B _2786_/B _2786_/C _2786_/D _2806_/A gf180mcu_as_sc_mcu7t3v3__ao211_2
XFILLER_116_154 VDD VDD VSS VSS gf180mcu_as_sc_mcu7t3v3__fillcap_16
XFILLER_176_1165 VDD VDD VSS VSS gf180mcu_as_sc_mcu7t3v3__fillcap_4
XFILLER_176_1176 VDD VDD VSS VSS gf180mcu_as_sc_mcu7t3v3__fillcap_16
X_4456_ VDD VDD VSS VSS _4456_/S _5015_/Q _5044_/Q _4457_/B gf180mcu_as_sc_mcu7t3v3__mux2_2
XFILLER_131_124 VDD VDD VSS VSS gf180mcu_as_sc_mcu7t3v3__fillcap_16
XFILLER_8_1516 VDD VDD VSS VSS gf180mcu_as_sc_mcu7t3v3__fill_1
Xfanout703 VDD VDD VSS VSS _3566_/Y _3724_/C gf180mcu_as_sc_mcu7t3v3__buff_12
Xfanout714 VDD VDD VSS VSS _3268_/Y _3501_/B gf180mcu_as_sc_mcu7t3v3__buff_12
X_4387_ VDD VDD VSS VSS _5166_/Q _4470_/B _4479_/C _5116_/Q _4388_/B gf180mcu_as_sc_mcu7t3v3__ao22_2
X_3407_ VDD VDD VSS VSS _3408_/B _3407_/B _3407_/C _3408_/C gf180mcu_as_sc_mcu7t3v3__nor3_2
XFILLER_131_179 VDD VDD VSS VSS gf180mcu_as_sc_mcu7t3v3__fillcap_8
Xfanout725 VDD VDD VSS VSS _3250_/Y _3448_/B gf180mcu_as_sc_mcu7t3v3__buff_12
Xfanout736 VDD VDD VSS VSS _2903_/Y _3121_/B gf180mcu_as_sc_mcu7t3v3__buff_12
Xfanout747 VDD VDD VSS VSS _4733_/C _4640_/S gf180mcu_as_sc_mcu7t3v3__buff_12
Xfanout758 VDD VDD VSS VSS _2894_/Y _3176_/S gf180mcu_as_sc_mcu7t3v3__buff_12
X_3338_ VDD VDD VSS VSS _3442_/B _3338_/B _3991_/A _3339_/C gf180mcu_as_sc_mcu7t3v3__mux2_2
XTAP_TAPCELL_ROW_75_1_1671 VDD VSS gf180mcu_as_sc_mcu7t3v3__tap_2
Xfanout769 VDD VDD VSS VSS _4272_/S _4273_/S gf180mcu_as_sc_mcu7t3v3__buff_12
XTAP_TAPCELL_ROW_16_1088 VDD VSS gf180mcu_as_sc_mcu7t3v3__tap_2
XTAP_TAPCELL_ROW_16_1077 VDD VSS gf180mcu_as_sc_mcu7t3v3__tap_2
XFILLER_105_68 VDD VDD VSS VSS gf180mcu_as_sc_mcu7t3v3__fill_2
X_3269_ VDD VDD VSS VSS _4915_/Q _3402_/B _3402_/C _3930_/A _3274_/C gf180mcu_as_sc_mcu7t3v3__ao22_2
X_5008_ VDD VDD VSS VSS clkload5/A _5008_/D _5008_/Q gf180mcu_as_sc_mcu7t3v3__dfxtp_2
XTAP_TAPCELL_ROW_85_3_2977 VDD VSS gf180mcu_as_sc_mcu7t3v3__tap_2
XFILLER_121_34 VDD VDD VSS VSS gf180mcu_as_sc_mcu7t3v3__fillcap_16
XFILLER_22_1087 VDD VDD VSS VSS gf180mcu_as_sc_mcu7t3v3__fillcap_16
XFILLER_38_193 VDD VDD VSS VSS gf180mcu_as_sc_mcu7t3v3__fillcap_16
XFILLER_157_6 VDD VDD VSS VSS gf180mcu_as_sc_mcu7t3v3__fillcap_16
XFILLER_187_1294 VDD VDD VSS VSS gf180mcu_as_sc_mcu7t3v3__fillcap_16
XFILLER_26_377 VDD VDD VSS VSS gf180mcu_as_sc_mcu7t3v3__fillcap_8
XFILLER_202_629 VDD VDD VSS VSS gf180mcu_as_sc_mcu7t3v3__fillcap_16
XFILLER_74_1453 VDD VDD VSS VSS gf180mcu_as_sc_mcu7t3v3__fillcap_8
XFILLER_161_1434 VDD VDD VSS VSS gf180mcu_as_sc_mcu7t3v3__fillcap_4
XFILLER_179_382 VDD VDD VSS VSS gf180mcu_as_sc_mcu7t3v3__fillcap_8
XFILLER_195_820 VDD VDD VSS VSS gf180mcu_as_sc_mcu7t3v3__fillcap_16
XFILLER_195_842 VDD VDD VSS VSS gf180mcu_as_sc_mcu7t3v3__fillcap_16
XFILLER_197_38 VDD VDD VSS VSS gf180mcu_as_sc_mcu7t3v3__fillcap_16
XFILLER_35_1437 VDD VDD VSS VSS gf180mcu_as_sc_mcu7t3v3__fillcap_16
XFILLER_74_1475 VDD VDD VSS VSS gf180mcu_as_sc_mcu7t3v3__fillcap_16
XPHY_EDGE_ROW_162_3_Left_547 VDD VSS gf180mcu_as_sc_mcu7t3v3__tap_2
XFILLER_22_594 VDD VDD VSS VSS gf180mcu_as_sc_mcu7t3v3__fill_1
XFILLER_182_514 VDD VDD VSS VSS gf180mcu_as_sc_mcu7t3v3__fillcap_8
XFILLER_202_1431 VDD VDD VSS VSS gf180mcu_as_sc_mcu7t3v3__fillcap_4
XFILLER_202_1453 VDD VDD VSS VSS gf180mcu_as_sc_mcu7t3v3__fillcap_16
XFILLER_210_695 VDD VDD VSS VSS gf180mcu_as_sc_mcu7t3v3__fillcap_4
XFILLER_33_1172 VDD VDD VSS VSS gf180mcu_as_sc_mcu7t3v3__fillcap_4
XFILLER_6_749 VDD VDD VSS VSS gf180mcu_as_sc_mcu7t3v3__fill_1
XFILLER_194_1221 VDD VDD VSS VSS gf180mcu_as_sc_mcu7t3v3__fillcap_4
XFILLER_194_1243 VDD VDD VSS VSS gf180mcu_as_sc_mcu7t3v3__fillcap_16
XFILLER_30_53 VDD VDD VSS VSS gf180mcu_as_sc_mcu7t3v3__fillcap_16
XTAP_TAPCELL_ROW_154_1_1907 VDD VSS gf180mcu_as_sc_mcu7t3v3__tap_2
XTAP_TAPCELL_ROW_166_3_3219 VDD VSS gf180mcu_as_sc_mcu7t3v3__tap_2
XFILLER_100_2 VDD VDD VSS VSS gf180mcu_as_sc_mcu7t3v3__fill_1
XFILLER_122_102 VDD VDD VSS VSS gf180mcu_as_sc_mcu7t3v3__fill_2
XFILLER_159_1396 VDD VDD VSS VSS gf180mcu_as_sc_mcu7t3v3__fillcap_4
XFILLER_190_591 VDD VDD VSS VSS gf180mcu_as_sc_mcu7t3v3__fillcap_4
XFILLER_29_1208 VDD VDD VSS VSS gf180mcu_as_sc_mcu7t3v3__fillcap_8
XFILLER_30_86 VDD VDD VSS VSS gf180mcu_as_sc_mcu7t3v3__fillcap_16
XFILLER_2_944 VDD VDD VSS VSS gf180mcu_as_sc_mcu7t3v3__fill_1
XTAP_TAPCELL_ROW_186_2254 VDD VSS gf180mcu_as_sc_mcu7t3v3__tap_2
XFILLER_39_51 VDD VDD VSS VSS gf180mcu_as_sc_mcu7t3v3__fill_2
XFILLER_46_1566 VDD VDD VSS VSS gf180mcu_as_sc_mcu7t3v3__fill_2
XFILLER_7_1015 VDD VDD VSS VSS gf180mcu_as_sc_mcu7t3v3__fillcap_16
XTAP_TAPCELL_ROW_186_2265 VDD VSS gf180mcu_as_sc_mcu7t3v3__tap_2
XFILLER_162_30 VDD VDD VSS VSS gf180mcu_as_sc_mcu7t3v3__fillcap_4
XFILLER_209_206 VDD VDD VSS VSS gf180mcu_as_sc_mcu7t3v3__fillcap_4
XFILLER_209_228 VDD VDD VSS VSS gf180mcu_as_sc_mcu7t3v3__fill_2
XFILLER_206_957 VDD VDD VSS VSS gf180mcu_as_sc_mcu7t3v3__fill_1
XFILLER_44_141 VDD VDD VSS VSS gf180mcu_as_sc_mcu7t3v3__fillcap_16
XFILLER_55_72 VDD VDD VSS VSS gf180mcu_as_sc_mcu7t3v3__fillcap_16
XFILLER_53_1504 VDD VDD VSS VSS gf180mcu_as_sc_mcu7t3v3__fill_2
XFILLER_92_1531 VDD VDD VSS VSS gf180mcu_as_sc_mcu7t3v3__fillcap_4
XPHY_EDGE_ROW_94_3_Left_479 VDD VSS gf180mcu_as_sc_mcu7t3v3__tap_2
XFILLER_207_1364 VDD VDD VSS VSS gf180mcu_as_sc_mcu7t3v3__fillcap_16
XFILLER_20_509 VDD VDD VSS VSS gf180mcu_as_sc_mcu7t3v3__fill_2
XFILLER_92_1564 VDD VDD VSS VSS gf180mcu_as_sc_mcu7t3v3__fillcap_4
XFILLER_197_190 VDD VDD VSS VSS gf180mcu_as_sc_mcu7t3v3__fillcap_16
XFILLER_9_532 VDD VDD VSS VSS gf180mcu_as_sc_mcu7t3v3__fill_2
XFILLER_12_1212 VDD VDD VSS VSS gf180mcu_as_sc_mcu7t3v3__fillcap_8
XFILLER_185_352 VDD VDD VSS VSS gf180mcu_as_sc_mcu7t3v3__fillcap_8
XFILLER_185_374 VDD VDD VSS VSS gf180mcu_as_sc_mcu7t3v3__fillcap_8
XFILLER_199_1154 VDD VDD VSS VSS gf180mcu_as_sc_mcu7t3v3__fillcap_16
XFILLER_9_587 VDD VDD VSS VSS gf180mcu_as_sc_mcu7t3v3__fillcap_4
X_2640_ VDD VDD VSS VSS _2701_/A _2640_/B input5/Y _2641_/A gf180mcu_as_sc_mcu7t3v3__mux2_2
XFILLER_103_1373 VDD VDD VSS VSS gf180mcu_as_sc_mcu7t3v3__fill_1
XFILLER_103_1384 VDD VDD VSS VSS gf180mcu_as_sc_mcu7t3v3__fillcap_16
XFILLER_177_1452 VDD VDD VSS VSS gf180mcu_as_sc_mcu7t3v3__fillcap_4
Xoutput317 VDD VDD VSS VSS _5478_/Y dft_rdata[0] gf180mcu_as_sc_mcu7t3v3__buff_12
X_2571_ VDD VDD VSS VSS _2849_/A _2571_/B _2855_/A gf180mcu_as_sc_mcu7t3v3__nor2_2
XFILLER_86_1368 VDD VDD VSS VSS gf180mcu_as_sc_mcu7t3v3__fill_1
Xoutput339 VDD VDD VSS VSS _4861_/Q east_out[22] gf180mcu_as_sc_mcu7t3v3__buff_12
Xoutput328 VDD VDD VSS VSS _4851_/Q east_out[12] gf180mcu_as_sc_mcu7t3v3__buff_12
X_4310_ VDD VDD VSS VSS _4314_/S _5140_/Q _5139_/Q _5139_/D gf180mcu_as_sc_mcu7t3v3__mux2_2
XFILLER_113_124 VDD VDD VSS VSS gf180mcu_as_sc_mcu7t3v3__fill_1
XFILLER_113_135 VDD VDD VSS VSS gf180mcu_as_sc_mcu7t3v3__fillcap_4
XFILLER_113_146 VDD VDD VSS VSS gf180mcu_as_sc_mcu7t3v3__fill_2
XFILLER_138_1469 VDD VDD VSS VSS gf180mcu_as_sc_mcu7t3v3__fillcap_8
XFILLER_206_34 VDD VDD VSS VSS gf180mcu_as_sc_mcu7t3v3__fill_1
X_4241_ VDD VDD VSS VSS _4257_/S _4241_/B _5077_/Q _5077_/D gf180mcu_as_sc_mcu7t3v3__mux2_2
XFILLER_60_1519 VDD VDD VSS VSS gf180mcu_as_sc_mcu7t3v3__fill_2
X_4172_ VDD VDD VSS VSS _4232_/B _4193_/B _4193_/C _5010_/Q _5010_/D gf180mcu_as_sc_mcu7t3v3__ao22_2
XFILLER_3_1402 VDD VDD VSS VSS gf180mcu_as_sc_mcu7t3v3__fillcap_4
X_3123_ VDD VDD VSS VSS _3141_/B _3123_/B _3123_/C _3124_/C gf180mcu_as_sc_mcu7t3v3__nor3_2
X_3054_ VDD VDD VSS VSS _3129_/B _4927_/Q _3055_/D gf180mcu_as_sc_mcu7t3v3__or2_2
XFILLER_184_1412 VDD VDD VSS VSS gf180mcu_as_sc_mcu7t3v3__fillcap_8
XFILLER_23_1396 VDD VDD VSS VSS gf180mcu_as_sc_mcu7t3v3__fillcap_4
XFILLER_24_804 VDD VDD VSS VSS gf180mcu_as_sc_mcu7t3v3__fill_1
XFILLER_36_664 VDD VDD VSS VSS gf180mcu_as_sc_mcu7t3v3__fillcap_16
XFILLER_58_1415 VDD VDD VSS VSS gf180mcu_as_sc_mcu7t3v3__fillcap_16
XFILLER_97_1442 VDD VDD VSS VSS gf180mcu_as_sc_mcu7t3v3__fillcap_4
XFILLER_110_1399 VDD VDD VSS VSS gf180mcu_as_sc_mcu7t3v3__fillcap_8
XFILLER_184_1445 VDD VDD VSS VSS gf180mcu_as_sc_mcu7t3v3__fillcap_4
XFILLER_1_1192 VDD VDD VSS VSS gf180mcu_as_sc_mcu7t3v3__fillcap_16
XFILLER_189_680 VDD VDD VSS VSS gf180mcu_as_sc_mcu7t3v3__fillcap_16
X_3956_ VDD VDD VSS VSS _3956_/A _4032_/C _4030_/B _3956_/D _3957_/D gf180mcu_as_sc_mcu7t3v3__ao22_2
XFILLER_176_341 VDD VDD VSS VSS gf180mcu_as_sc_mcu7t3v3__fillcap_8
XFILLER_177_842 VDD VDD VSS VSS gf180mcu_as_sc_mcu7t3v3__fillcap_16
XFILLER_50_177 VDD VDD VSS VSS gf180mcu_as_sc_mcu7t3v3__fillcap_16
X_2907_ VDD VDD VSS VSS _3510_/A _3519_/A _3245_/C gf180mcu_as_sc_mcu7t3v3__or2_2
XFILLER_192_801 VDD VDD VSS VSS gf180mcu_as_sc_mcu7t3v3__fillcap_4
XFILLER_192_823 VDD VDD VSS VSS gf180mcu_as_sc_mcu7t3v3__fillcap_16
X_3887_ VDD VDD VSS VSS _3893_/B _5177_/Q _4927_/D gf180mcu_as_sc_mcu7t3v3__and2_2
XFILLER_178_1227 VDD VDD VSS VSS gf180mcu_as_sc_mcu7t3v3__fillcap_16
X_2838_ VDD VDD VSS VSS _2839_/B _2838_/B _5124_/Q gf180mcu_as_sc_mcu7t3v3__nor2_2
XFILLER_121_1495 VDD VDD VSS VSS gf180mcu_as_sc_mcu7t3v3__fillcap_16
XFILLER_30_1367 VDD VDD VSS VSS gf180mcu_as_sc_mcu7t3v3__fillcap_4
X_2769_ VDD VDD VSS VSS _5124_/Q _2838_/B _2845_/B _2770_/D gf180mcu_as_sc_mcu7t3v3__nand3_2
XFILLER_69_1566 VDD VDD VSS VSS gf180mcu_as_sc_mcu7t3v3__fill_2
X_4508_ VDD VDD VSS VSS _4511_/C _4992_/Q _4559_/S gf180mcu_as_sc_mcu7t3v3__nand2b_2
X_4439_ VDD VDD VSS VSS _4440_/D _4439_/B _4502_/A gf180mcu_as_sc_mcu7t3v3__nor2_2
XTAP_TAPCELL_ROW_18_1128 VDD VSS gf180mcu_as_sc_mcu7t3v3__tap_2
XTAP_TAPCELL_ROW_18_1117 VDD VSS gf180mcu_as_sc_mcu7t3v3__tap_2
XFILLER_104_168 VDD VDD VSS VSS gf180mcu_as_sc_mcu7t3v3__fillcap_4
XFILLER_8_1313 VDD VDD VSS VSS gf180mcu_as_sc_mcu7t3v3__fillcap_4
Xfanout511 VDD VDD VSS VSS _4582_/A _4521_/A gf180mcu_as_sc_mcu7t3v3__buff_12
Xfanout522 VDD VDD VSS VSS _3912_/Y _4158_/D gf180mcu_as_sc_mcu7t3v3__buff_12
Xfanout533 VDD VDD VSS VSS _3675_/B _3729_/B gf180mcu_as_sc_mcu7t3v3__buff_12
Xfanout544 VDD VDD VSS VSS _3284_/Y _3476_/D gf180mcu_as_sc_mcu7t3v3__buff_12
Xfanout555 VDD VDD VSS VSS _4105_/B _4033_/B gf180mcu_as_sc_mcu7t3v3__buff_12
Xfanout566 VDD VDD VSS VSS _4165_/A _4107_/A gf180mcu_as_sc_mcu7t3v3__buff_12
Xfanout577 VDD VDD VSS VSS _3445_/C _3522_/C gf180mcu_as_sc_mcu7t3v3__buff_12
Xfanout588 VDD VDD VSS VSS _3181_/A _3141_/B gf180mcu_as_sc_mcu7t3v3__buff_12
Xfanout599 VDD VDD VSS VSS _3919_/Y _4119_/B gf180mcu_as_sc_mcu7t3v3__buff_12
XTAP_TAPCELL_ROW_35_1497 VDD VSS gf180mcu_as_sc_mcu7t3v3__tap_2
XFILLER_206_209 VDD VDD VSS VSS gf180mcu_as_sc_mcu7t3v3__fillcap_16
Xmesh_tile_981 VDD VDD VSS VSS north_out[22] gf180mcu_as_sc_mcu7t3v3__tiel_4
Xmesh_tile_970 VDD VDD VSS VSS north_out[11] gf180mcu_as_sc_mcu7t3v3__tiel_4
XTAP_TAPCELL_ROW_181_2162 VDD VSS gf180mcu_as_sc_mcu7t3v3__tap_2
XTAP_TAPCELL_ROW_181_2151 VDD VSS gf180mcu_as_sc_mcu7t3v3__tap_2
XFILLER_76_1504 VDD VDD VSS VSS gf180mcu_as_sc_mcu7t3v3__fillcap_16
Xmesh_tile_992 VDD VDD VSS VSS north_out[33] gf180mcu_as_sc_mcu7t3v3__tiel_4
XTAP_TAPCELL_ROW_2_774 VDD VSS gf180mcu_as_sc_mcu7t3v3__tap_2
XFILLER_15_804 VDD VDD VSS VSS gf180mcu_as_sc_mcu7t3v3__fillcap_16
XFILLER_199_422 VDD VDD VSS VSS gf180mcu_as_sc_mcu7t3v3__fillcap_8
XFILLER_26_152 VDD VDD VSS VSS gf180mcu_as_sc_mcu7t3v3__fillcap_16
XFILLER_27_664 VDD VDD VSS VSS gf180mcu_as_sc_mcu7t3v3__fillcap_16
XTAP_TAPCELL_ROW_2_785 VDD VSS gf180mcu_as_sc_mcu7t3v3__tap_2
XFILLER_14_314 VDD VDD VSS VSS gf180mcu_as_sc_mcu7t3v3__fill_1
XFILLER_26_174 VDD VDD VSS VSS gf180mcu_as_sc_mcu7t3v3__fill_1
X_4877__1090 VDD VDD VSS VSS _4877_/D gf180mcu_as_sc_mcu7t3v3__tiel_4
XFILLER_148_2 VDD VDD VSS VSS gf180mcu_as_sc_mcu7t3v3__fillcap_16
XFILLER_202_437 VDD VDD VSS VSS gf180mcu_as_sc_mcu7t3v3__fillcap_16
XFILLER_30_807 VDD VDD VSS VSS gf180mcu_as_sc_mcu7t3v3__fill_1
XFILLER_30_818 VDD VDD VSS VSS gf180mcu_as_sc_mcu7t3v3__fillcap_8
XFILLER_41_166 VDD VDD VSS VSS gf180mcu_as_sc_mcu7t3v3__fillcap_8
XFILLER_35_1256 VDD VDD VSS VSS gf180mcu_as_sc_mcu7t3v3__fillcap_4
Xwire901 VDD VDD VSS VSS _2563_/A _2851_/A gf180mcu_as_sc_mcu7t3v3__clkbuff_12
XFILLER_10_586 VDD VDD VSS VSS gf180mcu_as_sc_mcu7t3v3__fillcap_8
XFILLER_194_171 VDD VDD VSS VSS gf180mcu_as_sc_mcu7t3v3__fillcap_4
XFILLER_10_597 VDD VDD VSS VSS gf180mcu_as_sc_mcu7t3v3__fillcap_16
XFILLER_41_96 VDD VDD VSS VSS gf180mcu_as_sc_mcu7t3v3__fill_1
XTAP_TAPCELL_ROW_188_2305 VDD VSS gf180mcu_as_sc_mcu7t3v3__tap_2
XFILLER_100_1568 VDD VDD VSS VSS gf180mcu_as_sc_mcu7t3v3__fill_1
XFILLER_182_377 VDD VDD VSS VSS gf180mcu_as_sc_mcu7t3v3__fillcap_8
XTAP_TAPCELL_ROW_188_2316 VDD VSS gf180mcu_as_sc_mcu7t3v3__tap_2
XFILLER_29_1049 VDD VDD VSS VSS gf180mcu_as_sc_mcu7t3v3__fill_1
Xclkbuf_leaf_30_clk_regs VDD VDD VSS VSS clkbuf_3_0__f_clk_regs/Y _5085_/CLK gf180mcu_as_sc_mcu7t3v3__clkbuff_12
XPHY_EDGE_ROW_153_3_Right_190 VDD VSS gf180mcu_as_sc_mcu7t3v3__tap_2
XFILLER_33_623 VDD VDD VSS VSS gf180mcu_as_sc_mcu7t3v3__fillcap_4
XFILLER_33_689 VDD VDD VSS VSS gf180mcu_as_sc_mcu7t3v3__fillcap_8
XFILLER_82_92 VDD VDD VSS VSS gf180mcu_as_sc_mcu7t3v3__fillcap_8
X_4790_ VDD VDD VSS VSS _4869_/CLK _4790_/D _4790_/Q gf180mcu_as_sc_mcu7t3v3__dfxtp_2
X_3810_ VDD VDD VSS VSS _3927_/A _3922_/B _3922_/A gf180mcu_as_sc_mcu7t3v3__nand2_2
XANTENNA_18 VDD VDD VSS VSS _3499_/B gf180mcu_as_sc_mcu7t3v3__diode_2
XANTENNA_29 VDD VDD VSS VSS _3217_/A gf180mcu_as_sc_mcu7t3v3__diode_2
XFILLER_203_1014 VDD VDD VSS VSS gf180mcu_as_sc_mcu7t3v3__fillcap_16
XFILLER_20_317 VDD VDD VSS VSS gf180mcu_as_sc_mcu7t3v3__fillcap_16
XFILLER_32_177 VDD VDD VSS VSS gf180mcu_as_sc_mcu7t3v3__fillcap_16
XFILLER_92_1383 VDD VDD VSS VSS gf180mcu_as_sc_mcu7t3v3__fillcap_4
XFILLER_92_1394 VDD VDD VSS VSS gf180mcu_as_sc_mcu7t3v3__fillcap_16
X_3741_ VDD VDD VSS VSS _4121_/A _3749_/B _3741_/C _4121_/D _3742_/D gf180mcu_as_sc_mcu7t3v3__ao22_2
XFILLER_105_1435 VDD VDD VSS VSS gf180mcu_as_sc_mcu7t3v3__fill_2
XFILLER_186_683 VDD VDD VSS VSS gf180mcu_as_sc_mcu7t3v3__fillcap_16
XFILLER_18_1476 VDD VDD VSS VSS gf180mcu_as_sc_mcu7t3v3__fill_2
XFILLER_53_1367 VDD VDD VSS VSS gf180mcu_as_sc_mcu7t3v3__fill_2
XFILLER_140_1348 VDD VDD VSS VSS gf180mcu_as_sc_mcu7t3v3__fillcap_16
XFILLER_174_834 VDD VDD VSS VSS gf180mcu_as_sc_mcu7t3v3__fillcap_16
XFILLER_201_492 VDD VDD VSS VSS gf180mcu_as_sc_mcu7t3v3__fillcap_16
XFILLER_9_384 VDD VDD VSS VSS gf180mcu_as_sc_mcu7t3v3__fillcap_16
X_3672_ VDD VDD VSS VSS _4046_/D _3724_/B _3672_/C _3672_/D _3674_/C gf180mcu_as_sc_mcu7t3v3__ao211_2
XFILLER_63_2 VDD VDD VSS VSS gf180mcu_as_sc_mcu7t3v3__fillcap_8
XTAP_TAPCELL_ROW_136_3_3130 VDD VSS gf180mcu_as_sc_mcu7t3v3__tap_2
X_2623_ VDD VDD VSS VSS _2624_/C _2644_/B _5262_/Q gf180mcu_as_sc_mcu7t3v3__nor2_2
X_2554_ VDD VDD VSS VSS _2795_/A _2838_/B _2554_/C _2558_/B _2765_/B gf180mcu_as_sc_mcu7t3v3__aoi31_2
XFILLER_64_1441 VDD VDD VSS VSS gf180mcu_as_sc_mcu7t3v3__fillcap_8
X_5273_ VDD VDD VSS VSS _5278_/CLK _5273_/D _5273_/Q gf180mcu_as_sc_mcu7t3v3__dfxtp_2
X_2485_ VDD VDD VSS VSS _5227_/Q _5226_/Q _2806_/D gf180mcu_as_sc_mcu7t3v3__or2_2
XFILLER_25_1414 VDD VDD VSS VSS gf180mcu_as_sc_mcu7t3v3__fill_2
X_4224_ VDD VDD VSS VSS _4253_/B _4224_/B _4224_/C _5060_/Q _5060_/D gf180mcu_as_sc_mcu7t3v3__ao22_2
XFILLER_116_1564 VDD VDD VSS VSS gf180mcu_as_sc_mcu7t3v3__fillcap_4
XFILLER_99_1504 VDD VDD VSS VSS gf180mcu_as_sc_mcu7t3v3__fillcap_4
XFILLER_99_1526 VDD VDD VSS VSS gf180mcu_as_sc_mcu7t3v3__fillcap_4
XTAP_TAPCELL_ROW_13_1014 VDD VSS gf180mcu_as_sc_mcu7t3v3__tap_2
XTAP_TAPCELL_ROW_13_1025 VDD VSS gf180mcu_as_sc_mcu7t3v3__tap_2
X_4155_ VDD VDD VSS VSS _4155_/A _4163_/B _4155_/C _4155_/D _4156_/B gf180mcu_as_sc_mcu7t3v3__ao211_2
XFILLER_151_1488 VDD VDD VSS VSS gf180mcu_as_sc_mcu7t3v3__fillcap_4
XFILLER_186_1507 VDD VDD VSS VSS gf180mcu_as_sc_mcu7t3v3__fill_2
XFILLER_28_439 VDD VDD VSS VSS gf180mcu_as_sc_mcu7t3v3__fill_2
X_3106_ VDD VDD VSS VSS _3691_/D _3115_/A _3106_/B _3106_/C _3107_/C gf180mcu_as_sc_mcu7t3v3__ao31_2
X_4086_ VDD VDD VSS VSS _4086_/A _4119_/B _4115_/B _4086_/D _4090_/A gf180mcu_as_sc_mcu7t3v3__ao211_2
XFILLER_184_1231 VDD VDD VSS VSS gf180mcu_as_sc_mcu7t3v3__fill_2
X_3037_ VDD VDD VSS VSS _3128_/A _3037_/B _3037_/C _3128_/D _3038_/D gf180mcu_as_sc_mcu7t3v3__ao211_2
XTAP_TAPCELL_ROW_30_1394 VDD VSS gf180mcu_as_sc_mcu7t3v3__tap_2
XTAP_TAPCELL_ROW_30_1383 VDD VSS gf180mcu_as_sc_mcu7t3v3__tap_2
XFILLER_102_69 VDD VDD VSS VSS gf180mcu_as_sc_mcu7t3v3__fillcap_16
XFILLER_36_494 VDD VDD VSS VSS gf180mcu_as_sc_mcu7t3v3__fillcap_16
XFILLER_178_18 VDD VDD VSS VSS gf180mcu_as_sc_mcu7t3v3__fillcap_16
XFILLER_184_1297 VDD VDD VSS VSS gf180mcu_as_sc_mcu7t3v3__fillcap_16
XFILLER_196_403 VDD VDD VSS VSS gf180mcu_as_sc_mcu7t3v3__fillcap_16
XFILLER_162_1540 VDD VDD VSS VSS gf180mcu_as_sc_mcu7t3v3__fill_1
XFILLER_71_1434 VDD VDD VSS VSS gf180mcu_as_sc_mcu7t3v3__fillcap_16
X_4988_ VDD VDD VSS VSS clkload1/A _4988_/D _4988_/Q gf180mcu_as_sc_mcu7t3v3__dfxtp_2
X_3939_ VDD VDD VSS VSS _3939_/A _4032_/B _4027_/B _3944_/C _3939_/D gf180mcu_as_sc_mcu7t3v3__aoi211_2
XFILLER_123_1568 VDD VDD VSS VSS gf180mcu_as_sc_mcu7t3v3__fill_1
XFILLER_176_171 VDD VDD VSS VSS gf180mcu_as_sc_mcu7t3v3__fillcap_4
XFILLER_176_193 VDD VDD VSS VSS gf180mcu_as_sc_mcu7t3v3__fillcap_16
XFILLER_180_804 VDD VDD VSS VSS gf180mcu_as_sc_mcu7t3v3__fill_1
XFILLER_30_1153 VDD VDD VSS VSS gf180mcu_as_sc_mcu7t3v3__fill_2
XFILLER_11_66 VDD VDD VSS VSS gf180mcu_as_sc_mcu7t3v3__fillcap_4
XFILLER_11_88 VDD VDD VSS VSS gf180mcu_as_sc_mcu7t3v3__fillcap_16
XFILLER_191_1224 VDD VDD VSS VSS gf180mcu_as_sc_mcu7t3v3__fillcap_16
XFILLER_127_88 VDD VDD VSS VSS gf180mcu_as_sc_mcu7t3v3__fillcap_16
XFILLER_87_48 VDD VDD VSS VSS gf180mcu_as_sc_mcu7t3v3__fillcap_16
XFILLER_28_1060 VDD VDD VSS VSS gf180mcu_as_sc_mcu7t3v3__fill_1
XTAP_TAPCELL_ROW_43_1_1573 VDD VSS gf180mcu_as_sc_mcu7t3v3__tap_2
XTAP_TAPCELL_ROW_183_2202 VDD VSS gf180mcu_as_sc_mcu7t3v3__tap_2
XFILLER_143_43 VDD VDD VSS VSS gf180mcu_as_sc_mcu7t3v3__fillcap_4
XFILLER_43_1558 VDD VDD VSS VSS gf180mcu_as_sc_mcu7t3v3__fillcap_8
XFILLER_8_1154 VDD VDD VSS VSS gf180mcu_as_sc_mcu7t3v3__fill_1
XPHY_EDGE_ROW_97_1_Left_307 VDD VSS gf180mcu_as_sc_mcu7t3v3__tap_2
XTAP_TAPCELL_ROW_7_888 VDD VSS gf180mcu_as_sc_mcu7t3v3__tap_2
XTAP_TAPCELL_ROW_7_877 VDD VSS gf180mcu_as_sc_mcu7t3v3__tap_2
XFILLER_130_1539 VDD VDD VSS VSS gf180mcu_as_sc_mcu7t3v3__fill_2
XFILLER_143_65 VDD VDD VSS VSS gf180mcu_as_sc_mcu7t3v3__fillcap_4
XFILLER_4_1029 VDD VDD VSS VSS gf180mcu_as_sc_mcu7t3v3__fill_2
XTAP_TAPCELL_ROW_53_3_2879 VDD VSS gf180mcu_as_sc_mcu7t3v3__tap_2
XFILLER_189_1186 VDD VDD VSS VSS gf180mcu_as_sc_mcu7t3v3__fillcap_4
XFILLER_28_995 VDD VDD VSS VSS gf180mcu_as_sc_mcu7t3v3__fillcap_16
XFILLER_203_702 VDD VDD VSS VSS gf180mcu_as_sc_mcu7t3v3__fillcap_16
XPHY_EDGE_ROW_106_3_Left_491 VDD VSS gf180mcu_as_sc_mcu7t3v3__tap_2
XFILLER_14_155 VDD VDD VSS VSS gf180mcu_as_sc_mcu7t3v3__fill_2
XFILLER_159_105 VDD VDD VSS VSS gf180mcu_as_sc_mcu7t3v3__fillcap_16
XFILLER_163_1348 VDD VDD VSS VSS gf180mcu_as_sc_mcu7t3v3__fillcap_8
XTAP_TAPCELL_ROW_129_1_1833 VDD VSS gf180mcu_as_sc_mcu7t3v3__tap_2
XFILLER_14_177 VDD VDD VSS VSS gf180mcu_as_sc_mcu7t3v3__fillcap_16
XFILLER_30_637 VDD VDD VSS VSS gf180mcu_as_sc_mcu7t3v3__fill_1
XFILLER_204_1345 VDD VDD VSS VSS gf180mcu_as_sc_mcu7t3v3__fillcap_16
XFILLER_7_800 VDD VDD VSS VSS gf180mcu_as_sc_mcu7t3v3__fill_2
XFILLER_204_1367 VDD VDD VSS VSS gf180mcu_as_sc_mcu7t3v3__fillcap_16
Xinput16 VDD VDD VSS VSS boot_data[4] _2715_/A gf180mcu_as_sc_mcu7t3v3__buff_12
Xinput27 VDD VDD VSS VSS dft_addr[4] _2420_/A gf180mcu_as_sc_mcu7t3v3__buff_12
XFILLER_183_675 VDD VDD VSS VSS gf180mcu_as_sc_mcu7t3v3__fill_1
XFILLER_196_1135 VDD VDD VSS VSS gf180mcu_as_sc_mcu7t3v3__fillcap_16
Xinput38 VDD VDD VSS VSS dft_wdata[3] _2709_/B gf180mcu_as_sc_mcu7t3v3__buff_12
Xinput49 VDD VDD VSS VSS east_in[14] _4046_/D gf180mcu_as_sc_mcu7t3v3__buff_12
XFILLER_183_686 VDD VDD VSS VSS gf180mcu_as_sc_mcu7t3v3__fillcap_8
XFILLER_196_1157 VDD VDD VSS VSS gf180mcu_as_sc_mcu7t3v3__fillcap_16
XFILLER_48_1403 VDD VDD VSS VSS gf180mcu_as_sc_mcu7t3v3__fill_1
XFILLER_6_387 VDD VDD VSS VSS gf180mcu_as_sc_mcu7t3v3__fillcap_4
XFILLER_174_1411 VDD VDD VSS VSS gf180mcu_as_sc_mcu7t3v3__fillcap_4
XFILLER_48_1425 VDD VDD VSS VSS gf180mcu_as_sc_mcu7t3v3__fillcap_8
XFILLER_87_1463 VDD VDD VSS VSS gf180mcu_as_sc_mcu7t3v3__fillcap_8
XFILLER_24_1491 VDD VDD VSS VSS gf180mcu_as_sc_mcu7t3v3__fillcap_8
XFILLER_0_1427 VDD VDD VSS VSS gf180mcu_as_sc_mcu7t3v3__fill_1
XFILLER_18_461 VDD VDD VSS VSS gf180mcu_as_sc_mcu7t3v3__fill_1
XPHY_EDGE_ROW_154_3_Right_191 VDD VSS gf180mcu_as_sc_mcu7t3v3__tap_2
XFILLER_93_91 VDD VDD VSS VSS gf180mcu_as_sc_mcu7t3v3__fillcap_4
X_4911_ VDD VDD VSS VSS _4946_/CLK _4911_/D _4911_/Q gf180mcu_as_sc_mcu7t3v3__dfxtp_2
XFILLER_209_1256 VDD VDD VSS VSS gf180mcu_as_sc_mcu7t3v3__fillcap_4
XFILLER_33_442 VDD VDD VSS VSS gf180mcu_as_sc_mcu7t3v3__fill_1
XFILLER_55_1418 VDD VDD VSS VSS gf180mcu_as_sc_mcu7t3v3__fillcap_16
XFILLER_146_1568 VDD VDD VSS VSS gf180mcu_as_sc_mcu7t3v3__fill_1
XFILLER_209_1278 VDD VDD VSS VSS gf180mcu_as_sc_mcu7t3v3__fillcap_16
XFILLER_33_486 VDD VDD VSS VSS gf180mcu_as_sc_mcu7t3v3__fillcap_4
X_4842_ VDD VDD VSS VSS _5280_/CLK _4842_/D _4842_/Q gf180mcu_as_sc_mcu7t3v3__dfxtp_2
XFILLER_18_1251 VDD VDD VSS VSS gf180mcu_as_sc_mcu7t3v3__fillcap_4
XFILLER_194_929 VDD VDD VSS VSS gf180mcu_as_sc_mcu7t3v3__fillcap_16
XFILLER_21_648 VDD VDD VSS VSS gf180mcu_as_sc_mcu7t3v3__fillcap_16
X_4773_ VDD VDD VSS VSS _5142_/CLK _4773_/D _4773_/Q gf180mcu_as_sc_mcu7t3v3__dfxtp_2
XFILLER_186_480 VDD VDD VSS VSS gf180mcu_as_sc_mcu7t3v3__fillcap_4
XFILLER_186_491 VDD VDD VSS VSS gf180mcu_as_sc_mcu7t3v3__fill_1
X_3724_ VDD VDD VSS VSS _4103_/A _3724_/B _3724_/C _4102_/A _3725_/C gf180mcu_as_sc_mcu7t3v3__ao22_2
XFILLER_158_193 VDD VDD VSS VSS gf180mcu_as_sc_mcu7t3v3__fill_2
X_3655_ VDD VDD VSS VSS _4927_/Q _3727_/B _3724_/C _4029_/A _3657_/C gf180mcu_as_sc_mcu7t3v3__ao22_2
XTAP_TAPCELL_ROW_48_1_1588 VDD VSS gf180mcu_as_sc_mcu7t3v3__tap_2
XFILLER_174_686 VDD VDD VSS VSS gf180mcu_as_sc_mcu7t3v3__fill_2
XFILLER_175_1208 VDD VDD VSS VSS gf180mcu_as_sc_mcu7t3v3__fillcap_16
X_2606_ VDD VDD VSS VSS _2606_/B _4766_/Q _2608_/B gf180mcu_as_sc_mcu7t3v3__xnor2_2
X_3586_ VDD VDD VSS VSS _3587_/C _3586_/C _3660_/B _3952_/A gf180mcu_as_sc_mcu7t3v3__aoi21_2
XFILLER_192_1566 VDD VDD VSS VSS gf180mcu_as_sc_mcu7t3v3__fill_2
X_2537_ VDD VDD VSS VSS _4364_/A _4370_/A _4364_/B _4365_/A gf180mcu_as_sc_mcu7t3v3__nand3_2
X_5256_ VDD VDD VSS VSS _5256_/CLK _5256_/D _5256_/Q gf180mcu_as_sc_mcu7t3v3__dfxtp_2
X_2468_ VDD VDD VSS VSS _2469_/C _4559_/S _5034_/Q _4561_/A gf180mcu_as_sc_mcu7t3v3__ao21_2
X_4207_ VDD VDD VSS VSS _4236_/B _4222_/B _4222_/C _5043_/Q _5043_/D gf180mcu_as_sc_mcu7t3v3__ao22_2
XTAP_TAPCELL_ROW_4_825 VDD VSS gf180mcu_as_sc_mcu7t3v3__tap_2
XTAP_TAPCELL_ROW_4_814 VDD VSS gf180mcu_as_sc_mcu7t3v3__tap_2
XFILLER_116_1383 VDD VDD VSS VSS gf180mcu_as_sc_mcu7t3v3__fill_1
XFILLER_25_1255 VDD VDD VSS VSS gf180mcu_as_sc_mcu7t3v3__fillcap_4
XFILLER_29_726 VDD VDD VSS VSS gf180mcu_as_sc_mcu7t3v3__fillcap_4
XPHY_EDGE_ROW_171_3_Left_556 VDD VSS gf180mcu_as_sc_mcu7t3v3__tap_2
X_5187_ VDD VDD VSS VSS clkload8/A _5187_/D _5187_/Q gf180mcu_as_sc_mcu7t3v3__dfxtp_2
X_2399_ VDD VDD VSS VSS _2802_/A _5227_/Q gf180mcu_as_sc_mcu7t3v3__inv_2
XTAP_TAPCELL_ROW_32_1445 VDD VSS gf180mcu_as_sc_mcu7t3v3__tap_2
XTAP_TAPCELL_ROW_32_1434 VDD VSS gf180mcu_as_sc_mcu7t3v3__tap_2
XFILLER_28_247 VDD VDD VSS VSS gf180mcu_as_sc_mcu7t3v3__fillcap_16
X_4138_ VDD VDD VSS VSS _4138_/A _4159_/B _4159_/C _4138_/D _4139_/D gf180mcu_as_sc_mcu7t3v3__ao22_2
X_4069_ VDD VDD VSS VSS _4069_/A _4118_/B _4118_/C _4069_/D _4070_/D gf180mcu_as_sc_mcu7t3v3__ao22_2
XFILLER_3_1084 VDD VDD VSS VSS gf180mcu_as_sc_mcu7t3v3__fill_2
XFILLER_12_604 VDD VDD VSS VSS gf180mcu_as_sc_mcu7t3v3__fillcap_8
XFILLER_25_965 VDD VDD VSS VSS gf180mcu_as_sc_mcu7t3v3__fillcap_4
XFILLER_197_756 VDD VDD VSS VSS gf180mcu_as_sc_mcu7t3v3__fillcap_8
XFILLER_24_497 VDD VDD VSS VSS gf180mcu_as_sc_mcu7t3v3__fillcap_16
XFILLER_36_1362 VDD VDD VSS VSS gf180mcu_as_sc_mcu7t3v3__fillcap_8
XTAP_TAPCELL_ROW_176_2050 VDD VSS gf180mcu_as_sc_mcu7t3v3__tap_2
XFILLER_11_158 VDD VDD VSS VSS gf180mcu_as_sc_mcu7t3v3__fillcap_8
XFILLER_164_174 VDD VDD VSS VSS gf180mcu_as_sc_mcu7t3v3__fill_1
XFILLER_197_1466 VDD VDD VSS VSS gf180mcu_as_sc_mcu7t3v3__fillcap_4
XFILLER_22_98 VDD VDD VSS VSS gf180mcu_as_sc_mcu7t3v3__fillcap_4
XFILLER_180_667 VDD VDD VSS VSS gf180mcu_as_sc_mcu7t3v3__fill_1
XFILLER_197_1488 VDD VDD VSS VSS gf180mcu_as_sc_mcu7t3v3__fillcap_16
XTAP_TAPCELL_ROW_210_2821 VDD VSS gf180mcu_as_sc_mcu7t3v3__tap_2
XTAP_TAPCELL_ROW_210_2810 VDD VSS gf180mcu_as_sc_mcu7t3v3__tap_2
XFILLER_3_379 VDD VDD VSS VSS gf180mcu_as_sc_mcu7t3v3__fill_2
XFILLER_98_69 VDD VDD VSS VSS gf180mcu_as_sc_mcu7t3v3__fillcap_16
XFILLER_154_53 VDD VDD VSS VSS gf180mcu_as_sc_mcu7t3v3__fillcap_16
XFILLER_26_1008 VDD VDD VSS VSS gf180mcu_as_sc_mcu7t3v3__fillcap_4
XTAP_TAPCELL_ROW_74_1_1667 VDD VSS gf180mcu_as_sc_mcu7t3v3__tap_2
XFILLER_134_1461 VDD VDD VSS VSS gf180mcu_as_sc_mcu7t3v3__fillcap_4
XTAP_TAPCELL_ROW_208_2750 VDD VSS gf180mcu_as_sc_mcu7t3v3__tap_2
XFILLER_170_30 VDD VDD VSS VSS gf180mcu_as_sc_mcu7t3v3__fillcap_4
XFILLER_19_236 VDD VDD VSS VSS gf180mcu_as_sc_mcu7t3v3__fillcap_4
XFILLER_47_51 VDD VDD VSS VSS gf180mcu_as_sc_mcu7t3v3__fillcap_4
XFILLER_93_139 VDD VDD VSS VSS gf180mcu_as_sc_mcu7t3v3__fill_1
XFILLER_169_1568 VDD VDD VSS VSS gf180mcu_as_sc_mcu7t3v3__fill_1
XTAP_TAPCELL_ROW_204_2658 VDD VSS gf180mcu_as_sc_mcu7t3v3__tap_2
XFILLER_16_932 VDD VDD VSS VSS gf180mcu_as_sc_mcu7t3v3__fillcap_8
XFILLER_170_85 VDD VDD VSS VSS gf180mcu_as_sc_mcu7t3v3__fillcap_16
XFILLER_34_228 VDD VDD VSS VSS gf180mcu_as_sc_mcu7t3v3__fillcap_16
XTAP_TAPCELL_ROW_204_2669 VDD VSS gf180mcu_as_sc_mcu7t3v3__tap_2
XFILLER_15_442 VDD VDD VSS VSS gf180mcu_as_sc_mcu7t3v3__fill_1
XFILLER_31_924 VDD VDD VSS VSS gf180mcu_as_sc_mcu7t3v3__fill_1
XFILLER_15_1402 VDD VDD VSS VSS gf180mcu_as_sc_mcu7t3v3__fillcap_8
XFILLER_179_72 VDD VDD VSS VSS gf180mcu_as_sc_mcu7t3v3__fillcap_16
XFILLER_30_434 VDD VDD VSS VSS gf180mcu_as_sc_mcu7t3v3__fill_2
XFILLER_31_979 VDD VDD VSS VSS gf180mcu_as_sc_mcu7t3v3__fill_1
XFILLER_8_34 VDD VDD VSS VSS gf180mcu_as_sc_mcu7t3v3__fill_1
XFILLER_200_1017 VDD VDD VSS VSS gf180mcu_as_sc_mcu7t3v3__fillcap_16
XFILLER_183_461 VDD VDD VSS VSS gf180mcu_as_sc_mcu7t3v3__fill_1
XFILLER_184_995 VDD VDD VSS VSS gf180mcu_as_sc_mcu7t3v3__fillcap_16
XFILLER_89_1558 VDD VDD VSS VSS gf180mcu_as_sc_mcu7t3v3__fillcap_8
XFILLER_13_1181 VDD VDD VSS VSS gf180mcu_as_sc_mcu7t3v3__fillcap_8
XFILLER_13_1192 VDD VDD VSS VSS gf180mcu_as_sc_mcu7t3v3__fillcap_16
XFILLER_155_196 VDD VDD VSS VSS gf180mcu_as_sc_mcu7t3v3__fill_1
X_3440_ VDD VDD VSS VSS _4935_/Q _3486_/B _3465_/C _4095_/A _3441_/C gf180mcu_as_sc_mcu7t3v3__ao22_2
X_3371_ VDD VDD VSS VSS _3442_/B _4024_/A _3372_/D gf180mcu_as_sc_mcu7t3v3__or2_2
XFILLER_170_177 VDD VDD VSS VSS gf180mcu_as_sc_mcu7t3v3__fill_2
XFILLER_3_891 VDD VDD VSS VSS gf180mcu_as_sc_mcu7t3v3__fillcap_4
X_5110_ VDD VDD VSS VSS _5280_/CLK _5110_/D _5110_/Q gf180mcu_as_sc_mcu7t3v3__dfxtp_2
XFILLER_69_158 VDD VDD VSS VSS gf180mcu_as_sc_mcu7t3v3__fill_2
X_5041_ VDD VDD VSS VSS clkload2/A _5041_/D _5041_/Q gf180mcu_as_sc_mcu7t3v3__dfxtp_2
XFILLER_61_1488 VDD VDD VSS VSS gf180mcu_as_sc_mcu7t3v3__fillcap_4
XFILLER_84_139 VDD VDD VSS VSS gf180mcu_as_sc_mcu7t3v3__fillcap_16
XFILLER_25_206 VDD VDD VSS VSS gf180mcu_as_sc_mcu7t3v3__fillcap_4
XFILLER_96_1518 VDD VDD VSS VSS gf180mcu_as_sc_mcu7t3v3__fill_2
XFILLER_20_1163 VDD VDD VSS VSS gf180mcu_as_sc_mcu7t3v3__fill_1
XFILLER_25_228 VDD VDD VSS VSS gf180mcu_as_sc_mcu7t3v3__fillcap_16
XFILLER_92_172 VDD VDD VSS VSS gf180mcu_as_sc_mcu7t3v3__fill_2
XPHY_EDGE_ROW_155_3_Right_192 VDD VSS gf180mcu_as_sc_mcu7t3v3__tap_2
XFILLER_0_1257 VDD VDD VSS VSS gf180mcu_as_sc_mcu7t3v3__fill_1
XFILLER_206_381 VDD VDD VSS VSS gf180mcu_as_sc_mcu7t3v3__fillcap_4
XFILLER_207_882 VDD VDD VSS VSS gf180mcu_as_sc_mcu7t3v3__fill_2
XFILLER_22_902 VDD VDD VSS VSS gf180mcu_as_sc_mcu7t3v3__fillcap_16
XFILLER_33_250 VDD VDD VSS VSS gf180mcu_as_sc_mcu7t3v3__fill_1
XFILLER_34_784 VDD VDD VSS VSS gf180mcu_as_sc_mcu7t3v3__fillcap_16
XFILLER_181_1256 VDD VDD VSS VSS gf180mcu_as_sc_mcu7t3v3__fillcap_4
XFILLER_181_1278 VDD VDD VSS VSS gf180mcu_as_sc_mcu7t3v3__fillcap_4
XFILLER_194_715 VDD VDD VSS VSS gf180mcu_as_sc_mcu7t3v3__fillcap_16
XFILLER_22_979 VDD VDD VSS VSS gf180mcu_as_sc_mcu7t3v3__fillcap_16
X_4825_ VDD VDD VSS VSS _5082_/CLK _4825_/D _4825_/Q gf180mcu_as_sc_mcu7t3v3__dfxtp_2
XFILLER_194_737 VDD VDD VSS VSS gf180mcu_as_sc_mcu7t3v3__fillcap_16
XFILLER_21_467 VDD VDD VSS VSS gf180mcu_as_sc_mcu7t3v3__fillcap_16
XFILLER_21_489 VDD VDD VSS VSS gf180mcu_as_sc_mcu7t3v3__fill_1
XTAP_TAPCELL_ROW_25_1271 VDD VSS gf180mcu_as_sc_mcu7t3v3__tap_2
XFILLER_120_1527 VDD VDD VSS VSS gf180mcu_as_sc_mcu7t3v3__fill_1
XFILLER_193_258 VDD VDD VSS VSS gf180mcu_as_sc_mcu7t3v3__fillcap_16
X_4756_ VDD VDD VSS VSS _5280_/CLK _4756_/D _4756_/Q gf180mcu_as_sc_mcu7t3v3__dfxtp_2
XTAP_TAPCELL_ROW_25_1282 VDD VSS gf180mcu_as_sc_mcu7t3v3__tap_2
XFILLER_146_141 VDD VDD VSS VSS gf180mcu_as_sc_mcu7t3v3__fill_1
XTAP_TAPCELL_ROW_104_3_3032 VDD VSS gf180mcu_as_sc_mcu7t3v3__tap_2
X_4687_ VDD VDD VSS VSS _4721_/A _4708_/C _4691_/D gf180mcu_as_sc_mcu7t3v3__and2_2
X_3707_ VDD VDD VSS VSS _4857_/D _3707_/C _3775_/B _4083_/A gf180mcu_as_sc_mcu7t3v3__aoi21_2
XFILLER_146_185 VDD VDD VSS VSS gf180mcu_as_sc_mcu7t3v3__fill_2
XFILLER_161_111 VDD VDD VSS VSS gf180mcu_as_sc_mcu7t3v3__fillcap_16
X_3638_ VDD VDD VSS VSS _3730_/D _3730_/A _3638_/B _3638_/C _3639_/C gf180mcu_as_sc_mcu7t3v3__ao31_2
XFILLER_118_1412 VDD VDD VSS VSS gf180mcu_as_sc_mcu7t3v3__fillcap_8
X_3569_ VDD VDD VSS VSS _3728_/C _3728_/B _3791_/B gf180mcu_as_sc_mcu7t3v3__and2_2
XTAP_TAPCELL_ROW_9_939 VDD VSS gf180mcu_as_sc_mcu7t3v3__tap_2
XTAP_TAPCELL_ROW_9_928 VDD VSS gf180mcu_as_sc_mcu7t3v3__tap_2
XFILLER_157_1483 VDD VDD VSS VSS gf180mcu_as_sc_mcu7t3v3__fill_2
XFILLER_191_18 VDD VDD VSS VSS gf180mcu_as_sc_mcu7t3v3__fillcap_16
XFILLER_1_839 VDD VDD VSS VSS gf180mcu_as_sc_mcu7t3v3__fill_1
XFILLER_66_1399 VDD VDD VSS VSS gf180mcu_as_sc_mcu7t3v3__fillcap_16
Xinput206 VDD VDD VSS VSS se_in[32] _3523_/A gf180mcu_as_sc_mcu7t3v3__buff_12
Xinput217 VDD VDD VSS VSS south_in[11] _4024_/D gf180mcu_as_sc_mcu7t3v3__buff_12
XFILLER_25_1041 VDD VDD VSS VSS gf180mcu_as_sc_mcu7t3v3__fillcap_8
XFILLER_25_1052 VDD VDD VSS VSS gf180mcu_as_sc_mcu7t3v3__fillcap_16
X_5239_ VDD VDD VSS VSS _5276_/CLK _5239_/D _5239_/Q gf180mcu_as_sc_mcu7t3v3__dfxtp_2
Xinput228 VDD VDD VSS VSS south_in[21] _4101_/D gf180mcu_as_sc_mcu7t3v3__buff_12
Xinput239 VDD VDD VSS VSS south_in[31] _3253_/A gf180mcu_as_sc_mcu7t3v3__buff_12
XFILLER_187_6 VDD VDD VSS VSS gf180mcu_as_sc_mcu7t3v3__fillcap_16
XFILLER_5_1146 VDD VDD VSS VSS gf180mcu_as_sc_mcu7t3v3__fill_2
XFILLER_84_27 VDD VDD VSS VSS gf180mcu_as_sc_mcu7t3v3__fillcap_8
XFILLER_29_578 VDD VDD VSS VSS gf180mcu_as_sc_mcu7t3v3__fillcap_16
XFILLER_16_228 VDD VDD VSS VSS gf180mcu_as_sc_mcu7t3v3__fillcap_16
XFILLER_17_43 VDD VDD VSS VSS gf180mcu_as_sc_mcu7t3v3__fillcap_16
XFILLER_83_183 VDD VDD VSS VSS gf180mcu_as_sc_mcu7t3v3__fill_2
XFILLER_186_1189 VDD VDD VSS VSS gf180mcu_as_sc_mcu7t3v3__fillcap_16
XFILLER_25_740 VDD VDD VSS VSS gf180mcu_as_sc_mcu7t3v3__fill_2
XFILLER_164_1432 VDD VDD VSS VSS gf180mcu_as_sc_mcu7t3v3__fillcap_8
XFILLER_25_784 VDD VDD VSS VSS gf180mcu_as_sc_mcu7t3v3__fill_2
XFILLER_77_1484 VDD VDD VSS VSS gf180mcu_as_sc_mcu7t3v3__fill_2
XFILLER_13_946 VDD VDD VSS VSS gf180mcu_as_sc_mcu7t3v3__fillcap_8
XFILLER_73_1348 VDD VDD VSS VSS gf180mcu_as_sc_mcu7t3v3__fillcap_8
XFILLER_9_906 VDD VDD VSS VSS gf180mcu_as_sc_mcu7t3v3__fillcap_4
XTAP_TAPCELL_ROW_195_2470 VDD VSS gf180mcu_as_sc_mcu7t3v3__tap_2
XTAP_TAPCELL_ROW_174_2009 VDD VSS gf180mcu_as_sc_mcu7t3v3__tap_2
XFILLER_129_119 VDD VDD VSS VSS gf180mcu_as_sc_mcu7t3v3__fillcap_16
XFILLER_184_214 VDD VDD VSS VSS gf180mcu_as_sc_mcu7t3v3__fillcap_16
XFILLER_32_1001 VDD VDD VSS VSS gf180mcu_as_sc_mcu7t3v3__fillcap_8
XFILLER_149_86 VDD VDD VSS VSS gf180mcu_as_sc_mcu7t3v3__fill_1
XFILLER_201_1326 VDD VDD VSS VSS gf180mcu_as_sc_mcu7t3v3__fillcap_4
XFILLER_36_1192 VDD VDD VSS VSS gf180mcu_as_sc_mcu7t3v3__fillcap_16
XTAP_TAPCELL_ROW_191_2378 VDD VSS gf180mcu_as_sc_mcu7t3v3__tap_2
XTAP_TAPCELL_ROW_191_2367 VDD VSS gf180mcu_as_sc_mcu7t3v3__tap_2
XFILLER_201_1348 VDD VDD VSS VSS gf180mcu_as_sc_mcu7t3v3__fillcap_16
XFILLER_193_1116 VDD VDD VSS VSS gf180mcu_as_sc_mcu7t3v3__fillcap_4
XFILLER_152_155 VDD VDD VSS VSS gf180mcu_as_sc_mcu7t3v3__fillcap_16
XFILLER_180_464 VDD VDD VSS VSS gf180mcu_as_sc_mcu7t3v3__fillcap_8
XFILLER_181_976 VDD VDD VSS VSS gf180mcu_as_sc_mcu7t3v3__fillcap_4
XFILLER_181_998 VDD VDD VSS VSS gf180mcu_as_sc_mcu7t3v3__fillcap_16
XFILLER_193_1138 VDD VDD VSS VSS gf180mcu_as_sc_mcu7t3v3__fillcap_16
XFILLER_152_177 VDD VDD VSS VSS gf180mcu_as_sc_mcu7t3v3__fillcap_16
XFILLER_171_1458 VDD VDD VSS VSS gf180mcu_as_sc_mcu7t3v3__fill_1
XFILLER_84_1477 VDD VDD VSS VSS gf180mcu_as_sc_mcu7t3v3__fillcap_16
XFILLER_0_883 VDD VDD VSS VSS gf180mcu_as_sc_mcu7t3v3__fill_1
XFILLER_58_61 VDD VDD VSS VSS gf180mcu_as_sc_mcu7t3v3__fill_2
XTAP_TAPCELL_ROW_130_3_3111 VDD VSS gf180mcu_as_sc_mcu7t3v3__tap_2
XTAP_TAPCELL_ROW_206_2709 VDD VSS gf180mcu_as_sc_mcu7t3v3__tap_2
XFILLER_0_894 VDD VDD VSS VSS gf180mcu_as_sc_mcu7t3v3__fill_2
XFILLER_208_613 VDD VDD VSS VSS gf180mcu_as_sc_mcu7t3v3__fillcap_16
XFILLER_1_1522 VDD VDD VSS VSS gf180mcu_as_sc_mcu7t3v3__fillcap_16
XFILLER_21_1472 VDD VDD VSS VSS gf180mcu_as_sc_mcu7t3v3__fillcap_16
XFILLER_74_161 VDD VDD VSS VSS gf180mcu_as_sc_mcu7t3v3__fillcap_4
XFILLER_74_183 VDD VDD VSS VSS gf180mcu_as_sc_mcu7t3v3__fill_1
XFILLER_35_559 VDD VDD VSS VSS gf180mcu_as_sc_mcu7t3v3__fill_1
XFILLER_15_250 VDD VDD VSS VSS gf180mcu_as_sc_mcu7t3v3__fillcap_4
XFILLER_16_795 VDD VDD VSS VSS gf180mcu_as_sc_mcu7t3v3__fillcap_8
XFILLER_91_1426 VDD VDD VSS VSS gf180mcu_as_sc_mcu7t3v3__fillcap_4
XTAP_TAPCELL_ROW_109_3_3047 VDD VSS gf180mcu_as_sc_mcu7t3v3__tap_2
X_2940_ VDD VDD VSS VSS _3794_/A _3803_/A _3283_/A gf180mcu_as_sc_mcu7t3v3__or2_2
XFILLER_188_575 VDD VDD VSS VSS gf180mcu_as_sc_mcu7t3v3__fillcap_16
XFILLER_200_69 VDD VDD VSS VSS gf180mcu_as_sc_mcu7t3v3__fillcap_16
XFILLER_30_220 VDD VDD VSS VSS gf180mcu_as_sc_mcu7t3v3__fill_2
XFILLER_56_1568 VDD VDD VSS VSS gf180mcu_as_sc_mcu7t3v3__fill_1
X_2871_ VDD VDD VSS VSS _4742_/A _2871_/B _2871_/C _4766_/D gf180mcu_as_sc_mcu7t3v3__nor3_2
XFILLER_188_597 VDD VDD VSS VSS gf180mcu_as_sc_mcu7t3v3__fillcap_16
XFILLER_203_384 VDD VDD VSS VSS gf180mcu_as_sc_mcu7t3v3__fillcap_16
XFILLER_206_1259 VDD VDD VSS VSS gf180mcu_as_sc_mcu7t3v3__fillcap_16
XFILLER_30_253 VDD VDD VSS VSS gf180mcu_as_sc_mcu7t3v3__fill_1
XFILLER_31_765 VDD VDD VSS VSS gf180mcu_as_sc_mcu7t3v3__fillcap_4
X_4610_ VDD VDD VSS VSS _5204_/Q _4622_/B _4622_/C _5205_/Q _5204_/D gf180mcu_as_sc_mcu7t3v3__ao22_2
XFILLER_191_718 VDD VDD VSS VSS gf180mcu_as_sc_mcu7t3v3__fillcap_16
XFILLER_30_297 VDD VDD VSS VSS gf180mcu_as_sc_mcu7t3v3__fillcap_4
XFILLER_11_1118 VDD VDD VSS VSS gf180mcu_as_sc_mcu7t3v3__fill_2
XFILLER_198_1049 VDD VDD VSS VSS gf180mcu_as_sc_mcu7t3v3__fillcap_16
XFILLER_209_34 VDD VDD VSS VSS gf180mcu_as_sc_mcu7t3v3__fillcap_16
X_4541_ VDD VDD VSS VSS _4541_/B _4591_/A _4548_/C gf180mcu_as_sc_mcu7t3v3__and2_2
XFILLER_128_174 VDD VDD VSS VSS gf180mcu_as_sc_mcu7t3v3__fill_1
X_4472_ VDD VDD VSS VSS _4476_/B _5075_/Q _4483_/S gf180mcu_as_sc_mcu7t3v3__nand2_2
X_3423_ VDD VDD VSS VSS _3455_/B _3423_/B _3423_/C _3424_/C gf180mcu_as_sc_mcu7t3v3__nor3_2
XTAP_TAPCELL_ROW_74_3_2942 VDD VSS gf180mcu_as_sc_mcu7t3v3__tap_2
XFILLER_97_220 VDD VDD VSS VSS gf180mcu_as_sc_mcu7t3v3__fill_2
X_3354_ VDD VDD VSS VSS _3356_/C _4007_/A _3449_/B _3354_/C gf180mcu_as_sc_mcu7t3v3__ao21_2
Xhold1105 VDD VDD VSS VSS hold1136/Y hold1105/Y gf180mcu_as_sc_mcu7t3v3__clkbuff_4
X_3285_ VDD VDD VSS VSS _3498_/S _3524_/C _3526_/B gf180mcu_as_sc_mcu7t3v3__nand2_2
XFILLER_152_1380 VDD VDD VSS VSS gf180mcu_as_sc_mcu7t3v3__fill_1
XFILLER_57_139 VDD VDD VSS VSS gf180mcu_as_sc_mcu7t3v3__fill_1
X_5024_ VDD VDD VSS VSS _5082_/CLK _5024_/D _5024_/Q gf180mcu_as_sc_mcu7t3v3__dfxtp_2
Xhold1116 VDD VDD VSS VSS hold1144/Y _4969_/D gf180mcu_as_sc_mcu7t3v3__clkbuff_4
Xhold1127 VDD VDD VSS VSS _5239_/Q _4659_/A gf180mcu_as_sc_mcu7t3v3__clkbuff_4
Xhold1138 VDD VDD VSS VSS _4967_/Q hold1138/Y gf180mcu_as_sc_mcu7t3v3__clkbuff_4
Xhold1149 VDD VDD VSS VSS _4971_/Q hold1149/Y gf180mcu_as_sc_mcu7t3v3__clkbuff_4
XFILLER_113_1375 VDD VDD VSS VSS gf180mcu_as_sc_mcu7t3v3__fill_1
XFILLER_65_150 VDD VDD VSS VSS gf180mcu_as_sc_mcu7t3v3__fillcap_4
XTAP_TAPCELL_ROW_54_3_2884 VDD VSS gf180mcu_as_sc_mcu7t3v3__tap_2
XFILLER_65_172 VDD VDD VSS VSS gf180mcu_as_sc_mcu7t3v3__fill_2
XFILLER_183_1329 VDD VDD VSS VSS gf180mcu_as_sc_mcu7t3v3__fill_1
XFILLER_198_317 VDD VDD VSS VSS gf180mcu_as_sc_mcu7t3v3__fillcap_4
XFILLER_80_131 VDD VDD VSS VSS gf180mcu_as_sc_mcu7t3v3__fillcap_4
XFILLER_0_1087 VDD VDD VSS VSS gf180mcu_as_sc_mcu7t3v3__fill_1
XPHY_EDGE_ROW_156_3_Right_193 VDD VSS gf180mcu_as_sc_mcu7t3v3__tap_2
XTAP_TAPCELL_ROW_27_1333 VDD VSS gf180mcu_as_sc_mcu7t3v3__tap_2
XTAP_TAPCELL_ROW_27_1322 VDD VSS gf180mcu_as_sc_mcu7t3v3__tap_2
XFILLER_179_564 VDD VDD VSS VSS gf180mcu_as_sc_mcu7t3v3__fill_1
XFILLER_22_732 VDD VDD VSS VSS gf180mcu_as_sc_mcu7t3v3__fill_2
XPHY_EDGE_ROW_169_1_Left_379 VDD VSS gf180mcu_as_sc_mcu7t3v3__tap_2
XFILLER_110_69 VDD VDD VSS VSS gf180mcu_as_sc_mcu7t3v3__fillcap_16
XFILLER_179_597 VDD VDD VSS VSS gf180mcu_as_sc_mcu7t3v3__fill_2
XFILLER_210_877 VDD VDD VSS VSS gf180mcu_as_sc_mcu7t3v3__fillcap_4
XFILLER_21_275 VDD VDD VSS VSS gf180mcu_as_sc_mcu7t3v3__fillcap_4
XFILLER_33_1343 VDD VDD VSS VSS gf180mcu_as_sc_mcu7t3v3__fillcap_16
XFILLER_6_909 VDD VDD VSS VSS gf180mcu_as_sc_mcu7t3v3__fillcap_16
X_4808_ VDD VDD VSS VSS _4919_/CLK _4808_/D _4808_/Q gf180mcu_as_sc_mcu7t3v3__dfxtp_2
XFILLER_119_163 VDD VDD VSS VSS gf180mcu_as_sc_mcu7t3v3__fillcap_16
XFILLER_181_206 VDD VDD VSS VSS gf180mcu_as_sc_mcu7t3v3__fillcap_4
X_4739_ VDD VDD VSS VSS _4739_/B _5271_/Q _4740_/B gf180mcu_as_sc_mcu7t3v3__or2_2
XFILLER_181_228 VDD VDD VSS VSS gf180mcu_as_sc_mcu7t3v3__fillcap_16
XFILLER_33_1398 VDD VDD VSS VSS gf180mcu_as_sc_mcu7t3v3__fill_2
XFILLER_79_27 VDD VDD VSS VSS gf180mcu_as_sc_mcu7t3v3__fillcap_4
XTAP_TAPCELL_ROW_123_1_1814 VDD VSS gf180mcu_as_sc_mcu7t3v3__tap_2
XTAP_TAPCELL_ROW_135_3_3126 VDD VSS gf180mcu_as_sc_mcu7t3v3__tap_2
XFILLER_194_1469 VDD VDD VSS VSS gf180mcu_as_sc_mcu7t3v3__fillcap_16
XFILLER_68_1439 VDD VDD VSS VSS gf180mcu_as_sc_mcu7t3v3__fillcap_8
XFILLER_134_177 VDD VDD VSS VSS gf180mcu_as_sc_mcu7t3v3__fillcap_4
XFILLER_135_88 VDD VDD VSS VSS gf180mcu_as_sc_mcu7t3v3__fill_1
XFILLER_27_1147 VDD VDD VSS VSS gf180mcu_as_sc_mcu7t3v3__fillcap_16
XFILLER_95_59 VDD VDD VSS VSS gf180mcu_as_sc_mcu7t3v3__fillcap_8
XFILLER_28_53 VDD VDD VSS VSS gf180mcu_as_sc_mcu7t3v3__fillcap_4
XFILLER_166_1505 VDD VDD VSS VSS gf180mcu_as_sc_mcu7t3v3__fill_2
XFILLER_178_2 VDD VDD VSS VSS gf180mcu_as_sc_mcu7t3v3__fillcap_16
XFILLER_17_526 VDD VDD VSS VSS gf180mcu_as_sc_mcu7t3v3__fillcap_16
XFILLER_28_86 VDD VDD VSS VSS gf180mcu_as_sc_mcu7t3v3__fillcap_16
XFILLER_56_194 VDD VDD VSS VSS gf180mcu_as_sc_mcu7t3v3__fill_2
XFILLER_71_142 VDD VDD VSS VSS gf180mcu_as_sc_mcu7t3v3__fillcap_16
XFILLER_79_1568 VDD VDD VSS VSS gf180mcu_as_sc_mcu7t3v3__fill_1
XPHY_EDGE_ROW_134_3_Left_519 VDD VSS gf180mcu_as_sc_mcu7t3v3__tap_2
XTAP_TAPCELL_ROW_69_1_1651 VDD VSS gf180mcu_as_sc_mcu7t3v3__tap_2
XTAP_TAPCELL_ROW_197_2510 VDD VSS gf180mcu_as_sc_mcu7t3v3__tap_2
XTAP_TAPCELL_ROW_193_2429 VDD VSS gf180mcu_as_sc_mcu7t3v3__tap_2
XTAP_TAPCELL_ROW_193_2418 VDD VSS gf180mcu_as_sc_mcu7t3v3__tap_2
XFILLER_157_203 VDD VDD VSS VSS gf180mcu_as_sc_mcu7t3v3__fillcap_4
XFILLER_185_501 VDD VDD VSS VSS gf180mcu_as_sc_mcu7t3v3__fillcap_16
XFILLER_207_1568 VDD VDD VSS VSS gf180mcu_as_sc_mcu7t3v3__fill_1
XTAP_TAPCELL_ROW_79_3_2957 VDD VSS gf180mcu_as_sc_mcu7t3v3__tap_2
XFILLER_185_556 VDD VDD VSS VSS gf180mcu_as_sc_mcu7t3v3__fillcap_4
XFILLER_185_578 VDD VDD VSS VSS gf180mcu_as_sc_mcu7t3v3__fillcap_16
XFILLER_200_387 VDD VDD VSS VSS gf180mcu_as_sc_mcu7t3v3__fillcap_4
XTAP_TAPCELL_ROW_11_966 VDD VSS gf180mcu_as_sc_mcu7t3v3__tap_2
XTAP_TAPCELL_ROW_49_1_1593 VDD VSS gf180mcu_as_sc_mcu7t3v3__tap_2
XFILLER_103_1566 VDD VDD VSS VSS gf180mcu_as_sc_mcu7t3v3__fill_2
XFILLER_86_1517 VDD VDD VSS VSS gf180mcu_as_sc_mcu7t3v3__fillcap_4
XTAP_TAPCELL_ROW_11_977 VDD VSS gf180mcu_as_sc_mcu7t3v3__tap_2
XFILLER_5_975 VDD VDD VSS VSS gf180mcu_as_sc_mcu7t3v3__fillcap_4
XFILLER_86_1539 VDD VDD VSS VSS gf180mcu_as_sc_mcu7t3v3__fillcap_4
XFILLER_49_1350 VDD VDD VSS VSS gf180mcu_as_sc_mcu7t3v3__fill_1
XFILLER_4_485 VDD VDD VSS VSS gf180mcu_as_sc_mcu7t3v3__fillcap_4
XTAP_TAPCELL_ROW_59_3_2899 VDD VSS gf180mcu_as_sc_mcu7t3v3__tap_2
XFILLER_79_220 VDD VDD VSS VSS gf180mcu_as_sc_mcu7t3v3__fill_2
XFILLER_136_1364 VDD VDD VSS VSS gf180mcu_as_sc_mcu7t3v3__fillcap_4
XFILLER_39_128 VDD VDD VSS VSS gf180mcu_as_sc_mcu7t3v3__fillcap_8
XFILLER_94_212 VDD VDD VSS VSS gf180mcu_as_sc_mcu7t3v3__fillcap_8
XTAP_TAPCELL_ROW_161_3_3205 VDD VSS gf180mcu_as_sc_mcu7t3v3__tap_2
X_3070_ VDD VDD VSS VSS _3129_/B _4929_/Q _3071_/D gf180mcu_as_sc_mcu7t3v3__or2_2
XFILLER_208_454 VDD VDD VSS VSS gf180mcu_as_sc_mcu7t3v3__fill_1
XFILLER_36_824 VDD VDD VSS VSS gf180mcu_as_sc_mcu7t3v3__fill_1
XFILLER_47_150 VDD VDD VSS VSS gf180mcu_as_sc_mcu7t3v3__fill_2
XFILLER_35_356 VDD VDD VSS VSS gf180mcu_as_sc_mcu7t3v3__fill_1
XFILLER_47_194 VDD VDD VSS VSS gf180mcu_as_sc_mcu7t3v3__fill_2
XFILLER_62_131 VDD VDD VSS VSS gf180mcu_as_sc_mcu7t3v3__fillcap_16
XTAP_TAPCELL_ROW_128_1_1829 VDD VSS gf180mcu_as_sc_mcu7t3v3__tap_2
X_3972_ VDD VDD VSS VSS _4982_/Q _4142_/B _4233_/B _4142_/D _4982_/D gf180mcu_as_sc_mcu7t3v3__ao22_2
XFILLER_188_372 VDD VDD VSS VSS gf180mcu_as_sc_mcu7t3v3__fillcap_4
XFILLER_31_562 VDD VDD VSS VSS gf180mcu_as_sc_mcu7t3v3__fillcap_16
X_2923_ VDD VDD VSS VSS _3791_/A _3800_/A _3531_/A gf180mcu_as_sc_mcu7t3v3__or2_2
XFILLER_108_1499 VDD VDD VSS VSS gf180mcu_as_sc_mcu7t3v3__fillcap_16
XFILLER_176_534 VDD VDD VSS VSS gf180mcu_as_sc_mcu7t3v3__fillcap_8
XFILLER_31_584 VDD VDD VSS VSS gf180mcu_as_sc_mcu7t3v3__fill_1
X_2854_ VDD VDD VSS VSS _4742_/A _4748_/B _2854_/B _2854_/C gf180mcu_as_sc_mcu7t3v3__ao21_2
XFILLER_163_206 VDD VDD VSS VSS gf180mcu_as_sc_mcu7t3v3__fillcap_4
X_2785_ VDD VDD VSS VSS _5236_/Q _4649_/A _4643_/A _5096_/Q _2786_/B gf180mcu_as_sc_mcu7t3v3__ao22_2
XTAP_TAPCELL_ROW_95_1_1730 VDD VSS gf180mcu_as_sc_mcu7t3v3__tap_2
XFILLER_116_122 VDD VDD VSS VSS gf180mcu_as_sc_mcu7t3v3__fillcap_16
X_4524_ VDD VDD VSS VSS _4524_/B _4533_/A _4531_/C gf180mcu_as_sc_mcu7t3v3__and2_2
XFILLER_116_177 VDD VDD VSS VSS gf180mcu_as_sc_mcu7t3v3__fillcap_4
X_4455_ VDD VDD VSS VSS _4458_/C _4986_/Q _4456_/S gf180mcu_as_sc_mcu7t3v3__nand2b_2
Xfanout704 VDD VDD VSS VSS _3566_/Y _3740_/C gf180mcu_as_sc_mcu7t3v3__buff_12
Xfanout715 VDD VDD VSS VSS _3128_/A _3045_/A gf180mcu_as_sc_mcu7t3v3__buff_12
X_4900__1067 VDD VDD VSS VSS _4900_/D gf180mcu_as_sc_mcu7t3v3__tiel_4
X_4386_ VDD VDD VSS VSS _4389_/C _4386_/B _4512_/A gf180mcu_as_sc_mcu7t3v3__nor2_2
X_3406_ VDD VDD VSS VSS _4056_/A _3453_/B _3453_/C _4057_/A _3407_/C gf180mcu_as_sc_mcu7t3v3__ao22_2
XFILLER_115_1415 VDD VDD VSS VSS gf180mcu_as_sc_mcu7t3v3__fill_1
XFILLER_154_1453 VDD VDD VSS VSS gf180mcu_as_sc_mcu7t3v3__fill_2
Xfanout726 VDD VDD VSS VSS _3250_/Y _3486_/B gf180mcu_as_sc_mcu7t3v3__buff_12
Xfanout737 VDD VDD VSS VSS _3128_/D _3045_/D gf180mcu_as_sc_mcu7t3v3__buff_12
Xfanout748 VDD VDD VSS VSS _2857_/Y _4733_/C gf180mcu_as_sc_mcu7t3v3__buff_12
X_3337_ VDD VDD VSS VSS _3338_/B _3989_/D _3403_/S _3337_/C gf180mcu_as_sc_mcu7t3v3__ao21_2
XFILLER_105_47 VDD VDD VSS VSS gf180mcu_as_sc_mcu7t3v3__fill_1
XFILLER_115_1459 VDD VDD VSS VSS gf180mcu_as_sc_mcu7t3v3__fillcap_8
XFILLER_85_212 VDD VDD VSS VSS gf180mcu_as_sc_mcu7t3v3__fillcap_8
Xfanout759 VDD VDD VSS VSS _4281_/S _4279_/S gf180mcu_as_sc_mcu7t3v3__buff_12
XTAP_TAPCELL_ROW_16_1078 VDD VSS gf180mcu_as_sc_mcu7t3v3__tap_2
XFILLER_22_1011 VDD VDD VSS VSS gf180mcu_as_sc_mcu7t3v3__fillcap_4
XFILLER_22_1033 VDD VDD VSS VSS gf180mcu_as_sc_mcu7t3v3__fill_2
XFILLER_65_18 VDD VDD VSS VSS gf180mcu_as_sc_mcu7t3v3__fill_1
XFILLER_6_1274 VDD VDD VSS VSS gf180mcu_as_sc_mcu7t3v3__fill_1
X_3268_ VDD VDD VSS VSS _3268_/Y _3486_/B _3268_/A gf180mcu_as_sc_mcu7t3v3__nor2_2
XTAP_TAPCELL_ROW_16_1089 VDD VSS gf180mcu_as_sc_mcu7t3v3__tap_2
XFILLER_187_1240 VDD VDD VSS VSS gf180mcu_as_sc_mcu7t3v3__fillcap_16
XFILLER_27_835 VDD VDD VSS VSS gf180mcu_as_sc_mcu7t3v3__fillcap_4
XFILLER_38_150 VDD VDD VSS VSS gf180mcu_as_sc_mcu7t3v3__fillcap_16
X_5007_ VDD VDD VSS VSS _5090_/CLK _5007_/D _5007_/Q gf180mcu_as_sc_mcu7t3v3__dfxtp_2
X_3199_ VDD VDD VSS VSS _3199_/B _4943_/Q _3213_/D gf180mcu_as_sc_mcu7t3v3__and2_2
XFILLER_187_1262 VDD VDD VSS VSS gf180mcu_as_sc_mcu7t3v3__fillcap_16
XFILLER_199_626 VDD VDD VSS VSS gf180mcu_as_sc_mcu7t3v3__fillcap_4
XFILLER_53_120 VDD VDD VSS VSS gf180mcu_as_sc_mcu7t3v3__fillcap_16
XFILLER_199_648 VDD VDD VSS VSS gf180mcu_as_sc_mcu7t3v3__fillcap_16
XFILLER_53_142 VDD VDD VSS VSS gf180mcu_as_sc_mcu7t3v3__fillcap_16
XPHY_EDGE_ROW_157_3_Right_194 VDD VSS gf180mcu_as_sc_mcu7t3v3__tap_2
XFILLER_22_551 VDD VDD VSS VSS gf180mcu_as_sc_mcu7t3v3__fillcap_4
XFILLER_122_1408 VDD VDD VSS VSS gf180mcu_as_sc_mcu7t3v3__fill_1
XFILLER_182_559 VDD VDD VSS VSS gf180mcu_as_sc_mcu7t3v3__fillcap_8
XFILLER_107_144 VDD VDD VSS VSS gf180mcu_as_sc_mcu7t3v3__fill_1
XTAP_TAPCELL_ROW_154_1_1908 VDD VSS gf180mcu_as_sc_mcu7t3v3__tap_2
XFILLER_146_43 VDD VDD VSS VSS gf180mcu_as_sc_mcu7t3v3__fill_1
XFILLER_159_1364 VDD VDD VSS VSS gf180mcu_as_sc_mcu7t3v3__fillcap_16
XFILLER_1_400 VDD VDD VSS VSS gf180mcu_as_sc_mcu7t3v3__fillcap_16
XFILLER_2_912 VDD VDD VSS VSS gf180mcu_as_sc_mcu7t3v3__fillcap_16
XFILLER_190_1119 VDD VDD VSS VSS gf180mcu_as_sc_mcu7t3v3__fillcap_16
XFILLER_46_1523 VDD VDD VSS VSS gf180mcu_as_sc_mcu7t3v3__fillcap_8
XFILLER_81_1414 VDD VDD VSS VSS gf180mcu_as_sc_mcu7t3v3__fill_2
XFILLER_81_1436 VDD VDD VSS VSS gf180mcu_as_sc_mcu7t3v3__fillcap_4
XTAP_TAPCELL_ROW_186_2266 VDD VSS gf180mcu_as_sc_mcu7t3v3__tap_2
XTAP_TAPCELL_ROW_186_2255 VDD VSS gf180mcu_as_sc_mcu7t3v3__tap_2
XFILLER_162_53 VDD VDD VSS VSS gf180mcu_as_sc_mcu7t3v3__fillcap_4
XFILLER_7_1049 VDD VDD VSS VSS gf180mcu_as_sc_mcu7t3v3__fill_1
XFILLER_18_802 VDD VDD VSS VSS gf180mcu_as_sc_mcu7t3v3__fill_2
XFILLER_18_846 VDD VDD VSS VSS gf180mcu_as_sc_mcu7t3v3__fill_2
XFILLER_206_925 VDD VDD VSS VSS gf180mcu_as_sc_mcu7t3v3__fillcap_16
XFILLER_206_947 VDD VDD VSS VSS gf180mcu_as_sc_mcu7t3v3__fillcap_8
XFILLER_189_136 VDD VDD VSS VSS gf180mcu_as_sc_mcu7t3v3__fillcap_4
XFILLER_207_1310 VDD VDD VSS VSS gf180mcu_as_sc_mcu7t3v3__fillcap_16
XFILLER_207_1332 VDD VDD VSS VSS gf180mcu_as_sc_mcu7t3v3__fillcap_16
XFILLER_13_562 VDD VDD VSS VSS gf180mcu_as_sc_mcu7t3v3__fillcap_8
XFILLER_185_320 VDD VDD VSS VSS gf180mcu_as_sc_mcu7t3v3__fillcap_8
XFILLER_185_342 VDD VDD VSS VSS gf180mcu_as_sc_mcu7t3v3__fill_1
XFILLER_199_1100 VDD VDD VSS VSS gf180mcu_as_sc_mcu7t3v3__fillcap_16
XFILLER_199_1122 VDD VDD VSS VSS gf180mcu_as_sc_mcu7t3v3__fillcap_16
XFILLER_71_72 VDD VDD VSS VSS gf180mcu_as_sc_mcu7t3v3__fillcap_4
XFILLER_145_206 VDD VDD VSS VSS gf180mcu_as_sc_mcu7t3v3__fillcap_4
XFILLER_185_364 VDD VDD VSS VSS gf180mcu_as_sc_mcu7t3v3__fill_2
XFILLER_187_72 VDD VDD VSS VSS gf180mcu_as_sc_mcu7t3v3__fillcap_16
XFILLER_201_696 VDD VDD VSS VSS gf180mcu_as_sc_mcu7t3v3__fillcap_4
XFILLER_12_1224 VDD VDD VSS VSS gf180mcu_as_sc_mcu7t3v3__fill_1
XFILLER_185_386 VDD VDD VSS VSS gf180mcu_as_sc_mcu7t3v3__fill_1
X_2570_ VDD VDD VSS VSS _5277_/Q _4708_/C _2875_/B _2571_/B gf180mcu_as_sc_mcu7t3v3__nand3_2
XFILLER_181_570 VDD VDD VSS VSS gf180mcu_as_sc_mcu7t3v3__fillcap_4
XFILLER_5_772 VDD VDD VSS VSS gf180mcu_as_sc_mcu7t3v3__fill_2
Xoutput329 VDD VDD VSS VSS _4852_/Q east_out[13] gf180mcu_as_sc_mcu7t3v3__buff_12
Xoutput318 VDD VDD VSS VSS _5479_/Y dft_rdata[1] gf180mcu_as_sc_mcu7t3v3__buff_12
X_4240_ VDD VDD VSS VSS _4256_/S _4240_/B _5076_/Q _5076_/D gf180mcu_as_sc_mcu7t3v3__mux2_2
X_4171_ VDD VDD VSS VSS _4231_/B _4197_/B _4197_/C _5009_/Q _5009_/D gf180mcu_as_sc_mcu7t3v3__ao22_2
XFILLER_67_212 VDD VDD VSS VSS gf180mcu_as_sc_mcu7t3v3__fillcap_8
XFILLER_96_80 VDD VDD VSS VSS gf180mcu_as_sc_mcu7t3v3__fillcap_16
X_3122_ VDD VDD VSS VSS _4097_/A _3163_/B _3122_/C _3122_/D _3123_/C gf180mcu_as_sc_mcu7t3v3__ao22_2
XFILLER_62_1380 VDD VDD VSS VSS gf180mcu_as_sc_mcu7t3v3__fill_1
X_3053_ VDD VDD VSS VSS _3128_/A _3053_/B _3053_/C _3128_/D _3055_/C gf180mcu_as_sc_mcu7t3v3__ao211_2
XFILLER_209_796 VDD VDD VSS VSS gf180mcu_as_sc_mcu7t3v3__fillcap_4
XFILLER_149_1555 VDD VDD VSS VSS gf180mcu_as_sc_mcu7t3v3__fill_1
XFILLER_149_1566 VDD VDD VSS VSS gf180mcu_as_sc_mcu7t3v3__fill_2
XFILLER_35_142 VDD VDD VSS VSS gf180mcu_as_sc_mcu7t3v3__fillcap_8
XFILLER_23_337 VDD VDD VSS VSS gf180mcu_as_sc_mcu7t3v3__fill_2
XFILLER_177_832 VDD VDD VSS VSS gf180mcu_as_sc_mcu7t3v3__fillcap_8
XFILLER_196_629 VDD VDD VSS VSS gf180mcu_as_sc_mcu7t3v3__fillcap_16
X_3955_ VDD VDD VSS VSS _4980_/Q _4166_/B _4231_/B _4166_/D _4980_/D gf180mcu_as_sc_mcu7t3v3__ao22_2
XFILLER_17_1157 VDD VDD VSS VSS gf180mcu_as_sc_mcu7t3v3__fillcap_16
X_2906_ VDD VDD VSS VSS _3818_/A _3510_/A _3519_/A gf180mcu_as_sc_mcu7t3v3__nor2_2
XFILLER_176_353 VDD VDD VSS VSS gf180mcu_as_sc_mcu7t3v3__fill_2
XFILLER_177_887 VDD VDD VSS VSS gf180mcu_as_sc_mcu7t3v3__fillcap_16
XFILLER_31_392 VDD VDD VSS VSS gf180mcu_as_sc_mcu7t3v3__fillcap_8
X_3886_ VDD VDD VSS VSS _3893_/B _5176_/Q _4926_/D gf180mcu_as_sc_mcu7t3v3__and2_2
XFILLER_178_1217 VDD VDD VSS VSS gf180mcu_as_sc_mcu7t3v3__fillcap_8
XFILLER_30_1335 VDD VDD VSS VSS gf180mcu_as_sc_mcu7t3v3__fillcap_4
XFILLER_69_1501 VDD VDD VSS VSS gf180mcu_as_sc_mcu7t3v3__fill_2
Xclkbuf_leaf_0_clk_regs VDD VDD VSS VSS clkbuf_leaf_2_clk_regs/A _4924_/CLK gf180mcu_as_sc_mcu7t3v3__clkbuff_12
X_2837_ VDD VDD VSS VSS _4746_/C _4748_/B gf180mcu_as_sc_mcu7t3v3__inv_2
XFILLER_121_1485 VDD VDD VSS VSS gf180mcu_as_sc_mcu7t3v3__fill_1
XFILLER_195_1520 VDD VDD VSS VSS gf180mcu_as_sc_mcu7t3v3__fillcap_16
XFILLER_195_1542 VDD VDD VSS VSS gf180mcu_as_sc_mcu7t3v3__fill_2
X_2768_ VDD VDD VSS VSS _2792_/A _5227_/Q _2845_/B gf180mcu_as_sc_mcu7t3v3__and2_2
X_4507_ VDD VDD VSS VSS _4511_/B _5079_/Q _4559_/S gf180mcu_as_sc_mcu7t3v3__nand2_2
X_2699_ VDD VDD VSS VSS _2699_/A _2699_/B _2699_/C _4262_/B _2701_/C gf180mcu_as_sc_mcu7t3v3__ao211_2
XFILLER_191_1417 VDD VDD VSS VSS gf180mcu_as_sc_mcu7t3v3__fillcap_16
X_4438_ VDD VDD VSS VSS _4542_/A _5013_/Q _5042_/Q _4439_/B gf180mcu_as_sc_mcu7t3v3__mux2_2
XTAP_TAPCELL_ROW_18_1129 VDD VSS gf180mcu_as_sc_mcu7t3v3__tap_2
XTAP_TAPCELL_ROW_18_1118 VDD VSS gf180mcu_as_sc_mcu7t3v3__tap_2
Xfanout512 VDD VDD VSS VSS _4582_/A _4512_/A gf180mcu_as_sc_mcu7t3v3__buff_12
Xfanout523 VDD VDD VSS VSS _3652_/D _3608_/B gf180mcu_as_sc_mcu7t3v3__buff_12
Xfanout534 VDD VDD VSS VSS _3556_/Y _3675_/B gf180mcu_as_sc_mcu7t3v3__buff_12
Xfanout545 VDD VDD VSS VSS _4540_/C _4479_/C gf180mcu_as_sc_mcu7t3v3__buff_12
Xfanout556 VDD VDD VSS VSS _3927_/Y _4105_/B gf180mcu_as_sc_mcu7t3v3__buff_12
X_4369_ VDD VDD VSS VSS _4370_/C _4369_/C _4369_/B _4512_/A gf180mcu_as_sc_mcu7t3v3__aoi21b_2
XFILLER_28_1297 VDD VDD VSS VSS gf180mcu_as_sc_mcu7t3v3__fillcap_16
Xfanout567 VDD VDD VSS VSS _4255_/S _4253_/S gf180mcu_as_sc_mcu7t3v3__buff_12
Xfanout578 VDD VDD VSS VSS _3514_/B _3523_/B gf180mcu_as_sc_mcu7t3v3__buff_12
Xfanout589 VDD VDD VSS VSS _3182_/B _3124_/B gf180mcu_as_sc_mcu7t3v3__buff_12
XTAP_TAPCELL_ROW_35_1498 VDD VSS gf180mcu_as_sc_mcu7t3v3__tap_2
XFILLER_27_610 VDD VDD VSS VSS gf180mcu_as_sc_mcu7t3v3__fillcap_16
XFILLER_73_204 VDD VDD VSS VSS gf180mcu_as_sc_mcu7t3v3__fillcap_4
Xmesh_tile_971 VDD VDD VSS VSS north_out[12] gf180mcu_as_sc_mcu7t3v3__tiel_4
Xmesh_tile_960 VDD VDD VSS VSS north_out[1] gf180mcu_as_sc_mcu7t3v3__tiel_4
XTAP_TAPCELL_ROW_181_2163 VDD VSS gf180mcu_as_sc_mcu7t3v3__tap_2
XTAP_TAPCELL_ROW_181_2152 VDD VSS gf180mcu_as_sc_mcu7t3v3__tap_2
XFILLER_27_632 VDD VDD VSS VSS gf180mcu_as_sc_mcu7t3v3__fillcap_16
Xmesh_tile_993 VDD VDD VSS VSS nw_out[0] gf180mcu_as_sc_mcu7t3v3__tiel_4
Xmesh_tile_982 VDD VDD VSS VSS north_out[23] gf180mcu_as_sc_mcu7t3v3__tiel_4
XTAP_TAPCELL_ROW_2_775 VDD VSS gf180mcu_as_sc_mcu7t3v3__tap_2
XTAP_TAPCELL_ROW_2_764 VDD VSS gf180mcu_as_sc_mcu7t3v3__tap_2
XFILLER_203_906 VDD VDD VSS VSS gf180mcu_as_sc_mcu7t3v3__fillcap_4
XFILLER_203_928 VDD VDD VSS VSS gf180mcu_as_sc_mcu7t3v3__fillcap_16
XFILLER_25_43 VDD VDD VSS VSS gf180mcu_as_sc_mcu7t3v3__fillcap_16
XFILLER_199_478 VDD VDD VSS VSS gf180mcu_as_sc_mcu7t3v3__fillcap_8
XFILLER_202_427 VDD VDD VSS VSS gf180mcu_as_sc_mcu7t3v3__fill_2
XFILLER_39_1382 VDD VDD VSS VSS gf180mcu_as_sc_mcu7t3v3__fillcap_8
XFILLER_179_180 VDD VDD VSS VSS gf180mcu_as_sc_mcu7t3v3__fillcap_4
XFILLER_35_1224 VDD VDD VSS VSS gf180mcu_as_sc_mcu7t3v3__fillcap_16
XPHY_EDGE_ROW_158_3_Right_195 VDD VSS gf180mcu_as_sc_mcu7t3v3__tap_2
Xwire902 VDD VDD VSS VSS wire902/A _3913_/A gf180mcu_as_sc_mcu7t3v3__clkbuff_12
XFILLER_210_2 VDD VDD VSS VSS gf180mcu_as_sc_mcu7t3v3__fillcap_16
XFILLER_41_42 VDD VDD VSS VSS gf180mcu_as_sc_mcu7t3v3__fill_2
XFILLER_100_1503 VDD VDD VSS VSS gf180mcu_as_sc_mcu7t3v3__fillcap_8
XFILLER_182_345 VDD VDD VSS VSS gf180mcu_as_sc_mcu7t3v3__fillcap_16
XFILLER_6_569 VDD VDD VSS VSS gf180mcu_as_sc_mcu7t3v3__fill_1
XTAP_TAPCELL_ROW_173_1_1963 VDD VSS gf180mcu_as_sc_mcu7t3v3__tap_2
XFILLER_191_890 VDD VDD VSS VSS gf180mcu_as_sc_mcu7t3v3__fillcap_16
XTAP_TAPCELL_ROW_188_2317 VDD VSS gf180mcu_as_sc_mcu7t3v3__tap_2
XTAP_TAPCELL_ROW_188_2306 VDD VSS gf180mcu_as_sc_mcu7t3v3__tap_2
XFILLER_150_220 VDD VDD VSS VSS gf180mcu_as_sc_mcu7t3v3__fill_2
XFILLER_172_1383 VDD VDD VSS VSS gf180mcu_as_sc_mcu7t3v3__fillcap_16
XFILLER_46_1364 VDD VDD VSS VSS gf180mcu_as_sc_mcu7t3v3__fillcap_16
XFILLER_49_212 VDD VDD VSS VSS gf180mcu_as_sc_mcu7t3v3__fillcap_8
XFILLER_20_1515 VDD VDD VSS VSS gf180mcu_as_sc_mcu7t3v3__fillcap_4
X_4976__1099 VDD VDD VSS VSS _4976_/D gf180mcu_as_sc_mcu7t3v3__tiel_4
XFILLER_17_186 VDD VDD VSS VSS gf180mcu_as_sc_mcu7t3v3__fillcap_4
XFILLER_205_276 VDD VDD VSS VSS gf180mcu_as_sc_mcu7t3v3__fillcap_4
XFILLER_205_298 VDD VDD VSS VSS gf180mcu_as_sc_mcu7t3v3__fillcap_16
XFILLER_82_60 VDD VDD VSS VSS gf180mcu_as_sc_mcu7t3v3__fillcap_16
XANTENNA_19 VDD VDD VSS VSS _3624_/B gf180mcu_as_sc_mcu7t3v3__diode_2
XFILLER_109_1550 VDD VDD VSS VSS gf180mcu_as_sc_mcu7t3v3__fillcap_4
XFILLER_14_893 VDD VDD VSS VSS gf180mcu_as_sc_mcu7t3v3__fillcap_4
XFILLER_177_128 VDD VDD VSS VSS gf180mcu_as_sc_mcu7t3v3__fillcap_8
XFILLER_92_1373 VDD VDD VSS VSS gf180mcu_as_sc_mcu7t3v3__fillcap_8
X_3740_ VDD VDD VSS VSS _4938_/Q _3740_/B _3740_/C _4120_/A _3742_/C gf180mcu_as_sc_mcu7t3v3__ao22_2
XFILLER_144_1474 VDD VDD VSS VSS gf180mcu_as_sc_mcu7t3v3__fillcap_16
XFILLER_186_662 VDD VDD VSS VSS gf180mcu_as_sc_mcu7t3v3__fill_2
XFILLER_9_341 VDD VDD VSS VSS gf180mcu_as_sc_mcu7t3v3__fillcap_8
XFILLER_9_352 VDD VDD VSS VSS gf180mcu_as_sc_mcu7t3v3__fillcap_16
XFILLER_105_1469 VDD VDD VSS VSS gf180mcu_as_sc_mcu7t3v3__fillcap_4
X_3671_ VDD VDD VSS VSS _4929_/Q _3727_/B _3724_/C _4045_/A _3672_/D gf180mcu_as_sc_mcu7t3v3__ao22_2
XFILLER_174_879 VDD VDD VSS VSS gf180mcu_as_sc_mcu7t3v3__fill_2
X_2622_ VDD VDD VSS VSS _2644_/B _4655_/B _2695_/A gf180mcu_as_sc_mcu7t3v3__nand2_2
XFILLER_12_1087 VDD VDD VSS VSS gf180mcu_as_sc_mcu7t3v3__fillcap_4
XFILLER_56_2 VDD VDD VSS VSS gf180mcu_as_sc_mcu7t3v3__fill_2
XFILLER_99_101 VDD VDD VSS VSS gf180mcu_as_sc_mcu7t3v3__fill_1
X_2553_ VDD VDD VSS VSS _5222_/Q _4703_/B _2554_/C gf180mcu_as_sc_mcu7t3v3__xnor2_2
XFILLER_141_220 VDD VDD VSS VSS gf180mcu_as_sc_mcu7t3v3__fill_2
X_5272_ VDD VDD VSS VSS _5278_/CLK _5272_/D _5272_/Q gf180mcu_as_sc_mcu7t3v3__dfxtp_2
X_2484_ VDD VDD VSS VSS _2840_/A _4637_/A _5227_/Q gf180mcu_as_sc_mcu7t3v3__nand2_2
XFILLER_64_1453 VDD VDD VSS VSS gf180mcu_as_sc_mcu7t3v3__fillcap_16
X_4223_ VDD VDD VSS VSS _4252_/B _4224_/B _4224_/C _5059_/Q _5059_/D gf180mcu_as_sc_mcu7t3v3__ao22_2
XFILLER_101_139 VDD VDD VSS VSS gf180mcu_as_sc_mcu7t3v3__fill_1
XFILLER_25_1459 VDD VDD VSS VSS gf180mcu_as_sc_mcu7t3v3__fill_1
XTAP_TAPCELL_ROW_13_1015 VDD VSS gf180mcu_as_sc_mcu7t3v3__tap_2
XTAP_TAPCELL_ROW_13_1026 VDD VSS gf180mcu_as_sc_mcu7t3v3__tap_2
X_4154_ VDD VDD VSS VSS _4154_/A _4162_/B _4160_/B _4154_/D _4155_/D gf180mcu_as_sc_mcu7t3v3__ao22_2
XFILLER_112_1429 VDD VDD VSS VSS gf180mcu_as_sc_mcu7t3v3__fill_1
XFILLER_210_1019 VDD VDD VSS VSS gf180mcu_as_sc_mcu7t3v3__fill_1
XFILLER_3_1200 VDD VDD VSS VSS gf180mcu_as_sc_mcu7t3v3__fill_2
X_4085_ VDD VDD VSS VSS _4085_/A _4118_/B _4118_/C _4085_/D _4086_/D gf180mcu_as_sc_mcu7t3v3__ao22_2
X_3105_ VDD VDD VSS VSS _3106_/C _3105_/C _3150_/C _4077_/A gf180mcu_as_sc_mcu7t3v3__aoi21_2
XFILLER_23_1172 VDD VDD VSS VSS gf180mcu_as_sc_mcu7t3v3__fillcap_4
X_3036_ VDD VDD VSS VSS _4014_/A _3127_/B _3127_/C _4013_/D _3037_/C gf180mcu_as_sc_mcu7t3v3__ao22_2
XFILLER_102_37 VDD VDD VSS VSS gf180mcu_as_sc_mcu7t3v3__fillcap_16
XFILLER_184_1221 VDD VDD VSS VSS gf180mcu_as_sc_mcu7t3v3__fillcap_4
XFILLER_70_218 VDD VDD VSS VSS gf180mcu_as_sc_mcu7t3v3__fillcap_4
XTAP_TAPCELL_ROW_30_1395 VDD VSS gf180mcu_as_sc_mcu7t3v3__tap_2
XTAP_TAPCELL_ROW_30_1384 VDD VSS gf180mcu_as_sc_mcu7t3v3__tap_2
XFILLER_19_1208 VDD VDD VSS VSS gf180mcu_as_sc_mcu7t3v3__fillcap_16
XFILLER_24_624 VDD VDD VSS VSS gf180mcu_as_sc_mcu7t3v3__fillcap_16
XFILLER_23_134 VDD VDD VSS VSS gf180mcu_as_sc_mcu7t3v3__fillcap_4
XFILLER_168_139 VDD VDD VSS VSS gf180mcu_as_sc_mcu7t3v3__fill_1
X_4987_ VDD VDD VSS VSS clkload1/A _4987_/D _4987_/Q gf180mcu_as_sc_mcu7t3v3__dfxtp_2
XFILLER_177_651 VDD VDD VSS VSS gf180mcu_as_sc_mcu7t3v3__fill_2
XFILLER_20_852 VDD VDD VSS VSS gf180mcu_as_sc_mcu7t3v3__fillcap_4
XFILLER_32_1419 VDD VDD VSS VSS gf180mcu_as_sc_mcu7t3v3__fill_2
XFILLER_36_1566 VDD VDD VSS VSS gf180mcu_as_sc_mcu7t3v3__fill_2
X_3938_ VDD VDD VSS VSS _3938_/A _4032_/C _4030_/B _3938_/D _3939_/D gf180mcu_as_sc_mcu7t3v3__ao22_2
XFILLER_123_1558 VDD VDD VSS VSS gf180mcu_as_sc_mcu7t3v3__fillcap_8
XFILLER_20_874 VDD VDD VSS VSS gf180mcu_as_sc_mcu7t3v3__fill_1
X_3869_ VDD VDD VSS VSS _3869_/A _3869_/B _3869_/C _3869_/D _4339_/B gf180mcu_as_sc_mcu7t3v3__nand4_2
XFILLER_191_120 VDD VDD VSS VSS gf180mcu_as_sc_mcu7t3v3__fillcap_16
XFILLER_191_142 VDD VDD VSS VSS gf180mcu_as_sc_mcu7t3v3__fillcap_16
XFILLER_194_18 VDD VDD VSS VSS gf180mcu_as_sc_mcu7t3v3__fillcap_16
XFILLER_11_34 VDD VDD VSS VSS gf180mcu_as_sc_mcu7t3v3__fillcap_16
XFILLER_69_1364 VDD VDD VSS VSS gf180mcu_as_sc_mcu7t3v3__fillcap_4
XPHY_EDGE_ROW_143_3_Left_528 VDD VSS gf180mcu_as_sc_mcu7t3v3__tap_2
XFILLER_82_1520 VDD VDD VSS VSS gf180mcu_as_sc_mcu7t3v3__fill_1
XTAP_TAPCELL_ROW_43_1_1574 VDD VSS gf180mcu_as_sc_mcu7t3v3__tap_2
XTAP_TAPCELL_ROW_183_2203 VDD VSS gf180mcu_as_sc_mcu7t3v3__tap_2
XFILLER_28_1072 VDD VDD VSS VSS gf180mcu_as_sc_mcu7t3v3__fillcap_8
XTAP_TAPCELL_ROW_7_889 VDD VSS gf180mcu_as_sc_mcu7t3v3__tap_2
XTAP_TAPCELL_ROW_7_878 VDD VSS gf180mcu_as_sc_mcu7t3v3__tap_2
XFILLER_207_508 VDD VDD VSS VSS gf180mcu_as_sc_mcu7t3v3__fillcap_16
XFILLER_143_99 VDD VDD VSS VSS gf180mcu_as_sc_mcu7t3v3__fillcap_16
XFILLER_189_1154 VDD VDD VSS VSS gf180mcu_as_sc_mcu7t3v3__fillcap_16
XFILLER_167_1430 VDD VDD VSS VSS gf180mcu_as_sc_mcu7t3v3__fill_1
XFILLER_27_462 VDD VDD VSS VSS gf180mcu_as_sc_mcu7t3v3__fillcap_4
XFILLER_28_963 VDD VDD VSS VSS gf180mcu_as_sc_mcu7t3v3__fillcap_16
XFILLER_36_31 VDD VDD VSS VSS gf180mcu_as_sc_mcu7t3v3__fill_2
XFILLER_14_101 VDD VDD VSS VSS gf180mcu_as_sc_mcu7t3v3__fillcap_4
XFILLER_36_97 VDD VDD VSS VSS gf180mcu_as_sc_mcu7t3v3__fillcap_4
XFILLER_14_123 VDD VDD VSS VSS gf180mcu_as_sc_mcu7t3v3__fillcap_16
XFILLER_167_1485 VDD VDD VSS VSS gf180mcu_as_sc_mcu7t3v3__fill_1
XFILLER_159_139 VDD VDD VSS VSS gf180mcu_as_sc_mcu7t3v3__fill_1
XFILLER_204_1313 VDD VDD VSS VSS gf180mcu_as_sc_mcu7t3v3__fillcap_16
XPHY_EDGE_ROW_204_Right_67 VDD VSS gf180mcu_as_sc_mcu7t3v3__tap_2
XFILLER_202_279 VDD VDD VSS VSS gf180mcu_as_sc_mcu7t3v3__fillcap_16
XPHY_EDGE_ROW_159_3_Right_196 VDD VSS gf180mcu_as_sc_mcu7t3v3__tap_2
XFILLER_10_351 VDD VDD VSS VSS gf180mcu_as_sc_mcu7t3v3__fill_1
XFILLER_168_85 VDD VDD VSS VSS gf180mcu_as_sc_mcu7t3v3__fillcap_8
XFILLER_195_470 VDD VDD VSS VSS gf180mcu_as_sc_mcu7t3v3__fillcap_16
XFILLER_195_492 VDD VDD VSS VSS gf180mcu_as_sc_mcu7t3v3__fillcap_16
XFILLER_196_1103 VDD VDD VSS VSS gf180mcu_as_sc_mcu7t3v3__fillcap_16
XFILLER_52_96 VDD VDD VSS VSS gf180mcu_as_sc_mcu7t3v3__fillcap_8
Xinput17 VDD VDD VSS VSS boot_data[5] _2722_/A gf180mcu_as_sc_mcu7t3v3__buff_12
Xinput28 VDD VDD VSS VSS dft_addr[5] _2421_/A gf180mcu_as_sc_mcu7t3v3__buff_12
XFILLER_10_384 VDD VDD VSS VSS gf180mcu_as_sc_mcu7t3v3__fill_1
XFILLER_11_896 VDD VDD VSS VSS gf180mcu_as_sc_mcu7t3v3__fill_2
Xinput39 VDD VDD VSS VSS dft_wdata[4] _2716_/B gf180mcu_as_sc_mcu7t3v3__buff_12
XFILLER_183_698 VDD VDD VSS VSS gf180mcu_as_sc_mcu7t3v3__fill_2
XFILLER_202_1081 VDD VDD VSS VSS gf180mcu_as_sc_mcu7t3v3__fillcap_4
XFILLER_123_220 VDD VDD VSS VSS gf180mcu_as_sc_mcu7t3v3__fill_2
XFILLER_48_1437 VDD VDD VSS VSS gf180mcu_as_sc_mcu7t3v3__fill_2
XFILLER_100_1399 VDD VDD VSS VSS gf180mcu_as_sc_mcu7t3v3__fillcap_4
XFILLER_135_1418 VDD VDD VSS VSS gf180mcu_as_sc_mcu7t3v3__fillcap_16
XFILLER_87_1497 VDD VDD VSS VSS gf180mcu_as_sc_mcu7t3v3__fill_1
XFILLER_96_104 VDD VDD VSS VSS gf180mcu_as_sc_mcu7t3v3__fill_1
XFILLER_2_594 VDD VDD VSS VSS gf180mcu_as_sc_mcu7t3v3__fill_1
XFILLER_111_1440 VDD VDD VSS VSS gf180mcu_as_sc_mcu7t3v3__fillcap_4
XFILLER_19_952 VDD VDD VSS VSS gf180mcu_as_sc_mcu7t3v3__fill_1
XFILLER_111_1462 VDD VDD VSS VSS gf180mcu_as_sc_mcu7t3v3__fill_2
XFILLER_20_1356 VDD VDD VSS VSS gf180mcu_as_sc_mcu7t3v3__fillcap_8
XFILLER_209_1224 VDD VDD VSS VSS gf180mcu_as_sc_mcu7t3v3__fillcap_16
XFILLER_33_410 VDD VDD VSS VSS gf180mcu_as_sc_mcu7t3v3__fillcap_8
XFILLER_34_933 VDD VDD VSS VSS gf180mcu_as_sc_mcu7t3v3__fillcap_8
XFILLER_59_1566 VDD VDD VSS VSS gf180mcu_as_sc_mcu7t3v3__fill_2
XFILLER_94_1435 VDD VDD VSS VSS gf180mcu_as_sc_mcu7t3v3__fill_1
X_4910_ VDD VDD VSS VSS _4946_/CLK _4910_/D _4910_/Q gf180mcu_as_sc_mcu7t3v3__dfxtp_2
XFILLER_33_454 VDD VDD VSS VSS gf180mcu_as_sc_mcu7t3v3__fillcap_16
X_4841_ VDD VDD VSS VSS clkload6/A _4841_/D _4841_/Q gf180mcu_as_sc_mcu7t3v3__dfxtp_2
XFILLER_109_1380 VDD VDD VSS VSS gf180mcu_as_sc_mcu7t3v3__fillcap_4
XFILLER_187_960 VDD VDD VSS VSS gf180mcu_as_sc_mcu7t3v3__fillcap_16
XFILLER_187_982 VDD VDD VSS VSS gf180mcu_as_sc_mcu7t3v3__fillcap_16
X_4772_ VDD VDD VSS VSS _5197_/CLK _4772_/D _4772_/Q gf180mcu_as_sc_mcu7t3v3__dfxtp_2
X_3723_ VDD VDD VSS VSS _4859_/D _3723_/C _3775_/B _3723_/A gf180mcu_as_sc_mcu7t3v3__aoi21_2
XFILLER_9_182 VDD VDD VSS VSS gf180mcu_as_sc_mcu7t3v3__fill_2
X_3654_ VDD VDD VSS VSS _4027_/A _3661_/B _3654_/C _3654_/Y _3661_/D gf180mcu_as_sc_mcu7t3v3__aoi211_2
XTAP_TAPCELL_ROW_48_1_1589 VDD VSS gf180mcu_as_sc_mcu7t3v3__tap_2
X_2605_ VDD VDD VSS VSS _4764_/Q _4765_/Q _2831_/A _2606_/B gf180mcu_as_sc_mcu7t3v3__nor3_2
XFILLER_192_1501 VDD VDD VSS VSS gf180mcu_as_sc_mcu7t3v3__fillcap_4
X_3585_ VDD VDD VSS VSS _3948_/A _3652_/B _3585_/C _3652_/D _3586_/C gf180mcu_as_sc_mcu7t3v3__ao211_2
XFILLER_0_509 VDD VDD VSS VSS gf180mcu_as_sc_mcu7t3v3__fill_1
X_2536_ VDD VDD VSS VSS _5159_/Q _4590_/A _5158_/Q _4364_/B gf180mcu_as_sc_mcu7t3v3__nor3_2
XFILLER_87_104 VDD VDD VSS VSS gf180mcu_as_sc_mcu7t3v3__fillcap_16
XFILLER_9_1420 VDD VDD VSS VSS gf180mcu_as_sc_mcu7t3v3__fillcap_4
X_5255_ VDD VDD VSS VSS _5262_/CLK _5255_/D _5255_/Q gf180mcu_as_sc_mcu7t3v3__dfxtp_2
X_2467_ VDD VDD VSS VSS _4369_/B _2467_/C _2467_/B _4572_/A gf180mcu_as_sc_mcu7t3v3__aoi21_2
XFILLER_29_1392 VDD VDD VSS VSS gf180mcu_as_sc_mcu7t3v3__fillcap_8
X_4206_ VDD VDD VSS VSS _4235_/B _4228_/B _4228_/C _5042_/Q _5042_/D gf180mcu_as_sc_mcu7t3v3__ao22_2
XTAP_TAPCELL_ROW_4_826 VDD VSS gf180mcu_as_sc_mcu7t3v3__tap_2
XTAP_TAPCELL_ROW_4_815 VDD VSS gf180mcu_as_sc_mcu7t3v3__tap_2
XTAP_TAPCELL_ROW_32_1424 VDD VSS gf180mcu_as_sc_mcu7t3v3__tap_2
XFILLER_190_1291 VDD VDD VSS VSS gf180mcu_as_sc_mcu7t3v3__fillcap_4
XFILLER_25_1278 VDD VDD VSS VSS gf180mcu_as_sc_mcu7t3v3__fillcap_16
X_5186_ VDD VDD VSS VSS clkload3/A _5186_/D _5186_/Q gf180mcu_as_sc_mcu7t3v3__dfxtp_2
X_2398_ VDD VDD VSS VSS _2767_/A _5226_/Q gf180mcu_as_sc_mcu7t3v3__inv_2
XTAP_TAPCELL_ROW_32_1435 VDD VSS gf180mcu_as_sc_mcu7t3v3__tap_2
X_4137_ VDD VDD VSS VSS _4137_/A _4160_/C _4152_/C _4940_/Q _4139_/C gf180mcu_as_sc_mcu7t3v3__ao22_2
XFILLER_113_69 VDD VDD VSS VSS gf180mcu_as_sc_mcu7t3v3__fill_1
XFILLER_3_1052 VDD VDD VSS VSS gf180mcu_as_sc_mcu7t3v3__fillcap_16
X_4068_ VDD VDD VSS VSS _4994_/Q _4166_/B _4245_/B _4166_/D _4994_/D gf180mcu_as_sc_mcu7t3v3__ao22_2
X_3019_ VDD VDD VSS VSS _3145_/A _3019_/B _3019_/C _3145_/D _3021_/C gf180mcu_as_sc_mcu7t3v3__ao211_2
XFILLER_197_702 VDD VDD VSS VSS gf180mcu_as_sc_mcu7t3v3__fillcap_16
XFILLER_24_454 VDD VDD VSS VSS gf180mcu_as_sc_mcu7t3v3__fill_1
XFILLER_11_104 VDD VDD VSS VSS gf180mcu_as_sc_mcu7t3v3__fillcap_16
XFILLER_12_616 VDD VDD VSS VSS gf180mcu_as_sc_mcu7t3v3__fill_2
XFILLER_19_1049 VDD VDD VSS VSS gf180mcu_as_sc_mcu7t3v3__fill_1
XTAP_TAPCELL_ROW_176_2040 VDD VSS gf180mcu_as_sc_mcu7t3v3__tap_2
XFILLER_197_768 VDD VDD VSS VSS gf180mcu_as_sc_mcu7t3v3__fill_2
XTAP_TAPCELL_ROW_176_2051 VDD VSS gf180mcu_as_sc_mcu7t3v3__tap_2
XFILLER_32_1205 VDD VDD VSS VSS gf180mcu_as_sc_mcu7t3v3__fillcap_16
XFILLER_32_1227 VDD VDD VSS VSS gf180mcu_as_sc_mcu7t3v3__fillcap_4
XFILLER_36_1396 VDD VDD VSS VSS gf180mcu_as_sc_mcu7t3v3__fillcap_16
XFILLER_197_1434 VDD VDD VSS VSS gf180mcu_as_sc_mcu7t3v3__fillcap_16
XFILLER_20_693 VDD VDD VSS VSS gf180mcu_as_sc_mcu7t3v3__fill_1
XFILLER_32_1249 VDD VDD VSS VSS gf180mcu_as_sc_mcu7t3v3__fill_2
XTAP_TAPCELL_ROW_94_1_1726 VDD VSS gf180mcu_as_sc_mcu7t3v3__tap_2
XFILLER_138_77 VDD VDD VSS VSS gf180mcu_as_sc_mcu7t3v3__fillcap_4
XFILLER_158_1418 VDD VDD VSS VSS gf180mcu_as_sc_mcu7t3v3__fill_1
XFILLER_180_613 VDD VDD VSS VSS gf180mcu_as_sc_mcu7t3v3__fillcap_16
XFILLER_192_473 VDD VDD VSS VSS gf180mcu_as_sc_mcu7t3v3__fillcap_8
XFILLER_4_804 VDD VDD VSS VSS gf180mcu_as_sc_mcu7t3v3__fill_1
XTAP_TAPCELL_ROW_210_2800 VDD VSS gf180mcu_as_sc_mcu7t3v3__tap_2
XFILLER_105_220 VDD VDD VSS VSS gf180mcu_as_sc_mcu7t3v3__fill_2
XFILLER_4_837 VDD VDD VSS VSS gf180mcu_as_sc_mcu7t3v3__fillcap_4
XFILLER_98_37 VDD VDD VSS VSS gf180mcu_as_sc_mcu7t3v3__fillcap_16
XTAP_TAPCELL_ROW_210_2822 VDD VSS gf180mcu_as_sc_mcu7t3v3__tap_2
XTAP_TAPCELL_ROW_210_2811 VDD VSS gf180mcu_as_sc_mcu7t3v3__tap_2
XFILLER_180_679 VDD VDD VSS VSS gf180mcu_as_sc_mcu7t3v3__fillcap_4
XFILLER_3_347 VDD VDD VSS VSS gf180mcu_as_sc_mcu7t3v3__fill_2
XFILLER_78_115 VDD VDD VSS VSS gf180mcu_as_sc_mcu7t3v3__fill_1
XFILLER_78_126 VDD VDD VSS VSS gf180mcu_as_sc_mcu7t3v3__fillcap_16
XFILLER_47_1470 VDD VDD VSS VSS gf180mcu_as_sc_mcu7t3v3__fillcap_16
XFILLER_82_1383 VDD VDD VSS VSS gf180mcu_as_sc_mcu7t3v3__fill_2
XTAP_TAPCELL_ROW_74_1_1668 VDD VSS gf180mcu_as_sc_mcu7t3v3__tap_2
XTAP_TAPCELL_ROW_208_2751 VDD VSS gf180mcu_as_sc_mcu7t3v3__tap_2
XTAP_TAPCELL_ROW_208_2740 VDD VSS gf180mcu_as_sc_mcu7t3v3__tap_2
XFILLER_130_1348 VDD VDD VSS VSS gf180mcu_as_sc_mcu7t3v3__fillcap_16
XFILLER_78_1408 VDD VDD VSS VSS gf180mcu_as_sc_mcu7t3v3__fillcap_8
XPHY_EDGE_ROW_100_1_Right_621 VDD VSS gf180mcu_as_sc_mcu7t3v3__tap_2
XFILLER_169_1558 VDD VDD VSS VSS gf180mcu_as_sc_mcu7t3v3__fillcap_8
XFILLER_16_900 VDD VDD VSS VSS gf180mcu_as_sc_mcu7t3v3__fillcap_16
XFILLER_170_53 VDD VDD VSS VSS gf180mcu_as_sc_mcu7t3v3__fillcap_16
XFILLER_207_349 VDD VDD VSS VSS gf180mcu_as_sc_mcu7t3v3__fill_1
XTAP_TAPCELL_ROW_204_2659 VDD VSS gf180mcu_as_sc_mcu7t3v3__tap_2
XFILLER_16_944 VDD VDD VSS VSS gf180mcu_as_sc_mcu7t3v3__fill_1
XFILLER_16_955 VDD VDD VSS VSS gf180mcu_as_sc_mcu7t3v3__fill_2
XFILLER_187_212 VDD VDD VSS VSS gf180mcu_as_sc_mcu7t3v3__fillcap_4
XFILLER_106_1520 VDD VDD VSS VSS gf180mcu_as_sc_mcu7t3v3__fill_1
XFILLER_15_1414 VDD VDD VSS VSS gf180mcu_as_sc_mcu7t3v3__fill_2
XFILLER_141_1422 VDD VDD VSS VSS gf180mcu_as_sc_mcu7t3v3__fill_1
XFILLER_187_278 VDD VDD VSS VSS gf180mcu_as_sc_mcu7t3v3__fill_2
XFILLER_30_457 VDD VDD VSS VSS gf180mcu_as_sc_mcu7t3v3__fillcap_8
XFILLER_155_131 VDD VDD VSS VSS gf180mcu_as_sc_mcu7t3v3__fillcap_8
XFILLER_183_440 VDD VDD VSS VSS gf180mcu_as_sc_mcu7t3v3__fill_1
XFILLER_184_941 VDD VDD VSS VSS gf180mcu_as_sc_mcu7t3v3__fillcap_4
XFILLER_184_963 VDD VDD VSS VSS gf180mcu_as_sc_mcu7t3v3__fillcap_16
XFILLER_141_1488 VDD VDD VSS VSS gf180mcu_as_sc_mcu7t3v3__fillcap_16
XFILLER_155_153 VDD VDD VSS VSS gf180mcu_as_sc_mcu7t3v3__fillcap_4
XFILLER_176_1507 VDD VDD VSS VSS gf180mcu_as_sc_mcu7t3v3__fillcap_8
XFILLER_195_72 VDD VDD VSS VSS gf180mcu_as_sc_mcu7t3v3__fillcap_16
XFILLER_170_101 VDD VDD VSS VSS gf180mcu_as_sc_mcu7t3v3__fillcap_4
XFILLER_170_123 VDD VDD VSS VSS gf180mcu_as_sc_mcu7t3v3__fillcap_8
XFILLER_7_697 VDD VDD VSS VSS gf180mcu_as_sc_mcu7t3v3__fill_2
XFILLER_174_1242 VDD VDD VSS VSS gf180mcu_as_sc_mcu7t3v3__fillcap_16
X_3370_ VDD VDD VSS VSS _4024_/D _3449_/B _3370_/C _3401_/B _3372_/C gf180mcu_as_sc_mcu7t3v3__ao211_2
XFILLER_111_212 VDD VDD VSS VSS gf180mcu_as_sc_mcu7t3v3__fillcap_8
XFILLER_174_1286 VDD VDD VSS VSS gf180mcu_as_sc_mcu7t3v3__fillcap_4
XFILLER_26_1543 VDD VDD VSS VSS gf180mcu_as_sc_mcu7t3v3__fill_1
XFILLER_2_380 VDD VDD VSS VSS gf180mcu_as_sc_mcu7t3v3__fillcap_4
XFILLER_61_1401 VDD VDD VSS VSS gf180mcu_as_sc_mcu7t3v3__fill_1
XFILLER_69_137 VDD VDD VSS VSS gf180mcu_as_sc_mcu7t3v3__fill_2
X_5040_ VDD VDD VSS VSS clkload5/A _5040_/D _5040_/Q gf180mcu_as_sc_mcu7t3v3__dfxtp_2
XFILLER_84_107 VDD VDD VSS VSS gf180mcu_as_sc_mcu7t3v3__fillcap_16
XFILLER_22_1418 VDD VDD VSS VSS gf180mcu_as_sc_mcu7t3v3__fillcap_16
XFILLER_113_1568 VDD VDD VSS VSS gf180mcu_as_sc_mcu7t3v3__fill_1
XFILLER_20_1131 VDD VDD VSS VSS gf180mcu_as_sc_mcu7t3v3__fill_2
XFILLER_20_1153 VDD VDD VSS VSS gf180mcu_as_sc_mcu7t3v3__fill_2
XFILLER_179_702 VDD VDD VSS VSS gf180mcu_as_sc_mcu7t3v3__fillcap_4
XFILLER_209_1032 VDD VDD VSS VSS gf180mcu_as_sc_mcu7t3v3__fillcap_16
XFILLER_92_195 VDD VDD VSS VSS gf180mcu_as_sc_mcu7t3v3__fill_2
XFILLER_179_757 VDD VDD VSS VSS gf180mcu_as_sc_mcu7t3v3__fillcap_8
XFILLER_181_1224 VDD VDD VSS VSS gf180mcu_as_sc_mcu7t3v3__fillcap_16
XFILLER_146_1399 VDD VDD VSS VSS gf180mcu_as_sc_mcu7t3v3__fillcap_16
XFILLER_22_947 VDD VDD VSS VSS gf180mcu_as_sc_mcu7t3v3__fillcap_16
XFILLER_33_273 VDD VDD VSS VSS gf180mcu_as_sc_mcu7t3v3__fillcap_4
X_4824_ VDD VDD VSS VSS _5068_/CLK _4824_/D _4824_/Q gf180mcu_as_sc_mcu7t3v3__dfxtp_2
X_4755_ VDD VDD VSS VSS _5280_/CLK _4755_/D _4755_/Q gf180mcu_as_sc_mcu7t3v3__dfxtp_2
XTAP_TAPCELL_ROW_25_1272 VDD VSS gf180mcu_as_sc_mcu7t3v3__tap_2
XFILLER_174_440 VDD VDD VSS VSS gf180mcu_as_sc_mcu7t3v3__fill_2
X_3706_ VDD VDD VSS VSS _3714_/D _3730_/A _3706_/B _3706_/C _3707_/C gf180mcu_as_sc_mcu7t3v3__ao31_2
XTAP_TAPCELL_ROW_25_1283 VDD VSS gf180mcu_as_sc_mcu7t3v3__tap_2
XFILLER_146_153 VDD VDD VSS VSS gf180mcu_as_sc_mcu7t3v3__fillcap_16
XTAP_TAPCELL_ROW_104_3_3033 VDD VSS gf180mcu_as_sc_mcu7t3v3__tap_2
X_4686_ VDD VDD VSS VSS _4686_/D _4686_/A _4686_/B _4686_/C _5249_/D gf180mcu_as_sc_mcu7t3v3__ao31_2
XFILLER_179_1186 VDD VDD VSS VSS gf180mcu_as_sc_mcu7t3v3__fillcap_4
X_3637_ VDD VDD VSS VSS _3638_/C _3637_/C _3729_/B _4009_/A gf180mcu_as_sc_mcu7t3v3__aoi21_2
XTAP_TAPCELL_ROW_9_918 VDD VSS gf180mcu_as_sc_mcu7t3v3__tap_2
XFILLER_108_69 VDD VDD VSS VSS gf180mcu_as_sc_mcu7t3v3__fillcap_16
Xmax_cap873 VDD VDD VSS VSS _4952_/D _3872_/A gf180mcu_as_sc_mcu7t3v3__clkbuff_12
X_3568_ VDD VDD VSS VSS _3933_/A _3649_/B _3568_/C _3568_/D _3571_/C gf180mcu_as_sc_mcu7t3v3__ao211_2
XTAP_TAPCELL_ROW_9_929 VDD VSS gf180mcu_as_sc_mcu7t3v3__tap_2
X_2519_ VDD VDD VSS VSS _4704_/B _4683_/B _2545_/B gf180mcu_as_sc_mcu7t3v3__or2_2
XFILLER_153_1348 VDD VDD VSS VSS gf180mcu_as_sc_mcu7t3v3__fillcap_16
Xinput207 VDD VDD VSS VSS se_in[33] _3528_/A gf180mcu_as_sc_mcu7t3v3__buff_12
Xinput218 VDD VDD VSS VSS south_in[12] _4031_/A gf180mcu_as_sc_mcu7t3v3__buff_12
X_3499_ VDD VDD VSS VSS _3499_/B _3525_/A _4832_/D gf180mcu_as_sc_mcu7t3v3__and2_2
X_5238_ VDD VDD VSS VSS _5276_/CLK _5238_/D _5238_/Q gf180mcu_as_sc_mcu7t3v3__dfxtp_2
Xinput229 VDD VDD VSS VSS south_in[22] _4111_/A gf180mcu_as_sc_mcu7t3v3__buff_12
XFILLER_40_1507 VDD VDD VSS VSS gf180mcu_as_sc_mcu7t3v3__fillcap_8
XFILLER_9_1294 VDD VDD VSS VSS gf180mcu_as_sc_mcu7t3v3__fillcap_8
X_5169_ VDD VDD VSS VSS clkload7/A _5169_/D _5169_/Q gf180mcu_as_sc_mcu7t3v3__dfxtp_2
XFILLER_29_557 VDD VDD VSS VSS gf180mcu_as_sc_mcu7t3v3__fill_2
XFILLER_186_1135 VDD VDD VSS VSS gf180mcu_as_sc_mcu7t3v3__fillcap_16
XFILLER_186_1157 VDD VDD VSS VSS gf180mcu_as_sc_mcu7t3v3__fillcap_16
XFILLER_77_1452 VDD VDD VSS VSS gf180mcu_as_sc_mcu7t3v3__fillcap_16
XFILLER_169_212 VDD VDD VSS VSS gf180mcu_as_sc_mcu7t3v3__fillcap_8
XFILLER_12_435 VDD VDD VSS VSS gf180mcu_as_sc_mcu7t3v3__fillcap_8
XFILLER_24_295 VDD VDD VSS VSS gf180mcu_as_sc_mcu7t3v3__fillcap_16
XFILLER_33_43 VDD VDD VSS VSS gf180mcu_as_sc_mcu7t3v3__fillcap_16
XTAP_TAPCELL_ROW_48_3_2864 VDD VSS gf180mcu_as_sc_mcu7t3v3__tap_2
XTAP_TAPCELL_ROW_195_2471 VDD VSS gf180mcu_as_sc_mcu7t3v3__tap_2
XTAP_TAPCELL_ROW_195_2460 VDD VSS gf180mcu_as_sc_mcu7t3v3__tap_2
XFILLER_12_457 VDD VDD VSS VSS gf180mcu_as_sc_mcu7t3v3__fillcap_4
XFILLER_149_43 VDD VDD VSS VSS gf180mcu_as_sc_mcu7t3v3__fillcap_16
XFILLER_32_1013 VDD VDD VSS VSS gf180mcu_as_sc_mcu7t3v3__fill_2
XTAP_TAPCELL_ROW_191_2379 VDD VSS gf180mcu_as_sc_mcu7t3v3__tap_2
XTAP_TAPCELL_ROW_191_2368 VDD VSS gf180mcu_as_sc_mcu7t3v3__tap_2
XFILLER_137_142 VDD VDD VSS VSS gf180mcu_as_sc_mcu7t3v3__fillcap_16
XFILLER_149_98 VDD VDD VSS VSS gf180mcu_as_sc_mcu7t3v3__fillcap_16
XFILLER_152_123 VDD VDD VSS VSS gf180mcu_as_sc_mcu7t3v3__fillcap_16
XFILLER_181_944 VDD VDD VSS VSS gf180mcu_as_sc_mcu7t3v3__fillcap_16
XFILLER_192_292 VDD VDD VSS VSS gf180mcu_as_sc_mcu7t3v3__fill_1
XFILLER_101_1483 VDD VDD VSS VSS gf180mcu_as_sc_mcu7t3v3__fill_2
XFILLER_101_1494 VDD VDD VSS VSS gf180mcu_as_sc_mcu7t3v3__fill_1
XFILLER_4_645 VDD VDD VSS VSS gf180mcu_as_sc_mcu7t3v3__fillcap_16
XFILLER_4_667 VDD VDD VSS VSS gf180mcu_as_sc_mcu7t3v3__fillcap_4
XFILLER_45_1418 VDD VDD VSS VSS gf180mcu_as_sc_mcu7t3v3__fill_1
XFILLER_136_1568 VDD VDD VSS VSS gf180mcu_as_sc_mcu7t3v3__fill_1
XFILLER_66_107 VDD VDD VSS VSS gf180mcu_as_sc_mcu7t3v3__fillcap_4
XTAP_TAPCELL_ROW_130_3_3112 VDD VSS gf180mcu_as_sc_mcu7t3v3__tap_2
XPHY_EDGE_ROW_101_1_Right_622 VDD VSS gf180mcu_as_sc_mcu7t3v3__tap_2
XFILLER_169_1388 VDD VDD VSS VSS gf180mcu_as_sc_mcu7t3v3__fillcap_16
XFILLER_16_741 VDD VDD VSS VSS gf180mcu_as_sc_mcu7t3v3__fill_2
XFILLER_1_1567 VDD VDD VSS VSS gf180mcu_as_sc_mcu7t3v3__fill_2
XFILLER_74_195 VDD VDD VSS VSS gf180mcu_as_sc_mcu7t3v3__fillcap_8
XFILLER_188_521 VDD VDD VSS VSS gf180mcu_as_sc_mcu7t3v3__fillcap_4
XFILLER_203_330 VDD VDD VSS VSS gf180mcu_as_sc_mcu7t3v3__fillcap_16
XFILLER_206_1205 VDD VDD VSS VSS gf180mcu_as_sc_mcu7t3v3__fillcap_16
XFILLER_15_273 VDD VDD VSS VSS gf180mcu_as_sc_mcu7t3v3__fillcap_4
XFILLER_188_543 VDD VDD VSS VSS gf180mcu_as_sc_mcu7t3v3__fillcap_16
XFILLER_200_37 VDD VDD VSS VSS gf180mcu_as_sc_mcu7t3v3__fillcap_16
XFILLER_203_352 VDD VDD VSS VSS gf180mcu_as_sc_mcu7t3v3__fillcap_16
XFILLER_206_1227 VDD VDD VSS VSS gf180mcu_as_sc_mcu7t3v3__fillcap_16
XTAP_TAPCELL_ROW_109_3_3048 VDD VSS gf180mcu_as_sc_mcu7t3v3__tap_2
X_2870_ VDD VDD VSS VSS _2870_/B _4766_/Q _2871_/C gf180mcu_as_sc_mcu7t3v3__xnor2_2
XFILLER_15_1211 VDD VDD VSS VSS gf180mcu_as_sc_mcu7t3v3__fill_2
XFILLER_175_204 VDD VDD VSS VSS gf180mcu_as_sc_mcu7t3v3__fillcap_4
XFILLER_15_1255 VDD VDD VSS VSS gf180mcu_as_sc_mcu7t3v3__fillcap_4
XFILLER_198_1017 VDD VDD VSS VSS gf180mcu_as_sc_mcu7t3v3__fillcap_16
XFILLER_30_265 VDD VDD VSS VSS gf180mcu_as_sc_mcu7t3v3__fillcap_16
XFILLER_106_1383 VDD VDD VSS VSS gf180mcu_as_sc_mcu7t3v3__fill_1
XFILLER_106_1394 VDD VDD VSS VSS gf180mcu_as_sc_mcu7t3v3__fillcap_16
XFILLER_128_142 VDD VDD VSS VSS gf180mcu_as_sc_mcu7t3v3__fillcap_4
X_4540_ VDD VDD VSS VSS _5184_/Q _4554_/B _4540_/C _5102_/Q _4541_/B gf180mcu_as_sc_mcu7t3v3__ao22_2
X_4471_ VDD VDD VSS VSS _4471_/B _4497_/A _4478_/C gf180mcu_as_sc_mcu7t3v3__and2_2
XFILLER_176_1359 VDD VDD VSS VSS gf180mcu_as_sc_mcu7t3v3__fillcap_4
X_3422_ VDD VDD VSS VSS _4070_/A _3467_/C _3445_/C _4073_/A _3423_/C gf180mcu_as_sc_mcu7t3v3__ao22_2
XTAP_TAPCELL_ROW_74_3_2943 VDD VSS gf180mcu_as_sc_mcu7t3v3__tap_2
XTAP_TAPCELL_ROW_20_1180 VDD VSS gf180mcu_as_sc_mcu7t3v3__tap_2
XFILLER_174_1072 VDD VDD VSS VSS gf180mcu_as_sc_mcu7t3v3__fillcap_16
X_3353_ VDD VDD VSS VSS _4924_/Q _3448_/B _3448_/C _4005_/A _3354_/C gf180mcu_as_sc_mcu7t3v3__ao22_2
Xhold1106 VDD VDD VSS VSS _5199_/Q _2581_/A gf180mcu_as_sc_mcu7t3v3__clkbuff_4
X_3284_ VDD VDD VSS VSS _3524_/C _3526_/B _3284_/Y gf180mcu_as_sc_mcu7t3v3__and2_2
X_5023_ VDD VDD VSS VSS _5095_/CLK _5023_/D _5023_/Q gf180mcu_as_sc_mcu7t3v3__dfxtp_2
Xhold1117 VDD VDD VSS VSS hold1146/Y _4968_/D gf180mcu_as_sc_mcu7t3v3__clkbuff_4
Xhold1128 VDD VDD VSS VSS _5273_/Q _4744_/A gf180mcu_as_sc_mcu7t3v3__clkbuff_4
Xhold1139 VDD VDD VSS VSS _4968_/Q hold1139/Y gf180mcu_as_sc_mcu7t3v3__clkbuff_4
XFILLER_26_1395 VDD VDD VSS VSS gf180mcu_as_sc_mcu7t3v3__fillcap_16
XFILLER_187_1466 VDD VDD VSS VSS gf180mcu_as_sc_mcu7t3v3__fillcap_4
XFILLER_26_527 VDD VDD VSS VSS gf180mcu_as_sc_mcu7t3v3__fillcap_4
XFILLER_0_1022 VDD VDD VSS VSS gf180mcu_as_sc_mcu7t3v3__fill_2
XFILLER_207_680 VDD VDD VSS VSS gf180mcu_as_sc_mcu7t3v3__fillcap_16
XFILLER_0_1077 VDD VDD VSS VSS gf180mcu_as_sc_mcu7t3v3__fillcap_4
XFILLER_34_571 VDD VDD VSS VSS gf180mcu_as_sc_mcu7t3v3__fillcap_8
XTAP_TAPCELL_ROW_27_1323 VDD VSS gf180mcu_as_sc_mcu7t3v3__tap_2
XFILLER_110_37 VDD VDD VSS VSS gf180mcu_as_sc_mcu7t3v3__fillcap_16
XFILLER_16_1008 VDD VDD VSS VSS gf180mcu_as_sc_mcu7t3v3__fillcap_4
XFILLER_179_543 VDD VDD VSS VSS gf180mcu_as_sc_mcu7t3v3__fillcap_8
XPHY_EDGE_ROW_152_3_Left_537 VDD VSS gf180mcu_as_sc_mcu7t3v3__tap_2
XTAP_TAPCELL_ROW_27_1334 VDD VSS gf180mcu_as_sc_mcu7t3v3__tap_2
XFILLER_179_576 VDD VDD VSS VSS gf180mcu_as_sc_mcu7t3v3__fillcap_8
XPHY_EDGE_ROW_3_Right_3 VDD VSS gf180mcu_as_sc_mcu7t3v3__tap_2
X_4807_ VDD VDD VSS VSS _5068_/CLK _4807_/D _4807_/Q gf180mcu_as_sc_mcu7t3v3__dfxtp_2
X_2999_ VDD VDD VSS VSS _3984_/A _3042_/B _3042_/C _3984_/D _3005_/B gf180mcu_as_sc_mcu7t3v3__ao22_2
XFILLER_119_142 VDD VDD VSS VSS gf180mcu_as_sc_mcu7t3v3__fillcap_8
X_4738_ VDD VDD VSS VSS _4748_/A _4749_/A _4750_/B gf180mcu_as_sc_mcu7t3v3__and2_2
XFILLER_134_123 VDD VDD VSS VSS gf180mcu_as_sc_mcu7t3v3__fillcap_4
XFILLER_194_1415 VDD VDD VSS VSS gf180mcu_as_sc_mcu7t3v3__fillcap_16
XTAP_TAPCELL_ROW_123_1_1815 VDD VSS gf180mcu_as_sc_mcu7t3v3__tap_2
X_4669_ VDD VDD VSS VSS _5112_/Q _4683_/C _4681_/C _5243_/Q _4670_/C gf180mcu_as_sc_mcu7t3v3__ao22_2
XFILLER_159_1568 VDD VDD VSS VSS gf180mcu_as_sc_mcu7t3v3__fill_1
XFILLER_194_1437 VDD VDD VSS VSS gf180mcu_as_sc_mcu7t3v3__fillcap_16
XTAP_TAPCELL_ROW_135_3_3127 VDD VSS gf180mcu_as_sc_mcu7t3v3__tap_2
XFILLER_190_785 VDD VDD VSS VSS gf180mcu_as_sc_mcu7t3v3__fillcap_16
XFILLER_1_648 VDD VDD VSS VSS gf180mcu_as_sc_mcu7t3v3__fill_2
XFILLER_88_221 VDD VDD VSS VSS gf180mcu_as_sc_mcu7t3v3__fill_1
Xclkbuf_1_1__f_clk VDD VDD VSS VSS clkbuf_0_clk/Y clkbuf_1_1__f_clk/Y gf180mcu_as_sc_mcu7t3v3__clkbuff_12
XFILLER_48_107 VDD VDD VSS VSS gf180mcu_as_sc_mcu7t3v3__fillcap_4
XFILLER_95_38 VDD VDD VSS VSS gf180mcu_as_sc_mcu7t3v3__fill_1
XFILLER_29_310 VDD VDD VSS VSS gf180mcu_as_sc_mcu7t3v3__fill_2
XFILLER_9_1091 VDD VDD VSS VSS gf180mcu_as_sc_mcu7t3v3__fill_1
XFILLER_29_343 VDD VDD VSS VSS gf180mcu_as_sc_mcu7t3v3__fillcap_4
XFILLER_40_1348 VDD VDD VSS VSS gf180mcu_as_sc_mcu7t3v3__fillcap_4
XFILLER_151_66 VDD VDD VSS VSS gf180mcu_as_sc_mcu7t3v3__fillcap_4
XFILLER_17_516 VDD VDD VSS VSS gf180mcu_as_sc_mcu7t3v3__fill_2
XFILLER_79_1558 VDD VDD VSS VSS gf180mcu_as_sc_mcu7t3v3__fillcap_8
XFILLER_151_88 VDD VDD VSS VSS gf180mcu_as_sc_mcu7t3v3__fillcap_16
XFILLER_166_1517 VDD VDD VSS VSS gf180mcu_as_sc_mcu7t3v3__fillcap_4
XFILLER_189_307 VDD VDD VSS VSS gf180mcu_as_sc_mcu7t3v3__fill_1
XTAP_TAPCELL_ROW_69_1_1652 VDD VSS gf180mcu_as_sc_mcu7t3v3__tap_2
XTAP_TAPCELL_ROW_197_2511 VDD VSS gf180mcu_as_sc_mcu7t3v3__tap_2
XTAP_TAPCELL_ROW_197_2500 VDD VSS gf180mcu_as_sc_mcu7t3v3__tap_2
XFILLER_44_53 VDD VDD VSS VSS gf180mcu_as_sc_mcu7t3v3__fillcap_16
XPHY_EDGE_ROW_84_3_Left_469 VDD VSS gf180mcu_as_sc_mcu7t3v3__tap_2
XFILLER_13_733 VDD VDD VSS VSS gf180mcu_as_sc_mcu7t3v3__fill_2
XFILLER_207_1536 VDD VDD VSS VSS gf180mcu_as_sc_mcu7t3v3__fillcap_4
XPHY_EDGE_ROW_17_Left_228 VDD VSS gf180mcu_as_sc_mcu7t3v3__tap_2
Xsram2048.u_bank1_920 VDD VDD VSS VSS sram2048.u_bank1/WEN[2] gf180mcu_as_sc_mcu7t3v3__tiel_4
XTAP_TAPCELL_ROW_193_2419 VDD VSS gf180mcu_as_sc_mcu7t3v3__tap_2
XTAP_TAPCELL_ROW_193_2408 VDD VSS gf180mcu_as_sc_mcu7t3v3__tap_2
XFILLER_13_766 VDD VDD VSS VSS gf180mcu_as_sc_mcu7t3v3__fillcap_4
XFILLER_197_384 VDD VDD VSS VSS gf180mcu_as_sc_mcu7t3v3__fillcap_8
XFILLER_200_311 VDD VDD VSS VSS gf180mcu_as_sc_mcu7t3v3__fillcap_4
XFILLER_207_1558 VDD VDD VSS VSS gf180mcu_as_sc_mcu7t3v3__fillcap_8
XTAP_TAPCELL_ROW_79_3_2958 VDD VSS gf180mcu_as_sc_mcu7t3v3__tap_2
XFILLER_13_788 VDD VDD VSS VSS gf180mcu_as_sc_mcu7t3v3__fillcap_8
XFILLER_199_1326 VDD VDD VSS VSS gf180mcu_as_sc_mcu7t3v3__fillcap_4
XFILLER_200_333 VDD VDD VSS VSS gf180mcu_as_sc_mcu7t3v3__fillcap_4
XFILLER_176_30 VDD VDD VSS VSS gf180mcu_as_sc_mcu7t3v3__fillcap_4
XFILLER_199_1348 VDD VDD VSS VSS gf180mcu_as_sc_mcu7t3v3__fillcap_16
XFILLER_8_247 VDD VDD VSS VSS gf180mcu_as_sc_mcu7t3v3__fillcap_4
XTAP_TAPCELL_ROW_11_967 VDD VSS gf180mcu_as_sc_mcu7t3v3__tap_2
XFILLER_51_1488 VDD VDD VSS VSS gf180mcu_as_sc_mcu7t3v3__fillcap_8
XTAP_TAPCELL_ROW_11_978 VDD VSS gf180mcu_as_sc_mcu7t3v3__tap_2
Xclkbuf_leaf_24_clk_regs VDD VDD VSS VSS clkbuf_3_5__f_clk_regs/Y _5111_/CLK gf180mcu_as_sc_mcu7t3v3__clkbuff_12
XFILLER_176_85 VDD VDD VSS VSS gf180mcu_as_sc_mcu7t3v3__fillcap_16
XFILLER_180_240 VDD VDD VSS VSS gf180mcu_as_sc_mcu7t3v3__fill_1
XFILLER_140_104 VDD VDD VSS VSS gf180mcu_as_sc_mcu7t3v3__fill_1
XPHY_EDGE_ROW_26_Left_237 VDD VSS gf180mcu_as_sc_mcu7t3v3__tap_2
XFILLER_69_72 VDD VDD VSS VSS gf180mcu_as_sc_mcu7t3v3__fillcap_16
XFILLER_209_978 VDD VDD VSS VSS gf180mcu_as_sc_mcu7t3v3__fill_2
XFILLER_36_814 VDD VDD VSS VSS gf180mcu_as_sc_mcu7t3v3__fill_2
XFILLER_21_1270 VDD VDD VSS VSS gf180mcu_as_sc_mcu7t3v3__fillcap_4
XPHY_EDGE_ROW_102_1_Right_623 VDD VSS gf180mcu_as_sc_mcu7t3v3__tap_2
XFILLER_23_508 VDD VDD VSS VSS gf180mcu_as_sc_mcu7t3v3__fillcap_16
XPHY_EDGE_ROW_35_Left_246 VDD VSS gf180mcu_as_sc_mcu7t3v3__tap_2
X_3971_ VDD VDD VSS VSS _3971_/A _4027_/B _3971_/C _4233_/B _4116_/A gf180mcu_as_sc_mcu7t3v3__aoi211_2
XFILLER_108_1423 VDD VDD VSS VSS gf180mcu_as_sc_mcu7t3v3__fill_1
XFILLER_16_582 VDD VDD VSS VSS gf180mcu_as_sc_mcu7t3v3__fillcap_8
XFILLER_189_874 VDD VDD VSS VSS gf180mcu_as_sc_mcu7t3v3__fillcap_16
XFILLER_204_661 VDD VDD VSS VSS gf180mcu_as_sc_mcu7t3v3__fillcap_4
XFILLER_210_108 VDD VDD VSS VSS gf180mcu_as_sc_mcu7t3v3__fill_2
X_2922_ VDD VDD VSS VSS _3807_/A _3791_/A _3800_/A gf180mcu_as_sc_mcu7t3v3__nor2_2
XFILLER_148_215 VDD VDD VSS VSS gf180mcu_as_sc_mcu7t3v3__fillcap_4
XFILLER_204_683 VDD VDD VSS VSS gf180mcu_as_sc_mcu7t3v3__fillcap_16
XFILLER_108_1489 VDD VDD VSS VSS gf180mcu_as_sc_mcu7t3v3__fill_2
X_2853_ VDD VDD VSS VSS _2854_/C _4377_/B _2853_/A gf180mcu_as_sc_mcu7t3v3__nand2_2
XTAP_TAPCELL_ROW_22_1220 VDD VSS gf180mcu_as_sc_mcu7t3v3__tap_2
X_2784_ VDD VDD VSS VSS _4647_/A _5234_/Q _2786_/C gf180mcu_as_sc_mcu7t3v3__and2_2
XTAP_TAPCELL_ROW_95_1_1731 VDD VSS gf180mcu_as_sc_mcu7t3v3__tap_2
XFILLER_116_101 VDD VDD VSS VSS gf180mcu_as_sc_mcu7t3v3__fillcap_4
XFILLER_30_1539 VDD VDD VSS VSS gf180mcu_as_sc_mcu7t3v3__fillcap_4
X_4523_ VDD VDD VSS VSS _5182_/Q _4590_/B _4575_/C _5100_/Q _4524_/B gf180mcu_as_sc_mcu7t3v3__ao22_2
XFILLER_67_1451 VDD VDD VSS VSS gf180mcu_as_sc_mcu7t3v3__fill_2
X_4454_ VDD VDD VSS VSS _4458_/B _5073_/Q _4456_/S gf180mcu_as_sc_mcu7t3v3__nand2_2
XFILLER_67_1484 VDD VDD VSS VSS gf180mcu_as_sc_mcu7t3v3__fill_2
Xfanout705 VDD VDD VSS VSS _3566_/Y _3770_/C gf180mcu_as_sc_mcu7t3v3__buff_12
X_4385_ VDD VDD VSS VSS _4385_/D _4538_/A _4385_/B _4385_/C _4386_/B gf180mcu_as_sc_mcu7t3v3__ao31_2
X_3405_ VDD VDD VSS VSS _3452_/S _4056_/D _3405_/A _3407_/B gf180mcu_as_sc_mcu7t3v3__mux2_2
XFILLER_115_1405 VDD VDD VSS VSS gf180mcu_as_sc_mcu7t3v3__fillcap_8
XFILLER_193_1492 VDD VDD VSS VSS gf180mcu_as_sc_mcu7t3v3__fill_2
XFILLER_63_1348 VDD VDD VSS VSS gf180mcu_as_sc_mcu7t3v3__fillcap_8
Xfanout716 VDD VDD VSS VSS _2948_/Y _3128_/A gf180mcu_as_sc_mcu7t3v3__buff_12
Xfanout727 VDD VDD VSS VSS _3250_/Y _3493_/B gf180mcu_as_sc_mcu7t3v3__buff_12
Xfanout738 VDD VDD VSS VSS _2902_/Y _3128_/D gf180mcu_as_sc_mcu7t3v3__buff_12
Xfanout749 VDD VDD VSS VSS _3127_/B _3076_/B gf180mcu_as_sc_mcu7t3v3__buff_12
X_3336_ VDD VDD VSS VSS _4922_/Q _3402_/B _3402_/C _3990_/A _3337_/C gf180mcu_as_sc_mcu7t3v3__ao22_2
XFILLER_6_1231 VDD VDD VSS VSS gf180mcu_as_sc_mcu7t3v3__fill_2
XTAP_TAPCELL_ROW_16_1079 VDD VSS gf180mcu_as_sc_mcu7t3v3__tap_2
XFILLER_26_1192 VDD VDD VSS VSS gf180mcu_as_sc_mcu7t3v3__fillcap_16
XPHY_EDGE_ROW_181_Right_44 VDD VSS gf180mcu_as_sc_mcu7t3v3__tap_2
X_5006_ VDD VDD VSS VSS clkload4/A _5006_/D _5006_/Q gf180mcu_as_sc_mcu7t3v3__dfxtp_2
X_3267_ VDD VDD VSS VSS _3267_/Y _3275_/B _3275_/A gf180mcu_as_sc_mcu7t3v3__nor2b_2
XFILLER_2_1117 VDD VDD VSS VSS gf180mcu_as_sc_mcu7t3v3__fillcap_8
XFILLER_6_1297 VDD VDD VSS VSS gf180mcu_as_sc_mcu7t3v3__fillcap_16
X_3198_ VDD VDD VSS VSS _3198_/B _3204_/C _3206_/C gf180mcu_as_sc_mcu7t3v3__or2_2
XFILLER_22_1078 VDD VDD VSS VSS gf180mcu_as_sc_mcu7t3v3__fillcap_4
XFILLER_27_858 VDD VDD VSS VSS gf180mcu_as_sc_mcu7t3v3__fillcap_8
XFILLER_183_1116 VDD VDD VSS VSS gf180mcu_as_sc_mcu7t3v3__fillcap_4
XFILLER_183_1138 VDD VDD VSS VSS gf180mcu_as_sc_mcu7t3v3__fillcap_16
XFILLER_126_1523 VDD VDD VSS VSS gf180mcu_as_sc_mcu7t3v3__fillcap_16
XFILLER_14_34 VDD VDD VSS VSS gf180mcu_as_sc_mcu7t3v3__fill_1
XFILLER_161_1414 VDD VDD VSS VSS gf180mcu_as_sc_mcu7t3v3__fill_2
XFILLER_210_620 VDD VDD VSS VSS gf180mcu_as_sc_mcu7t3v3__fill_1
XFILLER_210_675 VDD VDD VSS VSS gf180mcu_as_sc_mcu7t3v3__fillcap_4
XFILLER_210_686 VDD VDD VSS VSS gf180mcu_as_sc_mcu7t3v3__fillcap_4
XPHY_EDGE_ROW_190_Right_53 VDD VSS gf180mcu_as_sc_mcu7t3v3__tap_2
XFILLER_182_527 VDD VDD VSS VSS gf180mcu_as_sc_mcu7t3v3__fillcap_16
XFILLER_194_387 VDD VDD VSS VSS gf180mcu_as_sc_mcu7t3v3__fill_1
XFILLER_194_398 VDD VDD VSS VSS gf180mcu_as_sc_mcu7t3v3__fillcap_16
XTAP_TAPCELL_ROW_142_1_1870 VDD VSS gf180mcu_as_sc_mcu7t3v3__tap_2
XTAP_TAPCELL_ROW_154_3_3182 VDD VSS gf180mcu_as_sc_mcu7t3v3__tap_2
XFILLER_11_1472 VDD VDD VSS VSS gf180mcu_as_sc_mcu7t3v3__fillcap_4
XFILLER_122_104 VDD VDD VSS VSS gf180mcu_as_sc_mcu7t3v3__fill_1
XFILLER_146_88 VDD VDD VSS VSS gf180mcu_as_sc_mcu7t3v3__fillcap_4
XFILLER_46_1568 VDD VDD VSS VSS gf180mcu_as_sc_mcu7t3v3__fill_1
XTAP_TAPCELL_ROW_186_2267 VDD VSS gf180mcu_as_sc_mcu7t3v3__tap_2
XTAP_TAPCELL_ROW_186_2256 VDD VSS gf180mcu_as_sc_mcu7t3v3__tap_2
XFILLER_39_53 VDD VDD VSS VSS gf180mcu_as_sc_mcu7t3v3__fill_1
XFILLER_81_1459 VDD VDD VSS VSS gf180mcu_as_sc_mcu7t3v3__fillcap_4
XFILLER_17_302 VDD VDD VSS VSS gf180mcu_as_sc_mcu7t3v3__fill_1
XFILLER_188_1049 VDD VDD VSS VSS gf180mcu_as_sc_mcu7t3v3__fillcap_16
XFILLER_55_52 VDD VDD VSS VSS gf180mcu_as_sc_mcu7t3v3__fillcap_16
XFILLER_17_368 VDD VDD VSS VSS gf180mcu_as_sc_mcu7t3v3__fillcap_16
XFILLER_189_104 VDD VDD VSS VSS gf180mcu_as_sc_mcu7t3v3__fillcap_16
XFILLER_33_839 VDD VDD VSS VSS gf180mcu_as_sc_mcu7t3v3__fill_1
XFILLER_32_349 VDD VDD VSS VSS gf180mcu_as_sc_mcu7t3v3__fillcap_16
XFILLER_13_574 VDD VDD VSS VSS gf180mcu_as_sc_mcu7t3v3__fill_2
XFILLER_185_332 VDD VDD VSS VSS gf180mcu_as_sc_mcu7t3v3__fill_1
XFILLER_186_855 VDD VDD VSS VSS gf180mcu_as_sc_mcu7t3v3__fillcap_16
XFILLER_201_664 VDD VDD VSS VSS gf180mcu_as_sc_mcu7t3v3__fillcap_16
XFILLER_203_1208 VDD VDD VSS VSS gf180mcu_as_sc_mcu7t3v3__fillcap_16
XFILLER_9_534 VDD VDD VSS VSS gf180mcu_as_sc_mcu7t3v3__fill_1
XFILLER_186_877 VDD VDD VSS VSS gf180mcu_as_sc_mcu7t3v3__fillcap_16
XFILLER_9_578 VDD VDD VSS VSS gf180mcu_as_sc_mcu7t3v3__fill_2
XFILLER_142_1380 VDD VDD VSS VSS gf180mcu_as_sc_mcu7t3v3__fill_1
XFILLER_181_582 VDD VDD VSS VSS gf180mcu_as_sc_mcu7t3v3__fillcap_16
XFILLER_86_1348 VDD VDD VSS VSS gf180mcu_as_sc_mcu7t3v3__fillcap_16
Xoutput319 VDD VDD VSS VSS _5480_/Y dft_rdata[2] gf180mcu_as_sc_mcu7t3v3__buff_12
XFILLER_4_261 VDD VDD VSS VSS gf180mcu_as_sc_mcu7t3v3__fillcap_4
XFILLER_113_148 VDD VDD VSS VSS gf180mcu_as_sc_mcu7t3v3__fill_1
X_4170_ VDD VDD VSS VSS _4230_/B _4193_/B _4193_/C _5008_/Q _5008_/D gf180mcu_as_sc_mcu7t3v3__ao22_2
XFILLER_121_170 VDD VDD VSS VSS gf180mcu_as_sc_mcu7t3v3__fill_2
XFILLER_206_69 VDD VDD VSS VSS gf180mcu_as_sc_mcu7t3v3__fillcap_16
X_3121_ VDD VDD VSS VSS _3121_/B _4935_/Q _3122_/D gf180mcu_as_sc_mcu7t3v3__or2_2
XFILLER_23_1332 VDD VDD VSS VSS gf180mcu_as_sc_mcu7t3v3__fill_1
XFILLER_97_1411 VDD VDD VSS VSS gf180mcu_as_sc_mcu7t3v3__fillcap_4
X_3052_ VDD VDD VSS VSS _4029_/A _3127_/B _3127_/C _4031_/A _3053_/C gf180mcu_as_sc_mcu7t3v3__ao22_2
XFILLER_208_263 VDD VDD VSS VSS gf180mcu_as_sc_mcu7t3v3__fill_2
XFILLER_36_622 VDD VDD VSS VSS gf180mcu_as_sc_mcu7t3v3__fillcap_4
XFILLER_36_633 VDD VDD VSS VSS gf180mcu_as_sc_mcu7t3v3__fillcap_8
XFILLER_3_1459 VDD VDD VSS VSS gf180mcu_as_sc_mcu7t3v3__fill_1
XFILLER_23_305 VDD VDD VSS VSS gf180mcu_as_sc_mcu7t3v3__fill_2
XFILLER_97_1488 VDD VDD VSS VSS gf180mcu_as_sc_mcu7t3v3__fill_1
XFILLER_1_1183 VDD VDD VSS VSS gf180mcu_as_sc_mcu7t3v3__fillcap_4
XFILLER_50_102 VDD VDD VSS VSS gf180mcu_as_sc_mcu7t3v3__fill_2
XPHY_EDGE_ROW_103_1_Right_624 VDD VSS gf180mcu_as_sc_mcu7t3v3__tap_2
XTAP_TAPCELL_ROW_147_1_1885 VDD VSS gf180mcu_as_sc_mcu7t3v3__tap_2
XTAP_TAPCELL_ROW_159_3_3197 VDD VSS gf180mcu_as_sc_mcu7t3v3__tap_2
X_3954_ VDD VDD VSS VSS _4231_/B _3954_/B _4116_/A gf180mcu_as_sc_mcu7t3v3__nor2_2
XFILLER_50_168 VDD VDD VSS VSS gf180mcu_as_sc_mcu7t3v3__fillcap_4
X_3885_ VDD VDD VSS VSS _3890_/B _5175_/Q _4925_/D gf180mcu_as_sc_mcu7t3v3__and2_2
X_2905_ VDD VDD VSS VSS _3790_/A _3535_/A _3537_/A gf180mcu_as_sc_mcu7t3v3__or2_2
X_2836_ VDD VDD VSS VSS _4748_/B _4749_/A _4329_/A gf180mcu_as_sc_mcu7t3v3__nor2_2
XFILLER_121_1464 VDD VDD VSS VSS gf180mcu_as_sc_mcu7t3v3__fill_1
XFILLER_121_1475 VDD VDD VSS VSS gf180mcu_as_sc_mcu7t3v3__fillcap_8
XFILLER_191_346 VDD VDD VSS VSS gf180mcu_as_sc_mcu7t3v3__fillcap_4
XFILLER_191_368 VDD VDD VSS VSS gf180mcu_as_sc_mcu7t3v3__fillcap_16
X_2767_ VDD VDD VSS VSS _2767_/A _4637_/A _2840_/B _2840_/C _2770_/C gf180mcu_as_sc_mcu7t3v3__nand4_2
XFILLER_69_1568 VDD VDD VSS VSS gf180mcu_as_sc_mcu7t3v3__fill_1
X_4506_ VDD VDD VSS VSS _4506_/B _4591_/A _4513_/C gf180mcu_as_sc_mcu7t3v3__and2_2
X_2698_ VDD VDD VSS VSS _5159_/Q _4267_/S _4279_/S _5183_/Q _2699_/C gf180mcu_as_sc_mcu7t3v3__ao22_2
X_4437_ VDD VDD VSS VSS _4440_/C _4984_/Q _4500_/S gf180mcu_as_sc_mcu7t3v3__nand2b_2
XTAP_TAPCELL_ROW_18_1119 VDD VSS gf180mcu_as_sc_mcu7t3v3__tap_2
XFILLER_28_1243 VDD VDD VSS VSS gf180mcu_as_sc_mcu7t3v3__fillcap_16
Xfanout513 VDD VDD VSS VSS _4582_/A _4589_/A gf180mcu_as_sc_mcu7t3v3__buff_12
Xfanout524 VDD VDD VSS VSS _3661_/B _3652_/D gf180mcu_as_sc_mcu7t3v3__buff_12
XFILLER_116_69 VDD VDD VSS VSS gf180mcu_as_sc_mcu7t3v3__fillcap_16
Xfanout535 VDD VDD VSS VSS _3802_/B _3766_/B gf180mcu_as_sc_mcu7t3v3__buff_12
Xfanout546 VDD VDD VSS VSS _4532_/C _4540_/C gf180mcu_as_sc_mcu7t3v3__buff_12
Xfanout557 VDD VDD VSS VSS _3927_/Y _4122_/B gf180mcu_as_sc_mcu7t3v3__buff_12
X_4368_ VDD VDD VSS VSS _5482_/A _4575_/C _4368_/C _4378_/D _4369_/C gf180mcu_as_sc_mcu7t3v3__ao211_2
XFILLER_80_1470 VDD VDD VSS VSS gf180mcu_as_sc_mcu7t3v3__fillcap_16
Xfanout568 VDD VDD VSS VSS _4255_/S _4257_/S gf180mcu_as_sc_mcu7t3v3__buff_12
X_4299_ VDD VDD VSS VSS _4308_/S _5129_/Q _5128_/Q _5128_/D gf180mcu_as_sc_mcu7t3v3__mux2_2
X_3319_ VDD VDD VSS VSS _3971_/A _3463_/B _3319_/C _4809_/D _3416_/D gf180mcu_as_sc_mcu7t3v3__aoi211_2
XTAP_TAPCELL_ROW_35_1499 VDD VSS gf180mcu_as_sc_mcu7t3v3__tap_2
XFILLER_41_1454 VDD VDD VSS VSS gf180mcu_as_sc_mcu7t3v3__fillcap_16
Xmesh_tile_972 VDD VDD VSS VSS north_out[13] gf180mcu_as_sc_mcu7t3v3__tiel_4
Xmesh_tile_961 VDD VDD VSS VSS north_out[2] gf180mcu_as_sc_mcu7t3v3__tiel_4
Xmesh_tile_950 VDD VDD VSS VSS ne_out[25] gf180mcu_as_sc_mcu7t3v3__tiel_4
XTAP_TAPCELL_ROW_181_2164 VDD VSS gf180mcu_as_sc_mcu7t3v3__tap_2
XTAP_TAPCELL_ROW_181_2153 VDD VSS gf180mcu_as_sc_mcu7t3v3__tap_2
XFILLER_6_1083 VDD VDD VSS VSS gf180mcu_as_sc_mcu7t3v3__fill_2
Xmesh_tile_994 VDD VDD VSS VSS nw_out[1] gf180mcu_as_sc_mcu7t3v3__tiel_4
Xmesh_tile_983 VDD VDD VSS VSS north_out[24] gf180mcu_as_sc_mcu7t3v3__tiel_4
XTAP_TAPCELL_ROW_2_765 VDD VSS gf180mcu_as_sc_mcu7t3v3__tap_2
XFILLER_162_6 VDD VDD VSS VSS gf180mcu_as_sc_mcu7t3v3__fillcap_16
XFILLER_199_413 VDD VDD VSS VSS gf180mcu_as_sc_mcu7t3v3__fillcap_4
XFILLER_76_1539 VDD VDD VSS VSS gf180mcu_as_sc_mcu7t3v3__fill_2
XTAP_TAPCELL_ROW_2_776 VDD VSS gf180mcu_as_sc_mcu7t3v3__tap_2
XFILLER_199_446 VDD VDD VSS VSS gf180mcu_as_sc_mcu7t3v3__fillcap_16
XFILLER_14_349 VDD VDD VSS VSS gf180mcu_as_sc_mcu7t3v3__fillcap_16
XFILLER_165_1380 VDD VDD VSS VSS gf180mcu_as_sc_mcu7t3v3__fillcap_16
XFILLER_186_107 VDD VDD VSS VSS gf180mcu_as_sc_mcu7t3v3__fillcap_16
XFILLER_25_88 VDD VDD VSS VSS gf180mcu_as_sc_mcu7t3v3__fillcap_16
XFILLER_126_1364 VDD VDD VSS VSS gf180mcu_as_sc_mcu7t3v3__fillcap_16
XFILLER_39_1394 VDD VDD VSS VSS gf180mcu_as_sc_mcu7t3v3__fill_2
XFILLER_10_522 VDD VDD VSS VSS gf180mcu_as_sc_mcu7t3v3__fill_2
XFILLER_204_1539 VDD VDD VSS VSS gf180mcu_as_sc_mcu7t3v3__fillcap_4
Xwire903 VDD VDD VSS VSS wire903/A _4008_/D gf180mcu_as_sc_mcu7t3v3__clkbuff_12
XFILLER_183_858 VDD VDD VSS VSS gf180mcu_as_sc_mcu7t3v3__fillcap_16
XFILLER_195_696 VDD VDD VSS VSS gf180mcu_as_sc_mcu7t3v3__fillcap_4
XFILLER_157_54 VDD VDD VSS VSS gf180mcu_as_sc_mcu7t3v3__fillcap_4
XFILLER_196_1329 VDD VDD VSS VSS gf180mcu_as_sc_mcu7t3v3__fillcap_16
XTAP_TAPCELL_ROW_173_1_1964 VDD VSS gf180mcu_as_sc_mcu7t3v3__tap_2
XFILLER_203_2 VDD VDD VSS VSS gf180mcu_as_sc_mcu7t3v3__fillcap_16
XTAP_TAPCELL_ROW_103_3_3029 VDD VSS gf180mcu_as_sc_mcu7t3v3__tap_2
XTAP_TAPCELL_ROW_188_2318 VDD VSS gf180mcu_as_sc_mcu7t3v3__tap_2
XTAP_TAPCELL_ROW_188_2307 VDD VSS gf180mcu_as_sc_mcu7t3v3__tap_2
XFILLER_2_732 VDD VDD VSS VSS gf180mcu_as_sc_mcu7t3v3__fill_2
XFILLER_110_107 VDD VDD VSS VSS gf180mcu_as_sc_mcu7t3v3__fillcap_16
XFILLER_1_286 VDD VDD VSS VSS gf180mcu_as_sc_mcu7t3v3__fillcap_4
XFILLER_2_37 VDD VDD VSS VSS gf180mcu_as_sc_mcu7t3v3__fillcap_16
XFILLER_64_205 VDD VDD VSS VSS gf180mcu_as_sc_mcu7t3v3__fill_1
XFILLER_66_62 VDD VDD VSS VSS gf180mcu_as_sc_mcu7t3v3__fillcap_4
XPHY_EDGE_ROW_204_Left_414 VDD VSS gf180mcu_as_sc_mcu7t3v3__tap_2
XFILLER_17_121 VDD VDD VSS VSS gf180mcu_as_sc_mcu7t3v3__fillcap_16
XFILLER_66_84 VDD VDD VSS VSS gf180mcu_as_sc_mcu7t3v3__fill_2
XFILLER_17_154 VDD VDD VSS VSS gf180mcu_as_sc_mcu7t3v3__fillcap_16
XFILLER_18_688 VDD VDD VSS VSS gf180mcu_as_sc_mcu7t3v3__fillcap_16
XFILLER_205_244 VDD VDD VSS VSS gf180mcu_as_sc_mcu7t3v3__fillcap_16
XFILLER_144_1442 VDD VDD VSS VSS gf180mcu_as_sc_mcu7t3v3__fillcap_8
XFILLER_144_1453 VDD VDD VSS VSS gf180mcu_as_sc_mcu7t3v3__fillcap_8
XFILLER_105_1448 VDD VDD VSS VSS gf180mcu_as_sc_mcu7t3v3__fillcap_8
XFILLER_202_995 VDD VDD VSS VSS gf180mcu_as_sc_mcu7t3v3__fillcap_16
X_3670_ VDD VDD VSS VSS _3727_/C _4047_/A _3672_/C gf180mcu_as_sc_mcu7t3v3__and2_2
XFILLER_12_1033 VDD VDD VSS VSS gf180mcu_as_sc_mcu7t3v3__fillcap_4
X_2621_ VDD VDD VSS VSS _2621_/B _4643_/B _2624_/B gf180mcu_as_sc_mcu7t3v3__or2_2
X_2552_ VDD VDD VSS VSS _4649_/A _5272_/Q _2838_/B gf180mcu_as_sc_mcu7t3v3__and2_2
XFILLER_99_113 VDD VDD VSS VSS gf180mcu_as_sc_mcu7t3v3__fillcap_16
X_5271_ VDD VDD VSS VSS _5278_/CLK _5271_/D _5271_/Q gf180mcu_as_sc_mcu7t3v3__dfxtp_2
XFILLER_99_146 VDD VDD VSS VSS gf180mcu_as_sc_mcu7t3v3__fill_2
X_4222_ VDD VDD VSS VSS _4251_/B _4222_/B _4222_/C _5058_/Q _5058_/D gf180mcu_as_sc_mcu7t3v3__ao22_2
X_2483_ VDD VDD VSS VSS _2747_/B _4703_/B _2795_/A gf180mcu_as_sc_mcu7t3v3__nor2_2
XFILLER_116_1511 VDD VDD VSS VSS gf180mcu_as_sc_mcu7t3v3__fill_1
XFILLER_151_1413 VDD VDD VSS VSS gf180mcu_as_sc_mcu7t3v3__fill_2
XPHY_EDGE_ROW_161_3_Left_546 VDD VSS gf180mcu_as_sc_mcu7t3v3__tap_2
XFILLER_29_909 VDD VDD VSS VSS gf180mcu_as_sc_mcu7t3v3__fill_1
XTAP_TAPCELL_ROW_13_1016 VDD VSS gf180mcu_as_sc_mcu7t3v3__tap_2
XTAP_TAPCELL_ROW_13_1027 VDD VSS gf180mcu_as_sc_mcu7t3v3__tap_2
X_4153_ VDD VDD VSS VSS _4153_/A _4159_/B _4153_/C _4153_/D _4155_/C gf180mcu_as_sc_mcu7t3v3__ao211_2
XFILLER_28_419 VDD VDD VSS VSS gf180mcu_as_sc_mcu7t3v3__fillcap_16
XFILLER_55_216 VDD VDD VSS VSS gf180mcu_as_sc_mcu7t3v3__fill_1
X_4084_ VDD VDD VSS VSS _4996_/Q _4142_/B _4247_/B _4142_/D _4996_/D gf180mcu_as_sc_mcu7t3v3__ao22_2
X_3104_ VDD VDD VSS VSS _4078_/A _3229_/B _3104_/C _3104_/D _3105_/C gf180mcu_as_sc_mcu7t3v3__ao22_2
XFILLER_186_1509 VDD VDD VSS VSS gf180mcu_as_sc_mcu7t3v3__fill_1
X_3035_ VDD VDD VSS VSS _3129_/B _4925_/Q _3038_/C gf180mcu_as_sc_mcu7t3v3__or2_2
XFILLER_209_594 VDD VDD VSS VSS gf180mcu_as_sc_mcu7t3v3__fillcap_16
XFILLER_36_441 VDD VDD VSS VSS gf180mcu_as_sc_mcu7t3v3__fill_1
XPHY_EDGE_ROW_80_3_Right_117 VDD VSS gf180mcu_as_sc_mcu7t3v3__tap_2
XTAP_TAPCELL_ROW_30_1396 VDD VSS gf180mcu_as_sc_mcu7t3v3__tap_2
XTAP_TAPCELL_ROW_30_1385 VDD VSS gf180mcu_as_sc_mcu7t3v3__tap_2
XFILLER_184_1233 VDD VDD VSS VSS gf180mcu_as_sc_mcu7t3v3__fill_1
XFILLER_197_906 VDD VDD VSS VSS gf180mcu_as_sc_mcu7t3v3__fillcap_4
XFILLER_168_107 VDD VDD VSS VSS gf180mcu_as_sc_mcu7t3v3__fillcap_16
XFILLER_180_1119 VDD VDD VSS VSS gf180mcu_as_sc_mcu7t3v3__fillcap_16
XFILLER_184_1277 VDD VDD VSS VSS gf180mcu_as_sc_mcu7t3v3__fillcap_16
XFILLER_197_928 VDD VDD VSS VSS gf180mcu_as_sc_mcu7t3v3__fillcap_16
XPHY_EDGE_ROW_104_1_Right_625 VDD VSS gf180mcu_as_sc_mcu7t3v3__tap_2
X_4986_ VDD VDD VSS VSS _5082_/CLK _4986_/D _4986_/Q gf180mcu_as_sc_mcu7t3v3__dfxtp_2
XFILLER_123_1504 VDD VDD VSS VSS gf180mcu_as_sc_mcu7t3v3__fillcap_16
X_3937_ VDD VDD VSS VSS _4978_/Q _4142_/B _4229_/B _4142_/D _4978_/D gf180mcu_as_sc_mcu7t3v3__ao22_2
X_3868_ VDD VDD VSS VSS _3869_/D _3868_/A _3868_/B _3868_/C gf180mcu_as_sc_mcu7t3v3__ao21_2
XTAP_TAPCELL_ROW_63_1_1633 VDD VSS gf180mcu_as_sc_mcu7t3v3__tap_2
X_3799_ VDD VDD VSS VSS _3799_/A _3799_/B _3799_/C _3800_/D _3799_/D gf180mcu_as_sc_mcu7t3v3__oai211_2
X_2819_ VDD VDD VSS VSS _5482_/A _2833_/A _2828_/B gf180mcu_as_sc_mcu7t3v3__and2_2
XFILLER_192_699 VDD VDD VSS VSS gf180mcu_as_sc_mcu7t3v3__fillcap_16
XFILLER_30_1177 VDD VDD VSS VSS gf180mcu_as_sc_mcu7t3v3__fillcap_8
XFILLER_127_35 VDD VDD VSS VSS gf180mcu_as_sc_mcu7t3v3__fillcap_4
XFILLER_132_221 VDD VDD VSS VSS gf180mcu_as_sc_mcu7t3v3__fill_1
XFILLER_30_1199 VDD VDD VSS VSS gf180mcu_as_sc_mcu7t3v3__fillcap_16
XTAP_TAPCELL_ROW_73_3_2939 VDD VSS gf180mcu_as_sc_mcu7t3v3__tap_2
XFILLER_127_68 VDD VDD VSS VSS gf180mcu_as_sc_mcu7t3v3__fill_2
XFILLER_69_1398 VDD VDD VSS VSS gf180mcu_as_sc_mcu7t3v3__fillcap_8
XPHY_EDGE_ROW_93_3_Left_478 VDD VSS gf180mcu_as_sc_mcu7t3v3__tap_2
XTAP_TAPCELL_ROW_43_1_1575 VDD VSS gf180mcu_as_sc_mcu7t3v3__tap_2
XTAP_TAPCELL_ROW_183_2204 VDD VSS gf180mcu_as_sc_mcu7t3v3__tap_2
XFILLER_189_1100 VDD VDD VSS VSS gf180mcu_as_sc_mcu7t3v3__fillcap_16
XFILLER_28_1084 VDD VDD VSS VSS gf180mcu_as_sc_mcu7t3v3__fill_1
XFILLER_8_1134 VDD VDD VSS VSS gf180mcu_as_sc_mcu7t3v3__fillcap_16
XTAP_TAPCELL_ROW_7_879 VDD VSS gf180mcu_as_sc_mcu7t3v3__tap_2
XFILLER_189_1122 VDD VDD VSS VSS gf180mcu_as_sc_mcu7t3v3__fillcap_16
XFILLER_19_419 VDD VDD VSS VSS gf180mcu_as_sc_mcu7t3v3__fill_1
XFILLER_8_1189 VDD VDD VSS VSS gf180mcu_as_sc_mcu7t3v3__fillcap_16
XFILLER_210_1532 VDD VDD VSS VSS gf180mcu_as_sc_mcu7t3v3__fillcap_16
XFILLER_61_208 VDD VDD VSS VSS gf180mcu_as_sc_mcu7t3v3__fill_2
XFILLER_199_276 VDD VDD VSS VSS gf180mcu_as_sc_mcu7t3v3__fillcap_4
XFILLER_14_168 VDD VDD VSS VSS gf180mcu_as_sc_mcu7t3v3__fillcap_4
XFILLER_202_225 VDD VDD VSS VSS gf180mcu_as_sc_mcu7t3v3__fillcap_16
XFILLER_202_247 VDD VDD VSS VSS gf180mcu_as_sc_mcu7t3v3__fillcap_16
XFILLER_11_842 VDD VDD VSS VSS gf180mcu_as_sc_mcu7t3v3__fill_2
XFILLER_52_64 VDD VDD VSS VSS gf180mcu_as_sc_mcu7t3v3__fillcap_16
XFILLER_168_53 VDD VDD VSS VSS gf180mcu_as_sc_mcu7t3v3__fillcap_16
XFILLER_183_611 VDD VDD VSS VSS gf180mcu_as_sc_mcu7t3v3__fill_2
XFILLER_210_280 VDD VDD VSS VSS gf180mcu_as_sc_mcu7t3v3__fill_1
XFILLER_7_802 VDD VDD VSS VSS gf180mcu_as_sc_mcu7t3v3__fill_1
Xinput18 VDD VDD VSS VSS boot_data[6] _2729_/A gf180mcu_as_sc_mcu7t3v3__buff_12
XFILLER_167_184 VDD VDD VSS VSS gf180mcu_as_sc_mcu7t3v3__fillcap_4
XFILLER_52_1380 VDD VDD VSS VSS gf180mcu_as_sc_mcu7t3v3__fill_1
XFILLER_6_312 VDD VDD VSS VSS gf180mcu_as_sc_mcu7t3v3__fill_2
Xinput29 VDD VDD VSS VSS dft_addr[6] _2664_/B gf180mcu_as_sc_mcu7t3v3__buff_12
XFILLER_87_1454 VDD VDD VSS VSS gf180mcu_as_sc_mcu7t3v3__fill_2
XFILLER_139_1566 VDD VDD VSS VSS gf180mcu_as_sc_mcu7t3v3__fill_2
XFILLER_174_1446 VDD VDD VSS VSS gf180mcu_as_sc_mcu7t3v3__fillcap_16
XFILLER_174_1468 VDD VDD VSS VSS gf180mcu_as_sc_mcu7t3v3__fill_1
XFILLER_184_85 VDD VDD VSS VSS gf180mcu_as_sc_mcu7t3v3__fillcap_16
XFILLER_2_584 VDD VDD VSS VSS gf180mcu_as_sc_mcu7t3v3__fillcap_8
XFILLER_77_72 VDD VDD VSS VSS gf180mcu_as_sc_mcu7t3v3__fillcap_16
XFILLER_20_1313 VDD VDD VSS VSS gf180mcu_as_sc_mcu7t3v3__fillcap_16
XFILLER_4_1532 VDD VDD VSS VSS gf180mcu_as_sc_mcu7t3v3__fillcap_8
XFILLER_18_452 VDD VDD VSS VSS gf180mcu_as_sc_mcu7t3v3__fill_2
XFILLER_34_901 VDD VDD VSS VSS gf180mcu_as_sc_mcu7t3v3__fillcap_16
XFILLER_111_1474 VDD VDD VSS VSS gf180mcu_as_sc_mcu7t3v3__fillcap_8
XFILLER_185_1542 VDD VDD VSS VSS gf180mcu_as_sc_mcu7t3v3__fill_2
XFILLER_179_928 VDD VDD VSS VSS gf180mcu_as_sc_mcu7t3v3__fillcap_16
XFILLER_206_575 VDD VDD VSS VSS gf180mcu_as_sc_mcu7t3v3__fillcap_16
XFILLER_206_597 VDD VDD VSS VSS gf180mcu_as_sc_mcu7t3v3__fillcap_16
XFILLER_33_422 VDD VDD VSS VSS gf180mcu_as_sc_mcu7t3v3__fillcap_4
XFILLER_94_1469 VDD VDD VSS VSS gf180mcu_as_sc_mcu7t3v3__fillcap_16
X_4840_ VDD VDD VSS VSS _5262_/CLK _4840_/D _4840_/Q gf180mcu_as_sc_mcu7t3v3__dfxtp_2
XTAP_TAPCELL_ROW_68_1_1648 VDD VSS gf180mcu_as_sc_mcu7t3v3__tap_2
XFILLER_21_606 VDD VDD VSS VSS gf180mcu_as_sc_mcu7t3v3__fillcap_16
X_4771_ VDD VDD VSS VSS _5197_/CLK _4771_/D _4771_/Q gf180mcu_as_sc_mcu7t3v3__dfxtp_2
XFILLER_13_190 VDD VDD VSS VSS gf180mcu_as_sc_mcu7t3v3__fillcap_16
XFILLER_158_173 VDD VDD VSS VSS gf180mcu_as_sc_mcu7t3v3__fill_2
XFILLER_18_1297 VDD VDD VSS VSS gf180mcu_as_sc_mcu7t3v3__fillcap_16
X_3722_ VDD VDD VSS VSS _3746_/D _3794_/S _3722_/B _3722_/C _3723_/C gf180mcu_as_sc_mcu7t3v3__ao31_2
XFILLER_31_1420 VDD VDD VSS VSS gf180mcu_as_sc_mcu7t3v3__fill_1
XFILLER_70_1480 VDD VDD VSS VSS gf180mcu_as_sc_mcu7t3v3__fillcap_4
X_3653_ VDD VDD VSS VSS _3654_/C _3653_/C _3660_/B _4025_/A gf180mcu_as_sc_mcu7t3v3__aoi21_2
XFILLER_174_677 VDD VDD VSS VSS gf180mcu_as_sc_mcu7t3v3__fill_2
XFILLER_174_688 VDD VDD VSS VSS gf180mcu_as_sc_mcu7t3v3__fill_1
X_2604_ VDD VDD VSS VSS _2668_/B _2604_/B _2604_/A _2604_/Y gf180mcu_as_sc_mcu7t3v3__mux2_2
XFILLER_66_1505 VDD VDD VSS VSS gf180mcu_as_sc_mcu7t3v3__fill_2
XFILLER_66_1516 VDD VDD VSS VSS gf180mcu_as_sc_mcu7t3v3__fillcap_4
X_3584_ VDD VDD VSS VSS _3585_/C _3947_/A _3658_/B _3584_/C gf180mcu_as_sc_mcu7t3v3__ao21_2
XFILLER_114_221 VDD VDD VSS VSS gf180mcu_as_sc_mcu7t3v3__fill_1
XFILLER_66_1538 VDD VDD VSS VSS gf180mcu_as_sc_mcu7t3v3__fill_1
X_2535_ VDD VDD VSS VSS _5158_/Q _4590_/A _4354_/B gf180mcu_as_sc_mcu7t3v3__or2_2
XFILLER_192_1568 VDD VDD VSS VSS gf180mcu_as_sc_mcu7t3v3__fill_1
X_5254_ VDD VDD VSS VSS _5262_/CLK _5254_/D _5254_/Q gf180mcu_as_sc_mcu7t3v3__dfxtp_2
X_4876__1091 VDD VDD VSS VSS _4876_/D gf180mcu_as_sc_mcu7t3v3__tiel_4
X_2466_ VDD VDD VSS VSS _2467_/B _2466_/A gf180mcu_as_sc_mcu7t3v3__inv_2
XTAP_TAPCELL_ROW_36_1550 VDD VSS gf180mcu_as_sc_mcu7t3v3__tap_2
XFILLER_116_1352 VDD VDD VSS VSS gf180mcu_as_sc_mcu7t3v3__fill_2
XFILLER_25_1224 VDD VDD VSS VSS gf180mcu_as_sc_mcu7t3v3__fillcap_16
X_5185_ VDD VDD VSS VSS clkload8/A _5185_/D _5185_/Q gf180mcu_as_sc_mcu7t3v3__dfxtp_2
X_4205_ VDD VDD VSS VSS _4234_/B _4222_/B _4222_/C _5041_/Q _5041_/D gf180mcu_as_sc_mcu7t3v3__ao22_2
XTAP_TAPCELL_ROW_4_816 VDD VSS gf180mcu_as_sc_mcu7t3v3__tap_2
XFILLER_5_1329 VDD VDD VSS VSS gf180mcu_as_sc_mcu7t3v3__fill_1
XFILLER_9_1487 VDD VDD VSS VSS gf180mcu_as_sc_mcu7t3v3__fillcap_4
X_4136_ VDD VDD VSS VSS _4136_/A _4162_/B _4136_/C _4136_/D _4140_/A gf180mcu_as_sc_mcu7t3v3__ao211_2
X_2397_ VDD VDD VSS VSS _2558_/A _4703_/A gf180mcu_as_sc_mcu7t3v3__inv_2
XTAP_TAPCELL_ROW_4_827 VDD VSS gf180mcu_as_sc_mcu7t3v3__tap_2
XTAP_TAPCELL_ROW_32_1436 VDD VSS gf180mcu_as_sc_mcu7t3v3__tap_2
XTAP_TAPCELL_ROW_32_1425 VDD VSS gf180mcu_as_sc_mcu7t3v3__tap_2
X_4067_ VDD VDD VSS VSS _4067_/A _4141_/B _4067_/C _4245_/B _4124_/D gf180mcu_as_sc_mcu7t3v3__aoi211_2
XFILLER_25_912 VDD VDD VSS VSS gf180mcu_as_sc_mcu7t3v3__fillcap_8
XFILLER_36_260 VDD VDD VSS VSS gf180mcu_as_sc_mcu7t3v3__fill_1
XFILLER_36_271 VDD VDD VSS VSS gf180mcu_as_sc_mcu7t3v3__fill_1
X_3018_ VDD VDD VSS VSS _3999_/A _3127_/B _3127_/C _4000_/D _3019_/C gf180mcu_as_sc_mcu7t3v3__ao22_2
XFILLER_24_422 VDD VDD VSS VSS gf180mcu_as_sc_mcu7t3v3__fillcap_16
XPHY_EDGE_ROW_81_3_Right_118 VDD VSS gf180mcu_as_sc_mcu7t3v3__tap_2
XPHY_EDGE_ROW_105_1_Right_626 VDD VSS gf180mcu_as_sc_mcu7t3v3__tap_2
XFILLER_127_1481 VDD VDD VSS VSS gf180mcu_as_sc_mcu7t3v3__fillcap_4
X_4969_ VDD VDD VSS VSS _5111_/CLK _4969_/D _4969_/Q gf180mcu_as_sc_mcu7t3v3__dfxtp_2
XTAP_TAPCELL_ROW_176_2052 VDD VSS gf180mcu_as_sc_mcu7t3v3__tap_2
XTAP_TAPCELL_ROW_176_2041 VDD VSS gf180mcu_as_sc_mcu7t3v3__tap_2
XFILLER_127_1492 VDD VDD VSS VSS gf180mcu_as_sc_mcu7t3v3__fill_2
XFILLER_149_173 VDD VDD VSS VSS gf180mcu_as_sc_mcu7t3v3__fillcap_8
XFILLER_162_1383 VDD VDD VSS VSS gf180mcu_as_sc_mcu7t3v3__fillcap_16
XFILLER_196_279 VDD VDD VSS VSS gf180mcu_as_sc_mcu7t3v3__fillcap_4
XFILLER_197_1402 VDD VDD VSS VSS gf180mcu_as_sc_mcu7t3v3__fillcap_16
XFILLER_36_1386 VDD VDD VSS VSS gf180mcu_as_sc_mcu7t3v3__fillcap_8
XFILLER_138_34 VDD VDD VSS VSS gf180mcu_as_sc_mcu7t3v3__fill_1
XFILLER_20_683 VDD VDD VSS VSS gf180mcu_as_sc_mcu7t3v3__fillcap_8
XFILLER_10_1504 VDD VDD VSS VSS gf180mcu_as_sc_mcu7t3v3__fill_1
XFILLER_158_1408 VDD VDD VSS VSS gf180mcu_as_sc_mcu7t3v3__fillcap_8
XFILLER_203_1380 VDD VDD VSS VSS gf180mcu_as_sc_mcu7t3v3__fillcap_16
XTAP_TAPCELL_ROW_94_1_1727 VDD VSS gf180mcu_as_sc_mcu7t3v3__tap_2
XTAP_TAPCELL_ROW_210_2823 VDD VSS gf180mcu_as_sc_mcu7t3v3__tap_2
XTAP_TAPCELL_ROW_210_2812 VDD VSS gf180mcu_as_sc_mcu7t3v3__tap_2
XTAP_TAPCELL_ROW_210_2801 VDD VSS gf180mcu_as_sc_mcu7t3v3__tap_2
XFILLER_195_1170 VDD VDD VSS VSS gf180mcu_as_sc_mcu7t3v3__fillcap_16
XFILLER_195_1192 VDD VDD VSS VSS gf180mcu_as_sc_mcu7t3v3__fillcap_16
XFILLER_154_77 VDD VDD VSS VSS gf180mcu_as_sc_mcu7t3v3__fillcap_4
XFILLER_82_1373 VDD VDD VSS VSS gf180mcu_as_sc_mcu7t3v3__fillcap_8
XTAP_TAPCELL_ROW_208_2741 VDD VSS gf180mcu_as_sc_mcu7t3v3__tap_2
XFILLER_169_1504 VDD VDD VSS VSS gf180mcu_as_sc_mcu7t3v3__fill_2
XFILLER_208_807 VDD VDD VSS VSS gf180mcu_as_sc_mcu7t3v3__fillcap_8
XTAP_TAPCELL_ROW_208_2752 VDD VSS gf180mcu_as_sc_mcu7t3v3__tap_2
XFILLER_207_339 VDD VDD VSS VSS gf180mcu_as_sc_mcu7t3v3__fillcap_8
XFILLER_15_422 VDD VDD VSS VSS gf180mcu_as_sc_mcu7t3v3__fillcap_16
XFILLER_27_282 VDD VDD VSS VSS gf180mcu_as_sc_mcu7t3v3__fill_2
XTAP_TAPCELL_ROW_148_1_1890 VDD VSS gf180mcu_as_sc_mcu7t3v3__tap_2
XFILLER_203_556 VDD VDD VSS VSS gf180mcu_as_sc_mcu7t3v3__fillcap_4
XFILLER_63_52 VDD VDD VSS VSS gf180mcu_as_sc_mcu7t3v3__fillcap_4
XFILLER_15_488 VDD VDD VSS VSS gf180mcu_as_sc_mcu7t3v3__fill_2
XFILLER_175_408 VDD VDD VSS VSS gf180mcu_as_sc_mcu7t3v3__fillcap_8
XFILLER_176_909 VDD VDD VSS VSS gf180mcu_as_sc_mcu7t3v3__fillcap_16
XFILLER_188_769 VDD VDD VSS VSS gf180mcu_as_sc_mcu7t3v3__fillcap_16
XFILLER_203_578 VDD VDD VSS VSS gf180mcu_as_sc_mcu7t3v3__fillcap_16
XFILLER_54_1453 VDD VDD VSS VSS gf180mcu_as_sc_mcu7t3v3__fillcap_8
XFILLER_106_1543 VDD VDD VSS VSS gf180mcu_as_sc_mcu7t3v3__fill_1
XFILLER_208_1291 VDD VDD VSS VSS gf180mcu_as_sc_mcu7t3v3__fillcap_4
XFILLER_30_469 VDD VDD VSS VSS gf180mcu_as_sc_mcu7t3v3__fill_2
XFILLER_10_160 VDD VDD VSS VSS gf180mcu_as_sc_mcu7t3v3__fill_1
XFILLER_11_683 VDD VDD VSS VSS gf180mcu_as_sc_mcu7t3v3__fillcap_16
XFILLER_7_632 VDD VDD VSS VSS gf180mcu_as_sc_mcu7t3v3__fillcap_4
XFILLER_8_69 VDD VDD VSS VSS gf180mcu_as_sc_mcu7t3v3__fillcap_16
XFILLER_183_485 VDD VDD VSS VSS gf180mcu_as_sc_mcu7t3v3__fillcap_4
XTAP_TAPCELL_ROW_43_3_2850 VDD VSS gf180mcu_as_sc_mcu7t3v3__tap_2
XFILLER_170_146 VDD VDD VSS VSS gf180mcu_as_sc_mcu7t3v3__fill_2
XFILLER_139_1385 VDD VDD VSS VSS gf180mcu_as_sc_mcu7t3v3__fill_2
XFILLER_170_179 VDD VDD VSS VSS gf180mcu_as_sc_mcu7t3v3__fill_1
XFILLER_26_1511 VDD VDD VSS VSS gf180mcu_as_sc_mcu7t3v3__fill_2
XFILLER_61_1457 VDD VDD VSS VSS gf180mcu_as_sc_mcu7t3v3__fillcap_16
XFILLER_113_1558 VDD VDD VSS VSS gf180mcu_as_sc_mcu7t3v3__fillcap_8
XFILLER_26_709 VDD VDD VSS VSS gf180mcu_as_sc_mcu7t3v3__fillcap_16
XFILLER_77_193 VDD VDD VSS VSS gf180mcu_as_sc_mcu7t3v3__fillcap_4
XFILLER_0_1226 VDD VDD VSS VSS gf180mcu_as_sc_mcu7t3v3__fillcap_4
XFILLER_19_772 VDD VDD VSS VSS gf180mcu_as_sc_mcu7t3v3__fill_2
XFILLER_92_174 VDD VDD VSS VSS gf180mcu_as_sc_mcu7t3v3__fill_1
XFILLER_185_1372 VDD VDD VSS VSS gf180mcu_as_sc_mcu7t3v3__fill_1
XFILLER_207_884 VDD VDD VSS VSS gf180mcu_as_sc_mcu7t3v3__fill_1
XFILLER_34_753 VDD VDD VSS VSS gf180mcu_as_sc_mcu7t3v3__fillcap_4
XPHY_EDGE_ROW_159_1_Left_369 VDD VSS gf180mcu_as_sc_mcu7t3v3__tap_2
XFILLER_179_769 VDD VDD VSS VSS gf180mcu_as_sc_mcu7t3v3__fill_1
XFILLER_33_296 VDD VDD VSS VSS gf180mcu_as_sc_mcu7t3v3__fillcap_8
X_4823_ VDD VDD VSS VSS _5068_/CLK _4823_/D _4823_/Q gf180mcu_as_sc_mcu7t3v3__dfxtp_2
XFILLER_193_205 VDD VDD VSS VSS gf180mcu_as_sc_mcu7t3v3__fillcap_4
XFILLER_33_1504 VDD VDD VSS VSS gf180mcu_as_sc_mcu7t3v3__fill_2
XPHY_EDGE_ROW_96_1_Left_306 VDD VSS gf180mcu_as_sc_mcu7t3v3__tap_2
X_4754_ VDD VDD VSS VSS _5256_/CLK _4754_/D _4754_/Q gf180mcu_as_sc_mcu7t3v3__dfxtp_2
XFILLER_175_964 VDD VDD VSS VSS gf180mcu_as_sc_mcu7t3v3__fillcap_16
XFILLER_18_1094 VDD VDD VSS VSS gf180mcu_as_sc_mcu7t3v3__fill_1
X_3705_ VDD VDD VSS VSS _3706_/C _3705_/C _3766_/B _4081_/A gf180mcu_as_sc_mcu7t3v3__aoi21_2
XTAP_TAPCELL_ROW_25_1284 VDD VSS gf180mcu_as_sc_mcu7t3v3__tap_2
XTAP_TAPCELL_ROW_25_1273 VDD VSS gf180mcu_as_sc_mcu7t3v3__tap_2
XFILLER_179_1154 VDD VDD VSS VSS gf180mcu_as_sc_mcu7t3v3__fillcap_16
X_4685_ VDD VDD VSS VSS _5103_/Q _4731_/B _4685_/C _5249_/Q _4686_/D gf180mcu_as_sc_mcu7t3v3__ao22_2
XTAP_TAPCELL_ROW_104_3_3034 VDD VSS gf180mcu_as_sc_mcu7t3v3__tap_2
X_3636_ VDD VDD VSS VSS _3636_/D _4008_/D _3728_/B _3728_/C _3637_/C gf180mcu_as_sc_mcu7t3v3__ao31_2
XFILLER_108_37 VDD VDD VSS VSS gf180mcu_as_sc_mcu7t3v3__fillcap_16
XFILLER_161_135 VDD VDD VSS VSS gf180mcu_as_sc_mcu7t3v3__fillcap_4
XPHY_EDGE_ROW_105_3_Left_490 VDD VSS gf180mcu_as_sc_mcu7t3v3__tap_2
X_3567_ VDD VDD VSS VSS _4915_/Q _3648_/B _3648_/C _3930_/A _3568_/D gf180mcu_as_sc_mcu7t3v3__ao22_2
XTAP_TAPCELL_ROW_9_919 VDD VSS gf180mcu_as_sc_mcu7t3v3__tap_2
XFILLER_157_1463 VDD VDD VSS VSS gf180mcu_as_sc_mcu7t3v3__fillcap_16
XFILLER_157_1485 VDD VDD VSS VSS gf180mcu_as_sc_mcu7t3v3__fill_1
X_2518_ VDD VDD VSS VSS _4704_/B _4703_/B _4703_/A gf180mcu_as_sc_mcu7t3v3__nand2_2
XFILLER_192_1387 VDD VDD VSS VSS gf180mcu_as_sc_mcu7t3v3__fill_1
X_5237_ VDD VDD VSS VSS _5276_/CLK _5237_/D _5237_/Q gf180mcu_as_sc_mcu7t3v3__dfxtp_2
Xinput208 VDD VDD VSS VSS se_in[3] wire871/A gf180mcu_as_sc_mcu7t3v3__buff_12
X_3498_ VDD VDD VSS VSS _3498_/S _3498_/B _4156_/A _3499_/B gf180mcu_as_sc_mcu7t3v3__mux2_2
XFILLER_75_108 VDD VDD VSS VSS gf180mcu_as_sc_mcu7t3v3__fill_1
XFILLER_9_1262 VDD VDD VSS VSS gf180mcu_as_sc_mcu7t3v3__fillcap_16
Xinput219 VDD VDD VSS VSS south_in[13] _4040_/D gf180mcu_as_sc_mcu7t3v3__buff_12
X_2449_ VDD VDD VSS VSS _3192_/D _4160_/A gf180mcu_as_sc_mcu7t3v3__inv_2
XFILLER_124_69 VDD VDD VSS VSS gf180mcu_as_sc_mcu7t3v3__fill_2
XFILLER_40_1519 VDD VDD VSS VSS gf180mcu_as_sc_mcu7t3v3__fill_2
XFILLER_5_1148 VDD VDD VSS VSS gf180mcu_as_sc_mcu7t3v3__fill_1
XFILLER_75_119 VDD VDD VSS VSS gf180mcu_as_sc_mcu7t3v3__fillcap_4
X_5168_ VDD VDD VSS VSS clkload9/A _5168_/D _5168_/Q gf180mcu_as_sc_mcu7t3v3__dfxtp_2
XFILLER_186_1103 VDD VDD VSS VSS gf180mcu_as_sc_mcu7t3v3__fillcap_16
XPHY_EDGE_ROW_124_3_Left_509 VDD VSS gf180mcu_as_sc_mcu7t3v3__tap_2
X_5099_ VDD VDD VSS VSS clkload6/A _5099_/D _5099_/Q gf180mcu_as_sc_mcu7t3v3__dfxtp_2
X_4119_ VDD VDD VSS VSS _4119_/A _4119_/B _4136_/C _4119_/D _4123_/A gf180mcu_as_sc_mcu7t3v3__ao211_2
XFILLER_140_57 VDD VDD VSS VSS gf180mcu_as_sc_mcu7t3v3__fillcap_16
XFILLER_17_67 VDD VDD VSS VSS gf180mcu_as_sc_mcu7t3v3__fill_2
XFILLER_129_1565 VDD VDD VSS VSS gf180mcu_as_sc_mcu7t3v3__fillcap_4
XFILLER_12_403 VDD VDD VSS VSS gf180mcu_as_sc_mcu7t3v3__fillcap_4
XFILLER_24_241 VDD VDD VSS VSS gf180mcu_as_sc_mcu7t3v3__fillcap_4
XFILLER_24_263 VDD VDD VSS VSS gf180mcu_as_sc_mcu7t3v3__fillcap_16
XFILLER_25_786 VDD VDD VSS VSS gf180mcu_as_sc_mcu7t3v3__fill_1
XPHY_EDGE_ROW_182_Left_392 VDD VSS gf180mcu_as_sc_mcu7t3v3__tap_2
XPHY_EDGE_ROW_82_3_Right_119 VDD VSS gf180mcu_as_sc_mcu7t3v3__tap_2
XTAP_TAPCELL_ROW_48_3_2865 VDD VSS gf180mcu_as_sc_mcu7t3v3__tap_2
XTAP_TAPCELL_ROW_195_2461 VDD VSS gf180mcu_as_sc_mcu7t3v3__tap_2
XFILLER_8_407 VDD VDD VSS VSS gf180mcu_as_sc_mcu7t3v3__fill_2
XPHY_EDGE_ROW_106_1_Right_627 VDD VSS gf180mcu_as_sc_mcu7t3v3__tap_2
XTAP_TAPCELL_ROW_195_2472 VDD VSS gf180mcu_as_sc_mcu7t3v3__tap_2
XFILLER_200_559 VDD VDD VSS VSS gf180mcu_as_sc_mcu7t3v3__fillcap_16
XFILLER_33_88 VDD VDD VSS VSS gf180mcu_as_sc_mcu7t3v3__fillcap_16
XTAP_TAPCELL_ROW_191_2369 VDD VSS gf180mcu_as_sc_mcu7t3v3__tap_2
XFILLER_10_1301 VDD VDD VSS VSS gf180mcu_as_sc_mcu7t3v3__fill_2
XFILLER_181_912 VDD VDD VSS VSS gf180mcu_as_sc_mcu7t3v3__fillcap_16
XFILLER_193_750 VDD VDD VSS VSS gf180mcu_as_sc_mcu7t3v3__fillcap_16
XFILLER_193_772 VDD VDD VSS VSS gf180mcu_as_sc_mcu7t3v3__fillcap_16
XFILLER_137_176 VDD VDD VSS VSS gf180mcu_as_sc_mcu7t3v3__fillcap_8
XFILLER_10_1367 VDD VDD VSS VSS gf180mcu_as_sc_mcu7t3v3__fillcap_4
XFILLER_165_54 VDD VDD VSS VSS gf180mcu_as_sc_mcu7t3v3__fill_2
XFILLER_136_1503 VDD VDD VSS VSS gf180mcu_as_sc_mcu7t3v3__fillcap_4
XFILLER_3_178 VDD VDD VSS VSS gf180mcu_as_sc_mcu7t3v3__fill_1
XFILLER_49_1566 VDD VDD VSS VSS gf180mcu_as_sc_mcu7t3v3__fill_2
XFILLER_58_63 VDD VDD VSS VSS gf180mcu_as_sc_mcu7t3v3__fill_1
XFILLER_0_896 VDD VDD VSS VSS gf180mcu_as_sc_mcu7t3v3__fill_1
XTAP_TAPCELL_ROW_129_3_3107 VDD VSS gf180mcu_as_sc_mcu7t3v3__tap_2
XFILLER_169_1356 VDD VDD VSS VSS gf180mcu_as_sc_mcu7t3v3__fillcap_4
XFILLER_207_136 VDD VDD VSS VSS gf180mcu_as_sc_mcu7t3v3__fillcap_4
XFILLER_207_158 VDD VDD VSS VSS gf180mcu_as_sc_mcu7t3v3__fillcap_8
XFILLER_21_1463 VDD VDD VSS VSS gf180mcu_as_sc_mcu7t3v3__fillcap_4
XFILLER_35_528 VDD VDD VSS VSS gf180mcu_as_sc_mcu7t3v3__fill_2
XFILLER_182_1545 VDD VDD VSS VSS gf180mcu_as_sc_mcu7t3v3__fillcap_16
XFILLER_56_1537 VDD VDD VSS VSS gf180mcu_as_sc_mcu7t3v3__fillcap_4
XFILLER_91_1406 VDD VDD VSS VSS gf180mcu_as_sc_mcu7t3v3__fillcap_4
XTAP_TAPCELL_ROW_109_3_3049 VDD VSS gf180mcu_as_sc_mcu7t3v3__tap_2
XFILLER_30_244 VDD VDD VSS VSS gf180mcu_as_sc_mcu7t3v3__fill_1
XFILLER_90_72 VDD VDD VSS VSS gf180mcu_as_sc_mcu7t3v3__fillcap_16
XFILLER_12_981 VDD VDD VSS VSS gf180mcu_as_sc_mcu7t3v3__fillcap_4
XFILLER_180_1291 VDD VDD VSS VSS gf180mcu_as_sc_mcu7t3v3__fillcap_4
XFILLER_8_941 VDD VDD VSS VSS gf180mcu_as_sc_mcu7t3v3__fillcap_4
XPHY_EDGE_ROW_170_3_Left_555 VDD VSS gf180mcu_as_sc_mcu7t3v3__tap_2
XFILLER_106_1373 VDD VDD VSS VSS gf180mcu_as_sc_mcu7t3v3__fillcap_8
XFILLER_15_1278 VDD VDD VSS VSS gf180mcu_as_sc_mcu7t3v3__fillcap_4
XFILLER_7_451 VDD VDD VSS VSS gf180mcu_as_sc_mcu7t3v3__fill_2
XFILLER_8_963 VDD VDD VSS VSS gf180mcu_as_sc_mcu7t3v3__fillcap_16
XFILLER_176_1327 VDD VDD VSS VSS gf180mcu_as_sc_mcu7t3v3__fillcap_16
XFILLER_183_282 VDD VDD VSS VSS gf180mcu_as_sc_mcu7t3v3__fillcap_8
XFILLER_190_219 VDD VDD VSS VSS gf180mcu_as_sc_mcu7t3v3__fillcap_16
X_4470_ VDD VDD VSS VSS _5176_/Q _4470_/B _4479_/C _5110_/Q _4471_/B gf180mcu_as_sc_mcu7t3v3__ao22_2
X_3421_ VDD VDD VSS VSS _3467_/B _4069_/A _3421_/A _3423_/B gf180mcu_as_sc_mcu7t3v3__mux2_2
XTAP_TAPCELL_ROW_74_3_2944 VDD VSS gf180mcu_as_sc_mcu7t3v3__tap_2
XTAP_TAPCELL_ROW_20_1181 VDD VSS gf180mcu_as_sc_mcu7t3v3__tap_2
XTAP_TAPCELL_ROW_20_1170 VDD VSS gf180mcu_as_sc_mcu7t3v3__tap_2
X_3352_ VDD VDD VSS VSS _4003_/A _3463_/B _3352_/C _4813_/D _3416_/D gf180mcu_as_sc_mcu7t3v3__aoi211_2
XFILLER_31_2 VDD VDD VSS VSS gf180mcu_as_sc_mcu7t3v3__fillcap_16
XFILLER_151_190 VDD VDD VSS VSS gf180mcu_as_sc_mcu7t3v3__fillcap_16
X_3283_ VDD VDD VSS VSS _3283_/A _3526_/C _3526_/D _3524_/C gf180mcu_as_sc_mcu7t3v3__nor3_2
X_5022_ VDD VDD VSS VSS clkload4/A _5022_/D _5022_/Q gf180mcu_as_sc_mcu7t3v3__dfxtp_2
Xhold1107 VDD VDD VSS VSS hold1135/Y _2583_/C gf180mcu_as_sc_mcu7t3v3__clkbuff_4
Xhold1118 VDD VDD VSS VSS hold1143/Y _4959_/D gf180mcu_as_sc_mcu7t3v3__clkbuff_4
Xhold1129 VDD VDD VSS VSS _4951_/Q _2477_/B gf180mcu_as_sc_mcu7t3v3__clkbuff_4
XFILLER_187_1434 VDD VDD VSS VSS gf180mcu_as_sc_mcu7t3v3__fillcap_16
XFILLER_80_100 VDD VDD VSS VSS gf180mcu_as_sc_mcu7t3v3__fillcap_4
XFILLER_0_1045 VDD VDD VSS VSS gf180mcu_as_sc_mcu7t3v3__fillcap_4
XFILLER_0_70 VDD VDD VSS VSS gf180mcu_as_sc_mcu7t3v3__fillcap_4
XFILLER_148_1418 VDD VDD VSS VSS gf180mcu_as_sc_mcu7t3v3__fillcap_4
XFILLER_80_111 VDD VDD VSS VSS gf180mcu_as_sc_mcu7t3v3__fill_2
XFILLER_0_1056 VDD VDD VSS VSS gf180mcu_as_sc_mcu7t3v3__fill_1
XFILLER_179_522 VDD VDD VSS VSS gf180mcu_as_sc_mcu7t3v3__fill_1
XTAP_TAPCELL_ROW_27_1324 VDD VSS gf180mcu_as_sc_mcu7t3v3__tap_2
XFILLER_22_734 VDD VDD VSS VSS gf180mcu_as_sc_mcu7t3v3__fill_1
XFILLER_34_594 VDD VDD VSS VSS gf180mcu_as_sc_mcu7t3v3__fill_1
XFILLER_80_177 VDD VDD VSS VSS gf180mcu_as_sc_mcu7t3v3__fillcap_8
XTAP_TAPCELL_ROW_27_1335 VDD VSS gf180mcu_as_sc_mcu7t3v3__tap_2
XFILLER_179_599 VDD VDD VSS VSS gf180mcu_as_sc_mcu7t3v3__fill_1
XFILLER_21_233 VDD VDD VSS VSS gf180mcu_as_sc_mcu7t3v3__fill_1
X_4806_ VDD VDD VSS VSS _4919_/CLK _4806_/D _4806_/Q gf180mcu_as_sc_mcu7t3v3__dfxtp_2
XFILLER_10_929 VDD VDD VSS VSS gf180mcu_as_sc_mcu7t3v3__fillcap_16
XFILLER_119_121 VDD VDD VSS VSS gf180mcu_as_sc_mcu7t3v3__fillcap_4
XFILLER_72_1383 VDD VDD VSS VSS gf180mcu_as_sc_mcu7t3v3__fillcap_8
X_2998_ VDD VDD VSS VSS _3608_/A _3005_/A _2998_/C _2998_/Y _3594_/D gf180mcu_as_sc_mcu7t3v3__aoi211_2
XFILLER_175_772 VDD VDD VSS VSS gf180mcu_as_sc_mcu7t3v3__fillcap_16
X_4737_ VDD VDD VSS VSS _4739_/B _4742_/C _4737_/C _5270_/D gf180mcu_as_sc_mcu7t3v3__nor3_2
XFILLER_119_187 VDD VDD VSS VSS gf180mcu_as_sc_mcu7t3v3__fill_2
XFILLER_120_1348 VDD VDD VSS VSS gf180mcu_as_sc_mcu7t3v3__fillcap_16
XFILLER_134_102 VDD VDD VSS VSS gf180mcu_as_sc_mcu7t3v3__fill_2
XFILLER_174_282 VDD VDD VSS VSS gf180mcu_as_sc_mcu7t3v3__fill_2
XFILLER_190_731 VDD VDD VSS VSS gf180mcu_as_sc_mcu7t3v3__fillcap_4
X_4668_ VDD VDD VSS VSS _5241_/D _5241_/Q _4685_/C _4668_/C gf180mcu_as_sc_mcu7t3v3__ao21_2
XFILLER_159_1558 VDD VDD VSS VSS gf180mcu_as_sc_mcu7t3v3__fillcap_8
XFILLER_190_753 VDD VDD VSS VSS gf180mcu_as_sc_mcu7t3v3__fillcap_16
XFILLER_200_1361 VDD VDD VSS VSS gf180mcu_as_sc_mcu7t3v3__fillcap_4
XFILLER_200_1383 VDD VDD VSS VSS gf180mcu_as_sc_mcu7t3v3__fillcap_16
X_3619_ VDD VDD VSS VSS _3991_/A _3649_/B _3656_/C _3989_/D _3620_/D gf180mcu_as_sc_mcu7t3v3__ao22_2
XFILLER_1_616 VDD VDD VSS VSS gf180mcu_as_sc_mcu7t3v3__fill_2
X_4599_ VDD VDD VSS VSS _5193_/Q _4750_/D _4604_/C _5194_/Q _5193_/D gf180mcu_as_sc_mcu7t3v3__ao22_2
XFILLER_0_104 VDD VDD VSS VSS gf180mcu_as_sc_mcu7t3v3__fillcap_4
XFILLER_192_1151 VDD VDD VSS VSS gf180mcu_as_sc_mcu7t3v3__fillcap_4
XFILLER_192_1173 VDD VDD VSS VSS gf180mcu_as_sc_mcu7t3v3__fillcap_16
XFILLER_135_68 VDD VDD VSS VSS gf180mcu_as_sc_mcu7t3v3__fill_2
XTAP_TAPCELL_ROW_89_1_1711 VDD VSS gf180mcu_as_sc_mcu7t3v3__tap_2
XFILLER_192_6 VDD VDD VSS VSS gf180mcu_as_sc_mcu7t3v3__fillcap_16
XFILLER_151_34 VDD VDD VSS VSS gf180mcu_as_sc_mcu7t3v3__fillcap_8
XFILLER_79_1504 VDD VDD VSS VSS gf180mcu_as_sc_mcu7t3v3__fill_2
XFILLER_131_1488 VDD VDD VSS VSS gf180mcu_as_sc_mcu7t3v3__fillcap_16
XFILLER_29_388 VDD VDD VSS VSS gf180mcu_as_sc_mcu7t3v3__fill_1
XFILLER_56_196 VDD VDD VSS VSS gf180mcu_as_sc_mcu7t3v3__fill_1
XFILLER_71_133 VDD VDD VSS VSS gf180mcu_as_sc_mcu7t3v3__fillcap_4
XPHY_EDGE_ROW_190_Left_400 VDD VSS gf180mcu_as_sc_mcu7t3v3__tap_2
XTAP_TAPCELL_ROW_69_1_1653 VDD VSS gf180mcu_as_sc_mcu7t3v3__tap_2
XTAP_TAPCELL_ROW_197_2512 VDD VSS gf180mcu_as_sc_mcu7t3v3__tap_2
XTAP_TAPCELL_ROW_197_2501 VDD VSS gf180mcu_as_sc_mcu7t3v3__tap_2
XFILLER_204_139 VDD VDD VSS VSS gf180mcu_as_sc_mcu7t3v3__fillcap_16
XFILLER_207_1504 VDD VDD VSS VSS gf180mcu_as_sc_mcu7t3v3__fillcap_16
XFILLER_25_594 VDD VDD VSS VSS gf180mcu_as_sc_mcu7t3v3__fill_2
Xsram2048.u_bank1_921 VDD VDD VSS VSS sram2048.u_bank1/WEN[3] gf180mcu_as_sc_mcu7t3v3__tiel_4
XTAP_TAPCELL_ROW_193_2409 VDD VSS gf180mcu_as_sc_mcu7t3v3__tap_2
XFILLER_12_244 VDD VDD VSS VSS gf180mcu_as_sc_mcu7t3v3__fill_1
XFILLER_197_352 VDD VDD VSS VSS gf180mcu_as_sc_mcu7t3v3__fillcap_16
XTAP_TAPCELL_ROW_79_3_2959 VDD VSS gf180mcu_as_sc_mcu7t3v3__tap_2
XFILLER_100_82 VDD VDD VSS VSS gf180mcu_as_sc_mcu7t3v3__fillcap_4
XFILLER_60_31 VDD VDD VSS VSS gf180mcu_as_sc_mcu7t3v3__fillcap_4
XPHY_EDGE_ROW_107_1_Right_628 VDD VSS gf180mcu_as_sc_mcu7t3v3__tap_2
XFILLER_205_1294 VDD VDD VSS VSS gf180mcu_as_sc_mcu7t3v3__fillcap_16
XFILLER_60_53 VDD VDD VSS VSS gf180mcu_as_sc_mcu7t3v3__fillcap_16
XFILLER_90_1494 VDD VDD VSS VSS gf180mcu_as_sc_mcu7t3v3__fillcap_16
XFILLER_103_1568 VDD VDD VSS VSS gf180mcu_as_sc_mcu7t3v3__fill_1
XFILLER_176_53 VDD VDD VSS VSS gf180mcu_as_sc_mcu7t3v3__fillcap_16
XFILLER_5_922 VDD VDD VSS VSS gf180mcu_as_sc_mcu7t3v3__fillcap_16
XTAP_TAPCELL_ROW_11_968 VDD VSS gf180mcu_as_sc_mcu7t3v3__tap_2
XTAP_TAPCELL_ROW_11_979 VDD VSS gf180mcu_as_sc_mcu7t3v3__tap_2
XFILLER_125_124 VDD VDD VSS VSS gf180mcu_as_sc_mcu7t3v3__fillcap_16
XFILLER_181_764 VDD VDD VSS VSS gf180mcu_as_sc_mcu7t3v3__fillcap_4
XFILLER_197_1084 VDD VDD VSS VSS gf180mcu_as_sc_mcu7t3v3__fillcap_16
XFILLER_180_263 VDD VDD VSS VSS gf180mcu_as_sc_mcu7t3v3__fillcap_16
XFILLER_192_30 VDD VDD VSS VSS gf180mcu_as_sc_mcu7t3v3__fillcap_4
XFILLER_133_190 VDD VDD VSS VSS gf180mcu_as_sc_mcu7t3v3__fillcap_16
XFILLER_192_85 VDD VDD VSS VSS gf180mcu_as_sc_mcu7t3v3__fillcap_16
XFILLER_0_682 VDD VDD VSS VSS gf180mcu_as_sc_mcu7t3v3__fill_2
XFILLER_136_1399 VDD VDD VSS VSS gf180mcu_as_sc_mcu7t3v3__fillcap_16
XFILLER_110_1506 VDD VDD VSS VSS gf180mcu_as_sc_mcu7t3v3__fillcap_4
XPHY_EDGE_ROW_13_Right_13 VDD VSS gf180mcu_as_sc_mcu7t3v3__tap_2
XFILLER_35_314 VDD VDD VSS VSS gf180mcu_as_sc_mcu7t3v3__fillcap_8
XFILLER_47_163 VDD VDD VSS VSS gf180mcu_as_sc_mcu7t3v3__fillcap_4
XFILLER_85_72 VDD VDD VSS VSS gf180mcu_as_sc_mcu7t3v3__fillcap_8
XFILLER_208_489 VDD VDD VSS VSS gf180mcu_as_sc_mcu7t3v3__fillcap_16
XFILLER_189_820 VDD VDD VSS VSS gf180mcu_as_sc_mcu7t3v3__fillcap_16
XFILLER_95_1361 VDD VDD VSS VSS gf180mcu_as_sc_mcu7t3v3__fillcap_4
XTAP_TAPCELL_ROW_116_1_1792 VDD VSS gf180mcu_as_sc_mcu7t3v3__tap_2
X_3970_ VDD VDD VSS VSS _3971_/C _3970_/B _3970_/A gf180mcu_as_sc_mcu7t3v3__nor2_2
XFILLER_108_1413 VDD VDD VSS VSS gf180mcu_as_sc_mcu7t3v3__fillcap_8
XFILLER_16_594 VDD VDD VSS VSS gf180mcu_as_sc_mcu7t3v3__fill_1
XFILLER_189_842 VDD VDD VSS VSS gf180mcu_as_sc_mcu7t3v3__fillcap_16
XFILLER_1_1398 VDD VDD VSS VSS gf180mcu_as_sc_mcu7t3v3__fill_2
XFILLER_62_177 VDD VDD VSS VSS gf180mcu_as_sc_mcu7t3v3__fillcap_8
XFILLER_95_1394 VDD VDD VSS VSS gf180mcu_as_sc_mcu7t3v3__fillcap_16
X_2921_ VDD VDD VSS VSS _3553_/A _3554_/A _3814_/A _2932_/C gf180mcu_as_sc_mcu7t3v3__nand3_2
XFILLER_188_352 VDD VDD VSS VSS gf180mcu_as_sc_mcu7t3v3__fillcap_8
XFILLER_143_1348 VDD VDD VSS VSS gf180mcu_as_sc_mcu7t3v3__fillcap_16
X_2852_ VDD VDD VSS VSS _4377_/B _3874_/A _2852_/B _5097_/Q gf180mcu_as_sc_mcu7t3v3__aoi21_2
XTAP_TAPCELL_ROW_22_1210 VDD VSS gf180mcu_as_sc_mcu7t3v3__tap_2
XFILLER_176_569 VDD VDD VSS VSS gf180mcu_as_sc_mcu7t3v3__fillcap_4
XFILLER_30_1507 VDD VDD VSS VSS gf180mcu_as_sc_mcu7t3v3__fillcap_16
XPHY_EDGE_ROW_22_Right_22 VDD VSS gf180mcu_as_sc_mcu7t3v3__tap_2
X_2783_ VDD VDD VSS VSS _2783_/B _2783_/A _4647_/A gf180mcu_as_sc_mcu7t3v3__and2_2
XTAP_TAPCELL_ROW_22_1221 VDD VSS gf180mcu_as_sc_mcu7t3v3__tap_2
X_4522_ VDD VDD VSS VSS _5180_/Q _4574_/B _4522_/C _4522_/D _5180_/D gf180mcu_as_sc_mcu7t3v3__ao211_2
XFILLER_176_1135 VDD VDD VSS VSS gf180mcu_as_sc_mcu7t3v3__fillcap_16
X_4453_ VDD VDD VSS VSS _4453_/B _4533_/A _4460_/C gf180mcu_as_sc_mcu7t3v3__and2_2
XFILLER_176_1157 VDD VDD VSS VSS gf180mcu_as_sc_mcu7t3v3__fillcap_8
X_3404_ VDD VDD VSS VSS _4053_/A _3404_/B _3404_/C _3404_/D _3405_/A gf180mcu_as_sc_mcu7t3v3__ao211_2
X_4384_ VDD VDD VSS VSS _4385_/D _4384_/B _4538_/A gf180mcu_as_sc_mcu7t3v3__nor2_2
Xfanout717 VDD VDD VSS VSS _2948_/Y _3145_/A gf180mcu_as_sc_mcu7t3v3__buff_12
Xfanout728 VDD VDD VSS VSS _3127_/C _3076_/C gf180mcu_as_sc_mcu7t3v3__buff_12
Xfanout739 VDD VDD VSS VSS _2902_/Y _3145_/D gf180mcu_as_sc_mcu7t3v3__buff_12
X_3335_ VDD VDD VSS VSS _3616_/A _3463_/B _3335_/C _4811_/D _3416_/D gf180mcu_as_sc_mcu7t3v3__aoi211_2
XPHY_EDGE_ROW_31_Right_31 VDD VSS gf180mcu_as_sc_mcu7t3v3__tap_2
X_3266_ VDD VDD VSS VSS _3275_/B _3266_/B _3807_/A gf180mcu_as_sc_mcu7t3v3__nand2_2
XFILLER_6_1243 VDD VDD VSS VSS gf180mcu_as_sc_mcu7t3v3__fill_2
X_5005_ VDD VDD VSS VSS clkload3/A _5005_/D _5005_/Q gf180mcu_as_sc_mcu7t3v3__dfxtp_2
XFILLER_6_1287 VDD VDD VSS VSS gf180mcu_as_sc_mcu7t3v3__fillcap_8
X_3197_ VDD VDD VSS VSS _3227_/S _3197_/B _3788_/A _3198_/B gf180mcu_as_sc_mcu7t3v3__mux2_2
XFILLER_26_314 VDD VDD VSS VSS gf180mcu_as_sc_mcu7t3v3__fill_1
XFILLER_26_325 VDD VDD VSS VSS gf180mcu_as_sc_mcu7t3v3__fill_1
XFILLER_38_174 VDD VDD VSS VSS gf180mcu_as_sc_mcu7t3v3__fill_1
XFILLER_74_1423 VDD VDD VSS VSS gf180mcu_as_sc_mcu7t3v3__fill_2
XFILLER_179_352 VDD VDD VSS VSS gf180mcu_as_sc_mcu7t3v3__fillcap_4
XFILLER_34_380 VDD VDD VSS VSS gf180mcu_as_sc_mcu7t3v3__fillcap_4
XFILLER_126_1568 VDD VDD VSS VSS gf180mcu_as_sc_mcu7t3v3__fill_1
XFILLER_194_333 VDD VDD VSS VSS gf180mcu_as_sc_mcu7t3v3__fillcap_16
XFILLER_210_665 VDD VDD VSS VSS gf180mcu_as_sc_mcu7t3v3__fillcap_4
XFILLER_10_737 VDD VDD VSS VSS gf180mcu_as_sc_mcu7t3v3__fill_2
XFILLER_22_597 VDD VDD VSS VSS gf180mcu_as_sc_mcu7t3v3__fillcap_4
XFILLER_154_219 VDD VDD VSS VSS gf180mcu_as_sc_mcu7t3v3__fill_2
XFILLER_5_207 VDD VDD VSS VSS gf180mcu_as_sc_mcu7t3v3__fill_2
XTAP_TAPCELL_ROW_142_1_1871 VDD VSS gf180mcu_as_sc_mcu7t3v3__tap_2
XFILLER_107_135 VDD VDD VSS VSS gf180mcu_as_sc_mcu7t3v3__fillcap_4
XFILLER_11_1440 VDD VDD VSS VSS gf180mcu_as_sc_mcu7t3v3__fill_2
XTAP_TAPCELL_ROW_154_3_3183 VDD VSS gf180mcu_as_sc_mcu7t3v3__tap_2
XFILLER_11_1462 VDD VDD VSS VSS gf180mcu_as_sc_mcu7t3v3__fillcap_8
XFILLER_85_1530 VDD VDD VSS VSS gf180mcu_as_sc_mcu7t3v3__fill_1
XTAP_TAPCELL_ROW_186_2268 VDD VSS gf180mcu_as_sc_mcu7t3v3__tap_2
XTAP_TAPCELL_ROW_186_2257 VDD VSS gf180mcu_as_sc_mcu7t3v3__tap_2
XFILLER_162_22 VDD VDD VSS VSS gf180mcu_as_sc_mcu7t3v3__fillcap_8
XFILLER_39_43 VDD VDD VSS VSS gf180mcu_as_sc_mcu7t3v3__fillcap_8
XFILLER_188_1017 VDD VDD VSS VSS gf180mcu_as_sc_mcu7t3v3__fillcap_16
XFILLER_18_804 VDD VDD VSS VSS gf180mcu_as_sc_mcu7t3v3__fill_1
XFILLER_18_826 VDD VDD VSS VSS gf180mcu_as_sc_mcu7t3v3__fillcap_16
XFILLER_44_122 VDD VDD VSS VSS gf180mcu_as_sc_mcu7t3v3__fillcap_4
XFILLER_166_1348 VDD VDD VSS VSS gf180mcu_as_sc_mcu7t3v3__fillcap_16
XFILLER_32_317 VDD VDD VSS VSS gf180mcu_as_sc_mcu7t3v3__fillcap_16
XFILLER_44_177 VDD VDD VSS VSS gf180mcu_as_sc_mcu7t3v3__fillcap_4
XFILLER_92_1523 VDD VDD VSS VSS gf180mcu_as_sc_mcu7t3v3__fillcap_8
XFILLER_186_801 VDD VDD VSS VSS gf180mcu_as_sc_mcu7t3v3__fillcap_4
XFILLER_186_823 VDD VDD VSS VSS gf180mcu_as_sc_mcu7t3v3__fillcap_16
XFILLER_198_661 VDD VDD VSS VSS gf180mcu_as_sc_mcu7t3v3__fillcap_4
XFILLER_198_683 VDD VDD VSS VSS gf180mcu_as_sc_mcu7t3v3__fillcap_16
XFILLER_201_610 VDD VDD VSS VSS gf180mcu_as_sc_mcu7t3v3__fillcap_16
XFILLER_201_632 VDD VDD VSS VSS gf180mcu_as_sc_mcu7t3v3__fillcap_16
XFILLER_185_366 VDD VDD VSS VSS gf180mcu_as_sc_mcu7t3v3__fill_1
XPHY_EDGE_ROW_108_1_Right_629 VDD VSS gf180mcu_as_sc_mcu7t3v3__tap_2
XFILLER_12_1259 VDD VDD VSS VSS gf180mcu_as_sc_mcu7t3v3__fillcap_16
XFILLER_5_774 VDD VDD VSS VSS gf180mcu_as_sc_mcu7t3v3__fill_1
XFILLER_206_37 VDD VDD VSS VSS gf180mcu_as_sc_mcu7t3v3__fillcap_16
XFILLER_4_295 VDD VDD VSS VSS gf180mcu_as_sc_mcu7t3v3__fillcap_8
XPHY_EDGE_ROW_168_1_Left_378 VDD VSS gf180mcu_as_sc_mcu7t3v3__tap_2
X_3120_ VDD VDD VSS VSS _3145_/A _3120_/B _3120_/C _3145_/D _3122_/C gf180mcu_as_sc_mcu7t3v3__ao211_2
XFILLER_23_1366 VDD VDD VSS VSS gf180mcu_as_sc_mcu7t3v3__fill_2
X_3051_ VDD VDD VSS VSS _3126_/S _4030_/A _4030_/D _3053_/B gf180mcu_as_sc_mcu7t3v3__mux2_2
XFILLER_23_1388 VDD VDD VSS VSS gf180mcu_as_sc_mcu7t3v3__fillcap_8
XFILLER_36_645 VDD VDD VSS VSS gf180mcu_as_sc_mcu7t3v3__fill_1
XFILLER_97_1434 VDD VDD VSS VSS gf180mcu_as_sc_mcu7t3v3__fillcap_8
XFILLER_184_1437 VDD VDD VSS VSS gf180mcu_as_sc_mcu7t3v3__fillcap_8
XFILLER_24_807 VDD VDD VSS VSS gf180mcu_as_sc_mcu7t3v3__fillcap_16
XFILLER_35_133 VDD VDD VSS VSS gf180mcu_as_sc_mcu7t3v3__fillcap_4
XFILLER_149_1568 VDD VDD VSS VSS gf180mcu_as_sc_mcu7t3v3__fill_1
XFILLER_205_960 VDD VDD VSS VSS gf180mcu_as_sc_mcu7t3v3__fillcap_16
XTAP_TAPCELL_ROW_147_1_1886 VDD VSS gf180mcu_as_sc_mcu7t3v3__tap_2
XFILLER_205_982 VDD VDD VSS VSS gf180mcu_as_sc_mcu7t3v3__fillcap_16
XFILLER_50_136 VDD VDD VSS VSS gf180mcu_as_sc_mcu7t3v3__fillcap_16
XTAP_TAPCELL_ROW_159_3_3198 VDD VSS gf180mcu_as_sc_mcu7t3v3__tap_2
X_3953_ VDD VDD VSS VSS _3953_/A _4043_/B _3953_/C _3953_/D _3954_/B gf180mcu_as_sc_mcu7t3v3__ao22_2
XFILLER_188_171 VDD VDD VSS VSS gf180mcu_as_sc_mcu7t3v3__fillcap_4
X_3884_ VDD VDD VSS VSS _3890_/B _5174_/Q _4924_/D gf180mcu_as_sc_mcu7t3v3__and2_2
X_2904_ VDD VDD VSS VSS _3932_/A _3790_/A _3535_/A gf180mcu_as_sc_mcu7t3v3__nor2_2
XFILLER_176_355 VDD VDD VSS VSS gf180mcu_as_sc_mcu7t3v3__fill_1
XFILLER_188_193 VDD VDD VSS VSS gf180mcu_as_sc_mcu7t3v3__fillcap_16
X_2835_ VDD VDD VSS VSS _4748_/A _2835_/A _4762_/D gf180mcu_as_sc_mcu7t3v3__and2_2
XFILLER_121_1432 VDD VDD VSS VSS gf180mcu_as_sc_mcu7t3v3__fillcap_16
XFILLER_136_208 VDD VDD VSS VSS gf180mcu_as_sc_mcu7t3v3__fillcap_4
XFILLER_191_303 VDD VDD VSS VSS gf180mcu_as_sc_mcu7t3v3__fill_2
X_2766_ VDD VDD VSS VSS _4691_/A _2766_/B _2766_/C _4754_/Q _2840_/C gf180mcu_as_sc_mcu7t3v3__ao211_2
XFILLER_69_1558 VDD VDD VSS VSS gf180mcu_as_sc_mcu7t3v3__fillcap_8
XPHY_EDGE_ROW_133_3_Left_518 VDD VSS gf180mcu_as_sc_mcu7t3v3__tap_2
X_5485_ VDD VDD VSS VSS _5485_/A _5485_/Y gf180mcu_as_sc_mcu7t3v3__buff_2
X_4505_ VDD VDD VSS VSS _5180_/Q _4554_/B _4540_/C _5114_/Q _4506_/B gf180mcu_as_sc_mcu7t3v3__ao22_2
X_2697_ VDD VDD VSS VSS _2731_/S _5175_/Q _5167_/Q _2699_/B gf180mcu_as_sc_mcu7t3v3__mux2_2
XTAP_TAPCELL_ROW_42_3_2846 VDD VSS gf180mcu_as_sc_mcu7t3v3__tap_2
XFILLER_156_1539 VDD VDD VSS VSS gf180mcu_as_sc_mcu7t3v3__fill_2
X_4436_ VDD VDD VSS VSS _4440_/B _5071_/Q _4500_/S gf180mcu_as_sc_mcu7t3v3__nand2_2
XFILLER_116_37 VDD VDD VSS VSS gf180mcu_as_sc_mcu7t3v3__fillcap_16
Xfanout514 VDD VDD VSS VSS _4538_/D _4582_/A gf180mcu_as_sc_mcu7t3v3__buff_12
X_4367_ VDD VDD VSS VSS _4367_/B _4493_/B _4368_/C gf180mcu_as_sc_mcu7t3v3__and2_2
XFILLER_24_1119 VDD VDD VSS VSS gf180mcu_as_sc_mcu7t3v3__fillcap_16
XTAP_TAPCELL_ROW_118_1_1800 VDD VSS gf180mcu_as_sc_mcu7t3v3__tap_2
Xfanout525 VDD VDD VSS VSS _3731_/B _3661_/B gf180mcu_as_sc_mcu7t3v3__buff_12
Xfanout536 VDD VDD VSS VSS _3556_/Y _3802_/B gf180mcu_as_sc_mcu7t3v3__buff_12
Xfanout547 VDD VDD VSS VSS _4590_/C _4532_/C gf180mcu_as_sc_mcu7t3v3__buff_12
X_3318_ VDD VDD VSS VSS _3477_/B _3318_/B _3318_/C _3319_/C gf180mcu_as_sc_mcu7t3v3__nor3_2
XFILLER_112_193 VDD VDD VSS VSS gf180mcu_as_sc_mcu7t3v3__fillcap_4
XFILLER_28_1288 VDD VDD VSS VSS gf180mcu_as_sc_mcu7t3v3__fillcap_4
Xfanout558 VDD VDD VSS VSS _3927_/Y _4163_/B gf180mcu_as_sc_mcu7t3v3__buff_12
Xfanout569 VDD VDD VSS VSS _4255_/S _4256_/S gf180mcu_as_sc_mcu7t3v3__buff_12
X_4298_ VDD VDD VSS VSS _4308_/S _5128_/Q _5127_/Q _5127_/D gf180mcu_as_sc_mcu7t3v3__mux2_2
XFILLER_189_1326 VDD VDD VSS VSS gf180mcu_as_sc_mcu7t3v3__fillcap_4
XFILLER_189_1348 VDD VDD VSS VSS gf180mcu_as_sc_mcu7t3v3__fillcap_16
Xmesh_tile_962 VDD VDD VSS VSS north_out[3] gf180mcu_as_sc_mcu7t3v3__tiel_4
Xmesh_tile_951 VDD VDD VSS VSS ne_out[26] gf180mcu_as_sc_mcu7t3v3__tiel_4
Xmesh_tile_940 VDD VDD VSS VSS ne_out[15] gf180mcu_as_sc_mcu7t3v3__tiel_4
X_3249_ VDD VDD VSS VSS _3510_/C _3249_/B _3914_/A gf180mcu_as_sc_mcu7t3v3__nand2_2
XTAP_TAPCELL_ROW_181_2165 VDD VSS gf180mcu_as_sc_mcu7t3v3__tap_2
XTAP_TAPCELL_ROW_181_2154 VDD VSS gf180mcu_as_sc_mcu7t3v3__tap_2
XFILLER_132_69 VDD VDD VSS VSS gf180mcu_as_sc_mcu7t3v3__fillcap_16
Xmesh_tile_995 VDD VDD VSS VSS nw_out[2] gf180mcu_as_sc_mcu7t3v3__tiel_4
Xmesh_tile_984 VDD VDD VSS VSS north_out[25] gf180mcu_as_sc_mcu7t3v3__tiel_4
Xmesh_tile_973 VDD VDD VSS VSS north_out[14] gf180mcu_as_sc_mcu7t3v3__tiel_4
XTAP_TAPCELL_ROW_2_766 VDD VSS gf180mcu_as_sc_mcu7t3v3__tap_2
XTAP_TAPCELL_ROW_2_777 VDD VSS gf180mcu_as_sc_mcu7t3v3__tap_2
XFILLER_14_306 VDD VDD VSS VSS gf180mcu_as_sc_mcu7t3v3__fillcap_8
XFILLER_14_317 VDD VDD VSS VSS gf180mcu_as_sc_mcu7t3v3__fillcap_16
XFILLER_26_188 VDD VDD VSS VSS gf180mcu_as_sc_mcu7t3v3__fillcap_16
XFILLER_155_6 VDD VDD VSS VSS gf180mcu_as_sc_mcu7t3v3__fillcap_16
XFILLER_202_429 VDD VDD VSS VSS gf180mcu_as_sc_mcu7t3v3__fill_1
XFILLER_25_67 VDD VDD VSS VSS gf180mcu_as_sc_mcu7t3v3__fill_2
XFILLER_41_136 VDD VDD VSS VSS gf180mcu_as_sc_mcu7t3v3__fillcap_4
XFILLER_204_1507 VDD VDD VSS VSS gf180mcu_as_sc_mcu7t3v3__fillcap_16
XFILLER_10_512 VDD VDD VSS VSS gf180mcu_as_sc_mcu7t3v3__fill_2
XFILLER_126_1398 VDD VDD VSS VSS gf180mcu_as_sc_mcu7t3v3__fillcap_4
XFILLER_183_804 VDD VDD VSS VSS gf180mcu_as_sc_mcu7t3v3__fillcap_4
XFILLER_195_664 VDD VDD VSS VSS gf180mcu_as_sc_mcu7t3v3__fillcap_16
Xwire904 VDD VDD VSS VSS wire904/A _3992_/D gf180mcu_as_sc_mcu7t3v3__clkbuff_12
XFILLER_127_208 VDD VDD VSS VSS gf180mcu_as_sc_mcu7t3v3__fill_2
XFILLER_13_1524 VDD VDD VSS VSS gf180mcu_as_sc_mcu7t3v3__fillcap_16
XFILLER_157_22 VDD VDD VSS VSS gf180mcu_as_sc_mcu7t3v3__fillcap_16
XFILLER_194_185 VDD VDD VSS VSS gf180mcu_as_sc_mcu7t3v3__fillcap_4
XFILLER_210_495 VDD VDD VSS VSS gf180mcu_as_sc_mcu7t3v3__fillcap_4
XFILLER_41_66 VDD VDD VSS VSS gf180mcu_as_sc_mcu7t3v3__fillcap_4
XFILLER_202_1275 VDD VDD VSS VSS gf180mcu_as_sc_mcu7t3v3__fillcap_16
XFILLER_41_88 VDD VDD VSS VSS gf180mcu_as_sc_mcu7t3v3__fillcap_8
XTAP_TAPCELL_ROW_173_1_1965 VDD VSS gf180mcu_as_sc_mcu7t3v3__tap_2
XFILLER_157_88 VDD VDD VSS VSS gf180mcu_as_sc_mcu7t3v3__fillcap_16
XFILLER_202_1297 VDD VDD VSS VSS gf180mcu_as_sc_mcu7t3v3__fillcap_16
XTAP_TAPCELL_ROW_188_2319 VDD VSS gf180mcu_as_sc_mcu7t3v3__tap_2
XTAP_TAPCELL_ROW_188_2308 VDD VSS gf180mcu_as_sc_mcu7t3v3__tap_2
XFILLER_194_1065 VDD VDD VSS VSS gf180mcu_as_sc_mcu7t3v3__fillcap_16
XFILLER_194_1087 VDD VDD VSS VSS gf180mcu_as_sc_mcu7t3v3__fillcap_16
XFILLER_172_1352 VDD VDD VSS VSS gf180mcu_as_sc_mcu7t3v3__fill_2
XFILLER_173_54 VDD VDD VSS VSS gf180mcu_as_sc_mcu7t3v3__fillcap_16
XFILLER_1_265 VDD VDD VSS VSS gf180mcu_as_sc_mcu7t3v3__fill_1
XFILLER_106_92 VDD VDD VSS VSS gf180mcu_as_sc_mcu7t3v3__fill_2
XFILLER_18_667 VDD VDD VSS VSS gf180mcu_as_sc_mcu7t3v3__fillcap_4
XFILLER_205_212 VDD VDD VSS VSS gf180mcu_as_sc_mcu7t3v3__fillcap_16
XFILLER_209_1418 VDD VDD VSS VSS gf180mcu_as_sc_mcu7t3v3__fillcap_16
XFILLER_33_615 VDD VDD VSS VSS gf180mcu_as_sc_mcu7t3v3__fillcap_8
XFILLER_33_648 VDD VDD VSS VSS gf180mcu_as_sc_mcu7t3v3__fill_2
XFILLER_57_1440 VDD VDD VSS VSS gf180mcu_as_sc_mcu7t3v3__fill_2
XFILLER_202_941 VDD VDD VSS VSS gf180mcu_as_sc_mcu7t3v3__fillcap_4
XFILLER_202_963 VDD VDD VSS VSS gf180mcu_as_sc_mcu7t3v3__fillcap_16
XFILLER_57_1484 VDD VDD VSS VSS gf180mcu_as_sc_mcu7t3v3__fill_2
XFILLER_13_383 VDD VDD VSS VSS gf180mcu_as_sc_mcu7t3v3__fill_2
XFILLER_186_664 VDD VDD VSS VSS gf180mcu_as_sc_mcu7t3v3__fill_1
XFILLER_18_1468 VDD VDD VSS VSS gf180mcu_as_sc_mcu7t3v3__fillcap_8
XFILLER_207_1186 VDD VDD VSS VSS gf180mcu_as_sc_mcu7t3v3__fillcap_4
XFILLER_53_1348 VDD VDD VSS VSS gf180mcu_as_sc_mcu7t3v3__fillcap_4
XFILLER_118_219 VDD VDD VSS VSS gf180mcu_as_sc_mcu7t3v3__fill_2
XFILLER_185_163 VDD VDD VSS VSS gf180mcu_as_sc_mcu7t3v3__fillcap_16
X_2620_ VDD VDD VSS VSS _5245_/Q _2658_/S _2831_/A _2627_/B _2620_/D gf180mcu_as_sc_mcu7t3v3__oai211_2
XFILLER_56_4 VDD VDD VSS VSS gf180mcu_as_sc_mcu7t3v3__fill_1
X_2551_ VDD VDD VSS VSS _2558_/D _2557_/A gf180mcu_as_sc_mcu7t3v3__inv_2
XPHY_EDGE_ROW_173_3_Right_210 VDD VSS gf180mcu_as_sc_mcu7t3v3__tap_2
X_5270_ VDD VDD VSS VSS _5278_/CLK _5270_/D _5270_/Q gf180mcu_as_sc_mcu7t3v3__dfxtp_2
X_2482_ VDD VDD VSS VSS _2482_/B _4291_/A _4719_/A gf180mcu_as_sc_mcu7t3v3__or2_2
XFILLER_177_1296 VDD VDD VSS VSS gf180mcu_as_sc_mcu7t3v3__fillcap_4
XFILLER_29_1542 VDD VDD VSS VSS gf180mcu_as_sc_mcu7t3v3__fill_2
X_4221_ VDD VDD VSS VSS _4250_/B _4228_/B _4228_/C _5057_/Q _5057_/D gf180mcu_as_sc_mcu7t3v3__ao22_2
XFILLER_101_119 VDD VDD VSS VSS gf180mcu_as_sc_mcu7t3v3__fillcap_16
XFILLER_116_1523 VDD VDD VSS VSS gf180mcu_as_sc_mcu7t3v3__fillcap_8
XFILLER_116_1556 VDD VDD VSS VSS gf180mcu_as_sc_mcu7t3v3__fillcap_8
XTAP_TAPCELL_ROW_13_1006 VDD VSS gf180mcu_as_sc_mcu7t3v3__tap_2
XTAP_TAPCELL_ROW_13_1017 VDD VSS gf180mcu_as_sc_mcu7t3v3__tap_2
X_4152_ VDD VDD VSS VSS _4152_/A _4160_/C _4152_/C _4942_/Q _4153_/D gf180mcu_as_sc_mcu7t3v3__ao22_2
XFILLER_23_1130 VDD VDD VSS VSS gf180mcu_as_sc_mcu7t3v3__fillcap_4
XFILLER_3_1202 VDD VDD VSS VSS gf180mcu_as_sc_mcu7t3v3__fill_1
XFILLER_99_1518 VDD VDD VSS VSS gf180mcu_as_sc_mcu7t3v3__fillcap_8
X_4083_ VDD VDD VSS VSS _4083_/A _4141_/B _4083_/C _4247_/B _4124_/D gf180mcu_as_sc_mcu7t3v3__aoi211_2
X_3103_ VDD VDD VSS VSS _3145_/A _3103_/B _3103_/C _3145_/D _3104_/D gf180mcu_as_sc_mcu7t3v3__ao211_2
XFILLER_209_540 VDD VDD VSS VSS gf180mcu_as_sc_mcu7t3v3__fillcap_16
XFILLER_209_562 VDD VDD VSS VSS gf180mcu_as_sc_mcu7t3v3__fillcap_16
X_3034_ VDD VDD VSS VSS _3126_/S _4013_/A _4015_/A _3037_/B gf180mcu_as_sc_mcu7t3v3__mux2_2
XTAP_TAPCELL_ROW_30_1397 VDD VSS gf180mcu_as_sc_mcu7t3v3__tap_2
XTAP_TAPCELL_ROW_30_1386 VDD VSS gf180mcu_as_sc_mcu7t3v3__tap_2
X_4985_ VDD VDD VSS VSS clkload3/A _4985_/D _4985_/Q gf180mcu_as_sc_mcu7t3v3__dfxtp_2
XFILLER_23_158 VDD VDD VSS VSS gf180mcu_as_sc_mcu7t3v3__fillcap_4
X_3936_ VDD VDD VSS VSS _3936_/A _4043_/B _3936_/C _4229_/B _4116_/A gf180mcu_as_sc_mcu7t3v3__aoi211_2
XFILLER_36_1557 VDD VDD VSS VSS gf180mcu_as_sc_mcu7t3v3__fillcap_4
XFILLER_36_1568 VDD VDD VSS VSS gf180mcu_as_sc_mcu7t3v3__fill_1
XFILLER_176_163 VDD VDD VSS VSS gf180mcu_as_sc_mcu7t3v3__fillcap_8
XFILLER_34_1270 VDD VDD VSS VSS gf180mcu_as_sc_mcu7t3v3__fill_2
X_3867_ VDD VDD VSS VSS _3873_/B _3868_/B _3868_/A gf180mcu_as_sc_mcu7t3v3__nand2_2
XFILLER_180_807 VDD VDD VSS VSS gf180mcu_as_sc_mcu7t3v3__fillcap_4
XFILLER_192_645 VDD VDD VSS VSS gf180mcu_as_sc_mcu7t3v3__fillcap_16
X_3798_ VDD VDD VSS VSS _3799_/C _3798_/B _3798_/A gf180mcu_as_sc_mcu7t3v3__nand2_2
X_2818_ VDD VDD VSS VSS _4974_/D _2827_/B _4758_/Q _4757_/D gf180mcu_as_sc_mcu7t3v3__mux2_2
XTAP_TAPCELL_ROW_63_1_1634 VDD VSS gf180mcu_as_sc_mcu7t3v3__tap_2
XFILLER_178_1049 VDD VDD VSS VSS gf180mcu_as_sc_mcu7t3v3__fillcap_16
XFILLER_192_667 VDD VDD VSS VSS gf180mcu_as_sc_mcu7t3v3__fillcap_16
XFILLER_3_508 VDD VDD VSS VSS gf180mcu_as_sc_mcu7t3v3__fill_2
X_2749_ VDD VDD VSS VSS _4953_/Q _2765_/D _2810_/A gf180mcu_as_sc_mcu7t3v3__xnor2_2
XFILLER_191_188 VDD VDD VSS VSS gf180mcu_as_sc_mcu7t3v3__fill_2
XFILLER_195_1396 VDD VDD VSS VSS gf180mcu_as_sc_mcu7t3v3__fillcap_4
X_4419_ VDD VDD VSS VSS _4542_/A _5069_/Q _4982_/Q _4420_/A gf180mcu_as_sc_mcu7t3v3__mux2_2
XTAP_TAPCELL_ROW_183_2205 VDD VSS gf180mcu_as_sc_mcu7t3v3__tap_2
XFILLER_43_1528 VDD VDD VSS VSS gf180mcu_as_sc_mcu7t3v3__fill_2
XFILLER_8_1157 VDD VDD VSS VSS gf180mcu_as_sc_mcu7t3v3__fillcap_16
XFILLER_143_57 VDD VDD VSS VSS gf180mcu_as_sc_mcu7t3v3__fillcap_8
XFILLER_100_174 VDD VDD VSS VSS gf180mcu_as_sc_mcu7t3v3__fill_1
XFILLER_132_1380 VDD VDD VSS VSS gf180mcu_as_sc_mcu7t3v3__fill_1
XFILLER_132_1391 VDD VDD VSS VSS gf180mcu_as_sc_mcu7t3v3__fillcap_4
XFILLER_210_1566 VDD VDD VSS VSS gf180mcu_as_sc_mcu7t3v3__fill_2
XFILLER_36_33 VDD VDD VSS VSS gf180mcu_as_sc_mcu7t3v3__fill_1
XFILLER_36_44 VDD VDD VSS VSS gf180mcu_as_sc_mcu7t3v3__fill_2
XFILLER_128_1427 VDD VDD VSS VSS gf180mcu_as_sc_mcu7t3v3__fillcap_16
XFILLER_15_648 VDD VDD VSS VSS gf180mcu_as_sc_mcu7t3v3__fillcap_4
XFILLER_199_244 VDD VDD VSS VSS gf180mcu_as_sc_mcu7t3v3__fillcap_16
XFILLER_196_995 VDD VDD VSS VSS gf180mcu_as_sc_mcu7t3v3__fillcap_16
XFILLER_7_814 VDD VDD VSS VSS gf180mcu_as_sc_mcu7t3v3__fillcap_16
Xinput19 VDD VDD VSS VSS boot_data[7] _2736_/A gf180mcu_as_sc_mcu7t3v3__buff_12
XFILLER_10_364 VDD VDD VSS VSS gf180mcu_as_sc_mcu7t3v3__fillcap_16
XFILLER_11_898 VDD VDD VSS VSS gf180mcu_as_sc_mcu7t3v3__fill_1
XFILLER_7_858 VDD VDD VSS VSS gf180mcu_as_sc_mcu7t3v3__fillcap_16
Xwire756 VDD VDD VSS VSS _3059_/S _3126_/S gf180mcu_as_sc_mcu7t3v3__clkbuff_12
XFILLER_104_1493 VDD VDD VSS VSS gf180mcu_as_sc_mcu7t3v3__fillcap_16
XFILLER_182_155 VDD VDD VSS VSS gf180mcu_as_sc_mcu7t3v3__fillcap_16
XFILLER_174_1425 VDD VDD VSS VSS gf180mcu_as_sc_mcu7t3v3__fill_2
XFILLER_182_177 VDD VDD VSS VSS gf180mcu_as_sc_mcu7t3v3__fillcap_16
XFILLER_184_53 VDD VDD VSS VSS gf180mcu_as_sc_mcu7t3v3__fillcap_16
XFILLER_96_139 VDD VDD VSS VSS gf180mcu_as_sc_mcu7t3v3__fillcap_4
XFILLER_37_206 VDD VDD VSS VSS gf180mcu_as_sc_mcu7t3v3__fillcap_4
XFILLER_4_1500 VDD VDD VSS VSS gf180mcu_as_sc_mcu7t3v3__fillcap_4
XFILLER_206_521 VDD VDD VSS VSS gf180mcu_as_sc_mcu7t3v3__fillcap_4
XFILLER_185_1532 VDD VDD VSS VSS gf180mcu_as_sc_mcu7t3v3__fillcap_8
XFILLER_206_543 VDD VDD VSS VSS gf180mcu_as_sc_mcu7t3v3__fillcap_16
XFILLER_93_83 VDD VDD VSS VSS gf180mcu_as_sc_mcu7t3v3__fillcap_8
XFILLER_94_1415 VDD VDD VSS VSS gf180mcu_as_sc_mcu7t3v3__fillcap_16
XFILLER_146_1538 VDD VDD VSS VSS gf180mcu_as_sc_mcu7t3v3__fill_2
XFILLER_179_907 VDD VDD VSS VSS gf180mcu_as_sc_mcu7t3v3__fill_2
XFILLER_181_1418 VDD VDD VSS VSS gf180mcu_as_sc_mcu7t3v3__fillcap_16
XFILLER_59_1568 VDD VDD VSS VSS gf180mcu_as_sc_mcu7t3v3__fill_1
XTAP_TAPCELL_ROW_68_1_1649 VDD VSS gf180mcu_as_sc_mcu7t3v3__tap_2
XFILLER_33_478 VDD VDD VSS VSS gf180mcu_as_sc_mcu7t3v3__fill_1
XFILLER_18_1243 VDD VDD VSS VSS gf180mcu_as_sc_mcu7t3v3__fillcap_8
X_4770_ VDD VDD VSS VSS _5241_/CLK _4770_/D _4770_/Q gf180mcu_as_sc_mcu7t3v3__dfxtp_2
XFILLER_186_450 VDD VDD VSS VSS gf180mcu_as_sc_mcu7t3v3__fillcap_4
X_3721_ VDD VDD VSS VSS _3722_/C _3721_/C _3766_/B _4097_/A gf180mcu_as_sc_mcu7t3v3__aoi21_2
XFILLER_9_162 VDD VDD VSS VSS gf180mcu_as_sc_mcu7t3v3__fillcap_16
XFILLER_9_184 VDD VDD VSS VSS gf180mcu_as_sc_mcu7t3v3__fill_1
X_3652_ VDD VDD VSS VSS _4022_/A _3652_/B _3652_/C _3652_/D _3653_/C gf180mcu_as_sc_mcu7t3v3__ao211_2
XFILLER_61_2 VDD VDD VSS VSS gf180mcu_as_sc_mcu7t3v3__fill_2
X_3583_ VDD VDD VSS VSS _3947_/D _3650_/B _3583_/C _3583_/D _3584_/C gf180mcu_as_sc_mcu7t3v3__ao211_2
X_2603_ VDD VDD VSS VSS _2701_/A _2603_/B input1/Y _2604_/A gf180mcu_as_sc_mcu7t3v3__mux2_2
XFILLER_31_1487 VDD VDD VSS VSS gf180mcu_as_sc_mcu7t3v3__fillcap_16
X_2534_ VDD VDD VSS VSS _4371_/B _2534_/A _2534_/B _2534_/C _4366_/S gf180mcu_as_sc_mcu7t3v3__ao31_2
X_5253_ VDD VDD VSS VSS _5262_/CLK _5253_/D _5253_/Q gf180mcu_as_sc_mcu7t3v3__dfxtp_2
X_2465_ VDD VDD VSS VSS _4527_/S _5093_/Q _5006_/Q _2466_/A gf180mcu_as_sc_mcu7t3v3__mux2_2
XTAP_TAPCELL_ROW_36_1540 VDD VSS gf180mcu_as_sc_mcu7t3v3__tap_2
XFILLER_87_128 VDD VDD VSS VSS gf180mcu_as_sc_mcu7t3v3__fill_1
X_5184_ VDD VDD VSS VSS clkload8/A _5184_/D _5184_/Q gf180mcu_as_sc_mcu7t3v3__dfxtp_2
X_4204_ VDD VDD VSS VSS _4233_/B _4224_/B _4224_/C _5040_/Q _5040_/D gf180mcu_as_sc_mcu7t3v3__ao22_2
X_2396_ VDD VDD VSS VSS _4746_/D _2795_/A gf180mcu_as_sc_mcu7t3v3__inv_2
XTAP_TAPCELL_ROW_4_817 VDD VSS gf180mcu_as_sc_mcu7t3v3__tap_2
XTAP_TAPCELL_ROW_36_1551 VDD VSS gf180mcu_as_sc_mcu7t3v3__tap_2
XFILLER_29_718 VDD VDD VSS VSS gf180mcu_as_sc_mcu7t3v3__fillcap_8
X_4135_ VDD VDD VSS VSS _4135_/A _4160_/B _4161_/B _4135_/D _4136_/D gf180mcu_as_sc_mcu7t3v3__ao22_2
XTAP_TAPCELL_ROW_4_828 VDD VSS gf180mcu_as_sc_mcu7t3v3__tap_2
XTAP_TAPCELL_ROW_32_1437 VDD VSS gf180mcu_as_sc_mcu7t3v3__tap_2
XTAP_TAPCELL_ROW_32_1426 VDD VSS gf180mcu_as_sc_mcu7t3v3__tap_2
XFILLER_99_1348 VDD VDD VSS VSS gf180mcu_as_sc_mcu7t3v3__fill_1
XFILLER_113_49 VDD VDD VSS VSS gf180mcu_as_sc_mcu7t3v3__fillcap_16
XFILLER_186_1329 VDD VDD VSS VSS gf180mcu_as_sc_mcu7t3v3__fillcap_16
X_4066_ VDD VDD VSS VSS _4066_/A _4122_/B _4066_/C _4067_/C _4115_/B gf180mcu_as_sc_mcu7t3v3__aoi211_2
XFILLER_25_924 VDD VDD VSS VSS gf180mcu_as_sc_mcu7t3v3__fill_2
X_3017_ VDD VDD VSS VSS _3059_/S _3997_/D _4000_/A _3019_/B gf180mcu_as_sc_mcu7t3v3__mux2_2
XFILLER_51_220 VDD VDD VSS VSS gf180mcu_as_sc_mcu7t3v3__fill_2
XFILLER_196_225 VDD VDD VSS VSS gf180mcu_as_sc_mcu7t3v3__fillcap_16
XFILLER_197_726 VDD VDD VSS VSS gf180mcu_as_sc_mcu7t3v3__fillcap_4
XFILLER_24_467 VDD VDD VSS VSS gf180mcu_as_sc_mcu7t3v3__fill_2
XFILLER_149_130 VDD VDD VSS VSS gf180mcu_as_sc_mcu7t3v3__fillcap_8
XFILLER_184_409 VDD VDD VSS VSS gf180mcu_as_sc_mcu7t3v3__fillcap_16
XFILLER_196_247 VDD VDD VSS VSS gf180mcu_as_sc_mcu7t3v3__fillcap_16
X_4968_ VDD VDD VSS VSS _5111_/CLK _4968_/D _4968_/Q gf180mcu_as_sc_mcu7t3v3__dfxtp_2
XTAP_TAPCELL_ROW_176_2053 VDD VSS gf180mcu_as_sc_mcu7t3v3__tap_2
XTAP_TAPCELL_ROW_176_2042 VDD VSS gf180mcu_as_sc_mcu7t3v3__tap_2
XFILLER_178_995 VDD VDD VSS VSS gf180mcu_as_sc_mcu7t3v3__fillcap_16
X_4899_ VDD VDD VSS VSS _4904_/CLK _4899_/D _4899_/Q gf180mcu_as_sc_mcu7t3v3__dfxtp_2
X_3919_ VDD VDD VSS VSS _3919_/Y _3920_/A _3920_/B gf180mcu_as_sc_mcu7t3v3__nor2_2
XFILLER_149_185 VDD VDD VSS VSS gf180mcu_as_sc_mcu7t3v3__fill_1
XFILLER_20_662 VDD VDD VSS VSS gf180mcu_as_sc_mcu7t3v3__fill_2
XFILLER_192_453 VDD VDD VSS VSS gf180mcu_as_sc_mcu7t3v3__fill_2
XFILLER_193_976 VDD VDD VSS VSS gf180mcu_as_sc_mcu7t3v3__fillcap_4
XFILLER_193_998 VDD VDD VSS VSS gf180mcu_as_sc_mcu7t3v3__fillcap_16
XTAP_TAPCELL_ROW_94_1_1728 VDD VSS gf180mcu_as_sc_mcu7t3v3__tap_2
XFILLER_164_188 VDD VDD VSS VSS gf180mcu_as_sc_mcu7t3v3__fillcap_16
XFILLER_180_637 VDD VDD VSS VSS gf180mcu_as_sc_mcu7t3v3__fillcap_4
XTAP_TAPCELL_ROW_210_2824 VDD VSS gf180mcu_as_sc_mcu7t3v3__tap_2
XTAP_TAPCELL_ROW_210_2813 VDD VSS gf180mcu_as_sc_mcu7t3v3__tap_2
XTAP_TAPCELL_ROW_210_2802 VDD VSS gf180mcu_as_sc_mcu7t3v3__tap_2
XFILLER_180_659 VDD VDD VSS VSS gf180mcu_as_sc_mcu7t3v3__fillcap_4
XFILLER_3_349 VDD VDD VSS VSS gf180mcu_as_sc_mcu7t3v3__fill_1
XPHY_EDGE_ROW_160_1_Right_681 VDD VSS gf180mcu_as_sc_mcu7t3v3__tap_2
XFILLER_154_34 VDD VDD VSS VSS gf180mcu_as_sc_mcu7t3v3__fill_1
XFILLER_191_1046 VDD VDD VSS VSS gf180mcu_as_sc_mcu7t3v3__fillcap_4
XFILLER_191_1068 VDD VDD VSS VSS gf180mcu_as_sc_mcu7t3v3__fillcap_16
XFILLER_134_1453 VDD VDD VSS VSS gf180mcu_as_sc_mcu7t3v3__fillcap_8
XFILLER_134_1475 VDD VDD VSS VSS gf180mcu_as_sc_mcu7t3v3__fillcap_16
XFILLER_82_1385 VDD VDD VSS VSS gf180mcu_as_sc_mcu7t3v3__fill_1
XTAP_TAPCELL_ROW_208_2742 VDD VSS gf180mcu_as_sc_mcu7t3v3__tap_2
XFILLER_170_22 VDD VDD VSS VSS gf180mcu_as_sc_mcu7t3v3__fillcap_8
XFILLER_19_206 VDD VDD VSS VSS gf180mcu_as_sc_mcu7t3v3__fillcap_4
XFILLER_19_228 VDD VDD VSS VSS gf180mcu_as_sc_mcu7t3v3__fillcap_8
XFILLER_207_307 VDD VDD VSS VSS gf180mcu_as_sc_mcu7t3v3__fillcap_16
XFILLER_208_819 VDD VDD VSS VSS gf180mcu_as_sc_mcu7t3v3__fill_2
XFILLER_47_43 VDD VDD VSS VSS gf180mcu_as_sc_mcu7t3v3__fillcap_8
XFILLER_86_172 VDD VDD VSS VSS gf180mcu_as_sc_mcu7t3v3__fill_2
XTAP_TAPCELL_ROW_208_2753 VDD VSS gf180mcu_as_sc_mcu7t3v3__tap_2
XFILLER_169_1549 VDD VDD VSS VSS gf180mcu_as_sc_mcu7t3v3__fillcap_4
XFILLER_210_1330 VDD VDD VSS VSS gf180mcu_as_sc_mcu7t3v3__fill_1
XFILLER_210_1385 VDD VDD VSS VSS gf180mcu_as_sc_mcu7t3v3__fillcap_4
XFILLER_210_1396 VDD VDD VSS VSS gf180mcu_as_sc_mcu7t3v3__fillcap_4
XFILLER_28_795 VDD VDD VSS VSS gf180mcu_as_sc_mcu7t3v3__fillcap_8
XFILLER_16_957 VDD VDD VSS VSS gf180mcu_as_sc_mcu7t3v3__fill_1
XFILLER_16_968 VDD VDD VSS VSS gf180mcu_as_sc_mcu7t3v3__fillcap_16
XFILLER_188_715 VDD VDD VSS VSS gf180mcu_as_sc_mcu7t3v3__fillcap_16
XFILLER_188_737 VDD VDD VSS VSS gf180mcu_as_sc_mcu7t3v3__fillcap_16
XFILLER_203_524 VDD VDD VSS VSS gf180mcu_as_sc_mcu7t3v3__fillcap_16
Xclkbuf_leaf_18_clk_regs VDD VDD VSS VSS clkbuf_3_5__f_clk_regs/Y _5241_/CLK gf180mcu_as_sc_mcu7t3v3__clkbuff_12
XFILLER_187_258 VDD VDD VSS VSS gf180mcu_as_sc_mcu7t3v3__fillcap_16
XFILLER_63_97 VDD VDD VSS VSS gf180mcu_as_sc_mcu7t3v3__fillcap_16
XFILLER_141_1413 VDD VDD VSS VSS gf180mcu_as_sc_mcu7t3v3__fill_2
XFILLER_54_1465 VDD VDD VSS VSS gf180mcu_as_sc_mcu7t3v3__fill_2
XFILLER_8_37 VDD VDD VSS VSS gf180mcu_as_sc_mcu7t3v3__fillcap_16
XFILLER_141_1468 VDD VDD VSS VSS gf180mcu_as_sc_mcu7t3v3__fill_1
Xwire531 VDD VDD VSS VSS _3803_/B _3676_/B gf180mcu_as_sc_mcu7t3v3__clkbuff_12
XFILLER_204_1189 VDD VDD VSS VSS gf180mcu_as_sc_mcu7t3v3__fillcap_16
XTAP_TAPCELL_ROW_141_1_1867 VDD VSS gf180mcu_as_sc_mcu7t3v3__tap_2
XFILLER_7_699 VDD VDD VSS VSS gf180mcu_as_sc_mcu7t3v3__fill_1
XTAP_TAPCELL_ROW_153_3_3179 VDD VSS gf180mcu_as_sc_mcu7t3v3__tap_2
XTAP_TAPCELL_ROW_43_3_2851 VDD VSS gf180mcu_as_sc_mcu7t3v3__tap_2
XFILLER_139_1364 VDD VDD VSS VSS gf180mcu_as_sc_mcu7t3v3__fillcap_16
XFILLER_88_72 VDD VDD VSS VSS gf180mcu_as_sc_mcu7t3v3__fillcap_4
XFILLER_139_1397 VDD VDD VSS VSS gf180mcu_as_sc_mcu7t3v3__fillcap_16
XFILLER_69_139 VDD VDD VSS VSS gf180mcu_as_sc_mcu7t3v3__fill_1
XFILLER_20_1133 VDD VDD VSS VSS gf180mcu_as_sc_mcu7t3v3__fill_1
XFILLER_207_874 VDD VDD VSS VSS gf180mcu_as_sc_mcu7t3v3__fillcap_8
XPHY_EDGE_ROW_142_3_Left_527 VDD VSS gf180mcu_as_sc_mcu7t3v3__tap_2
XFILLER_185_1384 VDD VDD VSS VSS gf180mcu_as_sc_mcu7t3v3__fillcap_16
XFILLER_178_247 VDD VDD VSS VSS gf180mcu_as_sc_mcu7t3v3__fillcap_4
X_4822_ VDD VDD VSS VSS _5068_/CLK _4822_/D _4822_/Q gf180mcu_as_sc_mcu7t3v3__dfxtp_2
XFILLER_18_1073 VDD VDD VSS VSS gf180mcu_as_sc_mcu7t3v3__fillcap_4
X_4753_ VDD VDD VSS VSS _5095_/D _4753_/B _4753_/A gf180mcu_as_sc_mcu7t3v3__nor2_2
XFILLER_179_1100 VDD VDD VSS VSS gf180mcu_as_sc_mcu7t3v3__fillcap_16
XFILLER_186_280 VDD VDD VSS VSS gf180mcu_as_sc_mcu7t3v3__fillcap_16
XFILLER_193_228 VDD VDD VSS VSS gf180mcu_as_sc_mcu7t3v3__fillcap_4
X_3704_ VDD VDD VSS VSS _3704_/D _4077_/A _3728_/B _3800_/C _3705_/C gf180mcu_as_sc_mcu7t3v3__ao31_2
XTAP_TAPCELL_ROW_25_1285 VDD VSS gf180mcu_as_sc_mcu7t3v3__tap_2
XTAP_TAPCELL_ROW_25_1274 VDD VSS gf180mcu_as_sc_mcu7t3v3__tap_2
XFILLER_179_1122 VDD VDD VSS VSS gf180mcu_as_sc_mcu7t3v3__fillcap_16
X_4684_ VDD VDD VSS VSS _5257_/Q _4684_/A _4686_/C gf180mcu_as_sc_mcu7t3v3__or2_2
XFILLER_122_1390 VDD VDD VSS VSS gf180mcu_as_sc_mcu7t3v3__fillcap_16
XFILLER_146_177 VDD VDD VSS VSS gf180mcu_as_sc_mcu7t3v3__fillcap_8
XFILLER_175_998 VDD VDD VSS VSS gf180mcu_as_sc_mcu7t3v3__fillcap_16
XFILLER_200_1543 VDD VDD VSS VSS gf180mcu_as_sc_mcu7t3v3__fill_1
Xmax_cap820 VDD VDD VSS VSS _4091_/A _3715_/A gf180mcu_as_sc_mcu7t3v3__clkbuff_12
X_3635_ VDD VDD VSS VSS _4924_/Q _3727_/B _3727_/C _4007_/A _3636_/D gf180mcu_as_sc_mcu7t3v3__ao22_2
XFILLER_190_979 VDD VDD VSS VSS gf180mcu_as_sc_mcu7t3v3__fillcap_16
X_3566_ VDD VDD VSS VSS _3566_/Y _3740_/B _3790_/C gf180mcu_as_sc_mcu7t3v3__nor2_2
XFILLER_0_308 VDD VDD VSS VSS gf180mcu_as_sc_mcu7t3v3__fillcap_4
X_3497_ VDD VDD VSS VSS _4155_/A _3522_/C _3497_/C _3497_/D _3498_/B gf180mcu_as_sc_mcu7t3v3__ao211_2
X_2517_ VDD VDD VSS VSS _2517_/D _4749_/A _2517_/B _2517_/C _2765_/B gf180mcu_as_sc_mcu7t3v3__ao31_2
X_5236_ VDD VDD VSS VSS _5276_/CLK _5236_/D _5236_/Q gf180mcu_as_sc_mcu7t3v3__dfxtp_2
Xinput209 VDD VDD VSS VSS se_in[4] wire870/A gf180mcu_as_sc_mcu7t3v3__buff_12
X_2448_ VDD VDD VSS VSS _3775_/A _4156_/A gf180mcu_as_sc_mcu7t3v3__inv_2
XFILLER_124_37 VDD VDD VSS VSS gf180mcu_as_sc_mcu7t3v3__fillcap_16
XFILLER_5_1138 VDD VDD VSS VSS gf180mcu_as_sc_mcu7t3v3__fillcap_8
X_5167_ VDD VDD VSS VSS clkload9/A _5167_/D _5167_/Q gf180mcu_as_sc_mcu7t3v3__dfxtp_2
XFILLER_29_559 VDD VDD VSS VSS gf180mcu_as_sc_mcu7t3v3__fill_1
XFILLER_83_120 VDD VDD VSS VSS gf180mcu_as_sc_mcu7t3v3__fillcap_8
X_5098_ VDD VDD VSS VSS _5111_/CLK _5098_/D _5098_/Q gf180mcu_as_sc_mcu7t3v3__dfxtp_2
X_4118_ VDD VDD VSS VSS _4118_/A _4118_/B _4118_/C _4118_/D _4119_/D gf180mcu_as_sc_mcu7t3v3__ao22_2
XTAP_TAPCELL_ROW_68_3_2924 VDD VSS gf180mcu_as_sc_mcu7t3v3__tap_2
XPHY_EDGE_ROW_74_3_Left_459 VDD VSS gf180mcu_as_sc_mcu7t3v3__tap_2
X_4049_ VDD VDD VSS VSS _4049_/A _4105_/B _4049_/C _4049_/D _4050_/B gf180mcu_as_sc_mcu7t3v3__ao211_2
XTAP_TAPCELL_ROW_38_1_1560 VDD VSS gf180mcu_as_sc_mcu7t3v3__tap_2
XFILLER_13_916 VDD VDD VSS VSS gf180mcu_as_sc_mcu7t3v3__fill_2
XFILLER_197_556 VDD VDD VSS VSS gf180mcu_as_sc_mcu7t3v3__fillcap_4
XFILLER_200_505 VDD VDD VSS VSS gf180mcu_as_sc_mcu7t3v3__fillcap_16
XTAP_TAPCELL_ROW_48_3_2866 VDD VSS gf180mcu_as_sc_mcu7t3v3__tap_2
XTAP_TAPCELL_ROW_195_2462 VDD VSS gf180mcu_as_sc_mcu7t3v3__tap_2
XFILLER_185_718 VDD VDD VSS VSS gf180mcu_as_sc_mcu7t3v3__fillcap_16
XFILLER_197_578 VDD VDD VSS VSS gf180mcu_as_sc_mcu7t3v3__fillcap_16
XFILLER_200_527 VDD VDD VSS VSS gf180mcu_as_sc_mcu7t3v3__fillcap_16
XFILLER_33_67 VDD VDD VSS VSS gf180mcu_as_sc_mcu7t3v3__fill_2
XFILLER_36_1140 VDD VDD VSS VSS gf180mcu_as_sc_mcu7t3v3__fillcap_16
XTAP_TAPCELL_ROW_195_2473 VDD VSS gf180mcu_as_sc_mcu7t3v3__tap_2
XFILLER_149_67 VDD VDD VSS VSS gf180mcu_as_sc_mcu7t3v3__fill_2
XFILLER_21_960 VDD VDD VSS VSS gf180mcu_as_sc_mcu7t3v3__fillcap_16
XFILLER_21_982 VDD VDD VSS VSS gf180mcu_as_sc_mcu7t3v3__fillcap_16
XFILLER_152_103 VDD VDD VSS VSS gf180mcu_as_sc_mcu7t3v3__fill_2
XFILLER_165_22 VDD VDD VSS VSS gf180mcu_as_sc_mcu7t3v3__fillcap_16
XFILLER_101_1463 VDD VDD VSS VSS gf180mcu_as_sc_mcu7t3v3__fillcap_16
XFILLER_101_1485 VDD VDD VSS VSS gf180mcu_as_sc_mcu7t3v3__fill_1
XFILLER_109_2 VDD VDD VSS VSS gf180mcu_as_sc_mcu7t3v3__fill_2
XFILLER_175_1542 VDD VDD VSS VSS gf180mcu_as_sc_mcu7t3v3__fill_2
XFILLER_84_1447 VDD VDD VSS VSS gf180mcu_as_sc_mcu7t3v3__fillcap_4
XPHY_EDGE_ROW_161_1_Right_682 VDD VSS gf180mcu_as_sc_mcu7t3v3__tap_2
XFILLER_84_1469 VDD VDD VSS VSS gf180mcu_as_sc_mcu7t3v3__fill_1
XFILLER_58_53 VDD VDD VSS VSS gf180mcu_as_sc_mcu7t3v3__fillcap_8
XTAP_TAPCELL_ROW_129_3_3108 VDD VSS gf180mcu_as_sc_mcu7t3v3__tap_2
XFILLER_207_104 VDD VDD VSS VSS gf180mcu_as_sc_mcu7t3v3__fillcap_16
XFILLER_210_1160 VDD VDD VSS VSS gf180mcu_as_sc_mcu7t3v3__fill_1
XFILLER_60_1491 VDD VDD VSS VSS gf180mcu_as_sc_mcu7t3v3__fill_1
XFILLER_16_721 VDD VDD VSS VSS gf180mcu_as_sc_mcu7t3v3__fillcap_4
XFILLER_16_743 VDD VDD VSS VSS gf180mcu_as_sc_mcu7t3v3__fill_1
XFILLER_15_242 VDD VDD VSS VSS gf180mcu_as_sc_mcu7t3v3__fillcap_8
XFILLER_204_855 VDD VDD VSS VSS gf180mcu_as_sc_mcu7t3v3__fillcap_16
XFILLER_31_702 VDD VDD VSS VSS gf180mcu_as_sc_mcu7t3v3__fillcap_16
XFILLER_91_1418 VDD VDD VSS VSS gf180mcu_as_sc_mcu7t3v3__fillcap_8
XFILLER_130_80 VDD VDD VSS VSS gf180mcu_as_sc_mcu7t3v3__fillcap_16
XFILLER_204_877 VDD VDD VSS VSS gf180mcu_as_sc_mcu7t3v3__fillcap_16
XFILLER_30_212 VDD VDD VSS VSS gf180mcu_as_sc_mcu7t3v3__fillcap_8
XFILLER_15_1213 VDD VDD VSS VSS gf180mcu_as_sc_mcu7t3v3__fill_1
XFILLER_11_492 VDD VDD VSS VSS gf180mcu_as_sc_mcu7t3v3__fillcap_8
XFILLER_7_430 VDD VDD VSS VSS gf180mcu_as_sc_mcu7t3v3__fillcap_4
XFILLER_128_177 VDD VDD VSS VSS gf180mcu_as_sc_mcu7t3v3__fillcap_16
XTAP_TAPCELL_ROW_20_1160 VDD VSS gf180mcu_as_sc_mcu7t3v3__tap_2
X_3420_ VDD VDD VSS VSS _4069_/D _3468_/B _3420_/C _3420_/D _3421_/A gf180mcu_as_sc_mcu7t3v3__ao22_2
XTAP_TAPCELL_ROW_20_1171 VDD VSS gf180mcu_as_sc_mcu7t3v3__tap_2
XFILLER_143_158 VDD VDD VSS VSS gf180mcu_as_sc_mcu7t3v3__fillcap_16
X_3351_ VDD VDD VSS VSS _3455_/B _3351_/B _3351_/C _3352_/C gf180mcu_as_sc_mcu7t3v3__nor3_2
XFILLER_97_212 VDD VDD VSS VSS gf180mcu_as_sc_mcu7t3v3__fillcap_8
X_3282_ VDD VDD VSS VSS _3526_/D _3286_/B gf180mcu_as_sc_mcu7t3v3__inv_2
XFILLER_24_2 VDD VDD VSS VSS gf180mcu_as_sc_mcu7t3v3__fillcap_16
XFILLER_26_1364 VDD VDD VSS VSS gf180mcu_as_sc_mcu7t3v3__fill_1
X_5021_ VDD VDD VSS VSS clkload2/A _5021_/D _5021_/Q gf180mcu_as_sc_mcu7t3v3__dfxtp_2
Xhold1108 VDD VDD VSS VSS _3906_/B _2588_/A gf180mcu_as_sc_mcu7t3v3__clkbuff_4
Xhold1119 VDD VDD VSS VSS hold1147/Y _4957_/D gf180mcu_as_sc_mcu7t3v3__clkbuff_4
XFILLER_187_1402 VDD VDD VSS VSS gf180mcu_as_sc_mcu7t3v3__fillcap_16
XFILLER_65_142 VDD VDD VSS VSS gf180mcu_as_sc_mcu7t3v3__fillcap_8
XFILLER_0_1013 VDD VDD VSS VSS gf180mcu_as_sc_mcu7t3v3__fill_2
XFILLER_0_1024 VDD VDD VSS VSS gf180mcu_as_sc_mcu7t3v3__fill_1
XFILLER_80_123 VDD VDD VSS VSS gf180mcu_as_sc_mcu7t3v3__fillcap_8
XFILLER_185_1170 VDD VDD VSS VSS gf180mcu_as_sc_mcu7t3v3__fillcap_16
XTAP_TAPCELL_ROW_27_1314 VDD VSS gf180mcu_as_sc_mcu7t3v3__tap_2
XFILLER_185_1192 VDD VDD VSS VSS gf180mcu_as_sc_mcu7t3v3__fillcap_16
XFILLER_21_212 VDD VDD VSS VSS gf180mcu_as_sc_mcu7t3v3__fillcap_4
XTAP_TAPCELL_ROW_27_1325 VDD VSS gf180mcu_as_sc_mcu7t3v3__tap_2
XFILLER_210_847 VDD VDD VSS VSS gf180mcu_as_sc_mcu7t3v3__fill_2
XFILLER_21_245 VDD VDD VSS VSS gf180mcu_as_sc_mcu7t3v3__fill_2
XFILLER_33_1302 VDD VDD VSS VSS gf180mcu_as_sc_mcu7t3v3__fillcap_8
X_4805_ VDD VDD VSS VSS _5068_/CLK _4805_/D _4805_/Q gf180mcu_as_sc_mcu7t3v3__dfxtp_2
XFILLER_194_559 VDD VDD VSS VSS gf180mcu_as_sc_mcu7t3v3__fillcap_16
XFILLER_37_1482 VDD VDD VSS VSS gf180mcu_as_sc_mcu7t3v3__fillcap_4
X_2997_ VDD VDD VSS VSS _3005_/A _2997_/B _2997_/C _2998_/C gf180mcu_as_sc_mcu7t3v3__nor3_2
XFILLER_124_1485 VDD VDD VSS VSS gf180mcu_as_sc_mcu7t3v3__fillcap_16
XFILLER_72_1395 VDD VDD VSS VSS gf180mcu_as_sc_mcu7t3v3__fill_2
X_4736_ VDD VDD VSS VSS _4737_/C _4736_/B _5270_/Q gf180mcu_as_sc_mcu7t3v3__nor2_2
XTAP_TAPCELL_ROW_123_3_3090 VDD VSS gf180mcu_as_sc_mcu7t3v3__tap_2
X_4667_ VDD VDD VSS VSS _5104_/Q _4683_/C _4681_/C _5242_/Q _4668_/C gf180mcu_as_sc_mcu7t3v3__ao22_2
X_3618_ VDD VDD VSS VSS _4922_/Q _3648_/B _3648_/C _3990_/A _3620_/C gf180mcu_as_sc_mcu7t3v3__ao22_2
XFILLER_134_158 VDD VDD VSS VSS gf180mcu_as_sc_mcu7t3v3__fillcap_16
X_4598_ VDD VDD VSS VSS _5192_/Q _4750_/D _4604_/C _5193_/Q _5192_/D gf180mcu_as_sc_mcu7t3v3__ao22_2
XFILLER_135_47 VDD VDD VSS VSS gf180mcu_as_sc_mcu7t3v3__fill_2
X_3549_ VDD VDD VSS VSS _3562_/B _3811_/B _3776_/B gf180mcu_as_sc_mcu7t3v3__nand2_2
XFILLER_0_138 VDD VDD VSS VSS gf180mcu_as_sc_mcu7t3v3__fillcap_4
XTAP_TAPCELL_ROW_89_1_1712 VDD VSS gf180mcu_as_sc_mcu7t3v3__tap_2
XFILLER_170_1450 VDD VDD VSS VSS gf180mcu_as_sc_mcu7t3v3__fill_1
XFILLER_170_1461 VDD VDD VSS VSS gf180mcu_as_sc_mcu7t3v3__fillcap_4
XFILLER_44_1453 VDD VDD VSS VSS gf180mcu_as_sc_mcu7t3v3__fillcap_16
X_5219_ VDD VDD VSS VSS _5220_/CLK _5219_/D _5219_/Q gf180mcu_as_sc_mcu7t3v3__dfxtp_2
XFILLER_185_6 VDD VDD VSS VSS gf180mcu_as_sc_mcu7t3v3__fillcap_16
XFILLER_28_34 VDD VDD VSS VSS gf180mcu_as_sc_mcu7t3v3__fill_1
XFILLER_44_1486 VDD VDD VSS VSS gf180mcu_as_sc_mcu7t3v3__fillcap_16
XFILLER_17_518 VDD VDD VSS VSS gf180mcu_as_sc_mcu7t3v3__fill_1
XFILLER_29_356 VDD VDD VSS VSS gf180mcu_as_sc_mcu7t3v3__fill_1
XFILLER_204_107 VDD VDD VSS VSS gf180mcu_as_sc_mcu7t3v3__fillcap_16
XFILLER_71_101 VDD VDD VSS VSS gf180mcu_as_sc_mcu7t3v3__fillcap_16
XTAP_TAPCELL_ROW_197_2513 VDD VSS gf180mcu_as_sc_mcu7t3v3__tap_2
XTAP_TAPCELL_ROW_197_2502 VDD VSS gf180mcu_as_sc_mcu7t3v3__tap_2
XFILLER_13_702 VDD VDD VSS VSS gf180mcu_as_sc_mcu7t3v3__fillcap_4
XFILLER_25_562 VDD VDD VSS VSS gf180mcu_as_sc_mcu7t3v3__fillcap_16
XFILLER_71_178 VDD VDD VSS VSS gf180mcu_as_sc_mcu7t3v3__fill_1
XFILLER_71_189 VDD VDD VSS VSS gf180mcu_as_sc_mcu7t3v3__fillcap_16
XFILLER_16_1511 VDD VDD VSS VSS gf180mcu_as_sc_mcu7t3v3__fill_1
Xsram2048.u_bank1_922 VDD VDD VSS VSS sram2048.u_bank1/WEN[4] gf180mcu_as_sc_mcu7t3v3__tiel_4
XFILLER_185_548 VDD VDD VSS VSS gf180mcu_as_sc_mcu7t3v3__fillcap_8
XFILLER_201_858 VDD VDD VSS VSS gf180mcu_as_sc_mcu7t3v3__fillcap_16
XFILLER_205_1240 VDD VDD VSS VSS gf180mcu_as_sc_mcu7t3v3__fillcap_16
XFILLER_205_1262 VDD VDD VSS VSS gf180mcu_as_sc_mcu7t3v3__fillcap_16
XFILLER_8_205 VDD VDD VSS VSS gf180mcu_as_sc_mcu7t3v3__fillcap_4
XFILLER_51_1468 VDD VDD VSS VSS gf180mcu_as_sc_mcu7t3v3__fillcap_4
XFILLER_197_1030 VDD VDD VSS VSS gf180mcu_as_sc_mcu7t3v3__fillcap_16
XFILLER_197_1052 VDD VDD VSS VSS gf180mcu_as_sc_mcu7t3v3__fillcap_16
XFILLER_5_901 VDD VDD VSS VSS gf180mcu_as_sc_mcu7t3v3__fillcap_8
XTAP_TAPCELL_ROW_11_969 VDD VSS gf180mcu_as_sc_mcu7t3v3__tap_2
XFILLER_181_732 VDD VDD VSS VSS gf180mcu_as_sc_mcu7t3v3__fillcap_16
XFILLER_5_967 VDD VDD VSS VSS gf180mcu_as_sc_mcu7t3v3__fillcap_8
XFILLER_10_1154 VDD VDD VSS VSS gf180mcu_as_sc_mcu7t3v3__fill_1
XFILLER_10_1165 VDD VDD VSS VSS gf180mcu_as_sc_mcu7t3v3__fillcap_4
XFILLER_125_158 VDD VDD VSS VSS gf180mcu_as_sc_mcu7t3v3__fillcap_4
XFILLER_140_139 VDD VDD VSS VSS gf180mcu_as_sc_mcu7t3v3__fillcap_16
XFILLER_175_1383 VDD VDD VSS VSS gf180mcu_as_sc_mcu7t3v3__fillcap_4
XFILLER_79_212 VDD VDD VSS VSS gf180mcu_as_sc_mcu7t3v3__fillcap_8
XFILLER_192_53 VDD VDD VSS VSS gf180mcu_as_sc_mcu7t3v3__fillcap_16
XFILLER_69_96 VDD VDD VSS VSS gf180mcu_as_sc_mcu7t3v3__fillcap_16
XPHY_EDGE_ROW_162_1_Right_683 VDD VSS gf180mcu_as_sc_mcu7t3v3__tap_2
XFILLER_136_1378 VDD VDD VSS VSS gf180mcu_as_sc_mcu7t3v3__fill_2
XFILLER_62_1564 VDD VDD VSS VSS gf180mcu_as_sc_mcu7t3v3__fillcap_4
XFILLER_23_1537 VDD VDD VSS VSS gf180mcu_as_sc_mcu7t3v3__fill_2
XFILLER_47_120 VDD VDD VSS VSS gf180mcu_as_sc_mcu7t3v3__fillcap_16
XFILLER_208_457 VDD VDD VSS VSS gf180mcu_as_sc_mcu7t3v3__fillcap_16
XFILLER_47_142 VDD VDD VSS VSS gf180mcu_as_sc_mcu7t3v3__fillcap_8
Xclkbuf_leaf_33_clk_regs VDD VDD VSS VSS clkbuf_3_0__f_clk_regs/Y clkload4/A gf180mcu_as_sc_mcu7t3v3__clkbuff_12
XFILLER_141_90 VDD VDD VSS VSS gf180mcu_as_sc_mcu7t3v3__fill_1
XTAP_TAPCELL_ROW_116_1_1793 VDD VSS gf180mcu_as_sc_mcu7t3v3__tap_2
X_2920_ VDD VDD VSS VSS _3513_/A _3522_/A _3814_/A gf180mcu_as_sc_mcu7t3v3__or2_2
XFILLER_176_515 VDD VDD VSS VSS gf180mcu_as_sc_mcu7t3v3__fill_2
XFILLER_188_364 VDD VDD VSS VSS gf180mcu_as_sc_mcu7t3v3__fill_1
XFILLER_56_1379 VDD VDD VSS VSS gf180mcu_as_sc_mcu7t3v3__fill_2
XFILLER_108_1469 VDD VDD VSS VSS gf180mcu_as_sc_mcu7t3v3__fillcap_16
X_2851_ VDD VDD VSS VSS _3874_/A _2851_/B _2851_/A gf180mcu_as_sc_mcu7t3v3__nor2_2
XTAP_TAPCELL_ROW_22_1211 VDD VSS gf180mcu_as_sc_mcu7t3v3__tap_2
X_2782_ VDD VDD VSS VSS _4649_/A _5275_/Q _2783_/B gf180mcu_as_sc_mcu7t3v3__and2_2
XTAP_TAPCELL_ROW_22_1222 VDD VSS gf180mcu_as_sc_mcu7t3v3__tap_2
XFILLER_8_761 VDD VDD VSS VSS gf180mcu_as_sc_mcu7t3v3__fill_1
X_4521_ VDD VDD VSS VSS _4522_/D _4521_/B _4521_/A gf180mcu_as_sc_mcu7t3v3__nor2_2
XFILLER_171_220 VDD VDD VSS VSS gf180mcu_as_sc_mcu7t3v3__fill_2
XFILLER_176_1103 VDD VDD VSS VSS gf180mcu_as_sc_mcu7t3v3__fillcap_16
XFILLER_7_282 VDD VDD VSS VSS gf180mcu_as_sc_mcu7t3v3__fillcap_4
X_4452_ VDD VDD VSS VSS _5174_/Q _4493_/B _4532_/C _5108_/Q _4453_/B gf180mcu_as_sc_mcu7t3v3__ao22_2
XFILLER_119_1510 VDD VDD VSS VSS gf180mcu_as_sc_mcu7t3v3__fill_1
X_3403_ VDD VDD VSS VSS _3403_/S _4053_/D _3403_/A _3404_/D gf180mcu_as_sc_mcu7t3v3__mux2_2
XFILLER_193_1450 VDD VDD VSS VSS gf180mcu_as_sc_mcu7t3v3__fillcap_16
XFILLER_193_1472 VDD VDD VSS VSS gf180mcu_as_sc_mcu7t3v3__fillcap_16
XFILLER_67_1453 VDD VDD VSS VSS gf180mcu_as_sc_mcu7t3v3__fill_1
X_4383_ VDD VDD VSS VSS _4456_/S _5007_/Q _5036_/Q _4384_/B gf180mcu_as_sc_mcu7t3v3__mux2_2
XFILLER_28_1437 VDD VDD VSS VSS gf180mcu_as_sc_mcu7t3v3__fillcap_16
Xfanout707 VDD VDD VSS VSS _3450_/B _3401_/B gf180mcu_as_sc_mcu7t3v3__buff_12
Xfanout718 VDD VDD VSS VSS _2948_/Y _3178_/A gf180mcu_as_sc_mcu7t3v3__buff_12
Xfanout729 VDD VDD VSS VSS _2931_/Y _3127_/C gf180mcu_as_sc_mcu7t3v3__buff_12
X_3334_ VDD VDD VSS VSS _3408_/B _3334_/B _3334_/C _3335_/C gf180mcu_as_sc_mcu7t3v3__nor3_2
X_3265_ VDD VDD VSS VSS _3265_/B _3275_/A _3521_/B gf180mcu_as_sc_mcu7t3v3__and2_2
XFILLER_22_1025 VDD VDD VSS VSS gf180mcu_as_sc_mcu7t3v3__fillcap_8
XFILLER_26_1161 VDD VDD VSS VSS gf180mcu_as_sc_mcu7t3v3__fill_1
X_5004_ VDD VDD VSS VSS _5095_/CLK _5004_/D _5004_/Q gf180mcu_as_sc_mcu7t3v3__dfxtp_2
XFILLER_27_827 VDD VDD VSS VSS gf180mcu_as_sc_mcu7t3v3__fillcap_8
X_3196_ VDD VDD VSS VSS _3216_/B _3791_/A _3197_/B gf180mcu_as_sc_mcu7t3v3__or2_2
XFILLER_22_1069 VDD VDD VSS VSS gf180mcu_as_sc_mcu7t3v3__fill_2
XFILLER_198_139 VDD VDD VSS VSS gf180mcu_as_sc_mcu7t3v3__fillcap_16
XTAP_TAPCELL_ROW_162_1_1930 VDD VSS gf180mcu_as_sc_mcu7t3v3__tap_2
XFILLER_139_206 VDD VDD VSS VSS gf180mcu_as_sc_mcu7t3v3__fillcap_4
XFILLER_22_543 VDD VDD VSS VSS gf180mcu_as_sc_mcu7t3v3__fillcap_8
XFILLER_35_1419 VDD VDD VSS VSS gf180mcu_as_sc_mcu7t3v3__fillcap_4
XFILLER_39_1566 VDD VDD VSS VSS gf180mcu_as_sc_mcu7t3v3__fill_2
XFILLER_10_716 VDD VDD VSS VSS gf180mcu_as_sc_mcu7t3v3__fill_1
XFILLER_14_69 VDD VDD VSS VSS gf180mcu_as_sc_mcu7t3v3__fillcap_16
XFILLER_161_1438 VDD VDD VSS VSS gf180mcu_as_sc_mcu7t3v3__fill_1
XFILLER_210_655 VDD VDD VSS VSS gf180mcu_as_sc_mcu7t3v3__fillcap_4
XFILLER_210_699 VDD VDD VSS VSS gf180mcu_as_sc_mcu7t3v3__fill_2
XFILLER_33_1176 VDD VDD VSS VSS gf180mcu_as_sc_mcu7t3v3__fill_2
XTAP_TAPCELL_ROW_142_1_1872 VDD VSS gf180mcu_as_sc_mcu7t3v3__tap_2
X_4719_ VDD VDD VSS VSS _4721_/B _4719_/B _4719_/A gf180mcu_as_sc_mcu7t3v3__nand2_2
XFILLER_175_592 VDD VDD VSS VSS gf180mcu_as_sc_mcu7t3v3__fillcap_16
XFILLER_198_1361 VDD VDD VSS VSS gf180mcu_as_sc_mcu7t3v3__fillcap_4
XFILLER_198_1383 VDD VDD VSS VSS gf180mcu_as_sc_mcu7t3v3__fillcap_16
XFILLER_50_1490 VDD VDD VSS VSS gf180mcu_as_sc_mcu7t3v3__fill_2
XTAP_TAPCELL_ROW_154_3_3184 VDD VSS gf180mcu_as_sc_mcu7t3v3__tap_2
XFILLER_11_1485 VDD VDD VSS VSS gf180mcu_as_sc_mcu7t3v3__fillcap_16
XFILLER_85_1520 VDD VDD VSS VSS gf180mcu_as_sc_mcu7t3v3__fillcap_8
XFILLER_122_139 VDD VDD VSS VSS gf180mcu_as_sc_mcu7t3v3__fill_1
XFILLER_172_1523 VDD VDD VSS VSS gf180mcu_as_sc_mcu7t3v3__fillcap_16
XFILLER_46_1515 VDD VDD VSS VSS gf180mcu_as_sc_mcu7t3v3__fillcap_4
XFILLER_1_436 VDD VDD VSS VSS gf180mcu_as_sc_mcu7t3v3__fill_2
XTAP_TAPCELL_ROW_186_2269 VDD VSS gf180mcu_as_sc_mcu7t3v3__tap_2
XTAP_TAPCELL_ROW_186_2258 VDD VSS gf180mcu_as_sc_mcu7t3v3__tap_2
XFILLER_162_34 VDD VDD VSS VSS gf180mcu_as_sc_mcu7t3v3__fill_1
XFILLER_162_67 VDD VDD VSS VSS gf180mcu_as_sc_mcu7t3v3__fillcap_16
XFILLER_39_88 VDD VDD VSS VSS gf180mcu_as_sc_mcu7t3v3__fill_2
XFILLER_29_153 VDD VDD VSS VSS gf180mcu_as_sc_mcu7t3v3__fillcap_16
XFILLER_17_326 VDD VDD VSS VSS gf180mcu_as_sc_mcu7t3v3__fillcap_16
XFILLER_205_416 VDD VDD VSS VSS gf180mcu_as_sc_mcu7t3v3__fillcap_4
XFILLER_205_438 VDD VDD VSS VSS gf180mcu_as_sc_mcu7t3v3__fillcap_16
XFILLER_92_1535 VDD VDD VSS VSS gf180mcu_as_sc_mcu7t3v3__fill_2
XFILLER_111_60 VDD VDD VSS VSS gf180mcu_as_sc_mcu7t3v3__fill_2
XFILLER_25_381 VDD VDD VSS VSS gf180mcu_as_sc_mcu7t3v3__fill_2
XFILLER_92_1568 VDD VDD VSS VSS gf180mcu_as_sc_mcu7t3v3__fill_1
XFILLER_13_576 VDD VDD VSS VSS gf180mcu_as_sc_mcu7t3v3__fill_1
XFILLER_12_1227 VDD VDD VSS VSS gf180mcu_as_sc_mcu7t3v3__fillcap_4
XFILLER_142_1393 VDD VDD VSS VSS gf180mcu_as_sc_mcu7t3v3__fillcap_16
XFILLER_153_220 VDD VDD VSS VSS gf180mcu_as_sc_mcu7t3v3__fill_2
XFILLER_177_1456 VDD VDD VSS VSS gf180mcu_as_sc_mcu7t3v3__fill_1
XFILLER_181_562 VDD VDD VSS VSS gf180mcu_as_sc_mcu7t3v3__fillcap_8
XFILLER_5_742 VDD VDD VSS VSS gf180mcu_as_sc_mcu7t3v3__fill_2
XFILLER_113_106 VDD VDD VSS VSS gf180mcu_as_sc_mcu7t3v3__fillcap_16
XFILLER_113_139 VDD VDD VSS VSS gf180mcu_as_sc_mcu7t3v3__fill_1
XPHY_EDGE_ROW_151_3_Left_536 VDD VSS gf180mcu_as_sc_mcu7t3v3__tap_2
XPHY_EDGE_ROW_163_1_Right_684 VDD VSS gf180mcu_as_sc_mcu7t3v3__tap_2
XFILLER_121_172 VDD VDD VSS VSS gf180mcu_as_sc_mcu7t3v3__fill_1
XFILLER_121_183 VDD VDD VSS VSS gf180mcu_as_sc_mcu7t3v3__fillcap_16
XFILLER_7_1542 VDD VDD VSS VSS gf180mcu_as_sc_mcu7t3v3__fill_2
X_3050_ VDD VDD VSS VSS _4032_/A _3125_/B _3125_/C _4032_/D _3056_/B gf180mcu_as_sc_mcu7t3v3__ao22_2
XTAP_TAPCELL_ROW_167_1_1945 VDD VSS gf180mcu_as_sc_mcu7t3v3__tap_2
XFILLER_3_1406 VDD VDD VSS VSS gf180mcu_as_sc_mcu7t3v3__fill_2
XFILLER_62_1383 VDD VDD VSS VSS gf180mcu_as_sc_mcu7t3v3__fill_1
XTAP_TAPCELL_ROW_15_1070 VDD VSS gf180mcu_as_sc_mcu7t3v3__tap_2
XFILLER_110_1348 VDD VDD VSS VSS gf180mcu_as_sc_mcu7t3v3__fillcap_4
XFILLER_209_766 VDD VDD VSS VSS gf180mcu_as_sc_mcu7t3v3__fillcap_4
XFILLER_209_788 VDD VDD VSS VSS gf180mcu_as_sc_mcu7t3v3__fillcap_8
XFILLER_35_112 VDD VDD VSS VSS gf180mcu_as_sc_mcu7t3v3__fillcap_4
XFILLER_82_218 VDD VDD VSS VSS gf180mcu_as_sc_mcu7t3v3__fillcap_4
XFILLER_97_1446 VDD VDD VSS VSS gf180mcu_as_sc_mcu7t3v3__fill_1
XFILLER_149_1558 VDD VDD VSS VSS gf180mcu_as_sc_mcu7t3v3__fillcap_8
XFILLER_23_307 VDD VDD VSS VSS gf180mcu_as_sc_mcu7t3v3__fill_1
XFILLER_50_104 VDD VDD VSS VSS gf180mcu_as_sc_mcu7t3v3__fill_1
XTAP_TAPCELL_ROW_147_1_1887 VDD VSS gf180mcu_as_sc_mcu7t3v3__tap_2
XFILLER_182_1151 VDD VDD VSS VSS gf180mcu_as_sc_mcu7t3v3__fillcap_4
XTAP_TAPCELL_ROW_159_3_3199 VDD VSS gf180mcu_as_sc_mcu7t3v3__tap_2
X_3952_ VDD VDD VSS VSS _3953_/D _3952_/C _4033_/B _3952_/A gf180mcu_as_sc_mcu7t3v3__aoi21_2
XFILLER_17_1116 VDD VDD VSS VSS gf180mcu_as_sc_mcu7t3v3__fillcap_4
XFILLER_182_1173 VDD VDD VSS VSS gf180mcu_as_sc_mcu7t3v3__fillcap_16
XFILLER_91_2 VDD VDD VSS VSS gf180mcu_as_sc_mcu7t3v3__fillcap_8
X_3883_ VDD VDD VSS VSS _3902_/B _5173_/Q _4923_/D gf180mcu_as_sc_mcu7t3v3__and2_2
X_2903_ VDD VDD VSS VSS _2903_/Y _3199_/B _3542_/A gf180mcu_as_sc_mcu7t3v3__nand2_2
X_2834_ VDD VDD VSS VSS _4751_/B _4974_/D _4761_/D gf180mcu_as_sc_mcu7t3v3__and2_2
XFILLER_30_1305 VDD VDD VSS VSS gf180mcu_as_sc_mcu7t3v3__fillcap_4
XFILLER_34_1485 VDD VDD VSS VSS gf180mcu_as_sc_mcu7t3v3__fillcap_4
XFILLER_185_890 VDD VDD VSS VSS gf180mcu_as_sc_mcu7t3v3__fillcap_16
X_4504_ VDD VDD VSS VSS _5178_/Q _4504_/B _4504_/C _4504_/D _5178_/D gf180mcu_as_sc_mcu7t3v3__ao211_2
X_2765_ VDD VDD VSS VSS _4691_/A _2765_/B _2765_/C _2765_/D _2840_/B gf180mcu_as_sc_mcu7t3v3__ao211_2
X_5484_ VDD VDD VSS VSS _5484_/A _5484_/Y gf180mcu_as_sc_mcu7t3v3__buff_2
X_2696_ VDD VDD VSS VSS _4262_/A _2699_/A _4289_/S gf180mcu_as_sc_mcu7t3v3__and2_2
XPHY_EDGE_ROW_83_3_Left_468 VDD VSS gf180mcu_as_sc_mcu7t3v3__tap_2
X_4435_ VDD VDD VSS VSS _4435_/B _4497_/A _4442_/C gf180mcu_as_sc_mcu7t3v3__and2_2
XTAP_TAPCELL_ROW_42_3_2847 VDD VSS gf180mcu_as_sc_mcu7t3v3__tap_2
XFILLER_116_27 VDD VDD VSS VSS gf180mcu_as_sc_mcu7t3v3__fillcap_8
Xfanout515 VDD VDD VSS VSS _4227_/B _4224_/B gf180mcu_as_sc_mcu7t3v3__buff_12
X_4366_ VDD VDD VSS VSS _4366_/S _5162_/Q _4366_/A _4367_/B gf180mcu_as_sc_mcu7t3v3__mux2_2
XFILLER_8_1317 VDD VDD VSS VSS gf180mcu_as_sc_mcu7t3v3__fill_2
Xfanout526 VDD VDD VSS VSS _3676_/B _3731_/B gf180mcu_as_sc_mcu7t3v3__buff_12
Xfanout548 VDD VDD VSS VSS _4590_/C _4575_/C gf180mcu_as_sc_mcu7t3v3__buff_12
X_3317_ VDD VDD VSS VSS _3966_/A _3382_/B _3382_/C _3969_/A _3318_/C gf180mcu_as_sc_mcu7t3v3__ao22_2
XFILLER_80_1461 VDD VDD VSS VSS gf180mcu_as_sc_mcu7t3v3__fill_2
Xfanout559 VDD VDD VSS VSS _4164_/S _4106_/S gf180mcu_as_sc_mcu7t3v3__buff_12
X_4297_ VDD VDD VSS VSS _4297_/S _5126_/Q _4297_/A _5126_/D gf180mcu_as_sc_mcu7t3v3__mux2_2
XFILLER_41_1434 VDD VDD VSS VSS gf180mcu_as_sc_mcu7t3v3__fillcap_8
XFILLER_6_1063 VDD VDD VSS VSS gf180mcu_as_sc_mcu7t3v3__fillcap_16
Xmesh_tile_963 VDD VDD VSS VSS north_out[4] gf180mcu_as_sc_mcu7t3v3__tiel_4
Xmesh_tile_952 VDD VDD VSS VSS ne_out[27] gf180mcu_as_sc_mcu7t3v3__tiel_4
Xmesh_tile_941 VDD VDD VSS VSS ne_out[16] gf180mcu_as_sc_mcu7t3v3__tiel_4
Xmesh_tile_930 VDD VDD VSS VSS ne_out[5] gf180mcu_as_sc_mcu7t3v3__tiel_4
X_3248_ VDD VDD VSS VSS _3249_/B _3914_/A _3519_/D gf180mcu_as_sc_mcu7t3v3__and2_2
XTAP_TAPCELL_ROW_181_2155 VDD VSS gf180mcu_as_sc_mcu7t3v3__tap_2
XTAP_TAPCELL_ROW_181_2144 VDD VSS gf180mcu_as_sc_mcu7t3v3__tap_2
XFILLER_132_37 VDD VDD VSS VSS gf180mcu_as_sc_mcu7t3v3__fillcap_16
Xmesh_tile_996 VDD VDD VSS VSS nw_out[3] gf180mcu_as_sc_mcu7t3v3__tiel_4
Xmesh_tile_985 VDD VDD VSS VSS north_out[26] gf180mcu_as_sc_mcu7t3v3__tiel_4
Xmesh_tile_974 VDD VDD VSS VSS north_out[15] gf180mcu_as_sc_mcu7t3v3__tiel_4
X_3179_ VDD VDD VSS VSS _3179_/B _4942_/Q _3180_/D gf180mcu_as_sc_mcu7t3v3__or2_2
XTAP_TAPCELL_ROW_2_778 VDD VSS gf180mcu_as_sc_mcu7t3v3__tap_2
XTAP_TAPCELL_ROW_2_767 VDD VSS gf180mcu_as_sc_mcu7t3v3__tap_2
XFILLER_187_1084 VDD VDD VSS VSS gf180mcu_as_sc_mcu7t3v3__fillcap_16
XFILLER_41_104 VDD VDD VSS VSS gf180mcu_as_sc_mcu7t3v3__fillcap_16
XFILLER_202_419 VDD VDD VSS VSS gf180mcu_as_sc_mcu7t3v3__fillcap_8
XFILLER_195_610 VDD VDD VSS VSS gf180mcu_as_sc_mcu7t3v3__fillcap_16
XFILLER_195_632 VDD VDD VSS VSS gf180mcu_as_sc_mcu7t3v3__fillcap_16
XFILLER_23_874 VDD VDD VSS VSS gf180mcu_as_sc_mcu7t3v3__fillcap_4
XFILLER_39_1396 VDD VDD VSS VSS gf180mcu_as_sc_mcu7t3v3__fill_1
XFILLER_10_524 VDD VDD VSS VSS gf180mcu_as_sc_mcu7t3v3__fill_1
XFILLER_10_535 VDD VDD VSS VSS gf180mcu_as_sc_mcu7t3v3__fill_1
XFILLER_22_384 VDD VDD VSS VSS gf180mcu_as_sc_mcu7t3v3__fill_1
Xwire905 VDD VDD VSS VSS wire905/A _3984_/D gf180mcu_as_sc_mcu7t3v3__clkbuff_12
XFILLER_202_1221 VDD VDD VSS VSS gf180mcu_as_sc_mcu7t3v3__fillcap_4
XFILLER_202_1243 VDD VDD VSS VSS gf180mcu_as_sc_mcu7t3v3__fillcap_16
XFILLER_210_485 VDD VDD VSS VSS gf180mcu_as_sc_mcu7t3v3__fillcap_4
XFILLER_41_34 VDD VDD VSS VSS gf180mcu_as_sc_mcu7t3v3__fillcap_8
XFILLER_135_220 VDD VDD VSS VSS gf180mcu_as_sc_mcu7t3v3__fill_2
XFILLER_100_1539 VDD VDD VSS VSS gf180mcu_as_sc_mcu7t3v3__fill_2
XFILLER_194_1011 VDD VDD VSS VSS gf180mcu_as_sc_mcu7t3v3__fillcap_4
XFILLER_194_1033 VDD VDD VSS VSS gf180mcu_as_sc_mcu7t3v3__fillcap_16
XTAP_TAPCELL_ROW_188_2309 VDD VSS gf180mcu_as_sc_mcu7t3v3__tap_2
XFILLER_137_1440 VDD VDD VSS VSS gf180mcu_as_sc_mcu7t3v3__fillcap_16
XFILLER_173_22 VDD VDD VSS VSS gf180mcu_as_sc_mcu7t3v3__fillcap_16
XFILLER_2_734 VDD VDD VSS VSS gf180mcu_as_sc_mcu7t3v3__fill_1
XFILLER_103_183 VDD VDD VSS VSS gf180mcu_as_sc_mcu7t3v3__fill_2
XFILLER_106_71 VDD VDD VSS VSS gf180mcu_as_sc_mcu7t3v3__fillcap_4
XFILLER_133_1348 VDD VDD VSS VSS gf180mcu_as_sc_mcu7t3v3__fillcap_16
XFILLER_173_88 VDD VDD VSS VSS gf180mcu_as_sc_mcu7t3v3__fillcap_16
XFILLER_66_31 VDD VDD VSS VSS gf180mcu_as_sc_mcu7t3v3__fillcap_4
XFILLER_17_101 VDD VDD VSS VSS gf180mcu_as_sc_mcu7t3v3__fillcap_4
XFILLER_20_1507 VDD VDD VSS VSS gf180mcu_as_sc_mcu7t3v3__fillcap_8
XFILLER_66_86 VDD VDD VSS VSS gf180mcu_as_sc_mcu7t3v3__fill_1
XFILLER_122_70 VDD VDD VSS VSS gf180mcu_as_sc_mcu7t3v3__fillcap_16
XFILLER_206_769 VDD VDD VSS VSS gf180mcu_as_sc_mcu7t3v3__fillcap_16
XFILLER_33_627 VDD VDD VSS VSS gf180mcu_as_sc_mcu7t3v3__fill_2
XFILLER_109_1520 VDD VDD VSS VSS gf180mcu_as_sc_mcu7t3v3__fillcap_4
XFILLER_199_960 VDD VDD VSS VSS gf180mcu_as_sc_mcu7t3v3__fillcap_16
XFILLER_57_1463 VDD VDD VSS VSS gf180mcu_as_sc_mcu7t3v3__fillcap_4
XFILLER_96_1490 VDD VDD VSS VSS gf180mcu_as_sc_mcu7t3v3__fillcap_16
XFILLER_199_982 VDD VDD VSS VSS gf180mcu_as_sc_mcu7t3v3__fillcap_16
XFILLER_207_1154 VDD VDD VSS VSS gf180mcu_as_sc_mcu7t3v3__fillcap_16
XFILLER_32_148 VDD VDD VSS VSS gf180mcu_as_sc_mcu7t3v3__fillcap_16
XFILLER_185_120 VDD VDD VSS VSS gf180mcu_as_sc_mcu7t3v3__fillcap_8
XFILLER_198_85 VDD VDD VSS VSS gf180mcu_as_sc_mcu7t3v3__fillcap_16
XFILLER_185_142 VDD VDD VSS VSS gf180mcu_as_sc_mcu7t3v3__fill_2
XFILLER_12_1013 VDD VDD VSS VSS gf180mcu_as_sc_mcu7t3v3__fill_2
XFILLER_12_1046 VDD VDD VSS VSS gf180mcu_as_sc_mcu7t3v3__fillcap_16
X_2550_ VDD VDD VSS VSS _4754_/Q _4956_/Q _2556_/B _4705_/A _2557_/A gf180mcu_as_sc_mcu7t3v3__nand4_2
XFILLER_141_212 VDD VDD VSS VSS gf180mcu_as_sc_mcu7t3v3__fillcap_8
XFILLER_182_893 VDD VDD VSS VSS gf180mcu_as_sc_mcu7t3v3__fillcap_16
X_2481_ VDD VDD VSS VSS _4708_/C _2482_/B _4291_/A gf180mcu_as_sc_mcu7t3v3__nor2_2
X_4220_ VDD VDD VSS VSS _4249_/B _4222_/B _4222_/C _5056_/Q _5056_/D gf180mcu_as_sc_mcu7t3v3__ao22_2
XTAP_TAPCELL_ROW_17_1110 VDD VSS gf180mcu_as_sc_mcu7t3v3__tap_2
XFILLER_116_1568 VDD VDD VSS VSS gf180mcu_as_sc_mcu7t3v3__fill_1
XFILLER_151_1415 VDD VDD VSS VSS gf180mcu_as_sc_mcu7t3v3__fill_1
XFILLER_151_1448 VDD VDD VSS VSS gf180mcu_as_sc_mcu7t3v3__fillcap_16
XFILLER_99_1508 VDD VDD VSS VSS gf180mcu_as_sc_mcu7t3v3__fill_2
XTAP_TAPCELL_ROW_13_1007 VDD VSS gf180mcu_as_sc_mcu7t3v3__tap_2
XTAP_TAPCELL_ROW_13_1018 VDD VSS gf180mcu_as_sc_mcu7t3v3__tap_2
X_4151_ VDD VDD VSS VSS _4151_/A _4161_/B _4159_/C _4151_/D _4153_/C gf180mcu_as_sc_mcu7t3v3__ao22_2
XFILLER_7_1372 VDD VDD VSS VSS gf180mcu_as_sc_mcu7t3v3__fill_2
XPHY_EDGE_ROW_164_1_Right_685 VDD VSS gf180mcu_as_sc_mcu7t3v3__tap_2
X_4082_ VDD VDD VSS VSS _4083_/C _4082_/B _4082_/A gf180mcu_as_sc_mcu7t3v3__nor2_2
X_3102_ VDD VDD VSS VSS _4079_/A _3233_/B _3169_/C _4080_/D _3103_/C gf180mcu_as_sc_mcu7t3v3__ao22_2
XFILLER_23_1164 VDD VDD VSS VSS gf180mcu_as_sc_mcu7t3v3__fillcap_8
XFILLER_36_410 VDD VDD VSS VSS gf180mcu_as_sc_mcu7t3v3__fillcap_4
X_3033_ VDD VDD VSS VSS _3040_/B _3130_/B _4017_/A gf180mcu_as_sc_mcu7t3v3__nand2_2
XTAP_TAPCELL_ROW_30_1398 VDD VSS gf180mcu_as_sc_mcu7t3v3__tap_2
XTAP_TAPCELL_ROW_30_1387 VDD VSS gf180mcu_as_sc_mcu7t3v3__tap_2
XTAP_TAPCELL_ROW_95_3_3005 VDD VSS gf180mcu_as_sc_mcu7t3v3__tap_2
X_4984_ VDD VDD VSS VSS clkload5/A _4984_/D _4984_/Q gf180mcu_as_sc_mcu7t3v3__dfxtp_2
XFILLER_189_470 VDD VDD VSS VSS gf180mcu_as_sc_mcu7t3v3__fill_1
XFILLER_36_1514 VDD VDD VSS VSS gf180mcu_as_sc_mcu7t3v3__fillcap_4
X_3935_ VDD VDD VSS VSS _3936_/C _3935_/B _3935_/A gf180mcu_as_sc_mcu7t3v3__nor2_2
XFILLER_123_1528 VDD VDD VSS VSS gf180mcu_as_sc_mcu7t3v3__fill_2
XFILLER_177_632 VDD VDD VSS VSS gf180mcu_as_sc_mcu7t3v3__fill_2
XFILLER_189_492 VDD VDD VSS VSS gf180mcu_as_sc_mcu7t3v3__fillcap_4
XPHY_EDGE_ROW_140_3_Right_177 VDD VSS gf180mcu_as_sc_mcu7t3v3__tap_2
XFILLER_109_209 VDD VDD VSS VSS gf180mcu_as_sc_mcu7t3v3__fill_1
XFILLER_192_613 VDD VDD VSS VSS gf180mcu_as_sc_mcu7t3v3__fillcap_16
XFILLER_20_844 VDD VDD VSS VSS gf180mcu_as_sc_mcu7t3v3__fillcap_8
X_3866_ VDD VDD VSS VSS _5137_/Q _5138_/Q _3866_/C _3868_/B gf180mcu_as_sc_mcu7t3v3__nor3_2
XFILLER_178_1017 VDD VDD VSS VSS gf180mcu_as_sc_mcu7t3v3__fillcap_16
XFILLER_30_1135 VDD VDD VSS VSS gf180mcu_as_sc_mcu7t3v3__fillcap_4
X_3797_ VDD VDD VSS VSS _3797_/D _3797_/A _3812_/B _3797_/C _3798_/B gf180mcu_as_sc_mcu7t3v3__ao31_2
X_2817_ VDD VDD VSS VSS _5481_/A _2833_/A _2827_/B gf180mcu_as_sc_mcu7t3v3__and2_2
XTAP_TAPCELL_ROW_63_1_1635 VDD VSS gf180mcu_as_sc_mcu7t3v3__tap_2
XFILLER_117_220 VDD VDD VSS VSS gf180mcu_as_sc_mcu7t3v3__fill_2
XFILLER_180_819 VDD VDD VSS VSS gf180mcu_as_sc_mcu7t3v3__fill_1
XFILLER_30_1157 VDD VDD VSS VSS gf180mcu_as_sc_mcu7t3v3__fill_2
X_2748_ VDD VDD VSS VSS _4953_/Q _4754_/Q _2810_/D gf180mcu_as_sc_mcu7t3v3__and2_2
XFILLER_195_1364 VDD VDD VSS VSS gf180mcu_as_sc_mcu7t3v3__fillcap_16
XFILLER_156_1348 VDD VDD VSS VSS gf180mcu_as_sc_mcu7t3v3__fillcap_16
XFILLER_82_1523 VDD VDD VSS VSS gf180mcu_as_sc_mcu7t3v3__fillcap_16
XPHY_EDGE_ROW_178_Right_41 VDD VSS gf180mcu_as_sc_mcu7t3v3__tap_2
X_4418_ VDD VDD VSS VSS _4421_/C _4418_/C _5040_/Q _4542_/A gf180mcu_as_sc_mcu7t3v3__aoi21b_2
X_2679_ VDD VDD VSS VSS _4262_/A _5173_/Q _5165_/Q _2684_/B gf180mcu_as_sc_mcu7t3v3__mux2_2
XFILLER_8_1103 VDD VDD VSS VSS gf180mcu_as_sc_mcu7t3v3__fillcap_16
XTAP_TAPCELL_ROW_183_2206 VDD VSS gf180mcu_as_sc_mcu7t3v3__tap_2
XFILLER_98_181 VDD VDD VSS VSS gf180mcu_as_sc_mcu7t3v3__fill_2
X_4349_ VDD VDD VSS VSS _4366_/S _5159_/Q _4349_/A _4351_/B gf180mcu_as_sc_mcu7t3v3__mux2_2
XFILLER_143_69 VDD VDD VSS VSS gf180mcu_as_sc_mcu7t3v3__fill_1
XFILLER_28_944 VDD VDD VSS VSS gf180mcu_as_sc_mcu7t3v3__fill_1
XPHY_EDGE_ROW_38_1_Right_559 VDD VSS gf180mcu_as_sc_mcu7t3v3__tap_2
XFILLER_27_454 VDD VDD VSS VSS gf180mcu_as_sc_mcu7t3v3__fillcap_8
XFILLER_15_627 VDD VDD VSS VSS gf180mcu_as_sc_mcu7t3v3__fill_2
XFILLER_199_212 VDD VDD VSS VSS gf180mcu_as_sc_mcu7t3v3__fillcap_16
XFILLER_27_487 VDD VDD VSS VSS gf180mcu_as_sc_mcu7t3v3__fill_2
XFILLER_167_1488 VDD VDD VSS VSS gf180mcu_as_sc_mcu7t3v3__fillcap_16
XPHY_EDGE_ROW_187_Right_50 VDD VSS gf180mcu_as_sc_mcu7t3v3__tap_2
XFILLER_187_418 VDD VDD VSS VSS gf180mcu_as_sc_mcu7t3v3__fill_2
XFILLER_196_941 VDD VDD VSS VSS gf180mcu_as_sc_mcu7t3v3__fillcap_4
XFILLER_196_963 VDD VDD VSS VSS gf180mcu_as_sc_mcu7t3v3__fillcap_16
XFILLER_208_1485 VDD VDD VSS VSS gf180mcu_as_sc_mcu7t3v3__fillcap_16
XFILLER_23_682 VDD VDD VSS VSS gf180mcu_as_sc_mcu7t3v3__fillcap_16
XFILLER_35_1046 VDD VDD VSS VSS gf180mcu_as_sc_mcu7t3v3__fillcap_4
XFILLER_10_321 VDD VDD VSS VSS gf180mcu_as_sc_mcu7t3v3__fill_1
XFILLER_11_844 VDD VDD VSS VSS gf180mcu_as_sc_mcu7t3v3__fill_1
XFILLER_167_142 VDD VDD VSS VSS gf180mcu_as_sc_mcu7t3v3__fillcap_4
XFILLER_35_1068 VDD VDD VSS VSS gf180mcu_as_sc_mcu7t3v3__fillcap_8
XFILLER_104_1450 VDD VDD VSS VSS gf180mcu_as_sc_mcu7t3v3__fill_1
XFILLER_104_1461 VDD VDD VSS VSS gf180mcu_as_sc_mcu7t3v3__fillcap_4
XFILLER_11_888 VDD VDD VSS VSS gf180mcu_as_sc_mcu7t3v3__fillcap_8
XFILLER_13_1344 VDD VDD VSS VSS gf180mcu_as_sc_mcu7t3v3__fillcap_16
XFILLER_182_101 VDD VDD VSS VSS gf180mcu_as_sc_mcu7t3v3__fillcap_4
XFILLER_182_123 VDD VDD VSS VSS gf180mcu_as_sc_mcu7t3v3__fillcap_16
XFILLER_183_646 VDD VDD VSS VSS gf180mcu_as_sc_mcu7t3v3__fillcap_4
XFILLER_6_314 VDD VDD VSS VSS gf180mcu_as_sc_mcu7t3v3__fill_1
XTAP_TAPCELL_ROW_110_1_1774 VDD VSS gf180mcu_as_sc_mcu7t3v3__tap_2
XFILLER_10_387 VDD VDD VSS VSS gf180mcu_as_sc_mcu7t3v3__fillcap_16
XFILLER_13_1377 VDD VDD VSS VSS gf180mcu_as_sc_mcu7t3v3__fill_2
XTAP_TAPCELL_ROW_122_3_3086 VDD VSS gf180mcu_as_sc_mcu7t3v3__tap_2
XFILLER_123_212 VDD VDD VSS VSS gf180mcu_as_sc_mcu7t3v3__fillcap_8
XFILLER_174_1415 VDD VDD VSS VSS gf180mcu_as_sc_mcu7t3v3__fill_2
XFILLER_139_1568 VDD VDD VSS VSS gf180mcu_as_sc_mcu7t3v3__fill_1
XFILLER_96_107 VDD VDD VSS VSS gf180mcu_as_sc_mcu7t3v3__fillcap_16
XFILLER_89_192 VDD VDD VSS VSS gf180mcu_as_sc_mcu7t3v3__fillcap_16
XTAP_TAPCELL_ROW_88_1_1708 VDD VSS gf180mcu_as_sc_mcu7t3v3__tap_2
XTAP_TAPCELL_ROW_6_870 VDD VSS gf180mcu_as_sc_mcu7t3v3__tap_2
XFILLER_111_1410 VDD VDD VSS VSS gf180mcu_as_sc_mcu7t3v3__fillcap_4
Xfanout890 VDD VDD VSS VSS _4199_/A _3661_/D gf180mcu_as_sc_mcu7t3v3__buff_12
XFILLER_111_1432 VDD VDD VSS VSS gf180mcu_as_sc_mcu7t3v3__fillcap_8
XFILLER_18_421 VDD VDD VSS VSS gf180mcu_as_sc_mcu7t3v3__fillcap_4
XFILLER_19_944 VDD VDD VSS VSS gf180mcu_as_sc_mcu7t3v3__fillcap_8
XFILLER_4_1567 VDD VDD VSS VSS gf180mcu_as_sc_mcu7t3v3__fill_2
XFILLER_18_454 VDD VDD VSS VSS gf180mcu_as_sc_mcu7t3v3__fill_1
XPHY_EDGE_ROW_149_1_Left_359 VDD VSS gf180mcu_as_sc_mcu7t3v3__tap_2
XFILLER_34_947 VDD VDD VSS VSS gf180mcu_as_sc_mcu7t3v3__fillcap_16
XFILLER_59_1558 VDD VDD VSS VSS gf180mcu_as_sc_mcu7t3v3__fillcap_8
XFILLER_60_221 VDD VDD VSS VSS gf180mcu_as_sc_mcu7t3v3__fill_1
XFILLER_93_95 VDD VDD VSS VSS gf180mcu_as_sc_mcu7t3v3__fill_2
XFILLER_18_1222 VDD VDD VSS VSS gf180mcu_as_sc_mcu7t3v3__fill_2
XFILLER_18_1255 VDD VDD VSS VSS gf180mcu_as_sc_mcu7t3v3__fill_1
XFILLER_20_107 VDD VDD VSS VSS gf180mcu_as_sc_mcu7t3v3__fillcap_16
X_3720_ VDD VDD VSS VSS _3720_/D _4093_/A _3736_/B _3800_/C _3721_/C gf180mcu_as_sc_mcu7t3v3__ao31_2
XFILLER_158_153 VDD VDD VSS VSS gf180mcu_as_sc_mcu7t3v3__fillcap_16
XFILLER_201_260 VDD VDD VSS VSS gf180mcu_as_sc_mcu7t3v3__fillcap_16
XFILLER_173_112 VDD VDD VSS VSS gf180mcu_as_sc_mcu7t3v3__fill_2
XFILLER_179_1326 VDD VDD VSS VSS gf180mcu_as_sc_mcu7t3v3__fillcap_4
XFILLER_201_282 VDD VDD VSS VSS gf180mcu_as_sc_mcu7t3v3__fillcap_16
X_3651_ VDD VDD VSS VSS _3652_/C _4021_/A _3658_/B _3651_/C gf180mcu_as_sc_mcu7t3v3__ao21_2
XFILLER_174_679 VDD VDD VSS VSS gf180mcu_as_sc_mcu7t3v3__fill_1
XFILLER_179_1348 VDD VDD VSS VSS gf180mcu_as_sc_mcu7t3v3__fillcap_4
X_3582_ VDD VDD VSS VSS _3951_/A _3649_/B _3656_/C _3949_/A _3583_/D gf180mcu_as_sc_mcu7t3v3__ao22_2
X_2602_ VDD VDD VSS VSS _4262_/B _2602_/B _2731_/S _2603_/B gf180mcu_as_sc_mcu7t3v3__mux2_2
XFILLER_173_167 VDD VDD VSS VSS gf180mcu_as_sc_mcu7t3v3__fillcap_4
X_2533_ VDD VDD VSS VSS _4372_/B _4329_/A _2534_/C gf180mcu_as_sc_mcu7t3v3__nor2b_2
X_5252_ VDD VDD VSS VSS _5262_/CLK _5252_/D _5252_/Q gf180mcu_as_sc_mcu7t3v3__dfxtp_2
X_2464_ VDD VDD VSS VSS _2467_/C _2464_/C _5064_/Q _4527_/S gf180mcu_as_sc_mcu7t3v3__aoi21b_2
XTAP_TAPCELL_ROW_36_1541 VDD VSS gf180mcu_as_sc_mcu7t3v3__tap_2
XTAP_TAPCELL_ROW_36_1530 VDD VSS gf180mcu_as_sc_mcu7t3v3__tap_2
XPHY_EDGE_ROW_200_Right_63 VDD VSS gf180mcu_as_sc_mcu7t3v3__tap_2
X_5183_ VDD VDD VSS VSS clkload8/A _5183_/D _5183_/Q gf180mcu_as_sc_mcu7t3v3__dfxtp_2
X_4203_ VDD VDD VSS VSS _4232_/B _4224_/B _4224_/C _5039_/Q _5039_/D gf180mcu_as_sc_mcu7t3v3__ao22_2
X_2395_ VDD VDD VSS VSS _4733_/A _5268_/Q gf180mcu_as_sc_mcu7t3v3__inv_2
XTAP_TAPCELL_ROW_36_1552 VDD VSS gf180mcu_as_sc_mcu7t3v3__tap_2
XFILLER_25_1259 VDD VDD VSS VSS gf180mcu_as_sc_mcu7t3v3__fill_1
X_4134_ VDD VDD VSS VSS _5002_/Q _4142_/B _4253_/B _4142_/D _5002_/D gf180mcu_as_sc_mcu7t3v3__ao22_2
XTAP_TAPCELL_ROW_4_829 VDD VSS gf180mcu_as_sc_mcu7t3v3__tap_2
XTAP_TAPCELL_ROW_4_818 VDD VSS gf180mcu_as_sc_mcu7t3v3__tap_2
XTAP_TAPCELL_ROW_32_1438 VDD VSS gf180mcu_as_sc_mcu7t3v3__tap_2
XTAP_TAPCELL_ROW_32_1427 VDD VSS gf180mcu_as_sc_mcu7t3v3__tap_2
XPHY_EDGE_ROW_165_1_Right_686 VDD VSS gf180mcu_as_sc_mcu7t3v3__tap_2
XTAP_TAPCELL_ROW_37_3_2831 VDD VSS gf180mcu_as_sc_mcu7t3v3__tap_2
X_4065_ VDD VDD VSS VSS _4065_/A _4118_/C _4065_/C _4065_/D _4066_/C gf180mcu_as_sc_mcu7t3v3__ao211_2
XFILLER_36_240 VDD VDD VSS VSS gf180mcu_as_sc_mcu7t3v3__fillcap_16
X_3016_ VDD VDD VSS VSS _3998_/A _3229_/B _3125_/C _3997_/A _3022_/B gf180mcu_as_sc_mcu7t3v3__ao22_2
XFILLER_184_1065 VDD VDD VSS VSS gf180mcu_as_sc_mcu7t3v3__fillcap_16
XFILLER_184_1087 VDD VDD VSS VSS gf180mcu_as_sc_mcu7t3v3__fillcap_16
XFILLER_19_1019 VDD VDD VSS VSS gf180mcu_as_sc_mcu7t3v3__fillcap_16
XTAP_TAPCELL_ROW_115_1_1789 VDD VSS gf180mcu_as_sc_mcu7t3v3__tap_2
XFILLER_178_941 VDD VDD VSS VSS gf180mcu_as_sc_mcu7t3v3__fillcap_4
XFILLER_178_963 VDD VDD VSS VSS gf180mcu_as_sc_mcu7t3v3__fillcap_16
XFILLER_36_1344 VDD VDD VSS VSS gf180mcu_as_sc_mcu7t3v3__fillcap_16
X_4967_ VDD VDD VSS VSS _5111_/CLK _4967_/D _4967_/Q gf180mcu_as_sc_mcu7t3v3__dfxtp_2
XTAP_TAPCELL_ROW_176_2054 VDD VSS gf180mcu_as_sc_mcu7t3v3__tap_2
XTAP_TAPCELL_ROW_176_2043 VDD VSS gf180mcu_as_sc_mcu7t3v3__tap_2
XFILLER_149_142 VDD VDD VSS VSS gf180mcu_as_sc_mcu7t3v3__fillcap_4
X_4898_ VDD VDD VSS VSS _4904_/CLK _4898_/D _4898_/Q gf180mcu_as_sc_mcu7t3v3__dfxtp_2
X_3918_ VDD VDD VSS VSS _3920_/A _3923_/B _3918_/A gf180mcu_as_sc_mcu7t3v3__nand2_2
XFILLER_164_123 VDD VDD VSS VSS gf180mcu_as_sc_mcu7t3v3__fillcap_16
XFILLER_193_944 VDD VDD VSS VSS gf180mcu_as_sc_mcu7t3v3__fillcap_16
XPHY_EDGE_ROW_141_3_Right_178 VDD VSS gf180mcu_as_sc_mcu7t3v3__tap_2
X_3849_ VDD VDD VSS VSS _3850_/C _5134_/Q _5131_/Q gf180mcu_as_sc_mcu7t3v3__nor2_2
XTAP_TAPCELL_ROW_82_1_1690 VDD VSS gf180mcu_as_sc_mcu7t3v3__tap_2
XFILLER_4_807 VDD VDD VSS VSS gf180mcu_as_sc_mcu7t3v3__fillcap_4
XFILLER_138_69 VDD VDD VSS VSS gf180mcu_as_sc_mcu7t3v3__fillcap_8
XTAP_TAPCELL_ROW_210_2814 VDD VSS gf180mcu_as_sc_mcu7t3v3__tap_2
XTAP_TAPCELL_ROW_210_2803 VDD VSS gf180mcu_as_sc_mcu7t3v3__tap_2
XFILLER_105_212 VDD VDD VSS VSS gf180mcu_as_sc_mcu7t3v3__fillcap_8
XFILLER_191_1014 VDD VDD VSS VSS gf180mcu_as_sc_mcu7t3v3__fillcap_16
XTAP_TAPCELL_ROW_92_3_2996 VDD VSS gf180mcu_as_sc_mcu7t3v3__tap_2
XTAP_TAPCELL_ROW_210_2825 VDD VSS gf180mcu_as_sc_mcu7t3v3__tap_2
XFILLER_78_107 VDD VDD VSS VSS gf180mcu_as_sc_mcu7t3v3__fillcap_8
Xoutput460 VDD VDD VSS VSS _4882_/Q west_out[9] gf180mcu_as_sc_mcu7t3v3__buff_12
XFILLER_134_1443 VDD VDD VSS VSS gf180mcu_as_sc_mcu7t3v3__fill_1
XFILLER_134_1465 VDD VDD VSS VSS gf180mcu_as_sc_mcu7t3v3__fill_2
XFILLER_43_1348 VDD VDD VSS VSS gf180mcu_as_sc_mcu7t3v3__fillcap_16
XFILLER_47_1495 VDD VDD VSS VSS gf180mcu_as_sc_mcu7t3v3__fillcap_16
XTAP_TAPCELL_ROW_168_1_1950 VDD VSS gf180mcu_as_sc_mcu7t3v3__tap_2
XFILLER_47_55 VDD VDD VSS VSS gf180mcu_as_sc_mcu7t3v3__fill_2
XTAP_TAPCELL_ROW_208_2754 VDD VSS gf180mcu_as_sc_mcu7t3v3__tap_2
XTAP_TAPCELL_ROW_208_2743 VDD VSS gf180mcu_as_sc_mcu7t3v3__tap_2
XFILLER_170_34 VDD VDD VSS VSS gf180mcu_as_sc_mcu7t3v3__fill_1
XFILLER_47_88 VDD VDD VSS VSS gf180mcu_as_sc_mcu7t3v3__fillcap_16
XFILLER_15_402 VDD VDD VSS VSS gf180mcu_as_sc_mcu7t3v3__fillcap_16
XFILLER_210_1375 VDD VDD VSS VSS gf180mcu_as_sc_mcu7t3v3__fillcap_4
XFILLER_27_262 VDD VDD VSS VSS gf180mcu_as_sc_mcu7t3v3__fillcap_4
XFILLER_28_763 VDD VDD VSS VSS gf180mcu_as_sc_mcu7t3v3__fillcap_16
XFILLER_103_72 VDD VDD VSS VSS gf180mcu_as_sc_mcu7t3v3__fillcap_16
XFILLER_16_947 VDD VDD VSS VSS gf180mcu_as_sc_mcu7t3v3__fillcap_8
XFILLER_27_284 VDD VDD VSS VSS gf180mcu_as_sc_mcu7t3v3__fill_1
XFILLER_42_210 VDD VDD VSS VSS gf180mcu_as_sc_mcu7t3v3__fillcap_8
XFILLER_63_10 VDD VDD VSS VSS gf180mcu_as_sc_mcu7t3v3__fill_2
XFILLER_15_468 VDD VDD VSS VSS gf180mcu_as_sc_mcu7t3v3__fillcap_16
XFILLER_179_54 VDD VDD VSS VSS gf180mcu_as_sc_mcu7t3v3__fillcap_16
XPHY_EDGE_ROW_160_3_Left_545 VDD VSS gf180mcu_as_sc_mcu7t3v3__tap_2
XTAP_TAPCELL_ROW_63_3_2910 VDD VSS gf180mcu_as_sc_mcu7t3v3__tap_2
XFILLER_106_1523 VDD VDD VSS VSS gf180mcu_as_sc_mcu7t3v3__fillcap_16
XFILLER_204_1135 VDD VDD VSS VSS gf180mcu_as_sc_mcu7t3v3__fillcap_16
XFILLER_180_1485 VDD VDD VSS VSS gf180mcu_as_sc_mcu7t3v3__fillcap_16
XFILLER_183_410 VDD VDD VSS VSS gf180mcu_as_sc_mcu7t3v3__fillcap_8
XFILLER_204_1157 VDD VDD VSS VSS gf180mcu_as_sc_mcu7t3v3__fillcap_16
Xwire510 VDD VDD VSS VSS _2955_/Y _2956_/B gf180mcu_as_sc_mcu7t3v3__clkbuff_12
XFILLER_13_1152 VDD VDD VSS VSS gf180mcu_as_sc_mcu7t3v3__fill_2
XFILLER_155_167 VDD VDD VSS VSS gf180mcu_as_sc_mcu7t3v3__fillcap_16
XFILLER_6_155 VDD VDD VSS VSS gf180mcu_as_sc_mcu7t3v3__fillcap_4
XFILLER_6_177 VDD VDD VSS VSS gf180mcu_as_sc_mcu7t3v3__fillcap_16
XTAP_TAPCELL_ROW_141_1_1868 VDD VSS gf180mcu_as_sc_mcu7t3v3__tap_2
XFILLER_170_148 VDD VDD VSS VSS gf180mcu_as_sc_mcu7t3v3__fill_1
XFILLER_174_1278 VDD VDD VSS VSS gf180mcu_as_sc_mcu7t3v3__fillcap_8
XFILLER_26_1502 VDD VDD VSS VSS gf180mcu_as_sc_mcu7t3v3__fill_2
XFILLER_26_1513 VDD VDD VSS VSS gf180mcu_as_sc_mcu7t3v3__fill_1
XFILLER_2_372 VDD VDD VSS VSS gf180mcu_as_sc_mcu7t3v3__fillcap_8
XFILLER_3_895 VDD VDD VSS VSS gf180mcu_as_sc_mcu7t3v3__fill_2
XPHY_EDGE_ROW_103_3_Right_140 VDD VSS gf180mcu_as_sc_mcu7t3v3__tap_2
XFILLER_61_1415 VDD VDD VSS VSS gf180mcu_as_sc_mcu7t3v3__fill_1
XFILLER_207_820 VDD VDD VSS VSS gf180mcu_as_sc_mcu7t3v3__fillcap_16
XFILLER_92_132 VDD VDD VSS VSS gf180mcu_as_sc_mcu7t3v3__fillcap_4
XFILLER_19_774 VDD VDD VSS VSS gf180mcu_as_sc_mcu7t3v3__fill_1
XFILLER_207_842 VDD VDD VSS VSS gf180mcu_as_sc_mcu7t3v3__fillcap_16
XFILLER_20_1145 VDD VDD VSS VSS gf180mcu_as_sc_mcu7t3v3__fillcap_8
XFILLER_34_700 VDD VDD VSS VSS gf180mcu_as_sc_mcu7t3v3__fill_2
XFILLER_18_295 VDD VDD VSS VSS gf180mcu_as_sc_mcu7t3v3__fillcap_16
XFILLER_20_1189 VDD VDD VSS VSS gf180mcu_as_sc_mcu7t3v3__fillcap_16
XFILLER_34_733 VDD VDD VSS VSS gf180mcu_as_sc_mcu7t3v3__fill_2
XFILLER_59_1399 VDD VDD VSS VSS gf180mcu_as_sc_mcu7t3v3__fillcap_16
XPHY_EDGE_ROW_92_3_Left_477 VDD VSS gf180mcu_as_sc_mcu7t3v3__tap_2
X_4821_ VDD VDD VSS VSS _4919_/CLK _4821_/D _4821_/Q gf180mcu_as_sc_mcu7t3v3__dfxtp_2
XFILLER_72_1511 VDD VDD VSS VSS gf180mcu_as_sc_mcu7t3v3__fillcap_8
XFILLER_21_438 VDD VDD VSS VSS gf180mcu_as_sc_mcu7t3v3__fillcap_16
X_4752_ VDD VDD VSS VSS _4753_/A _4752_/B _4752_/C _5094_/D gf180mcu_as_sc_mcu7t3v3__nor3_2
XFILLER_174_410 VDD VDD VSS VSS gf180mcu_as_sc_mcu7t3v3__fillcap_8
XFILLER_202_591 VDD VDD VSS VSS gf180mcu_as_sc_mcu7t3v3__fillcap_4
X_4683_ VDD VDD VSS VSS _4686_/B _4683_/C _4683_/B _4703_/D gf180mcu_as_sc_mcu7t3v3__aoi21b_2
X_3703_ VDD VDD VSS VSS _4933_/Q _3740_/B _3741_/C _4080_/D _3704_/D gf180mcu_as_sc_mcu7t3v3__ao22_2
XTAP_TAPCELL_ROW_25_1286 VDD VSS gf180mcu_as_sc_mcu7t3v3__tap_2
XTAP_TAPCELL_ROW_25_1275 VDD VSS gf180mcu_as_sc_mcu7t3v3__tap_2
XFILLER_146_123 VDD VDD VSS VSS gf180mcu_as_sc_mcu7t3v3__fillcap_16
X_3634_ VDD VDD VSS VSS _3638_/B _3634_/C _3726_/B _4008_/A gf180mcu_as_sc_mcu7t3v3__aoi21_2
XFILLER_190_925 VDD VDD VSS VSS gf180mcu_as_sc_mcu7t3v3__fillcap_16
XFILLER_190_947 VDD VDD VSS VSS gf180mcu_as_sc_mcu7t3v3__fillcap_16
XFILLER_31_1285 VDD VDD VSS VSS gf180mcu_as_sc_mcu7t3v3__fillcap_16
X_3565_ VDD VDD VSS VSS _3656_/C _3933_/D _3568_/C gf180mcu_as_sc_mcu7t3v3__and2_2
XFILLER_192_1345 VDD VDD VSS VSS gf180mcu_as_sc_mcu7t3v3__fillcap_16
XFILLER_66_1348 VDD VDD VSS VSS gf180mcu_as_sc_mcu7t3v3__fillcap_4
X_3496_ VDD VDD VSS VSS _4154_/D _3502_/B _3504_/B _4154_/A _3497_/D gf180mcu_as_sc_mcu7t3v3__ao22_2
X_2516_ VDD VDD VSS VSS _4749_/A _2517_/B _2517_/C _2766_/B _2517_/D gf180mcu_as_sc_mcu7t3v3__aoi31_2
XFILLER_192_1367 VDD VDD VSS VSS gf180mcu_as_sc_mcu7t3v3__fillcap_16
X_5235_ VDD VDD VSS VSS _5276_/CLK _5235_/D _5235_/Q gf180mcu_as_sc_mcu7t3v3__dfxtp_2
X_2447_ VDD VDD VSS VSS _4141_/A _3483_/A gf180mcu_as_sc_mcu7t3v3__inv_2
XFILLER_29_1170 VDD VDD VSS VSS gf180mcu_as_sc_mcu7t3v3__fillcap_4
XFILLER_29_1192 VDD VDD VSS VSS gf180mcu_as_sc_mcu7t3v3__fillcap_16
X_5166_ VDD VDD VSS VSS clkload1/A _5166_/D _5166_/Q gf180mcu_as_sc_mcu7t3v3__dfxtp_2
XFILLER_29_549 VDD VDD VSS VSS gf180mcu_as_sc_mcu7t3v3__fillcap_8
XFILLER_83_132 VDD VDD VSS VSS gf180mcu_as_sc_mcu7t3v3__fill_1
XPHY_EDGE_ROW_166_1_Right_687 VDD VSS gf180mcu_as_sc_mcu7t3v3__tap_2
X_5097_ VDD VDD VSS VSS _5277_/CLK _5097_/D _5097_/Q gf180mcu_as_sc_mcu7t3v3__dfxtp_2
X_4117_ VDD VDD VSS VSS _5000_/Q _4158_/B _4251_/B _4117_/D _5000_/D gf180mcu_as_sc_mcu7t3v3__ao22_2
XTAP_TAPCELL_ROW_68_3_2925 VDD VSS gf180mcu_as_sc_mcu7t3v3__tap_2
X_4048_ VDD VDD VSS VSS _4048_/A _4104_/B _4104_/C _4048_/D _4049_/D gf180mcu_as_sc_mcu7t3v3__ao22_2
XFILLER_140_37 VDD VDD VSS VSS gf180mcu_as_sc_mcu7t3v3__fillcap_8
XFILLER_17_69 VDD VDD VSS VSS gf180mcu_as_sc_mcu7t3v3__fill_1
XTAP_TAPCELL_ROW_203_2640 VDD VSS gf180mcu_as_sc_mcu7t3v3__tap_2
XFILLER_197_524 VDD VDD VSS VSS gf180mcu_as_sc_mcu7t3v3__fillcap_16
XFILLER_77_1488 VDD VDD VSS VSS gf180mcu_as_sc_mcu7t3v3__fillcap_4
XTAP_TAPCELL_ROW_195_2452 VDD VSS gf180mcu_as_sc_mcu7t3v3__tap_2
XFILLER_8_409 VDD VDD VSS VSS gf180mcu_as_sc_mcu7t3v3__fill_1
XTAP_TAPCELL_ROW_195_2463 VDD VSS gf180mcu_as_sc_mcu7t3v3__tap_2
XFILLER_205_1466 VDD VDD VSS VSS gf180mcu_as_sc_mcu7t3v3__fillcap_4
XFILLER_137_123 VDD VDD VSS VSS gf180mcu_as_sc_mcu7t3v3__fillcap_16
XFILLER_205_1488 VDD VDD VSS VSS gf180mcu_as_sc_mcu7t3v3__fillcap_16
XPHY_EDGE_ROW_142_3_Right_179 VDD VSS gf180mcu_as_sc_mcu7t3v3__tap_2
XFILLER_10_1314 VDD VDD VSS VSS gf180mcu_as_sc_mcu7t3v3__fillcap_16
XFILLER_197_1256 VDD VDD VSS VSS gf180mcu_as_sc_mcu7t3v3__fillcap_4
XFILLER_197_1278 VDD VDD VSS VSS gf180mcu_as_sc_mcu7t3v3__fillcap_16
XFILLER_101_1453 VDD VDD VSS VSS gf180mcu_as_sc_mcu7t3v3__fill_2
XFILLER_84_1415 VDD VDD VSS VSS gf180mcu_as_sc_mcu7t3v3__fillcap_16
XFILLER_165_56 VDD VDD VSS VSS gf180mcu_as_sc_mcu7t3v3__fill_1
XFILLER_49_1568 VDD VDD VSS VSS gf180mcu_as_sc_mcu7t3v3__fill_1
XTAP_TAPCELL_ROW_8_910 VDD VSS gf180mcu_as_sc_mcu7t3v3__tap_2
XFILLER_0_843 VDD VDD VSS VSS gf180mcu_as_sc_mcu7t3v3__fill_2
XFILLER_181_66 VDD VDD VSS VSS gf180mcu_as_sc_mcu7t3v3__fillcap_4
XFILLER_58_98 VDD VDD VSS VSS gf180mcu_as_sc_mcu7t3v3__fillcap_4
XTAP_TAPCELL_ROW_129_3_3109 VDD VSS gf180mcu_as_sc_mcu7t3v3__tap_2
XFILLER_181_88 VDD VDD VSS VSS gf180mcu_as_sc_mcu7t3v3__fillcap_16
XFILLER_114_82 VDD VDD VSS VSS gf180mcu_as_sc_mcu7t3v3__fillcap_16
XFILLER_35_508 VDD VDD VSS VSS gf180mcu_as_sc_mcu7t3v3__fillcap_16
XFILLER_74_31 VDD VDD VSS VSS gf180mcu_as_sc_mcu7t3v3__fillcap_4
XFILLER_204_801 VDD VDD VSS VSS gf180mcu_as_sc_mcu7t3v3__fillcap_4
XFILLER_28_582 VDD VDD VSS VSS gf180mcu_as_sc_mcu7t3v3__fillcap_4
XFILLER_74_53 VDD VDD VSS VSS gf180mcu_as_sc_mcu7t3v3__fillcap_16
XTAP_TAPCELL_ROW_96_3_3010 VDD VSS gf180mcu_as_sc_mcu7t3v3__tap_2
XFILLER_182_1503 VDD VDD VSS VSS gf180mcu_as_sc_mcu7t3v3__fill_2
XFILLER_204_823 VDD VDD VSS VSS gf180mcu_as_sc_mcu7t3v3__fillcap_16
XFILLER_95_1566 VDD VDD VSS VSS gf180mcu_as_sc_mcu7t3v3__fill_2
XFILLER_15_254 VDD VDD VSS VSS gf180mcu_as_sc_mcu7t3v3__fill_1
X_4875__1092 VDD VDD VSS VSS _4875_/D gf180mcu_as_sc_mcu7t3v3__tiel_4
XFILLER_15_1203 VDD VDD VSS VSS gf180mcu_as_sc_mcu7t3v3__fillcap_8
XFILLER_15_298 VDD VDD VSS VSS gf180mcu_as_sc_mcu7t3v3__fillcap_16
XFILLER_30_224 VDD VDD VSS VSS gf180mcu_as_sc_mcu7t3v3__fillcap_16
XFILLER_31_769 VDD VDD VSS VSS gf180mcu_as_sc_mcu7t3v3__fill_1
XFILLER_128_101 VDD VDD VSS VSS gf180mcu_as_sc_mcu7t3v3__fillcap_4
XFILLER_145_1380 VDD VDD VSS VSS gf180mcu_as_sc_mcu7t3v3__fillcap_16
XFILLER_184_785 VDD VDD VSS VSS gf180mcu_as_sc_mcu7t3v3__fillcap_16
XFILLER_143_115 VDD VDD VSS VSS gf180mcu_as_sc_mcu7t3v3__fillcap_4
XFILLER_99_72 VDD VDD VSS VSS gf180mcu_as_sc_mcu7t3v3__fill_1
XTAP_TAPCELL_ROW_20_1172 VDD VSS gf180mcu_as_sc_mcu7t3v3__tap_2
XTAP_TAPCELL_ROW_20_1161 VDD VSS gf180mcu_as_sc_mcu7t3v3__tap_2
X_3350_ VDD VDD VSS VSS _3998_/A _3467_/C _3445_/C _4001_/A _3351_/C gf180mcu_as_sc_mcu7t3v3__ao22_2
X_5020_ VDD VDD VSS VSS clkload4/A _5020_/D _5020_/Q gf180mcu_as_sc_mcu7t3v3__dfxtp_2
X_3281_ VDD VDD VSS VSS _3286_/B _3281_/B _3922_/A gf180mcu_as_sc_mcu7t3v3__nand2_2
XPHY_EDGE_ROW_104_3_Right_141 VDD VSS gf180mcu_as_sc_mcu7t3v3__tap_2
Xhold1109 VDD VDD VSS VSS _2588_/Y hold1109/Y gf180mcu_as_sc_mcu7t3v3__clkbuff_4
XFILLER_4_1161 VDD VDD VSS VSS gf180mcu_as_sc_mcu7t3v3__fill_1
XFILLER_65_154 VDD VDD VSS VSS gf180mcu_as_sc_mcu7t3v3__fill_2
XFILLER_0_1069 VDD VDD VSS VSS gf180mcu_as_sc_mcu7t3v3__fillcap_4
XFILLER_179_502 VDD VDD VSS VSS gf180mcu_as_sc_mcu7t3v3__fillcap_16
XFILLER_206_171 VDD VDD VSS VSS gf180mcu_as_sc_mcu7t3v3__fillcap_4
XFILLER_80_135 VDD VDD VSS VSS gf180mcu_as_sc_mcu7t3v3__fill_2
XTAP_TAPCELL_ROW_27_1315 VDD VSS gf180mcu_as_sc_mcu7t3v3__tap_2
XFILLER_206_193 VDD VDD VSS VSS gf180mcu_as_sc_mcu7t3v3__fillcap_16
XFILLER_21_202 VDD VDD VSS VSS gf180mcu_as_sc_mcu7t3v3__fillcap_8
XTAP_TAPCELL_ROW_27_1326 VDD VSS gf180mcu_as_sc_mcu7t3v3__tap_2
XFILLER_181_1046 VDD VDD VSS VSS gf180mcu_as_sc_mcu7t3v3__fillcap_4
XFILLER_181_1068 VDD VDD VSS VSS gf180mcu_as_sc_mcu7t3v3__fillcap_16
XFILLER_194_505 VDD VDD VSS VSS gf180mcu_as_sc_mcu7t3v3__fillcap_16
XFILLER_22_769 VDD VDD VSS VSS gf180mcu_as_sc_mcu7t3v3__fillcap_16
XFILLER_72_1352 VDD VDD VSS VSS gf180mcu_as_sc_mcu7t3v3__fill_2
X_4804_ VDD VDD VSS VSS _4869_/CLK _4804_/D _4804_/Q gf180mcu_as_sc_mcu7t3v3__dfxtp_2
XFILLER_124_1453 VDD VDD VSS VSS gf180mcu_as_sc_mcu7t3v3__fillcap_16
XFILLER_194_527 VDD VDD VSS VSS gf180mcu_as_sc_mcu7t3v3__fillcap_16
XFILLER_21_279 VDD VDD VSS VSS gf180mcu_as_sc_mcu7t3v3__fill_1
X_4735_ VDD VDD VSS VSS _5269_/D _4735_/B _4736_/B gf180mcu_as_sc_mcu7t3v3__nor2_2
X_2996_ VDD VDD VSS VSS _3977_/A _3079_/B _2996_/C _2996_/D _2997_/C gf180mcu_as_sc_mcu7t3v3__ao22_2
XFILLER_119_27 VDD VDD VSS VSS gf180mcu_as_sc_mcu7t3v3__fillcap_16
XFILLER_174_240 VDD VDD VSS VSS gf180mcu_as_sc_mcu7t3v3__fillcap_16
XFILLER_198_1543 VDD VDD VSS VSS gf180mcu_as_sc_mcu7t3v3__fill_1
XFILLER_134_104 VDD VDD VSS VSS gf180mcu_as_sc_mcu7t3v3__fill_1
XTAP_TAPCELL_ROW_123_3_3091 VDD VSS gf180mcu_as_sc_mcu7t3v3__tap_2
X_4666_ VDD VDD VSS VSS _4666_/B _4721_/A _4681_/C gf180mcu_as_sc_mcu7t3v3__and2_2
XTAP_TAPCELL_ROW_190_2360 VDD VSS gf180mcu_as_sc_mcu7t3v3__tap_2
XFILLER_119_189 VDD VDD VSS VSS gf180mcu_as_sc_mcu7t3v3__fill_1
XFILLER_159_1549 VDD VDD VSS VSS gf180mcu_as_sc_mcu7t3v3__fillcap_4
XFILLER_174_295 VDD VDD VSS VSS gf180mcu_as_sc_mcu7t3v3__fillcap_8
Xclkbuf_leaf_3_clk_regs VDD VDD VSS VSS clkbuf_leaf_9_clk_regs/A _4946_/CLK gf180mcu_as_sc_mcu7t3v3__clkbuff_12
X_4597_ VDD VDD VSS VSS _5191_/Q _4750_/D _4604_/C _5192_/Q _5191_/D gf180mcu_as_sc_mcu7t3v3__ao22_2
X_3617_ VDD VDD VSS VSS _3658_/B _3992_/D _3621_/C gf180mcu_as_sc_mcu7t3v3__and2_2
X_3548_ VDD VDD VSS VSS _3780_/A _3548_/A _3811_/B gf180mcu_as_sc_mcu7t3v3__and2_2
XFILLER_1_618 VDD VDD VSS VSS gf180mcu_as_sc_mcu7t3v3__fill_1
X_3479_ VDD VDD VSS VSS _4940_/Q _3493_/B _3479_/C _4138_/A _3480_/D gf180mcu_as_sc_mcu7t3v3__ao22_2
XTAP_TAPCELL_ROW_89_1_1713 VDD VSS gf180mcu_as_sc_mcu7t3v3__tap_2
X_5218_ VDD VDD VSS VSS _5220_/CLK _5218_/D _5218_/Q gf180mcu_as_sc_mcu7t3v3__dfxtp_2
XFILLER_131_1446 VDD VDD VSS VSS gf180mcu_as_sc_mcu7t3v3__fillcap_4
XFILLER_28_57 VDD VDD VSS VSS gf180mcu_as_sc_mcu7t3v3__fill_2
XFILLER_29_335 VDD VDD VSS VSS gf180mcu_as_sc_mcu7t3v3__fillcap_8
X_5149_ VDD VDD VSS VSS _5216_/CLK _5149_/D _5149_/Q gf180mcu_as_sc_mcu7t3v3__dfxtp_2
XFILLER_131_1479 VDD VDD VSS VSS gf180mcu_as_sc_mcu7t3v3__fillcap_4
XFILLER_151_58 VDD VDD VSS VSS gf180mcu_as_sc_mcu7t3v3__fillcap_8
XFILLER_17_508 VDD VDD VSS VSS gf180mcu_as_sc_mcu7t3v3__fillcap_8
XFILLER_29_368 VDD VDD VSS VSS gf180mcu_as_sc_mcu7t3v3__fillcap_16
XFILLER_166_1509 VDD VDD VSS VSS gf180mcu_as_sc_mcu7t3v3__fillcap_8
XPHY_EDGE_ROW_167_1_Right_688 VDD VSS gf180mcu_as_sc_mcu7t3v3__tap_2
XTAP_TAPCELL_ROW_197_2514 VDD VSS gf180mcu_as_sc_mcu7t3v3__tap_2
XTAP_TAPCELL_ROW_197_2503 VDD VSS gf180mcu_as_sc_mcu7t3v3__tap_2
XFILLER_44_34 VDD VDD VSS VSS gf180mcu_as_sc_mcu7t3v3__fill_1
XFILLER_198_855 VDD VDD VSS VSS gf180mcu_as_sc_mcu7t3v3__fillcap_16
XFILLER_12_224 VDD VDD VSS VSS gf180mcu_as_sc_mcu7t3v3__fillcap_16
XFILLER_13_758 VDD VDD VSS VSS gf180mcu_as_sc_mcu7t3v3__fillcap_8
XFILLER_157_207 VDD VDD VSS VSS gf180mcu_as_sc_mcu7t3v3__fill_2
XFILLER_198_877 VDD VDD VSS VSS gf180mcu_as_sc_mcu7t3v3__fillcap_16
XFILLER_201_837 VDD VDD VSS VSS gf180mcu_as_sc_mcu7t3v3__fill_2
XFILLER_25_596 VDD VDD VSS VSS gf180mcu_as_sc_mcu7t3v3__fill_1
XFILLER_9_718 VDD VDD VSS VSS gf180mcu_as_sc_mcu7t3v3__fillcap_16
Xsram2048.u_bank1_923 VDD VDD VSS VSS sram2048.u_bank1/WEN[5] gf180mcu_as_sc_mcu7t3v3__tiel_4
XFILLER_12_279 VDD VDD VSS VSS gf180mcu_as_sc_mcu7t3v3__fillcap_16
XFILLER_51_1414 VDD VDD VSS VSS gf180mcu_as_sc_mcu7t3v3__fill_2
XFILLER_103_1504 VDD VDD VSS VSS gf180mcu_as_sc_mcu7t3v3__fillcap_16
XFILLER_176_22 VDD VDD VSS VSS gf180mcu_as_sc_mcu7t3v3__fillcap_8
XFILLER_201_1116 VDD VDD VSS VSS gf180mcu_as_sc_mcu7t3v3__fillcap_4
XFILLER_51_1436 VDD VDD VSS VSS gf180mcu_as_sc_mcu7t3v3__fillcap_16
XFILLER_121_2 VDD VDD VSS VSS gf180mcu_as_sc_mcu7t3v3__fillcap_16
XFILLER_201_1138 VDD VDD VSS VSS gf180mcu_as_sc_mcu7t3v3__fillcap_16
XFILLER_10_1111 VDD VDD VSS VSS gf180mcu_as_sc_mcu7t3v3__fillcap_4
XFILLER_181_788 VDD VDD VSS VSS gf180mcu_as_sc_mcu7t3v3__fillcap_16
XFILLER_5_979 VDD VDD VSS VSS gf180mcu_as_sc_mcu7t3v3__fill_1
XFILLER_10_1199 VDD VDD VSS VSS gf180mcu_as_sc_mcu7t3v3__fillcap_4
XFILLER_140_107 VDD VDD VSS VSS gf180mcu_as_sc_mcu7t3v3__fillcap_16
XPHY_EDGE_ROW_158_1_Left_368 VDD VSS gf180mcu_as_sc_mcu7t3v3__tap_2
XFILLER_23_1505 VDD VDD VSS VSS gf180mcu_as_sc_mcu7t3v3__fillcap_16
XPHY_EDGE_ROW_95_1_Left_305 VDD VSS gf180mcu_as_sc_mcu7t3v3__tap_2
XTAP_TAPCELL_ROW_136_1_1852 VDD VSS gf180mcu_as_sc_mcu7t3v3__tap_2
XTAP_TAPCELL_ROW_148_3_3164 VDD VSS gf180mcu_as_sc_mcu7t3v3__tap_2
XFILLER_0_684 VDD VDD VSS VSS gf180mcu_as_sc_mcu7t3v3__fill_1
XFILLER_208_403 VDD VDD VSS VSS gf180mcu_as_sc_mcu7t3v3__fillcap_8
XFILLER_208_436 VDD VDD VSS VSS gf180mcu_as_sc_mcu7t3v3__fillcap_16
XFILLER_1_1312 VDD VDD VSS VSS gf180mcu_as_sc_mcu7t3v3__fill_2
XFILLER_21_1262 VDD VDD VSS VSS gf180mcu_as_sc_mcu7t3v3__fillcap_8
XFILLER_62_102 VDD VDD VSS VSS gf180mcu_as_sc_mcu7t3v3__fill_2
XFILLER_35_349 VDD VDD VSS VSS gf180mcu_as_sc_mcu7t3v3__fill_1
XFILLER_95_1352 VDD VDD VSS VSS gf180mcu_as_sc_mcu7t3v3__fill_2
XTAP_TAPCELL_ROW_116_1_1794 VDD VSS gf180mcu_as_sc_mcu7t3v3__tap_2
XFILLER_186_1491 VDD VDD VSS VSS gf180mcu_as_sc_mcu7t3v3__fillcap_8
XFILLER_188_343 VDD VDD VSS VSS gf180mcu_as_sc_mcu7t3v3__fill_2
XFILLER_31_544 VDD VDD VSS VSS gf180mcu_as_sc_mcu7t3v3__fillcap_4
X_2850_ VDD VDD VSS VSS _3869_/B _2851_/B gf180mcu_as_sc_mcu7t3v3__inv_2
XFILLER_148_207 VDD VDD VSS VSS gf180mcu_as_sc_mcu7t3v3__fillcap_8
XFILLER_188_376 VDD VDD VSS VSS gf180mcu_as_sc_mcu7t3v3__fill_2
XFILLER_188_387 VDD VDD VSS VSS gf180mcu_as_sc_mcu7t3v3__fillcap_4
XFILLER_203_174 VDD VDD VSS VSS gf180mcu_as_sc_mcu7t3v3__fillcap_16
XFILLER_206_1049 VDD VDD VSS VSS gf180mcu_as_sc_mcu7t3v3__fillcap_16
XFILLER_191_508 VDD VDD VSS VSS gf180mcu_as_sc_mcu7t3v3__fillcap_16
X_2781_ VDD VDD VSS VSS _2781_/D _2783_/A _2781_/B _4734_/B _2786_/D gf180mcu_as_sc_mcu7t3v3__ao31_2
XTAP_TAPCELL_ROW_22_1223 VDD VSS gf180mcu_as_sc_mcu7t3v3__tap_2
XTAP_TAPCELL_ROW_22_1212 VDD VSS gf180mcu_as_sc_mcu7t3v3__tap_2
XFILLER_8_773 VDD VDD VSS VSS gf180mcu_as_sc_mcu7t3v3__fillcap_16
XPHY_EDGE_ROW_123_3_Left_508 VDD VSS gf180mcu_as_sc_mcu7t3v3__tap_2
XPHY_EDGE_ROW_129_1_Right_650 VDD VSS gf180mcu_as_sc_mcu7t3v3__tap_2
X_4520_ VDD VDD VSS VSS _4520_/D _4572_/A _4520_/B _4520_/C _4521_/B gf180mcu_as_sc_mcu7t3v3__ao31_2
XFILLER_184_582 VDD VDD VSS VSS gf180mcu_as_sc_mcu7t3v3__fillcap_4
X_4451_ VDD VDD VSS VSS _5172_/Q _4574_/B _4451_/C _4451_/D _5172_/D gf180mcu_as_sc_mcu7t3v3__ao211_2
X_3402_ VDD VDD VSS VSS _4930_/Q _3402_/B _3402_/C _4054_/A _3403_/A gf180mcu_as_sc_mcu7t3v3__ao22_2
X_4382_ VDD VDD VSS VSS _4385_/C _4978_/Q _4456_/S gf180mcu_as_sc_mcu7t3v3__nand2b_2
XFILLER_119_1566 VDD VDD VSS VSS gf180mcu_as_sc_mcu7t3v3__fill_2
XFILLER_154_1446 VDD VDD VSS VSS gf180mcu_as_sc_mcu7t3v3__fillcap_4
XPHY_EDGE_ROW_13_Left_224 VDD VSS gf180mcu_as_sc_mcu7t3v3__tap_2
Xfanout708 VDD VDD VSS VSS _3501_/C _3450_/B gf180mcu_as_sc_mcu7t3v3__buff_12
Xfanout719 VDD VDD VSS VSS _3727_/B _3648_/B gf180mcu_as_sc_mcu7t3v3__buff_12
X_3333_ VDD VDD VSS VSS _3984_/A _3453_/B _3453_/C _3985_/A _3334_/C gf180mcu_as_sc_mcu7t3v3__ao22_2
XPHY_EDGE_ROW_7_Right_7 VDD VSS gf180mcu_as_sc_mcu7t3v3__tap_2
X_3264_ VDD VDD VSS VSS _3807_/A _3530_/A _3265_/B gf180mcu_as_sc_mcu7t3v3__and2_2
XFILLER_189_1509 VDD VDD VSS VSS gf180mcu_as_sc_mcu7t3v3__fillcap_4
XFILLER_6_1245 VDD VDD VSS VSS gf180mcu_as_sc_mcu7t3v3__fill_1
XPHY_EDGE_ROW_105_3_Right_142 VDD VSS gf180mcu_as_sc_mcu7t3v3__tap_2
X_5003_ VDD VDD VSS VSS _5095_/CLK _5003_/D _5003_/Q gf180mcu_as_sc_mcu7t3v3__dfxtp_2
X_3195_ VDD VDD VSS VSS _3195_/B _3907_/A _4799_/D gf180mcu_as_sc_mcu7t3v3__and2_2
XFILLER_26_338 VDD VDD VSS VSS gf180mcu_as_sc_mcu7t3v3__fill_1
XFILLER_27_839 VDD VDD VSS VSS gf180mcu_as_sc_mcu7t3v3__fill_1
XFILLER_198_107 VDD VDD VSS VSS gf180mcu_as_sc_mcu7t3v3__fillcap_16
XFILLER_201_50 VDD VDD VSS VSS gf180mcu_as_sc_mcu7t3v3__fillcap_16
XFILLER_74_1425 VDD VDD VSS VSS gf180mcu_as_sc_mcu7t3v3__fill_1
XTAP_TAPCELL_ROW_162_1_1931 VDD VSS gf180mcu_as_sc_mcu7t3v3__tap_2
XFILLER_161_1406 VDD VDD VSS VSS gf180mcu_as_sc_mcu7t3v3__fillcap_8
XFILLER_201_72 VDD VDD VSS VSS gf180mcu_as_sc_mcu7t3v3__fillcap_16
XFILLER_22_522 VDD VDD VSS VSS gf180mcu_as_sc_mcu7t3v3__fill_2
XPHY_EDGE_ROW_22_Left_233 VDD VSS gf180mcu_as_sc_mcu7t3v3__tap_2
XTAP_TAPCELL_ROW_192_2400 VDD VSS gf180mcu_as_sc_mcu7t3v3__tap_2
XFILLER_14_37 VDD VDD VSS VSS gf180mcu_as_sc_mcu7t3v3__fillcap_16
XFILLER_194_313 VDD VDD VSS VSS gf180mcu_as_sc_mcu7t3v3__fill_2
XFILLER_195_836 VDD VDD VSS VSS gf180mcu_as_sc_mcu7t3v3__fillcap_4
XFILLER_210_645 VDD VDD VSS VSS gf180mcu_as_sc_mcu7t3v3__fill_1
XFILLER_22_555 VDD VDD VSS VSS gf180mcu_as_sc_mcu7t3v3__fill_1
XFILLER_10_739 VDD VDD VSS VSS gf180mcu_as_sc_mcu7t3v3__fill_1
XFILLER_194_357 VDD VDD VSS VSS gf180mcu_as_sc_mcu7t3v3__fillcap_4
XFILLER_195_858 VDD VDD VSS VSS gf180mcu_as_sc_mcu7t3v3__fillcap_16
XFILLER_22_588 VDD VDD VSS VSS gf180mcu_as_sc_mcu7t3v3__fillcap_4
X_2979_ VDD VDD VSS VSS _3961_/A _3079_/B _2979_/C _2979_/D _2980_/C gf180mcu_as_sc_mcu7t3v3__ao22_2
XFILLER_194_379 VDD VDD VSS VSS gf180mcu_as_sc_mcu7t3v3__fillcap_4
XFILLER_202_1469 VDD VDD VSS VSS gf180mcu_as_sc_mcu7t3v3__fillcap_16
XFILLER_5_209 VDD VDD VSS VSS gf180mcu_as_sc_mcu7t3v3__fill_1
X_4718_ VDD VDD VSS VSS _4721_/A _4718_/B _5478_/A _5261_/D gf180mcu_as_sc_mcu7t3v3__mux2_2
XFILLER_162_221 VDD VDD VSS VSS gf180mcu_as_sc_mcu7t3v3__fill_1
XFILLER_33_1199 VDD VDD VSS VSS gf180mcu_as_sc_mcu7t3v3__fillcap_16
X_4649_ VDD VDD VSS VSS _4659_/B _4649_/A _4649_/B _4649_/C gf180mcu_as_sc_mcu7t3v3__ao21_2
XFILLER_194_1259 VDD VDD VSS VSS gf180mcu_as_sc_mcu7t3v3__fillcap_16
XFILLER_30_69 VDD VDD VSS VSS gf180mcu_as_sc_mcu7t3v3__fillcap_4
XFILLER_122_107 VDD VDD VSS VSS gf180mcu_as_sc_mcu7t3v3__fillcap_16
XPHY_EDGE_ROW_31_Left_242 VDD VSS gf180mcu_as_sc_mcu7t3v3__tap_2
XFILLER_81_1418 VDD VDD VSS VSS gf180mcu_as_sc_mcu7t3v3__fillcap_4
XTAP_TAPCELL_ROW_186_2259 VDD VSS gf180mcu_as_sc_mcu7t3v3__tap_2
XFILLER_172_1568 VDD VDD VSS VSS gf180mcu_as_sc_mcu7t3v3__fill_1
XFILLER_130_173 VDD VDD VSS VSS gf180mcu_as_sc_mcu7t3v3__fill_2
XFILLER_162_57 VDD VDD VSS VSS gf180mcu_as_sc_mcu7t3v3__fill_2
XPHY_EDGE_ROW_168_1_Right_689 VDD VSS gf180mcu_as_sc_mcu7t3v3__tap_2
XFILLER_44_157 VDD VDD VSS VSS gf180mcu_as_sc_mcu7t3v3__fillcap_16
XFILLER_55_88 VDD VDD VSS VSS gf180mcu_as_sc_mcu7t3v3__fillcap_4
XFILLER_111_72 VDD VDD VSS VSS gf180mcu_as_sc_mcu7t3v3__fill_2
XFILLER_187_54 VDD VDD VSS VSS gf180mcu_as_sc_mcu7t3v3__fillcap_16
XFILLER_200_155 VDD VDD VSS VSS gf180mcu_as_sc_mcu7t3v3__fillcap_16
XFILLER_55_1380 VDD VDD VSS VSS gf180mcu_as_sc_mcu7t3v3__fillcap_4
XFILLER_71_76 VDD VDD VSS VSS gf180mcu_as_sc_mcu7t3v3__fill_2
XFILLER_107_1481 VDD VDD VSS VSS gf180mcu_as_sc_mcu7t3v3__fillcap_4
XFILLER_16_1364 VDD VDD VSS VSS gf180mcu_as_sc_mcu7t3v3__fill_1
XFILLER_200_177 VDD VDD VSS VSS gf180mcu_as_sc_mcu7t3v3__fillcap_16
XFILLER_177_1402 VDD VDD VSS VSS gf180mcu_as_sc_mcu7t3v3__fillcap_4
XFILLER_177_1468 VDD VDD VSS VSS gf180mcu_as_sc_mcu7t3v3__fill_2
XFILLER_4_242 VDD VDD VSS VSS gf180mcu_as_sc_mcu7t3v3__fill_2
XFILLER_181_574 VDD VDD VSS VSS gf180mcu_as_sc_mcu7t3v3__fill_1
XFILLER_136_80 VDD VDD VSS VSS gf180mcu_as_sc_mcu7t3v3__fillcap_4
XFILLER_175_1192 VDD VDD VSS VSS gf180mcu_as_sc_mcu7t3v3__fillcap_16
XFILLER_1_982 VDD VDD VSS VSS gf180mcu_as_sc_mcu7t3v3__fillcap_8
XFILLER_27_1460 VDD VDD VSS VSS gf180mcu_as_sc_mcu7t3v3__fillcap_8
XTAP_TAPCELL_ROW_167_1_1946 VDD VSS gf180mcu_as_sc_mcu7t3v3__tap_2
XFILLER_209_734 VDD VDD VSS VSS gf180mcu_as_sc_mcu7t3v3__fillcap_16
XFILLER_62_1395 VDD VDD VSS VSS gf180mcu_as_sc_mcu7t3v3__fillcap_16
XFILLER_97_1403 VDD VDD VSS VSS gf180mcu_as_sc_mcu7t3v3__fillcap_8
XTAP_TAPCELL_ROW_15_1060 VDD VSS gf180mcu_as_sc_mcu7t3v3__tap_2
XTAP_TAPCELL_ROW_15_1071 VDD VSS gf180mcu_as_sc_mcu7t3v3__tap_2
XFILLER_114_1485 VDD VDD VSS VSS gf180mcu_as_sc_mcu7t3v3__fillcap_4
XFILLER_23_1368 VDD VDD VSS VSS gf180mcu_as_sc_mcu7t3v3__fill_1
XFILLER_36_614 VDD VDD VSS VSS gf180mcu_as_sc_mcu7t3v3__fillcap_8
XFILLER_149_1537 VDD VDD VSS VSS gf180mcu_as_sc_mcu7t3v3__fillcap_16
XTAP_TAPCELL_ROW_52_1_1600 VDD VSS gf180mcu_as_sc_mcu7t3v3__tap_2
XFILLER_21_1092 VDD VDD VSS VSS gf180mcu_as_sc_mcu7t3v3__fillcap_4
XFILLER_35_179 VDD VDD VSS VSS gf180mcu_as_sc_mcu7t3v3__fillcap_16
X_3951_ VDD VDD VSS VSS _3951_/A _4030_/C _3951_/C _3951_/D _3952_/C gf180mcu_as_sc_mcu7t3v3__ao211_2
XFILLER_177_803 VDD VDD VSS VSS gf180mcu_as_sc_mcu7t3v3__fill_2
X_2902_ VDD VDD VSS VSS _3199_/B _3542_/A _2902_/Y gf180mcu_as_sc_mcu7t3v3__and2_2
XFILLER_176_313 VDD VDD VSS VSS gf180mcu_as_sc_mcu7t3v3__fill_2
XFILLER_189_696 VDD VDD VSS VSS gf180mcu_as_sc_mcu7t3v3__fillcap_4
XFILLER_31_352 VDD VDD VSS VSS gf180mcu_as_sc_mcu7t3v3__fill_2
X_3882_ VDD VDD VSS VSS _3893_/B _5172_/Q _4922_/D gf180mcu_as_sc_mcu7t3v3__and2_2
XTAP_TAPCELL_ROW_62_3_2906 VDD VSS gf180mcu_as_sc_mcu7t3v3__tap_2
XFILLER_177_858 VDD VDD VSS VSS gf180mcu_as_sc_mcu7t3v3__fillcap_4
XFILLER_34_1453 VDD VDD VSS VSS gf180mcu_as_sc_mcu7t3v3__fillcap_16
X_2833_ VDD VDD VSS VSS _5485_/A _2833_/A _4751_/B gf180mcu_as_sc_mcu7t3v3__and2_2
XFILLER_192_839 VDD VDD VSS VSS gf180mcu_as_sc_mcu7t3v3__fillcap_16
X_2764_ VDD VDD VSS VSS _2764_/B _2764_/A _2842_/A gf180mcu_as_sc_mcu7t3v3__xnor2_2
XFILLER_144_221 VDD VDD VSS VSS gf180mcu_as_sc_mcu7t3v3__fill_1
XFILLER_30_1339 VDD VDD VSS VSS gf180mcu_as_sc_mcu7t3v3__fill_1
X_4503_ VDD VDD VSS VSS _4504_/D _4503_/B _4521_/A gf180mcu_as_sc_mcu7t3v3__nor2_2
X_5483_ VDD VDD VSS VSS _5483_/A _5483_/Y gf180mcu_as_sc_mcu7t3v3__buff_2
X_2695_ VDD VDD VSS VSS _2695_/A _4968_/Q _2734_/S _2695_/D _2701_/B gf180mcu_as_sc_mcu7t3v3__ao211_2
XFILLER_104_107 VDD VDD VSS VSS gf180mcu_as_sc_mcu7t3v3__fillcap_16
X_4434_ VDD VDD VSS VSS _5172_/Q _4470_/B _4479_/C _5122_/Q _4435_/B gf180mcu_as_sc_mcu7t3v3__ao22_2
XTAP_TAPCELL_ROW_42_3_2848 VDD VSS gf180mcu_as_sc_mcu7t3v3__tap_2
X_4365_ VDD VDD VSS VSS _4366_/A _4365_/B _4365_/A gf180mcu_as_sc_mcu7t3v3__nand2_2
Xfanout516 VDD VDD VSS VSS _4227_/B _4222_/B gf180mcu_as_sc_mcu7t3v3__buff_12
Xfanout527 VDD VDD VSS VSS _3802_/C _3758_/D gf180mcu_as_sc_mcu7t3v3__buff_12
Xfanout538 VDD VDD VSS VSS _3416_/B _3463_/B gf180mcu_as_sc_mcu7t3v3__buff_12
X_3316_ VDD VDD VSS VSS _3381_/S _3965_/A _3316_/A _3318_/B gf180mcu_as_sc_mcu7t3v3__mux2_2
XFILLER_112_173 VDD VDD VSS VSS gf180mcu_as_sc_mcu7t3v3__fill_2
Xfanout549 VDD VDD VSS VSS _4533_/A _4497_/A gf180mcu_as_sc_mcu7t3v3__buff_12
X_4296_ VDD VDD VSS VSS _4297_/A _5127_/Q _4329_/A _4328_/B gf180mcu_as_sc_mcu7t3v3__ao21_2
XFILLER_132_1541 VDD VDD VSS VSS gf180mcu_as_sc_mcu7t3v3__fill_2
XFILLER_132_27 VDD VDD VSS VSS gf180mcu_as_sc_mcu7t3v3__fillcap_8
XFILLER_6_1031 VDD VDD VSS VSS gf180mcu_as_sc_mcu7t3v3__fillcap_16
XFILLER_73_208 VDD VDD VSS VSS gf180mcu_as_sc_mcu7t3v3__fill_2
Xmesh_tile_953 VDD VDD VSS VSS ne_out[28] gf180mcu_as_sc_mcu7t3v3__tiel_4
Xmesh_tile_942 VDD VDD VSS VSS ne_out[17] gf180mcu_as_sc_mcu7t3v3__tiel_4
Xmesh_tile_931 VDD VDD VSS VSS ne_out[6] gf180mcu_as_sc_mcu7t3v3__tiel_4
X_3247_ VDD VDD VSS VSS _3247_/B _3542_/A _3519_/C gf180mcu_as_sc_mcu7t3v3__or2_2
XTAP_TAPCELL_ROW_181_2156 VDD VSS gf180mcu_as_sc_mcu7t3v3__tap_2
XTAP_TAPCELL_ROW_181_2145 VDD VSS gf180mcu_as_sc_mcu7t3v3__tap_2
XFILLER_187_1030 VDD VDD VSS VSS gf180mcu_as_sc_mcu7t3v3__fillcap_16
XFILLER_26_102 VDD VDD VSS VSS gf180mcu_as_sc_mcu7t3v3__fill_2
XPHY_EDGE_ROW_106_3_Right_143 VDD VSS gf180mcu_as_sc_mcu7t3v3__tap_2
Xmesh_tile_986 VDD VDD VSS VSS north_out[27] gf180mcu_as_sc_mcu7t3v3__tiel_4
Xmesh_tile_975 VDD VDD VSS VSS north_out[16] gf180mcu_as_sc_mcu7t3v3__tiel_4
Xmesh_tile_964 VDD VDD VSS VSS north_out[5] gf180mcu_as_sc_mcu7t3v3__tiel_4
X_3178_ VDD VDD VSS VSS _3178_/A _3178_/B _3178_/C _3178_/D _3180_/C gf180mcu_as_sc_mcu7t3v3__ao211_2
XFILLER_187_1052 VDD VDD VSS VSS gf180mcu_as_sc_mcu7t3v3__fillcap_16
XFILLER_199_405 VDD VDD VSS VSS gf180mcu_as_sc_mcu7t3v3__fillcap_8
XFILLER_26_124 VDD VDD VSS VSS gf180mcu_as_sc_mcu7t3v3__fill_1
Xmesh_tile_997 VDD VDD VSS VSS nw_out[4] gf180mcu_as_sc_mcu7t3v3__tiel_4
XTAP_TAPCELL_ROW_2_779 VDD VSS gf180mcu_as_sc_mcu7t3v3__tap_2
XTAP_TAPCELL_ROW_2_768 VDD VSS gf180mcu_as_sc_mcu7t3v3__tap_2
XFILLER_26_168 VDD VDD VSS VSS gf180mcu_as_sc_mcu7t3v3__fillcap_4
XFILLER_23_842 VDD VDD VSS VSS gf180mcu_as_sc_mcu7t3v3__fillcap_16
XFILLER_25_69 VDD VDD VSS VSS gf180mcu_as_sc_mcu7t3v3__fill_1
XFILLER_10_514 VDD VDD VSS VSS gf180mcu_as_sc_mcu7t3v3__fill_1
XFILLER_179_184 VDD VDD VSS VSS gf180mcu_as_sc_mcu7t3v3__fill_2
XFILLER_52_1520 VDD VDD VSS VSS gf180mcu_as_sc_mcu7t3v3__fill_1
Xwire906 VDD VDD VSS VSS wire906/A _3976_/D gf180mcu_as_sc_mcu7t3v3__clkbuff_12
XFILLER_210_475 VDD VDD VSS VSS gf180mcu_as_sc_mcu7t3v3__fill_1
XFILLER_100_1518 VDD VDD VSS VSS gf180mcu_as_sc_mcu7t3v3__fill_2
XFILLER_11_1294 VDD VDD VSS VSS gf180mcu_as_sc_mcu7t3v3__fillcap_8
XFILLER_1_212 VDD VDD VSS VSS gf180mcu_as_sc_mcu7t3v3__fill_1
XTAP_TAPCELL_ROW_57_1_1615 VDD VSS gf180mcu_as_sc_mcu7t3v3__tap_2
XFILLER_137_1496 VDD VDD VSS VSS gf180mcu_as_sc_mcu7t3v3__fillcap_4
XFILLER_206_715 VDD VDD VSS VSS gf180mcu_as_sc_mcu7t3v3__fillcap_16
XFILLER_206_737 VDD VDD VSS VSS gf180mcu_as_sc_mcu7t3v3__fillcap_16
XFILLER_66_98 VDD VDD VSS VSS gf180mcu_as_sc_mcu7t3v3__fillcap_4
XFILLER_82_31 VDD VDD VSS VSS gf180mcu_as_sc_mcu7t3v3__fillcap_4
XFILLER_207_1122 VDD VDD VSS VSS gf180mcu_as_sc_mcu7t3v3__fillcap_16
XFILLER_32_116 VDD VDD VSS VSS gf180mcu_as_sc_mcu7t3v3__fillcap_16
XFILLER_57_1442 VDD VDD VSS VSS gf180mcu_as_sc_mcu7t3v3__fill_1
XFILLER_109_1554 VDD VDD VSS VSS gf180mcu_as_sc_mcu7t3v3__fill_2
XFILLER_183_1472 VDD VDD VSS VSS gf180mcu_as_sc_mcu7t3v3__fillcap_16
XFILLER_18_1437 VDD VDD VSS VSS gf180mcu_as_sc_mcu7t3v3__fillcap_4
XFILLER_198_53 VDD VDD VSS VSS gf180mcu_as_sc_mcu7t3v3__fillcap_16
XFILLER_25_190 VDD VDD VSS VSS gf180mcu_as_sc_mcu7t3v3__fillcap_16
XFILLER_14_897 VDD VDD VSS VSS gf180mcu_as_sc_mcu7t3v3__fill_2
XFILLER_185_132 VDD VDD VSS VSS gf180mcu_as_sc_mcu7t3v3__fill_1
XFILLER_186_633 VDD VDD VSS VSS gf180mcu_as_sc_mcu7t3v3__fill_2
XFILLER_201_464 VDD VDD VSS VSS gf180mcu_as_sc_mcu7t3v3__fillcap_16
XFILLER_13_396 VDD VDD VSS VSS gf180mcu_as_sc_mcu7t3v3__fill_2
XFILLER_186_699 VDD VDD VSS VSS gf180mcu_as_sc_mcu7t3v3__fillcap_16
XFILLER_185_187 VDD VDD VSS VSS gf180mcu_as_sc_mcu7t3v3__fill_2
XFILLER_177_1232 VDD VDD VSS VSS gf180mcu_as_sc_mcu7t3v3__fillcap_16
XFILLER_5_562 VDD VDD VSS VSS gf180mcu_as_sc_mcu7t3v3__fill_2
X_2480_ VDD VDD VSS VSS _5274_/Q _5275_/Q _2482_/B gf180mcu_as_sc_mcu7t3v3__or2_2
XTAP_TAPCELL_ROW_17_1100 VDD VSS gf180mcu_as_sc_mcu7t3v3__tap_2
XFILLER_151_1405 VDD VDD VSS VSS gf180mcu_as_sc_mcu7t3v3__fillcap_8
X_4150_ VDD VDD VSS VSS _5004_/Q _4150_/B _4255_/B _4158_/D _5004_/D gf180mcu_as_sc_mcu7t3v3__ao22_2
XTAP_TAPCELL_ROW_17_1111 VDD VSS gf180mcu_as_sc_mcu7t3v3__tap_2
XTAP_TAPCELL_ROW_13_1008 VDD VSS gf180mcu_as_sc_mcu7t3v3__tap_2
X_3101_ VDD VDD VSS VSS _3121_/B _4933_/Q _3104_/C gf180mcu_as_sc_mcu7t3v3__or2_2
XTAP_TAPCELL_ROW_13_1019 VDD VSS gf180mcu_as_sc_mcu7t3v3__tap_2
X_4081_ VDD VDD VSS VSS _4081_/A _4122_/B _4081_/C _4081_/D _4082_/B gf180mcu_as_sc_mcu7t3v3__ao211_2
XTAP_TAPCELL_ROW_34_1480 VDD VSS gf180mcu_as_sc_mcu7t3v3__tap_2
XFILLER_55_208 VDD VDD VSS VSS gf180mcu_as_sc_mcu7t3v3__fill_2
Xinput190 VDD VDD VSS VSS se_in[18] _4081_/A gf180mcu_as_sc_mcu7t3v3__buff_12
X_3032_ VDD VDD VSS VSS _3032_/Y _3032_/C _3132_/B _3639_/A gf180mcu_as_sc_mcu7t3v3__aoi21_2
XFILLER_188_1361 VDD VDD VSS VSS gf180mcu_as_sc_mcu7t3v3__fillcap_4
XFILLER_36_444 VDD VDD VSS VSS gf180mcu_as_sc_mcu7t3v3__fillcap_16
XFILLER_3_1259 VDD VDD VSS VSS gf180mcu_as_sc_mcu7t3v3__fill_1
XTAP_TAPCELL_ROW_30_1388 VDD VSS gf180mcu_as_sc_mcu7t3v3__tap_2
XFILLER_188_1394 VDD VDD VSS VSS gf180mcu_as_sc_mcu7t3v3__fillcap_16
XTAP_TAPCELL_ROW_30_1399 VDD VSS gf180mcu_as_sc_mcu7t3v3__tap_2
XFILLER_23_138 VDD VDD VSS VSS gf180mcu_as_sc_mcu7t3v3__fill_2
X_4983_ VDD VDD VSS VSS clkload1/A _4983_/D _4983_/Q gf180mcu_as_sc_mcu7t3v3__dfxtp_2
XTAP_TAPCELL_ROW_95_3_3006 VDD VSS gf180mcu_as_sc_mcu7t3v3__tap_2
XFILLER_162_1523 VDD VDD VSS VSS gf180mcu_as_sc_mcu7t3v3__fillcap_4
XFILLER_196_419 VDD VDD VSS VSS gf180mcu_as_sc_mcu7t3v3__fillcap_16
X_3934_ VDD VDD VSS VSS _3934_/A _4033_/B _3934_/C _3934_/D _3935_/B gf180mcu_as_sc_mcu7t3v3__ao211_2
XFILLER_176_121 VDD VDD VSS VSS gf180mcu_as_sc_mcu7t3v3__fill_1
X_3865_ VDD VDD VSS VSS _5136_/Q _5135_/Q _3866_/C gf180mcu_as_sc_mcu7t3v3__or2_2
XFILLER_177_688 VDD VDD VSS VSS gf180mcu_as_sc_mcu7t3v3__fill_2
XFILLER_203_1520 VDD VDD VSS VSS gf180mcu_as_sc_mcu7t3v3__fillcap_16
XFILLER_203_1542 VDD VDD VSS VSS gf180mcu_as_sc_mcu7t3v3__fill_2
XFILLER_31_182 VDD VDD VSS VSS gf180mcu_as_sc_mcu7t3v3__fillcap_4
XFILLER_34_1250 VDD VDD VSS VSS gf180mcu_as_sc_mcu7t3v3__fillcap_16
X_2816_ VDD VDD VSS VSS _4974_/D _2826_/B _4757_/Q _4756_/D gf180mcu_as_sc_mcu7t3v3__mux2_2
XFILLER_30_1103 VDD VDD VSS VSS gf180mcu_as_sc_mcu7t3v3__fillcap_16
XFILLER_34_1294 VDD VDD VSS VSS gf180mcu_as_sc_mcu7t3v3__fill_1
XFILLER_9_890 VDD VDD VSS VSS gf180mcu_as_sc_mcu7t3v3__fillcap_16
X_3796_ VDD VDD VSS VSS _3796_/A _3796_/B _3796_/C _3796_/D _3797_/D gf180mcu_as_sc_mcu7t3v3__ao22_2
XFILLER_195_1310 VDD VDD VSS VSS gf180mcu_as_sc_mcu7t3v3__fillcap_16
XFILLER_195_1332 VDD VDD VSS VSS gf180mcu_as_sc_mcu7t3v3__fillcap_16
XPHY_EDGE_ROW_200_Left_410 VDD VSS gf180mcu_as_sc_mcu7t3v3__tap_2
X_2747_ VDD VDD VSS VSS _2747_/B _2747_/A _2845_/A gf180mcu_as_sc_mcu7t3v3__and2_2
XFILLER_127_27 VDD VDD VSS VSS gf180mcu_as_sc_mcu7t3v3__fillcap_8
XFILLER_69_1368 VDD VDD VSS VSS gf180mcu_as_sc_mcu7t3v3__fill_2
X_2678_ VDD VDD VSS VSS _4272_/S _4264_/B _4265_/B gf180mcu_as_sc_mcu7t3v3__and2_2
X_4417_ VDD VDD VSS VSS _4418_/C _4542_/A _5011_/Q _4546_/A gf180mcu_as_sc_mcu7t3v3__ao21_2
XTAP_TAPCELL_ROW_183_2207 VDD VSS gf180mcu_as_sc_mcu7t3v3__tap_2
XFILLER_28_1054 VDD VDD VSS VSS gf180mcu_as_sc_mcu7t3v3__fillcap_4
XFILLER_28_1087 VDD VDD VSS VSS gf180mcu_as_sc_mcu7t3v3__fillcap_16
XFILLER_82_1568 VDD VDD VSS VSS gf180mcu_as_sc_mcu7t3v3__fill_1
X_4348_ VDD VDD VSS VSS _5158_/Q _5157_/Q _4349_/A gf180mcu_as_sc_mcu7t3v3__xnor2_2
XFILLER_28_901 VDD VDD VSS VSS gf180mcu_as_sc_mcu7t3v3__fill_2
X_4279_ VDD VDD VSS VSS _4279_/S _5483_/A _5113_/Q _5113_/D gf180mcu_as_sc_mcu7t3v3__mux2_2
XFILLER_100_187 VDD VDD VSS VSS gf180mcu_as_sc_mcu7t3v3__fillcap_16
XFILLER_167_1412 VDD VDD VSS VSS gf180mcu_as_sc_mcu7t3v3__fillcap_4
XFILLER_210_1568 VDD VDD VSS VSS gf180mcu_as_sc_mcu7t3v3__fill_1
XFILLER_27_422 VDD VDD VSS VSS gf180mcu_as_sc_mcu7t3v3__fillcap_16
XPHY_EDGE_ROW_107_3_Right_144 VDD VSS gf180mcu_as_sc_mcu7t3v3__tap_2
XFILLER_160_6 VDD VDD VSS VSS gf180mcu_as_sc_mcu7t3v3__fillcap_16
XFILLER_27_466 VDD VDD VSS VSS gf180mcu_as_sc_mcu7t3v3__fill_1
XFILLER_188_909 VDD VDD VSS VSS gf180mcu_as_sc_mcu7t3v3__fillcap_16
XFILLER_203_718 VDD VDD VSS VSS gf180mcu_as_sc_mcu7t3v3__fillcap_16
XFILLER_208_1431 VDD VDD VSS VSS gf180mcu_as_sc_mcu7t3v3__fillcap_4
XFILLER_208_1453 VDD VDD VSS VSS gf180mcu_as_sc_mcu7t3v3__fillcap_16
XPHY_EDGE_ROW_167_1_Left_377 VDD VSS gf180mcu_as_sc_mcu7t3v3__tap_2
XFILLER_11_834 VDD VDD VSS VSS gf180mcu_as_sc_mcu7t3v3__fillcap_4
XFILLER_35_1014 VDD VDD VSS VSS gf180mcu_as_sc_mcu7t3v3__fillcap_16
XFILLER_10_311 VDD VDD VSS VSS gf180mcu_as_sc_mcu7t3v3__fillcap_4
XFILLER_168_34 VDD VDD VSS VSS gf180mcu_as_sc_mcu7t3v3__fill_1
XFILLER_52_1372 VDD VDD VSS VSS gf180mcu_as_sc_mcu7t3v3__fillcap_8
XFILLER_52_1383 VDD VDD VSS VSS gf180mcu_as_sc_mcu7t3v3__fillcap_4
XFILLER_6_304 VDD VDD VSS VSS gf180mcu_as_sc_mcu7t3v3__fillcap_8
XFILLER_7_838 VDD VDD VSS VSS gf180mcu_as_sc_mcu7t3v3__fill_2
XFILLER_104_1473 VDD VDD VSS VSS gf180mcu_as_sc_mcu7t3v3__fillcap_4
XTAP_TAPCELL_ROW_110_1_1775 VDD VSS gf180mcu_as_sc_mcu7t3v3__tap_2
XTAP_TAPCELL_ROW_122_3_3087 VDD VSS gf180mcu_as_sc_mcu7t3v3__tap_2
XFILLER_123_202 VDD VDD VSS VSS gf180mcu_as_sc_mcu7t3v3__fillcap_8
XFILLER_13_1389 VDD VDD VSS VSS gf180mcu_as_sc_mcu7t3v3__fill_2
XFILLER_191_680 VDD VDD VSS VSS gf180mcu_as_sc_mcu7t3v3__fillcap_16
XFILLER_201_2 VDD VDD VSS VSS gf180mcu_as_sc_mcu7t3v3__fillcap_16
XFILLER_139_1558 VDD VDD VSS VSS gf180mcu_as_sc_mcu7t3v3__fillcap_8
XFILLER_174_1427 VDD VDD VSS VSS gf180mcu_as_sc_mcu7t3v3__fill_1
XFILLER_2_510 VDD VDD VSS VSS gf180mcu_as_sc_mcu7t3v3__fillcap_4
XFILLER_2_554 VDD VDD VSS VSS gf180mcu_as_sc_mcu7t3v3__fill_2
XTAP_TAPCELL_ROW_88_1_1709 VDD VSS gf180mcu_as_sc_mcu7t3v3__tap_2
XTAP_TAPCELL_ROW_6_871 VDD VSS gf180mcu_as_sc_mcu7t3v3__tap_2
XTAP_TAPCELL_ROW_6_860 VDD VSS gf180mcu_as_sc_mcu7t3v3__tap_2
XFILLER_111_1422 VDD VDD VSS VSS gf180mcu_as_sc_mcu7t3v3__fill_2
XFILLER_19_912 VDD VDD VSS VSS gf180mcu_as_sc_mcu7t3v3__fillcap_4
XFILLER_203_18 VDD VDD VSS VSS gf180mcu_as_sc_mcu7t3v3__fillcap_16
Xfanout891 VDD VDD VSS VSS wire900/Y _4199_/A gf180mcu_as_sc_mcu7t3v3__buff_12
XFILLER_111_1444 VDD VDD VSS VSS gf180mcu_as_sc_mcu7t3v3__fill_1
XFILLER_59_1504 VDD VDD VSS VSS gf180mcu_as_sc_mcu7t3v3__fill_2
XFILLER_111_1488 VDD VDD VSS VSS gf180mcu_as_sc_mcu7t3v3__fillcap_16
XFILLER_93_52 VDD VDD VSS VSS gf180mcu_as_sc_mcu7t3v3__fillcap_16
XPHY_EDGE_ROW_132_3_Left_517 VDD VSS gf180mcu_as_sc_mcu7t3v3__tap_2
XFILLER_179_909 VDD VDD VSS VSS gf180mcu_as_sc_mcu7t3v3__fill_1
XFILLER_26_90 VDD VDD VSS VSS gf180mcu_as_sc_mcu7t3v3__fillcap_8
XFILLER_14_661 VDD VDD VSS VSS gf180mcu_as_sc_mcu7t3v3__fillcap_4
XFILLER_14_683 VDD VDD VSS VSS gf180mcu_as_sc_mcu7t3v3__fillcap_16
XFILLER_109_1384 VDD VDD VSS VSS gf180mcu_as_sc_mcu7t3v3__fill_2
XFILLER_174_614 VDD VDD VSS VSS gf180mcu_as_sc_mcu7t3v3__fillcap_16
XFILLER_18_1267 VDD VDD VSS VSS gf180mcu_as_sc_mcu7t3v3__fillcap_16
XFILLER_9_120 VDD VDD VSS VSS gf180mcu_as_sc_mcu7t3v3__fillcap_16
XFILLER_70_1461 VDD VDD VSS VSS gf180mcu_as_sc_mcu7t3v3__fillcap_4
XFILLER_70_1472 VDD VDD VSS VSS gf180mcu_as_sc_mcu7t3v3__fillcap_8
X_3650_ VDD VDD VSS VSS _4021_/D _3650_/B _3650_/C _3650_/D _3651_/C gf180mcu_as_sc_mcu7t3v3__ao211_2
X_3581_ VDD VDD VSS VSS _4917_/Q _3648_/B _3648_/C _3950_/A _3583_/C gf180mcu_as_sc_mcu7t3v3__ao22_2
X_2601_ VDD VDD VSS VSS _2602_/B _4765_/Q _2831_/A _2601_/C _2601_/D gf180mcu_as_sc_mcu7t3v3__aoi22_2
X_2532_ VDD VDD VSS VSS _4749_/A _2792_/A _2534_/C gf180mcu_as_sc_mcu7t3v3__or2_2
XFILLER_177_1084 VDD VDD VSS VSS gf180mcu_as_sc_mcu7t3v3__fillcap_16
XFILLER_181_190 VDD VDD VSS VSS gf180mcu_as_sc_mcu7t3v3__fillcap_16
XFILLER_6_893 VDD VDD VSS VSS gf180mcu_as_sc_mcu7t3v3__fillcap_16
X_5251_ VDD VDD VSS VSS _5262_/CLK _5251_/D _5251_/Q gf180mcu_as_sc_mcu7t3v3__dfxtp_2
X_4202_ VDD VDD VSS VSS _4231_/B _4228_/B _4228_/C _5038_/Q _5038_/D gf180mcu_as_sc_mcu7t3v3__ao22_2
X_2463_ VDD VDD VSS VSS _2464_/C _4527_/S _5035_/Q _4502_/A gf180mcu_as_sc_mcu7t3v3__ao21_2
XTAP_TAPCELL_ROW_36_1531 VDD VSS gf180mcu_as_sc_mcu7t3v3__tap_2
XTAP_TAPCELL_ROW_36_1520 VDD VSS gf180mcu_as_sc_mcu7t3v3__tap_2
XFILLER_155_1371 VDD VDD VSS VSS gf180mcu_as_sc_mcu7t3v3__fillcap_8
XFILLER_9_1424 VDD VDD VSS VSS gf180mcu_as_sc_mcu7t3v3__fill_2
XFILLER_9_1435 VDD VDD VSS VSS gf180mcu_as_sc_mcu7t3v3__fillcap_16
X_5182_ VDD VDD VSS VSS clkload8/A _5182_/D _5182_/Q gf180mcu_as_sc_mcu7t3v3__dfxtp_2
X_2394_ VDD VDD VSS VSS _3848_/A _3844_/C gf180mcu_as_sc_mcu7t3v3__inv_2
XTAP_TAPCELL_ROW_4_808 VDD VSS gf180mcu_as_sc_mcu7t3v3__tap_2
XTAP_TAPCELL_ROW_36_1553 VDD VSS gf180mcu_as_sc_mcu7t3v3__tap_2
XTAP_TAPCELL_ROW_36_1542 VDD VSS gf180mcu_as_sc_mcu7t3v3__tap_2
XFILLER_3_72 VDD VDD VSS VSS gf180mcu_as_sc_mcu7t3v3__fillcap_16
XFILLER_95_130 VDD VDD VSS VSS gf180mcu_as_sc_mcu7t3v3__fillcap_8
X_4133_ VDD VDD VSS VSS _4253_/B _4133_/B _4141_/D gf180mcu_as_sc_mcu7t3v3__nor2_2
XTAP_TAPCELL_ROW_4_819 VDD VSS gf180mcu_as_sc_mcu7t3v3__tap_2
XTAP_TAPCELL_ROW_32_1439 VDD VSS gf180mcu_as_sc_mcu7t3v3__tap_2
XTAP_TAPCELL_ROW_32_1428 VDD VSS gf180mcu_as_sc_mcu7t3v3__tap_2
XFILLER_113_18 VDD VDD VSS VSS gf180mcu_as_sc_mcu7t3v3__fillcap_4
XFILLER_28_208 VDD VDD VSS VSS gf180mcu_as_sc_mcu7t3v3__fillcap_4
X_4064_ VDD VDD VSS VSS _4064_/A _4119_/B _4118_/B _4064_/D _4065_/D gf180mcu_as_sc_mcu7t3v3__ao22_2
XTAP_TAPCELL_ROW_37_3_2832 VDD VSS gf180mcu_as_sc_mcu7t3v3__tap_2
XFILLER_3_1034 VDD VDD VSS VSS gf180mcu_as_sc_mcu7t3v3__fillcap_16
XFILLER_7_1192 VDD VDD VSS VSS gf180mcu_as_sc_mcu7t3v3__fillcap_8
XFILLER_95_185 VDD VDD VSS VSS gf180mcu_as_sc_mcu7t3v3__fillcap_16
XPHY_EDGE_ROW_64_3_Left_449 VDD VSS gf180mcu_as_sc_mcu7t3v3__tap_2
X_3015_ VDD VDD VSS VSS _3015_/B _3795_/A _4778_/D gf180mcu_as_sc_mcu7t3v3__and2_2
XFILLER_184_1011 VDD VDD VSS VSS gf180mcu_as_sc_mcu7t3v3__fillcap_4
XFILLER_184_1033 VDD VDD VSS VSS gf180mcu_as_sc_mcu7t3v3__fillcap_16
XFILLER_36_274 VDD VDD VSS VSS gf180mcu_as_sc_mcu7t3v3__fillcap_16
XFILLER_24_469 VDD VDD VSS VSS gf180mcu_as_sc_mcu7t3v3__fill_1
X_4966_ VDD VDD VSS VSS _5285_/CLK _4966_/D _4966_/Q gf180mcu_as_sc_mcu7t3v3__dfxtp_2
XTAP_TAPCELL_ROW_201_2590 VDD VSS gf180mcu_as_sc_mcu7t3v3__tap_2
XTAP_TAPCELL_ROW_176_2055 VDD VSS gf180mcu_as_sc_mcu7t3v3__tap_2
XTAP_TAPCELL_ROW_176_2044 VDD VSS gf180mcu_as_sc_mcu7t3v3__tap_2
XFILLER_127_1473 VDD VDD VSS VSS gf180mcu_as_sc_mcu7t3v3__fillcap_8
XFILLER_162_1364 VDD VDD VSS VSS gf180mcu_as_sc_mcu7t3v3__fill_1
XFILLER_193_912 VDD VDD VSS VSS gf180mcu_as_sc_mcu7t3v3__fillcap_16
XFILLER_20_642 VDD VDD VSS VSS gf180mcu_as_sc_mcu7t3v3__fillcap_16
X_4897_ VDD VDD VSS VSS _4904_/CLK _4897_/D _4897_/Q gf180mcu_as_sc_mcu7t3v3__dfxtp_2
X_3917_ VDD VDD VSS VSS _3931_/B _3917_/A _3923_/B gf180mcu_as_sc_mcu7t3v3__and2_2
XFILLER_123_1348 VDD VDD VSS VSS gf180mcu_as_sc_mcu7t3v3__fillcap_16
XFILLER_164_102 VDD VDD VSS VSS gf180mcu_as_sc_mcu7t3v3__fill_2
XFILLER_20_664 VDD VDD VSS VSS gf180mcu_as_sc_mcu7t3v3__fill_1
XFILLER_22_37 VDD VDD VSS VSS gf180mcu_as_sc_mcu7t3v3__fillcap_16
X_3848_ VDD VDD VSS VSS _3848_/B _3848_/A _4913_/D gf180mcu_as_sc_mcu7t3v3__and2_2
XTAP_TAPCELL_ROW_82_1_1691 VDD VSS gf180mcu_as_sc_mcu7t3v3__tap_2
XFILLER_10_1507 VDD VDD VSS VSS gf180mcu_as_sc_mcu7t3v3__fillcap_16
XFILLER_138_37 VDD VDD VSS VSS gf180mcu_as_sc_mcu7t3v3__fillcap_16
X_3779_ VDD VDD VSS VSS _4159_/A _3779_/B _3779_/C _3779_/D _3781_/A gf180mcu_as_sc_mcu7t3v3__ao211_2
XFILLER_192_488 VDD VDD VSS VSS gf180mcu_as_sc_mcu7t3v3__fillcap_16
XTAP_TAPCELL_ROW_210_2815 VDD VSS gf180mcu_as_sc_mcu7t3v3__tap_2
XTAP_TAPCELL_ROW_210_2804 VDD VSS gf180mcu_as_sc_mcu7t3v3__tap_2
XPHY_EDGE_ROW_5_Left_216 VDD VSS gf180mcu_as_sc_mcu7t3v3__tap_2
XTAP_TAPCELL_ROW_92_3_2997 VDD VSS gf180mcu_as_sc_mcu7t3v3__tap_2
XTAP_TAPCELL_ROW_210_2826 VDD VSS gf180mcu_as_sc_mcu7t3v3__tap_2
Xoutput450 VDD VDD VSS VSS _4903_/Q west_out[30] gf180mcu_as_sc_mcu7t3v3__buff_12
XFILLER_154_69 VDD VDD VSS VSS gf180mcu_as_sc_mcu7t3v3__fillcap_8
XFILLER_173_1482 VDD VDD VSS VSS gf180mcu_as_sc_mcu7t3v3__fillcap_4
XFILLER_86_174 VDD VDD VSS VSS gf180mcu_as_sc_mcu7t3v3__fill_1
XTAP_TAPCELL_ROW_208_2755 VDD VSS gf180mcu_as_sc_mcu7t3v3__tap_2
XTAP_TAPCELL_ROW_208_2744 VDD VSS gf180mcu_as_sc_mcu7t3v3__tap_2
XFILLER_28_731 VDD VDD VSS VSS gf180mcu_as_sc_mcu7t3v3__fillcap_4
XFILLER_103_51 VDD VDD VSS VSS gf180mcu_as_sc_mcu7t3v3__fill_2
XFILLER_27_296 VDD VDD VSS VSS gf180mcu_as_sc_mcu7t3v3__fillcap_16
XPHY_EDGE_ROW_108_3_Right_145 VDD VSS gf180mcu_as_sc_mcu7t3v3__tap_2
XFILLER_151_2 VDD VDD VSS VSS gf180mcu_as_sc_mcu7t3v3__fillcap_16
XFILLER_179_22 VDD VDD VSS VSS gf180mcu_as_sc_mcu7t3v3__fillcap_16
XFILLER_187_216 VDD VDD VSS VSS gf180mcu_as_sc_mcu7t3v3__fill_2
XFILLER_19_1510 VDD VDD VSS VSS gf180mcu_as_sc_mcu7t3v3__fillcap_8
XFILLER_63_44 VDD VDD VSS VSS gf180mcu_as_sc_mcu7t3v3__fillcap_8
XTAP_TAPCELL_ROW_161_1_1927 VDD VSS gf180mcu_as_sc_mcu7t3v3__tap_2
XTAP_TAPCELL_ROW_173_3_3239 VDD VSS gf180mcu_as_sc_mcu7t3v3__tap_2
XFILLER_204_1103 VDD VDD VSS VSS gf180mcu_as_sc_mcu7t3v3__fillcap_16
XFILLER_30_406 VDD VDD VSS VSS gf180mcu_as_sc_mcu7t3v3__fillcap_16
XFILLER_93_1483 VDD VDD VSS VSS gf180mcu_as_sc_mcu7t3v3__fill_2
XTAP_TAPCELL_ROW_63_3_2911 VDD VSS gf180mcu_as_sc_mcu7t3v3__tap_2
XFILLER_141_1415 VDD VDD VSS VSS gf180mcu_as_sc_mcu7t3v3__fill_1
XFILLER_179_88 VDD VDD VSS VSS gf180mcu_as_sc_mcu7t3v3__fillcap_16
XFILLER_180_1453 VDD VDD VSS VSS gf180mcu_as_sc_mcu7t3v3__fillcap_16
XFILLER_54_1467 VDD VDD VSS VSS gf180mcu_as_sc_mcu7t3v3__fill_1
Xwire500 VDD VDD VSS VSS _3049_/Y wire500/Y gf180mcu_as_sc_mcu7t3v3__clkbuff_12
XFILLER_10_152 VDD VDD VSS VSS gf180mcu_as_sc_mcu7t3v3__fillcap_8
XFILLER_11_653 VDD VDD VSS VSS gf180mcu_as_sc_mcu7t3v3__fill_2
XFILLER_141_1448 VDD VDD VSS VSS gf180mcu_as_sc_mcu7t3v3__fillcap_16
XFILLER_183_422 VDD VDD VSS VSS gf180mcu_as_sc_mcu7t3v3__fillcap_16
XFILLER_195_282 VDD VDD VSS VSS gf180mcu_as_sc_mcu7t3v3__fillcap_4
XFILLER_6_101 VDD VDD VSS VSS gf180mcu_as_sc_mcu7t3v3__fillcap_4
XFILLER_195_54 VDD VDD VSS VSS gf180mcu_as_sc_mcu7t3v3__fillcap_16
XFILLER_6_123 VDD VDD VSS VSS gf180mcu_as_sc_mcu7t3v3__fillcap_16
XTAP_TAPCELL_ROW_141_1_1869 VDD VSS gf180mcu_as_sc_mcu7t3v3__tap_2
Xclkbuf_leaf_27_clk_regs VDD VDD VSS VSS clkload0/A clkload9/A gf180mcu_as_sc_mcu7t3v3__clkbuff_12
XFILLER_163_190 VDD VDD VSS VSS gf180mcu_as_sc_mcu7t3v3__fillcap_16
XFILLER_174_1268 VDD VDD VSS VSS gf180mcu_as_sc_mcu7t3v3__fill_2
XFILLER_2_384 VDD VDD VSS VSS gf180mcu_as_sc_mcu7t3v3__fill_1
XFILLER_113_1517 VDD VDD VSS VSS gf180mcu_as_sc_mcu7t3v3__fillcap_4
XFILLER_77_174 VDD VDD VSS VSS gf180mcu_as_sc_mcu7t3v3__fill_1
XFILLER_19_720 VDD VDD VSS VSS gf180mcu_as_sc_mcu7t3v3__fillcap_16
XFILLER_24_1282 VDD VDD VSS VSS gf180mcu_as_sc_mcu7t3v3__fill_2
XFILLER_77_185 VDD VDD VSS VSS gf180mcu_as_sc_mcu7t3v3__fillcap_8
XFILLER_18_241 VDD VDD VSS VSS gf180mcu_as_sc_mcu7t3v3__fillcap_4
XFILLER_179_706 VDD VDD VSS VSS gf180mcu_as_sc_mcu7t3v3__fill_1
XFILLER_18_263 VDD VDD VSS VSS gf180mcu_as_sc_mcu7t3v3__fillcap_16
XFILLER_20_1157 VDD VDD VSS VSS gf180mcu_as_sc_mcu7t3v3__fillcap_4
XFILLER_98_1383 VDD VDD VSS VSS gf180mcu_as_sc_mcu7t3v3__fill_1
XFILLER_98_1394 VDD VDD VSS VSS gf180mcu_as_sc_mcu7t3v3__fill_2
XFILLER_185_1364 VDD VDD VSS VSS gf180mcu_as_sc_mcu7t3v3__fillcap_8
XFILLER_22_918 VDD VDD VSS VSS gf180mcu_as_sc_mcu7t3v3__fillcap_16
XFILLER_33_244 VDD VDD VSS VSS gf180mcu_as_sc_mcu7t3v3__fillcap_4
X_4820_ VDD VDD VSS VSS _5068_/CLK _4820_/D _4820_/Q gf180mcu_as_sc_mcu7t3v3__dfxtp_2
XFILLER_146_1348 VDD VDD VSS VSS gf180mcu_as_sc_mcu7t3v3__fillcap_16
XFILLER_33_277 VDD VDD VSS VSS gf180mcu_as_sc_mcu7t3v3__fill_2
XFILLER_175_912 VDD VDD VSS VSS gf180mcu_as_sc_mcu7t3v3__fillcap_16
XFILLER_187_750 VDD VDD VSS VSS gf180mcu_as_sc_mcu7t3v3__fillcap_16
XFILLER_187_772 VDD VDD VSS VSS gf180mcu_as_sc_mcu7t3v3__fillcap_16
X_4751_ VDD VDD VSS VSS _4751_/B _4975_/D _5285_/D gf180mcu_as_sc_mcu7t3v3__and2_2
XFILLER_174_422 VDD VDD VSS VSS gf180mcu_as_sc_mcu7t3v3__fill_2
XFILLER_186_271 VDD VDD VSS VSS gf180mcu_as_sc_mcu7t3v3__fill_2
X_4682_ VDD VDD VSS VSS _5248_/D _5102_/Q _4725_/B _4682_/C gf180mcu_as_sc_mcu7t3v3__ao21_2
X_3702_ VDD VDD VSS VSS _3706_/B _3702_/C _3758_/B _4078_/A gf180mcu_as_sc_mcu7t3v3__aoi21_2
XTAP_TAPCELL_ROW_25_1287 VDD VSS gf180mcu_as_sc_mcu7t3v3__tap_2
XTAP_TAPCELL_ROW_25_1276 VDD VSS gf180mcu_as_sc_mcu7t3v3__tap_2
XFILLER_174_444 VDD VDD VSS VSS gf180mcu_as_sc_mcu7t3v3__fillcap_16
XFILLER_200_1501 VDD VDD VSS VSS gf180mcu_as_sc_mcu7t3v3__fillcap_4
XFILLER_200_1523 VDD VDD VSS VSS gf180mcu_as_sc_mcu7t3v3__fillcap_16
X_3633_ VDD VDD VSS VSS _3634_/C _4006_/A _3725_/B _3633_/C gf180mcu_as_sc_mcu7t3v3__ao21_2
XFILLER_161_127 VDD VDD VSS VSS gf180mcu_as_sc_mcu7t3v3__fillcap_8
XFILLER_192_1313 VDD VDD VSS VSS gf180mcu_as_sc_mcu7t3v3__fillcap_16
X_3564_ VDD VDD VSS VSS _3564_/Y _3797_/C _3798_/A gf180mcu_as_sc_mcu7t3v3__nor2b_2
X_3495_ VDD VDD VSS VSS _4151_/A _3500_/B _3495_/C _3495_/D _3497_/C gf180mcu_as_sc_mcu7t3v3__ao211_2
X_2515_ VDD VDD VSS VSS _2517_/D _4749_/A _4663_/A _5240_/Q gf180mcu_as_sc_mcu7t3v3__aoi21_2
XFILLER_157_1488 VDD VDD VSS VSS gf180mcu_as_sc_mcu7t3v3__fill_2
X_5234_ VDD VDD VSS VSS _5276_/CLK _5234_/D _5234_/Q gf180mcu_as_sc_mcu7t3v3__dfxtp_2
Xmax_cap899 VDD VDD VSS VSS _2851_/A _3844_/C gf180mcu_as_sc_mcu7t3v3__clkbuff_12
X_2446_ VDD VDD VSS VSS _3477_/A _2446_/A gf180mcu_as_sc_mcu7t3v3__inv_2
XTAP_TAPCELL_ROW_58_1_1620 VDD VSS gf180mcu_as_sc_mcu7t3v3__tap_2
X_5165_ VDD VDD VSS VSS clkload9/A _5165_/D _5165_/Q gf180mcu_as_sc_mcu7t3v3__dfxtp_2
XFILLER_190_1081 VDD VDD VSS VSS gf180mcu_as_sc_mcu7t3v3__fillcap_4
XFILLER_25_1068 VDD VDD VSS VSS gf180mcu_as_sc_mcu7t3v3__fill_2
XFILLER_29_517 VDD VDD VSS VSS gf180mcu_as_sc_mcu7t3v3__fillcap_16
X_4116_ VDD VDD VSS VSS _4251_/B _4116_/B _4116_/A gf180mcu_as_sc_mcu7t3v3__nor2_2
XFILLER_42_1360 VDD VDD VSS VSS gf180mcu_as_sc_mcu7t3v3__fill_1
XFILLER_68_185 VDD VDD VSS VSS gf180mcu_as_sc_mcu7t3v3__fill_1
X_5096_ VDD VDD VSS VSS _5276_/CLK _5096_/D _5096_/Q gf180mcu_as_sc_mcu7t3v3__dfxtp_2
XTAP_TAPCELL_ROW_68_3_2926 VDD VSS gf180mcu_as_sc_mcu7t3v3__tap_2
X_4047_ VDD VDD VSS VSS _4047_/A _4101_/C _4047_/C _4047_/D _4049_/C gf180mcu_as_sc_mcu7t3v3__ao211_2
XFILLER_140_27 VDD VDD VSS VSS gf180mcu_as_sc_mcu7t3v3__fillcap_8
XFILLER_17_59 VDD VDD VSS VSS gf180mcu_as_sc_mcu7t3v3__fillcap_8
XTAP_TAPCELL_ROW_203_2641 VDD VSS gf180mcu_as_sc_mcu7t3v3__tap_2
XTAP_TAPCELL_ROW_203_2630 VDD VSS gf180mcu_as_sc_mcu7t3v3__tap_2
XFILLER_164_1415 VDD VDD VSS VSS gf180mcu_as_sc_mcu7t3v3__fillcap_4
XFILLER_36_1120 VDD VDD VSS VSS gf180mcu_as_sc_mcu7t3v3__fill_2
XTAP_TAPCELL_ROW_195_2453 VDD VSS gf180mcu_as_sc_mcu7t3v3__tap_2
XFILLER_205_1434 VDD VDD VSS VSS gf180mcu_as_sc_mcu7t3v3__fillcap_16
X_4949_ VDD VDD VSS VSS _4977_/CLK _4949_/D _4949_/Q gf180mcu_as_sc_mcu7t3v3__dfxtp_2
XTAP_TAPCELL_ROW_195_2464 VDD VSS gf180mcu_as_sc_mcu7t3v3__tap_2
XFILLER_178_794 VDD VDD VSS VSS gf180mcu_as_sc_mcu7t3v3__fillcap_4
XFILLER_32_1017 VDD VDD VSS VSS gf180mcu_as_sc_mcu7t3v3__fillcap_16
XFILLER_33_69 VDD VDD VSS VSS gf180mcu_as_sc_mcu7t3v3__fill_1
XFILLER_36_1186 VDD VDD VSS VSS gf180mcu_as_sc_mcu7t3v3__fillcap_4
XFILLER_149_69 VDD VDD VSS VSS gf180mcu_as_sc_mcu7t3v3__fill_1
XFILLER_177_282 VDD VDD VSS VSS gf180mcu_as_sc_mcu7t3v3__fillcap_4
XFILLER_197_1224 VDD VDD VSS VSS gf180mcu_as_sc_mcu7t3v3__fillcap_16
XFILLER_101_1410 VDD VDD VSS VSS gf180mcu_as_sc_mcu7t3v3__fillcap_4
XFILLER_192_274 VDD VDD VSS VSS gf180mcu_as_sc_mcu7t3v3__fillcap_16
XFILLER_109_4 VDD VDD VSS VSS gf180mcu_as_sc_mcu7t3v3__fill_1
XFILLER_165_68 VDD VDD VSS VSS gf180mcu_as_sc_mcu7t3v3__fill_2
XFILLER_49_1558 VDD VDD VSS VSS gf180mcu_as_sc_mcu7t3v3__fillcap_8
XTAP_TAPCELL_ROW_8_911 VDD VSS gf180mcu_as_sc_mcu7t3v3__tap_2
XTAP_TAPCELL_ROW_8_900 VDD VSS gf180mcu_as_sc_mcu7t3v3__tap_2
XFILLER_171_1408 VDD VDD VSS VSS gf180mcu_as_sc_mcu7t3v3__fillcap_8
XTAP_TAPCELL_ROW_117_3_3071 VDD VSS gf180mcu_as_sc_mcu7t3v3__tap_2
XFILLER_181_34 VDD VDD VSS VSS gf180mcu_as_sc_mcu7t3v3__fillcap_16
XFILLER_114_50 VDD VDD VSS VSS gf180mcu_as_sc_mcu7t3v3__fillcap_16
XFILLER_208_629 VDD VDD VSS VSS gf180mcu_as_sc_mcu7t3v3__fillcap_16
XFILLER_59_185 VDD VDD VSS VSS gf180mcu_as_sc_mcu7t3v3__fillcap_16
XFILLER_74_100 VDD VDD VSS VSS gf180mcu_as_sc_mcu7t3v3__fillcap_4
XFILLER_169_1348 VDD VDD VSS VSS gf180mcu_as_sc_mcu7t3v3__fillcap_8
XFILLER_95_1501 VDD VDD VSS VSS gf180mcu_as_sc_mcu7t3v3__fillcap_8
XFILLER_15_200 VDD VDD VSS VSS gf180mcu_as_sc_mcu7t3v3__fill_2
XFILLER_1_1538 VDD VDD VSS VSS gf180mcu_as_sc_mcu7t3v3__fill_2
XFILLER_21_1488 VDD VDD VSS VSS gf180mcu_as_sc_mcu7t3v3__fillcap_16
XFILLER_28_561 VDD VDD VSS VSS gf180mcu_as_sc_mcu7t3v3__fill_1
XFILLER_74_177 VDD VDD VSS VSS gf180mcu_as_sc_mcu7t3v3__fillcap_4
XFILLER_182_1515 VDD VDD VSS VSS gf180mcu_as_sc_mcu7t3v3__fill_2
XPHY_EDGE_ROW_109_3_Right_146 VDD VSS gf180mcu_as_sc_mcu7t3v3__tap_2
XFILLER_130_71 VDD VDD VSS VSS gf180mcu_as_sc_mcu7t3v3__fill_2
XFILLER_15_277 VDD VDD VSS VSS gf180mcu_as_sc_mcu7t3v3__fill_2
XFILLER_12_940 VDD VDD VSS VSS gf180mcu_as_sc_mcu7t3v3__fillcap_4
XFILLER_175_208 VDD VDD VSS VSS gf180mcu_as_sc_mcu7t3v3__fill_2
XFILLER_15_1226 VDD VDD VSS VSS gf180mcu_as_sc_mcu7t3v3__fillcap_4
XFILLER_30_247 VDD VDD VSS VSS gf180mcu_as_sc_mcu7t3v3__fillcap_4
XFILLER_128_146 VDD VDD VSS VSS gf180mcu_as_sc_mcu7t3v3__fill_1
XFILLER_15_1259 VDD VDD VSS VSS gf180mcu_as_sc_mcu7t3v3__fill_1
XFILLER_184_731 VDD VDD VSS VSS gf180mcu_as_sc_mcu7t3v3__fillcap_4
XFILLER_184_753 VDD VDD VSS VSS gf180mcu_as_sc_mcu7t3v3__fillcap_16
XFILLER_196_591 VDD VDD VSS VSS gf180mcu_as_sc_mcu7t3v3__fillcap_4
XFILLER_23_91 VDD VDD VSS VSS gf180mcu_as_sc_mcu7t3v3__fillcap_16
XFILLER_7_410 VDD VDD VSS VSS gf180mcu_as_sc_mcu7t3v3__fill_2
XFILLER_8_933 VDD VDD VSS VSS gf180mcu_as_sc_mcu7t3v3__fillcap_8
XTAP_TAPCELL_ROW_20_1173 VDD VSS gf180mcu_as_sc_mcu7t3v3__tap_2
XTAP_TAPCELL_ROW_20_1162 VDD VSS gf180mcu_as_sc_mcu7t3v3__tap_2
X_3280_ VDD VDD VSS VSS _3280_/D _3553_/A _3280_/B _3814_/A _3526_/C gf180mcu_as_sc_mcu7t3v3__ao31_2
XFILLER_2_170 VDD VDD VSS VSS gf180mcu_as_sc_mcu7t3v3__fillcap_4
XFILLER_117_1472 VDD VDD VSS VSS gf180mcu_as_sc_mcu7t3v3__fillcap_4
XFILLER_0_1015 VDD VDD VSS VSS gf180mcu_as_sc_mcu7t3v3__fill_1
XFILLER_0_40 VDD VDD VSS VSS gf180mcu_as_sc_mcu7t3v3__fill_2
XFILLER_65_199 VDD VDD VSS VSS gf180mcu_as_sc_mcu7t3v3__fillcap_8
XFILLER_0_1037 VDD VDD VSS VSS gf180mcu_as_sc_mcu7t3v3__fillcap_4
XTAP_TAPCELL_ROW_143_3_3150 VDD VSS gf180mcu_as_sc_mcu7t3v3__tap_2
XFILLER_181_1014 VDD VDD VSS VSS gf180mcu_as_sc_mcu7t3v3__fillcap_16
XTAP_TAPCELL_ROW_27_1327 VDD VSS gf180mcu_as_sc_mcu7t3v3__tap_2
XTAP_TAPCELL_ROW_27_1316 VDD VSS gf180mcu_as_sc_mcu7t3v3__tap_2
XFILLER_21_225 VDD VDD VSS VSS gf180mcu_as_sc_mcu7t3v3__fillcap_8
XFILLER_22_737 VDD VDD VSS VSS gf180mcu_as_sc_mcu7t3v3__fillcap_16
XFILLER_34_597 VDD VDD VSS VSS gf180mcu_as_sc_mcu7t3v3__fillcap_16
X_4803_ VDD VDD VSS VSS _4869_/CLK _4803_/D _4803_/Q gf180mcu_as_sc_mcu7t3v3__dfxtp_2
XFILLER_203_890 VDD VDD VSS VSS gf180mcu_as_sc_mcu7t3v3__fillcap_16
XFILLER_210_849 VDD VDD VSS VSS gf180mcu_as_sc_mcu7t3v3__fill_1
XFILLER_21_247 VDD VDD VSS VSS gf180mcu_as_sc_mcu7t3v3__fill_1
X_4734_ VDD VDD VSS VSS _4735_/B _4734_/B _4748_/A gf180mcu_as_sc_mcu7t3v3__nand2_2
X_2995_ VDD VDD VSS VSS _3078_/B _4920_/Q _2996_/D gf180mcu_as_sc_mcu7t3v3__or2_2
XFILLER_30_781 VDD VDD VSS VSS gf180mcu_as_sc_mcu7t3v3__fillcap_4
XFILLER_72_1397 VDD VDD VSS VSS gf180mcu_as_sc_mcu7t3v3__fill_1
XTAP_TAPCELL_ROW_190_2350 VDD VSS gf180mcu_as_sc_mcu7t3v3__tap_2
XFILLER_119_179 VDD VDD VSS VSS gf180mcu_as_sc_mcu7t3v3__fillcap_8
X_4665_ VDD VDD VSS VSS _4686_/A _4685_/C gf180mcu_as_sc_mcu7t3v3__inv_2
XTAP_TAPCELL_ROW_190_2361 VDD VSS gf180mcu_as_sc_mcu7t3v3__tap_2
XFILLER_134_127 VDD VDD VSS VSS gf180mcu_as_sc_mcu7t3v3__fill_1
XFILLER_174_274 VDD VDD VSS VSS gf180mcu_as_sc_mcu7t3v3__fillcap_8
X_4596_ VDD VDD VSS VSS _5190_/Q _4750_/D _4604_/C _5191_/Q _5190_/D gf180mcu_as_sc_mcu7t3v3__ao22_2
X_3616_ VDD VDD VSS VSS _4845_/D _3616_/C _3652_/D _3616_/A gf180mcu_as_sc_mcu7t3v3__aoi21_2
XFILLER_1_608 VDD VDD VSS VSS gf180mcu_as_sc_mcu7t3v3__fillcap_8
X_3547_ VDD VDD VSS VSS _3786_/A _3798_/A _3562_/A gf180mcu_as_sc_mcu7t3v3__and2_2
XFILLER_135_27 VDD VDD VSS VSS gf180mcu_as_sc_mcu7t3v3__fillcap_16
XFILLER_27_1108 VDD VDD VSS VSS gf180mcu_as_sc_mcu7t3v3__fill_1
X_3478_ VDD VDD VSS VSS _4137_/A _3501_/B _3503_/B _4138_/D _3480_/C gf180mcu_as_sc_mcu7t3v3__ao22_2
XFILLER_131_1414 VDD VDD VSS VSS gf180mcu_as_sc_mcu7t3v3__fill_2
XFILLER_44_1433 VDD VDD VSS VSS gf180mcu_as_sc_mcu7t3v3__fillcap_4
XFILLER_83_1482 VDD VDD VSS VSS gf180mcu_as_sc_mcu7t3v3__fillcap_4
X_5217_ VDD VDD VSS VSS _5220_/CLK _5217_/D _5217_/Q gf180mcu_as_sc_mcu7t3v3__dfxtp_2
X_2429_ VDD VDD VSS VSS _3616_/A _3986_/A gf180mcu_as_sc_mcu7t3v3__inv_2
XFILLER_44_1477 VDD VDD VSS VSS gf180mcu_as_sc_mcu7t3v3__fill_2
X_5148_ VDD VDD VSS VSS _5216_/CLK _5148_/D _5148_/Q gf180mcu_as_sc_mcu7t3v3__dfxtp_2
XTAP_TAPCELL_ROW_87_3_2981 VDD VSS gf180mcu_as_sc_mcu7t3v3__tap_2
XFILLER_29_347 VDD VDD VSS VSS gf180mcu_as_sc_mcu7t3v3__fill_2
XFILLER_56_155 VDD VDD VSS VSS gf180mcu_as_sc_mcu7t3v3__fillcap_4
X_5079_ VDD VDD VSS VSS _5085_/CLK _5079_/D _5079_/Q gf180mcu_as_sc_mcu7t3v3__dfxtp_2
XFILLER_56_177 VDD VDD VSS VSS gf180mcu_as_sc_mcu7t3v3__fill_2
XTAP_TAPCELL_ROW_197_2504 VDD VSS gf180mcu_as_sc_mcu7t3v3__tap_2
XFILLER_198_823 VDD VDD VSS VSS gf180mcu_as_sc_mcu7t3v3__fillcap_16
XFILLER_71_158 VDD VDD VSS VSS gf180mcu_as_sc_mcu7t3v3__fillcap_4
XTAP_TAPCELL_ROW_197_2515 VDD VSS gf180mcu_as_sc_mcu7t3v3__tap_2
XTAP_TAPCELL_ROW_0_696 VDD VSS gf180mcu_as_sc_mcu7t3v3__tap_2
Xsram2048.u_bank1_924 VDD VDD VSS VSS sram2048.u_bank1/WEN[6] gf180mcu_as_sc_mcu7t3v3__tiel_4
XFILLER_12_247 VDD VDD VSS VSS gf180mcu_as_sc_mcu7t3v3__fillcap_16
XFILLER_185_517 VDD VDD VSS VSS gf180mcu_as_sc_mcu7t3v3__fillcap_16
XFILLER_200_337 VDD VDD VSS VSS gf180mcu_as_sc_mcu7t3v3__fill_2
XFILLER_51_1426 VDD VDD VSS VSS gf180mcu_as_sc_mcu7t3v3__fill_2
XFILLER_90_1453 VDD VDD VSS VSS gf180mcu_as_sc_mcu7t3v3__fillcap_16
XFILLER_176_34 VDD VDD VSS VSS gf180mcu_as_sc_mcu7t3v3__fill_1
XFILLER_14_1292 VDD VDD VSS VSS gf180mcu_as_sc_mcu7t3v3__fill_2
XFILLER_193_594 VDD VDD VSS VSS gf180mcu_as_sc_mcu7t3v3__fillcap_16
XFILLER_5_18 VDD VDD VSS VSS gf180mcu_as_sc_mcu7t3v3__fillcap_16
XFILLER_109_72 VDD VDD VSS VSS gf180mcu_as_sc_mcu7t3v3__fillcap_16
XFILLER_4_457 VDD VDD VSS VSS gf180mcu_as_sc_mcu7t3v3__fill_1
XPHY_EDGE_ROW_141_3_Left_526 VDD VSS gf180mcu_as_sc_mcu7t3v3__tap_2
XFILLER_192_22 VDD VDD VSS VSS gf180mcu_as_sc_mcu7t3v3__fillcap_8
XFILLER_69_65 VDD VDD VSS VSS gf180mcu_as_sc_mcu7t3v3__fillcap_4
XFILLER_0_652 VDD VDD VSS VSS gf180mcu_as_sc_mcu7t3v3__fill_2
XTAP_TAPCELL_ROW_136_1_1853 VDD VSS gf180mcu_as_sc_mcu7t3v3__tap_2
XTAP_TAPCELL_ROW_148_3_3165 VDD VSS gf180mcu_as_sc_mcu7t3v3__tap_2
XFILLER_23_1539 VDD VDD VSS VSS gf180mcu_as_sc_mcu7t3v3__fill_1
XFILLER_36_818 VDD VDD VSS VSS gf180mcu_as_sc_mcu7t3v3__fillcap_4
XFILLER_21_1274 VDD VDD VSS VSS gf180mcu_as_sc_mcu7t3v3__fill_2
XFILLER_62_147 VDD VDD VSS VSS gf180mcu_as_sc_mcu7t3v3__fillcap_4
XFILLER_203_120 VDD VDD VSS VSS gf180mcu_as_sc_mcu7t3v3__fillcap_16
XFILLER_16_597 VDD VDD VSS VSS gf180mcu_as_sc_mcu7t3v3__fillcap_4
XFILLER_182_1345 VDD VDD VSS VSS gf180mcu_as_sc_mcu7t3v3__fillcap_16
XFILLER_182_1367 VDD VDD VSS VSS gf180mcu_as_sc_mcu7t3v3__fill_1
XFILLER_188_333 VDD VDD VSS VSS gf180mcu_as_sc_mcu7t3v3__fill_2
XFILLER_203_142 VDD VDD VSS VSS gf180mcu_as_sc_mcu7t3v3__fillcap_16
XFILLER_206_1017 VDD VDD VSS VSS gf180mcu_as_sc_mcu7t3v3__fillcap_16
XFILLER_56_1348 VDD VDD VSS VSS gf180mcu_as_sc_mcu7t3v3__fillcap_16
XFILLER_108_1449 VDD VDD VSS VSS gf180mcu_as_sc_mcu7t3v3__fill_2
XFILLER_148_219 VDD VDD VSS VSS gf180mcu_as_sc_mcu7t3v3__fill_2
XFILLER_176_517 VDD VDD VSS VSS gf180mcu_as_sc_mcu7t3v3__fill_1
XFILLER_31_578 VDD VDD VSS VSS gf180mcu_as_sc_mcu7t3v3__fillcap_4
XFILLER_70_191 VDD VDD VSS VSS gf180mcu_as_sc_mcu7t3v3__fill_2
XFILLER_15_1034 VDD VDD VSS VSS gf180mcu_as_sc_mcu7t3v3__fillcap_4
XFILLER_19_1192 VDD VDD VSS VSS gf180mcu_as_sc_mcu7t3v3__fillcap_16
XFILLER_200_860 VDD VDD VSS VSS gf180mcu_as_sc_mcu7t3v3__fillcap_8
X_2780_ VDD VDD VSS VSS _2781_/D _2780_/B _2883_/B gf180mcu_as_sc_mcu7t3v3__nor2_2
XTAP_TAPCELL_ROW_22_1224 VDD VSS gf180mcu_as_sc_mcu7t3v3__tap_2
XTAP_TAPCELL_ROW_22_1213 VDD VSS gf180mcu_as_sc_mcu7t3v3__tap_2
XPHY_EDGE_ROW_73_3_Left_458 VDD VSS gf180mcu_as_sc_mcu7t3v3__tap_2
XTAP_TAPCELL_ROW_10_960 VDD VSS gf180mcu_as_sc_mcu7t3v3__tap_2
X_4450_ VDD VDD VSS VSS _4451_/D _4450_/B _4521_/A gf180mcu_as_sc_mcu7t3v3__nor2_2
XFILLER_109_190 VDD VDD VSS VSS gf180mcu_as_sc_mcu7t3v3__fillcap_4
XFILLER_116_138 VDD VDD VSS VSS gf180mcu_as_sc_mcu7t3v3__fillcap_16
XFILLER_158_1550 VDD VDD VSS VSS gf180mcu_as_sc_mcu7t3v3__fillcap_16
X_4381_ VDD VDD VSS VSS _4385_/B _5065_/Q _4456_/S gf180mcu_as_sc_mcu7t3v3__nand2_2
X_3401_ VDD VDD VSS VSS _3401_/B _4055_/A _3404_/C gf180mcu_as_sc_mcu7t3v3__and2_2
XFILLER_131_108 VDD VDD VSS VSS gf180mcu_as_sc_mcu7t3v3__fillcap_16
X_3332_ VDD VDD VSS VSS _3452_/S _3984_/D _3332_/A _3334_/B gf180mcu_as_sc_mcu7t3v3__mux2_2
XFILLER_124_193 VDD VDD VSS VSS gf180mcu_as_sc_mcu7t3v3__fillcap_4
XFILLER_67_1488 VDD VDD VSS VSS gf180mcu_as_sc_mcu7t3v3__fillcap_16
Xfanout709 VDD VDD VSS VSS _3501_/C _3479_/C gf180mcu_as_sc_mcu7t3v3__buff_12
X_3263_ VDD VDD VSS VSS _3263_/B _3263_/A _3275_/A gf180mcu_as_sc_mcu7t3v3__and2_2
X_5002_ VDD VDD VSS VSS _5090_/CLK _5002_/D _5002_/Q gf180mcu_as_sc_mcu7t3v3__dfxtp_2
X_3194_ VDD VDD VSS VSS _3194_/S _3194_/B _4164_/A _3195_/B gf180mcu_as_sc_mcu7t3v3__mux2_2
XFILLER_6_1268 VDD VDD VSS VSS gf180mcu_as_sc_mcu7t3v3__fillcap_4
XFILLER_187_1256 VDD VDD VSS VSS gf180mcu_as_sc_mcu7t3v3__fillcap_4
XFILLER_26_306 VDD VDD VSS VSS gf180mcu_as_sc_mcu7t3v3__fillcap_8
XFILLER_26_317 VDD VDD VSS VSS gf180mcu_as_sc_mcu7t3v3__fillcap_8
XFILLER_38_166 VDD VDD VSS VSS gf180mcu_as_sc_mcu7t3v3__fillcap_8
XFILLER_38_177 VDD VDD VSS VSS gf180mcu_as_sc_mcu7t3v3__fillcap_16
XFILLER_121_18 VDD VDD VSS VSS gf180mcu_as_sc_mcu7t3v3__fillcap_16
XFILLER_187_1278 VDD VDD VSS VSS gf180mcu_as_sc_mcu7t3v3__fillcap_16
XFILLER_207_470 VDD VDD VSS VSS gf180mcu_as_sc_mcu7t3v3__fillcap_16
XFILLER_53_136 VDD VDD VSS VSS gf180mcu_as_sc_mcu7t3v3__fillcap_4
XFILLER_165_1532 VDD VDD VSS VSS gf180mcu_as_sc_mcu7t3v3__fillcap_16
XFILLER_179_322 VDD VDD VSS VSS gf180mcu_as_sc_mcu7t3v3__fillcap_16
XFILLER_207_492 VDD VDD VSS VSS gf180mcu_as_sc_mcu7t3v3__fillcap_16
XFILLER_35_873 VDD VDD VSS VSS gf180mcu_as_sc_mcu7t3v3__fillcap_16
XFILLER_74_1415 VDD VDD VSS VSS gf180mcu_as_sc_mcu7t3v3__fillcap_8
XTAP_TAPCELL_ROW_162_1_1932 VDD VSS gf180mcu_as_sc_mcu7t3v3__tap_2
XFILLER_126_1505 VDD VDD VSS VSS gf180mcu_as_sc_mcu7t3v3__fill_2
XFILLER_161_1418 VDD VDD VSS VSS gf180mcu_as_sc_mcu7t3v3__fillcap_16
XFILLER_195_804 VDD VDD VSS VSS gf180mcu_as_sc_mcu7t3v3__fillcap_16
XFILLER_39_1568 VDD VDD VSS VSS gf180mcu_as_sc_mcu7t3v3__fill_1
XTAP_TAPCELL_ROW_192_2401 VDD VSS gf180mcu_as_sc_mcu7t3v3__tap_2
XFILLER_210_635 VDD VDD VSS VSS gf180mcu_as_sc_mcu7t3v3__fillcap_4
XFILLER_61_191 VDD VDD VSS VSS gf180mcu_as_sc_mcu7t3v3__fill_2
XFILLER_10_729 VDD VDD VSS VSS gf180mcu_as_sc_mcu7t3v3__fillcap_4
XFILLER_202_1415 VDD VDD VSS VSS gf180mcu_as_sc_mcu7t3v3__fillcap_16
XFILLER_210_679 VDD VDD VSS VSS gf180mcu_as_sc_mcu7t3v3__fill_1
XFILLER_33_1134 VDD VDD VSS VSS gf180mcu_as_sc_mcu7t3v3__fillcap_4
X_2978_ VDD VDD VSS VSS _3078_/B _4918_/Q _2979_/D gf180mcu_as_sc_mcu7t3v3__or2_2
XFILLER_202_1437 VDD VDD VSS VSS gf180mcu_as_sc_mcu7t3v3__fillcap_16
X_4717_ VDD VDD VSS VSS _4717_/S _5261_/Q _5251_/Q _4718_/B gf180mcu_as_sc_mcu7t3v3__mux2_2
XFILLER_107_127 VDD VDD VSS VSS gf180mcu_as_sc_mcu7t3v3__fillcap_8
XFILLER_11_1432 VDD VDD VSS VSS gf180mcu_as_sc_mcu7t3v3__fillcap_8
XFILLER_194_1205 VDD VDD VSS VSS gf180mcu_as_sc_mcu7t3v3__fillcap_16
XFILLER_30_37 VDD VDD VSS VSS gf180mcu_as_sc_mcu7t3v3__fillcap_16
XFILLER_33_1189 VDD VDD VSS VSS gf180mcu_as_sc_mcu7t3v3__fill_1
X_4648_ VDD VDD VSS VSS _4649_/C _5234_/Q _5235_/Q _5235_/D gf180mcu_as_sc_mcu7t3v3__mux2_2
XFILLER_146_37 VDD VDD VSS VSS gf180mcu_as_sc_mcu7t3v3__fillcap_4
XFILLER_194_1227 VDD VDD VSS VSS gf180mcu_as_sc_mcu7t3v3__fillcap_16
XFILLER_50_1492 VDD VDD VSS VSS gf180mcu_as_sc_mcu7t3v3__fill_1
XFILLER_190_575 VDD VDD VSS VSS gf180mcu_as_sc_mcu7t3v3__fillcap_16
XFILLER_190_597 VDD VDD VSS VSS gf180mcu_as_sc_mcu7t3v3__fillcap_16
XFILLER_1_416 VDD VDD VSS VSS gf180mcu_as_sc_mcu7t3v3__fillcap_4
XFILLER_2_928 VDD VDD VSS VSS gf180mcu_as_sc_mcu7t3v3__fillcap_16
XFILLER_85_1566 VDD VDD VSS VSS gf180mcu_as_sc_mcu7t3v3__fill_2
X_4579_ VDD VDD VSS VSS _4579_/S _5029_/Q _5058_/Q _4580_/B gf180mcu_as_sc_mcu7t3v3__mux2_2
XFILLER_130_141 VDD VDD VSS VSS gf180mcu_as_sc_mcu7t3v3__fill_1
XFILLER_190_6 VDD VDD VSS VSS gf180mcu_as_sc_mcu7t3v3__fillcap_16
XFILLER_76_217 VDD VDD VSS VSS gf180mcu_as_sc_mcu7t3v3__fillcap_4
XFILLER_29_133 VDD VDD VSS VSS gf180mcu_as_sc_mcu7t3v3__fillcap_4
XFILLER_79_1348 VDD VDD VSS VSS gf180mcu_as_sc_mcu7t3v3__fillcap_4
XFILLER_111_51 VDD VDD VSS VSS gf180mcu_as_sc_mcu7t3v3__fill_2
XFILLER_111_62 VDD VDD VSS VSS gf180mcu_as_sc_mcu7t3v3__fill_1
XFILLER_207_1326 VDD VDD VSS VSS gf180mcu_as_sc_mcu7t3v3__fillcap_4
XFILLER_187_22 VDD VDD VSS VSS gf180mcu_as_sc_mcu7t3v3__fillcap_16
XFILLER_197_174 VDD VDD VSS VSS gf180mcu_as_sc_mcu7t3v3__fillcap_16
XFILLER_200_101 VDD VDD VSS VSS gf180mcu_as_sc_mcu7t3v3__fillcap_4
XFILLER_207_1348 VDD VDD VSS VSS gf180mcu_as_sc_mcu7t3v3__fillcap_16
XFILLER_13_589 VDD VDD VSS VSS gf180mcu_as_sc_mcu7t3v3__fillcap_4
XFILLER_199_1116 VDD VDD VSS VSS gf180mcu_as_sc_mcu7t3v3__fillcap_4
XFILLER_200_123 VDD VDD VSS VSS gf180mcu_as_sc_mcu7t3v3__fillcap_16
XFILLER_71_66 VDD VDD VSS VSS gf180mcu_as_sc_mcu7t3v3__fillcap_4
XFILLER_187_88 VDD VDD VSS VSS gf180mcu_as_sc_mcu7t3v3__fillcap_16
XFILLER_199_1138 VDD VDD VSS VSS gf180mcu_as_sc_mcu7t3v3__fillcap_16
XTAP_TAPCELL_ROW_81_1_1687 VDD VSS gf180mcu_as_sc_mcu7t3v3__tap_2
XFILLER_177_1436 VDD VDD VSS VSS gf180mcu_as_sc_mcu7t3v3__fillcap_16
XFILLER_181_553 VDD VDD VSS VSS gf180mcu_as_sc_mcu7t3v3__fillcap_4
XFILLER_5_744 VDD VDD VSS VSS gf180mcu_as_sc_mcu7t3v3__fill_1
XFILLER_4_265 VDD VDD VSS VSS gf180mcu_as_sc_mcu7t3v3__fill_2
XFILLER_206_18 VDD VDD VSS VSS gf180mcu_as_sc_mcu7t3v3__fillcap_16
XFILLER_1_972 VDD VDD VSS VSS gf180mcu_as_sc_mcu7t3v3__fillcap_8
XFILLER_209_702 VDD VDD VSS VSS gf180mcu_as_sc_mcu7t3v3__fillcap_16
XFILLER_96_96 VDD VDD VSS VSS gf180mcu_as_sc_mcu7t3v3__fillcap_8
XTAP_TAPCELL_ROW_15_1050 VDD VSS gf180mcu_as_sc_mcu7t3v3__tap_2
XTAP_TAPCELL_ROW_167_1_1947 VDD VSS gf180mcu_as_sc_mcu7t3v3__tap_2
XFILLER_114_1453 VDD VDD VSS VSS gf180mcu_as_sc_mcu7t3v3__fillcap_16
XFILLER_3_1408 VDD VDD VSS VSS gf180mcu_as_sc_mcu7t3v3__fill_1
XTAP_TAPCELL_ROW_15_1061 VDD VSS gf180mcu_as_sc_mcu7t3v3__tap_2
Xmesh_tile VDD VDD VSS VSS ne_out[0] gf180mcu_as_sc_mcu7t3v3__tiel_4
XFILLER_149_1505 VDD VDD VSS VSS gf180mcu_as_sc_mcu7t3v3__fillcap_4
XFILLER_152_91 VDD VDD VSS VSS gf180mcu_as_sc_mcu7t3v3__fillcap_8
XFILLER_23_1358 VDD VDD VSS VSS gf180mcu_as_sc_mcu7t3v3__fillcap_8
XFILLER_36_626 VDD VDD VSS VSS gf180mcu_as_sc_mcu7t3v3__fill_2
XFILLER_97_1415 VDD VDD VSS VSS gf180mcu_as_sc_mcu7t3v3__fill_1
XFILLER_36_648 VDD VDD VSS VSS gf180mcu_as_sc_mcu7t3v3__fillcap_16
XTAP_TAPCELL_ROW_52_1_1601 VDD VSS gf180mcu_as_sc_mcu7t3v3__tap_2
X_3950_ VDD VDD VSS VSS _3950_/A _4023_/B _4023_/C _4917_/Q _3951_/D gf180mcu_as_sc_mcu7t3v3__ao22_2
XFILLER_16_383 VDD VDD VSS VSS gf180mcu_as_sc_mcu7t3v3__fill_2
XFILLER_189_664 VDD VDD VSS VSS gf180mcu_as_sc_mcu7t3v3__fillcap_16
XFILLER_1_1187 VDD VDD VSS VSS gf180mcu_as_sc_mcu7t3v3__fill_2
XFILLER_204_451 VDD VDD VSS VSS gf180mcu_as_sc_mcu7t3v3__fillcap_4
X_2901_ VDD VDD VSS VSS _3199_/B _3247_/B _3249_/B gf180mcu_as_sc_mcu7t3v3__nand2b_2
XFILLER_204_473 VDD VDD VSS VSS gf180mcu_as_sc_mcu7t3v3__fillcap_16
XFILLER_43_180 VDD VDD VSS VSS gf180mcu_as_sc_mcu7t3v3__fillcap_4
X_3881_ VDD VDD VSS VSS _3890_/B _5171_/Q _4921_/D gf180mcu_as_sc_mcu7t3v3__and2_2
XTAP_TAPCELL_ROW_62_3_2907 VDD VSS gf180mcu_as_sc_mcu7t3v3__tap_2
X_2832_ VDD VDD VSS VSS _2832_/S _2832_/B _2832_/A _2832_/Y gf180mcu_as_sc_mcu7t3v3__mux2_2
XFILLER_192_807 VDD VDD VSS VSS gf180mcu_as_sc_mcu7t3v3__fillcap_16
X_2763_ VDD VDD VSS VSS _2764_/B _2810_/A _2771_/B gf180mcu_as_sc_mcu7t3v3__xnor2_2
X_4502_ VDD VDD VSS VSS _4502_/D _4502_/A _4502_/B _4502_/C _4503_/B gf180mcu_as_sc_mcu7t3v3__ao31_2
XFILLER_195_1536 VDD VDD VSS VSS gf180mcu_as_sc_mcu7t3v3__fillcap_4
X_5482_ VDD VDD VSS VSS _5482_/A _5482_/Y gf180mcu_as_sc_mcu7t3v3__buff_2
X_2694_ VDD VDD VSS VSS _4959_/Q _2732_/S _2695_/D gf180mcu_as_sc_mcu7t3v3__and2_2
X_4433_ VDD VDD VSS VSS _5170_/Q _4504_/B _4433_/C _4433_/D _5170_/D gf180mcu_as_sc_mcu7t3v3__ao211_2
XFILLER_158_1380 VDD VDD VSS VSS gf180mcu_as_sc_mcu7t3v3__fill_1
X_4364_ VDD VDD VSS VSS _4365_/B _4364_/A _4364_/B _4370_/A gf180mcu_as_sc_mcu7t3v3__ao21_2
XFILLER_8_1319 VDD VDD VSS VSS gf180mcu_as_sc_mcu7t3v3__fill_1
Xfanout517 VDD VDD VSS VSS _4227_/B _4228_/B gf180mcu_as_sc_mcu7t3v3__buff_12
Xfanout528 VDD VDD VSS VSS _3803_/B _3775_/B gf180mcu_as_sc_mcu7t3v3__buff_12
Xfanout539 VDD VDD VSS VSS _3477_/B _3416_/B gf180mcu_as_sc_mcu7t3v3__buff_12
X_4295_ VDD VDD VSS VSS _4328_/B _4295_/B _4329_/A gf180mcu_as_sc_mcu7t3v3__nor2_2
X_3315_ VDD VDD VSS VSS _3965_/D _3404_/B _3315_/C _3315_/D _3316_/A gf180mcu_as_sc_mcu7t3v3__ao22_2
XFILLER_41_1403 VDD VDD VSS VSS gf180mcu_as_sc_mcu7t3v3__fill_2
X_3246_ VDD VDD VSS VSS _3510_/D _3247_/B _3542_/A gf180mcu_as_sc_mcu7t3v3__nor2_2
Xmesh_tile_954 VDD VDD VSS VSS ne_out[29] gf180mcu_as_sc_mcu7t3v3__tiel_4
Xmesh_tile_943 VDD VDD VSS VSS ne_out[18] gf180mcu_as_sc_mcu7t3v3__tiel_4
Xmesh_tile_932 VDD VDD VSS VSS ne_out[7] gf180mcu_as_sc_mcu7t3v3__tiel_4
XTAP_TAPCELL_ROW_181_2157 VDD VSS gf180mcu_as_sc_mcu7t3v3__tap_2
XTAP_TAPCELL_ROW_181_2146 VDD VSS gf180mcu_as_sc_mcu7t3v3__tap_2
XFILLER_27_626 VDD VDD VSS VSS gf180mcu_as_sc_mcu7t3v3__fillcap_4
XFILLER_6_1087 VDD VDD VSS VSS gf180mcu_as_sc_mcu7t3v3__fillcap_16
Xmesh_tile_987 VDD VDD VSS VSS north_out[28] gf180mcu_as_sc_mcu7t3v3__tiel_4
Xmesh_tile_976 VDD VDD VSS VSS north_out[17] gf180mcu_as_sc_mcu7t3v3__tiel_4
Xmesh_tile_965 VDD VDD VSS VSS north_out[6] gf180mcu_as_sc_mcu7t3v3__tiel_4
X_3177_ VDD VDD VSS VSS _4152_/A _3222_/D _3236_/C _4151_/D _3178_/C gf180mcu_as_sc_mcu7t3v3__ao22_2
XFILLER_199_417 VDD VDD VSS VSS gf180mcu_as_sc_mcu7t3v3__fill_2
XFILLER_26_136 VDD VDD VSS VSS gf180mcu_as_sc_mcu7t3v3__fillcap_16
XFILLER_27_648 VDD VDD VSS VSS gf180mcu_as_sc_mcu7t3v3__fillcap_16
XFILLER_81_220 VDD VDD VSS VSS gf180mcu_as_sc_mcu7t3v3__fill_2
Xmesh_tile_998 VDD VDD VSS VSS nw_out[5] gf180mcu_as_sc_mcu7t3v3__tiel_4
XTAP_TAPCELL_ROW_2_769 VDD VSS gf180mcu_as_sc_mcu7t3v3__tap_2
XFILLER_25_59 VDD VDD VSS VSS gf180mcu_as_sc_mcu7t3v3__fillcap_8
XFILLER_210_410 VDD VDD VSS VSS gf180mcu_as_sc_mcu7t3v3__fillcap_4
Xwire907 VDD VDD VSS VSS wire907/A _3965_/A gf180mcu_as_sc_mcu7t3v3__clkbuff_12
XFILLER_194_155 VDD VDD VSS VSS gf180mcu_as_sc_mcu7t3v3__fillcap_16
XFILLER_135_200 VDD VDD VSS VSS gf180mcu_as_sc_mcu7t3v3__fillcap_8
XFILLER_182_317 VDD VDD VSS VSS gf180mcu_as_sc_mcu7t3v3__fill_2
XFILLER_194_177 VDD VDD VSS VSS gf180mcu_as_sc_mcu7t3v3__fillcap_8
XFILLER_11_1240 VDD VDD VSS VSS gf180mcu_as_sc_mcu7t3v3__fillcap_16
XFILLER_157_69 VDD VDD VSS VSS gf180mcu_as_sc_mcu7t3v3__fill_1
XFILLER_11_1262 VDD VDD VSS VSS gf180mcu_as_sc_mcu7t3v3__fillcap_16
XTAP_TAPCELL_ROW_57_1_1616 VDD VSS gf180mcu_as_sc_mcu7t3v3__tap_2
XFILLER_172_1399 VDD VDD VSS VSS gf180mcu_as_sc_mcu7t3v3__fillcap_16
XFILLER_181_2 VDD VDD VSS VSS gf180mcu_as_sc_mcu7t3v3__fillcap_16
XFILLER_66_66 VDD VDD VSS VSS gf180mcu_as_sc_mcu7t3v3__fill_2
XPHY_EDGE_ROW_59_1_Right_580 VDD VSS gf180mcu_as_sc_mcu7t3v3__tap_2
XFILLER_18_659 VDD VDD VSS VSS gf180mcu_as_sc_mcu7t3v3__fillcap_4
XFILLER_72_220 VDD VDD VSS VSS gf180mcu_as_sc_mcu7t3v3__fill_2
XPHY_EDGE_ROW_139_1_Left_349 VDD VSS gf180mcu_as_sc_mcu7t3v3__tap_2
XFILLER_18_1405 VDD VDD VSS VSS gf180mcu_as_sc_mcu7t3v3__fillcap_4
XFILLER_33_629 VDD VDD VSS VSS gf180mcu_as_sc_mcu7t3v3__fill_1
XFILLER_13_320 VDD VDD VSS VSS gf180mcu_as_sc_mcu7t3v3__fillcap_16
XFILLER_82_76 VDD VDD VSS VSS gf180mcu_as_sc_mcu7t3v3__fillcap_16
XFILLER_109_1566 VDD VDD VSS VSS gf180mcu_as_sc_mcu7t3v3__fill_2
XFILLER_201_432 VDD VDD VSS VSS gf180mcu_as_sc_mcu7t3v3__fillcap_16
XFILLER_16_1151 VDD VDD VSS VSS gf180mcu_as_sc_mcu7t3v3__fillcap_4
XFILLER_174_818 VDD VDD VSS VSS gf180mcu_as_sc_mcu7t3v3__fillcap_16
XFILLER_185_144 VDD VDD VSS VSS gf180mcu_as_sc_mcu7t3v3__fill_1
XFILLER_186_667 VDD VDD VSS VSS gf180mcu_as_sc_mcu7t3v3__fillcap_16
XFILLER_40_172 VDD VDD VSS VSS gf180mcu_as_sc_mcu7t3v3__fill_2
XFILLER_9_368 VDD VDD VSS VSS gf180mcu_as_sc_mcu7t3v3__fillcap_16
XFILLER_16_1173 VDD VDD VSS VSS gf180mcu_as_sc_mcu7t3v3__fill_2
XFILLER_177_1200 VDD VDD VSS VSS gf180mcu_as_sc_mcu7t3v3__fillcap_4
XFILLER_12_1037 VDD VDD VSS VSS gf180mcu_as_sc_mcu7t3v3__fill_2
XFILLER_31_80 VDD VDD VSS VSS gf180mcu_as_sc_mcu7t3v3__fillcap_4
XTAP_TAPCELL_ROW_17_1101 VDD VSS gf180mcu_as_sc_mcu7t3v3__tap_2
XFILLER_190_1433 VDD VDD VSS VSS gf180mcu_as_sc_mcu7t3v3__fill_2
XFILLER_64_1425 VDD VDD VSS VSS gf180mcu_as_sc_mcu7t3v3__fillcap_16
XPHY_EDGE_ROW_189_Left_399 VDD VSS gf180mcu_as_sc_mcu7t3v3__tap_2
XTAP_TAPCELL_ROW_17_1112 VDD VSS gf180mcu_as_sc_mcu7t3v3__tap_2
XTAP_TAPCELL_ROW_13_1009 VDD VSS gf180mcu_as_sc_mcu7t3v3__tap_2
X_3100_ VDD VDD VSS VSS _3143_/S _4077_/D _4080_/A _3103_/B gf180mcu_as_sc_mcu7t3v3__mux2_2
XFILLER_23_1122 VDD VDD VSS VSS gf180mcu_as_sc_mcu7t3v3__fillcap_8
X_4080_ VDD VDD VSS VSS _4080_/A _4130_/B _4128_/B _4080_/D _4081_/D gf180mcu_as_sc_mcu7t3v3__ao22_2
XTAP_TAPCELL_ROW_34_1481 VDD VSS gf180mcu_as_sc_mcu7t3v3__tap_2
XTAP_TAPCELL_ROW_34_1470 VDD VSS gf180mcu_as_sc_mcu7t3v3__tap_2
XFILLER_7_1374 VDD VDD VSS VSS gf180mcu_as_sc_mcu7t3v3__fill_1
XFILLER_7_1396 VDD VDD VSS VSS gf180mcu_as_sc_mcu7t3v3__fillcap_4
Xinput180 VDD VDD VSS VSS rst wire902/A gf180mcu_as_sc_mcu7t3v3__buff_12
X_3031_ VDD VDD VSS VSS _3615_/D _3115_/A _3031_/B _3031_/C _3032_/C gf180mcu_as_sc_mcu7t3v3__ao31_2
XFILLER_23_1188 VDD VDD VSS VSS gf180mcu_as_sc_mcu7t3v3__fill_2
XFILLER_63_220 VDD VDD VSS VSS gf180mcu_as_sc_mcu7t3v3__fill_2
Xinput191 VDD VDD VSS VSS se_in[19] _4089_/A gf180mcu_as_sc_mcu7t3v3__buff_12
XTAP_TAPCELL_ROW_30_1389 VDD VSS gf180mcu_as_sc_mcu7t3v3__tap_2
XFILLER_36_478 VDD VDD VSS VSS gf180mcu_as_sc_mcu7t3v3__fillcap_16
X_4982_ VDD VDD VSS VSS _5073_/CLK _4982_/D _4982_/Q gf180mcu_as_sc_mcu7t3v3__dfxtp_2
XTAP_TAPCELL_ROW_95_3_3007 VDD VSS gf180mcu_as_sc_mcu7t3v3__tap_2
XFILLER_177_601 VDD VDD VSS VSS gf180mcu_as_sc_mcu7t3v3__fill_1
XFILLER_71_1418 VDD VDD VSS VSS gf180mcu_as_sc_mcu7t3v3__fillcap_16
X_3933_ VDD VDD VSS VSS _3933_/A _4030_/C _4031_/B _3933_/D _3934_/D gf180mcu_as_sc_mcu7t3v3__ao22_2
XFILLER_162_1568 VDD VDD VSS VSS gf180mcu_as_sc_mcu7t3v3__fill_1
X_3864_ VDD VDD VSS VSS _5141_/Q _5142_/Q _3864_/C _3868_/A gf180mcu_as_sc_mcu7t3v3__nor3_2
XFILLER_20_868 VDD VDD VSS VSS gf180mcu_as_sc_mcu7t3v3__fillcap_4
XFILLER_32_695 VDD VDD VSS VSS gf180mcu_as_sc_mcu7t3v3__fill_2
X_2815_ VDD VDD VSS VSS _5480_/A _2815_/A _2826_/B gf180mcu_as_sc_mcu7t3v3__and2_2
XFILLER_176_177 VDD VDD VSS VSS gf180mcu_as_sc_mcu7t3v3__fillcap_16
X_3795_ VDD VDD VSS VSS _3795_/B _3795_/A _4868_/D gf180mcu_as_sc_mcu7t3v3__and2_2
XFILLER_191_136 VDD VDD VSS VSS gf180mcu_as_sc_mcu7t3v3__fillcap_4
XFILLER_191_158 VDD VDD VSS VSS gf180mcu_as_sc_mcu7t3v3__fillcap_4
X_2746_ VDD VDD VSS VSS _4626_/B _2746_/B _2838_/B gf180mcu_as_sc_mcu7t3v3__nor2_2
XFILLER_127_39 VDD VDD VSS VSS gf180mcu_as_sc_mcu7t3v3__fill_2
X_2677_ VDD VDD VSS VSS _2731_/S _5099_/Q _2677_/Y gf180mcu_as_sc_mcu7t3v3__and2_2
XFILLER_191_1208 VDD VDD VSS VSS gf180mcu_as_sc_mcu7t3v3__fillcap_16
X_4416_ VDD VDD VSS VSS _5168_/Q _4504_/B _4416_/C _4416_/D _5168_/D gf180mcu_as_sc_mcu7t3v3__ao211_2
XFILLER_207_50 VDD VDD VSS VSS gf180mcu_as_sc_mcu7t3v3__fillcap_16
XFILLER_207_72 VDD VDD VSS VSS gf180mcu_as_sc_mcu7t3v3__fillcap_16
XFILLER_28_1011 VDD VDD VSS VSS gf180mcu_as_sc_mcu7t3v3__fillcap_4
XTAP_TAPCELL_ROW_183_2208 VDD VSS gf180mcu_as_sc_mcu7t3v3__tap_2
XFILLER_100_100 VDD VDD VSS VSS gf180mcu_as_sc_mcu7t3v3__fillcap_4
XFILLER_143_27 VDD VDD VSS VSS gf180mcu_as_sc_mcu7t3v3__fillcap_16
X_4347_ VDD VDD VSS VSS _4538_/D _4350_/C _4554_/B gf180mcu_as_sc_mcu7t3v3__nand2b_2
XFILLER_100_122 VDD VDD VSS VSS gf180mcu_as_sc_mcu7t3v3__fill_1
X_4278_ VDD VDD VSS VSS _4281_/S _5482_/A _5112_/Q _5112_/D gf180mcu_as_sc_mcu7t3v3__mux2_2
XFILLER_210_1514 VDD VDD VSS VSS gf180mcu_as_sc_mcu7t3v3__fillcap_16
X_3229_ VDD VDD VSS VSS _3513_/A _3229_/B _3229_/C _3229_/D _3230_/A gf180mcu_as_sc_mcu7t3v3__ao22_2
XFILLER_132_1383 VDD VDD VSS VSS gf180mcu_as_sc_mcu7t3v3__fillcap_8
XFILLER_36_36 VDD VDD VSS VSS gf180mcu_as_sc_mcu7t3v3__fillcap_8
XFILLER_54_220 VDD VDD VSS VSS gf180mcu_as_sc_mcu7t3v3__fill_2
XFILLER_28_979 VDD VDD VSS VSS gf180mcu_as_sc_mcu7t3v3__fillcap_16
XTAP_TAPCELL_ROW_206_2694 VDD VSS gf180mcu_as_sc_mcu7t3v3__tap_2
XFILLER_15_629 VDD VDD VSS VSS gf180mcu_as_sc_mcu7t3v3__fill_1
XFILLER_27_489 VDD VDD VSS VSS gf180mcu_as_sc_mcu7t3v3__fill_1
XTAP_TAPCELL_ROW_130_1_1834 VDD VSS gf180mcu_as_sc_mcu7t3v3__tap_2
XTAP_TAPCELL_ROW_142_3_3146 VDD VSS gf180mcu_as_sc_mcu7t3v3__tap_2
XFILLER_14_139 VDD VDD VSS VSS gf180mcu_as_sc_mcu7t3v3__fillcap_16
XPHY_EDGE_ROW_150_3_Left_535 VDD VSS gf180mcu_as_sc_mcu7t3v3__tap_2
XFILLER_204_1329 VDD VDD VSS VSS gf180mcu_as_sc_mcu7t3v3__fillcap_16
XFILLER_210_240 VDD VDD VSS VSS gf180mcu_as_sc_mcu7t3v3__fillcap_4
XFILLER_13_1324 VDD VDD VSS VSS gf180mcu_as_sc_mcu7t3v3__fillcap_4
XFILLER_167_188 VDD VDD VSS VSS gf180mcu_as_sc_mcu7t3v3__fill_1
XFILLER_195_486 VDD VDD VSS VSS gf180mcu_as_sc_mcu7t3v3__fillcap_4
XFILLER_196_1119 VDD VDD VSS VSS gf180mcu_as_sc_mcu7t3v3__fillcap_16
XFILLER_87_1414 VDD VDD VSS VSS gf180mcu_as_sc_mcu7t3v3__fill_2
XTAP_TAPCELL_ROW_110_1_1776 VDD VSS gf180mcu_as_sc_mcu7t3v3__tap_2
XTAP_TAPCELL_ROW_122_3_3088 VDD VSS gf180mcu_as_sc_mcu7t3v3__tap_2
XFILLER_139_1504 VDD VDD VSS VSS gf180mcu_as_sc_mcu7t3v3__fill_2
XFILLER_13_1379 VDD VDD VSS VSS gf180mcu_as_sc_mcu7t3v3__fill_1
XFILLER_184_34 VDD VDD VSS VSS gf180mcu_as_sc_mcu7t3v3__fill_1
XFILLER_174_1417 VDD VDD VSS VSS gf180mcu_as_sc_mcu7t3v3__fill_1
XFILLER_117_72 VDD VDD VSS VSS gf180mcu_as_sc_mcu7t3v3__fillcap_16
XFILLER_7_2 VDD VDD VSS VSS gf180mcu_as_sc_mcu7t3v3__fillcap_16
XFILLER_24_1431 VDD VDD VSS VSS gf180mcu_as_sc_mcu7t3v3__fillcap_4
XTAP_TAPCELL_ROW_6_872 VDD VSS gf180mcu_as_sc_mcu7t3v3__tap_2
XTAP_TAPCELL_ROW_6_861 VDD VSS gf180mcu_as_sc_mcu7t3v3__tap_2
XFILLER_150_1450 VDD VDD VSS VSS gf180mcu_as_sc_mcu7t3v3__fill_1
XFILLER_24_1453 VDD VDD VSS VSS gf180mcu_as_sc_mcu7t3v3__fillcap_4
Xfanout892 VDD VDD VSS VSS _3714_/D _3691_/D gf180mcu_as_sc_mcu7t3v3__buff_12
XFILLER_45_220 VDD VDD VSS VSS gf180mcu_as_sc_mcu7t3v3__fill_2
XFILLER_98_1543 VDD VDD VSS VSS gf180mcu_as_sc_mcu7t3v3__fill_1
XFILLER_33_426 VDD VDD VSS VSS gf180mcu_as_sc_mcu7t3v3__fill_2
XPHY_EDGE_ROW_82_3_Left_467 VDD VSS gf180mcu_as_sc_mcu7t3v3__tap_2
XFILLER_18_1202 VDD VDD VSS VSS gf180mcu_as_sc_mcu7t3v3__fillcap_16
XFILLER_183_1270 VDD VDD VSS VSS gf180mcu_as_sc_mcu7t3v3__fillcap_4
XFILLER_18_1224 VDD VDD VSS VSS gf180mcu_as_sc_mcu7t3v3__fill_1
XFILLER_186_464 VDD VDD VSS VSS gf180mcu_as_sc_mcu7t3v3__fillcap_16
XFILLER_187_976 VDD VDD VSS VSS gf180mcu_as_sc_mcu7t3v3__fillcap_4
XFILLER_202_785 VDD VDD VSS VSS gf180mcu_as_sc_mcu7t3v3__fillcap_16
XFILLER_158_177 VDD VDD VSS VSS gf180mcu_as_sc_mcu7t3v3__fillcap_16
XFILLER_173_114 VDD VDD VSS VSS gf180mcu_as_sc_mcu7t3v3__fill_1
XFILLER_187_998 VDD VDD VSS VSS gf180mcu_as_sc_mcu7t3v3__fillcap_16
XFILLER_31_1402 VDD VDD VSS VSS gf180mcu_as_sc_mcu7t3v3__fillcap_16
X_3580_ VDD VDD VSS VSS _3944_/A _3608_/B _3580_/C _3580_/Y _3594_/D gf180mcu_as_sc_mcu7t3v3__aoi211_2
X_2600_ VDD VDD VSS VSS _4765_/Q _4764_/Q _2601_/C gf180mcu_as_sc_mcu7t3v3__xnor2_2
XFILLER_177_1030 VDD VDD VSS VSS gf180mcu_as_sc_mcu7t3v3__fillcap_16
XFILLER_177_1052 VDD VDD VSS VSS gf180mcu_as_sc_mcu7t3v3__fillcap_16
X_2531_ VDD VDD VSS VSS _4371_/B _2802_/A _2747_/A gf180mcu_as_sc_mcu7t3v3__nand2_2
XFILLER_182_692 VDD VDD VSS VSS gf180mcu_as_sc_mcu7t3v3__fillcap_4
XPHY_EDGE_ROW_197_Left_407 VDD VSS gf180mcu_as_sc_mcu7t3v3__tap_2
X_5250_ VDD VDD VSS VSS _5256_/CLK _5250_/D _5250_/Q gf180mcu_as_sc_mcu7t3v3__dfxtp_2
XFILLER_68_1380 VDD VDD VSS VSS gf180mcu_as_sc_mcu7t3v3__fill_1
X_4201_ VDD VDD VSS VSS _4230_/B _4224_/B _4224_/C _5037_/Q _5037_/D gf180mcu_as_sc_mcu7t3v3__ao22_2
X_2462_ VDD VDD VSS VSS _4546_/A _2462_/B _2462_/A _4350_/D gf180mcu_as_sc_mcu7t3v3__mux2_2
XTAP_TAPCELL_ROW_36_1532 VDD VSS gf180mcu_as_sc_mcu7t3v3__tap_2
XTAP_TAPCELL_ROW_36_1521 VDD VSS gf180mcu_as_sc_mcu7t3v3__tap_2
XFILLER_155_1383 VDD VDD VSS VSS gf180mcu_as_sc_mcu7t3v3__fill_2
X_5181_ VDD VDD VSS VSS clkload8/A _5181_/D _5181_/Q gf180mcu_as_sc_mcu7t3v3__dfxtp_2
X_2393_ VDD VDD VSS VSS _2882_/A _4763_/Q gf180mcu_as_sc_mcu7t3v3__inv_2
XTAP_TAPCELL_ROW_36_1554 VDD VSS gf180mcu_as_sc_mcu7t3v3__tap_2
XTAP_TAPCELL_ROW_36_1543 VDD VSS gf180mcu_as_sc_mcu7t3v3__tap_2
XFILLER_42_1520 VDD VDD VSS VSS gf180mcu_as_sc_mcu7t3v3__fill_1
XFILLER_9_1469 VDD VDD VSS VSS gf180mcu_as_sc_mcu7t3v3__fill_1
XTAP_TAPCELL_ROW_135_1_1849 VDD VSS gf180mcu_as_sc_mcu7t3v3__tap_2
X_4132_ VDD VDD VSS VSS _4132_/A _4136_/C _4132_/C _4132_/D _4133_/B gf180mcu_as_sc_mcu7t3v3__ao22_2
XTAP_TAPCELL_ROW_4_809 VDD VSS gf180mcu_as_sc_mcu7t3v3__tap_2
XTAP_TAPCELL_ROW_32_1429 VDD VSS gf180mcu_as_sc_mcu7t3v3__tap_2
XFILLER_3_1002 VDD VDD VSS VSS gf180mcu_as_sc_mcu7t3v3__fillcap_16
XFILLER_95_142 VDD VDD VSS VSS gf180mcu_as_sc_mcu7t3v3__fill_2
X_4063_ VDD VDD VSS VSS _4063_/A _4130_/B _4063_/C _4063_/D _4065_/C gf180mcu_as_sc_mcu7t3v3__ao211_2
XTAP_TAPCELL_ROW_37_3_2833 VDD VSS gf180mcu_as_sc_mcu7t3v3__tap_2
XFILLER_42_1564 VDD VDD VSS VSS gf180mcu_as_sc_mcu7t3v3__fillcap_4
X_3014_ VDD VDD VSS VSS _3115_/A _3014_/B _3994_/A _3014_/Y gf180mcu_as_sc_mcu7t3v3__mux2_2
XFILLER_3_1068 VDD VDD VSS VSS gf180mcu_as_sc_mcu7t3v3__fillcap_16
XFILLER_51_212 VDD VDD VSS VSS gf180mcu_as_sc_mcu7t3v3__fillcap_8
XFILLER_197_718 VDD VDD VSS VSS gf180mcu_as_sc_mcu7t3v3__fillcap_8
XFILLER_36_1302 VDD VDD VSS VSS gf180mcu_as_sc_mcu7t3v3__fill_2
X_4965_ VDD VDD VSS VSS _5276_/CLK _4965_/D _4965_/Q gf180mcu_as_sc_mcu7t3v3__dfxtp_2
XFILLER_127_1441 VDD VDD VSS VSS gf180mcu_as_sc_mcu7t3v3__fillcap_16
X_3916_ VDD VDD VSS VSS _3924_/C _3931_/B gf180mcu_as_sc_mcu7t3v3__inv_2
XTAP_TAPCELL_ROW_201_2591 VDD VSS gf180mcu_as_sc_mcu7t3v3__tap_2
XTAP_TAPCELL_ROW_176_2045 VDD VSS gf180mcu_as_sc_mcu7t3v3__tap_2
XTAP_TAPCELL_ROW_176_2034 VDD VSS gf180mcu_as_sc_mcu7t3v3__tap_2
XFILLER_127_1485 VDD VDD VSS VSS gf180mcu_as_sc_mcu7t3v3__fill_1
X_4896_ VDD VDD VSS VSS _4904_/CLK _4896_/D _4896_/Q gf180mcu_as_sc_mcu7t3v3__dfxtp_2
XFILLER_22_27 VDD VDD VSS VSS gf180mcu_as_sc_mcu7t3v3__fillcap_8
X_3847_ VDD VDD VSS VSS _3847_/S _3847_/B _3847_/A _3848_/B gf180mcu_as_sc_mcu7t3v3__mux2_2
XTAP_TAPCELL_ROW_82_1_1692 VDD VSS gf180mcu_as_sc_mcu7t3v3__tap_2
X_3778_ VDD VDD VSS VSS _3778_/B _4159_/D _3779_/D gf180mcu_as_sc_mcu7t3v3__and2_2
XFILLER_180_629 VDD VDD VSS VSS gf180mcu_as_sc_mcu7t3v3__fillcap_8
X_2729_ VDD VDD VSS VSS _2730_/D _2729_/C _2736_/B _2729_/A gf180mcu_as_sc_mcu7t3v3__aoi21b_2
XTAP_TAPCELL_ROW_210_2805 VDD VSS gf180mcu_as_sc_mcu7t3v3__tap_2
XTAP_TAPCELL_ROW_92_3_2998 VDD VSS gf180mcu_as_sc_mcu7t3v3__tap_2
XTAP_TAPCELL_ROW_210_2827 VDD VSS gf180mcu_as_sc_mcu7t3v3__tap_2
XTAP_TAPCELL_ROW_210_2816 VDD VSS gf180mcu_as_sc_mcu7t3v3__tap_2
XFILLER_154_37 VDD VDD VSS VSS gf180mcu_as_sc_mcu7t3v3__fillcap_16
XFILLER_47_1442 VDD VDD VSS VSS gf180mcu_as_sc_mcu7t3v3__fill_1
Xoutput451 VDD VDD VSS VSS _4904_/Q west_out[31] gf180mcu_as_sc_mcu7t3v3__buff_12
Xoutput440 VDD VDD VSS VSS _4894_/Q west_out[21] gf180mcu_as_sc_mcu7t3v3__buff_12
XFILLER_120_217 VDD VDD VSS VSS gf180mcu_as_sc_mcu7t3v3__fillcap_4
XFILLER_173_1450 VDD VDD VSS VSS gf180mcu_as_sc_mcu7t3v3__fillcap_4
XFILLER_134_1467 VDD VDD VSS VSS gf180mcu_as_sc_mcu7t3v3__fill_1
XFILLER_210_1300 VDD VDD VSS VSS gf180mcu_as_sc_mcu7t3v3__fill_1
XTAP_TAPCELL_ROW_208_2756 VDD VSS gf180mcu_as_sc_mcu7t3v3__tap_2
XTAP_TAPCELL_ROW_208_2745 VDD VSS gf180mcu_as_sc_mcu7t3v3__tap_2
XFILLER_47_68 VDD VDD VSS VSS gf180mcu_as_sc_mcu7t3v3__fill_2
XPHY_EDGE_ROW_29_Right_29 VDD VSS gf180mcu_as_sc_mcu7t3v3__tap_2
XFILLER_16_916 VDD VDD VSS VSS gf180mcu_as_sc_mcu7t3v3__fillcap_16
XFILLER_170_69 VDD VDD VSS VSS gf180mcu_as_sc_mcu7t3v3__fillcap_16
XFILLER_210_1355 VDD VDD VSS VSS gf180mcu_as_sc_mcu7t3v3__fillcap_4
XFILLER_210_1366 VDD VDD VSS VSS gf180mcu_as_sc_mcu7t3v3__fillcap_4
XFILLER_27_220 VDD VDD VSS VSS gf180mcu_as_sc_mcu7t3v3__fill_2
XFILLER_187_206 VDD VDD VSS VSS gf180mcu_as_sc_mcu7t3v3__fillcap_4
XFILLER_19_1522 VDD VDD VSS VSS gf180mcu_as_sc_mcu7t3v3__fill_2
XFILLER_31_908 VDD VDD VSS VSS gf180mcu_as_sc_mcu7t3v3__fill_2
XFILLER_63_56 VDD VDD VSS VSS gf180mcu_as_sc_mcu7t3v3__fill_2
XTAP_TAPCELL_ROW_161_1_1928 VDD VSS gf180mcu_as_sc_mcu7t3v3__tap_2
XFILLER_144_2 VDD VDD VSS VSS gf180mcu_as_sc_mcu7t3v3__fillcap_16
XFILLER_106_1514 VDD VDD VSS VSS gf180mcu_as_sc_mcu7t3v3__fillcap_4
XFILLER_11_632 VDD VDD VSS VSS gf180mcu_as_sc_mcu7t3v3__fillcap_4
XFILLER_23_492 VDD VDD VSS VSS gf180mcu_as_sc_mcu7t3v3__fillcap_16
XFILLER_8_18 VDD VDD VSS VSS gf180mcu_as_sc_mcu7t3v3__fillcap_16
Xwire501 VDD VDD VSS VSS _3023_/Y _4779_/D gf180mcu_as_sc_mcu7t3v3__clkbuff_12
XFILLER_184_979 VDD VDD VSS VSS gf180mcu_as_sc_mcu7t3v3__fillcap_16
XFILLER_195_22 VDD VDD VSS VSS gf180mcu_as_sc_mcu7t3v3__fillcap_16
XFILLER_183_489 VDD VDD VSS VSS gf180mcu_as_sc_mcu7t3v3__fill_1
XFILLER_195_88 VDD VDD VSS VSS gf180mcu_as_sc_mcu7t3v3__fillcap_16
XFILLER_128_93 VDD VDD VSS VSS gf180mcu_as_sc_mcu7t3v3__fillcap_8
XFILLER_178_1394 VDD VDD VSS VSS gf180mcu_as_sc_mcu7t3v3__fillcap_16
XFILLER_3_842 VDD VDD VSS VSS gf180mcu_as_sc_mcu7t3v3__fillcap_8
XFILLER_88_53 VDD VDD VSS VSS gf180mcu_as_sc_mcu7t3v3__fillcap_8
XFILLER_26_1504 VDD VDD VSS VSS gf180mcu_as_sc_mcu7t3v3__fill_1
XFILLER_3_875 VDD VDD VSS VSS gf180mcu_as_sc_mcu7t3v3__fillcap_16
XFILLER_3_897 VDD VDD VSS VSS gf180mcu_as_sc_mcu7t3v3__fill_1
XFILLER_152_1523 VDD VDD VSS VSS gf180mcu_as_sc_mcu7t3v3__fillcap_16
XFILLER_77_120 VDD VDD VSS VSS gf180mcu_as_sc_mcu7t3v3__fillcap_4
XFILLER_77_142 VDD VDD VSS VSS gf180mcu_as_sc_mcu7t3v3__fillcap_16
XFILLER_77_197 VDD VDD VSS VSS gf180mcu_as_sc_mcu7t3v3__fill_2
XFILLER_185_1310 VDD VDD VSS VSS gf180mcu_as_sc_mcu7t3v3__fillcap_16
XFILLER_185_1332 VDD VDD VSS VSS gf180mcu_as_sc_mcu7t3v3__fillcap_16
XFILLER_19_787 VDD VDD VSS VSS gf180mcu_as_sc_mcu7t3v3__fillcap_4
XFILLER_33_212 VDD VDD VSS VSS gf180mcu_as_sc_mcu7t3v3__fillcap_16
XFILLER_98_1373 VDD VDD VSS VSS gf180mcu_as_sc_mcu7t3v3__fillcap_8
X_4879__1088 VDD VDD VSS VSS _4879_/D gf180mcu_as_sc_mcu7t3v3__tiel_4
XFILLER_206_365 VDD VDD VSS VSS gf180mcu_as_sc_mcu7t3v3__fillcap_16
XFILLER_206_387 VDD VDD VSS VSS gf180mcu_as_sc_mcu7t3v3__fillcap_16
XFILLER_209_1048 VDD VDD VSS VSS gf180mcu_as_sc_mcu7t3v3__fill_2
XFILLER_15_982 VDD VDD VSS VSS gf180mcu_as_sc_mcu7t3v3__fillcap_16
XFILLER_178_228 VDD VDD VSS VSS gf180mcu_as_sc_mcu7t3v3__fill_2
XFILLER_18_1065 VDD VDD VSS VSS gf180mcu_as_sc_mcu7t3v3__fillcap_8
XFILLER_193_209 VDD VDD VSS VSS gf180mcu_as_sc_mcu7t3v3__fill_1
XFILLER_72_1535 VDD VDD VSS VSS gf180mcu_as_sc_mcu7t3v3__fillcap_4
XFILLER_72_1568 VDD VDD VSS VSS gf180mcu_as_sc_mcu7t3v3__fill_1
X_4750_ VDD VDD VSS VSS _5278_/D _4750_/A _4750_/B _4750_/C _4750_/D gf180mcu_as_sc_mcu7t3v3__aoi22_2
XFILLER_174_401 VDD VDD VSS VSS gf180mcu_as_sc_mcu7t3v3__fillcap_4
X_4681_ VDD VDD VSS VSS _5248_/Q _4685_/C _4681_/C _5249_/Q _4682_/C gf180mcu_as_sc_mcu7t3v3__ao22_2
X_3701_ VDD VDD VSS VSS _3702_/C _4077_/D _3751_/B _3701_/C gf180mcu_as_sc_mcu7t3v3__ao21_2
XTAP_TAPCELL_ROW_25_1288 VDD VSS gf180mcu_as_sc_mcu7t3v3__tap_2
XTAP_TAPCELL_ROW_25_1277 VDD VSS gf180mcu_as_sc_mcu7t3v3__tap_2
X_3632_ VDD VDD VSS VSS _4006_/D _3724_/B _3724_/C _4005_/A _3633_/C gf180mcu_as_sc_mcu7t3v3__ao22_2
XFILLER_146_169 VDD VDD VSS VSS gf180mcu_as_sc_mcu7t3v3__fillcap_4
XFILLER_161_139 VDD VDD VSS VSS gf180mcu_as_sc_mcu7t3v3__fill_1
XFILLER_183_990 VDD VDD VSS VSS gf180mcu_as_sc_mcu7t3v3__fillcap_4
X_3563_ VDD VDD VSS VSS _3563_/Y _3563_/B _3563_/A gf180mcu_as_sc_mcu7t3v3__nor2_2
X_3494_ VDD VDD VSS VSS _4153_/A _3501_/C _3503_/B _4151_/D _3495_/D gf180mcu_as_sc_mcu7t3v3__ao22_2
X_2514_ VDD VDD VSS VSS _4663_/A _5240_/Q _4703_/D gf180mcu_as_sc_mcu7t3v3__and2_2
X_5233_ VDD VDD VSS VSS _5233_/CLK _5233_/D _5233_/Q gf180mcu_as_sc_mcu7t3v3__dfxtp_2
X_2445_ VDD VDD VSS VSS _4124_/A _2445_/A gf180mcu_as_sc_mcu7t3v3__inv_2
XFILLER_25_1025 VDD VDD VSS VSS gf180mcu_as_sc_mcu7t3v3__fillcap_16
XFILLER_9_1255 VDD VDD VSS VSS gf180mcu_as_sc_mcu7t3v3__fillcap_4
X_5164_ VDD VDD VSS VSS _5260_/CLK _5164_/D _5164_/Q gf180mcu_as_sc_mcu7t3v3__dfxtp_2
XFILLER_5_1119 VDD VDD VSS VSS gf180mcu_as_sc_mcu7t3v3__fill_1
X_4115_ VDD VDD VSS VSS _4115_/A _4115_/B _4115_/C _4115_/D _4116_/B gf180mcu_as_sc_mcu7t3v3__ao22_2
X_5095_ VDD VDD VSS VSS _5095_/CLK _5095_/D _5095_/Q gf180mcu_as_sc_mcu7t3v3__dfxtp_2
XFILLER_17_27 VDD VDD VSS VSS gf180mcu_as_sc_mcu7t3v3__fillcap_16
XFILLER_42_1383 VDD VDD VSS VSS gf180mcu_as_sc_mcu7t3v3__fillcap_16
X_4046_ VDD VDD VSS VSS _4046_/A _4101_/B _4103_/B _4046_/D _4047_/D gf180mcu_as_sc_mcu7t3v3__ao22_2
XFILLER_25_702 VDD VDD VSS VSS gf180mcu_as_sc_mcu7t3v3__fillcap_4
XFILLER_83_167 VDD VDD VSS VSS gf180mcu_as_sc_mcu7t3v3__fillcap_16
XTAP_TAPCELL_ROW_203_2642 VDD VSS gf180mcu_as_sc_mcu7t3v3__tap_2
XTAP_TAPCELL_ROW_203_2631 VDD VSS gf180mcu_as_sc_mcu7t3v3__tap_2
XFILLER_77_1468 VDD VDD VSS VSS gf180mcu_as_sc_mcu7t3v3__fillcap_16
XFILLER_12_407 VDD VDD VSS VSS gf180mcu_as_sc_mcu7t3v3__fill_1
XFILLER_205_1402 VDD VDD VSS VSS gf180mcu_as_sc_mcu7t3v3__fillcap_16
XFILLER_33_59 VDD VDD VSS VSS gf180mcu_as_sc_mcu7t3v3__fillcap_8
X_4948_ VDD VDD VSS VSS _5216_/CLK _4948_/D _4948_/Q gf180mcu_as_sc_mcu7t3v3__dfxtp_2
XTAP_TAPCELL_ROW_195_2465 VDD VSS gf180mcu_as_sc_mcu7t3v3__tap_2
XTAP_TAPCELL_ROW_195_2454 VDD VSS gf180mcu_as_sc_mcu7t3v3__tap_2
XFILLER_149_59 VDD VDD VSS VSS gf180mcu_as_sc_mcu7t3v3__fillcap_8
XFILLER_177_250 VDD VDD VSS VSS gf180mcu_as_sc_mcu7t3v3__fill_1
X_4879_ VDD VDD VSS VSS _4924_/CLK _4879_/D _4879_/Q gf180mcu_as_sc_mcu7t3v3__dfxtp_2
XFILLER_192_231 VDD VDD VSS VSS gf180mcu_as_sc_mcu7t3v3__fill_2
XFILLER_20_473 VDD VDD VSS VSS gf180mcu_as_sc_mcu7t3v3__fillcap_4
XFILLER_137_158 VDD VDD VSS VSS gf180mcu_as_sc_mcu7t3v3__fillcap_8
XFILLER_203_1170 VDD VDD VSS VSS gf180mcu_as_sc_mcu7t3v3__fillcap_16
XFILLER_203_1192 VDD VDD VSS VSS gf180mcu_as_sc_mcu7t3v3__fillcap_16
XFILLER_4_617 VDD VDD VSS VSS gf180mcu_as_sc_mcu7t3v3__fill_1
XFILLER_101_1455 VDD VDD VSS VSS gf180mcu_as_sc_mcu7t3v3__fill_1
XFILLER_10_1338 VDD VDD VSS VSS gf180mcu_as_sc_mcu7t3v3__fill_2
XFILLER_140_1493 VDD VDD VSS VSS gf180mcu_as_sc_mcu7t3v3__fill_2
XFILLER_152_139 VDD VDD VSS VSS gf180mcu_as_sc_mcu7t3v3__fillcap_16
XFILLER_49_1504 VDD VDD VSS VSS gf180mcu_as_sc_mcu7t3v3__fill_2
XPHY_EDGE_ROW_148_1_Left_358 VDD VSS gf180mcu_as_sc_mcu7t3v3__tap_2
XFILLER_101_1488 VDD VDD VSS VSS gf180mcu_as_sc_mcu7t3v3__fillcap_4
XTAP_TAPCELL_ROW_8_912 VDD VSS gf180mcu_as_sc_mcu7t3v3__tap_2
XTAP_TAPCELL_ROW_8_901 VDD VSS gf180mcu_as_sc_mcu7t3v3__tap_2
XFILLER_160_150 VDD VDD VSS VSS gf180mcu_as_sc_mcu7t3v3__fillcap_16
XFILLER_0_845 VDD VDD VSS VSS gf180mcu_as_sc_mcu7t3v3__fill_1
XTAP_TAPCELL_ROW_105_1_1760 VDD VSS gf180mcu_as_sc_mcu7t3v3__tap_2
XTAP_TAPCELL_ROW_117_3_3072 VDD VSS gf180mcu_as_sc_mcu7t3v3__tap_2
XFILLER_59_142 VDD VDD VSS VSS gf180mcu_as_sc_mcu7t3v3__fillcap_4
XFILLER_60_1450 VDD VDD VSS VSS gf180mcu_as_sc_mcu7t3v3__fill_1
XFILLER_21_1434 VDD VDD VSS VSS gf180mcu_as_sc_mcu7t3v3__fill_1
XFILLER_74_145 VDD VDD VSS VSS gf180mcu_as_sc_mcu7t3v3__fillcap_16
XFILLER_210_1185 VDD VDD VSS VSS gf180mcu_as_sc_mcu7t3v3__fillcap_4
XFILLER_210_1196 VDD VDD VSS VSS gf180mcu_as_sc_mcu7t3v3__fillcap_4
XFILLER_21_1467 VDD VDD VSS VSS gf180mcu_as_sc_mcu7t3v3__fill_2
XFILLER_95_1568 VDD VDD VSS VSS gf180mcu_as_sc_mcu7t3v3__fill_1
XFILLER_16_779 VDD VDD VSS VSS gf180mcu_as_sc_mcu7t3v3__fillcap_16
XFILLER_203_346 VDD VDD VSS VSS gf180mcu_as_sc_mcu7t3v3__fillcap_4
XFILLER_188_559 VDD VDD VSS VSS gf180mcu_as_sc_mcu7t3v3__fillcap_16
XFILLER_203_368 VDD VDD VSS VSS gf180mcu_as_sc_mcu7t3v3__fillcap_16
XFILLER_12_996 VDD VDD VSS VSS gf180mcu_as_sc_mcu7t3v3__fill_2
XFILLER_209_18 VDD VDD VSS VSS gf180mcu_as_sc_mcu7t3v3__fillcap_16
XFILLER_7_422 VDD VDD VSS VSS gf180mcu_as_sc_mcu7t3v3__fillcap_8
XFILLER_128_158 VDD VDD VSS VSS gf180mcu_as_sc_mcu7t3v3__fillcap_16
XTAP_TAPCELL_ROW_20_1174 VDD VSS gf180mcu_as_sc_mcu7t3v3__tap_2
XTAP_TAPCELL_ROW_20_1163 VDD VSS gf180mcu_as_sc_mcu7t3v3__tap_2
XFILLER_174_1022 VDD VDD VSS VSS gf180mcu_as_sc_mcu7t3v3__fillcap_4
XFILLER_99_85 VDD VDD VSS VSS gf180mcu_as_sc_mcu7t3v3__fillcap_16
XFILLER_97_204 VDD VDD VSS VSS gf180mcu_as_sc_mcu7t3v3__fillcap_4
XFILLER_152_1364 VDD VDD VSS VSS gf180mcu_as_sc_mcu7t3v3__fillcap_16
XFILLER_26_1356 VDD VDD VSS VSS gf180mcu_as_sc_mcu7t3v3__fillcap_8
XFILLER_26_1367 VDD VDD VSS VSS gf180mcu_as_sc_mcu7t3v3__fill_1
XFILLER_0_1005 VDD VDD VSS VSS gf180mcu_as_sc_mcu7t3v3__fillcap_4
XFILLER_80_104 VDD VDD VSS VSS gf180mcu_as_sc_mcu7t3v3__fill_1
XFILLER_0_74 VDD VDD VSS VSS gf180mcu_as_sc_mcu7t3v3__fill_2
XFILLER_207_696 VDD VDD VSS VSS gf180mcu_as_sc_mcu7t3v3__fillcap_4
XFILLER_34_543 VDD VDD VSS VSS gf180mcu_as_sc_mcu7t3v3__fill_2
XFILLER_80_148 VDD VDD VSS VSS gf180mcu_as_sc_mcu7t3v3__fill_2
XTAP_TAPCELL_ROW_143_3_3151 VDD VSS gf180mcu_as_sc_mcu7t3v3__tap_2
XTAP_TAPCELL_ROW_27_1328 VDD VSS gf180mcu_as_sc_mcu7t3v3__tap_2
XTAP_TAPCELL_ROW_27_1317 VDD VSS gf180mcu_as_sc_mcu7t3v3__tap_2
X_4802_ VDD VDD VSS VSS _5214_/CLK _4802_/D _4802_/Q gf180mcu_as_sc_mcu7t3v3__dfxtp_2
X_2994_ VDD VDD VSS VSS _3045_/A _2994_/B _2994_/C _3045_/D _2996_/C gf180mcu_as_sc_mcu7t3v3__ao211_2
XFILLER_124_1422 VDD VDD VSS VSS gf180mcu_as_sc_mcu7t3v3__fillcap_16
XFILLER_163_1482 VDD VDD VSS VSS gf180mcu_as_sc_mcu7t3v3__fillcap_4
XFILLER_21_259 VDD VDD VSS VSS gf180mcu_as_sc_mcu7t3v3__fillcap_16
XFILLER_9_72 VDD VDD VSS VSS gf180mcu_as_sc_mcu7t3v3__fillcap_16
X_4733_ VDD VDD VSS VSS _4733_/A _4733_/B _4733_/C _5268_/D _4742_/C gf180mcu_as_sc_mcu7t3v3__aoi211_2
XFILLER_119_125 VDD VDD VSS VSS gf180mcu_as_sc_mcu7t3v3__fill_2
XFILLER_174_231 VDD VDD VSS VSS gf180mcu_as_sc_mcu7t3v3__fillcap_4
XFILLER_198_1501 VDD VDD VSS VSS gf180mcu_as_sc_mcu7t3v3__fillcap_4
XFILLER_198_1523 VDD VDD VSS VSS gf180mcu_as_sc_mcu7t3v3__fillcap_16
X_4664_ VDD VDD VSS VSS _4674_/B _4666_/B _4683_/C gf180mcu_as_sc_mcu7t3v3__nor2_2
XTAP_TAPCELL_ROW_190_2362 VDD VSS gf180mcu_as_sc_mcu7t3v3__tap_2
XTAP_TAPCELL_ROW_190_2351 VDD VSS gf180mcu_as_sc_mcu7t3v3__tap_2
X_4595_ VDD VDD VSS VSS _5189_/Q _4750_/D _4604_/C _5190_/Q _5189_/D gf180mcu_as_sc_mcu7t3v3__ao22_2
X_3615_ VDD VDD VSS VSS _3615_/D _3730_/A _3615_/B _3615_/C _3616_/C gf180mcu_as_sc_mcu7t3v3__ao31_2
XFILLER_196_1291 VDD VDD VSS VSS gf180mcu_as_sc_mcu7t3v3__fillcap_4
X_3546_ VDD VDD VSS VSS _3797_/C _3563_/A _3786_/A gf180mcu_as_sc_mcu7t3v3__and2_2
XFILLER_0_108 VDD VDD VSS VSS gf180mcu_as_sc_mcu7t3v3__fill_2
XFILLER_142_172 VDD VDD VSS VSS gf180mcu_as_sc_mcu7t3v3__fill_2
XFILLER_83_1450 VDD VDD VSS VSS gf180mcu_as_sc_mcu7t3v3__fillcap_16
X_5216_ VDD VDD VSS VSS _5216_/CLK _5216_/D _5216_/Q gf180mcu_as_sc_mcu7t3v3__dfxtp_2
X_3477_ VDD VDD VSS VSS _3477_/A _3477_/B _3477_/C _4829_/D _4199_/A gf180mcu_as_sc_mcu7t3v3__aoi211_2
XFILLER_170_1453 VDD VDD VSS VSS gf180mcu_as_sc_mcu7t3v3__fillcap_8
X_2428_ VDD VDD VSS VSS _3608_/A _3978_/A gf180mcu_as_sc_mcu7t3v3__inv_2
XFILLER_28_37 VDD VDD VSS VSS gf180mcu_as_sc_mcu7t3v3__fillcap_16
XFILLER_56_101 VDD VDD VSS VSS gf180mcu_as_sc_mcu7t3v3__fillcap_4
X_5147_ VDD VDD VSS VSS _5220_/CLK _5147_/D _5147_/Q gf180mcu_as_sc_mcu7t3v3__dfxtp_2
XTAP_TAPCELL_ROW_87_3_2982 VDD VSS gf180mcu_as_sc_mcu7t3v3__tap_2
XFILLER_56_123 VDD VDD VSS VSS gf180mcu_as_sc_mcu7t3v3__fillcap_16
X_5078_ VDD VDD VSS VSS clkload4/A _5078_/D _5078_/Q gf180mcu_as_sc_mcu7t3v3__dfxtp_2
X_4029_ VDD VDD VSS VSS _4029_/A _4102_/B _4102_/C _4927_/Q _4031_/C gf180mcu_as_sc_mcu7t3v3__ao22_2
XTAP_TAPCELL_ROW_197_2505 VDD VSS gf180mcu_as_sc_mcu7t3v3__tap_2
XFILLER_198_802 VDD VDD VSS VSS gf180mcu_as_sc_mcu7t3v3__fill_2
XFILLER_71_137 VDD VDD VSS VSS gf180mcu_as_sc_mcu7t3v3__fill_2
XTAP_TAPCELL_ROW_197_2516 VDD VSS gf180mcu_as_sc_mcu7t3v3__tap_2
XFILLER_0_1561 VDD VDD VSS VSS gf180mcu_as_sc_mcu7t3v3__fill_2
XTAP_TAPCELL_ROW_0_697 VDD VSS gf180mcu_as_sc_mcu7t3v3__tap_2
XFILLER_44_69 VDD VDD VSS VSS gf180mcu_as_sc_mcu7t3v3__fill_2
Xsram2048.u_bank1_925 VDD VDD VSS VSS sram2048.u_bank1/WEN[7] gf180mcu_as_sc_mcu7t3v3__tiel_4
XFILLER_157_209 VDD VDD VSS VSS gf180mcu_as_sc_mcu7t3v3__fill_1
XFILLER_201_839 VDD VDD VSS VSS gf180mcu_as_sc_mcu7t3v3__fill_1
XFILLER_100_86 VDD VDD VSS VSS gf180mcu_as_sc_mcu7t3v3__fill_2
XFILLER_165_220 VDD VDD VSS VSS gf180mcu_as_sc_mcu7t3v3__fill_2
XTAP_TAPCELL_ROW_50_1_1594 VDD VSS gf180mcu_as_sc_mcu7t3v3__tap_2
XFILLER_103_1528 VDD VDD VSS VSS gf180mcu_as_sc_mcu7t3v3__fill_2
XFILLER_14_1260 VDD VDD VSS VSS gf180mcu_as_sc_mcu7t3v3__fillcap_4
XFILLER_181_702 VDD VDD VSS VSS gf180mcu_as_sc_mcu7t3v3__fillcap_4
XFILLER_193_540 VDD VDD VSS VSS gf180mcu_as_sc_mcu7t3v3__fillcap_16
XFILLER_193_562 VDD VDD VSS VSS gf180mcu_as_sc_mcu7t3v3__fillcap_16
XTAP_TAPCELL_ROW_156_1_1912 VDD VSS gf180mcu_as_sc_mcu7t3v3__tap_2
XTAP_TAPCELL_ROW_168_3_3224 VDD VSS gf180mcu_as_sc_mcu7t3v3__tap_2
XFILLER_10_1157 VDD VDD VSS VSS gf180mcu_as_sc_mcu7t3v3__fillcap_8
XFILLER_118_191 VDD VDD VSS VSS gf180mcu_as_sc_mcu7t3v3__fill_1
XFILLER_180_234 VDD VDD VSS VSS gf180mcu_as_sc_mcu7t3v3__fillcap_4
XFILLER_181_768 VDD VDD VSS VSS gf180mcu_as_sc_mcu7t3v3__fill_2
XFILLER_88_1372 VDD VDD VSS VSS gf180mcu_as_sc_mcu7t3v3__fill_2
XFILLER_88_1383 VDD VDD VSS VSS gf180mcu_as_sc_mcu7t3v3__fillcap_16
XFILLER_192_34 VDD VDD VSS VSS gf180mcu_as_sc_mcu7t3v3__fill_1
XPHY_EDGE_ROW_91_3_Left_476 VDD VSS gf180mcu_as_sc_mcu7t3v3__tap_2
XFILLER_0_620 VDD VDD VSS VSS gf180mcu_as_sc_mcu7t3v3__fill_1
XFILLER_136_1348 VDD VDD VSS VSS gf180mcu_as_sc_mcu7t3v3__fillcap_16
XFILLER_175_1375 VDD VDD VSS VSS gf180mcu_as_sc_mcu7t3v3__fillcap_8
XFILLER_49_1389 VDD VDD VSS VSS gf180mcu_as_sc_mcu7t3v3__fillcap_16
XFILLER_69_88 VDD VDD VSS VSS gf180mcu_as_sc_mcu7t3v3__fill_1
XFILLER_62_1523 VDD VDD VSS VSS gf180mcu_as_sc_mcu7t3v3__fillcap_8
XTAP_TAPCELL_ROW_136_1_1854 VDD VSS gf180mcu_as_sc_mcu7t3v3__tap_2
XTAP_TAPCELL_ROW_148_3_3166 VDD VSS gf180mcu_as_sc_mcu7t3v3__tap_2
XFILLER_125_72 VDD VDD VSS VSS gf180mcu_as_sc_mcu7t3v3__fill_2
XFILLER_62_1556 VDD VDD VSS VSS gf180mcu_as_sc_mcu7t3v3__fillcap_8
XFILLER_85_65 VDD VDD VSS VSS gf180mcu_as_sc_mcu7t3v3__fillcap_4
XFILLER_112_1370 VDD VDD VSS VSS gf180mcu_as_sc_mcu7t3v3__fill_1
XFILLER_47_167 VDD VDD VSS VSS gf180mcu_as_sc_mcu7t3v3__fill_2
XFILLER_62_104 VDD VDD VSS VSS gf180mcu_as_sc_mcu7t3v3__fill_1
XFILLER_16_543 VDD VDD VSS VSS gf180mcu_as_sc_mcu7t3v3__fillcap_4
XFILLER_18_81 VDD VDD VSS VSS gf180mcu_as_sc_mcu7t3v3__fill_1
XFILLER_62_115 VDD VDD VSS VSS gf180mcu_as_sc_mcu7t3v3__fillcap_4
XFILLER_147_1455 VDD VDD VSS VSS gf180mcu_as_sc_mcu7t3v3__fillcap_4
XFILLER_182_1313 VDD VDD VSS VSS gf180mcu_as_sc_mcu7t3v3__fillcap_16
XFILLER_188_312 VDD VDD VSS VSS gf180mcu_as_sc_mcu7t3v3__fill_2
XFILLER_95_1365 VDD VDD VSS VSS gf180mcu_as_sc_mcu7t3v3__fill_2
XFILLER_147_1488 VDD VDD VSS VSS gf180mcu_as_sc_mcu7t3v3__fill_2
XFILLER_204_699 VDD VDD VSS VSS gf180mcu_as_sc_mcu7t3v3__fillcap_16
XFILLER_156_220 VDD VDD VSS VSS gf180mcu_as_sc_mcu7t3v3__fill_2
XFILLER_180_1081 VDD VDD VSS VSS gf180mcu_as_sc_mcu7t3v3__fillcap_4
XFILLER_197_890 VDD VDD VSS VSS gf180mcu_as_sc_mcu7t3v3__fillcap_16
XTAP_TAPCELL_ROW_22_1225 VDD VSS gf180mcu_as_sc_mcu7t3v3__tap_2
XTAP_TAPCELL_ROW_22_1214 VDD VSS gf180mcu_as_sc_mcu7t3v3__tap_2
XFILLER_15_1079 VDD VDD VSS VSS gf180mcu_as_sc_mcu7t3v3__fill_2
XFILLER_200_872 VDD VDD VSS VSS gf180mcu_as_sc_mcu7t3v3__fill_2
XFILLER_171_212 VDD VDD VSS VSS gf180mcu_as_sc_mcu7t3v3__fillcap_8
XTAP_TAPCELL_ROW_10_950 VDD VSS gf180mcu_as_sc_mcu7t3v3__tap_2
XTAP_TAPCELL_ROW_10_961 VDD VSS gf180mcu_as_sc_mcu7t3v3__tap_2
XFILLER_50_90 VDD VDD VSS VSS gf180mcu_as_sc_mcu7t3v3__fillcap_8
X_4380_ VDD VDD VSS VSS _4380_/B _4380_/A _5164_/D gf180mcu_as_sc_mcu7t3v3__and2_2
X_3400_ VDD VDD VSS VSS _3400_/B _3525_/A _4819_/D gf180mcu_as_sc_mcu7t3v3__and2_2
XFILLER_154_1415 VDD VDD VSS VSS gf180mcu_as_sc_mcu7t3v3__fillcap_8
XFILLER_28_1407 VDD VDD VSS VSS gf180mcu_as_sc_mcu7t3v3__fill_2
Xclkbuf_leaf_11_clk_regs VDD VDD VSS VSS clkbuf_leaf_7_clk_regs/A _5198_/CLK gf180mcu_as_sc_mcu7t3v3__clkbuff_12
X_3331_ VDD VDD VSS VSS _3981_/A _3404_/B _3331_/C _3331_/D _3332_/A gf180mcu_as_sc_mcu7t3v3__ao22_2
XFILLER_119_1568 VDD VDD VSS VSS gf180mcu_as_sc_mcu7t3v3__fill_1
X_3262_ VDD VDD VSS VSS _3520_/B _3776_/A _3262_/Y gf180mcu_as_sc_mcu7t3v3__and2_2
XFILLER_38_101 VDD VDD VSS VSS gf180mcu_as_sc_mcu7t3v3__fillcap_4
XFILLER_6_1214 VDD VDD VSS VSS gf180mcu_as_sc_mcu7t3v3__fillcap_4
X_5001_ VDD VDD VSS VSS _5095_/CLK _5001_/D _5001_/Q gf180mcu_as_sc_mcu7t3v3__dfxtp_2
X_3193_ VDD VDD VSS VSS _4163_/A _3241_/B _3193_/C _3193_/D _3194_/B gf180mcu_as_sc_mcu7t3v3__ao22_2
XFILLER_22_1017 VDD VDD VSS VSS gf180mcu_as_sc_mcu7t3v3__fill_1
XFILLER_38_134 VDD VDD VSS VSS gf180mcu_as_sc_mcu7t3v3__fillcap_16
XFILLER_187_1224 VDD VDD VSS VSS gf180mcu_as_sc_mcu7t3v3__fillcap_16
XFILLER_53_104 VDD VDD VSS VSS gf180mcu_as_sc_mcu7t3v3__fillcap_16
XFILLER_165_1566 VDD VDD VSS VSS gf180mcu_as_sc_mcu7t3v3__fill_2
XFILLER_179_356 VDD VDD VSS VSS gf180mcu_as_sc_mcu7t3v3__fill_1
XFILLER_22_524 VDD VDD VSS VSS gf180mcu_as_sc_mcu7t3v3__fill_1
XFILLER_34_384 VDD VDD VSS VSS gf180mcu_as_sc_mcu7t3v3__fill_1
XFILLER_39_1558 VDD VDD VSS VSS gf180mcu_as_sc_mcu7t3v3__fillcap_8
XFILLER_126_1539 VDD VDD VSS VSS gf180mcu_as_sc_mcu7t3v3__fill_2
XFILLER_210_614 VDD VDD VSS VSS gf180mcu_as_sc_mcu7t3v3__fillcap_4
XFILLER_210_625 VDD VDD VSS VSS gf180mcu_as_sc_mcu7t3v3__fillcap_4
XFILLER_33_1102 VDD VDD VSS VSS gf180mcu_as_sc_mcu7t3v3__fillcap_4
XTAP_TAPCELL_ROW_192_2402 VDD VSS gf180mcu_as_sc_mcu7t3v3__tap_2
XFILLER_147_220 VDD VDD VSS VSS gf180mcu_as_sc_mcu7t3v3__fill_2
XFILLER_206_1563 VDD VDD VSS VSS gf180mcu_as_sc_mcu7t3v3__fillcap_4
XFILLER_210_669 VDD VDD VSS VSS gf180mcu_as_sc_mcu7t3v3__fill_2
X_2977_ VDD VDD VSS VSS _3045_/A _2977_/B _2977_/C _3045_/D _2979_/C gf180mcu_as_sc_mcu7t3v3__ao211_2
XFILLER_175_562 VDD VDD VSS VSS gf180mcu_as_sc_mcu7t3v3__fillcap_4
X_4716_ VDD VDD VSS VSS _4721_/A _4716_/B _5107_/Q _5260_/D gf180mcu_as_sc_mcu7t3v3__mux2_2
XFILLER_30_27 VDD VDD VSS VSS gf180mcu_as_sc_mcu7t3v3__fillcap_8
XFILLER_50_1471 VDD VDD VSS VSS gf180mcu_as_sc_mcu7t3v3__fill_1
X_4647_ VDD VDD VSS VSS _5234_/D _4647_/A _4660_/A _4647_/C gf180mcu_as_sc_mcu7t3v3__ao21_2
XFILLER_107_139 VDD VDD VSS VSS gf180mcu_as_sc_mcu7t3v3__fill_1
XFILLER_146_27 VDD VDD VSS VSS gf180mcu_as_sc_mcu7t3v3__fillcap_8
XFILLER_159_1348 VDD VDD VSS VSS gf180mcu_as_sc_mcu7t3v3__fillcap_16
XFILLER_190_543 VDD VDD VSS VSS gf180mcu_as_sc_mcu7t3v3__fillcap_16
XFILLER_200_1151 VDD VDD VSS VSS gf180mcu_as_sc_mcu7t3v3__fillcap_4
XFILLER_200_1173 VDD VDD VSS VSS gf180mcu_as_sc_mcu7t3v3__fillcap_16
XFILLER_46_1507 VDD VDD VSS VSS gf180mcu_as_sc_mcu7t3v3__fillcap_8
X_4578_ VDD VDD VSS VSS _4581_/C _5000_/Q _4579_/S gf180mcu_as_sc_mcu7t3v3__nand2b_2
XFILLER_115_194 VDD VDD VSS VSS gf180mcu_as_sc_mcu7t3v3__fillcap_16
X_3529_ VDD VDD VSS VSS _3557_/B _3922_/B _3559_/A gf180mcu_as_sc_mcu7t3v3__nand2_2
XFILLER_130_153 VDD VDD VSS VSS gf180mcu_as_sc_mcu7t3v3__fillcap_16
X_4874__1093 VDD VDD VSS VSS _4874_/D gf180mcu_as_sc_mcu7t3v3__tiel_4
XFILLER_162_37 VDD VDD VSS VSS gf180mcu_as_sc_mcu7t3v3__fillcap_16
XFILLER_162_59 VDD VDD VSS VSS gf180mcu_as_sc_mcu7t3v3__fill_1
XFILLER_29_101 VDD VDD VSS VSS gf180mcu_as_sc_mcu7t3v3__fillcap_16
XFILLER_39_69 VDD VDD VSS VSS gf180mcu_as_sc_mcu7t3v3__fill_1
XFILLER_183_6 VDD VDD VSS VSS gf180mcu_as_sc_mcu7t3v3__fillcap_16
XFILLER_206_909 VDD VDD VSS VSS gf180mcu_as_sc_mcu7t3v3__fillcap_16
XFILLER_22_1540 VDD VDD VSS VSS gf180mcu_as_sc_mcu7t3v3__fillcap_4
XFILLER_44_104 VDD VDD VSS VSS gf180mcu_as_sc_mcu7t3v3__fill_1
XFILLER_44_126 VDD VDD VSS VSS gf180mcu_as_sc_mcu7t3v3__fill_1
XFILLER_55_68 VDD VDD VSS VSS gf180mcu_as_sc_mcu7t3v3__fill_2
XFILLER_0_1391 VDD VDD VSS VSS gf180mcu_as_sc_mcu7t3v3__fill_2
XFILLER_197_120 VDD VDD VSS VSS gf180mcu_as_sc_mcu7t3v3__fillcap_16
XFILLER_111_85 VDD VDD VSS VSS gf180mcu_as_sc_mcu7t3v3__fillcap_16
XFILLER_13_557 VDD VDD VSS VSS gf180mcu_as_sc_mcu7t3v3__fill_2
XFILLER_16_1311 VDD VDD VSS VSS gf180mcu_as_sc_mcu7t3v3__fill_1
XFILLER_185_304 VDD VDD VSS VSS gf180mcu_as_sc_mcu7t3v3__fillcap_16
XFILLER_197_142 VDD VDD VSS VSS gf180mcu_as_sc_mcu7t3v3__fillcap_16
XFILLER_25_395 VDD VDD VSS VSS gf180mcu_as_sc_mcu7t3v3__fill_1
XFILLER_71_78 VDD VDD VSS VSS gf180mcu_as_sc_mcu7t3v3__fill_1
XFILLER_9_528 VDD VDD VSS VSS gf180mcu_as_sc_mcu7t3v3__fillcap_4
XFILLER_194_871 VDD VDD VSS VSS gf180mcu_as_sc_mcu7t3v3__fillcap_4
XFILLER_205_1084 VDD VDD VSS VSS gf180mcu_as_sc_mcu7t3v3__fillcap_16
XFILLER_21_590 VDD VDD VSS VSS gf180mcu_as_sc_mcu7t3v3__fillcap_16
XTAP_TAPCELL_ROW_81_1_1688 VDD VSS gf180mcu_as_sc_mcu7t3v3__tap_2
XFILLER_153_212 VDD VDD VSS VSS gf180mcu_as_sc_mcu7t3v3__fillcap_8
XFILLER_193_370 VDD VDD VSS VSS gf180mcu_as_sc_mcu7t3v3__fill_1
XFILLER_181_532 VDD VDD VSS VSS gf180mcu_as_sc_mcu7t3v3__fill_2
XFILLER_181_598 VDD VDD VSS VSS gf180mcu_as_sc_mcu7t3v3__fillcap_16
XFILLER_4_244 VDD VDD VSS VSS gf180mcu_as_sc_mcu7t3v3__fill_1
XFILLER_175_1172 VDD VDD VSS VSS gf180mcu_as_sc_mcu7t3v3__fillcap_16
XFILLER_121_120 VDD VDD VSS VSS gf180mcu_as_sc_mcu7t3v3__fillcap_16
XFILLER_121_142 VDD VDD VSS VSS gf180mcu_as_sc_mcu7t3v3__fill_1
XFILLER_96_31 VDD VDD VSS VSS gf180mcu_as_sc_mcu7t3v3__fillcap_4
XFILLER_0_450 VDD VDD VSS VSS gf180mcu_as_sc_mcu7t3v3__fill_1
XFILLER_62_1364 VDD VDD VSS VSS gf180mcu_as_sc_mcu7t3v3__fillcap_16
XFILLER_96_64 VDD VDD VSS VSS gf180mcu_as_sc_mcu7t3v3__fillcap_16
XTAP_TAPCELL_ROW_15_1051 VDD VSS gf180mcu_as_sc_mcu7t3v3__tap_2
XTAP_TAPCELL_ROW_15_1062 VDD VSS gf180mcu_as_sc_mcu7t3v3__tap_2
XFILLER_1_1100 VDD VDD VSS VSS gf180mcu_as_sc_mcu7t3v3__fillcap_16
XFILLER_35_104 VDD VDD VSS VSS gf180mcu_as_sc_mcu7t3v3__fillcap_8
XFILLER_1_1122 VDD VDD VSS VSS gf180mcu_as_sc_mcu7t3v3__fillcap_4
XFILLER_35_137 VDD VDD VSS VSS gf180mcu_as_sc_mcu7t3v3__fill_2
XFILLER_90_221 VDD VDD VSS VSS gf180mcu_as_sc_mcu7t3v3__fill_1
XTAP_TAPCELL_ROW_52_1_1602 VDD VSS gf180mcu_as_sc_mcu7t3v3__tap_2
XFILLER_189_610 VDD VDD VSS VSS gf180mcu_as_sc_mcu7t3v3__fillcap_16
XFILLER_17_885 VDD VDD VSS VSS gf180mcu_as_sc_mcu7t3v3__fillcap_16
XFILLER_189_632 VDD VDD VSS VSS gf180mcu_as_sc_mcu7t3v3__fillcap_16
XFILLER_50_107 VDD VDD VSS VSS gf180mcu_as_sc_mcu7t3v3__fill_2
X_2900_ VDD VDD VSS VSS _3247_/B _4946_/Q _4944_/Q gf180mcu_as_sc_mcu7t3v3__nand2_2
X_3880_ VDD VDD VSS VSS _3890_/B _5170_/Q _4920_/D gf180mcu_as_sc_mcu7t3v3__and2_2
XTAP_TAPCELL_ROW_62_3_2908 VDD VSS gf180mcu_as_sc_mcu7t3v3__tap_2
XFILLER_31_376 VDD VDD VSS VSS gf180mcu_as_sc_mcu7t3v3__fillcap_16
XFILLER_34_1433 VDD VDD VSS VSS gf180mcu_as_sc_mcu7t3v3__fill_2
X_2831_ VDD VDD VSS VSS _4952_/D _2831_/B _2831_/A _2832_/A gf180mcu_as_sc_mcu7t3v3__mux2_2
XFILLER_129_220 VDD VDD VSS VSS gf180mcu_as_sc_mcu7t3v3__fill_2
X_2762_ VDD VDD VSS VSS _2764_/B _2810_/C _2810_/B gf180mcu_as_sc_mcu7t3v3__nand2_2
XFILLER_195_1504 VDD VDD VSS VSS gf180mcu_as_sc_mcu7t3v3__fillcap_16
X_5481_ VDD VDD VSS VSS _5481_/A _5481_/Y gf180mcu_as_sc_mcu7t3v3__buff_2
X_4501_ VDD VDD VSS VSS _4502_/D _4501_/B _4502_/A gf180mcu_as_sc_mcu7t3v3__nor2_2
X_4432_ VDD VDD VSS VSS _4433_/D _4432_/B _4521_/A gf180mcu_as_sc_mcu7t3v3__nor2_2
X_2693_ VDD VDD VSS VSS _2709_/A _2693_/B _2693_/A _2693_/Y gf180mcu_as_sc_mcu7t3v3__mux2_2
X_4363_ VDD VDD VSS VSS _4379_/B _4363_/B _5160_/Q _5160_/D gf180mcu_as_sc_mcu7t3v3__mux2_2
XFILLER_193_1294 VDD VDD VSS VSS gf180mcu_as_sc_mcu7t3v3__fillcap_16
XFILLER_28_1259 VDD VDD VSS VSS gf180mcu_as_sc_mcu7t3v3__fill_1
Xfanout518 VDD VDD VSS VSS _4198_/Y _4227_/B gf180mcu_as_sc_mcu7t3v3__buff_12
X_4294_ VDD VDD VSS VSS _4294_/B _4294_/A _4295_/B gf180mcu_as_sc_mcu7t3v3__xnor2_2
X_3314_ VDD VDD VSS VSS _3442_/B _3968_/A _3315_/D gf180mcu_as_sc_mcu7t3v3__or2_2
XFILLER_112_153 VDD VDD VSS VSS gf180mcu_as_sc_mcu7t3v3__fillcap_16
XFILLER_80_1453 VDD VDD VSS VSS gf180mcu_as_sc_mcu7t3v3__fillcap_8
X_3245_ VDD VDD VSS VSS _3534_/A _3932_/A _3245_/C _3268_/A gf180mcu_as_sc_mcu7t3v3__nand3_2
XTAP_TAPCELL_ROW_185_2250 VDD VSS gf180mcu_as_sc_mcu7t3v3__tap_2
XFILLER_132_1543 VDD VDD VSS VSS gf180mcu_as_sc_mcu7t3v3__fill_1
XFILLER_80_1486 VDD VDD VSS VSS gf180mcu_as_sc_mcu7t3v3__fillcap_8
Xmesh_tile_944 VDD VDD VSS VSS ne_out[19] gf180mcu_as_sc_mcu7t3v3__tiel_4
Xmesh_tile_933 VDD VDD VSS VSS ne_out[8] gf180mcu_as_sc_mcu7t3v3__tiel_4
XTAP_TAPCELL_ROW_181_2147 VDD VSS gf180mcu_as_sc_mcu7t3v3__tap_2
Xmesh_tile_977 VDD VDD VSS VSS north_out[18] gf180mcu_as_sc_mcu7t3v3__tiel_4
Xmesh_tile_966 VDD VDD VSS VSS north_out[7] gf180mcu_as_sc_mcu7t3v3__tiel_4
Xmesh_tile_955 VDD VDD VSS VSS ne_out[30] gf180mcu_as_sc_mcu7t3v3__tiel_4
X_3176_ VDD VDD VSS VSS _3176_/S _4151_/A _4153_/A _3178_/B gf180mcu_as_sc_mcu7t3v3__mux2_2
XTAP_TAPCELL_ROW_181_2158 VDD VSS gf180mcu_as_sc_mcu7t3v3__tap_2
XFILLER_26_104 VDD VDD VSS VSS gf180mcu_as_sc_mcu7t3v3__fill_1
XFILLER_26_115 VDD VDD VSS VSS gf180mcu_as_sc_mcu7t3v3__fill_2
Xmesh_tile_999 VDD VDD VSS VSS nw_out[6] gf180mcu_as_sc_mcu7t3v3__tiel_4
Xmesh_tile_988 VDD VDD VSS VSS north_out[29] gf180mcu_as_sc_mcu7t3v3__tiel_4
XFILLER_25_27 VDD VDD VSS VSS gf180mcu_as_sc_mcu7t3v3__fillcap_16
XTAP_TAPCELL_ROW_111_3_3053 VDD VSS gf180mcu_as_sc_mcu7t3v3__tap_2
XFILLER_179_120 VDD VDD VSS VSS gf180mcu_as_sc_mcu7t3v3__fillcap_16
XFILLER_23_833 VDD VDD VSS VSS gf180mcu_as_sc_mcu7t3v3__fillcap_4
XFILLER_35_671 VDD VDD VSS VSS gf180mcu_as_sc_mcu7t3v3__fillcap_4
XPHY_EDGE_ROW_157_1_Left_367 VDD VSS gf180mcu_as_sc_mcu7t3v3__tap_2
XFILLER_179_142 VDD VDD VSS VSS gf180mcu_as_sc_mcu7t3v3__fillcap_4
XFILLER_35_1208 VDD VDD VSS VSS gf180mcu_as_sc_mcu7t3v3__fillcap_16
XFILLER_165_1396 VDD VDD VSS VSS gf180mcu_as_sc_mcu7t3v3__fillcap_16
XFILLER_179_186 VDD VDD VSS VSS gf180mcu_as_sc_mcu7t3v3__fill_1
XFILLER_194_101 VDD VDD VSS VSS gf180mcu_as_sc_mcu7t3v3__fillcap_4
XFILLER_194_123 VDD VDD VSS VSS gf180mcu_as_sc_mcu7t3v3__fillcap_16
XPHY_EDGE_ROW_94_1_Left_304 VDD VSS gf180mcu_as_sc_mcu7t3v3__tap_2
XFILLER_10_527 VDD VDD VSS VSS gf180mcu_as_sc_mcu7t3v3__fillcap_8
XFILLER_22_387 VDD VDD VSS VSS gf180mcu_as_sc_mcu7t3v3__fill_2
Xwire908 VDD VDD VSS VSS wire908/A _3956_/A gf180mcu_as_sc_mcu7t3v3__clkbuff_12
XFILLER_176_893 VDD VDD VSS VSS gf180mcu_as_sc_mcu7t3v3__fillcap_16
XFILLER_194_189 VDD VDD VSS VSS gf180mcu_as_sc_mcu7t3v3__fill_1
XFILLER_210_499 VDD VDD VSS VSS gf180mcu_as_sc_mcu7t3v3__fill_2
XFILLER_135_212 VDD VDD VSS VSS gf180mcu_as_sc_mcu7t3v3__fillcap_8
XFILLER_175_392 VDD VDD VSS VSS gf180mcu_as_sc_mcu7t3v3__fillcap_4
XFILLER_102_1391 VDD VDD VSS VSS gf180mcu_as_sc_mcu7t3v3__fill_1
XFILLER_150_204 VDD VDD VSS VSS gf180mcu_as_sc_mcu7t3v3__fillcap_16
XFILLER_190_373 VDD VDD VSS VSS gf180mcu_as_sc_mcu7t3v3__fill_2
XFILLER_191_874 VDD VDD VSS VSS gf180mcu_as_sc_mcu7t3v3__fillcap_16
XFILLER_137_1410 VDD VDD VSS VSS gf180mcu_as_sc_mcu7t3v3__fillcap_4
XFILLER_103_120 VDD VDD VSS VSS gf180mcu_as_sc_mcu7t3v3__fillcap_16
XFILLER_103_142 VDD VDD VSS VSS gf180mcu_as_sc_mcu7t3v3__fillcap_4
XFILLER_46_1348 VDD VDD VSS VSS gf180mcu_as_sc_mcu7t3v3__fillcap_16
XTAP_TAPCELL_ROW_57_1_1617 VDD VSS gf180mcu_as_sc_mcu7t3v3__tap_2
XFILLER_18_605 VDD VDD VSS VSS gf180mcu_as_sc_mcu7t3v3__fill_2
XPHY_EDGE_ROW_122_3_Left_507 VDD VSS gf180mcu_as_sc_mcu7t3v3__tap_2
XFILLER_174_2 VDD VDD VSS VSS gf180mcu_as_sc_mcu7t3v3__fillcap_16
XFILLER_17_137 VDD VDD VSS VSS gf180mcu_as_sc_mcu7t3v3__fill_2
XPHY_EDGE_ROW_89_1_Left_299 VDD VSS gf180mcu_as_sc_mcu7t3v3__tap_2
XFILLER_207_1102 VDD VDD VSS VSS gf180mcu_as_sc_mcu7t3v3__fillcap_16
XFILLER_26_693 VDD VDD VSS VSS gf180mcu_as_sc_mcu7t3v3__fillcap_16
XFILLER_32_107 VDD VDD VSS VSS gf180mcu_as_sc_mcu7t3v3__fill_2
XFILLER_82_44 VDD VDD VSS VSS gf180mcu_as_sc_mcu7t3v3__fillcap_16
XFILLER_144_1403 VDD VDD VSS VSS gf180mcu_as_sc_mcu7t3v3__fill_1
XFILLER_183_1463 VDD VDD VSS VSS gf180mcu_as_sc_mcu7t3v3__fillcap_4
XFILLER_186_613 VDD VDD VSS VSS gf180mcu_as_sc_mcu7t3v3__fillcap_16
XFILLER_198_473 VDD VDD VSS VSS gf180mcu_as_sc_mcu7t3v3__fillcap_16
XFILLER_57_1455 VDD VDD VSS VSS gf180mcu_as_sc_mcu7t3v3__fillcap_4
XFILLER_57_1488 VDD VDD VSS VSS gf180mcu_as_sc_mcu7t3v3__fillcap_16
XFILLER_14_877 VDD VDD VSS VSS gf180mcu_as_sc_mcu7t3v3__fillcap_16
XFILLER_186_635 VDD VDD VSS VSS gf180mcu_as_sc_mcu7t3v3__fill_1
XFILLER_186_646 VDD VDD VSS VSS gf180mcu_as_sc_mcu7t3v3__fillcap_16
XFILLER_201_422 VDD VDD VSS VSS gf180mcu_as_sc_mcu7t3v3__fill_2
XFILLER_9_325 VDD VDD VSS VSS gf180mcu_as_sc_mcu7t3v3__fillcap_16
XFILLER_13_398 VDD VDD VSS VSS gf180mcu_as_sc_mcu7t3v3__fill_1
XFILLER_201_488 VDD VDD VSS VSS gf180mcu_as_sc_mcu7t3v3__fill_2
XFILLER_185_189 VDD VDD VSS VSS gf180mcu_as_sc_mcu7t3v3__fill_1
XFILLER_177_1256 VDD VDD VSS VSS gf180mcu_as_sc_mcu7t3v3__fillcap_4
XFILLER_5_542 VDD VDD VSS VSS gf180mcu_as_sc_mcu7t3v3__fillcap_16
XFILLER_5_564 VDD VDD VSS VSS gf180mcu_as_sc_mcu7t3v3__fill_1
XFILLER_190_1445 VDD VDD VSS VSS gf180mcu_as_sc_mcu7t3v3__fill_2
XTAP_TAPCELL_ROW_17_1113 VDD VSS gf180mcu_as_sc_mcu7t3v3__tap_2
XTAP_TAPCELL_ROW_17_1102 VDD VSS gf180mcu_as_sc_mcu7t3v3__tap_2
XFILLER_151_1418 VDD VDD VSS VSS gf180mcu_as_sc_mcu7t3v3__fill_2
XTAP_TAPCELL_ROW_104_1_1756 VDD VSS gf180mcu_as_sc_mcu7t3v3__tap_2
XFILLER_0_280 VDD VDD VSS VSS gf180mcu_as_sc_mcu7t3v3__fill_1
XPHY_EDGE_ROW_54_3_Left_439 VDD VSS gf180mcu_as_sc_mcu7t3v3__tap_2
XTAP_TAPCELL_ROW_116_3_3068 VDD VSS gf180mcu_as_sc_mcu7t3v3__tap_2
XTAP_TAPCELL_ROW_34_1471 VDD VSS gf180mcu_as_sc_mcu7t3v3__tap_2
XFILLER_23_1134 VDD VDD VSS VSS gf180mcu_as_sc_mcu7t3v3__fill_2
XFILLER_36_402 VDD VDD VSS VSS gf180mcu_as_sc_mcu7t3v3__fillcap_4
XFILLER_7_1364 VDD VDD VSS VSS gf180mcu_as_sc_mcu7t3v3__fillcap_8
Xinput170 VDD VDD VSS VSS nw_in[31] _3513_/A gf180mcu_as_sc_mcu7t3v3__buff_12
Xinput181 VDD VDD VSS VSS se_in[0] wire883/A gf180mcu_as_sc_mcu7t3v3__buff_12
X_3030_ VDD VDD VSS VSS _3031_/C _3030_/C _3125_/C _4008_/D gf180mcu_as_sc_mcu7t3v3__aoi21_2
XTAP_TAPCELL_ROW_34_1482 VDD VSS gf180mcu_as_sc_mcu7t3v3__tap_2
Xinput192 VDD VDD VSS VSS se_in[1] wire876/A gf180mcu_as_sc_mcu7t3v3__buff_12
XFILLER_184_1205 VDD VDD VSS VSS gf180mcu_as_sc_mcu7t3v3__fillcap_16
XFILLER_184_1227 VDD VDD VSS VSS gf180mcu_as_sc_mcu7t3v3__fillcap_4
XFILLER_40_1481 VDD VDD VSS VSS gf180mcu_as_sc_mcu7t3v3__fill_1
XFILLER_205_750 VDD VDD VSS VSS gf180mcu_as_sc_mcu7t3v3__fillcap_16
XFILLER_23_107 VDD VDD VSS VSS gf180mcu_as_sc_mcu7t3v3__fillcap_16
X_4981_ VDD VDD VSS VSS _5082_/CLK _4981_/D _4981_/Q gf180mcu_as_sc_mcu7t3v3__dfxtp_2
XFILLER_16_170 VDD VDD VSS VSS gf180mcu_as_sc_mcu7t3v3__fillcap_4
XFILLER_205_772 VDD VDD VSS VSS gf180mcu_as_sc_mcu7t3v3__fillcap_16
XFILLER_71_1408 VDD VDD VSS VSS gf180mcu_as_sc_mcu7t3v3__fillcap_8
XFILLER_75_1566 VDD VDD VSS VSS gf180mcu_as_sc_mcu7t3v3__fill_2
X_3932_ VDD VDD VSS VSS _3932_/A _3932_/B _3932_/C _3932_/Y _3932_/D gf180mcu_as_sc_mcu7t3v3__aoi211_2
XTAP_TAPCELL_ROW_81_3_2963 VDD VSS gf180mcu_as_sc_mcu7t3v3__tap_2
XFILLER_176_101 VDD VDD VSS VSS gf180mcu_as_sc_mcu7t3v3__fillcap_4
XFILLER_20_803 VDD VDD VSS VSS gf180mcu_as_sc_mcu7t3v3__fill_2
X_3863_ VDD VDD VSS VSS _5140_/Q _5139_/Q _3864_/C gf180mcu_as_sc_mcu7t3v3__or2_2
X_2814_ VDD VDD VSS VSS _4974_/D _2825_/B _4756_/Q _4755_/D gf180mcu_as_sc_mcu7t3v3__mux2_2
XFILLER_191_104 VDD VDD VSS VSS gf180mcu_as_sc_mcu7t3v3__fillcap_16
X_3794_ VDD VDD VSS VSS _3794_/S _3794_/B _3794_/A _3795_/B gf180mcu_as_sc_mcu7t3v3__mux2_2
XFILLER_117_212 VDD VDD VSS VSS gf180mcu_as_sc_mcu7t3v3__fillcap_8
XFILLER_11_18 VDD VDD VSS VSS gf180mcu_as_sc_mcu7t3v3__fillcap_16
XFILLER_30_1149 VDD VDD VSS VSS gf180mcu_as_sc_mcu7t3v3__fillcap_4
X_2745_ VDD VDD VSS VSS _2745_/B _2745_/A _2746_/B gf180mcu_as_sc_mcu7t3v3__xnor2_2
XFILLER_69_1348 VDD VDD VSS VSS gf180mcu_as_sc_mcu7t3v3__fillcap_16
X_2676_ VDD VDD VSS VSS _2832_/S _2676_/B _2676_/C _2676_/D _2676_/Y gf180mcu_as_sc_mcu7t3v3__ao22_2
X_4415_ VDD VDD VSS VSS _4416_/D _4415_/B _4512_/A gf180mcu_as_sc_mcu7t3v3__nor2_2
X_4346_ VDD VDD VSS VSS _4379_/B _4346_/B _5157_/Q _5157_/D gf180mcu_as_sc_mcu7t3v3__mux2_2
XTAP_TAPCELL_ROW_183_2209 VDD VSS gf180mcu_as_sc_mcu7t3v3__tap_2
XFILLER_189_1116 VDD VDD VSS VSS gf180mcu_as_sc_mcu7t3v3__fillcap_4
X_4277_ VDD VDD VSS VSS _4279_/S _5481_/A _5111_/Q _5111_/D gf180mcu_as_sc_mcu7t3v3__mux2_2
XFILLER_189_1138 VDD VDD VSS VSS gf180mcu_as_sc_mcu7t3v3__fillcap_16
X_3228_ VDD VDD VSS VSS _3228_/B _3228_/A _3229_/D gf180mcu_as_sc_mcu7t3v3__or2_2
XFILLER_210_1548 VDD VDD VSS VSS gf180mcu_as_sc_mcu7t3v3__fillcap_16
XFILLER_28_947 VDD VDD VSS VSS gf180mcu_as_sc_mcu7t3v3__fillcap_16
XPHY_EDGE_ROW_19_Left_230 VDD VSS gf180mcu_as_sc_mcu7t3v3__tap_2
X_3159_ VDD VDD VSS VSS _3176_/S _4135_/D _4138_/A _3161_/B gf180mcu_as_sc_mcu7t3v3__mux2_2
XTAP_TAPCELL_ROW_206_2695 VDD VSS gf180mcu_as_sc_mcu7t3v3__tap_2
XFILLER_14_107 VDD VDD VSS VSS gf180mcu_as_sc_mcu7t3v3__fillcap_16
XFILLER_27_479 VDD VDD VSS VSS gf180mcu_as_sc_mcu7t3v3__fillcap_8
XTAP_TAPCELL_ROW_130_1_1835 VDD VSS gf180mcu_as_sc_mcu7t3v3__tap_2
XTAP_TAPCELL_ROW_142_3_3147 VDD VSS gf180mcu_as_sc_mcu7t3v3__tap_2
XFILLER_167_123 VDD VDD VSS VSS gf180mcu_as_sc_mcu7t3v3__fillcap_4
XFILLER_195_454 VDD VDD VSS VSS gf180mcu_as_sc_mcu7t3v3__fillcap_16
XFILLER_22_173 VDD VDD VSS VSS gf180mcu_as_sc_mcu7t3v3__fill_2
XFILLER_104_1431 VDD VDD VSS VSS gf180mcu_as_sc_mcu7t3v3__fill_1
XFILLER_104_1442 VDD VDD VSS VSS gf180mcu_as_sc_mcu7t3v3__fillcap_8
XFILLER_168_69 VDD VDD VSS VSS gf180mcu_as_sc_mcu7t3v3__fillcap_16
XFILLER_17_1472 VDD VDD VSS VSS gf180mcu_as_sc_mcu7t3v3__fillcap_16
XFILLER_183_627 VDD VDD VSS VSS gf180mcu_as_sc_mcu7t3v3__fill_2
XFILLER_210_274 VDD VDD VSS VSS gf180mcu_as_sc_mcu7t3v3__fillcap_4
XFILLER_6_317 VDD VDD VSS VSS gf180mcu_as_sc_mcu7t3v3__fill_1
XFILLER_104_1453 VDD VDD VSS VSS gf180mcu_as_sc_mcu7t3v3__fillcap_8
XFILLER_202_1065 VDD VDD VSS VSS gf180mcu_as_sc_mcu7t3v3__fillcap_16
XFILLER_87_1404 VDD VDD VSS VSS gf180mcu_as_sc_mcu7t3v3__fill_2
XFILLER_202_1087 VDD VDD VSS VSS gf180mcu_as_sc_mcu7t3v3__fillcap_16
XFILLER_11_1060 VDD VDD VSS VSS gf180mcu_as_sc_mcu7t3v3__fillcap_4
XFILLER_2_556 VDD VDD VSS VSS gf180mcu_as_sc_mcu7t3v3__fill_1
XTAP_TAPCELL_ROW_76_1_1672 VDD VSS gf180mcu_as_sc_mcu7t3v3__tap_2
XFILLER_63_1470 VDD VDD VSS VSS gf180mcu_as_sc_mcu7t3v3__fillcap_8
XFILLER_77_66 VDD VDD VSS VSS gf180mcu_as_sc_mcu7t3v3__fillcap_4
XFILLER_77_88 VDD VDD VSS VSS gf180mcu_as_sc_mcu7t3v3__fillcap_16
Xfanout860 VDD VDD VSS VSS _2832_/S _2737_/A gf180mcu_as_sc_mcu7t3v3__buff_12
XTAP_TAPCELL_ROW_6_862 VDD VSS gf180mcu_as_sc_mcu7t3v3__tap_2
XFILLER_111_1402 VDD VDD VSS VSS gf180mcu_as_sc_mcu7t3v3__fillcap_8
XFILLER_4_1504 VDD VDD VSS VSS gf180mcu_as_sc_mcu7t3v3__fill_1
Xfanout893 VDD VDD VSS VSS _3746_/D _3714_/D gf180mcu_as_sc_mcu7t3v3__buff_12
XTAP_TAPCELL_ROW_86_3_2978 VDD VSS gf180mcu_as_sc_mcu7t3v3__tap_2
XTAP_TAPCELL_ROW_6_873 VDD VSS gf180mcu_as_sc_mcu7t3v3__tap_2
XFILLER_111_1424 VDD VDD VSS VSS gf180mcu_as_sc_mcu7t3v3__fill_1
XFILLER_133_72 VDD VDD VSS VSS gf180mcu_as_sc_mcu7t3v3__fillcap_16
XFILLER_18_413 VDD VDD VSS VSS gf180mcu_as_sc_mcu7t3v3__fillcap_8
XFILLER_20_1329 VDD VDD VSS VSS gf180mcu_as_sc_mcu7t3v3__fill_2
XFILLER_18_457 VDD VDD VSS VSS gf180mcu_as_sc_mcu7t3v3__fillcap_4
XFILLER_34_917 VDD VDD VSS VSS gf180mcu_as_sc_mcu7t3v3__fillcap_16
XFILLER_209_1208 VDD VDD VSS VSS gf180mcu_as_sc_mcu7t3v3__fillcap_16
XFILLER_187_944 VDD VDD VSS VSS gf180mcu_as_sc_mcu7t3v3__fillcap_16
XFILLER_202_731 VDD VDD VSS VSS gf180mcu_as_sc_mcu7t3v3__fillcap_4
XFILLER_202_753 VDD VDD VSS VSS gf180mcu_as_sc_mcu7t3v3__fillcap_16
XFILLER_109_1386 VDD VDD VSS VSS gf180mcu_as_sc_mcu7t3v3__fill_1
XFILLER_109_1397 VDD VDD VSS VSS gf180mcu_as_sc_mcu7t3v3__fillcap_8
XFILLER_158_123 VDD VDD VSS VSS gf180mcu_as_sc_mcu7t3v3__fillcap_16
XFILLER_186_454 VDD VDD VSS VSS gf180mcu_as_sc_mcu7t3v3__fill_1
XFILLER_173_104 VDD VDD VSS VSS gf180mcu_as_sc_mcu7t3v3__fillcap_8
XFILLER_122_1564 VDD VDD VSS VSS gf180mcu_as_sc_mcu7t3v3__fillcap_4
XFILLER_31_1458 VDD VDD VSS VSS gf180mcu_as_sc_mcu7t3v3__fill_2
XFILLER_6_840 VDD VDD VSS VSS gf180mcu_as_sc_mcu7t3v3__fill_2
X_2530_ VDD VDD VSS VSS _2541_/B _2530_/B _2534_/B gf180mcu_as_sc_mcu7t3v3__nor2b_2
XFILLER_192_1507 VDD VDD VSS VSS gf180mcu_as_sc_mcu7t3v3__fillcap_16
X_2461_ VDD VDD VSS VSS _4586_/S _5032_/Q _5061_/Q _2462_/A gf180mcu_as_sc_mcu7t3v3__mux2_2
XFILLER_29_1332 VDD VDD VSS VSS gf180mcu_as_sc_mcu7t3v3__fillcap_4
X_4200_ VDD VDD VSS VSS _4229_/B _4224_/B _4224_/C _5036_/Q _5036_/D gf180mcu_as_sc_mcu7t3v3__ao22_2
XTAP_TAPCELL_ROW_36_1522 VDD VSS gf180mcu_as_sc_mcu7t3v3__tap_2
X_5180_ VDD VDD VSS VSS clkload9/A _5180_/D _5180_/Q gf180mcu_as_sc_mcu7t3v3__dfxtp_2
X_2392_ VDD VDD VSS VSS _3847_/A _4913_/Q gf180mcu_as_sc_mcu7t3v3__inv_2
XTAP_TAPCELL_ROW_36_1555 VDD VSS gf180mcu_as_sc_mcu7t3v3__tap_2
XTAP_TAPCELL_ROW_36_1544 VDD VSS gf180mcu_as_sc_mcu7t3v3__tap_2
XTAP_TAPCELL_ROW_36_1533 VDD VSS gf180mcu_as_sc_mcu7t3v3__tap_2
XFILLER_190_1275 VDD VDD VSS VSS gf180mcu_as_sc_mcu7t3v3__fillcap_16
X_4131_ VDD VDD VSS VSS _4132_/D _4131_/C _4163_/B _4131_/A gf180mcu_as_sc_mcu7t3v3__aoi21_2
XFILLER_190_1297 VDD VDD VSS VSS gf180mcu_as_sc_mcu7t3v3__fillcap_16
XFILLER_7_1150 VDD VDD VSS VSS gf180mcu_as_sc_mcu7t3v3__fill_1
X_4062_ VDD VDD VSS VSS _4128_/B _4062_/A _4063_/D gf180mcu_as_sc_mcu7t3v3__and2_2
XFILLER_209_352 VDD VDD VSS VSS gf180mcu_as_sc_mcu7t3v3__fillcap_16
XFILLER_36_210 VDD VDD VSS VSS gf180mcu_as_sc_mcu7t3v3__fill_2
X_3013_ VDD VDD VSS VSS _3992_/D _3042_/C _3013_/C _3013_/D _3014_/B gf180mcu_as_sc_mcu7t3v3__ao211_2
XFILLER_36_265 VDD VDD VSS VSS gf180mcu_as_sc_mcu7t3v3__fillcap_4
XFILLER_24_438 VDD VDD VSS VSS gf180mcu_as_sc_mcu7t3v3__fillcap_16
X_4964_ VDD VDD VSS VSS _5277_/CLK _4964_/D _4964_/Q gf180mcu_as_sc_mcu7t3v3__dfxtp_2
XFILLER_36_1325 VDD VDD VSS VSS gf180mcu_as_sc_mcu7t3v3__fill_1
X_3915_ VDD VDD VSS VSS _3931_/B _3932_/D _3915_/A gf180mcu_as_sc_mcu7t3v3__nor2_2
XTAP_TAPCELL_ROW_201_2592 VDD VSS gf180mcu_as_sc_mcu7t3v3__tap_2
XTAP_TAPCELL_ROW_176_2046 VDD VSS gf180mcu_as_sc_mcu7t3v3__tap_2
XTAP_TAPCELL_ROW_176_2035 VDD VSS gf180mcu_as_sc_mcu7t3v3__tap_2
XFILLER_162_1377 VDD VDD VSS VSS gf180mcu_as_sc_mcu7t3v3__fillcap_4
X_4895_ VDD VDD VSS VSS _4904_/CLK _4895_/D _4895_/Q gf180mcu_as_sc_mcu7t3v3__dfxtp_2
XFILLER_162_1399 VDD VDD VSS VSS gf180mcu_as_sc_mcu7t3v3__fillcap_16
XFILLER_164_104 VDD VDD VSS VSS gf180mcu_as_sc_mcu7t3v3__fill_1
XFILLER_197_1418 VDD VDD VSS VSS gf180mcu_as_sc_mcu7t3v3__fillcap_16
XFILLER_34_1060 VDD VDD VSS VSS gf180mcu_as_sc_mcu7t3v3__fillcap_16
X_3846_ VDD VDD VSS VSS _3847_/B _3847_/A _3846_/B _4914_/Q gf180mcu_as_sc_mcu7t3v3__aoi21_2
XFILLER_192_457 VDD VDD VSS VSS gf180mcu_as_sc_mcu7t3v3__fillcap_16
X_3777_ VDD VDD VSS VSS _3792_/D _4160_/D _3777_/B _3799_/D _3779_/C gf180mcu_as_sc_mcu7t3v3__ao31_2
XFILLER_203_1396 VDD VDD VSS VSS gf180mcu_as_sc_mcu7t3v3__fillcap_4
X_2728_ VDD VDD VSS VSS _2735_/A _2728_/B _2728_/C _2735_/D _2730_/C gf180mcu_as_sc_mcu7t3v3__ao211_2
XTAP_TAPCELL_ROW_210_2806 VDD VSS gf180mcu_as_sc_mcu7t3v3__tap_2
XTAP_TAPCELL_ROW_210_2817 VDD VSS gf180mcu_as_sc_mcu7t3v3__tap_2
XFILLER_172_181 VDD VDD VSS VSS gf180mcu_as_sc_mcu7t3v3__fill_2
XFILLER_195_1186 VDD VDD VSS VSS gf180mcu_as_sc_mcu7t3v3__fillcap_4
Xoutput452 VDD VDD VSS VSS _4905_/Q west_out[32] gf180mcu_as_sc_mcu7t3v3__buff_12
Xoutput441 VDD VDD VSS VSS _4895_/Q west_out[22] gf180mcu_as_sc_mcu7t3v3__buff_12
Xoutput430 VDD VDD VSS VSS _4885_/Q west_out[12] gf180mcu_as_sc_mcu7t3v3__buff_12
X_2659_ VDD VDD VSS VSS _2659_/S _2659_/B _5266_/Q _2662_/C gf180mcu_as_sc_mcu7t3v3__mux2_2
X_4329_ VDD VDD VSS VSS _4331_/D _4371_/B _4371_/A _4329_/A gf180mcu_as_sc_mcu7t3v3__aoi21b_2
XTAP_TAPCELL_ROW_208_2757 VDD VSS gf180mcu_as_sc_mcu7t3v3__tap_2
XTAP_TAPCELL_ROW_208_2746 VDD VSS gf180mcu_as_sc_mcu7t3v3__tap_2
XFILLER_170_37 VDD VDD VSS VSS gf180mcu_as_sc_mcu7t3v3__fillcap_16
XFILLER_210_1345 VDD VDD VSS VSS gf180mcu_as_sc_mcu7t3v3__fillcap_4
XFILLER_103_31 VDD VDD VSS VSS gf180mcu_as_sc_mcu7t3v3__fillcap_16
XFILLER_103_64 VDD VDD VSS VSS gf180mcu_as_sc_mcu7t3v3__fillcap_4
XFILLER_210_1389 VDD VDD VSS VSS gf180mcu_as_sc_mcu7t3v3__fill_1
XFILLER_27_254 VDD VDD VSS VSS gf180mcu_as_sc_mcu7t3v3__fillcap_8
XFILLER_110_1490 VDD VDD VSS VSS gf180mcu_as_sc_mcu7t3v3__fillcap_16
XFILLER_15_438 VDD VDD VSS VSS gf180mcu_as_sc_mcu7t3v3__fillcap_4
XTAP_TAPCELL_ROW_161_1_1929 VDD VSS gf180mcu_as_sc_mcu7t3v3__tap_2
XFILLER_180_1433 VDD VDD VSS VSS gf180mcu_as_sc_mcu7t3v3__fill_2
XFILLER_93_1485 VDD VDD VSS VSS gf180mcu_as_sc_mcu7t3v3__fill_1
XFILLER_23_471 VDD VDD VSS VSS gf180mcu_as_sc_mcu7t3v3__fillcap_4
XFILLER_54_1447 VDD VDD VSS VSS gf180mcu_as_sc_mcu7t3v3__fillcap_4
XFILLER_11_655 VDD VDD VSS VSS gf180mcu_as_sc_mcu7t3v3__fill_1
XFILLER_13_1100 VDD VDD VSS VSS gf180mcu_as_sc_mcu7t3v3__fillcap_16
XFILLER_184_925 VDD VDD VSS VSS gf180mcu_as_sc_mcu7t3v3__fillcap_16
XFILLER_196_785 VDD VDD VSS VSS gf180mcu_as_sc_mcu7t3v3__fillcap_16
Xwire502 VDD VDD VSS VSS _3014_/Y _3015_/B gf180mcu_as_sc_mcu7t3v3__clkbuff_12
XFILLER_11_699 VDD VDD VSS VSS gf180mcu_as_sc_mcu7t3v3__fill_1
XFILLER_13_1122 VDD VDD VSS VSS gf180mcu_as_sc_mcu7t3v3__fillcap_4
XFILLER_155_115 VDD VDD VSS VSS gf180mcu_as_sc_mcu7t3v3__fillcap_16
XFILLER_184_947 VDD VDD VSS VSS gf180mcu_as_sc_mcu7t3v3__fillcap_16
XFILLER_195_295 VDD VDD VSS VSS gf180mcu_as_sc_mcu7t3v3__fillcap_16
XFILLER_7_626 VDD VDD VSS VSS gf180mcu_as_sc_mcu7t3v3__fillcap_4
XFILLER_170_107 VDD VDD VSS VSS gf180mcu_as_sc_mcu7t3v3__fillcap_16
XFILLER_128_61 VDD VDD VSS VSS gf180mcu_as_sc_mcu7t3v3__fillcap_16
XFILLER_174_1226 VDD VDD VSS VSS gf180mcu_as_sc_mcu7t3v3__fillcap_16
XFILLER_88_76 VDD VDD VSS VSS gf180mcu_as_sc_mcu7t3v3__fill_2
XFILLER_61_1418 VDD VDD VSS VSS gf180mcu_as_sc_mcu7t3v3__fillcap_4
XFILLER_144_93 VDD VDD VSS VSS gf180mcu_as_sc_mcu7t3v3__fill_1
XFILLER_152_1568 VDD VDD VSS VSS gf180mcu_as_sc_mcu7t3v3__fill_1
XFILLER_4_1301 VDD VDD VSS VSS gf180mcu_as_sc_mcu7t3v3__fill_2
XFILLER_8_1492 VDD VDD VSS VSS gf180mcu_as_sc_mcu7t3v3__fill_2
Xfanout690 VDD VDD VSS VSS fanout692/A _4101_/C gf180mcu_as_sc_mcu7t3v3__buff_12
XFILLER_19_744 VDD VDD VSS VSS gf180mcu_as_sc_mcu7t3v3__fillcap_4
XFILLER_206_311 VDD VDD VSS VSS gf180mcu_as_sc_mcu7t3v3__fillcap_4
XFILLER_19_799 VDD VDD VSS VSS gf180mcu_as_sc_mcu7t3v3__fillcap_4
XFILLER_206_333 VDD VDD VSS VSS gf180mcu_as_sc_mcu7t3v3__fillcap_16
XFILLER_92_168 VDD VDD VSS VSS gf180mcu_as_sc_mcu7t3v3__fillcap_4
XFILLER_98_1396 VDD VDD VSS VSS gf180mcu_as_sc_mcu7t3v3__fill_1
Xclkbuf_leaf_36_clk_regs VDD VDD VSS VSS clkbuf_3_3__f_clk_regs/Y _5082_/CLK gf180mcu_as_sc_mcu7t3v3__clkbuff_12
X_4887__1080 VDD VDD VSS VSS _4887_/D gf180mcu_as_sc_mcu7t3v3__tiel_4
XFILLER_181_1208 VDD VDD VSS VSS gf180mcu_as_sc_mcu7t3v3__fillcap_16
XFILLER_2_1080 VDD VDD VSS VSS gf180mcu_as_sc_mcu7t3v3__fillcap_4
XFILLER_33_279 VDD VDD VSS VSS gf180mcu_as_sc_mcu7t3v3__fill_1
XTAP_TAPCELL_ROW_29_1370 VDD VSS gf180mcu_as_sc_mcu7t3v3__tap_2
XFILLER_18_1033 VDD VDD VSS VSS gf180mcu_as_sc_mcu7t3v3__fillcap_16
X_3700_ VDD VDD VSS VSS _4080_/A _3749_/B _3740_/C _4079_/A _3701_/C gf180mcu_as_sc_mcu7t3v3__ao22_2
XFILLER_175_936 VDD VDD VSS VSS gf180mcu_as_sc_mcu7t3v3__fill_2
XFILLER_186_251 VDD VDD VSS VSS gf180mcu_as_sc_mcu7t3v3__fill_2
XFILLER_18_1077 VDD VDD VSS VSS gf180mcu_as_sc_mcu7t3v3__fill_1
X_4680_ VDD VDD VSS VSS _5247_/D _5101_/Q _4725_/B _4680_/C gf180mcu_as_sc_mcu7t3v3__ao21_2
XTAP_TAPCELL_ROW_25_1278 VDD VSS gf180mcu_as_sc_mcu7t3v3__tap_2
XFILLER_31_1222 VDD VDD VSS VSS gf180mcu_as_sc_mcu7t3v3__fill_1
X_3631_ VDD VDD VSS VSS _4003_/A _3731_/B _3631_/C _3631_/Y _3691_/D gf180mcu_as_sc_mcu7t3v3__aoi211_2
XTAP_TAPCELL_ROW_25_1289 VDD VSS gf180mcu_as_sc_mcu7t3v3__tap_2
XFILLER_31_1244 VDD VDD VSS VSS gf180mcu_as_sc_mcu7t3v3__fillcap_4
X_3562_ VDD VDD VSS VSS _3562_/Y _3562_/B _3562_/A gf180mcu_as_sc_mcu7t3v3__nor2b_2
X_2513_ VDD VDD VSS VSS _4683_/B _4703_/A _4637_/A _4663_/A gf180mcu_as_sc_mcu7t3v3__nand3_2
X_3493_ VDD VDD VSS VSS _4942_/Q _3493_/B _3501_/B _4152_/A _3495_/C gf180mcu_as_sc_mcu7t3v3__ao22_2
XFILLER_157_1479 VDD VDD VSS VSS gf180mcu_as_sc_mcu7t3v3__fillcap_4
XFILLER_29_1140 VDD VDD VSS VSS gf180mcu_as_sc_mcu7t3v3__fill_1
XPHY_EDGE_ROW_166_1_Left_376 VDD VSS gf180mcu_as_sc_mcu7t3v3__tap_2
X_5232_ VDD VDD VSS VSS _5262_/CLK _5232_/D _5232_/Q gf180mcu_as_sc_mcu7t3v3__dfxtp_2
X_2444_ VDD VDD VSS VSS _4115_/A _2444_/A gf180mcu_as_sc_mcu7t3v3__inv_2
X_5163_ VDD VDD VSS VSS _5260_/CLK _5163_/D _5163_/Q gf180mcu_as_sc_mcu7t3v3__dfxtp_2
XFILLER_9_1278 VDD VDD VSS VSS gf180mcu_as_sc_mcu7t3v3__fillcap_16
X_4114_ VDD VDD VSS VSS _4115_/D _4114_/C _4122_/B _4114_/A gf180mcu_as_sc_mcu7t3v3__aoi21_2
X_5094_ VDD VDD VSS VSS _5095_/CLK _5094_/D _5094_/Q gf180mcu_as_sc_mcu7t3v3__dfxtp_2
XFILLER_186_1119 VDD VDD VSS VSS gf180mcu_as_sc_mcu7t3v3__fillcap_16
XFILLER_204_85 VDD VDD VSS VSS gf180mcu_as_sc_mcu7t3v3__fillcap_16
XFILLER_42_1373 VDD VDD VSS VSS gf180mcu_as_sc_mcu7t3v3__fillcap_8
X_4045_ VDD VDD VSS VSS _4045_/A _4102_/B _4102_/C _4929_/Q _4047_/C gf180mcu_as_sc_mcu7t3v3__ao22_2
XFILLER_129_1504 VDD VDD VSS VSS gf180mcu_as_sc_mcu7t3v3__fillcap_16
XTAP_TAPCELL_ROW_203_2643 VDD VSS gf180mcu_as_sc_mcu7t3v3__tap_2
XTAP_TAPCELL_ROW_203_2632 VDD VSS gf180mcu_as_sc_mcu7t3v3__tap_2
XFILLER_25_736 VDD VDD VSS VSS gf180mcu_as_sc_mcu7t3v3__fillcap_4
XFILLER_25_769 VDD VDD VSS VSS gf180mcu_as_sc_mcu7t3v3__fill_1
XFILLER_24_279 VDD VDD VSS VSS gf180mcu_as_sc_mcu7t3v3__fillcap_16
XFILLER_33_27 VDD VDD VSS VSS gf180mcu_as_sc_mcu7t3v3__fillcap_16
XFILLER_33_780 VDD VDD VSS VSS gf180mcu_as_sc_mcu7t3v3__fill_2
X_4947_ VDD VDD VSS VSS clkload8/A _4947_/D _4947_/Q gf180mcu_as_sc_mcu7t3v3__dfxtp_2
XTAP_TAPCELL_ROW_195_2466 VDD VSS gf180mcu_as_sc_mcu7t3v3__tap_2
XTAP_TAPCELL_ROW_195_2455 VDD VSS gf180mcu_as_sc_mcu7t3v3__tap_2
XFILLER_149_27 VDD VDD VSS VSS gf180mcu_as_sc_mcu7t3v3__fillcap_16
XFILLER_20_441 VDD VDD VSS VSS gf180mcu_as_sc_mcu7t3v3__fillcap_8
XFILLER_32_290 VDD VDD VSS VSS gf180mcu_as_sc_mcu7t3v3__fillcap_8
XFILLER_36_1166 VDD VDD VSS VSS gf180mcu_as_sc_mcu7t3v3__fillcap_4
X_4878_ VDD VDD VSS VSS _4924_/CLK _4878_/D _4878_/Q gf180mcu_as_sc_mcu7t3v3__dfxtp_2
X_3829_ VDD VDD VSS VSS _4752_/B _3835_/B _4909_/Q gf180mcu_as_sc_mcu7t3v3__nor2_2
XFILLER_140_1450 VDD VDD VSS VSS gf180mcu_as_sc_mcu7t3v3__fill_1
XFILLER_14_1464 VDD VDD VSS VSS gf180mcu_as_sc_mcu7t3v3__fillcap_4
XFILLER_181_906 VDD VDD VSS VSS gf180mcu_as_sc_mcu7t3v3__fillcap_4
XFILLER_181_928 VDD VDD VSS VSS gf180mcu_as_sc_mcu7t3v3__fillcap_16
XFILLER_193_766 VDD VDD VSS VSS gf180mcu_as_sc_mcu7t3v3__fillcap_4
XFILLER_193_788 VDD VDD VSS VSS gf180mcu_as_sc_mcu7t3v3__fillcap_16
XTAP_TAPCELL_ROW_137_3_3131 VDD VSS gf180mcu_as_sc_mcu7t3v3__tap_2
XFILLER_101_1434 VDD VDD VSS VSS gf180mcu_as_sc_mcu7t3v3__fillcap_4
XFILLER_14_1497 VDD VDD VSS VSS gf180mcu_as_sc_mcu7t3v3__fillcap_8
XFILLER_152_107 VDD VDD VSS VSS gf180mcu_as_sc_mcu7t3v3__fillcap_16
XFILLER_180_427 VDD VDD VSS VSS gf180mcu_as_sc_mcu7t3v3__fill_2
XPHY_EDGE_ROW_131_3_Left_516 VDD VSS gf180mcu_as_sc_mcu7t3v3__tap_2
XFILLER_175_1524 VDD VDD VSS VSS gf180mcu_as_sc_mcu7t3v3__fillcap_16
XTAP_TAPCELL_ROW_8_913 VDD VSS gf180mcu_as_sc_mcu7t3v3__tap_2
XTAP_TAPCELL_ROW_8_902 VDD VSS gf180mcu_as_sc_mcu7t3v3__tap_2
XFILLER_59_121 VDD VDD VSS VSS gf180mcu_as_sc_mcu7t3v3__fillcap_16
XTAP_TAPCELL_ROW_105_1_1761 VDD VSS gf180mcu_as_sc_mcu7t3v3__tap_2
XTAP_TAPCELL_ROW_117_3_3073 VDD VSS gf180mcu_as_sc_mcu7t3v3__tap_2
XFILLER_21_1402 VDD VDD VSS VSS gf180mcu_as_sc_mcu7t3v3__fillcap_16
XFILLER_210_1153 VDD VDD VSS VSS gf180mcu_as_sc_mcu7t3v3__fill_2
XFILLER_15_202 VDD VDD VSS VSS gf180mcu_as_sc_mcu7t3v3__fill_1
XFILLER_210_1175 VDD VDD VSS VSS gf180mcu_as_sc_mcu7t3v3__fillcap_4
XFILLER_28_574 VDD VDD VSS VSS gf180mcu_as_sc_mcu7t3v3__fillcap_8
XFILLER_182_1517 VDD VDD VSS VSS gf180mcu_as_sc_mcu7t3v3__fill_1
XFILLER_188_505 VDD VDD VSS VSS gf180mcu_as_sc_mcu7t3v3__fillcap_16
XFILLER_56_1509 VDD VDD VSS VSS gf180mcu_as_sc_mcu7t3v3__fill_1
XFILLER_95_1558 VDD VDD VSS VSS gf180mcu_as_sc_mcu7t3v3__fillcap_8
XFILLER_188_527 VDD VDD VSS VSS gf180mcu_as_sc_mcu7t3v3__fillcap_16
XFILLER_203_314 VDD VDD VSS VSS gf180mcu_as_sc_mcu7t3v3__fillcap_16
XFILLER_15_279 VDD VDD VSS VSS gf180mcu_as_sc_mcu7t3v3__fill_1
XFILLER_19_1397 VDD VDD VSS VSS gf180mcu_as_sc_mcu7t3v3__fill_2
XFILLER_90_88 VDD VDD VSS VSS gf180mcu_as_sc_mcu7t3v3__fillcap_16
XFILLER_11_474 VDD VDD VSS VSS gf180mcu_as_sc_mcu7t3v3__fillcap_16
XFILLER_128_115 VDD VDD VSS VSS gf180mcu_as_sc_mcu7t3v3__fill_2
XFILLER_15_1239 VDD VDD VSS VSS gf180mcu_as_sc_mcu7t3v3__fillcap_16
XFILLER_32_1531 VDD VDD VSS VSS gf180mcu_as_sc_mcu7t3v3__fill_1
XFILLER_7_412 VDD VDD VSS VSS gf180mcu_as_sc_mcu7t3v3__fill_1
XFILLER_7_434 VDD VDD VSS VSS gf180mcu_as_sc_mcu7t3v3__fill_2
XFILLER_8_979 VDD VDD VSS VSS gf180mcu_as_sc_mcu7t3v3__fillcap_16
XFILLER_99_31 VDD VDD VSS VSS gf180mcu_as_sc_mcu7t3v3__fillcap_16
XPHY_EDGE_ROW_63_3_Left_448 VDD VSS gf180mcu_as_sc_mcu7t3v3__tap_2
XTAP_TAPCELL_ROW_20_1175 VDD VSS gf180mcu_as_sc_mcu7t3v3__tap_2
XTAP_TAPCELL_ROW_20_1164 VDD VSS gf180mcu_as_sc_mcu7t3v3__tap_2
XFILLER_136_181 VDD VDD VSS VSS gf180mcu_as_sc_mcu7t3v3__fill_2
XFILLER_174_1056 VDD VDD VSS VSS gf180mcu_as_sc_mcu7t3v3__fillcap_16
XFILLER_26_1313 VDD VDD VSS VSS gf180mcu_as_sc_mcu7t3v3__fillcap_16
XTAP_TAPCELL_ROW_163_3_3210 VDD VSS gf180mcu_as_sc_mcu7t3v3__tap_2
XFILLER_24_1070 VDD VDD VSS VSS gf180mcu_as_sc_mcu7t3v3__fill_1
XFILLER_4_1153 VDD VDD VSS VSS gf180mcu_as_sc_mcu7t3v3__fill_2
XFILLER_0_42 VDD VDD VSS VSS gf180mcu_as_sc_mcu7t3v3__fill_1
XFILLER_65_168 VDD VDD VSS VSS gf180mcu_as_sc_mcu7t3v3__fillcap_4
XFILLER_19_585 VDD VDD VSS VSS gf180mcu_as_sc_mcu7t3v3__fillcap_16
XFILLER_207_664 VDD VDD VSS VSS gf180mcu_as_sc_mcu7t3v3__fillcap_16
XTAP_TAPCELL_ROW_27_1329 VDD VSS gf180mcu_as_sc_mcu7t3v3__tap_2
XTAP_TAPCELL_ROW_27_1318 VDD VSS gf180mcu_as_sc_mcu7t3v3__tap_2
XFILLER_163_1450 VDD VDD VSS VSS gf180mcu_as_sc_mcu7t3v3__fillcap_16
XFILLER_21_216 VDD VDD VSS VSS gf180mcu_as_sc_mcu7t3v3__fill_2
X_4801_ VDD VDD VSS VSS _4869_/CLK _4801_/D _4801_/Q gf180mcu_as_sc_mcu7t3v3__dfxtp_2
X_2993_ VDD VDD VSS VSS _3974_/A _3076_/B _3076_/C _3973_/D _2994_/C gf180mcu_as_sc_mcu7t3v3__ao22_2
X_4732_ VDD VDD VSS VSS _5267_/D _5267_/Q _4732_/B _4732_/C gf180mcu_as_sc_mcu7t3v3__ao21_2
XFILLER_33_1328 VDD VDD VSS VSS gf180mcu_as_sc_mcu7t3v3__fill_2
X_4663_ VDD VDD VSS VSS _4666_/B _4708_/C _4663_/B _4663_/A gf180mcu_as_sc_mcu7t3v3__aoi21_2
XFILLER_175_788 VDD VDD VSS VSS gf180mcu_as_sc_mcu7t3v3__fillcap_16
XFILLER_31_1030 VDD VDD VSS VSS gf180mcu_as_sc_mcu7t3v3__fillcap_4
X_3614_ VDD VDD VSS VSS _3615_/C _3614_/C _3660_/B _3985_/A gf180mcu_as_sc_mcu7t3v3__aoi21_2
XTAP_TAPCELL_ROW_190_2363 VDD VSS gf180mcu_as_sc_mcu7t3v3__tap_2
XTAP_TAPCELL_ROW_190_2352 VDD VSS gf180mcu_as_sc_mcu7t3v3__tap_2
XFILLER_134_107 VDD VDD VSS VSS gf180mcu_as_sc_mcu7t3v3__fillcap_16
X_4594_ VDD VDD VSS VSS _4601_/C _4742_/C _4594_/A gf180mcu_as_sc_mcu7t3v3__nor2_2
XFILLER_190_769 VDD VDD VSS VSS gf180mcu_as_sc_mcu7t3v3__fillcap_16
XFILLER_200_1399 VDD VDD VSS VSS gf180mcu_as_sc_mcu7t3v3__fillcap_16
X_3545_ VDD VDD VSS VSS _3563_/B _3797_/C _3798_/A gf180mcu_as_sc_mcu7t3v3__nand2_2
X_3476_ VDD VDD VSS VSS _4131_/A _3522_/C _3476_/C _3477_/C _3476_/D gf180mcu_as_sc_mcu7t3v3__aoi211_2
XFILLER_192_1189 VDD VDD VSS VSS gf180mcu_as_sc_mcu7t3v3__fillcap_16
XFILLER_9_1020 VDD VDD VSS VSS gf180mcu_as_sc_mcu7t3v3__fillcap_8
X_5215_ VDD VDD VSS VSS _5216_/CLK _5215_/D _5215_/Q gf180mcu_as_sc_mcu7t3v3__dfxtp_2
X_2427_ VDD VDD VSS VSS _3971_/A _2427_/A gf180mcu_as_sc_mcu7t3v3__inv_2
XFILLER_170_1465 VDD VDD VSS VSS gf180mcu_as_sc_mcu7t3v3__fill_2
X_5146_ VDD VDD VSS VSS _5220_/CLK _5146_/D _5146_/Q gf180mcu_as_sc_mcu7t3v3__dfxtp_2
XTAP_TAPCELL_ROW_87_3_2983 VDD VSS gf180mcu_as_sc_mcu7t3v3__tap_2
XFILLER_29_349 VDD VDD VSS VSS gf180mcu_as_sc_mcu7t3v3__fill_1
X_5077_ VDD VDD VSS VSS clkload2/A _5077_/D _5077_/Q gf180mcu_as_sc_mcu7t3v3__dfxtp_2
XFILLER_25_500 VDD VDD VSS VSS gf180mcu_as_sc_mcu7t3v3__fill_1
XFILLER_56_179 VDD VDD VSS VSS gf180mcu_as_sc_mcu7t3v3__fill_1
X_4028_ VDD VDD VSS VSS _4989_/Q _4158_/B _4240_/B _4117_/D _4989_/D gf180mcu_as_sc_mcu7t3v3__ao22_2
XTAP_TAPCELL_ROW_197_2517 VDD VSS gf180mcu_as_sc_mcu7t3v3__tap_2
XTAP_TAPCELL_ROW_197_2506 VDD VSS gf180mcu_as_sc_mcu7t3v3__tap_2
XFILLER_13_706 VDD VDD VSS VSS gf180mcu_as_sc_mcu7t3v3__fill_2
XFILLER_168_1383 VDD VDD VSS VSS gf180mcu_as_sc_mcu7t3v3__fillcap_16
XFILLER_197_324 VDD VDD VSS VSS gf180mcu_as_sc_mcu7t3v3__fillcap_4
XFILLER_44_37 VDD VDD VSS VSS gf180mcu_as_sc_mcu7t3v3__fillcap_16
XTAP_TAPCELL_ROW_0_698 VDD VSS gf180mcu_as_sc_mcu7t3v3__tap_2
XFILLER_129_1389 VDD VDD VSS VSS gf180mcu_as_sc_mcu7t3v3__fillcap_16
XFILLER_142_1523 VDD VDD VSS VSS gf180mcu_as_sc_mcu7t3v3__fillcap_16
XFILLER_197_368 VDD VDD VSS VSS gf180mcu_as_sc_mcu7t3v3__fillcap_16
XFILLER_200_317 VDD VDD VSS VSS gf180mcu_as_sc_mcu7t3v3__fillcap_16
XFILLER_209_1380 VDD VDD VSS VSS gf180mcu_as_sc_mcu7t3v3__fillcap_16
XFILLER_90_1433 VDD VDD VSS VSS gf180mcu_as_sc_mcu7t3v3__fillcap_16
XFILLER_100_65 VDD VDD VSS VSS gf180mcu_as_sc_mcu7t3v3__fillcap_4
XFILLER_21_772 VDD VDD VSS VSS gf180mcu_as_sc_mcu7t3v3__fillcap_16
XFILLER_51_1428 VDD VDD VSS VSS gf180mcu_as_sc_mcu7t3v3__fill_1
XFILLER_90_1477 VDD VDD VSS VSS gf180mcu_as_sc_mcu7t3v3__fill_2
XPHY_EDGE_ROW_110_1_Right_631 VDD VSS gf180mcu_as_sc_mcu7t3v3__tap_2
XTAP_TAPCELL_ROW_50_1_1595 VDD VSS gf180mcu_as_sc_mcu7t3v3__tap_2
XFILLER_60_69 VDD VDD VSS VSS gf180mcu_as_sc_mcu7t3v3__fill_2
XTAP_TAPCELL_ROW_156_1_1913 VDD VSS gf180mcu_as_sc_mcu7t3v3__tap_2
XFILLER_14_1294 VDD VDD VSS VSS gf180mcu_as_sc_mcu7t3v3__fill_1
XFILLER_176_69 VDD VDD VSS VSS gf180mcu_as_sc_mcu7t3v3__fillcap_16
XFILLER_5_938 VDD VDD VSS VSS gf180mcu_as_sc_mcu7t3v3__fill_2
XTAP_TAPCELL_ROW_168_3_3225 VDD VSS gf180mcu_as_sc_mcu7t3v3__tap_2
XFILLER_10_1169 VDD VDD VSS VSS gf180mcu_as_sc_mcu7t3v3__fill_2
XFILLER_180_279 VDD VDD VSS VSS gf180mcu_as_sc_mcu7t3v3__fill_2
XFILLER_175_1387 VDD VDD VSS VSS gf180mcu_as_sc_mcu7t3v3__fill_1
XFILLER_0_654 VDD VDD VSS VSS gf180mcu_as_sc_mcu7t3v3__fill_1
XFILLER_62_1568 VDD VDD VSS VSS gf180mcu_as_sc_mcu7t3v3__fill_1
XFILLER_21_1210 VDD VDD VSS VSS gf180mcu_as_sc_mcu7t3v3__fill_1
XFILLER_1_1326 VDD VDD VSS VSS gf180mcu_as_sc_mcu7t3v3__fillcap_4
XFILLER_85_99 VDD VDD VSS VSS gf180mcu_as_sc_mcu7t3v3__fillcap_16
XFILLER_112_1393 VDD VDD VSS VSS gf180mcu_as_sc_mcu7t3v3__fillcap_4
XFILLER_141_72 VDD VDD VSS VSS gf180mcu_as_sc_mcu7t3v3__fillcap_16
XFILLER_16_522 VDD VDD VSS VSS gf180mcu_as_sc_mcu7t3v3__fill_2
XFILLER_18_93 VDD VDD VSS VSS gf180mcu_as_sc_mcu7t3v3__fillcap_8
XFILLER_28_382 VDD VDD VSS VSS gf180mcu_as_sc_mcu7t3v3__fill_2
XFILLER_147_1434 VDD VDD VSS VSS gf180mcu_as_sc_mcu7t3v3__fill_1
XFILLER_189_836 VDD VDD VSS VSS gf180mcu_as_sc_mcu7t3v3__fillcap_4
XFILLER_204_645 VDD VDD VSS VSS gf180mcu_as_sc_mcu7t3v3__fillcap_16
XFILLER_188_335 VDD VDD VSS VSS gf180mcu_as_sc_mcu7t3v3__fill_1
XFILLER_189_858 VDD VDD VSS VSS gf180mcu_as_sc_mcu7t3v3__fillcap_16
XFILLER_204_667 VDD VDD VSS VSS gf180mcu_as_sc_mcu7t3v3__fillcap_16
XFILLER_15_1014 VDD VDD VSS VSS gf180mcu_as_sc_mcu7t3v3__fillcap_4
XFILLER_8_732 VDD VDD VSS VSS gf180mcu_as_sc_mcu7t3v3__fill_2
XTAP_TAPCELL_ROW_22_1215 VDD VSS gf180mcu_as_sc_mcu7t3v3__tap_2
XTAP_TAPCELL_ROW_22_1204 VDD VSS gf180mcu_as_sc_mcu7t3v3__tap_2
XFILLER_11_282 VDD VDD VSS VSS gf180mcu_as_sc_mcu7t3v3__fill_2
XFILLER_116_107 VDD VDD VSS VSS gf180mcu_as_sc_mcu7t3v3__fillcap_4
XFILLER_184_574 VDD VDD VSS VSS gf180mcu_as_sc_mcu7t3v3__fillcap_8
XFILLER_32_1361 VDD VDD VSS VSS gf180mcu_as_sc_mcu7t3v3__fillcap_4
XFILLER_32_1383 VDD VDD VSS VSS gf180mcu_as_sc_mcu7t3v3__fillcap_16
XTAP_TAPCELL_ROW_10_940 VDD VSS gf180mcu_as_sc_mcu7t3v3__tap_2
XTAP_TAPCELL_ROW_10_951 VDD VSS gf180mcu_as_sc_mcu7t3v3__tap_2
XFILLER_7_286 VDD VDD VSS VSS gf180mcu_as_sc_mcu7t3v3__fill_2
XFILLER_4_960 VDD VDD VSS VSS gf180mcu_as_sc_mcu7t3v3__fillcap_16
X_3330_ VDD VDD VSS VSS _3442_/B _3983_/A _3331_/D gf180mcu_as_sc_mcu7t3v3__or2_2
XFILLER_119_1558 VDD VDD VSS VSS gf180mcu_as_sc_mcu7t3v3__fillcap_8
XFILLER_124_173 VDD VDD VSS VSS gf180mcu_as_sc_mcu7t3v3__fill_2
XFILLER_26_1110 VDD VDD VSS VSS gf180mcu_as_sc_mcu7t3v3__fillcap_8
XFILLER_3_492 VDD VDD VSS VSS gf180mcu_as_sc_mcu7t3v3__fillcap_16
X_5000_ VDD VDD VSS VSS clkload1/A _5000_/D _5000_/Q gf180mcu_as_sc_mcu7t3v3__dfxtp_2
X_3261_ VDD VDD VSS VSS _3263_/B _3261_/B _3776_/A gf180mcu_as_sc_mcu7t3v3__nand2_2
X_3192_ VDD VDD VSS VSS _3193_/D _3192_/A _3240_/B _3239_/A _3192_/D gf180mcu_as_sc_mcu7t3v3__aoi22_2
XFILLER_26_1176 VDD VDD VSS VSS gf180mcu_as_sc_mcu7t3v3__fillcap_16
XFILLER_208_984 VDD VDD VSS VSS gf180mcu_as_sc_mcu7t3v3__fillcap_4
XFILLER_39_1504 VDD VDD VSS VSS gf180mcu_as_sc_mcu7t3v3__fill_2
XFILLER_14_18 VDD VDD VSS VSS gf180mcu_as_sc_mcu7t3v3__fillcap_16
XFILLER_179_346 VDD VDD VSS VSS gf180mcu_as_sc_mcu7t3v3__fillcap_4
XFILLER_22_514 VDD VDD VSS VSS gf180mcu_as_sc_mcu7t3v3__fillcap_8
XTAP_TAPCELL_ROW_192_2403 VDD VSS gf180mcu_as_sc_mcu7t3v3__tap_2
XFILLER_194_349 VDD VDD VSS VSS gf180mcu_as_sc_mcu7t3v3__fillcap_8
XFILLER_210_648 VDD VDD VSS VSS gf180mcu_as_sc_mcu7t3v3__fill_2
XFILLER_210_659 VDD VDD VSS VSS gf180mcu_as_sc_mcu7t3v3__fill_2
X_2976_ VDD VDD VSS VSS _3959_/A _3076_/B _3076_/C _3958_/A _2977_/C gf180mcu_as_sc_mcu7t3v3__ao22_2
X_4715_ VDD VDD VSS VSS _4717_/S _5260_/Q _5261_/Q _4716_/B gf180mcu_as_sc_mcu7t3v3__mux2_2
X_4646_ VDD VDD VSS VSS _4646_/D _4733_/A _5235_/Q _4646_/C _4647_/C gf180mcu_as_sc_mcu7t3v3__ao31_2
X_4577_ VDD VDD VSS VSS _4581_/B _5087_/Q _4579_/S gf180mcu_as_sc_mcu7t3v3__nand2_2
XFILLER_46_1519 VDD VDD VSS VSS gf180mcu_as_sc_mcu7t3v3__fill_2
XFILLER_85_1568 VDD VDD VSS VSS gf180mcu_as_sc_mcu7t3v3__fill_1
X_3528_ VDD VDD VSS VSS _3922_/B _3528_/B _3528_/A gf180mcu_as_sc_mcu7t3v3__nor2b_2
X_3459_ VDD VDD VSS VSS _3460_/A _4109_/D _3468_/B _3459_/C gf180mcu_as_sc_mcu7t3v3__ao21_2
XFILLER_135_1360 VDD VDD VSS VSS gf180mcu_as_sc_mcu7t3v3__fill_2
XPHY_EDGE_ROW_129_1_Left_339 VDD VSS gf180mcu_as_sc_mcu7t3v3__tap_2
X_5129_ VDD VDD VSS VSS _5197_/CLK _5129_/D _5129_/Q gf180mcu_as_sc_mcu7t3v3__dfxtp_2
XFILLER_176_6 VDD VDD VSS VSS gf180mcu_as_sc_mcu7t3v3__fillcap_16
XFILLER_26_831 VDD VDD VSS VSS gf180mcu_as_sc_mcu7t3v3__fill_1
XFILLER_55_36 VDD VDD VSS VSS gf180mcu_as_sc_mcu7t3v3__fillcap_16
XFILLER_37_190 VDD VDD VSS VSS gf180mcu_as_sc_mcu7t3v3__fillcap_8
XFILLER_92_1517 VDD VDD VSS VSS gf180mcu_as_sc_mcu7t3v3__fillcap_4
XFILLER_13_503 VDD VDD VSS VSS gf180mcu_as_sc_mcu7t3v3__fill_2
XFILLER_52_171 VDD VDD VSS VSS gf180mcu_as_sc_mcu7t3v3__fillcap_4
XFILLER_186_839 VDD VDD VSS VSS gf180mcu_as_sc_mcu7t3v3__fillcap_16
XFILLER_201_626 VDD VDD VSS VSS gf180mcu_as_sc_mcu7t3v3__fillcap_4
XFILLER_179_891 VDD VDD VSS VSS gf180mcu_as_sc_mcu7t3v3__fillcap_16
XFILLER_181_1380 VDD VDD VSS VSS gf180mcu_as_sc_mcu7t3v3__fillcap_4
XFILLER_198_699 VDD VDD VSS VSS gf180mcu_as_sc_mcu7t3v3__fillcap_16
XFILLER_201_648 VDD VDD VSS VSS gf180mcu_as_sc_mcu7t3v3__fillcap_16
XFILLER_205_1030 VDD VDD VSS VSS gf180mcu_as_sc_mcu7t3v3__fillcap_16
XFILLER_205_1052 VDD VDD VSS VSS gf180mcu_as_sc_mcu7t3v3__fillcap_16
XFILLER_138_221 VDD VDD VSS VSS gf180mcu_as_sc_mcu7t3v3__fill_1
XFILLER_142_1364 VDD VDD VSS VSS gf180mcu_as_sc_mcu7t3v3__fillcap_16
XTAP_TAPCELL_ROW_81_1_1689 VDD VSS gf180mcu_as_sc_mcu7t3v3__tap_2
XFILLER_5_702 VDD VDD VSS VSS gf180mcu_as_sc_mcu7t3v3__fillcap_4
XPHY_EDGE_ROW_111_1_Right_632 VDD VSS gf180mcu_as_sc_mcu7t3v3__tap_2
XFILLER_193_382 VDD VDD VSS VSS gf180mcu_as_sc_mcu7t3v3__fillcap_4
XFILLER_4_267 VDD VDD VSS VSS gf180mcu_as_sc_mcu7t3v3__fill_1
XFILLER_0_440 VDD VDD VSS VSS gf180mcu_as_sc_mcu7t3v3__fill_2
XFILLER_106_195 VDD VDD VSS VSS gf180mcu_as_sc_mcu7t3v3__fill_2
XFILLER_121_154 VDD VDD VSS VSS gf180mcu_as_sc_mcu7t3v3__fillcap_16
XFILLER_153_1482 VDD VDD VSS VSS gf180mcu_as_sc_mcu7t3v3__fillcap_4
XFILLER_23_1316 VDD VDD VSS VSS gf180mcu_as_sc_mcu7t3v3__fill_2
XTAP_TAPCELL_ROW_15_1052 VDD VSS gf180mcu_as_sc_mcu7t3v3__tap_2
XTAP_TAPCELL_ROW_15_1063 VDD VSS gf180mcu_as_sc_mcu7t3v3__tap_2
XFILLER_208_247 VDD VDD VSS VSS gf180mcu_as_sc_mcu7t3v3__fillcap_16
XFILLER_36_628 VDD VDD VSS VSS gf180mcu_as_sc_mcu7t3v3__fill_1
XFILLER_35_116 VDD VDD VSS VSS gf180mcu_as_sc_mcu7t3v3__fill_2
XFILLER_17_842 VDD VDD VSS VSS gf180mcu_as_sc_mcu7t3v3__fillcap_16
XFILLER_21_1084 VDD VDD VSS VSS gf180mcu_as_sc_mcu7t3v3__fillcap_8
XFILLER_16_363 VDD VDD VSS VSS gf180mcu_as_sc_mcu7t3v3__fillcap_16
XFILLER_186_1291 VDD VDD VSS VSS gf180mcu_as_sc_mcu7t3v3__fillcap_4
XFILLER_1_1189 VDD VDD VSS VSS gf180mcu_as_sc_mcu7t3v3__fill_1
XFILLER_205_976 VDD VDD VSS VSS gf180mcu_as_sc_mcu7t3v3__fillcap_4
XTAP_TAPCELL_ROW_50_3_2870 VDD VSS gf180mcu_as_sc_mcu7t3v3__tap_2
XFILLER_205_998 VDD VDD VSS VSS gf180mcu_as_sc_mcu7t3v3__fillcap_16
X_2830_ VDD VDD VSS VSS _4975_/D _2830_/B _5285_/Q _5284_/D gf180mcu_as_sc_mcu7t3v3__mux2_2
XFILLER_160_1431 VDD VDD VSS VSS gf180mcu_as_sc_mcu7t3v3__fillcap_16
XFILLER_121_1415 VDD VDD VSS VSS gf180mcu_as_sc_mcu7t3v3__fill_1
XFILLER_12_591 VDD VDD VSS VSS gf180mcu_as_sc_mcu7t3v3__fillcap_4
XFILLER_160_1453 VDD VDD VSS VSS gf180mcu_as_sc_mcu7t3v3__fillcap_4
XFILLER_176_349 VDD VDD VSS VSS gf180mcu_as_sc_mcu7t3v3__fillcap_4
XFILLER_30_1309 VDD VDD VSS VSS gf180mcu_as_sc_mcu7t3v3__fill_2
X_2761_ VDD VDD VSS VSS _4691_/A _2766_/B _2766_/C _2761_/D _2810_/C gf180mcu_as_sc_mcu7t3v3__ao211_2
XFILLER_121_1448 VDD VDD VSS VSS gf180mcu_as_sc_mcu7t3v3__fillcap_16
XFILLER_34_1489 VDD VDD VSS VSS gf180mcu_as_sc_mcu7t3v3__fill_2
X_5480_ VDD VDD VSS VSS _5480_/A _5480_/Y gf180mcu_as_sc_mcu7t3v3__buff_2
X_4500_ VDD VDD VSS VSS _4500_/S _5020_/Q _5049_/Q _4501_/B gf180mcu_as_sc_mcu7t3v3__mux2_2
X_2692_ VDD VDD VSS VSS _2701_/A _2692_/B _2692_/A _2693_/A gf180mcu_as_sc_mcu7t3v3__mux2_2
XANTENNA_1 VDD VDD VSS VSS _4793_/D gf180mcu_as_sc_mcu7t3v3__diode_2
XFILLER_201_1450 VDD VDD VSS VSS gf180mcu_as_sc_mcu7t3v3__fillcap_16
XFILLER_201_1472 VDD VDD VSS VSS gf180mcu_as_sc_mcu7t3v3__fillcap_16
X_4431_ VDD VDD VSS VSS _4431_/D _4510_/A _4431_/B _4431_/C _4432_/B gf180mcu_as_sc_mcu7t3v3__ao31_2
XFILLER_6_85 VDD VDD VSS VSS gf180mcu_as_sc_mcu7t3v3__fillcap_16
XFILLER_193_1240 VDD VDD VSS VSS gf180mcu_as_sc_mcu7t3v3__fillcap_16
XFILLER_193_1262 VDD VDD VSS VSS gf180mcu_as_sc_mcu7t3v3__fillcap_16
XFILLER_28_1227 VDD VDD VSS VSS gf180mcu_as_sc_mcu7t3v3__fillcap_16
X_4362_ VDD VDD VSS VSS _4363_/B _4362_/C _4362_/B _4512_/A gf180mcu_as_sc_mcu7t3v3__ao21b_2
XFILLER_112_121 VDD VDD VSS VSS gf180mcu_as_sc_mcu7t3v3__fillcap_4
Xfanout519 VDD VDD VSS VSS _4158_/D _4142_/D gf180mcu_as_sc_mcu7t3v3__buff_12
X_4293_ VDD VDD VSS VSS _4297_/S _5125_/Q _5126_/Q _5125_/D gf180mcu_as_sc_mcu7t3v3__mux2_2
X_3313_ VDD VDD VSS VSS _3968_/D _3403_/S _3313_/C _3401_/B _3315_/C gf180mcu_as_sc_mcu7t3v3__ao211_2
XTAP_TAPCELL_ROW_185_2240 VDD VSS gf180mcu_as_sc_mcu7t3v3__tap_2
XFILLER_6_1012 VDD VDD VSS VSS gf180mcu_as_sc_mcu7t3v3__fill_2
X_3244_ VDD VDD VSS VSS _3932_/A _3534_/A _3818_/B gf180mcu_as_sc_mcu7t3v3__and2_2
XTAP_TAPCELL_ROW_185_2251 VDD VSS gf180mcu_as_sc_mcu7t3v3__tap_2
XFILLER_41_1405 VDD VDD VSS VSS gf180mcu_as_sc_mcu7t3v3__fill_1
Xmesh_tile_945 VDD VDD VSS VSS ne_out[20] gf180mcu_as_sc_mcu7t3v3__tiel_4
Xmesh_tile_934 VDD VDD VSS VSS ne_out[9] gf180mcu_as_sc_mcu7t3v3__tiel_4
Xmesh_tile_978 VDD VDD VSS VSS north_out[19] gf180mcu_as_sc_mcu7t3v3__tiel_4
Xmesh_tile_967 VDD VDD VSS VSS north_out[8] gf180mcu_as_sc_mcu7t3v3__tiel_4
Xmesh_tile_956 VDD VDD VSS VSS ne_out[31] gf180mcu_as_sc_mcu7t3v3__tiel_4
X_3175_ VDD VDD VSS VSS _4154_/A _3240_/B _3239_/A _4154_/D _3181_/B gf180mcu_as_sc_mcu7t3v3__ao22_2
XTAP_TAPCELL_ROW_181_2159 VDD VSS gf180mcu_as_sc_mcu7t3v3__tap_2
XTAP_TAPCELL_ROW_181_2148 VDD VSS gf180mcu_as_sc_mcu7t3v3__tap_2
Xmesh_tile_989 VDD VDD VSS VSS north_out[30] gf180mcu_as_sc_mcu7t3v3__tiel_4
XFILLER_199_419 VDD VDD VSS VSS gf180mcu_as_sc_mcu7t3v3__fill_1
XFILLER_19_190 VDD VDD VSS VSS gf180mcu_as_sc_mcu7t3v3__fillcap_16
XPHY_EDGE_ROW_140_3_Left_525 VDD VSS gf180mcu_as_sc_mcu7t3v3__tap_2
XFILLER_23_801 VDD VDD VSS VSS gf180mcu_as_sc_mcu7t3v3__fillcap_16
XFILLER_39_1356 VDD VDD VSS VSS gf180mcu_as_sc_mcu7t3v3__fill_1
XTAP_TAPCELL_ROW_111_3_3054 VDD VSS gf180mcu_as_sc_mcu7t3v3__tap_2
XFILLER_165_1364 VDD VDD VSS VSS gf180mcu_as_sc_mcu7t3v3__fillcap_16
XFILLER_34_171 VDD VDD VSS VSS gf180mcu_as_sc_mcu7t3v3__fillcap_4
XFILLER_34_193 VDD VDD VSS VSS gf180mcu_as_sc_mcu7t3v3__fillcap_8
XPHY_EDGE_ROW_62_3_Right_99 VDD VSS gf180mcu_as_sc_mcu7t3v3__tap_2
XFILLER_126_1348 VDD VDD VSS VSS gf180mcu_as_sc_mcu7t3v3__fillcap_16
XFILLER_206_1361 VDD VDD VSS VSS gf180mcu_as_sc_mcu7t3v3__fillcap_4
XFILLER_23_878 VDD VDD VSS VSS gf180mcu_as_sc_mcu7t3v3__fill_1
XFILLER_206_1383 VDD VDD VSS VSS gf180mcu_as_sc_mcu7t3v3__fillcap_16
XFILLER_210_478 VDD VDD VSS VSS gf180mcu_as_sc_mcu7t3v3__fill_2
XFILLER_210_489 VDD VDD VSS VSS gf180mcu_as_sc_mcu7t3v3__fill_2
Xwire909 VDD VDD VSS VSS wire909/A _3947_/A gf180mcu_as_sc_mcu7t3v3__clkbuff_12
X_2959_ VDD VDD VSS VSS _3078_/B _4916_/Q _2962_/C gf180mcu_as_sc_mcu7t3v3__or2_2
XFILLER_157_38 VDD VDD VSS VSS gf180mcu_as_sc_mcu7t3v3__fillcap_16
XFILLER_182_319 VDD VDD VSS VSS gf180mcu_as_sc_mcu7t3v3__fill_1
XFILLER_191_820 VDD VDD VSS VSS gf180mcu_as_sc_mcu7t3v3__fillcap_16
XFILLER_198_1151 VDD VDD VSS VSS gf180mcu_as_sc_mcu7t3v3__fillcap_4
XFILLER_191_842 VDD VDD VSS VSS gf180mcu_as_sc_mcu7t3v3__fillcap_16
XFILLER_198_1173 VDD VDD VSS VSS gf180mcu_as_sc_mcu7t3v3__fillcap_16
X_4629_ VDD VDD VSS VSS _5220_/Q _4629_/B _4629_/C _4629_/D _5220_/D gf180mcu_as_sc_mcu7t3v3__ao22_2
XFILLER_137_1488 VDD VDD VSS VSS gf180mcu_as_sc_mcu7t3v3__fillcap_8
XFILLER_106_75 VDD VDD VSS VSS gf180mcu_as_sc_mcu7t3v3__fill_2
XTAP_TAPCELL_ROW_55_3_2885 VDD VSS gf180mcu_as_sc_mcu7t3v3__tap_2
XFILLER_66_68 VDD VDD VSS VSS gf180mcu_as_sc_mcu7t3v3__fill_1
XFILLER_17_105 VDD VDD VSS VSS gf180mcu_as_sc_mcu7t3v3__fill_2
XPHY_EDGE_ROW_72_3_Left_457 VDD VSS gf180mcu_as_sc_mcu7t3v3__tap_2
XFILLER_205_206 VDD VDD VSS VSS gf180mcu_as_sc_mcu7t3v3__fillcap_4
XFILLER_205_228 VDD VDD VSS VSS gf180mcu_as_sc_mcu7t3v3__fillcap_16
XFILLER_96_1450 VDD VDD VSS VSS gf180mcu_as_sc_mcu7t3v3__fill_1
XFILLER_96_1461 VDD VDD VSS VSS gf180mcu_as_sc_mcu7t3v3__fill_1
XTAP_TAPCELL_ROW_1_760 VDD VSS gf180mcu_as_sc_mcu7t3v3__tap_2
XFILLER_148_1540 VDD VDD VSS VSS gf180mcu_as_sc_mcu7t3v3__fill_1
XFILLER_2_1487 VDD VDD VSS VSS gf180mcu_as_sc_mcu7t3v3__fillcap_16
XFILLER_109_1524 VDD VDD VSS VSS gf180mcu_as_sc_mcu7t3v3__fill_1
XFILLER_198_34 VDD VDD VSS VSS gf180mcu_as_sc_mcu7t3v3__fill_1
XFILLER_57_1467 VDD VDD VSS VSS gf180mcu_as_sc_mcu7t3v3__fill_2
XFILLER_109_1568 VDD VDD VSS VSS gf180mcu_as_sc_mcu7t3v3__fill_1
XFILLER_13_344 VDD VDD VSS VSS gf180mcu_as_sc_mcu7t3v3__fillcap_4
XFILLER_15_72 VDD VDD VSS VSS gf180mcu_as_sc_mcu7t3v3__fillcap_16
XFILLER_202_979 VDD VDD VSS VSS gf180mcu_as_sc_mcu7t3v3__fillcap_16
XFILLER_40_174 VDD VDD VSS VSS gf180mcu_as_sc_mcu7t3v3__fill_1
XFILLER_12_1017 VDD VDD VSS VSS gf180mcu_as_sc_mcu7t3v3__fillcap_16
XFILLER_185_179 VDD VDD VSS VSS gf180mcu_as_sc_mcu7t3v3__fillcap_8
XFILLER_182_853 VDD VDD VSS VSS gf180mcu_as_sc_mcu7t3v3__fillcap_4
XPHY_EDGE_ROW_112_1_Right_633 VDD VSS gf180mcu_as_sc_mcu7t3v3__tap_2
XFILLER_147_60 VDD VDD VSS VSS gf180mcu_as_sc_mcu7t3v3__fillcap_8
XFILLER_181_341 VDD VDD VSS VSS gf180mcu_as_sc_mcu7t3v3__fillcap_8
XFILLER_181_352 VDD VDD VSS VSS gf180mcu_as_sc_mcu7t3v3__fillcap_8
XFILLER_68_1530 VDD VDD VSS VSS gf180mcu_as_sc_mcu7t3v3__fill_1
XFILLER_181_385 VDD VDD VSS VSS gf180mcu_as_sc_mcu7t3v3__fillcap_8
XFILLER_29_1536 VDD VDD VSS VSS gf180mcu_as_sc_mcu7t3v3__fillcap_4
XTAP_TAPCELL_ROW_17_1114 VDD VSS gf180mcu_as_sc_mcu7t3v3__tap_2
XTAP_TAPCELL_ROW_17_1103 VDD VSS gf180mcu_as_sc_mcu7t3v3__tap_2
XFILLER_155_1566 VDD VDD VSS VSS gf180mcu_as_sc_mcu7t3v3__fill_2
XFILLER_64_1449 VDD VDD VSS VSS gf180mcu_as_sc_mcu7t3v3__fill_2
XTAP_TAPCELL_ROW_104_1_1757 VDD VSS gf180mcu_as_sc_mcu7t3v3__tap_2
XFILLER_7_1332 VDD VDD VSS VSS gf180mcu_as_sc_mcu7t3v3__fillcap_16
XTAP_TAPCELL_ROW_116_3_3069 VDD VSS gf180mcu_as_sc_mcu7t3v3__tap_2
XTAP_TAPCELL_ROW_34_1472 VDD VSS gf180mcu_as_sc_mcu7t3v3__tap_2
Xinput160 VDD VDD VSS VSS nw_in[22] _4110_/A gf180mcu_as_sc_mcu7t3v3__buff_12
Xinput171 VDD VDD VSS VSS nw_in[32] _3522_/A gf180mcu_as_sc_mcu7t3v3__buff_12
XTAP_TAPCELL_ROW_34_1483 VDD VSS gf180mcu_as_sc_mcu7t3v3__tap_2
XFILLER_209_556 VDD VDD VSS VSS gf180mcu_as_sc_mcu7t3v3__fillcap_4
XFILLER_209_578 VDD VDD VSS VSS gf180mcu_as_sc_mcu7t3v3__fillcap_16
Xinput182 VDD VDD VSS VSS se_in[10] wire882/A gf180mcu_as_sc_mcu7t3v3__buff_12
Xinput193 VDD VDD VSS VSS se_in[20] _4097_/A gf180mcu_as_sc_mcu7t3v3__buff_12
XFILLER_149_1348 VDD VDD VSS VSS gf180mcu_as_sc_mcu7t3v3__fillcap_4
X_4980_ VDD VDD VSS VSS clkload2/A _4980_/D _4980_/Q gf180mcu_as_sc_mcu7t3v3__dfxtp_2
XFILLER_17_694 VDD VDD VSS VSS gf180mcu_as_sc_mcu7t3v3__fillcap_4
X_3931_ VDD VDD VSS VSS _3931_/B _3931_/A _3931_/Y gf180mcu_as_sc_mcu7t3v3__and2_2
XTAP_TAPCELL_ROW_81_3_2964 VDD VSS gf180mcu_as_sc_mcu7t3v3__tap_2
XFILLER_177_647 VDD VDD VSS VSS gf180mcu_as_sc_mcu7t3v3__fillcap_4
XFILLER_189_485 VDD VDD VSS VSS gf180mcu_as_sc_mcu7t3v3__fillcap_4
X_3862_ VDD VDD VSS VSS _3868_/C _3862_/A _3871_/B _3862_/C _3869_/C gf180mcu_as_sc_mcu7t3v3__ao31_2
XFILLER_31_174 VDD VDD VSS VSS gf180mcu_as_sc_mcu7t3v3__fillcap_8
X_2813_ VDD VDD VSS VSS _5479_/A _2833_/A _2825_/B gf180mcu_as_sc_mcu7t3v3__and2_2
XFILLER_34_1286 VDD VDD VSS VSS gf180mcu_as_sc_mcu7t3v3__fillcap_8
X_3793_ VDD VDD VSS VSS _3794_/B _3793_/A _3802_/B _3793_/C gf180mcu_as_sc_mcu7t3v3__ao21_2
XFILLER_30_1139 VDD VDD VSS VSS gf180mcu_as_sc_mcu7t3v3__fill_2
XFILLER_34_1297 VDD VDD VSS VSS gf180mcu_as_sc_mcu7t3v3__fillcap_16
X_2744_ VDD VDD VSS VSS _4947_/Q _2744_/B _2744_/A _5485_/A gf180mcu_as_sc_mcu7t3v3__mux2_2
X_2675_ VDD VDD VSS VSS _2676_/D _2729_/C _2722_/B _2675_/A gf180mcu_as_sc_mcu7t3v3__aoi21b_2
X_4414_ VDD VDD VSS VSS _4414_/D _4538_/A _4414_/B _4414_/C _4415_/B gf180mcu_as_sc_mcu7t3v3__ao31_2
X_4345_ VDD VDD VSS VSS _4346_/B _4345_/C _4345_/B _4554_/B gf180mcu_as_sc_mcu7t3v3__aoi21_2
XFILLER_28_1046 VDD VDD VSS VSS gf180mcu_as_sc_mcu7t3v3__fillcap_8
X_4276_ VDD VDD VSS VSS _4281_/S _5480_/A _5110_/Q _5110_/D gf180mcu_as_sc_mcu7t3v3__mux2_2
XTAP_TAPCELL_ROW_162_3_3206 VDD VSS gf180mcu_as_sc_mcu7t3v3__tap_2
XFILLER_45_1382 VDD VDD VSS VSS gf180mcu_as_sc_mcu7t3v3__fillcap_16
X_3227_ VDD VDD VSS VSS _3227_/S _3512_/A _3511_/A _3228_/B gf180mcu_as_sc_mcu7t3v3__mux2_2
XFILLER_36_27 VDD VDD VSS VSS gf180mcu_as_sc_mcu7t3v3__fillcap_4
X_3158_ VDD VDD VSS VSS _4136_/A _3240_/B _3239_/A _4135_/A _3164_/B gf180mcu_as_sc_mcu7t3v3__ao22_2
XTAP_TAPCELL_ROW_206_2696 VDD VSS gf180mcu_as_sc_mcu7t3v3__tap_2
XFILLER_36_970 VDD VDD VSS VSS gf180mcu_as_sc_mcu7t3v3__fillcap_16
XTAP_TAPCELL_ROW_130_1_1836 VDD VSS gf180mcu_as_sc_mcu7t3v3__tap_2
X_3089_ VDD VDD VSS VSS _4067_/A _3141_/B _3089_/C _3089_/Y _3691_/D gf180mcu_as_sc_mcu7t3v3__aoi211_2
XFILLER_202_209 VDD VDD VSS VSS gf180mcu_as_sc_mcu7t3v3__fillcap_16
XTAP_TAPCELL_ROW_142_3_3148 VDD VSS gf180mcu_as_sc_mcu7t3v3__tap_2
XFILLER_195_422 VDD VDD VSS VSS gf180mcu_as_sc_mcu7t3v3__fillcap_16
XFILLER_52_37 VDD VDD VSS VSS gf180mcu_as_sc_mcu7t3v3__fillcap_16
XFILLER_11_826 VDD VDD VSS VSS gf180mcu_as_sc_mcu7t3v3__fillcap_8
XFILLER_167_146 VDD VDD VSS VSS gf180mcu_as_sc_mcu7t3v3__fill_1
XFILLER_168_37 VDD VDD VSS VSS gf180mcu_as_sc_mcu7t3v3__fillcap_16
Xwire706 VDD VDD VSS VSS _3271_/Y _3442_/B gf180mcu_as_sc_mcu7t3v3__clkbuff_12
XFILLER_143_1492 VDD VDD VSS VSS gf180mcu_as_sc_mcu7t3v3__fill_2
XFILLER_202_1011 VDD VDD VSS VSS gf180mcu_as_sc_mcu7t3v3__fillcap_4
XFILLER_202_1033 VDD VDD VSS VSS gf180mcu_as_sc_mcu7t3v3__fillcap_16
XFILLER_52_1364 VDD VDD VSS VSS gf180mcu_as_sc_mcu7t3v3__fill_1
XFILLER_104_1465 VDD VDD VSS VSS gf180mcu_as_sc_mcu7t3v3__fill_1
XFILLER_52_1397 VDD VDD VSS VSS gf180mcu_as_sc_mcu7t3v3__fillcap_16
XFILLER_11_1072 VDD VDD VSS VSS gf180mcu_as_sc_mcu7t3v3__fillcap_4
XFILLER_184_69 VDD VDD VSS VSS gf180mcu_as_sc_mcu7t3v3__fillcap_16
XFILLER_2_502 VDD VDD VSS VSS gf180mcu_as_sc_mcu7t3v3__fillcap_8
XFILLER_190_193 VDD VDD VSS VSS gf180mcu_as_sc_mcu7t3v3__fill_2
XTAP_TAPCELL_ROW_76_1_1673 VDD VSS gf180mcu_as_sc_mcu7t3v3__tap_2
Xfanout861 VDD VDD VSS VSS _2736_/C _2729_/C gf180mcu_as_sc_mcu7t3v3__buff_12
XTAP_TAPCELL_ROW_6_863 VDD VSS gf180mcu_as_sc_mcu7t3v3__tap_2
XTAP_TAPCELL_ROW_6_852 VDD VSS gf180mcu_as_sc_mcu7t3v3__tap_2
XFILLER_150_1430 VDD VDD VSS VSS gf180mcu_as_sc_mcu7t3v3__fillcap_4
XTAP_TAPCELL_ROW_12_1000 VDD VSS gf180mcu_as_sc_mcu7t3v3__tap_2
Xfanout894 VDD VDD VSS VSS wire900/Y _3746_/D gf180mcu_as_sc_mcu7t3v3__buff_12
XFILLER_111_1414 VDD VDD VSS VSS gf180mcu_as_sc_mcu7t3v3__fill_2
XFILLER_150_1485 VDD VDD VSS VSS gf180mcu_as_sc_mcu7t3v3__fill_2
XFILLER_98_1523 VDD VDD VSS VSS gf180mcu_as_sc_mcu7t3v3__fillcap_16
XTAP_TAPCELL_ROW_86_3_2979 VDD VSS gf180mcu_as_sc_mcu7t3v3__tap_2
XFILLER_24_1499 VDD VDD VSS VSS gf180mcu_as_sc_mcu7t3v3__fillcap_4
XFILLER_206_559 VDD VDD VSS VSS gf180mcu_as_sc_mcu7t3v3__fillcap_16
XFILLER_33_428 VDD VDD VSS VSS gf180mcu_as_sc_mcu7t3v3__fill_1
XFILLER_187_912 VDD VDD VSS VSS gf180mcu_as_sc_mcu7t3v3__fillcap_16
XFILLER_199_750 VDD VDD VSS VSS gf180mcu_as_sc_mcu7t3v3__fillcap_16
XFILLER_199_772 VDD VDD VSS VSS gf180mcu_as_sc_mcu7t3v3__fillcap_16
XFILLER_198_271 VDD VDD VSS VSS gf180mcu_as_sc_mcu7t3v3__fillcap_4
XFILLER_13_174 VDD VDD VSS VSS gf180mcu_as_sc_mcu7t3v3__fillcap_16
XFILLER_70_1453 VDD VDD VSS VSS gf180mcu_as_sc_mcu7t3v3__fillcap_8
XFILLER_9_178 VDD VDD VSS VSS gf180mcu_as_sc_mcu7t3v3__fillcap_4
XTAP_TAPCELL_ROW_155_1_1909 VDD VSS gf180mcu_as_sc_mcu7t3v3__tap_2
XFILLER_6_874 VDD VDD VSS VSS gf180mcu_as_sc_mcu7t3v3__fill_1
XPHY_EDGE_ROW_113_1_Right_634 VDD VSS gf180mcu_as_sc_mcu7t3v3__tap_2
X_2460_ VDD VDD VSS VSS _4586_/S _5090_/Q _5003_/Q _2462_/B gf180mcu_as_sc_mcu7t3v3__mux2_2
XTAP_TAPCELL_ROW_36_1523 VDD VSS gf180mcu_as_sc_mcu7t3v3__tap_2
XTAP_TAPCELL_ROW_36_1512 VDD VSS gf180mcu_as_sc_mcu7t3v3__tap_2
XFILLER_190_1221 VDD VDD VSS VSS gf180mcu_as_sc_mcu7t3v3__fillcap_4
XFILLER_190_1243 VDD VDD VSS VSS gf180mcu_as_sc_mcu7t3v3__fillcap_16
XFILLER_25_1208 VDD VDD VSS VSS gf180mcu_as_sc_mcu7t3v3__fillcap_16
XFILLER_68_1393 VDD VDD VSS VSS gf180mcu_as_sc_mcu7t3v3__fillcap_4
X_4130_ VDD VDD VSS VSS _4130_/A _4130_/B _4130_/C _4130_/D _4131_/C gf180mcu_as_sc_mcu7t3v3__ao211_2
X_2391_ VDD VDD VSS VSS _2699_/A _5099_/Q gf180mcu_as_sc_mcu7t3v3__inv_2
XTAP_TAPCELL_ROW_36_1556 VDD VSS gf180mcu_as_sc_mcu7t3v3__tap_2
XTAP_TAPCELL_ROW_36_1545 VDD VSS gf180mcu_as_sc_mcu7t3v3__tap_2
XTAP_TAPCELL_ROW_36_1534 VDD VSS gf180mcu_as_sc_mcu7t3v3__tap_2
X_4061_ VDD VDD VSS VSS _4061_/A _4129_/B _4129_/C _4931_/Q _4063_/C gf180mcu_as_sc_mcu7t3v3__ao22_2
XFILLER_7_1184 VDD VDD VSS VSS gf180mcu_as_sc_mcu7t3v3__fillcap_4
X_3012_ VDD VDD VSS VSS _3992_/A _3042_/B _3012_/C _3012_/D _3013_/D gf180mcu_as_sc_mcu7t3v3__ao22_2
X_4963_ VDD VDD VSS VSS _5111_/CLK _4963_/D _4963_/Q gf180mcu_as_sc_mcu7t3v3__dfxtp_2
XFILLER_166_1481 VDD VDD VSS VSS gf180mcu_as_sc_mcu7t3v3__fillcap_16
XFILLER_36_1304 VDD VDD VSS VSS gf180mcu_as_sc_mcu7t3v3__fill_1
X_3914_ VDD VDD VSS VSS _3932_/D _3914_/A _3914_/B _3929_/A gf180mcu_as_sc_mcu7t3v3__ao21_2
XTAP_TAPCELL_ROW_201_2593 VDD VSS gf180mcu_as_sc_mcu7t3v3__tap_2
XTAP_TAPCELL_ROW_176_2047 VDD VSS gf180mcu_as_sc_mcu7t3v3__tap_2
XTAP_TAPCELL_ROW_176_2036 VDD VSS gf180mcu_as_sc_mcu7t3v3__tap_2
XFILLER_177_422 VDD VDD VSS VSS gf180mcu_as_sc_mcu7t3v3__fillcap_4
XFILLER_189_293 VDD VDD VSS VSS gf180mcu_as_sc_mcu7t3v3__fillcap_8
X_4894_ VDD VDD VSS VSS _4904_/CLK _4894_/D _4894_/Q gf180mcu_as_sc_mcu7t3v3__dfxtp_2
XFILLER_149_157 VDD VDD VSS VSS gf180mcu_as_sc_mcu7t3v3__fillcap_16
XFILLER_20_667 VDD VDD VSS VSS gf180mcu_as_sc_mcu7t3v3__fillcap_16
X_3845_ VDD VDD VSS VSS _3845_/B _3845_/A _3847_/S gf180mcu_as_sc_mcu7t3v3__or2_2
XFILLER_138_18 VDD VDD VSS VSS gf180mcu_as_sc_mcu7t3v3__fillcap_16
XFILLER_192_425 VDD VDD VSS VSS gf180mcu_as_sc_mcu7t3v3__fill_2
XFILLER_203_1364 VDD VDD VSS VSS gf180mcu_as_sc_mcu7t3v3__fillcap_16
X_3776_ VDD VDD VSS VSS _3780_/C _3776_/A _3776_/B _4161_/A gf180mcu_as_sc_mcu7t3v3__ao21_2
XFILLER_157_190 VDD VDD VSS VSS gf180mcu_as_sc_mcu7t3v3__fill_2
XPHY_EDGE_ROW_138_1_Left_348 VDD VSS gf180mcu_as_sc_mcu7t3v3__tap_2
X_2727_ VDD VDD VSS VSS _2734_/S _2727_/B _2727_/A _2728_/C gf180mcu_as_sc_mcu7t3v3__mux2_2
XFILLER_195_1154 VDD VDD VSS VSS gf180mcu_as_sc_mcu7t3v3__fillcap_16
Xoutput420 VDD VDD VSS VSS _4808_/Q south_out[3] gf180mcu_as_sc_mcu7t3v3__buff_12
XTAP_TAPCELL_ROW_210_2818 VDD VSS gf180mcu_as_sc_mcu7t3v3__tap_2
XTAP_TAPCELL_ROW_210_2807 VDD VSS gf180mcu_as_sc_mcu7t3v3__tap_2
Xclkbuf_leaf_6_clk_regs VDD VDD VSS VSS clkbuf_leaf_7_clk_regs/A _5214_/CLK gf180mcu_as_sc_mcu7t3v3__clkbuff_12
Xoutput453 VDD VDD VSS VSS _4906_/Q west_out[33] gf180mcu_as_sc_mcu7t3v3__buff_12
Xoutput442 VDD VDD VSS VSS _4896_/Q west_out[23] gf180mcu_as_sc_mcu7t3v3__buff_12
Xoutput431 VDD VDD VSS VSS _4886_/Q west_out[13] gf180mcu_as_sc_mcu7t3v3__buff_12
X_2658_ VDD VDD VSS VSS _2658_/S _5261_/Q _5249_/Q _2659_/B gf180mcu_as_sc_mcu7t3v3__mux2_2
XFILLER_134_1403 VDD VDD VSS VSS gf180mcu_as_sc_mcu7t3v3__fill_1
X_2589_ VDD VDD VSS VSS _2589_/Y _3907_/B _4949_/Q _2589_/A gf180mcu_as_sc_mcu7t3v3__aoi21b_2
X_4328_ VDD VDD VSS VSS _4328_/A _4328_/B _4328_/C _5156_/Q _5156_/D gf180mcu_as_sc_mcu7t3v3__ao22_2
X_4259_ VDD VDD VSS VSS _4643_/B _4643_/A _4259_/B _4259_/C _4260_/B gf180mcu_as_sc_mcu7t3v3__ao31_2
XTAP_TAPCELL_ROW_3_800 VDD VSS gf180mcu_as_sc_mcu7t3v3__tap_2
XTAP_TAPCELL_ROW_208_2758 VDD VSS gf180mcu_as_sc_mcu7t3v3__tap_2
XTAP_TAPCELL_ROW_208_2747 VDD VSS gf180mcu_as_sc_mcu7t3v3__tap_2
XFILLER_210_1335 VDD VDD VSS VSS gf180mcu_as_sc_mcu7t3v3__fillcap_4
XFILLER_86_177 VDD VDD VSS VSS gf180mcu_as_sc_mcu7t3v3__fill_2
XFILLER_210_1379 VDD VDD VSS VSS gf180mcu_as_sc_mcu7t3v3__fill_2
XFILLER_27_266 VDD VDD VSS VSS gf180mcu_as_sc_mcu7t3v3__fill_2
XFILLER_19_1524 VDD VDD VSS VSS gf180mcu_as_sc_mcu7t3v3__fill_1
XFILLER_196_731 VDD VDD VSS VSS gf180mcu_as_sc_mcu7t3v3__fillcap_4
XFILLER_196_753 VDD VDD VSS VSS gf180mcu_as_sc_mcu7t3v3__fillcap_16
XFILLER_208_1275 VDD VDD VSS VSS gf180mcu_as_sc_mcu7t3v3__fillcap_16
XFILLER_141_1418 VDD VDD VSS VSS gf180mcu_as_sc_mcu7t3v3__fillcap_4
XFILLER_195_241 VDD VDD VSS VSS gf180mcu_as_sc_mcu7t3v3__fill_1
XFILLER_195_252 VDD VDD VSS VSS gf180mcu_as_sc_mcu7t3v3__fillcap_16
XFILLER_208_1297 VDD VDD VSS VSS gf180mcu_as_sc_mcu7t3v3__fillcap_16
Xwire503 VDD VDD VSS VSS _3006_/Y _4777_/D gf180mcu_as_sc_mcu7t3v3__clkbuff_12
XFILLER_183_469 VDD VDD VSS VSS gf180mcu_as_sc_mcu7t3v3__fillcap_16
XFILLER_6_159 VDD VDD VSS VSS gf180mcu_as_sc_mcu7t3v3__fill_2
XFILLER_13_1189 VDD VDD VSS VSS gf180mcu_as_sc_mcu7t3v3__fill_1
XFILLER_178_1363 VDD VDD VSS VSS gf180mcu_as_sc_mcu7t3v3__fill_2
XFILLER_2_398 VDD VDD VSS VSS gf180mcu_as_sc_mcu7t3v3__fill_2
XFILLER_65_1566 VDD VDD VSS VSS gf180mcu_as_sc_mcu7t3v3__fill_2
XTAP_TAPCELL_ROW_31_1420 VDD VSS gf180mcu_as_sc_mcu7t3v3__tap_2
XFILLER_77_166 VDD VDD VSS VSS gf180mcu_as_sc_mcu7t3v3__fillcap_8
Xfanout680 VDD VDD VSS VSS _3727_/C _3656_/C gf180mcu_as_sc_mcu7t3v3__buff_12
Xfanout691 VDD VDD VSS VSS _3932_/Y _4128_/B gf180mcu_as_sc_mcu7t3v3__buff_12
XFILLER_20_1127 VDD VDD VSS VSS gf180mcu_as_sc_mcu7t3v3__fillcap_4
XFILLER_92_136 VDD VDD VSS VSS gf180mcu_as_sc_mcu7t3v3__fill_2
XFILLER_34_737 VDD VDD VSS VSS gf180mcu_as_sc_mcu7t3v3__fillcap_16
XPHY_EDGE_ROW_1_Left_212 VDD VSS gf180mcu_as_sc_mcu7t3v3__tap_2
XTAP_TAPCELL_ROW_29_1371 VDD VSS gf180mcu_as_sc_mcu7t3v3__tap_2
XTAP_TAPCELL_ROW_29_1360 VDD VSS gf180mcu_as_sc_mcu7t3v3__tap_2
XFILLER_186_230 VDD VDD VSS VSS gf180mcu_as_sc_mcu7t3v3__fill_2
XFILLER_186_263 VDD VDD VSS VSS gf180mcu_as_sc_mcu7t3v3__fillcap_8
XTAP_TAPCELL_ROW_25_1279 VDD VSS gf180mcu_as_sc_mcu7t3v3__tap_2
XFILLER_174_436 VDD VDD VSS VSS gf180mcu_as_sc_mcu7t3v3__fillcap_4
XFILLER_179_1116 VDD VDD VSS VSS gf180mcu_as_sc_mcu7t3v3__fillcap_4
XFILLER_186_296 VDD VDD VSS VSS gf180mcu_as_sc_mcu7t3v3__fillcap_16
X_3630_ VDD VDD VSS VSS _3631_/C _3630_/C _3729_/B _4001_/A gf180mcu_as_sc_mcu7t3v3__aoi21_2
XFILLER_139_190 VDD VDD VSS VSS gf180mcu_as_sc_mcu7t3v3__fillcap_16
XFILLER_179_1138 VDD VDD VSS VSS gf180mcu_as_sc_mcu7t3v3__fillcap_16
X_3561_ VDD VDD VSS VSS _3561_/Y _3561_/B _3561_/A gf180mcu_as_sc_mcu7t3v3__nor2_2
XPHY_EDGE_ROW_175_Right_38 VDD VSS gf180mcu_as_sc_mcu7t3v3__tap_2
XPHY_EDGE_ROW_90_3_Right_127 VDD VSS gf180mcu_as_sc_mcu7t3v3__tap_2
X_2512_ VDD VDD VSS VSS _5262_/Q _4662_/C _4708_/B _2517_/C gf180mcu_as_sc_mcu7t3v3__nand3_2
XFILLER_157_1447 VDD VDD VSS VSS gf180mcu_as_sc_mcu7t3v3__fillcap_16
XFILLER_196_1485 VDD VDD VSS VSS gf180mcu_as_sc_mcu7t3v3__fillcap_16
XFILLER_6_682 VDD VDD VSS VSS gf180mcu_as_sc_mcu7t3v3__fill_2
XPHY_EDGE_ROW_114_1_Right_635 VDD VSS gf180mcu_as_sc_mcu7t3v3__tap_2
X_3492_ VDD VDD VSS VSS _3492_/B _3525_/A _4831_/D gf180mcu_as_sc_mcu7t3v3__and2_2
X_5231_ VDD VDD VSS VSS _5256_/CLK _5231_/D _5231_/Q gf180mcu_as_sc_mcu7t3v3__dfxtp_2
X_2443_ VDD VDD VSS VSS _3731_/A _4106_/A gf180mcu_as_sc_mcu7t3v3__inv_2
XFILLER_29_1174 VDD VDD VSS VSS gf180mcu_as_sc_mcu7t3v3__fill_2
XFILLER_68_100 VDD VDD VSS VSS gf180mcu_as_sc_mcu7t3v3__fillcap_4
X_5162_ VDD VDD VSS VSS _5260_/CLK _5162_/D _5162_/Q gf180mcu_as_sc_mcu7t3v3__dfxtp_2
XFILLER_25_1049 VDD VDD VSS VSS gf180mcu_as_sc_mcu7t3v3__fill_1
X_5093_ VDD VDD VSS VSS clkload4/A _5093_/D _5093_/Q gf180mcu_as_sc_mcu7t3v3__dfxtp_2
X_4113_ VDD VDD VSS VSS _4113_/A _4130_/B _4113_/C _4113_/D _4114_/C gf180mcu_as_sc_mcu7t3v3__ao211_2
XTAP_TAPCELL_ROW_56_3_2890 VDD VSS gf180mcu_as_sc_mcu7t3v3__tap_2
XFILLER_68_177 VDD VDD VSS VSS gf180mcu_as_sc_mcu7t3v3__fillcap_8
XFILLER_204_53 VDD VDD VSS VSS gf180mcu_as_sc_mcu7t3v3__fillcap_16
XFILLER_209_150 VDD VDD VSS VSS gf180mcu_as_sc_mcu7t3v3__fillcap_4
X_4044_ VDD VDD VSS VSS _4991_/Q _4166_/B _4242_/B _4166_/D _4991_/D gf180mcu_as_sc_mcu7t3v3__ao22_2
XPHY_EDGE_ROW_184_Right_47 VDD VSS gf180mcu_as_sc_mcu7t3v3__tap_2
XTAP_TAPCELL_ROW_203_2644 VDD VSS gf180mcu_as_sc_mcu7t3v3__tap_2
XTAP_TAPCELL_ROW_203_2633 VDD VSS gf180mcu_as_sc_mcu7t3v3__tap_2
XFILLER_24_225 VDD VDD VSS VSS gf180mcu_as_sc_mcu7t3v3__fillcap_16
XFILLER_24_247 VDD VDD VSS VSS gf180mcu_as_sc_mcu7t3v3__fillcap_16
X_4946_ VDD VDD VSS VSS _4946_/CLK _4946_/D _4946_/Q gf180mcu_as_sc_mcu7t3v3__dfxtp_2
XTAP_TAPCELL_ROW_195_2467 VDD VSS gf180mcu_as_sc_mcu7t3v3__tap_2
XTAP_TAPCELL_ROW_195_2456 VDD VSS gf180mcu_as_sc_mcu7t3v3__tap_2
XFILLER_32_1009 VDD VDD VSS VSS gf180mcu_as_sc_mcu7t3v3__fillcap_4
X_4877_ VDD VDD VSS VSS _4924_/CLK _4877_/D _4877_/Q gf180mcu_as_sc_mcu7t3v3__dfxtp_2
XFILLER_193_734 VDD VDD VSS VSS gf180mcu_as_sc_mcu7t3v3__fillcap_16
XFILLER_20_453 VDD VDD VSS VSS gf180mcu_as_sc_mcu7t3v3__fill_2
XFILLER_21_976 VDD VDD VSS VSS gf180mcu_as_sc_mcu7t3v3__fillcap_4
XFILLER_21_998 VDD VDD VSS VSS gf180mcu_as_sc_mcu7t3v3__fillcap_16
XTAP_TAPCELL_ROW_125_1_1820 VDD VSS gf180mcu_as_sc_mcu7t3v3__tap_2
X_3828_ VDD VDD VSS VSS _3869_/A _4914_/Q _3835_/B gf180mcu_as_sc_mcu7t3v3__and2_2
XPHY_EDGE_ROW_193_Right_56 VDD VSS gf180mcu_as_sc_mcu7t3v3__tap_2
XTAP_TAPCELL_ROW_137_3_3132 VDD VSS gf180mcu_as_sc_mcu7t3v3__tap_2
XFILLER_140_1495 VDD VDD VSS VSS gf180mcu_as_sc_mcu7t3v3__fill_1
XFILLER_174_970 VDD VDD VSS VSS gf180mcu_as_sc_mcu7t3v3__fillcap_16
X_3759_ VDD VDD VSS VSS _3760_/C _3759_/C _3766_/B _4139_/A gf180mcu_as_sc_mcu7t3v3__aoi21_2
XFILLER_101_1479 VDD VDD VSS VSS gf180mcu_as_sc_mcu7t3v3__fillcap_4
XFILLER_145_182 VDD VDD VSS VSS gf180mcu_as_sc_mcu7t3v3__fillcap_4
XFILLER_165_38 VDD VDD VSS VSS gf180mcu_as_sc_mcu7t3v3__fillcap_16
XPHY_EDGE_ROW_81_3_Left_466 VDD VSS gf180mcu_as_sc_mcu7t3v3__tap_2
XTAP_TAPCELL_ROW_8_914 VDD VSS gf180mcu_as_sc_mcu7t3v3__tap_2
XTAP_TAPCELL_ROW_8_903 VDD VSS gf180mcu_as_sc_mcu7t3v3__tap_2
XFILLER_160_174 VDD VDD VSS VSS gf180mcu_as_sc_mcu7t3v3__fill_1
XFILLER_160_185 VDD VDD VSS VSS gf180mcu_as_sc_mcu7t3v3__fillcap_4
XFILLER_112_1531 VDD VDD VSS VSS gf180mcu_as_sc_mcu7t3v3__fill_1
XFILLER_60_1485 VDD VDD VSS VSS gf180mcu_as_sc_mcu7t3v3__fillcap_4
XFILLER_210_1165 VDD VDD VSS VSS gf180mcu_as_sc_mcu7t3v3__fillcap_4
XFILLER_21_1447 VDD VDD VSS VSS gf180mcu_as_sc_mcu7t3v3__fillcap_16
XFILLER_21_1469 VDD VDD VSS VSS gf180mcu_as_sc_mcu7t3v3__fill_1
XFILLER_16_737 VDD VDD VSS VSS gf180mcu_as_sc_mcu7t3v3__fillcap_4
XFILLER_182_1507 VDD VDD VSS VSS gf180mcu_as_sc_mcu7t3v3__fillcap_8
XFILLER_28_586 VDD VDD VSS VSS gf180mcu_as_sc_mcu7t3v3__fill_2
XFILLER_28_597 VDD VDD VSS VSS gf180mcu_as_sc_mcu7t3v3__fillcap_16
XFILLER_130_63 VDD VDD VSS VSS gf180mcu_as_sc_mcu7t3v3__fillcap_8
XFILLER_19_1310 VDD VDD VSS VSS gf180mcu_as_sc_mcu7t3v3__fillcap_16
XFILLER_31_718 VDD VDD VSS VSS gf180mcu_as_sc_mcu7t3v3__fill_2
XFILLER_130_96 VDD VDD VSS VSS gf180mcu_as_sc_mcu7t3v3__fillcap_8
XFILLER_208_1050 VDD VDD VSS VSS gf180mcu_as_sc_mcu7t3v3__fill_1
XFILLER_12_965 VDD VDD VSS VSS gf180mcu_as_sc_mcu7t3v3__fillcap_16
XFILLER_180_1275 VDD VDD VSS VSS gf180mcu_as_sc_mcu7t3v3__fillcap_16
XFILLER_12_998 VDD VDD VSS VSS gf180mcu_as_sc_mcu7t3v3__fill_1
XFILLER_180_1297 VDD VDD VSS VSS gf180mcu_as_sc_mcu7t3v3__fillcap_4
XFILLER_183_200 VDD VDD VSS VSS gf180mcu_as_sc_mcu7t3v3__fill_2
XFILLER_23_72 VDD VDD VSS VSS gf180mcu_as_sc_mcu7t3v3__fillcap_8
XFILLER_8_947 VDD VDD VSS VSS gf180mcu_as_sc_mcu7t3v3__fillcap_16
XFILLER_139_72 VDD VDD VSS VSS gf180mcu_as_sc_mcu7t3v3__fillcap_16
XFILLER_143_119 VDD VDD VSS VSS gf180mcu_as_sc_mcu7t3v3__fill_2
XTAP_TAPCELL_ROW_20_1165 VDD VSS gf180mcu_as_sc_mcu7t3v3__tap_2
XFILLER_174_1013 VDD VDD VSS VSS gf180mcu_as_sc_mcu7t3v3__fillcap_4
XTAP_TAPCELL_ROW_20_1176 VDD VSS gf180mcu_as_sc_mcu7t3v3__tap_2
XFILLER_180_995 VDD VDD VSS VSS gf180mcu_as_sc_mcu7t3v3__fillcap_16
XFILLER_151_174 VDD VDD VSS VSS gf180mcu_as_sc_mcu7t3v3__fillcap_16
XFILLER_2_162 VDD VDD VSS VSS gf180mcu_as_sc_mcu7t3v3__fillcap_8
XFILLER_117_1464 VDD VDD VSS VSS gf180mcu_as_sc_mcu7t3v3__fill_1
XTAP_TAPCELL_ROW_163_3_3211 VDD VSS gf180mcu_as_sc_mcu7t3v3__tap_2
XFILLER_65_114 VDD VDD VSS VSS gf180mcu_as_sc_mcu7t3v3__fill_1
XFILLER_187_1418 VDD VDD VSS VSS gf180mcu_as_sc_mcu7t3v3__fillcap_16
XFILLER_19_531 VDD VDD VSS VSS gf180mcu_as_sc_mcu7t3v3__fill_2
XFILLER_207_610 VDD VDD VSS VSS gf180mcu_as_sc_mcu7t3v3__fillcap_16
XFILLER_24_1060 VDD VDD VSS VSS gf180mcu_as_sc_mcu7t3v3__fillcap_8
XFILLER_4_1121 VDD VDD VSS VSS gf180mcu_as_sc_mcu7t3v3__fillcap_16
XFILLER_207_632 VDD VDD VSS VSS gf180mcu_as_sc_mcu7t3v3__fillcap_16
XFILLER_24_1082 VDD VDD VSS VSS gf180mcu_as_sc_mcu7t3v3__fill_2
XFILLER_0_1029 VDD VDD VSS VSS gf180mcu_as_sc_mcu7t3v3__fillcap_4
XFILLER_0_76 VDD VDD VSS VSS gf180mcu_as_sc_mcu7t3v3__fill_1
XFILLER_34_523 VDD VDD VSS VSS gf180mcu_as_sc_mcu7t3v3__fill_2
XFILLER_185_1186 VDD VDD VSS VSS gf180mcu_as_sc_mcu7t3v3__fillcap_4
XFILLER_34_545 VDD VDD VSS VSS gf180mcu_as_sc_mcu7t3v3__fill_1
X_4800_ VDD VDD VSS VSS _5214_/CLK _4800_/D _4800_/Q gf180mcu_as_sc_mcu7t3v3__dfxtp_2
XTAP_TAPCELL_ROW_27_1319 VDD VSS gf180mcu_as_sc_mcu7t3v3__tap_2
X_2992_ VDD VDD VSS VSS _3075_/S _3973_/A _3975_/A _2994_/B gf180mcu_as_sc_mcu7t3v3__mux2_2
XFILLER_37_1465 VDD VDD VSS VSS gf180mcu_as_sc_mcu7t3v3__fillcap_4
X_4731_ VDD VDD VSS VSS _5266_/D _5111_/Q _4731_/B _4731_/C gf180mcu_as_sc_mcu7t3v3__ao21_2
XFILLER_119_127 VDD VDD VSS VSS gf180mcu_as_sc_mcu7t3v3__fill_1
XFILLER_187_594 VDD VDD VSS VSS gf180mcu_as_sc_mcu7t3v3__fillcap_16
XFILLER_202_381 VDD VDD VSS VSS gf180mcu_as_sc_mcu7t3v3__fillcap_4
X_4662_ VDD VDD VSS VSS _4663_/B _4703_/A _4746_/A _4662_/C gf180mcu_as_sc_mcu7t3v3__ao21_2
X_3613_ VDD VDD VSS VSS _3613_/D _3984_/D _3728_/B _3728_/C _3614_/C gf180mcu_as_sc_mcu7t3v3__ao31_2
XTAP_TAPCELL_ROW_190_2353 VDD VSS gf180mcu_as_sc_mcu7t3v3__tap_2
XTAP_TAPCELL_ROW_190_2342 VDD VSS gf180mcu_as_sc_mcu7t3v3__tap_2
XFILLER_190_715 VDD VDD VSS VSS gf180mcu_as_sc_mcu7t3v3__fillcap_16
XFILLER_190_737 VDD VDD VSS VSS gf180mcu_as_sc_mcu7t3v3__fillcap_16
XFILLER_200_1345 VDD VDD VSS VSS gf180mcu_as_sc_mcu7t3v3__fillcap_16
XFILLER_31_1075 VDD VDD VSS VSS gf180mcu_as_sc_mcu7t3v3__fill_2
Xmax_cap611 VDD VDD VSS VSS _3772_/C _3761_/B gf180mcu_as_sc_mcu7t3v3__clkbuff_12
X_4593_ VDD VDD VSS VSS _4748_/A _4594_/A _4593_/Y gf180mcu_as_sc_mcu7t3v3__and2_2
XFILLER_127_171 VDD VDD VSS VSS gf180mcu_as_sc_mcu7t3v3__fillcap_16
XFILLER_200_1367 VDD VDD VSS VSS gf180mcu_as_sc_mcu7t3v3__fillcap_16
XPHY_EDGE_ROW_91_3_Right_128 VDD VSS gf180mcu_as_sc_mcu7t3v3__tap_2
X_3544_ VDD VDD VSS VSS _3787_/A _3818_/D _3544_/C _3797_/C gf180mcu_as_sc_mcu7t3v3__nand3_2
XFILLER_192_1135 VDD VDD VSS VSS gf180mcu_as_sc_mcu7t3v3__fillcap_16
X_3475_ VDD VDD VSS VSS _4126_/D _3500_/B _3475_/C _3475_/D _3476_/C gf180mcu_as_sc_mcu7t3v3__ao211_2
XFILLER_142_174 VDD VDD VSS VSS gf180mcu_as_sc_mcu7t3v3__fill_1
XFILLER_192_1157 VDD VDD VSS VSS gf180mcu_as_sc_mcu7t3v3__fillcap_16
XFILLER_88_217 VDD VDD VSS VSS gf180mcu_as_sc_mcu7t3v3__fillcap_4
XPHY_EDGE_ROW_115_1_Right_636 VDD VSS gf180mcu_as_sc_mcu7t3v3__tap_2
X_5214_ VDD VDD VSS VSS _5214_/CLK _5214_/D _5214_/Q gf180mcu_as_sc_mcu7t3v3__dfxtp_2
X_2426_ VDD VDD VSS VSS _3962_/A _2426_/A gf180mcu_as_sc_mcu7t3v3__inv_2
XFILLER_131_1406 VDD VDD VSS VSS gf180mcu_as_sc_mcu7t3v3__fillcap_8
XFILLER_29_306 VDD VDD VSS VSS gf180mcu_as_sc_mcu7t3v3__fillcap_4
XFILLER_44_1469 VDD VDD VSS VSS gf180mcu_as_sc_mcu7t3v3__fillcap_8
XFILLER_9_1087 VDD VDD VSS VSS gf180mcu_as_sc_mcu7t3v3__fillcap_4
X_5145_ VDD VDD VSS VSS _5220_/CLK _5145_/D _5145_/Q gf180mcu_as_sc_mcu7t3v3__dfxtp_2
XFILLER_151_18 VDD VDD VSS VSS gf180mcu_as_sc_mcu7t3v3__fillcap_16
X_5076_ VDD VDD VSS VSS clkload1/A _5076_/D _5076_/Q gf180mcu_as_sc_mcu7t3v3__dfxtp_2
X_4027_ VDD VDD VSS VSS _4027_/A _4027_/B _4027_/C _4240_/B _4116_/A gf180mcu_as_sc_mcu7t3v3__aoi211_2
XFILLER_198_804 VDD VDD VSS VSS gf180mcu_as_sc_mcu7t3v3__fill_1
XFILLER_71_117 VDD VDD VSS VSS gf180mcu_as_sc_mcu7t3v3__fillcap_16
XFILLER_71_139 VDD VDD VSS VSS gf180mcu_as_sc_mcu7t3v3__fill_1
XTAP_TAPCELL_ROW_70_1_1654 VDD VSS gf180mcu_as_sc_mcu7t3v3__tap_2
XTAP_TAPCELL_ROW_197_2507 VDD VSS gf180mcu_as_sc_mcu7t3v3__tap_2
XFILLER_0_1563 VDD VDD VSS VSS gf180mcu_as_sc_mcu7t3v3__fill_1
XFILLER_25_556 VDD VDD VSS VSS gf180mcu_as_sc_mcu7t3v3__fillcap_4
XFILLER_25_578 VDD VDD VSS VSS gf180mcu_as_sc_mcu7t3v3__fillcap_16
XFILLER_90_1401 VDD VDD VSS VSS gf180mcu_as_sc_mcu7t3v3__fillcap_16
XTAP_TAPCELL_ROW_0_699 VDD VSS gf180mcu_as_sc_mcu7t3v3__tap_2
XFILLER_178_561 VDD VDD VSS VSS gf180mcu_as_sc_mcu7t3v3__fill_1
X_4929_ VDD VDD VSS VSS _5082_/CLK _4929_/D _4929_/Q gf180mcu_as_sc_mcu7t3v3__dfxtp_2
XFILLER_100_88 VDD VDD VSS VSS gf180mcu_as_sc_mcu7t3v3__fill_1
XFILLER_205_1256 VDD VDD VSS VSS gf180mcu_as_sc_mcu7t3v3__fillcap_4
XFILLER_205_1278 VDD VDD VSS VSS gf180mcu_as_sc_mcu7t3v3__fillcap_16
XFILLER_21_762 VDD VDD VSS VSS gf180mcu_as_sc_mcu7t3v3__fillcap_8
XFILLER_51_1418 VDD VDD VSS VSS gf180mcu_as_sc_mcu7t3v3__fillcap_8
XFILLER_60_37 VDD VDD VSS VSS gf180mcu_as_sc_mcu7t3v3__fillcap_16
XTAP_TAPCELL_ROW_50_1_1596 VDD VSS gf180mcu_as_sc_mcu7t3v3__tap_2
XFILLER_142_1568 VDD VDD VSS VSS gf180mcu_as_sc_mcu7t3v3__fill_1
XFILLER_176_37 VDD VDD VSS VSS gf180mcu_as_sc_mcu7t3v3__fillcap_16
XFILLER_105_1390 VDD VDD VSS VSS gf180mcu_as_sc_mcu7t3v3__fillcap_16
XFILLER_10_1115 VDD VDD VSS VSS gf180mcu_as_sc_mcu7t3v3__fill_1
XFILLER_125_108 VDD VDD VSS VSS gf180mcu_as_sc_mcu7t3v3__fillcap_16
XFILLER_197_1046 VDD VDD VSS VSS gf180mcu_as_sc_mcu7t3v3__fillcap_4
XFILLER_197_1068 VDD VDD VSS VSS gf180mcu_as_sc_mcu7t3v3__fillcap_16
XTAP_TAPCELL_ROW_156_1_1914 VDD VSS gf180mcu_as_sc_mcu7t3v3__tap_2
XTAP_TAPCELL_ROW_168_3_3226 VDD VSS gf180mcu_as_sc_mcu7t3v3__tap_2
XFILLER_109_64 VDD VDD VSS VSS gf180mcu_as_sc_mcu7t3v3__fillcap_4
XFILLER_175_1311 VDD VDD VSS VSS gf180mcu_as_sc_mcu7t3v3__fillcap_8
XFILLER_179_1480 VDD VDD VSS VSS gf180mcu_as_sc_mcu7t3v3__fillcap_4
XFILLER_180_247 VDD VDD VSS VSS gf180mcu_as_sc_mcu7t3v3__fillcap_16
XFILLER_181_748 VDD VDD VSS VSS gf180mcu_as_sc_mcu7t3v3__fillcap_16
XFILLER_69_57 VDD VDD VSS VSS gf180mcu_as_sc_mcu7t3v3__fillcap_8
X_4878__1089 VDD VDD VSS VSS _4878_/D gf180mcu_as_sc_mcu7t3v3__tiel_4
XFILLER_133_174 VDD VDD VSS VSS gf180mcu_as_sc_mcu7t3v3__fillcap_16
XFILLER_125_52 VDD VDD VSS VSS gf180mcu_as_sc_mcu7t3v3__fillcap_16
XFILLER_192_69 VDD VDD VSS VSS gf180mcu_as_sc_mcu7t3v3__fillcap_16
XFILLER_125_74 VDD VDD VSS VSS gf180mcu_as_sc_mcu7t3v3__fill_1
XFILLER_209_908 VDD VDD VSS VSS gf180mcu_as_sc_mcu7t3v3__fill_2
XFILLER_47_136 VDD VDD VSS VSS gf180mcu_as_sc_mcu7t3v3__fillcap_4
XFILLER_47_169 VDD VDD VSS VSS gf180mcu_as_sc_mcu7t3v3__fill_1
XPHY_EDGE_ROW_207_Left_417 VDD VSS gf180mcu_as_sc_mcu7t3v3__tap_2
XFILLER_141_62 VDD VDD VSS VSS gf180mcu_as_sc_mcu7t3v3__fillcap_8
XFILLER_189_804 VDD VDD VSS VSS gf180mcu_as_sc_mcu7t3v3__fillcap_16
XFILLER_21_1255 VDD VDD VSS VSS gf180mcu_as_sc_mcu7t3v3__fillcap_4
XFILLER_186_1462 VDD VDD VSS VSS gf180mcu_as_sc_mcu7t3v3__fill_2
XFILLER_188_314 VDD VDD VSS VSS gf180mcu_as_sc_mcu7t3v3__fill_1
XFILLER_204_613 VDD VDD VSS VSS gf180mcu_as_sc_mcu7t3v3__fillcap_16
XFILLER_31_559 VDD VDD VSS VSS gf180mcu_as_sc_mcu7t3v3__fill_1
XFILLER_34_71 VDD VDD VSS VSS gf180mcu_as_sc_mcu7t3v3__fillcap_16
XFILLER_15_1026 VDD VDD VSS VSS gf180mcu_as_sc_mcu7t3v3__fillcap_8
XFILLER_8_711 VDD VDD VSS VSS gf180mcu_as_sc_mcu7t3v3__fill_2
XTAP_TAPCELL_ROW_22_1216 VDD VSS gf180mcu_as_sc_mcu7t3v3__tap_2
XTAP_TAPCELL_ROW_22_1205 VDD VSS gf180mcu_as_sc_mcu7t3v3__tap_2
XFILLER_200_874 VDD VDD VSS VSS gf180mcu_as_sc_mcu7t3v3__fill_1
XFILLER_8_755 VDD VDD VSS VSS gf180mcu_as_sc_mcu7t3v3__fillcap_4
XFILLER_184_586 VDD VDD VSS VSS gf180mcu_as_sc_mcu7t3v3__fill_2
XTAP_TAPCELL_ROW_10_941 VDD VSS gf180mcu_as_sc_mcu7t3v3__tap_2
XTAP_TAPCELL_ROW_10_952 VDD VSS gf180mcu_as_sc_mcu7t3v3__tap_2
XFILLER_176_1119 VDD VDD VSS VSS gf180mcu_as_sc_mcu7t3v3__fillcap_16
XFILLER_119_1504 VDD VDD VSS VSS gf180mcu_as_sc_mcu7t3v3__fillcap_4
XFILLER_124_130 VDD VDD VSS VSS gf180mcu_as_sc_mcu7t3v3__fillcap_16
XFILLER_180_770 VDD VDD VSS VSS gf180mcu_as_sc_mcu7t3v3__fillcap_16
XFILLER_28_1409 VDD VDD VSS VSS gf180mcu_as_sc_mcu7t3v3__fill_1
XFILLER_67_1447 VDD VDD VSS VSS gf180mcu_as_sc_mcu7t3v3__fillcap_4
XFILLER_193_1466 VDD VDD VSS VSS gf180mcu_as_sc_mcu7t3v3__fillcap_4
XFILLER_193_1488 VDD VDD VSS VSS gf180mcu_as_sc_mcu7t3v3__fillcap_4
X_3260_ VDD VDD VSS VSS _3261_/B _3263_/A _3520_/B gf180mcu_as_sc_mcu7t3v3__and2_2
XTAP_TAPCELL_ROW_75_1_1669 VDD VSS gf180mcu_as_sc_mcu7t3v3__tap_2
XFILLER_6_1227 VDD VDD VSS VSS gf180mcu_as_sc_mcu7t3v3__fillcap_4
X_3191_ VDD VDD VSS VSS _4161_/A _3237_/B _3238_/C _3191_/D _3193_/C gf180mcu_as_sc_mcu7t3v3__ao211_2
XFILLER_93_220 VDD VDD VSS VSS gf180mcu_as_sc_mcu7t3v3__fill_2
XTAP_TAPCELL_ROW_183_2190 VDD VSS gf180mcu_as_sc_mcu7t3v3__tap_2
XPHY_EDGE_ROW_147_1_Left_357 VDD VSS gf180mcu_as_sc_mcu7t3v3__tap_2
Xclkbuf_leaf_20_clk_regs VDD VDD VSS VSS clkload0/A _5260_/CLK gf180mcu_as_sc_mcu7t3v3__clkbuff_12
XFILLER_165_1568 VDD VDD VSS VSS gf180mcu_as_sc_mcu7t3v3__fill_1
XFILLER_34_364 VDD VDD VSS VSS gf180mcu_as_sc_mcu7t3v3__fillcap_16
XFILLER_210_605 VDD VDD VSS VSS gf180mcu_as_sc_mcu7t3v3__fill_2
XFILLER_61_183 VDD VDD VSS VSS gf180mcu_as_sc_mcu7t3v3__fillcap_8
XTAP_TAPCELL_ROW_192_2404 VDD VSS gf180mcu_as_sc_mcu7t3v3__tap_2
XFILLER_194_317 VDD VDD VSS VSS gf180mcu_as_sc_mcu7t3v3__fillcap_16
XFILLER_33_1115 VDD VDD VSS VSS gf180mcu_as_sc_mcu7t3v3__fillcap_4
X_4714_ VDD VDD VSS VSS _4721_/A _4714_/B _5106_/Q _5259_/D gf180mcu_as_sc_mcu7t3v3__mux2_2
X_2975_ VDD VDD VSS VSS _3008_/S _3956_/D _3960_/A _2977_/B gf180mcu_as_sc_mcu7t3v3__mux2_2
XFILLER_175_531 VDD VDD VSS VSS gf180mcu_as_sc_mcu7t3v3__fillcap_16
XFILLER_11_1402 VDD VDD VSS VSS gf180mcu_as_sc_mcu7t3v3__fill_2
X_4645_ VDD VDD VSS VSS _4645_/B _5234_/Q _4646_/D gf180mcu_as_sc_mcu7t3v3__and2_2
XFILLER_198_1399 VDD VDD VSS VSS gf180mcu_as_sc_mcu7t3v3__fillcap_16
X_4576_ VDD VDD VSS VSS _4576_/B _4591_/A _4583_/C gf180mcu_as_sc_mcu7t3v3__and2_2
X_3527_ VDD VDD VSS VSS _3527_/B _3624_/A _4838_/D gf180mcu_as_sc_mcu7t3v3__and2_2
XFILLER_85_1558 VDD VDD VSS VSS gf180mcu_as_sc_mcu7t3v3__fillcap_8
XPHY_EDGE_ROW_92_3_Right_129 VDD VSS gf180mcu_as_sc_mcu7t3v3__tap_2
XFILLER_172_1539 VDD VDD VSS VSS gf180mcu_as_sc_mcu7t3v3__fill_2
XFILLER_39_27 VDD VDD VSS VSS gf180mcu_as_sc_mcu7t3v3__fillcap_16
XFILLER_48_1380 VDD VDD VSS VSS gf180mcu_as_sc_mcu7t3v3__fill_1
XPHY_EDGE_ROW_116_1_Right_637 VDD VSS gf180mcu_as_sc_mcu7t3v3__tap_2
X_3458_ VDD VDD VSS VSS _4111_/A _3466_/B _3458_/C _3458_/D _3459_/C gf180mcu_as_sc_mcu7t3v3__ao211_2
XFILLER_76_209 VDD VDD VSS VSS gf180mcu_as_sc_mcu7t3v3__fillcap_8
X_3389_ VDD VDD VSS VSS _3467_/B _4037_/A _3389_/A _3391_/B gf180mcu_as_sc_mcu7t3v3__mux2_2
X_2409_ VDD VDD VSS VSS _4337_/B _5158_/Q gf180mcu_as_sc_mcu7t3v3__inv_2
XFILLER_130_199 VDD VDD VSS VSS gf180mcu_as_sc_mcu7t3v3__fillcap_16
X_5128_ VDD VDD VSS VSS _5278_/CLK _5128_/D _5128_/Q gf180mcu_as_sc_mcu7t3v3__dfxtp_2
XFILLER_29_169 VDD VDD VSS VSS gf180mcu_as_sc_mcu7t3v3__fill_1
XPHY_EDGE_ROW_79_1_Left_289 VDD VSS gf180mcu_as_sc_mcu7t3v3__tap_2
X_5059_ VDD VDD VSS VSS _5095_/CLK _5059_/D _5059_/Q gf180mcu_as_sc_mcu7t3v3__dfxtp_2
XFILLER_169_6 VDD VDD VSS VSS gf180mcu_as_sc_mcu7t3v3__fillcap_16
XFILLER_198_645 VDD VDD VSS VSS gf180mcu_as_sc_mcu7t3v3__fillcap_16
XFILLER_0_1393 VDD VDD VSS VSS gf180mcu_as_sc_mcu7t3v3__fill_1
XFILLER_13_559 VDD VDD VSS VSS gf180mcu_as_sc_mcu7t3v3__fill_1
XFILLER_186_807 VDD VDD VSS VSS gf180mcu_as_sc_mcu7t3v3__fillcap_16
XFILLER_198_667 VDD VDD VSS VSS gf180mcu_as_sc_mcu7t3v3__fillcap_16
XFILLER_9_508 VDD VDD VSS VSS gf180mcu_as_sc_mcu7t3v3__fillcap_8
XFILLER_185_328 VDD VDD VSS VSS gf180mcu_as_sc_mcu7t3v3__fillcap_4
XFILLER_55_1384 VDD VDD VSS VSS gf180mcu_as_sc_mcu7t3v3__fill_2
XFILLER_71_58 VDD VDD VSS VSS gf180mcu_as_sc_mcu7t3v3__fillcap_8
XFILLER_107_1485 VDD VDD VSS VSS gf180mcu_as_sc_mcu7t3v3__fill_1
XFILLER_177_1406 VDD VDD VSS VSS gf180mcu_as_sc_mcu7t3v3__fill_2
XFILLER_181_545 VDD VDD VSS VSS gf180mcu_as_sc_mcu7t3v3__fillcap_8
XFILLER_136_95 VDD VDD VSS VSS gf180mcu_as_sc_mcu7t3v3__fillcap_8
XPHY_EDGE_ROW_44_3_Left_429 VDD VSS gf180mcu_as_sc_mcu7t3v3__tap_2
XFILLER_114_1445 VDD VDD VSS VSS gf180mcu_as_sc_mcu7t3v3__fillcap_4
XFILLER_121_199 VDD VDD VSS VSS gf180mcu_as_sc_mcu7t3v3__fillcap_8
XFILLER_75_220 VDD VDD VSS VSS gf180mcu_as_sc_mcu7t3v3__fill_2
XTAP_TAPCELL_ROW_15_1053 VDD VSS gf180mcu_as_sc_mcu7t3v3__tap_2
XTAP_TAPCELL_ROW_15_1064 VDD VSS gf180mcu_as_sc_mcu7t3v3__tap_2
XFILLER_114_1489 VDD VDD VSS VSS gf180mcu_as_sc_mcu7t3v3__fill_2
XFILLER_97_1418 VDD VDD VSS VSS gf180mcu_as_sc_mcu7t3v3__fillcap_16
XPHY_EDGE_ROW_169_3_Left_554 VDD VSS gf180mcu_as_sc_mcu7t3v3__tap_2
XFILLER_21_1030 VDD VDD VSS VSS gf180mcu_as_sc_mcu7t3v3__fillcap_4
XFILLER_21_1041 VDD VDD VSS VSS gf180mcu_as_sc_mcu7t3v3__fillcap_8
XFILLER_21_1052 VDD VDD VSS VSS gf180mcu_as_sc_mcu7t3v3__fillcap_16
XFILLER_29_670 VDD VDD VSS VSS gf180mcu_as_sc_mcu7t3v3__fill_2
XFILLER_90_201 VDD VDD VSS VSS gf180mcu_as_sc_mcu7t3v3__fillcap_16
XFILLER_205_944 VDD VDD VSS VSS gf180mcu_as_sc_mcu7t3v3__fillcap_16
XFILLER_21_1096 VDD VDD VSS VSS gf180mcu_as_sc_mcu7t3v3__fill_2
XFILLER_35_139 VDD VDD VSS VSS gf180mcu_as_sc_mcu7t3v3__fill_1
XTAP_TAPCELL_ROW_50_3_2871 VDD VSS gf180mcu_as_sc_mcu7t3v3__tap_2
XFILLER_188_155 VDD VDD VSS VSS gf180mcu_as_sc_mcu7t3v3__fillcap_16
XFILLER_43_172 VDD VDD VSS VSS gf180mcu_as_sc_mcu7t3v3__fillcap_8
XFILLER_125_1530 VDD VDD VSS VSS gf180mcu_as_sc_mcu7t3v3__fill_1
XFILLER_176_317 VDD VDD VSS VSS gf180mcu_as_sc_mcu7t3v3__fill_2
XFILLER_182_1189 VDD VDD VSS VSS gf180mcu_as_sc_mcu7t3v3__fillcap_16
XFILLER_188_177 VDD VDD VSS VSS gf180mcu_as_sc_mcu7t3v3__fillcap_16
XFILLER_31_345 VDD VDD VSS VSS gf180mcu_as_sc_mcu7t3v3__fillcap_4
XFILLER_73_1473 VDD VDD VSS VSS gf180mcu_as_sc_mcu7t3v3__fill_2
X_2760_ VDD VDD VSS VSS _4691_/A _2765_/B _2765_/C _2809_/B _2810_/B gf180mcu_as_sc_mcu7t3v3__ao211_2
X_2691_ VDD VDD VSS VSS _2692_/B _4262_/B _2691_/B _2691_/C gf180mcu_as_sc_mcu7t3v3__ao21_2
XANTENNA_2 VDD VDD VSS VSS _4845_/D gf180mcu_as_sc_mcu7t3v3__diode_2
X_4430_ VDD VDD VSS VSS _4431_/D _4430_/B _4510_/A gf180mcu_as_sc_mcu7t3v3__nor2_2
XFILLER_6_53 VDD VDD VSS VSS gf180mcu_as_sc_mcu7t3v3__fillcap_16
XFILLER_28_1206 VDD VDD VSS VSS gf180mcu_as_sc_mcu7t3v3__fillcap_8
X_4361_ VDD VDD VSS VSS _5481_/A _4532_/C _4361_/C _4493_/B _4362_/C gf180mcu_as_sc_mcu7t3v3__ao22_2
X_4292_ VDD VDD VSS VSS _4329_/A _4327_/C _4627_/B _4297_/S gf180mcu_as_sc_mcu7t3v3__mux2_2
X_3312_ VDD VDD VSS VSS _4919_/Q _3402_/B _3402_/C _3967_/A _3313_/C gf180mcu_as_sc_mcu7t3v3__ao22_2
XFILLER_112_177 VDD VDD VSS VSS gf180mcu_as_sc_mcu7t3v3__fillcap_16
XTAP_TAPCELL_ROW_131_3_3113 VDD VSS gf180mcu_as_sc_mcu7t3v3__tap_2
X_3243_ VDD VDD VSS VSS _4804_/D _3760_/D _3243_/B _3243_/A gf180mcu_as_sc_mcu7t3v3__aoi21_2
XTAP_TAPCELL_ROW_185_2252 VDD VSS gf180mcu_as_sc_mcu7t3v3__tap_2
XTAP_TAPCELL_ROW_185_2241 VDD VSS gf180mcu_as_sc_mcu7t3v3__tap_2
Xmesh_tile_935 VDD VDD VSS VSS ne_out[10] gf180mcu_as_sc_mcu7t3v3__tiel_4
XFILLER_6_1079 VDD VDD VSS VSS gf180mcu_as_sc_mcu7t3v3__fillcap_4
XPHY_EDGE_ROW_40_1_Right_561 VDD VSS gf180mcu_as_sc_mcu7t3v3__tap_2
Xmesh_tile_968 VDD VDD VSS VSS north_out[9] gf180mcu_as_sc_mcu7t3v3__tiel_4
Xmesh_tile_957 VDD VDD VSS VSS ne_out[32] gf180mcu_as_sc_mcu7t3v3__tiel_4
Xmesh_tile_946 VDD VDD VSS VSS ne_out[21] gf180mcu_as_sc_mcu7t3v3__tiel_4
X_3174_ VDD VDD VSS VSS _3174_/B _3907_/A _4797_/D gf180mcu_as_sc_mcu7t3v3__and2_2
XTAP_TAPCELL_ROW_181_2149 VDD VSS gf180mcu_as_sc_mcu7t3v3__tap_2
XFILLER_81_212 VDD VDD VSS VSS gf180mcu_as_sc_mcu7t3v3__fillcap_8
Xmesh_tile_979 VDD VDD VSS VSS north_out[20] gf180mcu_as_sc_mcu7t3v3__tiel_4
XFILLER_35_640 VDD VDD VSS VSS gf180mcu_as_sc_mcu7t3v3__fill_1
XPHY_EDGE_ROW_90_3_Left_475 VDD VSS gf180mcu_as_sc_mcu7t3v3__tap_2
XTAP_TAPCELL_ROW_111_3_3055 VDD VSS gf180mcu_as_sc_mcu7t3v3__tap_2
XFILLER_22_312 VDD VDD VSS VSS gf180mcu_as_sc_mcu7t3v3__fill_2
XFILLER_195_626 VDD VDD VSS VSS gf180mcu_as_sc_mcu7t3v3__fillcap_4
XFILLER_195_648 VDD VDD VSS VSS gf180mcu_as_sc_mcu7t3v3__fillcap_16
X_2958_ VDD VDD VSS VSS _3008_/S _3938_/D _3942_/A _2961_/B gf180mcu_as_sc_mcu7t3v3__mux2_2
XFILLER_202_1259 VDD VDD VSS VSS gf180mcu_as_sc_mcu7t3v3__fillcap_16
XFILLER_52_1568 VDD VDD VSS VSS gf180mcu_as_sc_mcu7t3v3__fill_1
X_4628_ VDD VDD VSS VSS _4628_/S _4628_/B _4628_/A _4629_/D gf180mcu_as_sc_mcu7t3v3__mux2_2
X_2889_ VDD VDD VSS VSS _3548_/A _3776_/A _3776_/B _3227_/S gf180mcu_as_sc_mcu7t3v3__nand3_2
XFILLER_194_1049 VDD VDD VSS VSS gf180mcu_as_sc_mcu7t3v3__fillcap_16
XFILLER_2_706 VDD VDD VSS VSS gf180mcu_as_sc_mcu7t3v3__fill_1
X_4559_ VDD VDD VSS VSS _4559_/S _5027_/Q _5056_/Q _4560_/B gf180mcu_as_sc_mcu7t3v3__mux2_2
XTAP_TAPCELL_ROW_45_1_1580 VDD VSS gf180mcu_as_sc_mcu7t3v3__tap_2
XFILLER_137_1456 VDD VDD VSS VSS gf180mcu_as_sc_mcu7t3v3__fill_2
XFILLER_173_38 VDD VDD VSS VSS gf180mcu_as_sc_mcu7t3v3__fillcap_16
XFILLER_57_220 VDD VDD VSS VSS gf180mcu_as_sc_mcu7t3v3__fill_2
XPHY_EDGE_ROW_117_1_Right_638 VDD VSS gf180mcu_as_sc_mcu7t3v3__tap_2
XTAP_TAPCELL_ROW_55_3_2886 VDD VSS gf180mcu_as_sc_mcu7t3v3__tap_2
XFILLER_2_1433 VDD VDD VSS VSS gf180mcu_as_sc_mcu7t3v3__fill_2
XFILLER_17_139 VDD VDD VSS VSS gf180mcu_as_sc_mcu7t3v3__fill_1
XTAP_TAPCELL_ROW_1_761 VDD VSS gf180mcu_as_sc_mcu7t3v3__tap_2
XTAP_TAPCELL_ROW_1_750 VDD VSS gf180mcu_as_sc_mcu7t3v3__tap_2
XFILLER_122_86 VDD VDD VSS VSS gf180mcu_as_sc_mcu7t3v3__fillcap_16
XFILLER_148_1530 VDD VDD VSS VSS gf180mcu_as_sc_mcu7t3v3__fillcap_8
XFILLER_199_976 VDD VDD VSS VSS gf180mcu_as_sc_mcu7t3v3__fillcap_4
XFILLER_202_925 VDD VDD VSS VSS gf180mcu_as_sc_mcu7t3v3__fillcap_16
XFILLER_109_1558 VDD VDD VSS VSS gf180mcu_as_sc_mcu7t3v3__fillcap_8
XFILLER_199_998 VDD VDD VSS VSS gf180mcu_as_sc_mcu7t3v3__fillcap_16
XFILLER_201_413 VDD VDD VSS VSS gf180mcu_as_sc_mcu7t3v3__fillcap_4
XFILLER_201_424 VDD VDD VSS VSS gf180mcu_as_sc_mcu7t3v3__fill_1
XFILLER_202_947 VDD VDD VSS VSS gf180mcu_as_sc_mcu7t3v3__fillcap_16
XFILLER_40_164 VDD VDD VSS VSS gf180mcu_as_sc_mcu7t3v3__fillcap_8
XFILLER_9_349 VDD VDD VSS VSS gf180mcu_as_sc_mcu7t3v3__fill_1
XFILLER_182_821 VDD VDD VSS VSS gf180mcu_as_sc_mcu7t3v3__fillcap_16
XFILLER_31_50 VDD VDD VSS VSS gf180mcu_as_sc_mcu7t3v3__fillcap_16
XTAP_TAPCELL_ROW_124_1_1816 VDD VSS gf180mcu_as_sc_mcu7t3v3__tap_2
XTAP_TAPCELL_ROW_136_3_3128 VDD VSS gf180mcu_as_sc_mcu7t3v3__tap_2
XFILLER_31_72 VDD VDD VSS VSS gf180mcu_as_sc_mcu7t3v3__fillcap_8
XFILLER_31_94 VDD VDD VSS VSS gf180mcu_as_sc_mcu7t3v3__fillcap_16
XFILLER_68_1520 VDD VDD VSS VSS gf180mcu_as_sc_mcu7t3v3__fill_1
XFILLER_147_72 VDD VDD VSS VSS gf180mcu_as_sc_mcu7t3v3__fillcap_16
XFILLER_177_1269 VDD VDD VSS VSS gf180mcu_as_sc_mcu7t3v3__fill_2
XFILLER_29_1515 VDD VDD VSS VSS gf180mcu_as_sc_mcu7t3v3__fill_2
XFILLER_68_1564 VDD VDD VSS VSS gf180mcu_as_sc_mcu7t3v3__fillcap_4
XPHY_EDGE_ROW_79_1_Right_600 VDD VSS gf180mcu_as_sc_mcu7t3v3__tap_2
XTAP_TAPCELL_ROW_17_1115 VDD VSS gf180mcu_as_sc_mcu7t3v3__tap_2
XTAP_TAPCELL_ROW_17_1104 VDD VSS gf180mcu_as_sc_mcu7t3v3__tap_2
XFILLER_1_772 VDD VDD VSS VSS gf180mcu_as_sc_mcu7t3v3__fill_2
XTAP_TAPCELL_ROW_104_1_1758 VDD VSS gf180mcu_as_sc_mcu7t3v3__tap_2
XFILLER_209_524 VDD VDD VSS VSS gf180mcu_as_sc_mcu7t3v3__fillcap_16
XFILLER_23_1136 VDD VDD VSS VSS gf180mcu_as_sc_mcu7t3v3__fill_1
Xinput150 VDD VDD VSS VSS nw_in[13] _4038_/A gf180mcu_as_sc_mcu7t3v3__buff_12
Xinput161 VDD VDD VSS VSS nw_in[23] _4119_/A gf180mcu_as_sc_mcu7t3v3__buff_12
Xinput172 VDD VDD VSS VSS nw_in[33] _3553_/A gf180mcu_as_sc_mcu7t3v3__buff_12
XTAP_TAPCELL_ROW_34_1484 VDD VSS gf180mcu_as_sc_mcu7t3v3__tap_2
XTAP_TAPCELL_ROW_34_1473 VDD VSS gf180mcu_as_sc_mcu7t3v3__tap_2
XFILLER_40_1450 VDD VDD VSS VSS gf180mcu_as_sc_mcu7t3v3__fill_1
XFILLER_63_212 VDD VDD VSS VSS gf180mcu_as_sc_mcu7t3v3__fillcap_8
Xinput183 VDD VDD VSS VSS se_in[11] wire881/A gf180mcu_as_sc_mcu7t3v3__buff_12
Xinput194 VDD VDD VSS VSS se_in[21] wire875/A gf180mcu_as_sc_mcu7t3v3__buff_12
X_3930_ VDD VDD VSS VSS _3930_/A _4023_/B _4023_/C _4915_/Q _3934_/C gf180mcu_as_sc_mcu7t3v3__ao22_2
XFILLER_75_1568 VDD VDD VSS VSS gf180mcu_as_sc_mcu7t3v3__fill_1
XFILLER_162_1527 VDD VDD VSS VSS gf180mcu_as_sc_mcu7t3v3__fill_2
XFILLER_162_1538 VDD VDD VSS VSS gf180mcu_as_sc_mcu7t3v3__fill_2
XFILLER_204_295 VDD VDD VSS VSS gf180mcu_as_sc_mcu7t3v3__fillcap_16
XFILLER_31_142 VDD VDD VSS VSS gf180mcu_as_sc_mcu7t3v3__fillcap_16
X_3861_ VDD VDD VSS VSS _5127_/Q _4691_/A _3862_/C gf180mcu_as_sc_mcu7t3v3__and2_2
XTAP_TAPCELL_ROW_81_3_2965 VDD VSS gf180mcu_as_sc_mcu7t3v3__tap_2
XFILLER_176_147 VDD VDD VSS VSS gf180mcu_as_sc_mcu7t3v3__fillcap_16
XFILLER_31_186 VDD VDD VSS VSS gf180mcu_as_sc_mcu7t3v3__fill_2
X_4873__1094 VDD VDD VSS VSS _4873_/D gf180mcu_as_sc_mcu7t3v3__tiel_4
X_3792_ VDD VDD VSS VSS _3792_/A _3792_/B _3792_/C _3792_/D _3793_/C gf180mcu_as_sc_mcu7t3v3__ao211_2
X_2812_ VDD VDD VSS VSS _4974_/D _2812_/B _4755_/Q _4754_/D gf180mcu_as_sc_mcu7t3v3__mux2_2
XFILLER_192_629 VDD VDD VSS VSS gf180mcu_as_sc_mcu7t3v3__fillcap_16
XFILLER_199_1450 VDD VDD VSS VSS gf180mcu_as_sc_mcu7t3v3__fillcap_16
XFILLER_75_2 VDD VDD VSS VSS gf180mcu_as_sc_mcu7t3v3__fill_2
X_2743_ VDD VDD VSS VSS _4947_/Q _2743_/B _2743_/A _5484_/A gf180mcu_as_sc_mcu7t3v3__mux2_2
XFILLER_185_681 VDD VDD VSS VSS gf180mcu_as_sc_mcu7t3v3__fillcap_16
XFILLER_199_1472 VDD VDD VSS VSS gf180mcu_as_sc_mcu7t3v3__fillcap_16
X_2674_ VDD VDD VSS VSS _5198_/Q _2858_/B _2674_/C _2674_/D _2676_/C gf180mcu_as_sc_mcu7t3v3__ao211_2
XFILLER_132_217 VDD VDD VSS VSS gf180mcu_as_sc_mcu7t3v3__fillcap_4
X_4413_ VDD VDD VSS VSS _4414_/D _4413_/B _4538_/A gf180mcu_as_sc_mcu7t3v3__nor2_2
X_4344_ VDD VDD VSS VSS _4350_/C _4344_/B _4344_/C _4345_/C _4554_/B gf180mcu_as_sc_mcu7t3v3__aoi211_2
XFILLER_28_1058 VDD VDD VSS VSS gf180mcu_as_sc_mcu7t3v3__fill_2
XFILLER_8_1119 VDD VDD VSS VSS gf180mcu_as_sc_mcu7t3v3__fillcap_4
XPHY_EDGE_ROW_176_Left_386 VDD VSS gf180mcu_as_sc_mcu7t3v3__tap_2
X_4275_ VDD VDD VSS VSS _4281_/S _5479_/A _5109_/Q _5109_/D gf180mcu_as_sc_mcu7t3v3__mux2_2
XTAP_TAPCELL_ROW_162_3_3207 VDD VSS gf180mcu_as_sc_mcu7t3v3__tap_2
XFILLER_39_220 VDD VDD VSS VSS gf180mcu_as_sc_mcu7t3v3__fill_2
X_3226_ VDD VDD VSS VSS _3914_/A _3247_/B _3228_/A _3229_/C _3226_/D gf180mcu_as_sc_mcu7t3v3__oai211_2
XFILLER_132_1364 VDD VDD VSS VSS gf180mcu_as_sc_mcu7t3v3__fillcap_16
XFILLER_27_415 VDD VDD VSS VSS gf180mcu_as_sc_mcu7t3v3__fillcap_4
XFILLER_54_212 VDD VDD VSS VSS gf180mcu_as_sc_mcu7t3v3__fillcap_8
XPHY_EDGE_ROW_41_1_Right_562 VDD VSS gf180mcu_as_sc_mcu7t3v3__tap_2
X_3157_ VDD VDD VSS VSS _4132_/A _3182_/B _3157_/C _3157_/Y _3760_/D gf180mcu_as_sc_mcu7t3v3__aoi211_2
XFILLER_199_206 VDD VDD VSS VSS gf180mcu_as_sc_mcu7t3v3__fillcap_4
XTAP_TAPCELL_ROW_206_2697 VDD VSS gf180mcu_as_sc_mcu7t3v3__tap_2
XFILLER_199_228 VDD VDD VSS VSS gf180mcu_as_sc_mcu7t3v3__fillcap_16
X_3088_ VDD VDD VSS VSS _3141_/B _3088_/B _3088_/C _3089_/C gf180mcu_as_sc_mcu7t3v3__nor3_2
XFILLER_23_632 VDD VDD VSS VSS gf180mcu_as_sc_mcu7t3v3__fillcap_4
XFILLER_35_492 VDD VDD VSS VSS gf180mcu_as_sc_mcu7t3v3__fillcap_16
XFILLER_210_210 VDD VDD VSS VSS gf180mcu_as_sc_mcu7t3v3__fill_2
XFILLER_52_27 VDD VDD VSS VSS gf180mcu_as_sc_mcu7t3v3__fillcap_8
XFILLER_11_838 VDD VDD VSS VSS gf180mcu_as_sc_mcu7t3v3__fill_2
XFILLER_196_979 VDD VDD VSS VSS gf180mcu_as_sc_mcu7t3v3__fillcap_16
XFILLER_23_698 VDD VDD VSS VSS gf180mcu_as_sc_mcu7t3v3__fill_2
XPHY_EDGE_ROW_185_Left_395 VDD VSS gf180mcu_as_sc_mcu7t3v3__tap_2
XFILLER_17_1463 VDD VDD VSS VSS gf180mcu_as_sc_mcu7t3v3__fillcap_4
XFILLER_183_607 VDD VDD VSS VSS gf180mcu_as_sc_mcu7t3v3__fillcap_4
XFILLER_183_629 VDD VDD VSS VSS gf180mcu_as_sc_mcu7t3v3__fill_1
XTAP_TAPCELL_ROW_96_1_1732 VDD VSS gf180mcu_as_sc_mcu7t3v3__tap_2
XFILLER_104_1477 VDD VDD VSS VSS gf180mcu_as_sc_mcu7t3v3__fill_2
XFILLER_176_681 VDD VDD VSS VSS gf180mcu_as_sc_mcu7t3v3__fillcap_4
XFILLER_178_1501 VDD VDD VSS VSS gf180mcu_as_sc_mcu7t3v3__fillcap_4
XFILLER_182_139 VDD VDD VSS VSS gf180mcu_as_sc_mcu7t3v3__fillcap_16
XFILLER_87_1406 VDD VDD VSS VSS gf180mcu_as_sc_mcu7t3v3__fill_1
XFILLER_175_180 VDD VDD VSS VSS gf180mcu_as_sc_mcu7t3v3__fillcap_16
XFILLER_178_1567 VDD VDD VSS VSS gf180mcu_as_sc_mcu7t3v3__fill_2
XFILLER_184_37 VDD VDD VSS VSS gf180mcu_as_sc_mcu7t3v3__fillcap_16
XFILLER_2_514 VDD VDD VSS VSS gf180mcu_as_sc_mcu7t3v3__fill_2
XFILLER_89_142 VDD VDD VSS VSS gf180mcu_as_sc_mcu7t3v3__fill_2
XTAP_TAPCELL_ROW_76_1_1674 VDD VSS gf180mcu_as_sc_mcu7t3v3__tap_2
XTAP_TAPCELL_ROW_6_853 VDD VSS gf180mcu_as_sc_mcu7t3v3__tap_2
XFILLER_150_1453 VDD VDD VSS VSS gf180mcu_as_sc_mcu7t3v3__fillcap_16
XFILLER_19_916 VDD VDD VSS VSS gf180mcu_as_sc_mcu7t3v3__fill_1
XPHY_EDGE_ROW_118_1_Right_639 VDD VSS gf180mcu_as_sc_mcu7t3v3__tap_2
XTAP_TAPCELL_ROW_12_1001 VDD VSS gf180mcu_as_sc_mcu7t3v3__tap_2
Xfanout862 VDD VDD VSS VSS _2832_/S _2736_/C gf180mcu_as_sc_mcu7t3v3__buff_12
Xfanout884 VDD VDD VSS VSS _3594_/D _3416_/D gf180mcu_as_sc_mcu7t3v3__buff_12
XTAP_TAPCELL_ROW_6_864 VDD VSS gf180mcu_as_sc_mcu7t3v3__tap_2
Xfanout895 VDD VDD VSS VSS _4753_/A _3831_/A gf180mcu_as_sc_mcu7t3v3__buff_12
XFILLER_206_505 VDD VDD VSS VSS gf180mcu_as_sc_mcu7t3v3__fillcap_16
XFILLER_206_527 VDD VDD VSS VSS gf180mcu_as_sc_mcu7t3v3__fillcap_16
XFILLER_45_212 VDD VDD VSS VSS gf180mcu_as_sc_mcu7t3v3__fillcap_8
XFILLER_27_960 VDD VDD VSS VSS gf180mcu_as_sc_mcu7t3v3__fillcap_16
XFILLER_27_982 VDD VDD VSS VSS gf180mcu_as_sc_mcu7t3v3__fillcap_16
XFILLER_33_418 VDD VDD VSS VSS gf180mcu_as_sc_mcu7t3v3__fill_2
XFILLER_183_1240 VDD VDD VSS VSS gf180mcu_as_sc_mcu7t3v3__fillcap_16
XFILLER_26_61 VDD VDD VSS VSS gf180mcu_as_sc_mcu7t3v3__fill_2
XFILLER_13_120 VDD VDD VSS VSS gf180mcu_as_sc_mcu7t3v3__fillcap_16
XFILLER_13_142 VDD VDD VSS VSS gf180mcu_as_sc_mcu7t3v3__fillcap_16
XFILLER_158_103 VDD VDD VSS VSS gf180mcu_as_sc_mcu7t3v3__fill_2
XFILLER_183_1262 VDD VDD VSS VSS gf180mcu_as_sc_mcu7t3v3__fillcap_8
XFILLER_18_1227 VDD VDD VSS VSS gf180mcu_as_sc_mcu7t3v3__fillcap_16
XFILLER_186_434 VDD VDD VSS VSS gf180mcu_as_sc_mcu7t3v3__fill_1
XFILLER_158_169 VDD VDD VSS VSS gf180mcu_as_sc_mcu7t3v3__fillcap_4
XFILLER_201_276 VDD VDD VSS VSS gf180mcu_as_sc_mcu7t3v3__fillcap_4
XFILLER_9_146 VDD VDD VSS VSS gf180mcu_as_sc_mcu7t3v3__fillcap_16
XFILLER_201_298 VDD VDD VSS VSS gf180mcu_as_sc_mcu7t3v3__fillcap_16
XFILLER_10_893 VDD VDD VSS VSS gf180mcu_as_sc_mcu7t3v3__fillcap_8
XFILLER_6_853 VDD VDD VSS VSS gf180mcu_as_sc_mcu7t3v3__fill_1
XFILLER_114_217 VDD VDD VSS VSS gf180mcu_as_sc_mcu7t3v3__fillcap_4
XPHY_EDGE_ROW_156_1_Left_366 VDD VSS gf180mcu_as_sc_mcu7t3v3__tap_2
XTAP_TAPCELL_ROW_36_1513 VDD VSS gf180mcu_as_sc_mcu7t3v3__tap_2
XFILLER_174_70 VDD VDD VSS VSS gf180mcu_as_sc_mcu7t3v3__fillcap_16
X_2390_ VDD VDD VSS VSS _2534_/A _5277_/Q gf180mcu_as_sc_mcu7t3v3__inv_2
XTAP_TAPCELL_ROW_36_1557 VDD VSS gf180mcu_as_sc_mcu7t3v3__tap_2
XTAP_TAPCELL_ROW_36_1546 VDD VSS gf180mcu_as_sc_mcu7t3v3__tap_2
XTAP_TAPCELL_ROW_36_1535 VDD VSS gf180mcu_as_sc_mcu7t3v3__tap_2
XTAP_TAPCELL_ROW_36_1524 VDD VSS gf180mcu_as_sc_mcu7t3v3__tap_2
XFILLER_116_1348 VDD VDD VSS VSS gf180mcu_as_sc_mcu7t3v3__fillcap_4
XFILLER_155_1397 VDD VDD VSS VSS gf180mcu_as_sc_mcu7t3v3__fillcap_16
XFILLER_1_580 VDD VDD VSS VSS gf180mcu_as_sc_mcu7t3v3__fill_1
XFILLER_29_1378 VDD VDD VSS VSS gf180mcu_as_sc_mcu7t3v3__fill_2
XFILLER_42_1523 VDD VDD VSS VSS gf180mcu_as_sc_mcu7t3v3__fillcap_8
XPHY_EDGE_ROW_93_1_Left_303 VDD VSS gf180mcu_as_sc_mcu7t3v3__tap_2
X_4060_ VDD VDD VSS VSS _4993_/Q _4166_/B _4244_/B _4166_/D _4993_/D gf180mcu_as_sc_mcu7t3v3__ao22_2
XFILLER_42_1556 VDD VDD VSS VSS gf180mcu_as_sc_mcu7t3v3__fillcap_8
X_3011_ VDD VDD VSS VSS _3129_/B _4922_/Q _3012_/D gf180mcu_as_sc_mcu7t3v3__or2_2
XFILLER_188_1151 VDD VDD VSS VSS gf180mcu_as_sc_mcu7t3v3__fillcap_4
XFILLER_188_1173 VDD VDD VSS VSS gf180mcu_as_sc_mcu7t3v3__fillcap_16
XFILLER_36_256 VDD VDD VSS VSS gf180mcu_as_sc_mcu7t3v3__fillcap_4
XFILLER_51_204 VDD VDD VSS VSS gf180mcu_as_sc_mcu7t3v3__fillcap_4
XFILLER_17_492 VDD VDD VSS VSS gf180mcu_as_sc_mcu7t3v3__fillcap_16
X_4962_ VDD VDD VSS VSS _5111_/CLK _4962_/D _4962_/Q gf180mcu_as_sc_mcu7t3v3__dfxtp_2
XFILLER_196_209 VDD VDD VSS VSS gf180mcu_as_sc_mcu7t3v3__fillcap_16
XFILLER_32_451 VDD VDD VSS VSS gf180mcu_as_sc_mcu7t3v3__fillcap_4
X_4893_ VDD VDD VSS VSS _4904_/CLK _4893_/D _4893_/Q gf180mcu_as_sc_mcu7t3v3__dfxtp_2
X_3913_ VDD VDD VSS VSS _3913_/Y _4117_/D _3913_/A gf180mcu_as_sc_mcu7t3v3__nor2_2
XTAP_TAPCELL_ROW_201_2594 VDD VSS gf180mcu_as_sc_mcu7t3v3__tap_2
XTAP_TAPCELL_ROW_176_2037 VDD VSS gf180mcu_as_sc_mcu7t3v3__tap_2
XFILLER_149_114 VDD VDD VSS VSS gf180mcu_as_sc_mcu7t3v3__fillcap_16
XFILLER_178_979 VDD VDD VSS VSS gf180mcu_as_sc_mcu7t3v3__fillcap_16
XFILLER_32_473 VDD VDD VSS VSS gf180mcu_as_sc_mcu7t3v3__fillcap_16
XFILLER_75_1398 VDD VDD VSS VSS gf180mcu_as_sc_mcu7t3v3__fillcap_16
X_3844_ VDD VDD VSS VSS _4912_/D _3844_/C _3844_/B _3844_/A gf180mcu_as_sc_mcu7t3v3__aoi21_2
XTAP_TAPCELL_ROW_176_2048 VDD VSS gf180mcu_as_sc_mcu7t3v3__tap_2
XFILLER_127_1488 VDD VDD VSS VSS gf180mcu_as_sc_mcu7t3v3__fillcap_4
XFILLER_203_1310 VDD VDD VSS VSS gf180mcu_as_sc_mcu7t3v3__fillcap_16
XFILLER_203_1332 VDD VDD VSS VSS gf180mcu_as_sc_mcu7t3v3__fillcap_16
XFILLER_164_139 VDD VDD VSS VSS gf180mcu_as_sc_mcu7t3v3__fillcap_8
XFILLER_34_1084 VDD VDD VSS VSS gf180mcu_as_sc_mcu7t3v3__fill_1
XPHY_EDGE_ROW_121_3_Left_506 VDD VSS gf180mcu_as_sc_mcu7t3v3__tap_2
X_3775_ VDD VDD VSS VSS _3775_/A _3775_/B _3775_/C _4866_/D _3831_/A gf180mcu_as_sc_mcu7t3v3__aoi211_2
XFILLER_195_1100 VDD VDD VSS VSS gf180mcu_as_sc_mcu7t3v3__fillcap_16
XFILLER_195_1122 VDD VDD VSS VSS gf180mcu_as_sc_mcu7t3v3__fillcap_16
X_2726_ VDD VDD VSS VSS _5163_/Q _4267_/S _4279_/S _5187_/Q _2727_/B gf180mcu_as_sc_mcu7t3v3__ao22_2
XFILLER_12_1371 VDD VDD VSS VSS gf180mcu_as_sc_mcu7t3v3__fill_2
XPHY_EDGE_ROW_88_1_Left_298 VDD VSS gf180mcu_as_sc_mcu7t3v3__tap_2
Xoutput410 VDD VDD VSS VSS _4830_/Q south_out[25] gf180mcu_as_sc_mcu7t3v3__buff_12
X_2657_ VDD VDD VSS VSS _2657_/Y _2668_/B _2657_/B _2657_/C _2657_/D gf180mcu_as_sc_mcu7t3v3__aoi22_2
XTAP_TAPCELL_ROW_210_2819 VDD VSS gf180mcu_as_sc_mcu7t3v3__tap_2
XTAP_TAPCELL_ROW_210_2808 VDD VSS gf180mcu_as_sc_mcu7t3v3__tap_2
XFILLER_154_18 VDD VDD VSS VSS gf180mcu_as_sc_mcu7t3v3__fillcap_16
XFILLER_172_183 VDD VDD VSS VSS gf180mcu_as_sc_mcu7t3v3__fill_1
XFILLER_86_1450 VDD VDD VSS VSS gf180mcu_as_sc_mcu7t3v3__fill_1
Xoutput443 VDD VDD VSS VSS _4897_/Q west_out[24] gf180mcu_as_sc_mcu7t3v3__buff_12
Xoutput432 VDD VDD VSS VSS _4887_/Q west_out[14] gf180mcu_as_sc_mcu7t3v3__buff_12
Xoutput421 VDD VDD VSS VSS _4809_/Q south_out[4] gf180mcu_as_sc_mcu7t3v3__buff_12
XFILLER_120_209 VDD VDD VSS VSS gf180mcu_as_sc_mcu7t3v3__fillcap_8
XFILLER_47_1434 VDD VDD VSS VSS gf180mcu_as_sc_mcu7t3v3__fillcap_8
Xoutput454 VDD VDD VSS VSS _4876_/Q west_out[3] gf180mcu_as_sc_mcu7t3v3__buff_12
X_2588_ VDD VDD VSS VSS _2588_/Y _2588_/B _2588_/A gf180mcu_as_sc_mcu7t3v3__nand2b_2
XFILLER_86_123 VDD VDD VSS VSS gf180mcu_as_sc_mcu7t3v3__fillcap_16
X_4327_ VDD VDD VSS VSS _4328_/C _5233_/Q _4329_/A _4327_/C gf180mcu_as_sc_mcu7t3v3__ao21_2
XFILLER_47_27 VDD VDD VSS VSS gf180mcu_as_sc_mcu7t3v3__fillcap_16
X_4258_ VDD VDD VSS VSS _4260_/A _4258_/C _4259_/B _4643_/A gf180mcu_as_sc_mcu7t3v3__aoi21_2
XTAP_TAPCELL_ROW_3_801 VDD VSS gf180mcu_as_sc_mcu7t3v3__tap_2
XTAP_TAPCELL_ROW_208_2748 VDD VSS gf180mcu_as_sc_mcu7t3v3__tap_2
XFILLER_210_1325 VDD VDD VSS VSS gf180mcu_as_sc_mcu7t3v3__fill_1
X_3209_ VDD VDD VSS VSS _3209_/B _3907_/A _4800_/D gf180mcu_as_sc_mcu7t3v3__and2_2
XTAP_TAPCELL_ROW_208_2759 VDD VSS gf180mcu_as_sc_mcu7t3v3__tap_2
XFILLER_27_212 VDD VDD VSS VSS gf180mcu_as_sc_mcu7t3v3__fillcap_8
X_4189_ VDD VDD VSS VSS _4249_/B _4191_/B _4191_/C _5027_/Q _5027_/D gf180mcu_as_sc_mcu7t3v3__ao22_2
XFILLER_15_418 VDD VDD VSS VSS gf180mcu_as_sc_mcu7t3v3__fill_2
XFILLER_28_779 VDD VDD VSS VSS gf180mcu_as_sc_mcu7t3v3__fillcap_16
XPHY_EDGE_ROW_42_1_Right_563 VDD VSS gf180mcu_as_sc_mcu7t3v3__tap_2
XFILLER_103_88 VDD VDD VSS VSS gf180mcu_as_sc_mcu7t3v3__fillcap_16
XFILLER_203_508 VDD VDD VSS VSS gf180mcu_as_sc_mcu7t3v3__fillcap_16
XFILLER_208_1221 VDD VDD VSS VSS gf180mcu_as_sc_mcu7t3v3__fillcap_4
XFILLER_208_1243 VDD VDD VSS VSS gf180mcu_as_sc_mcu7t3v3__fillcap_16
XFILLER_24_963 VDD VDD VSS VSS gf180mcu_as_sc_mcu7t3v3__fillcap_4
XPHY_EDGE_ROW_193_Left_403 VDD VSS gf180mcu_as_sc_mcu7t3v3__tap_2
XFILLER_10_101 VDD VDD VSS VSS gf180mcu_as_sc_mcu7t3v3__fillcap_4
XFILLER_145_1566 VDD VDD VSS VSS gf180mcu_as_sc_mcu7t3v3__fill_2
XFILLER_106_1539 VDD VDD VSS VSS gf180mcu_as_sc_mcu7t3v3__fillcap_4
XPHY_EDGE_ROW_53_3_Left_438 VDD VSS gf180mcu_as_sc_mcu7t3v3__tap_2
Xwire504 VDD VDD VSS VSS wire505/Y _4776_/D gf180mcu_as_sc_mcu7t3v3__clkbuff_12
XFILLER_195_286 VDD VDD VSS VSS gf180mcu_as_sc_mcu7t3v3__fill_2
Xwire537 VDD VDD VSS VSS _3498_/S _3505_/S gf180mcu_as_sc_mcu7t3v3__clkbuff_12
XFILLER_148_191 VDD VDD VSS VSS gf180mcu_as_sc_mcu7t3v3__fillcap_16
XFILLER_155_139 VDD VDD VSS VSS gf180mcu_as_sc_mcu7t3v3__fill_1
XFILLER_183_448 VDD VDD VSS VSS gf180mcu_as_sc_mcu7t3v3__fill_2
XFILLER_12_85 VDD VDD VSS VSS gf180mcu_as_sc_mcu7t3v3__fillcap_16
XFILLER_139_1348 VDD VDD VSS VSS gf180mcu_as_sc_mcu7t3v3__fillcap_16
XFILLER_191_492 VDD VDD VSS VSS gf180mcu_as_sc_mcu7t3v3__fillcap_16
XFILLER_30_1482 VDD VDD VSS VSS gf180mcu_as_sc_mcu7t3v3__fillcap_16
XFILLER_191_1542 VDD VDD VSS VSS gf180mcu_as_sc_mcu7t3v3__fill_2
XFILLER_26_1507 VDD VDD VSS VSS gf180mcu_as_sc_mcu7t3v3__fillcap_4
XFILLER_2_333 VDD VDD VSS VSS gf180mcu_as_sc_mcu7t3v3__fill_1
XFILLER_5_2 VDD VDD VSS VSS gf180mcu_as_sc_mcu7t3v3__fillcap_16
XTAP_TAPCELL_ROW_31_1410 VDD VSS gf180mcu_as_sc_mcu7t3v3__tap_2
XFILLER_19_702 VDD VDD VSS VSS gf180mcu_as_sc_mcu7t3v3__fillcap_4
XFILLER_24_1231 VDD VDD VSS VSS gf180mcu_as_sc_mcu7t3v3__fill_1
Xfanout670 VDD VDD VSS VSS _4601_/C _4629_/C gf180mcu_as_sc_mcu7t3v3__buff_12
Xfanout681 VDD VDD VSS VSS _3564_/Y _3727_/C gf180mcu_as_sc_mcu7t3v3__buff_12
Xfanout692 VDD VDD VSS VSS fanout692/A _4159_/C gf180mcu_as_sc_mcu7t3v3__buff_12
XTAP_TAPCELL_ROW_31_1421 VDD VSS gf180mcu_as_sc_mcu7t3v3__tap_2
XFILLER_207_836 VDD VDD VSS VSS gf180mcu_as_sc_mcu7t3v3__fillcap_4
XFILLER_24_1297 VDD VDD VSS VSS gf180mcu_as_sc_mcu7t3v3__fillcap_16
XFILLER_4_1347 VDD VDD VSS VSS gf180mcu_as_sc_mcu7t3v3__fillcap_4
XFILLER_207_858 VDD VDD VSS VSS gf180mcu_as_sc_mcu7t3v3__fillcap_16
XPHY_EDGE_ROW_16_Right_16 VDD VSS gf180mcu_as_sc_mcu7t3v3__tap_2
XFILLER_33_248 VDD VDD VSS VSS gf180mcu_as_sc_mcu7t3v3__fill_2
XTAP_TAPCELL_ROW_29_1361 VDD VSS gf180mcu_as_sc_mcu7t3v3__tap_2
XFILLER_14_473 VDD VDD VSS VSS gf180mcu_as_sc_mcu7t3v3__fillcap_16
XTAP_TAPCELL_ROW_29_1372 VDD VSS gf180mcu_as_sc_mcu7t3v3__tap_2
XFILLER_175_905 VDD VDD VSS VSS gf180mcu_as_sc_mcu7t3v3__fillcap_4
XFILLER_30_966 VDD VDD VSS VSS gf180mcu_as_sc_mcu7t3v3__fill_2
XFILLER_175_938 VDD VDD VSS VSS gf180mcu_as_sc_mcu7t3v3__fill_1
XFILLER_35_1382 VDD VDD VSS VSS gf180mcu_as_sc_mcu7t3v3__fillcap_16
XFILLER_146_139 VDD VDD VSS VSS gf180mcu_as_sc_mcu7t3v3__fill_2
XFILLER_183_960 VDD VDD VSS VSS gf180mcu_as_sc_mcu7t3v3__fillcap_16
XFILLER_196_1431 VDD VDD VSS VSS gf180mcu_as_sc_mcu7t3v3__fillcap_4
XFILLER_31_1257 VDD VDD VSS VSS gf180mcu_as_sc_mcu7t3v3__fill_2
XPHY_EDGE_ROW_25_Right_25 VDD VSS gf180mcu_as_sc_mcu7t3v3__tap_2
X_3560_ VDD VDD VSS VSS _3805_/B _3805_/A _3560_/Y gf180mcu_as_sc_mcu7t3v3__or2_2
XFILLER_154_161 VDD VDD VSS VSS gf180mcu_as_sc_mcu7t3v3__fill_2
XFILLER_183_982 VDD VDD VSS VSS gf180mcu_as_sc_mcu7t3v3__fillcap_8
XFILLER_196_1453 VDD VDD VSS VSS gf180mcu_as_sc_mcu7t3v3__fillcap_16
Xmax_cap826 VDD VDD VSS VSS _3848_/A fanout825/A gf180mcu_as_sc_mcu7t3v3__clkbuff_12
X_2511_ VDD VDD VSS VSS _2517_/B _4662_/C _4708_/B _2511_/C gf180mcu_as_sc_mcu7t3v3__ao21_2
X_5230_ VDD VDD VSS VSS _5241_/CLK _5230_/D _5230_/Q gf180mcu_as_sc_mcu7t3v3__dfxtp_2
X_3491_ VDD VDD VSS VSS _3505_/S _3491_/B _4148_/A _3492_/B gf180mcu_as_sc_mcu7t3v3__mux2_2
X_2442_ VDD VDD VSS VSS _4099_/A _2442_/A gf180mcu_as_sc_mcu7t3v3__inv_2
XFILLER_38_2 VDD VDD VSS VSS gf180mcu_as_sc_mcu7t3v3__fillcap_16
XFILLER_9_1247 VDD VDD VSS VSS gf180mcu_as_sc_mcu7t3v3__fillcap_8
X_5161_ VDD VDD VSS VSS clkload8/A _5161_/D _5161_/Q gf180mcu_as_sc_mcu7t3v3__dfxtp_2
XFILLER_68_145 VDD VDD VSS VSS gf180mcu_as_sc_mcu7t3v3__fillcap_8
X_5092_ VDD VDD VSS VSS clkload3/A _5092_/D _5092_/Q gf180mcu_as_sc_mcu7t3v3__dfxtp_2
X_4112_ VDD VDD VSS VSS _4112_/A _4129_/B _4129_/C _4937_/Q _4113_/D gf180mcu_as_sc_mcu7t3v3__ao22_2
XFILLER_83_104 VDD VDD VSS VSS gf180mcu_as_sc_mcu7t3v3__fillcap_16
X_4043_ VDD VDD VSS VSS _4043_/A _4043_/B _4043_/C _4242_/B _4116_/A gf180mcu_as_sc_mcu7t3v3__aoi211_2
XPHY_EDGE_ROW_34_Right_34 VDD VSS gf180mcu_as_sc_mcu7t3v3__tap_2
XTAP_TAPCELL_ROW_203_2645 VDD VSS gf180mcu_as_sc_mcu7t3v3__tap_2
XTAP_TAPCELL_ROW_203_2634 VDD VSS gf180mcu_as_sc_mcu7t3v3__tap_2
XFILLER_164_1419 VDD VDD VSS VSS gf180mcu_as_sc_mcu7t3v3__fill_2
XFILLER_91_170 VDD VDD VSS VSS gf180mcu_as_sc_mcu7t3v3__fillcap_8
XTAP_TAPCELL_ROW_199_2560 VDD VSS gf180mcu_as_sc_mcu7t3v3__tap_2
X_4945_ VDD VDD VSS VSS _5216_/CLK _4945_/D _4945_/Q gf180mcu_as_sc_mcu7t3v3__dfxtp_2
XFILLER_33_782 VDD VDD VSS VSS gf180mcu_as_sc_mcu7t3v3__fill_1
XFILLER_36_1124 VDD VDD VSS VSS gf180mcu_as_sc_mcu7t3v3__fillcap_16
XTAP_TAPCELL_ROW_195_2468 VDD VSS gf180mcu_as_sc_mcu7t3v3__tap_2
XTAP_TAPCELL_ROW_195_2457 VDD VSS gf180mcu_as_sc_mcu7t3v3__tap_2
XFILLER_193_702 VDD VDD VSS VSS gf180mcu_as_sc_mcu7t3v3__fillcap_16
XFILLER_21_944 VDD VDD VSS VSS gf180mcu_as_sc_mcu7t3v3__fillcap_16
X_4876_ VDD VDD VSS VSS _4924_/CLK _4876_/D _4876_/Q gf180mcu_as_sc_mcu7t3v3__dfxtp_2
XFILLER_14_1411 VDD VDD VSS VSS gf180mcu_as_sc_mcu7t3v3__fillcap_16
XFILLER_177_286 VDD VDD VSS VSS gf180mcu_as_sc_mcu7t3v3__fill_2
XFILLER_192_223 VDD VDD VSS VSS gf180mcu_as_sc_mcu7t3v3__fillcap_8
X_3827_ VDD VDD VSS VSS _4908_/D _3827_/B _4253_/S gf180mcu_as_sc_mcu7t3v3__nor2_2
XFILLER_101_1414 VDD VDD VSS VSS gf180mcu_as_sc_mcu7t3v3__fill_2
XFILLER_137_139 VDD VDD VSS VSS gf180mcu_as_sc_mcu7t3v3__fill_1
XFILLER_88_1523 VDD VDD VSS VSS gf180mcu_as_sc_mcu7t3v3__fillcap_4
XTAP_TAPCELL_ROW_125_1_1821 VDD VSS gf180mcu_as_sc_mcu7t3v3__tap_2
XTAP_TAPCELL_ROW_137_3_3133 VDD VSS gf180mcu_as_sc_mcu7t3v3__tap_2
X_3758_ VDD VDD VSS VSS _4136_/A _3758_/B _3758_/C _3758_/D _3759_/C gf180mcu_as_sc_mcu7t3v3__ao211_2
XFILLER_140_1485 VDD VDD VSS VSS gf180mcu_as_sc_mcu7t3v3__fillcap_8
XFILLER_180_429 VDD VDD VSS VSS gf180mcu_as_sc_mcu7t3v3__fill_1
XFILLER_4_609 VDD VDD VSS VSS gf180mcu_as_sc_mcu7t3v3__fillcap_8
X_2709_ VDD VDD VSS VSS _2709_/A _2709_/B _2709_/C _2709_/D _2709_/Y gf180mcu_as_sc_mcu7t3v3__ao22_2
X_3689_ VDD VDD VSS VSS _3689_/D _4064_/D _3728_/B _3728_/C _3690_/C gf180mcu_as_sc_mcu7t3v3__ao31_2
XTAP_TAPCELL_ROW_8_904 VDD VSS gf180mcu_as_sc_mcu7t3v3__tap_2
XTAP_TAPCELL_ROW_8_915 VDD VSS gf180mcu_as_sc_mcu7t3v3__tap_2
XFILLER_58_37 VDD VDD VSS VSS gf180mcu_as_sc_mcu7t3v3__fillcap_16
XFILLER_101_220 VDD VDD VSS VSS gf180mcu_as_sc_mcu7t3v3__fill_2
XFILLER_199_6 VDD VDD VSS VSS gf180mcu_as_sc_mcu7t3v3__fillcap_16
XFILLER_74_104 VDD VDD VSS VSS gf180mcu_as_sc_mcu7t3v3__fill_1
XFILLER_60_1453 VDD VDD VSS VSS gf180mcu_as_sc_mcu7t3v3__fillcap_16
XFILLER_114_98 VDD VDD VSS VSS gf180mcu_as_sc_mcu7t3v3__fillcap_4
XFILLER_210_1155 VDD VDD VSS VSS gf180mcu_as_sc_mcu7t3v3__fill_1
XFILLER_28_543 VDD VDD VSS VSS gf180mcu_as_sc_mcu7t3v3__fillcap_16
XFILLER_15_226 VDD VDD VSS VSS gf180mcu_as_sc_mcu7t3v3__fillcap_16
XFILLER_74_69 VDD VDD VSS VSS gf180mcu_as_sc_mcu7t3v3__fill_1
XPHY_EDGE_ROW_43_1_Right_564 VDD VSS gf180mcu_as_sc_mcu7t3v3__tap_2
XFILLER_204_839 VDD VDD VSS VSS gf180mcu_as_sc_mcu7t3v3__fillcap_16
XFILLER_82_181 VDD VDD VSS VSS gf180mcu_as_sc_mcu7t3v3__fill_1
XFILLER_180_1221 VDD VDD VSS VSS gf180mcu_as_sc_mcu7t3v3__fillcap_4
XFILLER_19_1344 VDD VDD VSS VSS gf180mcu_as_sc_mcu7t3v3__fillcap_4
XFILLER_90_46 VDD VDD VSS VSS gf180mcu_as_sc_mcu7t3v3__fillcap_16
XFILLER_12_944 VDD VDD VSS VSS gf180mcu_as_sc_mcu7t3v3__fill_1
XFILLER_180_1243 VDD VDD VSS VSS gf180mcu_as_sc_mcu7t3v3__fillcap_16
XFILLER_208_1084 VDD VDD VSS VSS gf180mcu_as_sc_mcu7t3v3__fill_1
XFILLER_8_904 VDD VDD VSS VSS gf180mcu_as_sc_mcu7t3v3__fill_2
XFILLER_145_1396 VDD VDD VSS VSS gf180mcu_as_sc_mcu7t3v3__fillcap_16
XFILLER_19_1399 VDD VDD VSS VSS gf180mcu_as_sc_mcu7t3v3__fill_1
XFILLER_32_1511 VDD VDD VSS VSS gf180mcu_as_sc_mcu7t3v3__fill_2
XFILLER_7_436 VDD VDD VSS VSS gf180mcu_as_sc_mcu7t3v3__fill_1
XFILLER_99_55 VDD VDD VSS VSS gf180mcu_as_sc_mcu7t3v3__fillcap_4
XTAP_TAPCELL_ROW_20_1166 VDD VSS gf180mcu_as_sc_mcu7t3v3__tap_2
XFILLER_151_120 VDD VDD VSS VSS gf180mcu_as_sc_mcu7t3v3__fillcap_16
XFILLER_180_941 VDD VDD VSS VSS gf180mcu_as_sc_mcu7t3v3__fillcap_4
XTAP_TAPCELL_ROW_20_1177 VDD VSS gf180mcu_as_sc_mcu7t3v3__tap_2
XFILLER_151_142 VDD VDD VSS VSS gf180mcu_as_sc_mcu7t3v3__fillcap_16
XFILLER_180_963 VDD VDD VSS VSS gf180mcu_as_sc_mcu7t3v3__fillcap_16
XFILLER_155_72 VDD VDD VSS VSS gf180mcu_as_sc_mcu7t3v3__fillcap_16
XFILLER_2_174 VDD VDD VSS VSS gf180mcu_as_sc_mcu7t3v3__fill_1
XTAP_TAPCELL_ROW_44_1_1576 VDD VSS gf180mcu_as_sc_mcu7t3v3__tap_2
XFILLER_191_1383 VDD VDD VSS VSS gf180mcu_as_sc_mcu7t3v3__fillcap_4
XFILLER_19_510 VDD VDD VSS VSS gf180mcu_as_sc_mcu7t3v3__fill_2
XFILLER_80_107 VDD VDD VSS VSS gf180mcu_as_sc_mcu7t3v3__fillcap_4
XFILLER_179_518 VDD VDD VSS VSS gf180mcu_as_sc_mcu7t3v3__fillcap_4
XFILLER_185_1154 VDD VDD VSS VSS gf180mcu_as_sc_mcu7t3v3__fillcap_16
XFILLER_159_220 VDD VDD VSS VSS gf180mcu_as_sc_mcu7t3v3__fill_2
XFILLER_34_579 VDD VDD VSS VSS gf180mcu_as_sc_mcu7t3v3__fill_1
XFILLER_37_1422 VDD VDD VSS VSS gf180mcu_as_sc_mcu7t3v3__fill_2
XFILLER_76_1493 VDD VDD VSS VSS gf180mcu_as_sc_mcu7t3v3__fillcap_4
X_2991_ VDD VDD VSS VSS _3976_/A _3042_/B _3042_/C _3976_/D _2997_/B gf180mcu_as_sc_mcu7t3v3__ao22_2
XFILLER_187_562 VDD VDD VSS VSS gf180mcu_as_sc_mcu7t3v3__fillcap_16
X_4730_ VDD VDD VSS VSS _5251_/Q _4730_/B _4730_/C _5266_/Q _4731_/C gf180mcu_as_sc_mcu7t3v3__ao22_2
XFILLER_124_1469 VDD VDD VSS VSS gf180mcu_as_sc_mcu7t3v3__fillcap_16
XFILLER_37_1488 VDD VDD VSS VSS gf180mcu_as_sc_mcu7t3v3__fillcap_16
X_4661_ VDD VDD VSS VSS _4683_/C _5485_/A _5240_/Q _5240_/D gf180mcu_as_sc_mcu7t3v3__mux2_2
XFILLER_200_1313 VDD VDD VSS VSS gf180mcu_as_sc_mcu7t3v3__fillcap_16
XFILLER_30_785 VDD VDD VSS VSS gf180mcu_as_sc_mcu7t3v3__fill_2
X_3612_ VDD VDD VSS VSS _4921_/Q _3648_/B _3727_/C _3981_/D _3613_/D gf180mcu_as_sc_mcu7t3v3__ao22_2
XTAP_TAPCELL_ROW_190_2354 VDD VSS gf180mcu_as_sc_mcu7t3v3__tap_2
XTAP_TAPCELL_ROW_190_2343 VDD VSS gf180mcu_as_sc_mcu7t3v3__tap_2
XFILLER_174_256 VDD VDD VSS VSS gf180mcu_as_sc_mcu7t3v3__fillcap_16
X_4592_ VDD VDD VSS VSS _5188_/Q _4592_/B _4592_/C _4592_/D _5188_/D gf180mcu_as_sc_mcu7t3v3__ao211_2
XFILLER_192_1103 VDD VDD VSS VSS gf180mcu_as_sc_mcu7t3v3__fillcap_16
X_3543_ VDD VDD VSS VSS _3798_/A _3740_/B _3777_/B gf180mcu_as_sc_mcu7t3v3__nor2_2
XFILLER_142_131 VDD VDD VSS VSS gf180mcu_as_sc_mcu7t3v3__fillcap_8
X_3474_ VDD VDD VSS VSS _4126_/A _3502_/B _3504_/B _4127_/A _3475_/D gf180mcu_as_sc_mcu7t3v3__ao22_2
X_5213_ VDD VDD VSS VSS _5214_/CLK _5213_/D _5213_/Q gf180mcu_as_sc_mcu7t3v3__dfxtp_2
X_2425_ VDD VDD VSS VSS _3953_/A _3302_/A gf180mcu_as_sc_mcu7t3v3__inv_2
XFILLER_44_1437 VDD VDD VSS VSS gf180mcu_as_sc_mcu7t3v3__fill_2
X_5144_ VDD VDD VSS VSS _5220_/CLK _5144_/D _5144_/Q gf180mcu_as_sc_mcu7t3v3__dfxtp_2
XFILLER_170_1467 VDD VDD VSS VSS gf180mcu_as_sc_mcu7t3v3__fill_1
XFILLER_28_18 VDD VDD VSS VSS gf180mcu_as_sc_mcu7t3v3__fillcap_16
XPHY_EDGE_ROW_119_1_Left_329 VDD VSS gf180mcu_as_sc_mcu7t3v3__tap_2
X_5075_ VDD VDD VSS VSS clkload1/A _5075_/D _5075_/Q gf180mcu_as_sc_mcu7t3v3__dfxtp_2
XFILLER_56_159 VDD VDD VSS VSS gf180mcu_as_sc_mcu7t3v3__fill_1
X_4026_ VDD VDD VSS VSS _4027_/C _4026_/B _4026_/A gf180mcu_as_sc_mcu7t3v3__nor2_2
XFILLER_25_513 VDD VDD VSS VSS gf180mcu_as_sc_mcu7t3v3__fillcap_16
XPHY_EDGE_ROW_170_1_Right_691 VDD VSS gf180mcu_as_sc_mcu7t3v3__tap_2
XTAP_TAPCELL_ROW_70_1_1655 VDD VSS gf180mcu_as_sc_mcu7t3v3__tap_2
XTAP_TAPCELL_ROW_197_2508 VDD VSS gf180mcu_as_sc_mcu7t3v3__tap_2
XFILLER_100_34 VDD VDD VSS VSS gf180mcu_as_sc_mcu7t3v3__fill_1
XFILLER_100_45 VDD VDD VSS VSS gf180mcu_as_sc_mcu7t3v3__fill_2
XFILLER_142_1503 VDD VDD VSS VSS gf180mcu_as_sc_mcu7t3v3__fill_1
XFILLER_205_1224 VDD VDD VSS VSS gf180mcu_as_sc_mcu7t3v3__fillcap_16
XFILLER_21_730 VDD VDD VSS VSS gf180mcu_as_sc_mcu7t3v3__fillcap_16
XFILLER_55_1566 VDD VDD VSS VSS gf180mcu_as_sc_mcu7t3v3__fill_2
X_4928_ VDD VDD VSS VSS clkload2/A _4928_/D _4928_/Q gf180mcu_as_sc_mcu7t3v3__dfxtp_2
XFILLER_165_212 VDD VDD VSS VSS gf180mcu_as_sc_mcu7t3v3__fillcap_8
XFILLER_90_1479 VDD VDD VSS VSS gf180mcu_as_sc_mcu7t3v3__fill_1
XFILLER_197_1014 VDD VDD VSS VSS gf180mcu_as_sc_mcu7t3v3__fillcap_16
X_4859_ VDD VDD VSS VSS _5192_/CLK _4859_/D _4859_/Q gf180mcu_as_sc_mcu7t3v3__dfxtp_2
XFILLER_109_32 VDD VDD VSS VSS gf180mcu_as_sc_mcu7t3v3__fillcap_16
XFILLER_118_172 VDD VDD VSS VSS gf180mcu_as_sc_mcu7t3v3__fill_2
XFILLER_88_1364 VDD VDD VSS VSS gf180mcu_as_sc_mcu7t3v3__fillcap_8
XFILLER_133_120 VDD VDD VSS VSS gf180mcu_as_sc_mcu7t3v3__fillcap_16
XFILLER_133_142 VDD VDD VSS VSS gf180mcu_as_sc_mcu7t3v3__fillcap_16
XFILLER_49_1348 VDD VDD VSS VSS gf180mcu_as_sc_mcu7t3v3__fill_2
X_4886__1081 VDD VDD VSS VSS _4886_/D gf180mcu_as_sc_mcu7t3v3__tiel_4
XFILLER_192_37 VDD VDD VSS VSS gf180mcu_as_sc_mcu7t3v3__fillcap_16
XFILLER_69_69 VDD VDD VSS VSS gf180mcu_as_sc_mcu7t3v3__fill_1
XFILLER_47_104 VDD VDD VSS VSS gf180mcu_as_sc_mcu7t3v3__fillcap_16
XFILLER_5_1420 VDD VDD VSS VSS gf180mcu_as_sc_mcu7t3v3__fill_2
XFILLER_85_57 VDD VDD VSS VSS gf180mcu_as_sc_mcu7t3v3__fillcap_8
XFILLER_16_524 VDD VDD VSS VSS gf180mcu_as_sc_mcu7t3v3__fill_1
XFILLER_28_362 VDD VDD VSS VSS gf180mcu_as_sc_mcu7t3v3__fillcap_16
XFILLER_28_384 VDD VDD VSS VSS gf180mcu_as_sc_mcu7t3v3__fill_1
XFILLER_29_885 VDD VDD VSS VSS gf180mcu_as_sc_mcu7t3v3__fillcap_16
XFILLER_62_107 VDD VDD VSS VSS gf180mcu_as_sc_mcu7t3v3__fillcap_8
XFILLER_147_1414 VDD VDD VSS VSS gf180mcu_as_sc_mcu7t3v3__fill_2
XFILLER_188_304 VDD VDD VSS VSS gf180mcu_as_sc_mcu7t3v3__fillcap_8
XFILLER_147_1447 VDD VDD VSS VSS gf180mcu_as_sc_mcu7t3v3__fillcap_8
XFILLER_19_1130 VDD VDD VSS VSS gf180mcu_as_sc_mcu7t3v3__fillcap_4
XFILLER_31_516 VDD VDD VSS VSS gf180mcu_as_sc_mcu7t3v3__fill_1
XPHY_EDGE_ROW_165_1_Left_375 VDD VSS gf180mcu_as_sc_mcu7t3v3__tap_2
XPHY_EDGE_ROW_44_1_Right_565 VDD VSS gf180mcu_as_sc_mcu7t3v3__tap_2
X_4952__1100 VDD VDD VSS VSS _4952_/RN gf180mcu_as_sc_mcu7t3v3__tieh_4
XFILLER_70_173 VDD VDD VSS VSS gf180mcu_as_sc_mcu7t3v3__fill_2
XTAP_TAPCELL_ROW_22_1217 VDD VSS gf180mcu_as_sc_mcu7t3v3__tap_2
XTAP_TAPCELL_ROW_22_1206 VDD VSS gf180mcu_as_sc_mcu7t3v3__tap_2
XFILLER_11_273 VDD VDD VSS VSS gf180mcu_as_sc_mcu7t3v3__fillcap_4
XFILLER_11_284 VDD VDD VSS VSS gf180mcu_as_sc_mcu7t3v3__fill_1
XFILLER_12_785 VDD VDD VSS VSS gf180mcu_as_sc_mcu7t3v3__fillcap_4
XFILLER_12_796 VDD VDD VSS VSS gf180mcu_as_sc_mcu7t3v3__fillcap_8
XFILLER_15_1038 VDD VDD VSS VSS gf180mcu_as_sc_mcu7t3v3__fill_1
XFILLER_184_543 VDD VDD VSS VSS gf180mcu_as_sc_mcu7t3v3__fill_2
XFILLER_8_734 VDD VDD VSS VSS gf180mcu_as_sc_mcu7t3v3__fill_1
XFILLER_8_745 VDD VDD VSS VSS gf180mcu_as_sc_mcu7t3v3__fill_2
XFILLER_109_150 VDD VDD VSS VSS gf180mcu_as_sc_mcu7t3v3__fillcap_4
XFILLER_8_789 VDD VDD VSS VSS gf180mcu_as_sc_mcu7t3v3__fillcap_16
XTAP_TAPCELL_ROW_10_942 VDD VSS gf180mcu_as_sc_mcu7t3v3__tap_2
XTAP_TAPCELL_ROW_10_953 VDD VSS gf180mcu_as_sc_mcu7t3v3__tap_2
XFILLER_109_194 VDD VDD VSS VSS gf180mcu_as_sc_mcu7t3v3__fill_1
XFILLER_193_1434 VDD VDD VSS VSS gf180mcu_as_sc_mcu7t3v3__fillcap_16
XFILLER_4_995 VDD VDD VSS VSS gf180mcu_as_sc_mcu7t3v3__fillcap_8
XFILLER_124_197 VDD VDD VSS VSS gf180mcu_as_sc_mcu7t3v3__fill_1
XTAP_TAPCELL_ROW_100_3_3020 VDD VSS gf180mcu_as_sc_mcu7t3v3__tap_2
XFILLER_59_91 VDD VDD VSS VSS gf180mcu_as_sc_mcu7t3v3__fillcap_4
X_3190_ VDD VDD VSS VSS _3237_/B _3204_/C _3227_/S gf180mcu_as_sc_mcu7t3v3__nor2_2
XTAP_TAPCELL_ROW_183_2191 VDD VSS gf180mcu_as_sc_mcu7t3v3__tap_2
XFILLER_130_1484 VDD VDD VSS VSS gf180mcu_as_sc_mcu7t3v3__fillcap_16
XPHY_EDGE_ROW_130_3_Left_515 VDD VSS gf180mcu_as_sc_mcu7t3v3__tap_2
XTAP_TAPCELL_ROW_149_1_1891 VDD VSS gf180mcu_as_sc_mcu7t3v3__tap_2
XFILLER_165_1558 VDD VDD VSS VSS gf180mcu_as_sc_mcu7t3v3__fillcap_8
XPHY_EDGE_ROW_52_3_Right_89 VDD VSS gf180mcu_as_sc_mcu7t3v3__tap_2
XFILLER_201_66 VDD VDD VSS VSS gf180mcu_as_sc_mcu7t3v3__fillcap_4
XFILLER_201_88 VDD VDD VSS VSS gf180mcu_as_sc_mcu7t3v3__fillcap_16
XFILLER_22_527 VDD VDD VSS VSS gf180mcu_as_sc_mcu7t3v3__fillcap_16
XFILLER_34_398 VDD VDD VSS VSS gf180mcu_as_sc_mcu7t3v3__fill_2
X_2974_ VDD VDD VSS VSS _3957_/A _3042_/B _3042_/C _3956_/A _2980_/B gf180mcu_as_sc_mcu7t3v3__ao22_2
XTAP_TAPCELL_ROW_192_2405 VDD VSS gf180mcu_as_sc_mcu7t3v3__tap_2
XFILLER_128_1380 VDD VDD VSS VSS gf180mcu_as_sc_mcu7t3v3__fill_1
XFILLER_188_871 VDD VDD VSS VSS gf180mcu_as_sc_mcu7t3v3__fillcap_4
XFILLER_188_893 VDD VDD VSS VSS gf180mcu_as_sc_mcu7t3v3__fillcap_16
XFILLER_203_680 VDD VDD VSS VSS gf180mcu_as_sc_mcu7t3v3__fillcap_16
XFILLER_206_1555 VDD VDD VSS VSS gf180mcu_as_sc_mcu7t3v3__fillcap_8
XFILLER_210_639 VDD VDD VSS VSS gf180mcu_as_sc_mcu7t3v3__fill_2
X_4713_ VDD VDD VSS VSS _4717_/S _5259_/Q _5260_/Q _4714_/B gf180mcu_as_sc_mcu7t3v3__mux2_2
XFILLER_147_212 VDD VDD VSS VSS gf180mcu_as_sc_mcu7t3v3__fillcap_8
XFILLER_30_582 VDD VDD VSS VSS gf180mcu_as_sc_mcu7t3v3__fill_2
XFILLER_33_1138 VDD VDD VSS VSS gf180mcu_as_sc_mcu7t3v3__fill_2
XFILLER_102_1520 VDD VDD VSS VSS gf180mcu_as_sc_mcu7t3v3__fill_1
XFILLER_175_576 VDD VDD VSS VSS gf180mcu_as_sc_mcu7t3v3__fillcap_16
XFILLER_198_1345 VDD VDD VSS VSS gf180mcu_as_sc_mcu7t3v3__fillcap_16
XFILLER_198_1367 VDD VDD VSS VSS gf180mcu_as_sc_mcu7t3v3__fillcap_16
XFILLER_50_1441 VDD VDD VSS VSS gf180mcu_as_sc_mcu7t3v3__fillcap_8
X_4644_ VDD VDD VSS VSS _4646_/C _4647_/A _4649_/C _4645_/B gf180mcu_as_sc_mcu7t3v3__nor3_2
XFILLER_85_1504 VDD VDD VSS VSS gf180mcu_as_sc_mcu7t3v3__fillcap_16
X_4575_ VDD VDD VSS VSS _5188_/Q _4575_/B _4575_/C _5106_/Q _4576_/B gf180mcu_as_sc_mcu7t3v3__ao22_2
XFILLER_115_120 VDD VDD VSS VSS gf180mcu_as_sc_mcu7t3v3__fillcap_16
XFILLER_115_142 VDD VDD VSS VSS gf180mcu_as_sc_mcu7t3v3__fillcap_16
X_3526_ VDD VDD VSS VSS _3817_/B _3526_/B _3526_/C _3526_/D _3527_/B gf180mcu_as_sc_mcu7t3v3__ao211_2
XFILLER_130_123 VDD VDD VSS VSS gf180mcu_as_sc_mcu7t3v3__fillcap_16
XFILLER_48_1370 VDD VDD VSS VSS gf180mcu_as_sc_mcu7t3v3__fillcap_8
X_3457_ VDD VDD VSS VSS _3479_/C _4113_/A _3458_/D gf180mcu_as_sc_mcu7t3v3__and2_2
XFILLER_135_1362 VDD VDD VSS VSS gf180mcu_as_sc_mcu7t3v3__fill_1
X_3388_ VDD VDD VSS VSS _4037_/D _3468_/B _3388_/C _3388_/D _3389_/A gf180mcu_as_sc_mcu7t3v3__ao22_2
X_2408_ VDD VDD VSS VSS _4364_/A _5160_/Q gf180mcu_as_sc_mcu7t3v3__inv_2
X_5127_ VDD VDD VSS VSS _5278_/CLK _5127_/D _5127_/Q gf180mcu_as_sc_mcu7t3v3__dfxtp_2
XFILLER_29_137 VDD VDD VSS VSS gf180mcu_as_sc_mcu7t3v3__fill_2
XPHY_EDGE_ROW_2_Right_2 VDD VSS gf180mcu_as_sc_mcu7t3v3__tap_2
XPHY_EDGE_ROW_62_3_Left_447 VDD VSS gf180mcu_as_sc_mcu7t3v3__tap_2
X_5058_ VDD VDD VSS VSS _5085_/CLK _5058_/D _5058_/Q gf180mcu_as_sc_mcu7t3v3__dfxtp_2
XFILLER_44_107 VDD VDD VSS VSS gf180mcu_as_sc_mcu7t3v3__fill_1
X_4009_ VDD VDD VSS VSS _4009_/A _4105_/B _4009_/C _4009_/D _4010_/B gf180mcu_as_sc_mcu7t3v3__ao211_2
XFILLER_198_613 VDD VDD VSS VSS gf180mcu_as_sc_mcu7t3v3__fillcap_16
XPHY_EDGE_ROW_171_1_Right_692 VDD VSS gf180mcu_as_sc_mcu7t3v3__tap_2
XFILLER_13_505 VDD VDD VSS VSS gf180mcu_as_sc_mcu7t3v3__fill_1
XFILLER_13_516 VDD VDD VSS VSS gf180mcu_as_sc_mcu7t3v3__fill_1
XFILLER_13_549 VDD VDD VSS VSS gf180mcu_as_sc_mcu7t3v3__fillcap_8
XFILLER_21_582 VDD VDD VSS VSS gf180mcu_as_sc_mcu7t3v3__fill_1
XFILLER_194_885 VDD VDD VSS VSS gf180mcu_as_sc_mcu7t3v3__fill_2
XTAP_TAPCELL_ROW_105_3_3035 VDD VSS gf180mcu_as_sc_mcu7t3v3__tap_2
XFILLER_181_524 VDD VDD VSS VSS gf180mcu_as_sc_mcu7t3v3__fillcap_8
XFILLER_181_557 VDD VDD VSS VSS gf180mcu_as_sc_mcu7t3v3__fill_2
XFILLER_175_1142 VDD VDD VSS VSS gf180mcu_as_sc_mcu7t3v3__fill_2
XFILLER_20_85 VDD VDD VSS VSS gf180mcu_as_sc_mcu7t3v3__fillcap_16
Xinput310 VDD VDD VSS VSS west_in[3] _3956_/D gf180mcu_as_sc_mcu7t3v3__buff_12
XFILLER_188_1503 VDD VDD VSS VSS gf180mcu_as_sc_mcu7t3v3__fill_2
XFILLER_23_1318 VDD VDD VSS VSS gf180mcu_as_sc_mcu7t3v3__fill_1
XTAP_TAPCELL_ROW_15_1054 VDD VSS gf180mcu_as_sc_mcu7t3v3__tap_2
XTAP_TAPCELL_ROW_15_1065 VDD VSS gf180mcu_as_sc_mcu7t3v3__tap_2
XTAP_TAPCELL_ROW_70_3_2930 VDD VSS gf180mcu_as_sc_mcu7t3v3__tap_2
XFILLER_29_72 VDD VDD VSS VSS gf180mcu_as_sc_mcu7t3v3__fillcap_4
XFILLER_149_1509 VDD VDD VSS VSS gf180mcu_as_sc_mcu7t3v3__fill_1
XFILLER_35_118 VDD VDD VSS VSS gf180mcu_as_sc_mcu7t3v3__fill_1
XFILLER_17_833 VDD VDD VSS VSS gf180mcu_as_sc_mcu7t3v3__fillcap_4
XFILLER_205_912 VDD VDD VSS VSS gf180mcu_as_sc_mcu7t3v3__fillcap_16
XFILLER_28_192 VDD VDD VSS VSS gf180mcu_as_sc_mcu7t3v3__fillcap_16
XFILLER_188_101 VDD VDD VSS VSS gf180mcu_as_sc_mcu7t3v3__fillcap_4
XFILLER_16_387 VDD VDD VSS VSS gf180mcu_as_sc_mcu7t3v3__fillcap_16
XFILLER_182_1135 VDD VDD VSS VSS gf180mcu_as_sc_mcu7t3v3__fillcap_16
XFILLER_182_1157 VDD VDD VSS VSS gf180mcu_as_sc_mcu7t3v3__fillcap_16
XFILLER_188_123 VDD VDD VSS VSS gf180mcu_as_sc_mcu7t3v3__fillcap_16
XFILLER_31_302 VDD VDD VSS VSS gf180mcu_as_sc_mcu7t3v3__fill_1
XFILLER_31_313 VDD VDD VSS VSS gf180mcu_as_sc_mcu7t3v3__fillcap_16
XFILLER_43_184 VDD VDD VSS VSS gf180mcu_as_sc_mcu7t3v3__fill_1
XPHY_EDGE_ROW_45_1_Right_566 VDD VSS gf180mcu_as_sc_mcu7t3v3__tap_2
XTAP_TAPCELL_ROW_50_3_2872 VDD VSS gf180mcu_as_sc_mcu7t3v3__tap_2
XFILLER_129_212 VDD VDD VSS VSS gf180mcu_as_sc_mcu7t3v3__fillcap_8
XFILLER_184_351 VDD VDD VSS VSS gf180mcu_as_sc_mcu7t3v3__fill_1
XFILLER_185_874 VDD VDD VSS VSS gf180mcu_as_sc_mcu7t3v3__fillcap_16
XFILLER_200_661 VDD VDD VSS VSS gf180mcu_as_sc_mcu7t3v3__fillcap_4
XFILLER_200_683 VDD VDD VSS VSS gf180mcu_as_sc_mcu7t3v3__fillcap_16
XFILLER_34_1469 VDD VDD VSS VSS gf180mcu_as_sc_mcu7t3v3__fillcap_16
X_2690_ VDD VDD VSS VSS _2735_/A _2690_/B _2690_/C _2734_/S _2691_/C gf180mcu_as_sc_mcu7t3v3__ao22_2
XANTENNA_3 VDD VDD VSS VSS _4848_/D gf180mcu_as_sc_mcu7t3v3__diode_2
XFILLER_184_395 VDD VDD VSS VSS gf180mcu_as_sc_mcu7t3v3__fill_2
XFILLER_8_597 VDD VDD VSS VSS gf180mcu_as_sc_mcu7t3v3__fill_2
X_4360_ VDD VDD VSS VSS _4366_/S _5161_/Q _4360_/A _4361_/C gf180mcu_as_sc_mcu7t3v3__mux2_2
X_3311_ VDD VDD VSS VSS _3962_/A _3416_/B _3311_/C _4808_/D _3416_/D gf180mcu_as_sc_mcu7t3v3__aoi211_2
X_4291_ VDD VDD VSS VSS _4627_/B _4649_/A _4291_/A gf180mcu_as_sc_mcu7t3v3__nand2_2
XTAP_TAPCELL_ROW_131_3_3114 VDD VSS gf180mcu_as_sc_mcu7t3v3__tap_2
X_3242_ VDD VDD VSS VSS _4803_/D _3831_/A _3242_/B _3242_/A gf180mcu_as_sc_mcu7t3v3__aoi21_2
XTAP_TAPCELL_ROW_185_2253 VDD VSS gf180mcu_as_sc_mcu7t3v3__tap_2
XTAP_TAPCELL_ROW_185_2242 VDD VSS gf180mcu_as_sc_mcu7t3v3__tap_2
XFILLER_41_1418 VDD VDD VSS VSS gf180mcu_as_sc_mcu7t3v3__fillcap_16
XFILLER_6_1014 VDD VDD VSS VSS gf180mcu_as_sc_mcu7t3v3__fill_1
Xmesh_tile_936 VDD VDD VSS VSS ne_out[11] gf180mcu_as_sc_mcu7t3v3__tiel_4
X_3173_ VDD VDD VSS VSS _3194_/S _3173_/B _4148_/A _3174_/B gf180mcu_as_sc_mcu7t3v3__mux2_2
XFILLER_6_1047 VDD VDD VSS VSS gf180mcu_as_sc_mcu7t3v3__fillcap_16
Xmesh_tile_969 VDD VDD VSS VSS north_out[10] gf180mcu_as_sc_mcu7t3v3__tiel_4
Xmesh_tile_958 VDD VDD VSS VSS ne_out[33] gf180mcu_as_sc_mcu7t3v3__tiel_4
Xmesh_tile_947 VDD VDD VSS VSS ne_out[22] gf180mcu_as_sc_mcu7t3v3__tiel_4
XFILLER_187_1046 VDD VDD VSS VSS gf180mcu_as_sc_mcu7t3v3__fillcap_4
XFILLER_26_107 VDD VDD VSS VSS gf180mcu_as_sc_mcu7t3v3__fillcap_8
XFILLER_187_1068 VDD VDD VSS VSS gf180mcu_as_sc_mcu7t3v3__fillcap_16
XFILLER_78_1352 VDD VDD VSS VSS gf180mcu_as_sc_mcu7t3v3__fill_2
XFILLER_23_858 VDD VDD VSS VSS gf180mcu_as_sc_mcu7t3v3__fillcap_16
XFILLER_91_1530 VDD VDD VSS VSS gf180mcu_as_sc_mcu7t3v3__fill_1
XFILLER_210_414 VDD VDD VSS VSS gf180mcu_as_sc_mcu7t3v3__fill_2
XFILLER_22_368 VDD VDD VSS VSS gf180mcu_as_sc_mcu7t3v3__fillcap_16
XFILLER_202_1205 VDD VDD VSS VSS gf180mcu_as_sc_mcu7t3v3__fillcap_16
XFILLER_210_469 VDD VDD VSS VSS gf180mcu_as_sc_mcu7t3v3__fill_2
XFILLER_41_18 VDD VDD VSS VSS gf180mcu_as_sc_mcu7t3v3__fillcap_16
X_2957_ VDD VDD VSS VSS _2964_/B _3079_/B _3943_/A gf180mcu_as_sc_mcu7t3v3__nand2_2
XFILLER_202_1227 VDD VDD VSS VSS gf180mcu_as_sc_mcu7t3v3__fillcap_16
X_2888_ VDD VDD VSS VSS _3788_/A _3796_/A _3776_/B gf180mcu_as_sc_mcu7t3v3__or2_2
X_4627_ VDD VDD VSS VSS _4627_/B _4627_/A _4628_/A gf180mcu_as_sc_mcu7t3v3__and2_2
XFILLER_102_1383 VDD VDD VSS VSS gf180mcu_as_sc_mcu7t3v3__fillcap_8
XFILLER_194_1017 VDD VDD VSS VSS gf180mcu_as_sc_mcu7t3v3__fillcap_16
XTAP_TAPCELL_ROW_75_3_2945 VDD VSS gf180mcu_as_sc_mcu7t3v3__tap_2
XTAP_TAPCELL_ROW_174_1990 VDD VSS gf180mcu_as_sc_mcu7t3v3__tap_2
XFILLER_190_365 VDD VDD VSS VSS gf180mcu_as_sc_mcu7t3v3__fillcap_8
XFILLER_190_387 VDD VDD VSS VSS gf180mcu_as_sc_mcu7t3v3__fillcap_16
XFILLER_85_1356 VDD VDD VSS VSS gf180mcu_as_sc_mcu7t3v3__fill_2
X_4558_ VDD VDD VSS VSS _4561_/C _4998_/Q _4559_/S gf180mcu_as_sc_mcu7t3v3__nand2b_2
X_4489_ VDD VDD VSS VSS _4500_/S _5019_/Q _5048_/Q _4490_/B gf180mcu_as_sc_mcu7t3v3__mux2_2
X_3509_ VDD VDD VSS VSS _3511_/C _3518_/C _3509_/B _3509_/A gf180mcu_as_sc_mcu7t3v3__aoi21_2
XTAP_TAPCELL_ROW_45_1_1581 VDD VSS gf180mcu_as_sc_mcu7t3v3__tap_2
XFILLER_172_1348 VDD VDD VSS VSS gf180mcu_as_sc_mcu7t3v3__fillcap_4
XFILLER_106_77 VDD VDD VSS VSS gf180mcu_as_sc_mcu7t3v3__fill_1
XFILLER_106_88 VDD VDD VSS VSS gf180mcu_as_sc_mcu7t3v3__fillcap_4
XTAP_TAPCELL_ROW_55_3_2887 VDD VSS gf180mcu_as_sc_mcu7t3v3__tap_2
XFILLER_22_1362 VDD VDD VSS VSS gf180mcu_as_sc_mcu7t3v3__fill_2
XFILLER_122_54 VDD VDD VSS VSS gf180mcu_as_sc_mcu7t3v3__fillcap_16
XFILLER_96_1430 VDD VDD VSS VSS gf180mcu_as_sc_mcu7t3v3__fillcap_16
XTAP_TAPCELL_ROW_1_762 VDD VSS gf180mcu_as_sc_mcu7t3v3__tap_2
XTAP_TAPCELL_ROW_1_751 VDD VSS gf180mcu_as_sc_mcu7t3v3__tap_2
XFILLER_109_1504 VDD VDD VSS VSS gf180mcu_as_sc_mcu7t3v3__fillcap_16
XFILLER_14_803 VDD VDD VSS VSS gf180mcu_as_sc_mcu7t3v3__fill_2
XFILLER_198_421 VDD VDD VSS VSS gf180mcu_as_sc_mcu7t3v3__fillcap_4
XFILLER_199_944 VDD VDD VSS VSS gf180mcu_as_sc_mcu7t3v3__fillcap_16
XFILLER_96_1474 VDD VDD VSS VSS gf180mcu_as_sc_mcu7t3v3__fillcap_16
XFILLER_18_1409 VDD VDD VSS VSS gf180mcu_as_sc_mcu7t3v3__fill_1
XFILLER_201_403 VDD VDD VSS VSS gf180mcu_as_sc_mcu7t3v3__fill_2
XFILLER_57_1447 VDD VDD VSS VSS gf180mcu_as_sc_mcu7t3v3__fillcap_8
XFILLER_57_1469 VDD VDD VSS VSS gf180mcu_as_sc_mcu7t3v3__fill_1
XPHY_EDGE_ROW_172_1_Right_693 VDD VSS gf180mcu_as_sc_mcu7t3v3__tap_2
XFILLER_183_1488 VDD VDD VSS VSS gf180mcu_as_sc_mcu7t3v3__fillcap_16
XFILLER_185_104 VDD VDD VSS VSS gf180mcu_as_sc_mcu7t3v3__fillcap_16
XFILLER_198_69 VDD VDD VSS VSS gf180mcu_as_sc_mcu7t3v3__fillcap_16
XFILLER_207_1138 VDD VDD VSS VSS gf180mcu_as_sc_mcu7t3v3__fillcap_16
XFILLER_40_143 VDD VDD VSS VSS gf180mcu_as_sc_mcu7t3v3__fill_2
XFILLER_13_379 VDD VDD VSS VSS gf180mcu_as_sc_mcu7t3v3__fillcap_4
XFILLER_182_811 VDD VDD VSS VSS gf180mcu_as_sc_mcu7t3v3__fill_2
XFILLER_177_1204 VDD VDD VSS VSS gf180mcu_as_sc_mcu7t3v3__fill_2
XFILLER_5_512 VDD VDD VSS VSS gf180mcu_as_sc_mcu7t3v3__fill_2
XTAP_TAPCELL_ROW_124_1_1817 VDD VSS gf180mcu_as_sc_mcu7t3v3__tap_2
XTAP_TAPCELL_ROW_136_3_3129 VDD VSS gf180mcu_as_sc_mcu7t3v3__tap_2
XFILLER_177_1248 VDD VDD VSS VSS gf180mcu_as_sc_mcu7t3v3__fillcap_8
XFILLER_182_877 VDD VDD VSS VSS gf180mcu_as_sc_mcu7t3v3__fillcap_16
XTAP_TAPCELL_ROW_17_1105 VDD VSS gf180mcu_as_sc_mcu7t3v3__tap_2
XFILLER_155_1568 VDD VDD VSS VSS gf180mcu_as_sc_mcu7t3v3__fill_1
XFILLER_190_1437 VDD VDD VSS VSS gf180mcu_as_sc_mcu7t3v3__fillcap_8
XFILLER_163_72 VDD VDD VSS VSS gf180mcu_as_sc_mcu7t3v3__fillcap_16
XFILLER_27_1262 VDD VDD VSS VSS gf180mcu_as_sc_mcu7t3v3__fillcap_16
XFILLER_23_1115 VDD VDD VSS VSS gf180mcu_as_sc_mcu7t3v3__fillcap_4
XFILLER_23_1148 VDD VDD VSS VSS gf180mcu_as_sc_mcu7t3v3__fillcap_16
Xinput140 VDD VDD VSS VSS north_in[4] _3967_/A gf180mcu_as_sc_mcu7t3v3__buff_12
Xinput151 VDD VDD VSS VSS nw_in[14] _4048_/A gf180mcu_as_sc_mcu7t3v3__buff_12
Xinput162 VDD VDD VSS VSS nw_in[24] _4127_/A gf180mcu_as_sc_mcu7t3v3__buff_12
XTAP_TAPCELL_ROW_34_1485 VDD VSS gf180mcu_as_sc_mcu7t3v3__tap_2
XTAP_TAPCELL_ROW_34_1474 VDD VSS gf180mcu_as_sc_mcu7t3v3__tap_2
XFILLER_40_1440 VDD VDD VSS VSS gf180mcu_as_sc_mcu7t3v3__fillcap_8
Xinput173 VDD VDD VSS VSS nw_in[3] _3957_/A gf180mcu_as_sc_mcu7t3v3__buff_12
Xinput184 VDD VDD VSS VSS se_in[12] wire880/A gf180mcu_as_sc_mcu7t3v3__buff_12
Xinput195 VDD VDD VSS VSS se_in[22] wire874/A gf180mcu_as_sc_mcu7t3v3__buff_12
XFILLER_189_454 VDD VDD VSS VSS gf180mcu_as_sc_mcu7t3v3__fillcap_16
XFILLER_204_241 VDD VDD VSS VSS gf180mcu_as_sc_mcu7t3v3__fillcap_4
XFILLER_31_110 VDD VDD VSS VSS gf180mcu_as_sc_mcu7t3v3__fillcap_16
XFILLER_75_1558 VDD VDD VSS VSS gf180mcu_as_sc_mcu7t3v3__fillcap_8
XFILLER_204_263 VDD VDD VSS VSS gf180mcu_as_sc_mcu7t3v3__fillcap_16
XFILLER_72_80 VDD VDD VSS VSS gf180mcu_as_sc_mcu7t3v3__fillcap_16
X_3860_ VDD VDD VSS VSS _5128_/Q _5129_/Q _5130_/Q _3871_/B gf180mcu_as_sc_mcu7t3v3__nor3_2
XFILLER_176_115 VDD VDD VSS VSS gf180mcu_as_sc_mcu7t3v3__fillcap_4
XFILLER_20_828 VDD VDD VSS VSS gf180mcu_as_sc_mcu7t3v3__fillcap_16
XFILLER_38_1380 VDD VDD VSS VSS gf180mcu_as_sc_mcu7t3v3__fill_1
XFILLER_38_1391 VDD VDD VSS VSS gf180mcu_as_sc_mcu7t3v3__fillcap_4
XPHY_EDGE_ROW_46_1_Right_567 VDD VSS gf180mcu_as_sc_mcu7t3v3__tap_2
X_3791_ VDD VDD VSS VSS _3791_/A _3791_/B _3791_/C _3799_/D _3792_/C gf180mcu_as_sc_mcu7t3v3__ao22_2
X_2811_ VDD VDD VSS VSS _4953_/D _2811_/C _2841_/A _4719_/A gf180mcu_as_sc_mcu7t3v3__aoi21_2
XTAP_TAPCELL_ROW_178_2090 VDD VSS gf180mcu_as_sc_mcu7t3v3__tap_2
XFILLER_203_1536 VDD VDD VSS VSS gf180mcu_as_sc_mcu7t3v3__fillcap_4
XFILLER_34_1266 VDD VDD VSS VSS gf180mcu_as_sc_mcu7t3v3__fillcap_4
XPHY_EDGE_ROW_128_1_Left_338 VDD VSS gf180mcu_as_sc_mcu7t3v3__tap_2
X_2742_ VDD VDD VSS VSS _4947_/Q _2742_/B _2742_/A _5483_/A gf180mcu_as_sc_mcu7t3v3__mux2_2
XFILLER_30_1119 VDD VDD VSS VSS gf180mcu_as_sc_mcu7t3v3__fillcap_16
XFILLER_8_361 VDD VDD VSS VSS gf180mcu_as_sc_mcu7t3v3__fillcap_16
XFILLER_195_1326 VDD VDD VSS VSS gf180mcu_as_sc_mcu7t3v3__fillcap_4
XFILLER_195_1348 VDD VDD VSS VSS gf180mcu_as_sc_mcu7t3v3__fillcap_16
X_4412_ VDD VDD VSS VSS _4456_/S _5010_/Q _5039_/Q _4413_/B gf180mcu_as_sc_mcu7t3v3__mux2_2
X_2673_ VDD VDD VSS VSS _2673_/B _5134_/Q _2674_/D gf180mcu_as_sc_mcu7t3v3__and2_2
XFILLER_82_1518 VDD VDD VSS VSS gf180mcu_as_sc_mcu7t3v3__fill_2
X_4343_ VDD VDD VSS VSS _4350_/A _5478_/A _4344_/C gf180mcu_as_sc_mcu7t3v3__and2_2
X_4274_ VDD VDD VSS VSS _4281_/S _5478_/A _5108_/Q _5108_/D gf180mcu_as_sc_mcu7t3v3__mux2_2
XFILLER_100_104 VDD VDD VSS VSS gf180mcu_as_sc_mcu7t3v3__fill_1
X_3225_ VDD VDD VSS VSS _3226_/D _3225_/B _3225_/A gf180mcu_as_sc_mcu7t3v3__nand2_2
XTAP_TAPCELL_ROW_162_3_3208 VDD VSS gf180mcu_as_sc_mcu7t3v3__tap_2
XFILLER_171_1392 VDD VDD VSS VSS gf180mcu_as_sc_mcu7t3v3__fillcap_16
XFILLER_28_928 VDD VDD VSS VSS gf180mcu_as_sc_mcu7t3v3__fillcap_16
X_3156_ VDD VDD VSS VSS _3181_/A _3156_/B _3156_/C _3157_/C gf180mcu_as_sc_mcu7t3v3__nor3_2
XFILLER_27_438 VDD VDD VSS VSS gf180mcu_as_sc_mcu7t3v3__fillcap_16
X_3087_ VDD VDD VSS VSS _4066_/A _3163_/B _3087_/C _3087_/D _3088_/C gf180mcu_as_sc_mcu7t3v3__ao22_2
XFILLER_208_591 VDD VDD VSS VSS gf180mcu_as_sc_mcu7t3v3__fillcap_4
XTAP_TAPCELL_ROW_206_2698 VDD VSS gf180mcu_as_sc_mcu7t3v3__tap_2
XFILLER_195_402 VDD VDD VSS VSS gf180mcu_as_sc_mcu7t3v3__fillcap_16
XFILLER_196_925 VDD VDD VSS VSS gf180mcu_as_sc_mcu7t3v3__fillcap_16
XFILLER_208_1469 VDD VDD VSS VSS gf180mcu_as_sc_mcu7t3v3__fillcap_16
XFILLER_196_947 VDD VDD VSS VSS gf180mcu_as_sc_mcu7t3v3__fillcap_16
XFILLER_210_244 VDD VDD VSS VSS gf180mcu_as_sc_mcu7t3v3__fill_2
XFILLER_22_165 VDD VDD VSS VSS gf180mcu_as_sc_mcu7t3v3__fillcap_8
XFILLER_10_349 VDD VDD VSS VSS gf180mcu_as_sc_mcu7t3v3__fill_2
X_3989_ VDD VDD VSS VSS _3989_/A _4030_/B _4031_/B _3989_/D _3991_/C gf180mcu_as_sc_mcu7t3v3__ao22_2
XTAP_TAPCELL_ROW_96_1_1733 VDD VSS gf180mcu_as_sc_mcu7t3v3__tap_2
XFILLER_13_1328 VDD VDD VSS VSS gf180mcu_as_sc_mcu7t3v3__fill_2
XFILLER_182_107 VDD VDD VSS VSS gf180mcu_as_sc_mcu7t3v3__fillcap_16
XFILLER_11_1052 VDD VDD VSS VSS gf180mcu_as_sc_mcu7t3v3__fillcap_8
XFILLER_191_696 VDD VDD VSS VSS gf180mcu_as_sc_mcu7t3v3__fillcap_4
XFILLER_117_43 VDD VDD VSS VSS gf180mcu_as_sc_mcu7t3v3__fillcap_4
XFILLER_190_195 VDD VDD VSS VSS gf180mcu_as_sc_mcu7t3v3__fill_1
XFILLER_89_132 VDD VDD VSS VSS gf180mcu_as_sc_mcu7t3v3__fillcap_8
XFILLER_77_58 VDD VDD VSS VSS gf180mcu_as_sc_mcu7t3v3__fillcap_8
XFILLER_89_176 VDD VDD VSS VSS gf180mcu_as_sc_mcu7t3v3__fillcap_16
Xdelaybuf_0_clk VDD VDD VSS VSS clk delaybuf_1_clk/A gf180mcu_as_sc_mcu7t3v3__clkbuff_12
XTAP_TAPCELL_ROW_6_854 VDD VSS gf180mcu_as_sc_mcu7t3v3__tap_2
XFILLER_98_1503 VDD VDD VSS VSS gf180mcu_as_sc_mcu7t3v3__fillcap_4
XTAP_TAPCELL_ROW_12_1002 VDD VSS gf180mcu_as_sc_mcu7t3v3__tap_2
Xfanout863 VDD VDD VSS VSS input34/Y _2832_/S gf180mcu_as_sc_mcu7t3v3__buff_12
Xfanout885 VDD VDD VSS VSS _3594_/D _3463_/D gf180mcu_as_sc_mcu7t3v3__buff_12
XTAP_TAPCELL_ROW_6_865 VDD VSS gf180mcu_as_sc_mcu7t3v3__tap_2
Xfanout896 VDD VDD VSS VSS _3760_/D _4753_/A gf180mcu_as_sc_mcu7t3v3__buff_12
XFILLER_93_68 VDD VDD VSS VSS gf180mcu_as_sc_mcu7t3v3__fill_2
XFILLER_148_1394 VDD VDD VSS VSS gf180mcu_as_sc_mcu7t3v3__fillcap_16
XPHY_EDGE_ROW_173_1_Right_694 VDD VSS gf180mcu_as_sc_mcu7t3v3__tap_2
XFILLER_14_699 VDD VDD VSS VSS gf180mcu_as_sc_mcu7t3v3__fillcap_16
XFILLER_201_244 VDD VDD VSS VSS gf180mcu_as_sc_mcu7t3v3__fillcap_16
XFILLER_122_1501 VDD VDD VSS VSS gf180mcu_as_sc_mcu7t3v3__fillcap_16
XFILLER_122_1523 VDD VDD VSS VSS gf180mcu_as_sc_mcu7t3v3__fillcap_8
XFILLER_9_136 VDD VDD VSS VSS gf180mcu_as_sc_mcu7t3v3__fillcap_4
XFILLER_10_861 VDD VDD VSS VSS gf180mcu_as_sc_mcu7t3v3__fill_1
XFILLER_122_1556 VDD VDD VSS VSS gf180mcu_as_sc_mcu7t3v3__fillcap_8
XFILLER_42_72 VDD VDD VSS VSS gf180mcu_as_sc_mcu7t3v3__fillcap_16
XFILLER_158_83 VDD VDD VSS VSS gf180mcu_as_sc_mcu7t3v3__fillcap_16
XFILLER_6_832 VDD VDD VSS VSS gf180mcu_as_sc_mcu7t3v3__fillcap_8
XFILLER_182_663 VDD VDD VSS VSS gf180mcu_as_sc_mcu7t3v3__fill_2
XFILLER_182_696 VDD VDD VSS VSS gf180mcu_as_sc_mcu7t3v3__fill_2
XFILLER_29_1324 VDD VDD VSS VSS gf180mcu_as_sc_mcu7t3v3__fillcap_4
XTAP_TAPCELL_ROW_36_1514 VDD VSS gf180mcu_as_sc_mcu7t3v3__tap_2
XPHY_EDGE_ROW_61_3_Right_98 VDD VSS gf180mcu_as_sc_mcu7t3v3__tap_2
XTAP_TAPCELL_ROW_36_1547 VDD VSS gf180mcu_as_sc_mcu7t3v3__tap_2
XTAP_TAPCELL_ROW_36_1536 VDD VSS gf180mcu_as_sc_mcu7t3v3__tap_2
XTAP_TAPCELL_ROW_36_1525 VDD VSS gf180mcu_as_sc_mcu7t3v3__tap_2
XFILLER_3_88 VDD VDD VSS VSS gf180mcu_as_sc_mcu7t3v3__fill_2
XFILLER_27_1092 VDD VDD VSS VSS gf180mcu_as_sc_mcu7t3v3__fillcap_16
XFILLER_42_1568 VDD VDD VSS VSS gf180mcu_as_sc_mcu7t3v3__fill_1
X_3010_ VDD VDD VSS VSS _3045_/A _3010_/B _3010_/C _3045_/D _3012_/C gf180mcu_as_sc_mcu7t3v3__ao211_2
XFILLER_25_909 VDD VDD VSS VSS gf180mcu_as_sc_mcu7t3v3__fill_1
XFILLER_166_1450 VDD VDD VSS VSS gf180mcu_as_sc_mcu7t3v3__fill_1
XFILLER_184_1049 VDD VDD VSS VSS gf180mcu_as_sc_mcu7t3v3__fillcap_16
XFILLER_18_983 VDD VDD VSS VSS gf180mcu_as_sc_mcu7t3v3__fillcap_4
X_4961_ VDD VDD VSS VSS _5111_/CLK _4961_/D _4961_/Q gf180mcu_as_sc_mcu7t3v3__dfxtp_2
XFILLER_178_925 VDD VDD VSS VSS gf180mcu_as_sc_mcu7t3v3__fillcap_16
XFILLER_205_594 VDD VDD VSS VSS gf180mcu_as_sc_mcu7t3v3__fillcap_16
XFILLER_32_441 VDD VDD VSS VSS gf180mcu_as_sc_mcu7t3v3__fill_2
XFILLER_36_1328 VDD VDD VSS VSS gf180mcu_as_sc_mcu7t3v3__fillcap_16
X_4892_ VDD VDD VSS VSS _4904_/CLK _4892_/D _4892_/Q gf180mcu_as_sc_mcu7t3v3__dfxtp_2
X_3912_ VDD VDD VSS VSS _4198_/A _4908_/Q _3912_/Y gf180mcu_as_sc_mcu7t3v3__and2_2
XTAP_TAPCELL_ROW_201_2584 VDD VSS gf180mcu_as_sc_mcu7t3v3__tap_2
XTAP_TAPCELL_ROW_176_2038 VDD VSS gf180mcu_as_sc_mcu7t3v3__tap_2
XFILLER_178_947 VDD VDD VSS VSS gf180mcu_as_sc_mcu7t3v3__fillcap_16
X_3843_ VDD VDD VSS VSS _3843_/S _3843_/B _3845_/A _3844_/B gf180mcu_as_sc_mcu7t3v3__mux2_2
XTAP_TAPCELL_ROW_201_2595 VDD VSS gf180mcu_as_sc_mcu7t3v3__tap_2
XTAP_TAPCELL_ROW_176_2049 VDD VSS gf180mcu_as_sc_mcu7t3v3__tap_2
XFILLER_193_906 VDD VDD VSS VSS gf180mcu_as_sc_mcu7t3v3__fillcap_4
XFILLER_193_928 VDD VDD VSS VSS gf180mcu_as_sc_mcu7t3v3__fillcap_16
XFILLER_20_658 VDD VDD VSS VSS gf180mcu_as_sc_mcu7t3v3__fillcap_4
XPHY_EDGE_ROW_47_1_Right_568 VDD VSS gf180mcu_as_sc_mcu7t3v3__tap_2
XFILLER_164_107 VDD VDD VSS VSS gf180mcu_as_sc_mcu7t3v3__fillcap_16
XFILLER_192_427 VDD VDD VSS VSS gf180mcu_as_sc_mcu7t3v3__fill_1
XTAP_TAPCELL_ROW_106_3_3040 VDD VSS gf180mcu_as_sc_mcu7t3v3__tap_2
X_3774_ VDD VDD VSS VSS _4155_/A _3802_/B _3802_/C _3775_/C _3774_/D gf180mcu_as_sc_mcu7t3v3__aoi211_2
XFILLER_157_170 VDD VDD VSS VSS gf180mcu_as_sc_mcu7t3v3__fillcap_16
XFILLER_192_449 VDD VDD VSS VSS gf180mcu_as_sc_mcu7t3v3__fillcap_4
XFILLER_9_692 VDD VDD VSS VSS gf180mcu_as_sc_mcu7t3v3__fillcap_8
XPHY_EDGE_ROW_71_3_Left_456 VDD VSS gf180mcu_as_sc_mcu7t3v3__tap_2
X_2725_ VDD VDD VSS VSS _2732_/S _4963_/Q _4972_/Q _2727_/A gf180mcu_as_sc_mcu7t3v3__mux2_2
Xoutput411 VDD VDD VSS VSS _4831_/Q south_out[26] gf180mcu_as_sc_mcu7t3v3__buff_12
Xoutput400 VDD VDD VSS VSS _4821_/Q south_out[16] gf180mcu_as_sc_mcu7t3v3__buff_12
X_2656_ VDD VDD VSS VSS _2666_/B _2656_/B _2656_/C _2735_/D _2657_/D gf180mcu_as_sc_mcu7t3v3__ao211_2
XTAP_TAPCELL_ROW_210_2809 VDD VSS gf180mcu_as_sc_mcu7t3v3__tap_2
XFILLER_47_1413 VDD VDD VSS VSS gf180mcu_as_sc_mcu7t3v3__fill_2
Xoutput444 VDD VDD VSS VSS _4898_/Q west_out[25] gf180mcu_as_sc_mcu7t3v3__buff_12
Xoutput433 VDD VDD VSS VSS _4888_/Q west_out[15] gf180mcu_as_sc_mcu7t3v3__buff_12
Xoutput422 VDD VDD VSS VSS _4810_/Q south_out[5] gf180mcu_as_sc_mcu7t3v3__buff_12
XFILLER_138_1563 VDD VDD VSS VSS gf180mcu_as_sc_mcu7t3v3__fillcap_4
XFILLER_173_1454 VDD VDD VSS VSS gf180mcu_as_sc_mcu7t3v3__fill_1
Xoutput455 VDD VDD VSS VSS _4877_/Q west_out[4] gf180mcu_as_sc_mcu7t3v3__buff_12
X_2587_ VDD VDD VSS VSS _2587_/Y _2588_/B _2588_/A gf180mcu_as_sc_mcu7t3v3__nand2_2
X_4326_ VDD VDD VSS VSS _4326_/S _5156_/Q _5155_/Q _5155_/D gf180mcu_as_sc_mcu7t3v3__mux2_2
X_4257_ VDD VDD VSS VSS _4257_/S _4257_/B _5093_/Q _5093_/D gf180mcu_as_sc_mcu7t3v3__mux2_2
XTAP_TAPCELL_ROW_3_802 VDD VSS gf180mcu_as_sc_mcu7t3v3__tap_2
XTAP_TAPCELL_ROW_208_2749 VDD VSS gf180mcu_as_sc_mcu7t3v3__tap_2
XTAP_TAPCELL_ROW_208_2738 VDD VSS gf180mcu_as_sc_mcu7t3v3__tap_2
XFILLER_210_1315 VDD VDD VSS VSS gf180mcu_as_sc_mcu7t3v3__fillcap_4
XFILLER_86_168 VDD VDD VSS VSS gf180mcu_as_sc_mcu7t3v3__fillcap_4
XFILLER_86_179 VDD VDD VSS VSS gf180mcu_as_sc_mcu7t3v3__fill_1
X_4188_ VDD VDD VSS VSS _4248_/B _4191_/B _4191_/C _5026_/Q _5026_/D gf180mcu_as_sc_mcu7t3v3__ao22_2
X_3208_ VDD VDD VSS VSS _3209_/B _3794_/A _3218_/B _3208_/C gf180mcu_as_sc_mcu7t3v3__ao21_2
XFILLER_210_1359 VDD VDD VSS VSS gf180mcu_as_sc_mcu7t3v3__fill_1
XFILLER_27_224 VDD VDD VSS VSS gf180mcu_as_sc_mcu7t3v3__fill_2
X_3139_ VDD VDD VSS VSS _3140_/C _3139_/C _3150_/C _4109_/A gf180mcu_as_sc_mcu7t3v3__aoi21_2
XFILLER_27_268 VDD VDD VSS VSS gf180mcu_as_sc_mcu7t3v3__fill_1
XFILLER_58_1520 VDD VDD VSS VSS gf180mcu_as_sc_mcu7t3v3__fill_1
XFILLER_63_16 VDD VDD VSS VSS gf180mcu_as_sc_mcu7t3v3__fill_1
XFILLER_93_1422 VDD VDD VSS VSS gf180mcu_as_sc_mcu7t3v3__fill_1
XFILLER_179_38 VDD VDD VSS VSS gf180mcu_as_sc_mcu7t3v3__fillcap_16
XFILLER_19_1537 VDD VDD VSS VSS gf180mcu_as_sc_mcu7t3v3__fill_2
XFILLER_106_1518 VDD VDD VSS VSS gf180mcu_as_sc_mcu7t3v3__fill_2
XFILLER_180_1425 VDD VDD VSS VSS gf180mcu_as_sc_mcu7t3v3__fillcap_8
XFILLER_204_1119 VDD VDD VSS VSS gf180mcu_as_sc_mcu7t3v3__fillcap_16
XFILLER_54_1439 VDD VDD VSS VSS gf180mcu_as_sc_mcu7t3v3__fillcap_8
XFILLER_93_1488 VDD VDD VSS VSS gf180mcu_as_sc_mcu7t3v3__fillcap_16
XFILLER_11_636 VDD VDD VSS VSS gf180mcu_as_sc_mcu7t3v3__fill_1
XFILLER_141_1409 VDD VDD VSS VSS gf180mcu_as_sc_mcu7t3v3__fillcap_4
XFILLER_180_1469 VDD VDD VSS VSS gf180mcu_as_sc_mcu7t3v3__fillcap_16
XFILLER_195_232 VDD VDD VSS VSS gf180mcu_as_sc_mcu7t3v3__fill_2
Xwire505 VDD VDD VSS VSS _2998_/Y wire505/Y gf180mcu_as_sc_mcu7t3v3__clkbuff_12
XFILLER_183_438 VDD VDD VSS VSS gf180mcu_as_sc_mcu7t3v3__fill_2
XFILLER_195_276 VDD VDD VSS VSS gf180mcu_as_sc_mcu7t3v3__fillcap_4
XFILLER_12_53 VDD VDD VSS VSS gf180mcu_as_sc_mcu7t3v3__fillcap_16
XFILLER_13_1136 VDD VDD VSS VSS gf180mcu_as_sc_mcu7t3v3__fillcap_16
XFILLER_6_139 VDD VDD VSS VSS gf180mcu_as_sc_mcu7t3v3__fillcap_16
XFILLER_178_1343 VDD VDD VSS VSS gf180mcu_as_sc_mcu7t3v3__fillcap_16
XFILLER_65_1568 VDD VDD VSS VSS gf180mcu_as_sc_mcu7t3v3__fill_1
XTAP_TAPCELL_ROW_119_1_1801 VDD VSS gf180mcu_as_sc_mcu7t3v3__tap_2
XFILLER_77_124 VDD VDD VSS VSS gf180mcu_as_sc_mcu7t3v3__fill_1
XFILLER_77_135 VDD VDD VSS VSS gf180mcu_as_sc_mcu7t3v3__fillcap_4
Xfanout660 VDD VDD VSS VSS _2930_/Y _3150_/C gf180mcu_as_sc_mcu7t3v3__buff_12
XTAP_TAPCELL_ROW_31_1411 VDD VSS gf180mcu_as_sc_mcu7t3v3__tap_2
XFILLER_144_85 VDD VDD VSS VSS gf180mcu_as_sc_mcu7t3v3__fillcap_8
Xfanout671 VDD VDD VSS VSS _4629_/B _4750_/D gf180mcu_as_sc_mcu7t3v3__buff_12
Xfanout682 VDD VDD VSS VSS _3564_/Y _3741_/C gf180mcu_as_sc_mcu7t3v3__buff_12
XTAP_TAPCELL_ROW_31_1422 VDD VSS gf180mcu_as_sc_mcu7t3v3__tap_2
XFILLER_19_736 VDD VDD VSS VSS gf180mcu_as_sc_mcu7t3v3__fillcap_8
XFILLER_207_804 VDD VDD VSS VSS gf180mcu_as_sc_mcu7t3v3__fillcap_16
XFILLER_92_138 VDD VDD VSS VSS gf180mcu_as_sc_mcu7t3v3__fill_1
XFILLER_189_1472 VDD VDD VSS VSS gf180mcu_as_sc_mcu7t3v3__fillcap_4
XFILLER_37_72 VDD VDD VSS VSS gf180mcu_as_sc_mcu7t3v3__fillcap_16
XFILLER_160_84 VDD VDD VSS VSS gf180mcu_as_sc_mcu7t3v3__fillcap_16
XFILLER_18_279 VDD VDD VSS VSS gf180mcu_as_sc_mcu7t3v3__fillcap_16
XFILLER_2_1072 VDD VDD VSS VSS gf180mcu_as_sc_mcu7t3v3__fillcap_8
XFILLER_26_290 VDD VDD VSS VSS gf180mcu_as_sc_mcu7t3v3__fillcap_16
XTAP_TAPCELL_ROW_29_1362 VDD VSS gf180mcu_as_sc_mcu7t3v3__tap_2
XFILLER_14_452 VDD VDD VSS VSS gf180mcu_as_sc_mcu7t3v3__fill_2
XFILLER_30_923 VDD VDD VSS VSS gf180mcu_as_sc_mcu7t3v3__fill_2
XFILLER_72_1539 VDD VDD VSS VSS gf180mcu_as_sc_mcu7t3v3__fill_2
XTAP_TAPCELL_ROW_29_1373 VDD VSS gf180mcu_as_sc_mcu7t3v3__tap_2
XFILLER_175_928 VDD VDD VSS VSS gf180mcu_as_sc_mcu7t3v3__fillcap_8
XFILLER_186_243 VDD VDD VSS VSS gf180mcu_as_sc_mcu7t3v3__fill_2
XFILLER_187_766 VDD VDD VSS VSS gf180mcu_as_sc_mcu7t3v3__fillcap_4
XFILLER_202_575 VDD VDD VSS VSS gf180mcu_as_sc_mcu7t3v3__fillcap_16
XFILLER_146_107 VDD VDD VSS VSS gf180mcu_as_sc_mcu7t3v3__fillcap_16
XFILLER_174_405 VDD VDD VSS VSS gf180mcu_as_sc_mcu7t3v3__fill_2
XFILLER_187_788 VDD VDD VSS VSS gf180mcu_as_sc_mcu7t3v3__fillcap_16
XFILLER_202_597 VDD VDD VSS VSS gf180mcu_as_sc_mcu7t3v3__fillcap_16
XFILLER_122_1364 VDD VDD VSS VSS gf180mcu_as_sc_mcu7t3v3__fillcap_4
XFILLER_190_909 VDD VDD VSS VSS gf180mcu_as_sc_mcu7t3v3__fillcap_16
XFILLER_200_1539 VDD VDD VSS VSS gf180mcu_as_sc_mcu7t3v3__fillcap_4
XFILLER_31_1236 VDD VDD VSS VSS gf180mcu_as_sc_mcu7t3v3__fillcap_8
Xclkbuf_3_7__f_clk_regs VDD VDD VSS VSS clkbuf_2_3_0_clk_regs/Y clkbuf_leaf_7_clk_regs/A
+ gf180mcu_as_sc_mcu7t3v3__clkbuff_12
XFILLER_183_994 VDD VDD VSS VSS gf180mcu_as_sc_mcu7t3v3__fill_2
X_3490_ VDD VDD VSS VSS _4146_/A _3504_/B _3490_/C _3490_/D _3491_/B gf180mcu_as_sc_mcu7t3v3__ao211_2
X_2510_ VDD VDD VSS VSS _4708_/B _4703_/B _4633_/A gf180mcu_as_sc_mcu7t3v3__nor2b_2
XTAP_TAPCELL_ROW_76_3_2950 VDD VSS gf180mcu_as_sc_mcu7t3v3__tap_2
XFILLER_192_1329 VDD VDD VSS VSS gf180mcu_as_sc_mcu7t3v3__fillcap_16
XFILLER_5_150 VDD VDD VSS VSS gf180mcu_as_sc_mcu7t3v3__fillcap_4
XFILLER_6_684 VDD VDD VSS VSS gf180mcu_as_sc_mcu7t3v3__fill_1
X_2441_ VDD VDD VSS VSS _4091_/A _2441_/A gf180mcu_as_sc_mcu7t3v3__inv_2
XFILLER_29_1132 VDD VDD VSS VSS gf180mcu_as_sc_mcu7t3v3__fillcap_8
XFILLER_29_1176 VDD VDD VSS VSS gf180mcu_as_sc_mcu7t3v3__fill_1
XPHY_EDGE_ROW_150_3_Right_187 VDD VSS gf180mcu_as_sc_mcu7t3v3__tap_2
X_5160_ VDD VDD VSS VSS clkload7/A _5160_/D _5160_/Q gf180mcu_as_sc_mcu7t3v3__dfxtp_2
Xclkbuf_leaf_14_clk_regs VDD VDD VSS VSS clkbuf_3_4__f_clk_regs/Y _5276_/CLK gf180mcu_as_sc_mcu7t3v3__clkbuff_12
XFILLER_110_221 VDD VDD VSS VSS gf180mcu_as_sc_mcu7t3v3__fill_1
XFILLER_9_1259 VDD VDD VSS VSS gf180mcu_as_sc_mcu7t3v3__fill_1
X_5091_ VDD VDD VSS VSS clkload4/A _5091_/D _5091_/Q gf180mcu_as_sc_mcu7t3v3__dfxtp_2
X_4111_ VDD VDD VSS VSS _4128_/B _4111_/A _4113_/C gf180mcu_as_sc_mcu7t3v3__and2_2
X_4042_ VDD VDD VSS VSS _4043_/C _4042_/B _4042_/A gf180mcu_as_sc_mcu7t3v3__nor2_2
XFILLER_168_1523 VDD VDD VSS VSS gf180mcu_as_sc_mcu7t3v3__fillcap_16
XFILLER_25_706 VDD VDD VSS VSS gf180mcu_as_sc_mcu7t3v3__fill_2
XTAP_TAPCELL_ROW_203_2635 VDD VSS gf180mcu_as_sc_mcu7t3v3__tap_2
XTAP_TAPCELL_ROW_203_2646 VDD VSS gf180mcu_as_sc_mcu7t3v3__tap_2
XTAP_TAPCELL_ROW_199_2561 VDD VSS gf180mcu_as_sc_mcu7t3v3__tap_2
XTAP_TAPCELL_ROW_199_2550 VDD VSS gf180mcu_as_sc_mcu7t3v3__tap_2
XFILLER_197_508 VDD VDD VSS VSS gf180mcu_as_sc_mcu7t3v3__fillcap_16
XFILLER_209_1520 VDD VDD VSS VSS gf180mcu_as_sc_mcu7t3v3__fillcap_16
XFILLER_209_1542 VDD VDD VSS VSS gf180mcu_as_sc_mcu7t3v3__fillcap_16
X_4944_ VDD VDD VSS VSS _5216_/CLK _4944_/D _4944_/Q gf180mcu_as_sc_mcu7t3v3__dfxtp_2
XFILLER_21_912 VDD VDD VSS VSS gf180mcu_as_sc_mcu7t3v3__fillcap_16
XFILLER_33_772 VDD VDD VSS VSS gf180mcu_as_sc_mcu7t3v3__fillcap_8
XTAP_TAPCELL_ROW_195_2469 VDD VSS gf180mcu_as_sc_mcu7t3v3__tap_2
XTAP_TAPCELL_ROW_195_2458 VDD VSS gf180mcu_as_sc_mcu7t3v3__tap_2
XFILLER_36_1158 VDD VDD VSS VSS gf180mcu_as_sc_mcu7t3v3__fillcap_8
X_4875_ VDD VDD VSS VSS _4916_/CLK _4875_/D _4875_/Q gf180mcu_as_sc_mcu7t3v3__dfxtp_2
XFILLER_137_107 VDD VDD VSS VSS gf180mcu_as_sc_mcu7t3v3__fillcap_16
XFILLER_140_1420 VDD VDD VSS VSS gf180mcu_as_sc_mcu7t3v3__fill_1
XFILLER_177_265 VDD VDD VSS VSS gf180mcu_as_sc_mcu7t3v3__fillcap_4
XFILLER_53_1450 VDD VDD VSS VSS gf180mcu_as_sc_mcu7t3v3__fillcap_8
X_3826_ VDD VDD VSS VSS _3827_/B _3826_/B _4908_/Q gf180mcu_as_sc_mcu7t3v3__nor2_2
XFILLER_140_1453 VDD VDD VSS VSS gf180mcu_as_sc_mcu7t3v3__fillcap_16
XFILLER_20_477 VDD VDD VSS VSS gf180mcu_as_sc_mcu7t3v3__fill_2
XPHY_EDGE_ROW_48_1_Right_569 VDD VSS gf180mcu_as_sc_mcu7t3v3__tap_2
X_3757_ VDD VDD VSS VSS _3758_/C _4135_/A _3761_/B _3757_/C gf180mcu_as_sc_mcu7t3v3__ao21_2
XFILLER_180_419 VDD VDD VSS VSS gf180mcu_as_sc_mcu7t3v3__fillcap_8
X_2708_ VDD VDD VSS VSS _2709_/D _2729_/C _2722_/B _2708_/A gf180mcu_as_sc_mcu7t3v3__aoi21b_2
XFILLER_88_1568 VDD VDD VSS VSS gf180mcu_as_sc_mcu7t3v3__fill_1
X_3688_ VDD VDD VSS VSS _4931_/Q _3740_/B _3741_/C _4062_/A _3689_/D gf180mcu_as_sc_mcu7t3v3__ao22_2
XTAP_TAPCELL_ROW_8_905 VDD VSS gf180mcu_as_sc_mcu7t3v3__tap_2
X_2639_ VDD VDD VSS VSS _4264_/B _2639_/B _2639_/A _2640_/B gf180mcu_as_sc_mcu7t3v3__mux2_2
XTAP_TAPCELL_ROW_8_916 VDD VSS gf180mcu_as_sc_mcu7t3v3__tap_2
XFILLER_59_146 VDD VDD VSS VSS gf180mcu_as_sc_mcu7t3v3__fill_2
X_4309_ VDD VDD VSS VSS _4314_/S _5139_/Q _5138_/Q _5138_/D gf180mcu_as_sc_mcu7t3v3__mux2_2
XFILLER_114_66 VDD VDD VSS VSS gf180mcu_as_sc_mcu7t3v3__fillcap_16
XFILLER_28_522 VDD VDD VSS VSS gf180mcu_as_sc_mcu7t3v3__fill_2
XFILLER_74_37 VDD VDD VSS VSS gf180mcu_as_sc_mcu7t3v3__fillcap_16
XFILLER_204_807 VDD VDD VSS VSS gf180mcu_as_sc_mcu7t3v3__fillcap_16
XFILLER_210_1189 VDD VDD VSS VSS gf180mcu_as_sc_mcu7t3v3__fill_1
XFILLER_58_1383 VDD VDD VSS VSS gf180mcu_as_sc_mcu7t3v3__fillcap_16
XFILLER_11_422 VDD VDD VSS VSS gf180mcu_as_sc_mcu7t3v3__fillcap_16
XFILLER_145_1364 VDD VDD VSS VSS gf180mcu_as_sc_mcu7t3v3__fillcap_16
XFILLER_128_107 VDD VDD VSS VSS gf180mcu_as_sc_mcu7t3v3__fillcap_8
XFILLER_19_1389 VDD VDD VSS VSS gf180mcu_as_sc_mcu7t3v3__fillcap_8
XFILLER_23_293 VDD VDD VSS VSS gf180mcu_as_sc_mcu7t3v3__fillcap_8
XFILLER_184_769 VDD VDD VSS VSS gf180mcu_as_sc_mcu7t3v3__fillcap_16
XFILLER_136_173 VDD VDD VSS VSS gf180mcu_as_sc_mcu7t3v3__fill_2
XFILLER_178_1151 VDD VDD VSS VSS gf180mcu_as_sc_mcu7t3v3__fillcap_4
XTAP_TAPCELL_ROW_20_1178 VDD VSS gf180mcu_as_sc_mcu7t3v3__tap_2
XTAP_TAPCELL_ROW_20_1167 VDD VSS gf180mcu_as_sc_mcu7t3v3__tap_2
XFILLER_174_1026 VDD VDD VSS VSS gf180mcu_as_sc_mcu7t3v3__fill_1
XFILLER_191_290 VDD VDD VSS VSS gf180mcu_as_sc_mcu7t3v3__fillcap_4
XFILLER_3_643 VDD VDD VSS VSS gf180mcu_as_sc_mcu7t3v3__fillcap_4
XFILLER_191_1340 VDD VDD VSS VSS gf180mcu_as_sc_mcu7t3v3__fillcap_4
XFILLER_97_208 VDD VDD VSS VSS gf180mcu_as_sc_mcu7t3v3__fill_2
XTAP_TAPCELL_ROW_44_1_1577 VDD VSS gf180mcu_as_sc_mcu7t3v3__tap_2
XFILLER_156_1493 VDD VDD VSS VSS gf180mcu_as_sc_mcu7t3v3__fill_2
XFILLER_65_1398 VDD VDD VSS VSS gf180mcu_as_sc_mcu7t3v3__fillcap_16
XFILLER_117_1488 VDD VDD VSS VSS gf180mcu_as_sc_mcu7t3v3__fillcap_4
XFILLER_8_1270 VDD VDD VSS VSS gf180mcu_as_sc_mcu7t3v3__fillcap_16
XFILLER_171_50 VDD VDD VSS VSS gf180mcu_as_sc_mcu7t3v3__fillcap_16
XFILLER_171_72 VDD VDD VSS VSS gf180mcu_as_sc_mcu7t3v3__fillcap_16
XFILLER_48_82 VDD VDD VSS VSS gf180mcu_as_sc_mcu7t3v3__fill_2
XFILLER_185_1100 VDD VDD VSS VSS gf180mcu_as_sc_mcu7t3v3__fillcap_16
XFILLER_24_1084 VDD VDD VSS VSS gf180mcu_as_sc_mcu7t3v3__fill_1
XPHY_EDGE_ROW_137_1_Left_347 VDD VSS gf180mcu_as_sc_mcu7t3v3__tap_2
XFILLER_185_1122 VDD VDD VSS VSS gf180mcu_as_sc_mcu7t3v3__fillcap_16
XFILLER_206_155 VDD VDD VSS VSS gf180mcu_as_sc_mcu7t3v3__fillcap_16
XFILLER_206_177 VDD VDD VSS VSS gf180mcu_as_sc_mcu7t3v3__fillcap_16
XFILLER_76_1450 VDD VDD VSS VSS gf180mcu_as_sc_mcu7t3v3__fill_1
XFILLER_15_772 VDD VDD VSS VSS gf180mcu_as_sc_mcu7t3v3__fillcap_16
X_2990_ VDD VDD VSS VSS _2990_/Y _2990_/C _3005_/A _3971_/A gf180mcu_as_sc_mcu7t3v3__aoi21_2
XFILLER_9_43 VDD VDD VSS VSS gf180mcu_as_sc_mcu7t3v3__fillcap_16
X_4660_ VDD VDD VSS VSS _5239_/D _4660_/C _4660_/B _4660_/A gf180mcu_as_sc_mcu7t3v3__aoi21b_2
XFILLER_174_235 VDD VDD VSS VSS gf180mcu_as_sc_mcu7t3v3__fill_2
XFILLER_31_1022 VDD VDD VSS VSS gf180mcu_as_sc_mcu7t3v3__fill_1
X_3611_ VDD VDD VSS VSS _3615_/B _3611_/C _3652_/B _3984_/A gf180mcu_as_sc_mcu7t3v3__aoi21_2
XTAP_TAPCELL_ROW_190_2355 VDD VSS gf180mcu_as_sc_mcu7t3v3__tap_2
XTAP_TAPCELL_ROW_190_2344 VDD VSS gf180mcu_as_sc_mcu7t3v3__tap_2
XFILLER_7_960 VDD VDD VSS VSS gf180mcu_as_sc_mcu7t3v3__fillcap_8
X_4591_ VDD VDD VSS VSS _4591_/B _4591_/A _4592_/D gf180mcu_as_sc_mcu7t3v3__and2_2
XFILLER_7_982 VDD VDD VSS VSS gf180mcu_as_sc_mcu7t3v3__fillcap_8
Xwire880 VDD VDD VSS VSS wire880/A _4033_/A gf180mcu_as_sc_mcu7t3v3__clkbuff_12
X_3542_ VDD VDD VSS VSS _3914_/B _3542_/A _3542_/Y gf180mcu_as_sc_mcu7t3v3__and2_2
XFILLER_182_290 VDD VDD VSS VSS gf180mcu_as_sc_mcu7t3v3__fillcap_4
XFILLER_6_492 VDD VDD VSS VSS gf180mcu_as_sc_mcu7t3v3__fillcap_8
X_3473_ VDD VDD VSS VSS _4128_/A _3503_/B _3473_/C _3473_/D _3475_/C gf180mcu_as_sc_mcu7t3v3__ao211_2
X_5212_ VDD VDD VSS VSS _5214_/CLK _5212_/D _5212_/Q gf180mcu_as_sc_mcu7t3v3__dfxtp_2
X_2424_ VDD VDD VSS VSS _3944_/A _2424_/A gf180mcu_as_sc_mcu7t3v3__inv_2
XTAP_TAPCELL_ROW_90_1_1714 VDD VSS gf180mcu_as_sc_mcu7t3v3__tap_2
X_5143_ VDD VDD VSS VSS _5220_/CLK _5143_/D _5143_/Q gf180mcu_as_sc_mcu7t3v3__dfxtp_2
XFILLER_135_1566 VDD VDD VSS VSS gf180mcu_as_sc_mcu7t3v3__fill_2
XFILLER_170_1446 VDD VDD VSS VSS gf180mcu_as_sc_mcu7t3v3__fillcap_4
XFILLER_29_319 VDD VDD VSS VSS gf180mcu_as_sc_mcu7t3v3__fillcap_16
XPHY_EDGE_ROW_151_3_Right_188 VDD VSS gf180mcu_as_sc_mcu7t3v3__tap_2
XPHY_EDGE_ROW_69_1_Left_279 VDD VSS gf180mcu_as_sc_mcu7t3v3__tap_2
X_5074_ VDD VDD VSS VSS clkload1/A _5074_/D _5074_/Q gf180mcu_as_sc_mcu7t3v3__dfxtp_2
X_4025_ VDD VDD VSS VSS _4025_/A _4033_/B _4025_/C _4025_/D _4026_/B gf180mcu_as_sc_mcu7t3v3__ao211_2
XTAP_TAPCELL_ROW_70_1_1656 VDD VSS gf180mcu_as_sc_mcu7t3v3__tap_2
XTAP_TAPCELL_ROW_197_2509 VDD VSS gf180mcu_as_sc_mcu7t3v3__tap_2
XFILLER_168_1364 VDD VDD VSS VSS gf180mcu_as_sc_mcu7t3v3__fill_2
XFILLER_20_1471 VDD VDD VSS VSS gf180mcu_as_sc_mcu7t3v3__fillcap_8
XFILLER_44_18 VDD VDD VSS VSS gf180mcu_as_sc_mcu7t3v3__fillcap_16
XFILLER_64_193 VDD VDD VSS VSS gf180mcu_as_sc_mcu7t3v3__fillcap_8
XFILLER_12_208 VDD VDD VSS VSS gf180mcu_as_sc_mcu7t3v3__fillcap_16
XFILLER_198_839 VDD VDD VSS VSS gf180mcu_as_sc_mcu7t3v3__fillcap_16
Xsram2048.u_bank1_918 VDD VDD VSS VSS sram2048.u_bank1/WEN[0] gf180mcu_as_sc_mcu7t3v3__tiel_4
XFILLER_142_1515 VDD VDD VSS VSS gf180mcu_as_sc_mcu7t3v3__fillcap_4
XFILLER_16_1507 VDD VDD VSS VSS gf180mcu_as_sc_mcu7t3v3__fillcap_4
XFILLER_197_349 VDD VDD VSS VSS gf180mcu_as_sc_mcu7t3v3__fill_1
X_4927_ VDD VDD VSS VSS clkload7/A _4927_/D _4927_/Q gf180mcu_as_sc_mcu7t3v3__dfxtp_2
XFILLER_165_202 VDD VDD VSS VSS gf180mcu_as_sc_mcu7t3v3__fillcap_8
XFILLER_90_1469 VDD VDD VSS VSS gf180mcu_as_sc_mcu7t3v3__fillcap_8
X_4858_ VDD VDD VSS VSS _5192_/CLK _4858_/D _4858_/Q gf180mcu_as_sc_mcu7t3v3__dfxtp_2
XFILLER_14_1231 VDD VDD VSS VSS gf180mcu_as_sc_mcu7t3v3__fill_2
XFILLER_20_263 VDD VDD VSS VSS gf180mcu_as_sc_mcu7t3v3__fillcap_16
X_3809_ VDD VDD VSS VSS _3932_/C _3818_/C _3818_/D gf180mcu_as_sc_mcu7t3v3__nand2_2
XFILLER_181_706 VDD VDD VSS VSS gf180mcu_as_sc_mcu7t3v3__fill_2
X_4789_ VDD VDD VSS VSS _5220_/CLK _4789_/D _4789_/Q gf180mcu_as_sc_mcu7t3v3__dfxtp_2
XFILLER_14_1297 VDD VDD VSS VSS gf180mcu_as_sc_mcu7t3v3__fillcap_16
XFILLER_180_238 VDD VDD VSS VSS gf180mcu_as_sc_mcu7t3v3__fill_2
XFILLER_109_88 VDD VDD VSS VSS gf180mcu_as_sc_mcu7t3v3__fillcap_16
XPHY_EDGE_ROW_159_3_Left_544 VDD VSS gf180mcu_as_sc_mcu7t3v3__tap_2
XFILLER_29_820 VDD VDD VSS VSS gf180mcu_as_sc_mcu7t3v3__fillcap_16
XFILLER_29_853 VDD VDD VSS VSS gf180mcu_as_sc_mcu7t3v3__fillcap_16
XFILLER_85_69 VDD VDD VSS VSS gf180mcu_as_sc_mcu7t3v3__fill_1
XFILLER_16_514 VDD VDD VSS VSS gf180mcu_as_sc_mcu7t3v3__fillcap_8
XFILLER_186_1431 VDD VDD VSS VSS gf180mcu_as_sc_mcu7t3v3__fillcap_4
XFILLER_55_160 VDD VDD VSS VSS gf180mcu_as_sc_mcu7t3v3__fill_1
XFILLER_62_119 VDD VDD VSS VSS gf180mcu_as_sc_mcu7t3v3__fill_1
XFILLER_99_1483 VDD VDD VSS VSS gf180mcu_as_sc_mcu7t3v3__fill_2
XFILLER_203_136 VDD VDD VSS VSS gf180mcu_as_sc_mcu7t3v3__fillcap_4
XTAP_TAPCELL_ROW_26_1310 VDD VSS gf180mcu_as_sc_mcu7t3v3__tap_2
XFILLER_203_158 VDD VDD VSS VSS gf180mcu_as_sc_mcu7t3v3__fillcap_16
XFILLER_24_591 VDD VDD VSS VSS gf180mcu_as_sc_mcu7t3v3__fillcap_4
XPHY_EDGE_ROW_113_3_Right_150 VDD VSS gf180mcu_as_sc_mcu7t3v3__tap_2
XFILLER_12_753 VDD VDD VSS VSS gf180mcu_as_sc_mcu7t3v3__fillcap_16
XTAP_TAPCELL_ROW_22_1207 VDD VSS gf180mcu_as_sc_mcu7t3v3__tap_2
XFILLER_184_522 VDD VDD VSS VSS gf180mcu_as_sc_mcu7t3v3__fill_2
XFILLER_8_724 VDD VDD VSS VSS gf180mcu_as_sc_mcu7t3v3__fillcap_8
XTAP_TAPCELL_ROW_95_1_1729 VDD VSS gf180mcu_as_sc_mcu7t3v3__tap_2
XTAP_TAPCELL_ROW_22_1218 VDD VSS gf180mcu_as_sc_mcu7t3v3__tap_2
XTAP_TAPCELL_ROW_10_943 VDD VSS gf180mcu_as_sc_mcu7t3v3__tap_2
XTAP_TAPCELL_ROW_10_954 VDD VSS gf180mcu_as_sc_mcu7t3v3__tap_2
XFILLER_109_173 VDD VDD VSS VSS gf180mcu_as_sc_mcu7t3v3__fillcap_4
XFILLER_193_1402 VDD VDD VSS VSS gf180mcu_as_sc_mcu7t3v3__fillcap_16
XFILLER_158_1566 VDD VDD VSS VSS gf180mcu_as_sc_mcu7t3v3__fill_2
XFILLER_191_1170 VDD VDD VSS VSS gf180mcu_as_sc_mcu7t3v3__fillcap_16
XTAP_TAPCELL_ROW_100_3_3021 VDD VSS gf180mcu_as_sc_mcu7t3v3__tap_2
XFILLER_191_1192 VDD VDD VSS VSS gf180mcu_as_sc_mcu7t3v3__fillcap_16
XFILLER_26_1157 VDD VDD VSS VSS gf180mcu_as_sc_mcu7t3v3__fillcap_4
XFILLER_6_1218 VDD VDD VSS VSS gf180mcu_as_sc_mcu7t3v3__fill_1
XFILLER_19_330 VDD VDD VSS VSS gf180mcu_as_sc_mcu7t3v3__fillcap_16
XFILLER_43_1482 VDD VDD VSS VSS gf180mcu_as_sc_mcu7t3v3__fillcap_4
XFILLER_78_1501 VDD VDD VSS VSS gf180mcu_as_sc_mcu7t3v3__fillcap_8
XTAP_TAPCELL_ROW_183_2192 VDD VSS gf180mcu_as_sc_mcu7t3v3__tap_2
XFILLER_19_352 VDD VDD VSS VSS gf180mcu_as_sc_mcu7t3v3__fill_2
XFILLER_19_374 VDD VDD VSS VSS gf180mcu_as_sc_mcu7t3v3__fillcap_4
XFILLER_208_976 VDD VDD VSS VSS gf180mcu_as_sc_mcu7t3v3__fillcap_8
XFILLER_78_1523 VDD VDD VSS VSS gf180mcu_as_sc_mcu7t3v3__fillcap_16
XFILLER_165_1504 VDD VDD VSS VSS gf180mcu_as_sc_mcu7t3v3__fill_1
XFILLER_207_486 VDD VDD VSS VSS gf180mcu_as_sc_mcu7t3v3__fillcap_4
XFILLER_34_333 VDD VDD VSS VSS gf180mcu_as_sc_mcu7t3v3__fillcap_4
XFILLER_35_867 VDD VDD VSS VSS gf180mcu_as_sc_mcu7t3v3__fill_2
XFILLER_46_193 VDD VDD VSS VSS gf180mcu_as_sc_mcu7t3v3__fillcap_4
XPHY_EDGE_ROW_80_3_Left_465 VDD VSS gf180mcu_as_sc_mcu7t3v3__tap_2
XTAP_TAPCELL_ROW_149_1_1892 VDD VSS gf180mcu_as_sc_mcu7t3v3__tap_2
XFILLER_165_1548 VDD VDD VSS VSS gf180mcu_as_sc_mcu7t3v3__fillcap_8
XFILLER_179_338 VDD VDD VSS VSS gf180mcu_as_sc_mcu7t3v3__fillcap_8
XFILLER_201_34 VDD VDD VSS VSS gf180mcu_as_sc_mcu7t3v3__fillcap_16
XFILLER_206_1501 VDD VDD VSS VSS gf180mcu_as_sc_mcu7t3v3__fillcap_4
XFILLER_35_889 VDD VDD VSS VSS gf180mcu_as_sc_mcu7t3v3__fillcap_16
XFILLER_206_1523 VDD VDD VSS VSS gf180mcu_as_sc_mcu7t3v3__fillcap_16
XFILLER_210_607 VDD VDD VSS VSS gf180mcu_as_sc_mcu7t3v3__fill_1
XFILLER_210_618 VDD VDD VSS VSS gf180mcu_as_sc_mcu7t3v3__fill_2
XFILLER_210_629 VDD VDD VSS VSS gf180mcu_as_sc_mcu7t3v3__fill_2
XFILLER_98_2 VDD VDD VSS VSS gf180mcu_as_sc_mcu7t3v3__fillcap_4
X_2973_ VDD VDD VSS VSS _3953_/A _3005_/A _2973_/C _2973_/Y _3615_/D gf180mcu_as_sc_mcu7t3v3__aoi211_2
XTAP_TAPCELL_ROW_192_2406 VDD VSS gf180mcu_as_sc_mcu7t3v3__tap_2
XFILLER_206_1567 VDD VDD VSS VSS gf180mcu_as_sc_mcu7t3v3__fill_2
XFILLER_33_1106 VDD VDD VSS VSS gf180mcu_as_sc_mcu7t3v3__fill_2
X_4712_ VDD VDD VSS VSS _4721_/A _4712_/B _5105_/Q _5258_/D gf180mcu_as_sc_mcu7t3v3__mux2_2
XFILLER_198_1313 VDD VDD VSS VSS gf180mcu_as_sc_mcu7t3v3__fillcap_16
XFILLER_11_1404 VDD VDD VSS VSS gf180mcu_as_sc_mcu7t3v3__fill_1
XFILLER_175_555 VDD VDD VSS VSS gf180mcu_as_sc_mcu7t3v3__fillcap_4
XFILLER_204_1291 VDD VDD VSS VSS gf180mcu_as_sc_mcu7t3v3__fillcap_4
XFILLER_50_1453 VDD VDD VSS VSS gf180mcu_as_sc_mcu7t3v3__fillcap_16
X_4643_ VDD VDD VSS VSS _4643_/B _4643_/A _4649_/C gf180mcu_as_sc_mcu7t3v3__and2_2
XFILLER_50_1486 VDD VDD VSS VSS gf180mcu_as_sc_mcu7t3v3__fillcap_4
X_4574_ VDD VDD VSS VSS _5186_/Q _4574_/B _4574_/C _4574_/D _5186_/D gf180mcu_as_sc_mcu7t3v3__ao211_2
XTAP_TAPCELL_ROW_44_3_2852 VDD VSS gf180mcu_as_sc_mcu7t3v3__tap_2
XFILLER_196_1081 VDD VDD VSS VSS gf180mcu_as_sc_mcu7t3v3__fillcap_4
X_3525_ VDD VDD VSS VSS _3525_/B _3525_/A _4837_/D gf180mcu_as_sc_mcu7t3v3__and2_2
X_3456_ VDD VDD VSS VSS _4937_/Q _3493_/B _3465_/C _4112_/A _3458_/C gf180mcu_as_sc_mcu7t3v3__ao22_2
X_3387_ VDD VDD VSS VSS _3442_/B _4040_/A _3388_/D gf180mcu_as_sc_mcu7t3v3__or2_2
X_2407_ VDD VDD VSS VSS _2539_/B _5163_/Q gf180mcu_as_sc_mcu7t3v3__inv_2
XFILLER_22_1511 VDD VDD VSS VSS gf180mcu_as_sc_mcu7t3v3__fill_2
XPHY_EDGE_ROW_152_3_Right_189 VDD VSS gf180mcu_as_sc_mcu7t3v3__tap_2
X_5126_ VDD VDD VSS VSS _5278_/CLK _5126_/D _5126_/Q gf180mcu_as_sc_mcu7t3v3__dfxtp_2
Xload_slew693 VDD VDD VSS VSS _3932_/Y fanout692/A gf180mcu_as_sc_mcu7t3v3__clkbuff_12
X_5057_ VDD VDD VSS VSS _5085_/CLK _5057_/D _5057_/Q gf180mcu_as_sc_mcu7t3v3__dfxtp_2
XFILLER_26_823 VDD VDD VSS VSS gf180mcu_as_sc_mcu7t3v3__fillcap_8
X_4008_ VDD VDD VSS VSS _4008_/A _4104_/B _4104_/C _4008_/D _4009_/D gf180mcu_as_sc_mcu7t3v3__ao22_2
XFILLER_25_333 VDD VDD VSS VSS gf180mcu_as_sc_mcu7t3v3__fillcap_4
XFILLER_92_1509 VDD VDD VSS VSS gf180mcu_as_sc_mcu7t3v3__fillcap_8
XFILLER_179_850 VDD VDD VSS VSS gf180mcu_as_sc_mcu7t3v3__fillcap_4
XFILLER_25_377 VDD VDD VSS VSS gf180mcu_as_sc_mcu7t3v3__fillcap_4
XFILLER_71_27 VDD VDD VSS VSS gf180mcu_as_sc_mcu7t3v3__fill_2
XFILLER_94_1380 VDD VDD VSS VSS gf180mcu_as_sc_mcu7t3v3__fill_1
XFILLER_187_38 VDD VDD VSS VSS gf180mcu_as_sc_mcu7t3v3__fillcap_16
XFILLER_52_196 VDD VDD VSS VSS gf180mcu_as_sc_mcu7t3v3__fill_1
XFILLER_55_1364 VDD VDD VSS VSS gf180mcu_as_sc_mcu7t3v3__fillcap_16
XFILLER_107_1465 VDD VDD VSS VSS gf180mcu_as_sc_mcu7t3v3__fillcap_16
XFILLER_138_213 VDD VDD VSS VSS gf180mcu_as_sc_mcu7t3v3__fillcap_8
XFILLER_16_1348 VDD VDD VSS VSS gf180mcu_as_sc_mcu7t3v3__fillcap_16
XFILLER_200_139 VDD VDD VSS VSS gf180mcu_as_sc_mcu7t3v3__fillcap_16
XFILLER_55_1386 VDD VDD VSS VSS gf180mcu_as_sc_mcu7t3v3__fill_1
XFILLER_177_1408 VDD VDD VSS VSS gf180mcu_as_sc_mcu7t3v3__fill_1
XFILLER_193_352 VDD VDD VSS VSS gf180mcu_as_sc_mcu7t3v3__fillcap_16
XTAP_TAPCELL_ROW_105_3_3036 VDD VSS gf180mcu_as_sc_mcu7t3v3__tap_2
XFILLER_193_396 VDD VDD VSS VSS gf180mcu_as_sc_mcu7t3v3__fillcap_16
XFILLER_4_226 VDD VDD VSS VSS gf180mcu_as_sc_mcu7t3v3__fillcap_16
XFILLER_1_900 VDD VDD VSS VSS gf180mcu_as_sc_mcu7t3v3__fillcap_8
XFILLER_20_53 VDD VDD VSS VSS gf180mcu_as_sc_mcu7t3v3__fillcap_16
XPHY_EDGE_ROW_199_Right_62 VDD VSS gf180mcu_as_sc_mcu7t3v3__tap_2
XFILLER_0_410 VDD VDD VSS VSS gf180mcu_as_sc_mcu7t3v3__fillcap_8
XFILLER_27_1444 VDD VDD VSS VSS gf180mcu_as_sc_mcu7t3v3__fillcap_16
Xinput300 VDD VDD VSS VSS west_in[25] _4135_/D gf180mcu_as_sc_mcu7t3v3__buff_12
Xinput311 VDD VDD VSS VSS west_in[4] _3965_/D gf180mcu_as_sc_mcu7t3v3__buff_12
XFILLER_209_718 VDD VDD VSS VSS gf180mcu_as_sc_mcu7t3v3__fillcap_16
XFILLER_23_1308 VDD VDD VSS VSS gf180mcu_as_sc_mcu7t3v3__fillcap_8
XFILLER_29_51 VDD VDD VSS VSS gf180mcu_as_sc_mcu7t3v3__fillcap_4
XTAP_TAPCELL_ROW_15_1055 VDD VSS gf180mcu_as_sc_mcu7t3v3__tap_2
XTAP_TAPCELL_ROW_70_3_2931 VDD VSS gf180mcu_as_sc_mcu7t3v3__tap_2
XFILLER_114_1469 VDD VDD VSS VSS gf180mcu_as_sc_mcu7t3v3__fillcap_16
XFILLER_152_41 VDD VDD VSS VSS gf180mcu_as_sc_mcu7t3v3__fill_1
XFILLER_188_1515 VDD VDD VSS VSS gf180mcu_as_sc_mcu7t3v3__fillcap_4
XTAP_TAPCELL_ROW_15_1066 VDD VSS gf180mcu_as_sc_mcu7t3v3__tap_2
XFILLER_29_672 VDD VDD VSS VSS gf180mcu_as_sc_mcu7t3v3__fill_1
XTAP_TAPCELL_ROW_39_1_1561 VDD VSS gf180mcu_as_sc_mcu7t3v3__tap_2
XFILLER_1_1126 VDD VDD VSS VSS gf180mcu_as_sc_mcu7t3v3__fill_2
XFILLER_182_1103 VDD VDD VSS VSS gf180mcu_as_sc_mcu7t3v3__fillcap_16
XFILLER_21_1098 VDD VDD VSS VSS gf180mcu_as_sc_mcu7t3v3__fill_1
XFILLER_43_130 VDD VDD VSS VSS gf180mcu_as_sc_mcu7t3v3__fillcap_8
XFILLER_45_72 VDD VDD VSS VSS gf180mcu_as_sc_mcu7t3v3__fillcap_16
XFILLER_32_859 VDD VDD VSS VSS gf180mcu_as_sc_mcu7t3v3__fillcap_16
XTAP_TAPCELL_ROW_49_3_2867 VDD VSS gf180mcu_as_sc_mcu7t3v3__tap_2
XFILLER_204_489 VDD VDD VSS VSS gf180mcu_as_sc_mcu7t3v3__fillcap_16
XFILLER_34_1415 VDD VDD VSS VSS gf180mcu_as_sc_mcu7t3v3__fill_2
XFILLER_73_1475 VDD VDD VSS VSS gf180mcu_as_sc_mcu7t3v3__fill_1
XPHY_EDGE_ROW_114_3_Right_151 VDD VSS gf180mcu_as_sc_mcu7t3v3__tap_2
XFILLER_121_1407 VDD VDD VSS VSS gf180mcu_as_sc_mcu7t3v3__fillcap_8
XFILLER_12_572 VDD VDD VSS VSS gf180mcu_as_sc_mcu7t3v3__fillcap_4
XFILLER_185_831 VDD VDD VSS VSS gf180mcu_as_sc_mcu7t3v3__fillcap_8
XFILLER_185_842 VDD VDD VSS VSS gf180mcu_as_sc_mcu7t3v3__fillcap_16
XFILLER_197_680 VDD VDD VSS VSS gf180mcu_as_sc_mcu7t3v3__fillcap_16
XFILLER_34_1437 VDD VDD VSS VSS gf180mcu_as_sc_mcu7t3v3__fillcap_16
XFILLER_8_587 VDD VDD VSS VSS gf180mcu_as_sc_mcu7t3v3__fillcap_8
XANTENNA_4 VDD VDD VSS VSS _4849_/D gf180mcu_as_sc_mcu7t3v3__diode_2
X_3310_ VDD VDD VSS VSS _3416_/B _3310_/B _3310_/C _3311_/C gf180mcu_as_sc_mcu7t3v3__nor3_2
XFILLER_112_102 VDD VDD VSS VSS gf180mcu_as_sc_mcu7t3v3__fill_2
XFILLER_45_1511 VDD VDD VSS VSS gf180mcu_as_sc_mcu7t3v3__fillcap_8
X_4290_ VDD VDD VSS VSS _4719_/A _4290_/B _5124_/Q _5124_/D gf180mcu_as_sc_mcu7t3v3__mux2_2
XFILLER_80_1424 VDD VDD VSS VSS gf180mcu_as_sc_mcu7t3v3__fill_2
XTAP_TAPCELL_ROW_131_3_3115 VDD VSS gf180mcu_as_sc_mcu7t3v3__tap_2
X_3241_ VDD VDD VSS VSS _3242_/B _3523_/A _3241_/B _3241_/C _3524_/A gf180mcu_as_sc_mcu7t3v3__aoi22_2
XTAP_TAPCELL_ROW_185_2243 VDD VSS gf180mcu_as_sc_mcu7t3v3__tap_2
XTAP_TAPCELL_ROW_185_2232 VDD VSS gf180mcu_as_sc_mcu7t3v3__tap_2
XFILLER_45_1566 VDD VDD VSS VSS gf180mcu_as_sc_mcu7t3v3__fill_2
XPHY_EDGE_ROW_203_Right_66 VDD VSS gf180mcu_as_sc_mcu7t3v3__tap_2
Xmesh_tile_926 VDD VDD VSS VSS ne_out[1] gf180mcu_as_sc_mcu7t3v3__tiel_4
X_3172_ VDD VDD VSS VSS _4146_/D _3239_/A _3172_/C _3172_/D _3173_/B gf180mcu_as_sc_mcu7t3v3__ao211_2
Xmesh_tile_959 VDD VDD VSS VSS north_out[0] gf180mcu_as_sc_mcu7t3v3__tiel_4
Xmesh_tile_948 VDD VDD VSS VSS ne_out[23] gf180mcu_as_sc_mcu7t3v3__tiel_4
Xmesh_tile_937 VDD VDD VSS VSS ne_out[12] gf180mcu_as_sc_mcu7t3v3__tiel_4
XFILLER_187_1014 VDD VDD VSS VSS gf180mcu_as_sc_mcu7t3v3__fillcap_16
XFILLER_179_146 VDD VDD VSS VSS gf180mcu_as_sc_mcu7t3v3__fill_2
XFILLER_22_314 VDD VDD VSS VSS gf180mcu_as_sc_mcu7t3v3__fill_1
XFILLER_22_325 VDD VDD VSS VSS gf180mcu_as_sc_mcu7t3v3__fill_2
XFILLER_23_837 VDD VDD VSS VSS gf180mcu_as_sc_mcu7t3v3__fill_2
XFILLER_34_163 VDD VDD VSS VSS gf180mcu_as_sc_mcu7t3v3__fillcap_8
XFILLER_39_1348 VDD VDD VSS VSS gf180mcu_as_sc_mcu7t3v3__fillcap_8
XFILLER_52_1537 VDD VDD VSS VSS gf180mcu_as_sc_mcu7t3v3__fillcap_4
X_2956_ VDD VDD VSS VSS _2956_/B _3795_/A _4771_/D gf180mcu_as_sc_mcu7t3v3__and2_2
XTAP_TAPCELL_ROW_65_1_1640 VDD VSS gf180mcu_as_sc_mcu7t3v3__tap_2
XFILLER_175_352 VDD VDD VSS VSS gf180mcu_as_sc_mcu7t3v3__fillcap_8
XFILLER_187_190 VDD VDD VSS VSS gf180mcu_as_sc_mcu7t3v3__fillcap_16
X_2887_ VDD VDD VSS VSS _3811_/A _3788_/A _3796_/A gf180mcu_as_sc_mcu7t3v3__nor2_2
XFILLER_175_396 VDD VDD VSS VSS gf180mcu_as_sc_mcu7t3v3__fill_1
X_4626_ VDD VDD VSS VSS _5276_/Q _4626_/B _4626_/A _4628_/B gf180mcu_as_sc_mcu7t3v3__mux2_2
XTAP_TAPCELL_ROW_174_1980 VDD VSS gf180mcu_as_sc_mcu7t3v3__tap_2
XFILLER_102_1373 VDD VDD VSS VSS gf180mcu_as_sc_mcu7t3v3__fill_1
XFILLER_11_1256 VDD VDD VSS VSS gf180mcu_as_sc_mcu7t3v3__fillcap_4
XFILLER_190_333 VDD VDD VSS VSS gf180mcu_as_sc_mcu7t3v3__fillcap_16
XFILLER_89_1482 VDD VDD VSS VSS gf180mcu_as_sc_mcu7t3v3__fillcap_4
XTAP_TAPCELL_ROW_75_3_2946 VDD VSS gf180mcu_as_sc_mcu7t3v3__tap_2
XTAP_TAPCELL_ROW_174_1991 VDD VSS gf180mcu_as_sc_mcu7t3v3__tap_2
XFILLER_11_1278 VDD VDD VSS VSS gf180mcu_as_sc_mcu7t3v3__fillcap_16
XFILLER_137_1414 VDD VDD VSS VSS gf180mcu_as_sc_mcu7t3v3__fill_2
XFILLER_1_207 VDD VDD VSS VSS gf180mcu_as_sc_mcu7t3v3__fill_2
X_4557_ VDD VDD VSS VSS _4561_/B _5085_/Q _4559_/S gf180mcu_as_sc_mcu7t3v3__nand2_2
XFILLER_137_1425 VDD VDD VSS VSS gf180mcu_as_sc_mcu7t3v3__fill_2
XFILLER_176_1485 VDD VDD VSS VSS gf180mcu_as_sc_mcu7t3v3__fillcap_16
X_4488_ VDD VDD VSS VSS _4491_/C _4990_/Q _4488_/A gf180mcu_as_sc_mcu7t3v3__nand2b_2
X_3508_ VDD VDD VSS VSS _3508_/A _3533_/A _3812_/A _3517_/D _3509_/B gf180mcu_as_sc_mcu7t3v3__nand4_2
XFILLER_103_146 VDD VDD VSS VSS gf180mcu_as_sc_mcu7t3v3__fill_1
XFILLER_106_45 VDD VDD VSS VSS gf180mcu_as_sc_mcu7t3v3__fillcap_4
XFILLER_137_1458 VDD VDD VSS VSS gf180mcu_as_sc_mcu7t3v3__fill_1
X_3439_ VDD VDD VSS VSS _4091_/A _3463_/B _3439_/C _4824_/D _3463_/D gf180mcu_as_sc_mcu7t3v3__aoi211_2
XFILLER_111_190 VDD VDD VSS VSS gf180mcu_as_sc_mcu7t3v3__fillcap_4
X_5109_ VDD VDD VSS VSS _5280_/CLK _5109_/D _5109_/Q gf180mcu_as_sc_mcu7t3v3__dfxtp_2
XFILLER_199_912 VDD VDD VSS VSS gf180mcu_as_sc_mcu7t3v3__fillcap_16
XTAP_TAPCELL_ROW_1_752 VDD VSS gf180mcu_as_sc_mcu7t3v3__tap_2
XFILLER_57_1426 VDD VDD VSS VSS gf180mcu_as_sc_mcu7t3v3__fill_1
XFILLER_82_37 VDD VDD VSS VSS gf180mcu_as_sc_mcu7t3v3__fill_2
XFILLER_96_1453 VDD VDD VSS VSS gf180mcu_as_sc_mcu7t3v3__fillcap_8
XTAP_TAPCELL_ROW_1_763 VDD VSS gf180mcu_as_sc_mcu7t3v3__tap_2
XFILLER_14_848 VDD VDD VSS VSS gf180mcu_as_sc_mcu7t3v3__fill_2
XFILLER_183_1467 VDD VDD VSS VSS gf180mcu_as_sc_mcu7t3v3__fill_2
XFILLER_198_37 VDD VDD VSS VSS gf180mcu_as_sc_mcu7t3v3__fillcap_16
XFILLER_25_174 VDD VDD VSS VSS gf180mcu_as_sc_mcu7t3v3__fillcap_16
XFILLER_13_336 VDD VDD VSS VSS gf180mcu_as_sc_mcu7t3v3__fillcap_8
XFILLER_201_448 VDD VDD VSS VSS gf180mcu_as_sc_mcu7t3v3__fillcap_16
XFILLER_40_177 VDD VDD VSS VSS gf180mcu_as_sc_mcu7t3v3__fill_2
XFILLER_12_1009 VDD VDD VSS VSS gf180mcu_as_sc_mcu7t3v3__fillcap_4
XFILLER_194_661 VDD VDD VSS VSS gf180mcu_as_sc_mcu7t3v3__fillcap_4
XFILLER_194_683 VDD VDD VSS VSS gf180mcu_as_sc_mcu7t3v3__fillcap_16
XTAP_TAPCELL_ROW_124_1_1818 VDD VSS gf180mcu_as_sc_mcu7t3v3__tap_2
XFILLER_182_867 VDD VDD VSS VSS gf180mcu_as_sc_mcu7t3v3__fillcap_8
XFILLER_193_182 VDD VDD VSS VSS gf180mcu_as_sc_mcu7t3v3__fillcap_4
XFILLER_68_1500 VDD VDD VSS VSS gf180mcu_as_sc_mcu7t3v3__fillcap_4
XPHY_EDGE_ROW_146_1_Left_356 VDD VSS gf180mcu_as_sc_mcu7t3v3__tap_2
XFILLER_141_208 VDD VDD VSS VSS gf180mcu_as_sc_mcu7t3v3__fill_2
XFILLER_5_579 VDD VDD VSS VSS gf180mcu_as_sc_mcu7t3v3__fill_1
XTAP_TAPCELL_ROW_17_1106 VDD VSS gf180mcu_as_sc_mcu7t3v3__tap_2
XFILLER_155_1558 VDD VDD VSS VSS gf180mcu_as_sc_mcu7t3v3__fillcap_8
XFILLER_0_240 VDD VDD VSS VSS gf180mcu_as_sc_mcu7t3v3__fillcap_4
XFILLER_1_774 VDD VDD VSS VSS gf180mcu_as_sc_mcu7t3v3__fill_1
XFILLER_27_1252 VDD VDD VSS VSS gf180mcu_as_sc_mcu7t3v3__fillcap_8
XPHY_EDGE_ROW_139_1_Right_660 VDD VSS gf180mcu_as_sc_mcu7t3v3__tap_2
Xinput130 VDD VDD VSS VSS north_in[26] _4144_/A gf180mcu_as_sc_mcu7t3v3__buff_12
Xinput141 VDD VDD VSS VSS north_in[5] _3974_/A gf180mcu_as_sc_mcu7t3v3__buff_12
Xinput152 VDD VDD VSS VSS nw_in[15] _4056_/A gf180mcu_as_sc_mcu7t3v3__buff_12
Xinput163 VDD VDD VSS VSS nw_in[25] _4136_/A gf180mcu_as_sc_mcu7t3v3__buff_12
XTAP_TAPCELL_ROW_34_1486 VDD VSS gf180mcu_as_sc_mcu7t3v3__tap_2
XTAP_TAPCELL_ROW_34_1475 VDD VSS gf180mcu_as_sc_mcu7t3v3__tap_2
XFILLER_188_1345 VDD VDD VSS VSS gf180mcu_as_sc_mcu7t3v3__fillcap_16
XFILLER_36_406 VDD VDD VSS VSS gf180mcu_as_sc_mcu7t3v3__fill_2
Xinput174 VDD VDD VSS VSS nw_in[4] _3966_/A gf180mcu_as_sc_mcu7t3v3__buff_12
Xinput185 VDD VDD VSS VSS se_in[13] _4041_/A gf180mcu_as_sc_mcu7t3v3__buff_12
Xinput196 VDD VDD VSS VSS se_in[23] _4122_/A gf180mcu_as_sc_mcu7t3v3__buff_12
XTAP_TAPCELL_ROW_180_2140 VDD VSS gf180mcu_as_sc_mcu7t3v3__tap_2
XFILLER_188_1378 VDD VDD VSS VSS gf180mcu_as_sc_mcu7t3v3__fillcap_16
XFILLER_36_439 VDD VDD VSS VSS gf180mcu_as_sc_mcu7t3v3__fill_2
XFILLER_75_1504 VDD VDD VSS VSS gf180mcu_as_sc_mcu7t3v3__fill_2
XFILLER_16_174 VDD VDD VSS VSS gf180mcu_as_sc_mcu7t3v3__fill_1
XFILLER_17_686 VDD VDD VSS VSS gf180mcu_as_sc_mcu7t3v3__fillcap_8
XFILLER_189_422 VDD VDD VSS VSS gf180mcu_as_sc_mcu7t3v3__fillcap_16
Xclkbuf_leaf_39_clk_regs VDD VDD VSS VSS clkbuf_3_3__f_clk_regs/Y _4919_/CLK gf180mcu_as_sc_mcu7t3v3__clkbuff_12
XFILLER_32_667 VDD VDD VSS VSS gf180mcu_as_sc_mcu7t3v3__fillcap_8
XFILLER_34_1201 VDD VDD VSS VSS gf180mcu_as_sc_mcu7t3v3__fillcap_16
XFILLER_203_1504 VDD VDD VSS VSS gf180mcu_as_sc_mcu7t3v3__fillcap_16
XFILLER_34_1234 VDD VDD VSS VSS gf180mcu_as_sc_mcu7t3v3__fillcap_16
XPHY_EDGE_ROW_115_3_Right_152 VDD VSS gf180mcu_as_sc_mcu7t3v3__tap_2
X_3790_ VDD VDD VSS VSS _3790_/A _3932_/B _3790_/C _3790_/D _3791_/C gf180mcu_as_sc_mcu7t3v3__ao22_2
X_2810_ VDD VDD VSS VSS _2810_/A _2810_/B _2810_/C _2841_/A _2810_/D gf180mcu_as_sc_mcu7t3v3__aoi31_2
XTAP_TAPCELL_ROW_178_2091 VDD VSS gf180mcu_as_sc_mcu7t3v3__tap_2
XTAP_TAPCELL_ROW_178_2080 VDD VSS gf180mcu_as_sc_mcu7t3v3__tap_2
XFILLER_201_960 VDD VDD VSS VSS gf180mcu_as_sc_mcu7t3v3__fillcap_16
XFILLER_201_982 VDD VDD VSS VSS gf180mcu_as_sc_mcu7t3v3__fillcap_16
XFILLER_31_188 VDD VDD VSS VSS gf180mcu_as_sc_mcu7t3v3__fill_1
XFILLER_9_830 VDD VDD VSS VSS gf180mcu_as_sc_mcu7t3v3__fillcap_4
X_2741_ VDD VDD VSS VSS _4947_/Q _2741_/B _2741_/A _5482_/A gf180mcu_as_sc_mcu7t3v3__mux2_2
XFILLER_75_4 VDD VDD VSS VSS gf180mcu_as_sc_mcu7t3v3__fill_1
XPHY_EDGE_ROW_78_1_Left_288 VDD VSS gf180mcu_as_sc_mcu7t3v3__tap_2
XFILLER_12_1543 VDD VDD VSS VSS gf180mcu_as_sc_mcu7t3v3__fill_1
X_4411_ VDD VDD VSS VSS _4414_/C _4981_/Q _4456_/S gf180mcu_as_sc_mcu7t3v3__nand2b_2
X_2672_ VDD VDD VSS VSS _2737_/A _2672_/B _2672_/C _2672_/D _2672_/Y gf180mcu_as_sc_mcu7t3v3__ao22_2
XFILLER_201_1294 VDD VDD VSS VSS gf180mcu_as_sc_mcu7t3v3__fillcap_16
X_4342_ VDD VDD VSS VSS _4538_/A _4342_/B _4342_/A _4344_/B gf180mcu_as_sc_mcu7t3v3__mux2_2
XFILLER_193_1084 VDD VDD VSS VSS gf180mcu_as_sc_mcu7t3v3__fillcap_16
XFILLER_207_66 VDD VDD VSS VSS gf180mcu_as_sc_mcu7t3v3__fillcap_4
XFILLER_207_88 VDD VDD VSS VSS gf180mcu_as_sc_mcu7t3v3__fillcap_16
XTAP_TAPCELL_ROW_150_3_3170 VDD VSS gf180mcu_as_sc_mcu7t3v3__tap_2
X_4273_ VDD VDD VSS VSS _4273_/S _5485_/A _5107_/Q _5107_/D gf180mcu_as_sc_mcu7t3v3__mux2_2
XFILLER_45_1352 VDD VDD VSS VSS gf180mcu_as_sc_mcu7t3v3__fill_2
XFILLER_98_177 VDD VDD VSS VSS gf180mcu_as_sc_mcu7t3v3__fillcap_4
X_3224_ VDD VDD VSS VSS _3225_/B _3542_/A _3249_/B _3224_/C _3224_/D gf180mcu_as_sc_mcu7t3v3__aoi22_2
.ends
