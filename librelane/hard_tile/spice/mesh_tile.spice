* NGSPICE file created from mesh_tile.ext - technology: gf180mcuD

* Black-box entry subcircuit for gf180mcu_as_sc_mcu7t3v3__fill_2 abstract view
.subckt gf180mcu_as_sc_mcu7t3v3__fill_2 VDD VNW VPW VSS
.ends

* Black-box entry subcircuit for gf180mcu_as_sc_mcu7t3v3__nor3_2 abstract view
.subckt gf180mcu_as_sc_mcu7t3v3__nor3_2 VDD VNW VPW VSS A B C Y
.ends

* Black-box entry subcircuit for gf180mcu_as_sc_mcu7t3v3__and2_2 abstract view
.subckt gf180mcu_as_sc_mcu7t3v3__and2_2 VDD VNW VPW VSS B A Y
.ends

* Black-box entry subcircuit for gf180mcu_as_sc_mcu7t3v3__fillcap_4 abstract view
.subckt gf180mcu_as_sc_mcu7t3v3__fillcap_4 VDD VNW VPW VSS
.ends

* Black-box entry subcircuit for gf180mcu_as_sc_mcu7t3v3__fillcap_16 abstract view
.subckt gf180mcu_as_sc_mcu7t3v3__fillcap_16 VDD VNW VPW VSS
.ends

* Black-box entry subcircuit for gf180mcu_as_sc_mcu7t3v3__clkbuff_12 abstract view
.subckt gf180mcu_as_sc_mcu7t3v3__clkbuff_12 VDD VNW VPW VSS A Y
.ends

* Black-box entry subcircuit for gf180mcu_as_sc_mcu7t3v3__fillcap_8 abstract view
.subckt gf180mcu_as_sc_mcu7t3v3__fillcap_8 VDD VNW VPW VSS
.ends

* Black-box entry subcircuit for gf180mcu_as_sc_mcu7t3v3__dfxtp_2 abstract view
.subckt gf180mcu_as_sc_mcu7t3v3__dfxtp_2 VDD VNW VPW VSS CLK D Q
.ends

* Black-box entry subcircuit for gf180mcu_as_sc_mcu7t3v3__fill_1 abstract view
.subckt gf180mcu_as_sc_mcu7t3v3__fill_1 VDD VNW VPW VSS
.ends

* Black-box entry subcircuit for gf180mcu_as_sc_mcu7t3v3__tap_2 abstract view
.subckt gf180mcu_as_sc_mcu7t3v3__tap_2 VDD VSS
.ends

* Black-box entry subcircuit for gf180mcu_as_sc_mcu7t3v3__clkbuff_4 abstract view
.subckt gf180mcu_as_sc_mcu7t3v3__clkbuff_4 VDD VNW VPW VSS A Y
.ends

* Black-box entry subcircuit for gf180mcu_as_sc_mcu7t3v3__ao22_2 abstract view
.subckt gf180mcu_as_sc_mcu7t3v3__ao22_2 VDD VNW VPW VSS A B C D Y
.ends

* Black-box entry subcircuit for gf180mcu_as_sc_mcu7t3v3__or2_2 abstract view
.subckt gf180mcu_as_sc_mcu7t3v3__or2_2 VDD VNW VPW VSS B A Y
.ends

* Black-box entry subcircuit for gf180mcu_as_sc_mcu7t3v3__ao211_2 abstract view
.subckt gf180mcu_as_sc_mcu7t3v3__ao211_2 VDD VNW VPW VSS A B C D Y
.ends

* Black-box entry subcircuit for gf180mcu_as_sc_mcu7t3v3__buff_12 abstract view
.subckt gf180mcu_as_sc_mcu7t3v3__buff_12 VDD VNW VPW VSS A Y
.ends

* Black-box entry subcircuit for gf180mcu_as_sc_mcu7t3v3__nor2_2 abstract view
.subckt gf180mcu_as_sc_mcu7t3v3__nor2_2 VDD VNW VPW VSS Y B A
.ends

* Black-box entry subcircuit for gf180mcu_as_sc_mcu7t3v3__mux2_2 abstract view
.subckt gf180mcu_as_sc_mcu7t3v3__mux2_2 VDD VNW VPW VSS S B A Y
.ends

* Black-box entry subcircuit for gf180mcu_as_sc_mcu7t3v3__aoi211_2 abstract view
.subckt gf180mcu_as_sc_mcu7t3v3__aoi211_2 VDD VNW VPW VSS A B C Y D
.ends

* Black-box entry subcircuit for gf180mcu_as_sc_mcu7t3v3__nor2b_2 abstract view
.subckt gf180mcu_as_sc_mcu7t3v3__nor2b_2 VDD VNW VPW VSS Y B A
.ends

* Black-box entry subcircuit for gf180mcu_as_sc_mcu7t3v3__nand2_2 abstract view
.subckt gf180mcu_as_sc_mcu7t3v3__nand2_2 VDD VNW VPW VSS Y B A
.ends

* Black-box entry subcircuit for gf180mcu_as_sc_mcu7t3v3__ao31_2 abstract view
.subckt gf180mcu_as_sc_mcu7t3v3__ao31_2 VDD VNW VPW VSS D A B C Y
.ends

* Black-box entry subcircuit for gf180mcu_as_sc_mcu7t3v3__ao21_2 abstract view
.subckt gf180mcu_as_sc_mcu7t3v3__ao21_2 VDD VNW VPW VSS Y A B C
.ends

* Black-box entry subcircuit for gf180mcu_as_sc_mcu7t3v3__tiel_4 abstract view
.subckt gf180mcu_as_sc_mcu7t3v3__tiel_4 VDD VNW VPW VSS ZERO
.ends

* Black-box entry subcircuit for gf180mcu_as_sc_mcu7t3v3__aoi21b_2 abstract view
.subckt gf180mcu_as_sc_mcu7t3v3__aoi21b_2 VDD VNW VPW VSS Y C B A
.ends

* Black-box entry subcircuit for gf180mcu_as_sc_mcu7t3v3__buff_2 abstract view
.subckt gf180mcu_as_sc_mcu7t3v3__buff_2 VDD VNW VPW VSS A Y
.ends

* Black-box entry subcircuit for gf180mcu_as_sc_mcu7t3v3__aoi21_2 abstract view
.subckt gf180mcu_as_sc_mcu7t3v3__aoi21_2 VDD VNW VPW VSS Y C B A
.ends

* Black-box entry subcircuit for gf180mcu_as_sc_mcu7t3v3__aoi31_2 abstract view
.subckt gf180mcu_as_sc_mcu7t3v3__aoi31_2 VDD VNW VPW VSS A B C Y D
.ends

* Black-box entry subcircuit for gf180mcu_as_sc_mcu7t3v3__inv_2 abstract view
.subckt gf180mcu_as_sc_mcu7t3v3__inv_2 VDD VNW VPW VSS Y A
.ends

* Black-box entry subcircuit for gf180mcu_as_sc_mcu7t3v3__diode_2 abstract view
.subckt gf180mcu_as_sc_mcu7t3v3__diode_2 VDD VNW VPW VSS DIODE
.ends

* Black-box entry subcircuit for gf180mcu_as_sc_mcu7t3v3__nand3_2 abstract view
.subckt gf180mcu_as_sc_mcu7t3v3__nand3_2 VDD VNW VPW VSS A B C Y
.ends

* Black-box entry subcircuit for gf180mcu_as_sc_mcu7t3v3__nand2b_2 abstract view
.subckt gf180mcu_as_sc_mcu7t3v3__nand2b_2 VDD VNW VPW VSS Y B A
.ends

* Black-box entry subcircuit for gf180mcu_as_sc_mcu7t3v3__xnor2_2 abstract view
.subckt gf180mcu_as_sc_mcu7t3v3__xnor2_2 VDD VNW VPW VSS B A Y
.ends

* Black-box entry subcircuit for gf180mcu_as_sc_mcu7t3v3__nand4_2 abstract view
.subckt gf180mcu_as_sc_mcu7t3v3__nand4_2 VDD VNW VPW VSS A B C D Y
.ends

* Black-box entry subcircuit for gf180mcu_as_sc_mcu7t3v3__aoi22_2 abstract view
.subckt gf180mcu_as_sc_mcu7t3v3__aoi22_2 VDD VNW VPW VSS Y A B C D
.ends

* Black-box entry subcircuit for gf180mcu_as_sc_mcu7t3v3__ao21b_2 abstract view
.subckt gf180mcu_as_sc_mcu7t3v3__ao21b_2 VDD VNW VPW VSS Y C B A
.ends

* Black-box entry subcircuit for gf180mcu_as_sc_mcu7t3v3__maj3_2 abstract view
.subckt gf180mcu_as_sc_mcu7t3v3__maj3_2 VDD VNW VPW VSS Y A B C
.ends

* Black-box entry subcircuit for gf180mcu_as_sc_mcu7t3v3__inv_4 abstract view
.subckt gf180mcu_as_sc_mcu7t3v3__inv_4 VDD VNW VPW VSS Y A
.ends

* Black-box entry subcircuit for gf180mcu_as_sc_mcu7t3v3__inv_6 abstract view
.subckt gf180mcu_as_sc_mcu7t3v3__inv_6 VDD VNW VPW VSS Y A
.ends

* Black-box entry subcircuit for gf180mcu_ocd_ip_sram__sram1024x8m8wm1 abstract view
.subckt gf180mcu_ocd_ip_sram__sram1024x8m8wm1 A[8] A[7] A[6] A[5] A[4] A[3] A[2] A[1]
+ A[0] CEN CLK D[7] D[6] D[5] D[4] D[3] D[2] D[1] D[0] GWEN Q[7] Q[6] Q[5] Q[4] Q[3]
+ Q[2] Q[1] Q[0] VDD VSS WEN[7] WEN[6] WEN[5] WEN[4] WEN[3] WEN[2] WEN[1] WEN[0] A[9]
.ends

* Black-box entry subcircuit for gf180mcu_as_sc_mcu7t3v3__dfsrtp_2 abstract view
.subckt gf180mcu_as_sc_mcu7t3v3__dfsrtp_2 VDD VNW VPW VSS CLK Q RN SN D
.ends

* Black-box entry subcircuit for gf180mcu_as_sc_mcu7t3v3__tieh_4 abstract view
.subckt gf180mcu_as_sc_mcu7t3v3__tieh_4 VDD VNW VPW VSS ONE
.ends

.subckt mesh_tile VDD VSS boot_addr[0] boot_addr[10] boot_addr[1] boot_addr[2] boot_addr[3]
+ boot_addr[4] boot_addr[5] boot_addr[6] boot_addr[7] boot_addr[8] boot_addr[9] boot_data[0]
+ boot_data[1] boot_data[2] boot_data[3] boot_data[4] boot_data[5] boot_data[6] boot_data[7]
+ boot_mode boot_wen clk dft_addr[0] dft_addr[10] dft_addr[1] dft_addr[2] dft_addr[3]
+ dft_addr[4] dft_addr[5] dft_addr[6] dft_addr[7] dft_addr[8] dft_addr[9] dft_ce dft_mode
+ dft_rdata[0] dft_rdata[1] dft_rdata[2] dft_rdata[3] dft_rdata[4] dft_rdata[5] dft_rdata[6]
+ dft_rdata[7] dft_wdata[0] dft_wdata[1] dft_wdata[2] dft_wdata[3] dft_wdata[4] dft_wdata[5]
+ dft_wdata[6] dft_wdata[7] dft_we east_in[0] east_in[10] east_in[11] east_in[12]
+ east_in[13] east_in[14] east_in[15] east_in[16] east_in[17] east_in[18] east_in[19]
+ east_in[1] east_in[20] east_in[21] east_in[22] east_in[23] east_in[24] east_in[25]
+ east_in[26] east_in[27] east_in[28] east_in[29] east_in[2] east_in[30] east_in[31]
+ east_in[32] east_in[33] east_in[34] east_in[35] east_in[3] east_in[4] east_in[5]
+ east_in[6] east_in[7] east_in[8] east_in[9] east_out[0] east_out[10] east_out[11]
+ east_out[12] east_out[13] east_out[14] east_out[15] east_out[16] east_out[17] east_out[18]
+ east_out[19] east_out[1] east_out[20] east_out[21] east_out[22] east_out[23] east_out[24]
+ east_out[25] east_out[26] east_out[27] east_out[28] east_out[29] east_out[2] east_out[30]
+ east_out[31] east_out[32] east_out[33] east_out[34] east_out[35] east_out[3] east_out[4]
+ east_out[5] east_out[6] east_out[7] east_out[8] east_out[9] ne_in[0] ne_in[10] ne_in[11]
+ ne_in[12] ne_in[13] ne_in[14] ne_in[15] ne_in[16] ne_in[17] ne_in[18] ne_in[19]
+ ne_in[1] ne_in[20] ne_in[21] ne_in[22] ne_in[23] ne_in[24] ne_in[25] ne_in[26] ne_in[27]
+ ne_in[28] ne_in[29] ne_in[2] ne_in[30] ne_in[31] ne_in[32] ne_in[33] ne_in[34] ne_in[35]
+ ne_in[3] ne_in[4] ne_in[5] ne_in[6] ne_in[7] ne_in[8] ne_in[9] ne_out[0] ne_out[10]
+ ne_out[11] ne_out[12] ne_out[13] ne_out[14] ne_out[15] ne_out[16] ne_out[17] ne_out[18]
+ ne_out[19] ne_out[1] ne_out[20] ne_out[21] ne_out[22] ne_out[23] ne_out[24] ne_out[25]
+ ne_out[26] ne_out[27] ne_out[28] ne_out[29] ne_out[2] ne_out[30] ne_out[31] ne_out[32]
+ ne_out[33] ne_out[34] ne_out[35] ne_out[3] ne_out[4] ne_out[5] ne_out[6] ne_out[7]
+ ne_out[8] ne_out[9] north_in[0] north_in[10] north_in[11] north_in[12] north_in[13]
+ north_in[14] north_in[15] north_in[16] north_in[17] north_in[18] north_in[19] north_in[1]
+ north_in[20] north_in[21] north_in[22] north_in[23] north_in[24] north_in[25] north_in[26]
+ north_in[27] north_in[28] north_in[29] north_in[2] north_in[30] north_in[31] north_in[32]
+ north_in[33] north_in[34] north_in[35] north_in[3] north_in[4] north_in[5] north_in[6]
+ north_in[7] north_in[8] north_in[9] north_out[0] north_out[10] north_out[11] north_out[12]
+ north_out[13] north_out[14] north_out[15] north_out[16] north_out[17] north_out[18]
+ north_out[19] north_out[1] north_out[20] north_out[21] north_out[22] north_out[23]
+ north_out[24] north_out[25] north_out[26] north_out[27] north_out[28] north_out[29]
+ north_out[2] north_out[30] north_out[31] north_out[32] north_out[33] north_out[34]
+ north_out[35] north_out[3] north_out[4] north_out[5] north_out[6] north_out[7] north_out[8]
+ north_out[9] nw_in[0] nw_in[10] nw_in[11] nw_in[12] nw_in[13] nw_in[14] nw_in[15]
+ nw_in[16] nw_in[17] nw_in[18] nw_in[19] nw_in[1] nw_in[20] nw_in[21] nw_in[22] nw_in[23]
+ nw_in[24] nw_in[25] nw_in[26] nw_in[27] nw_in[28] nw_in[29] nw_in[2] nw_in[30] nw_in[31]
+ nw_in[32] nw_in[33] nw_in[34] nw_in[35] nw_in[3] nw_in[4] nw_in[5] nw_in[6] nw_in[7]
+ nw_in[8] nw_in[9] nw_out[0] nw_out[10] nw_out[11] nw_out[12] nw_out[13] nw_out[14]
+ nw_out[15] nw_out[16] nw_out[17] nw_out[18] nw_out[19] nw_out[1] nw_out[20] nw_out[21]
+ nw_out[22] nw_out[23] nw_out[24] nw_out[25] nw_out[26] nw_out[27] nw_out[28] nw_out[29]
+ nw_out[2] nw_out[30] nw_out[31] nw_out[32] nw_out[33] nw_out[34] nw_out[35] nw_out[3]
+ nw_out[4] nw_out[5] nw_out[6] nw_out[7] nw_out[8] nw_out[9] rst se_in[0] se_in[10]
+ se_in[11] se_in[12] se_in[13] se_in[14] se_in[15] se_in[16] se_in[17] se_in[18]
+ se_in[19] se_in[1] se_in[20] se_in[21] se_in[22] se_in[23] se_in[24] se_in[25] se_in[26]
+ se_in[27] se_in[28] se_in[29] se_in[2] se_in[30] se_in[31] se_in[32] se_in[33] se_in[34]
+ se_in[35] se_in[3] se_in[4] se_in[5] se_in[6] se_in[7] se_in[8] se_in[9] se_out[0]
+ se_out[10] se_out[11] se_out[12] se_out[13] se_out[14] se_out[15] se_out[16] se_out[17]
+ se_out[18] se_out[19] se_out[1] se_out[20] se_out[21] se_out[22] se_out[23] se_out[24]
+ se_out[25] se_out[26] se_out[27] se_out[28] se_out[29] se_out[2] se_out[30] se_out[31]
+ se_out[32] se_out[33] se_out[34] se_out[35] se_out[3] se_out[4] se_out[5] se_out[6]
+ se_out[7] se_out[8] se_out[9] south_in[0] south_in[10] south_in[11] south_in[12]
+ south_in[13] south_in[14] south_in[15] south_in[16] south_in[17] south_in[18] south_in[19]
+ south_in[1] south_in[20] south_in[21] south_in[22] south_in[23] south_in[24] south_in[25]
+ south_in[26] south_in[27] south_in[28] south_in[29] south_in[2] south_in[30] south_in[31]
+ south_in[32] south_in[33] south_in[34] south_in[35] south_in[3] south_in[4] south_in[5]
+ south_in[6] south_in[7] south_in[8] south_in[9] south_out[0] south_out[10] south_out[11]
+ south_out[12] south_out[13] south_out[14] south_out[15] south_out[16] south_out[17]
+ south_out[18] south_out[19] south_out[1] south_out[20] south_out[21] south_out[22]
+ south_out[23] south_out[24] south_out[25] south_out[26] south_out[27] south_out[28]
+ south_out[29] south_out[2] south_out[30] south_out[31] south_out[32] south_out[33]
+ south_out[34] south_out[35] south_out[3] south_out[4] south_out[5] south_out[6]
+ south_out[7] south_out[8] south_out[9] sw_in[0] sw_in[10] sw_in[11] sw_in[12] sw_in[13]
+ sw_in[14] sw_in[15] sw_in[16] sw_in[17] sw_in[18] sw_in[19] sw_in[1] sw_in[20] sw_in[21]
+ sw_in[22] sw_in[23] sw_in[24] sw_in[25] sw_in[26] sw_in[27] sw_in[28] sw_in[29]
+ sw_in[2] sw_in[30] sw_in[31] sw_in[32] sw_in[33] sw_in[34] sw_in[35] sw_in[3] sw_in[4]
+ sw_in[5] sw_in[6] sw_in[7] sw_in[8] sw_in[9] sw_out[0] sw_out[10] sw_out[11] sw_out[12]
+ sw_out[13] sw_out[14] sw_out[15] sw_out[16] sw_out[17] sw_out[18] sw_out[19] sw_out[1]
+ sw_out[20] sw_out[21] sw_out[22] sw_out[23] sw_out[24] sw_out[25] sw_out[26] sw_out[27]
+ sw_out[28] sw_out[29] sw_out[2] sw_out[30] sw_out[31] sw_out[32] sw_out[33] sw_out[34]
+ sw_out[35] sw_out[3] sw_out[4] sw_out[5] sw_out[6] sw_out[7] sw_out[8] sw_out[9]
+ west_in[0] west_in[10] west_in[11] west_in[12] west_in[13] west_in[14] west_in[15]
+ west_in[16] west_in[17] west_in[18] west_in[19] west_in[1] west_in[20] west_in[21]
+ west_in[22] west_in[23] west_in[24] west_in[25] west_in[26] west_in[27] west_in[28]
+ west_in[29] west_in[2] west_in[30] west_in[31] west_in[32] west_in[33] west_in[34]
+ west_in[35] west_in[3] west_in[4] west_in[5] west_in[6] west_in[7] west_in[8] west_in[9]
+ west_out[0] west_out[10] west_out[11] west_out[12] west_out[13] west_out[14] west_out[15]
+ west_out[16] west_out[17] west_out[18] west_out[19] west_out[1] west_out[20] west_out[21]
+ west_out[22] west_out[23] west_out[24] west_out[25] west_out[26] west_out[27] west_out[28]
+ west_out[29] west_out[2] west_out[30] west_out[31] west_out[32] west_out[33] west_out[34]
+ west_out[35] west_out[3] west_out[4] west_out[5] west_out[6] west_out[7] west_out[8]
+ west_out[9]
XFILLER_80_1287 VDD VDD VSS VSS gf180mcu_as_sc_mcu7t3v3__fill_2
X_3155_ VDD VDD VSS VSS _4495_/Q _4498_/Q _3155_/C _3158_/B gf180mcu_as_sc_mcu7t3v3__nor3_2
X_3086_ VDD VDD VSS VSS _3471_/B _3086_/A _3447_/B gf180mcu_as_sc_mcu7t3v3__and2_2
XFILLER_161_1006 VDD VDD VSS VSS gf180mcu_as_sc_mcu7t3v3__fillcap_4
XFILLER_165_1153 VDD VDD VSS VSS gf180mcu_as_sc_mcu7t3v3__fillcap_16
XFILLER_52_29 VDD VDD VSS VSS gf180mcu_as_sc_mcu7t3v3__fillcap_4
X_3988_ VDD VDD VSS VSS _3988_/B _4244_/B _3988_/Y gf180mcu_as_sc_mcu7t3v3__and2_2
Xwire709 VDD VDD VSS VSS _5072_/A _3518_/B gf180mcu_as_sc_mcu7t3v3__clkbuff_12
X_2939_ VDD VDD VSS VSS _2986_/A _2974_/A _3017_/A gf180mcu_as_sc_mcu7t3v3__and2_2
XFILLER_11_1031 VDD VDD VSS VSS gf180mcu_as_sc_mcu7t3v3__fillcap_16
XFILLER_191_664 VDD VDD VSS VSS gf180mcu_as_sc_mcu7t3v3__fillcap_8
XFILLER_89_1290 VDD VDD VSS VSS gf180mcu_as_sc_mcu7t3v3__fillcap_16
X_4609_ VDD VDD VSS VSS _4831_/CLK _4609_/D _4609_/Q gf180mcu_as_sc_mcu7t3v3__dfxtp_2
XFILLER_2_527 VDD VDD VSS VSS gf180mcu_as_sc_mcu7t3v3__fill_1
XTAP_TAPCELL_ROW_6_811 VDD VSS gf180mcu_as_sc_mcu7t3v3__tap_2
XTAP_TAPCELL_ROW_6_800 VDD VSS gf180mcu_as_sc_mcu7t3v3__tap_2
XFILLER_172_1157 VDD VDD VSS VSS gf180mcu_as_sc_mcu7t3v3__fill_2
Xhold1051 VDD VDD VSS VSS _4329_/S _2333_/B gf180mcu_as_sc_mcu7t3v3__clkbuff_4
XFILLER_133_76 VDD VDD VSS VSS gf180mcu_as_sc_mcu7t3v3__fill_1
Xhold1062 VDD VDD VSS VSS hold1094/Y _4827_/D gf180mcu_as_sc_mcu7t3v3__clkbuff_4
Xhold1073 VDD VDD VSS VSS _4654_/Q _3588_/A gf180mcu_as_sc_mcu7t3v3__clkbuff_4
Xhold1084 VDD VDD VSS VSS hold1084/A hold1084/Y gf180mcu_as_sc_mcu7t3v3__clkbuff_4
XFILLER_2_1265 VDD VDD VSS VSS gf180mcu_as_sc_mcu7t3v3__fill_2
Xhold1095 VDD VDD VSS VSS _4818_/Q hold1095/Y gf180mcu_as_sc_mcu7t3v3__clkbuff_4
XPHY_EDGE_ROW_129_3_Right_170 VDD VSS gf180mcu_as_sc_mcu7t3v3__tap_2
XFILLER_93_69 VDD VDD VSS VSS gf180mcu_as_sc_mcu7t3v3__fill_1
XFILLER_148_1351 VDD VDD VSS VSS gf180mcu_as_sc_mcu7t3v3__fillcap_4
XFILLER_186_403 VDD VDD VSS VSS gf180mcu_as_sc_mcu7t3v3__fill_2
XFILLER_187_904 VDD VDD VSS VSS gf180mcu_as_sc_mcu7t3v3__fillcap_4
XTAP_TAPCELL_ROW_146_1_1099 VDD VSS gf180mcu_as_sc_mcu7t3v3__tap_2
XFILLER_13_188 VDD VDD VSS VSS gf180mcu_as_sc_mcu7t3v3__fillcap_8
XFILLER_158_149 VDD VDD VSS VSS gf180mcu_as_sc_mcu7t3v3__fillcap_16
Xclkbuf_3_6__f_clk_regs VDD VDD VSS VSS clkbuf_2_3_0_clk_regs/Y clkbuf_3_6__f_clk_regs/Y
+ gf180mcu_as_sc_mcu7t3v3__clkbuff_12
XTAP_TAPCELL_ROW_158_1249 VDD VSS gf180mcu_as_sc_mcu7t3v3__tap_2
XFILLER_10_840 VDD VDD VSS VSS gf180mcu_as_sc_mcu7t3v3__fillcap_4
XFILLER_155_812 VDD VDD VSS VSS gf180mcu_as_sc_mcu7t3v3__fill_1
XTAP_TAPCELL_ROW_175_1574 VDD VSS gf180mcu_as_sc_mcu7t3v3__tap_2
XTAP_TAPCELL_ROW_175_1563 VDD VSS gf180mcu_as_sc_mcu7t3v3__tap_2
XFILLER_154_333 VDD VDD VSS VSS gf180mcu_as_sc_mcu7t3v3__fillcap_8
XFILLER_170_804 VDD VDD VSS VSS gf180mcu_as_sc_mcu7t3v3__fill_1
XFILLER_170_815 VDD VDD VSS VSS gf180mcu_as_sc_mcu7t3v3__fill_1
XFILLER_177_1046 VDD VDD VSS VSS gf180mcu_as_sc_mcu7t3v3__fillcap_4
XFILLER_6_877 VDD VDD VSS VSS gf180mcu_as_sc_mcu7t3v3__fillcap_16
XFILLER_181_174 VDD VDD VSS VSS gf180mcu_as_sc_mcu7t3v3__fillcap_16
XFILLER_190_1202 VDD VDD VSS VSS gf180mcu_as_sc_mcu7t3v3__fillcap_16
XFILLER_190_1224 VDD VDD VSS VSS gf180mcu_as_sc_mcu7t3v3__fill_1
XFILLER_184_1017 VDD VDD VSS VSS gf180mcu_as_sc_mcu7t3v3__fillcap_16
XFILLER_189_263 VDD VDD VSS VSS gf180mcu_as_sc_mcu7t3v3__fillcap_4
X_3911_ VDD VDD VSS VSS _3911_/A _3930_/B _3929_/B _4242_/D _3912_/D gf180mcu_as_sc_mcu7t3v3__ao22_2
XFILLER_162_1348 VDD VDD VSS VSS gf180mcu_as_sc_mcu7t3v3__fill_2
X_3842_ VDD VDD VSS VSS _3859_/B _4183_/A _3844_/C gf180mcu_as_sc_mcu7t3v3__or2_2
XFILLER_164_119 VDD VDD VSS VSS gf180mcu_as_sc_mcu7t3v3__fill_2
XFILLER_192_439 VDD VDD VSS VSS gf180mcu_as_sc_mcu7t3v3__fill_2
X_3773_ VDD VDD VSS VSS _4120_/D _3799_/B _3773_/C _3773_/D _3774_/C gf180mcu_as_sc_mcu7t3v3__ao211_2
XFILLER_8_181 VDD VDD VSS VSS gf180mcu_as_sc_mcu7t3v3__fill_2
X_2724_ VDD VDD VSS VSS _2879_/B _4057_/A _2725_/D gf180mcu_as_sc_mcu7t3v3__or2_2
XFILLER_173_664 VDD VDD VSS VSS gf180mcu_as_sc_mcu7t3v3__fillcap_16
Xoutput401 VDD VDD VSS VSS _4688_/Q south_out[31] gf180mcu_as_sc_mcu7t3v3__buff_12
X_2655_ VDD VDD VSS VSS _2655_/Y _2658_/D _2656_/A gf180mcu_as_sc_mcu7t3v3__nor2_2
XFILLER_172_174 VDD VDD VSS VSS gf180mcu_as_sc_mcu7t3v3__fill_1
Xoutput423 VDD VDD VSS VSS _4748_/Q west_out[19] gf180mcu_as_sc_mcu7t3v3__buff_12
Xoutput434 VDD VDD VSS VSS _4758_/Q west_out[29] gf180mcu_as_sc_mcu7t3v3__buff_12
Xoutput412 VDD VDD VSS VSS _4666_/Q south_out[9] gf180mcu_as_sc_mcu7t3v3__buff_12
XTAP_TAPCELL_ROW_61_3_1972 VDD VSS gf180mcu_as_sc_mcu7t3v3__tap_2
Xoutput445 VDD VDD VSS VSS _4736_/Q west_out[7] gf180mcu_as_sc_mcu7t3v3__buff_12
X_4325_ VDD VDD VSS VSS _4326_/B _4517_/Q _4802_/D gf180mcu_as_sc_mcu7t3v3__and2_2
X_2586_ VDD VDD VSS VSS _4830_/D _2586_/B _4638_/Q _4637_/D gf180mcu_as_sc_mcu7t3v3__mux2_2
X_4256_ VDD VDD VSS VSS _4266_/B _4256_/A _4257_/D gf180mcu_as_sc_mcu7t3v3__and2_2
XFILLER_47_29 VDD VDD VSS VSS gf180mcu_as_sc_mcu7t3v3__fill_1
X_4187_ VDD VDD VSS VSS _4187_/A _4187_/B _4187_/C _4188_/C _4187_/D gf180mcu_as_sc_mcu7t3v3__aoi211_2
X_3207_ VDD VDD VSS VSS _3208_/C _3207_/B _3412_/A gf180mcu_as_sc_mcu7t3v3__nor2b_2
XPHY_EDGE_ROW_100_1_Right_609 VDD VSS gf180mcu_as_sc_mcu7t3v3__tap_2
X_3138_ VDD VDD VSS VSS _3141_/C _4443_/Q _3205_/A gf180mcu_as_sc_mcu7t3v3__nand2_2
XFILLER_167_1204 VDD VDD VSS VSS gf180mcu_as_sc_mcu7t3v3__fill_2
XFILLER_167_1237 VDD VDD VSS VSS gf180mcu_as_sc_mcu7t3v3__fill_1
X_3069_ VDD VDD VSS VSS _3070_/S _3528_/A _4468_/Q _4468_/D gf180mcu_as_sc_mcu7t3v3__mux2_2
XPHY_EDGE_ROW_38_1_Left_230 VDD VSS gf180mcu_as_sc_mcu7t3v3__tap_2
XFILLER_168_414 VDD VDD VSS VSS gf180mcu_as_sc_mcu7t3v3__fillcap_16
XFILLER_11_648 VDD VDD VSS VSS gf180mcu_as_sc_mcu7t3v3__fill_1
XFILLER_168_469 VDD VDD VSS VSS gf180mcu_as_sc_mcu7t3v3__fill_2
XFILLER_17_1273 VDD VDD VSS VSS gf180mcu_as_sc_mcu7t3v3__fill_1
XFILLER_6_107 VDD VDD VSS VSS gf180mcu_as_sc_mcu7t3v3__fill_1
XFILLER_192_951 VDD VDD VSS VSS gf180mcu_as_sc_mcu7t3v3__fill_1
XTAP_TAPCELL_ROW_153_1157 VDD VSS gf180mcu_as_sc_mcu7t3v3__tap_2
XTAP_TAPCELL_ROW_153_1146 VDD VSS gf180mcu_as_sc_mcu7t3v3__tap_2
XTAP_TAPCELL_ROW_170_1471 VDD VSS gf180mcu_as_sc_mcu7t3v3__tap_2
XFILLER_163_196 VDD VDD VSS VSS gf180mcu_as_sc_mcu7t3v3__fillcap_8
XTAP_TAPCELL_ROW_170_1482 VDD VSS gf180mcu_as_sc_mcu7t3v3__tap_2
XFILLER_144_53 VDD VDD VSS VSS gf180mcu_as_sc_mcu7t3v3__fillcap_16
Xfanout650 VDD VDD VSS VSS _3926_/B _3879_/B gf180mcu_as_sc_mcu7t3v3__buff_12
Xfanout661 VDD VDD VSS VSS _3870_/A _3796_/B gf180mcu_as_sc_mcu7t3v3__buff_12
Xfanout672 VDD VDD VSS VSS _2874_/B _2828_/B gf180mcu_as_sc_mcu7t3v3__buff_12
Xfanout683 VDD VDD VSS VSS _3614_/Y _3806_/B gf180mcu_as_sc_mcu7t3v3__buff_12
Xfanout694 VDD VDD VSS VSS _3868_/B wire695/A gf180mcu_as_sc_mcu7t3v3__buff_12
XFILLER_150_1285 VDD VDD VSS VSS gf180mcu_as_sc_mcu7t3v3__fillcap_4
XFILLER_24_1288 VDD VDD VSS VSS gf180mcu_as_sc_mcu7t3v3__fill_1
XFILLER_111_1269 VDD VDD VSS VSS gf180mcu_as_sc_mcu7t3v3__fill_1
XFILLER_185_1326 VDD VDD VSS VSS gf180mcu_as_sc_mcu7t3v3__fillcap_4
XFILLER_185_1348 VDD VDD VSS VSS gf180mcu_as_sc_mcu7t3v3__fillcap_4
XFILLER_2_1084 VDD VDD VSS VSS gf180mcu_as_sc_mcu7t3v3__fill_1
XTAP_TAPCELL_ROW_177_1614 VDD VSS gf180mcu_as_sc_mcu7t3v3__tap_2
XTAP_TAPCELL_ROW_177_1603 VDD VSS gf180mcu_as_sc_mcu7t3v3__tap_2
XFILLER_159_447 VDD VDD VSS VSS gf180mcu_as_sc_mcu7t3v3__fill_1
XFILLER_169_72 VDD VDD VSS VSS gf180mcu_as_sc_mcu7t3v3__fill_2
XFILLER_186_233 VDD VDD VSS VSS gf180mcu_as_sc_mcu7t3v3__fill_1
XFILLER_187_767 VDD VDD VSS VSS gf180mcu_as_sc_mcu7t3v3__fill_2
XFILLER_183_973 VDD VDD VSS VSS gf180mcu_as_sc_mcu7t3v3__fillcap_4
XTAP_TAPCELL_ROW_190_1858 VDD VSS gf180mcu_as_sc_mcu7t3v3__tap_2
XTAP_TAPCELL_ROW_190_1847 VDD VSS gf180mcu_as_sc_mcu7t3v3__tap_2
XPHY_EDGE_ROW_105_3_Left_477 VDD VSS gf180mcu_as_sc_mcu7t3v3__tap_2
XFILLER_154_174 VDD VDD VSS VSS gf180mcu_as_sc_mcu7t3v3__fill_1
XFILLER_6_696 VDD VDD VSS VSS gf180mcu_as_sc_mcu7t3v3__fillcap_8
X_2440_ VDD VDD VSS VSS _4536_/Q _3068_/S _3061_/S _4512_/Q _2441_/B gf180mcu_as_sc_mcu7t3v3__ao22_2
XFILLER_170_689 VDD VDD VSS VSS gf180mcu_as_sc_mcu7t3v3__fill_2
XFILLER_190_1021 VDD VDD VSS VSS gf180mcu_as_sc_mcu7t3v3__fill_1
XFILLER_68_103 VDD VDD VSS VSS gf180mcu_as_sc_mcu7t3v3__fill_2
X_2371_ VDD VDD VSS VSS _2371_/D _4829_/D _2371_/B _2371_/C _2372_/A gf180mcu_as_sc_mcu7t3v3__ao31_2
XPHY_EDGE_ROW_42_3_Left_414 VDD VSS gf180mcu_as_sc_mcu7t3v3__tap_2
XFILLER_190_1087 VDD VDD VSS VSS gf180mcu_as_sc_mcu7t3v3__fillcap_8
X_4110_ VDD VDD VSS VSS _4110_/A _4235_/B _4226_/B _4110_/D _4111_/B gf180mcu_as_sc_mcu7t3v3__ao22_2
X_4041_ VDD VDD VSS VSS _4042_/B _4041_/A _4154_/S _4041_/C gf180mcu_as_sc_mcu7t3v3__ao21_2
XFILLER_166_1292 VDD VDD VSS VSS gf180mcu_as_sc_mcu7t3v3__fill_2
XFILLER_178_734 VDD VDD VSS VSS gf180mcu_as_sc_mcu7t3v3__fill_1
XFILLER_177_233 VDD VDD VSS VSS gf180mcu_as_sc_mcu7t3v3__fillcap_16
XFILLER_165_417 VDD VDD VSS VSS gf180mcu_as_sc_mcu7t3v3__fill_2
XFILLER_177_277 VDD VDD VSS VSS gf180mcu_as_sc_mcu7t3v3__fill_2
X_3825_ VDD VDD VSS VSS _3827_/C _4169_/A _3871_/C _3825_/C gf180mcu_as_sc_mcu7t3v3__ao21_2
X_3756_ VDD VDD VSS VSS _4105_/A _3882_/B _3756_/C _3757_/C _3855_/B gf180mcu_as_sc_mcu7t3v3__aoi211_2
X_2707_ VDD VDD VSS VSS _4042_/A _2796_/D _2707_/C _2707_/D _2982_/A gf180mcu_as_sc_mcu7t3v3__ao22_2
XFILLER_12_1181 VDD VDD VSS VSS gf180mcu_as_sc_mcu7t3v3__fillcap_4
XFILLER_160_100 VDD VDD VSS VSS gf180mcu_as_sc_mcu7t3v3__fillcap_4
XFILLER_174_995 VDD VDD VSS VSS gf180mcu_as_sc_mcu7t3v3__fillcap_16
X_3687_ VDD VDD VSS VSS _4047_/D _3886_/B _3687_/C _3876_/D _3689_/C gf180mcu_as_sc_mcu7t3v3__ao211_2
X_2638_ VDD VDD VSS VSS _2638_/A _2659_/B _2638_/C _2638_/D _2654_/C gf180mcu_as_sc_mcu7t3v3__ao211_2
XFILLER_160_177 VDD VDD VSS VSS gf180mcu_as_sc_mcu7t3v3__fillcap_8
XFILLER_59_103 VDD VDD VSS VSS gf180mcu_as_sc_mcu7t3v3__fill_2
X_2569_ VDD VDD VSS VSS _4829_/D _2569_/B _4641_/Q _4640_/D gf180mcu_as_sc_mcu7t3v3__mux2_2
XFILLER_0_839 VDD VDD VSS VSS gf180mcu_as_sc_mcu7t3v3__fill_2
XFILLER_181_18 VDD VDD VSS VSS gf180mcu_as_sc_mcu7t3v3__fillcap_16
X_4308_ VDD VDD VSS VSS _4313_/B _4532_/Q _4785_/D gf180mcu_as_sc_mcu7t3v3__and2_2
XPHY_EDGE_ROW_99_3_Left_471 VDD VSS gf180mcu_as_sc_mcu7t3v3__tap_2
XFILLER_114_34 VDD VDD VSS VSS gf180mcu_as_sc_mcu7t3v3__fill_1
X_4239_ VDD VDD VSS VSS _4239_/B _4271_/A _4721_/D gf180mcu_as_sc_mcu7t3v3__and2_2
XFILLER_110_1291 VDD VDD VSS VSS gf180mcu_as_sc_mcu7t3v3__fillcap_8
XFILLER_145_1310 VDD VDD VSS VSS gf180mcu_as_sc_mcu7t3v3__fill_2
XFILLER_169_734 VDD VDD VSS VSS gf180mcu_as_sc_mcu7t3v3__fill_1
XFILLER_157_907 VDD VDD VSS VSS gf180mcu_as_sc_mcu7t3v3__fill_2
XFILLER_23_42 VDD VDD VSS VSS gf180mcu_as_sc_mcu7t3v3__fill_2
XFILLER_184_748 VDD VDD VSS VSS gf180mcu_as_sc_mcu7t3v3__fillcap_8
XFILLER_23_97 VDD VDD VSS VSS gf180mcu_as_sc_mcu7t3v3__fillcap_8
XTAP_TAPCELL_ROW_172_1522 VDD VSS gf180mcu_as_sc_mcu7t3v3__tap_2
XTAP_TAPCELL_ROW_172_1511 VDD VSS gf180mcu_as_sc_mcu7t3v3__tap_2
XFILLER_152_634 VDD VDD VSS VSS gf180mcu_as_sc_mcu7t3v3__fillcap_4
XFILLER_164_461 VDD VDD VSS VSS gf180mcu_as_sc_mcu7t3v3__fill_2
XFILLER_178_1152 VDD VDD VSS VSS gf180mcu_as_sc_mcu7t3v3__fill_2
XFILLER_192_781 VDD VDD VSS VSS gf180mcu_as_sc_mcu7t3v3__fill_1
XFILLER_99_68 VDD VDD VSS VSS gf180mcu_as_sc_mcu7t3v3__fill_2
XFILLER_178_1185 VDD VDD VSS VSS gf180mcu_as_sc_mcu7t3v3__fillcap_16
XFILLER_174_1049 VDD VDD VSS VSS gf180mcu_as_sc_mcu7t3v3__fillcap_16
XFILLER_191_1352 VDD VDD VSS VSS gf180mcu_as_sc_mcu7t3v3__fill_2
XFILLER_152_1325 VDD VDD VSS VSS gf180mcu_as_sc_mcu7t3v3__fill_1
XFILLER_48_72 VDD VDD VSS VSS gf180mcu_as_sc_mcu7t3v3__fill_1
Xfanout480 VDD VDD VSS VSS _3038_/B _3019_/B gf180mcu_as_sc_mcu7t3v3__buff_12
Xfanout491 VDD VDD VSS VSS _4230_/B _4138_/B gf180mcu_as_sc_mcu7t3v3__buff_12
XFILLER_189_1270 VDD VDD VSS VSS gf180mcu_as_sc_mcu7t3v3__fillcap_16
XTAP_TAPCELL_ROW_99_3_2010 VDD VSS gf180mcu_as_sc_mcu7t3v3__tap_2
XTAP_TAPCELL_ROW_113_3_2024 VDD VSS gf180mcu_as_sc_mcu7t3v3__tap_2
XFILLER_185_1167 VDD VDD VSS VSS gf180mcu_as_sc_mcu7t3v3__fillcap_16
XFILLER_185_1189 VDD VDD VSS VSS gf180mcu_as_sc_mcu7t3v3__fill_1
X_4756__1016 VDD VDD VSS VSS _4756_/D gf180mcu_as_sc_mcu7t3v3__tiel_4
XFILLER_159_255 VDD VDD VSS VSS gf180mcu_as_sc_mcu7t3v3__fill_1
XTAP_TAPCELL_ROW_192_1909 VDD VSS gf180mcu_as_sc_mcu7t3v3__tap_2
XTAP_TAPCELL_ROW_13_952 VDD VSS gf180mcu_as_sc_mcu7t3v3__tap_2
XTAP_TAPCELL_ROW_13_941 VDD VSS gf180mcu_as_sc_mcu7t3v3__tap_2
XTAP_TAPCELL_ROW_13_930 VDD VSS gf180mcu_as_sc_mcu7t3v3__tap_2
XFILLER_9_55 VDD VDD VSS VSS gf180mcu_as_sc_mcu7t3v3__fill_1
XFILLER_175_748 VDD VDD VSS VSS gf180mcu_as_sc_mcu7t3v3__fillcap_16
XFILLER_80_70 VDD VDD VSS VSS gf180mcu_as_sc_mcu7t3v3__fill_2
X_4590_ VDD VDD VSS VSS _4829_/CLK _4590_/D _4590_/Q gf180mcu_as_sc_mcu7t3v3__dfxtp_2
X_3610_ VDD VDD VSS VSS _3610_/A _4655_/Q _3610_/C _3610_/D _4655_/D gf180mcu_as_sc_mcu7t3v3__ao22_2
XTAP_TAPCELL_ROW_13_963 VDD VSS gf180mcu_as_sc_mcu7t3v3__tap_2
XFILLER_174_247 VDD VDD VSS VSS gf180mcu_as_sc_mcu7t3v3__fillcap_16
XFILLER_7_950 VDD VDD VSS VSS gf180mcu_as_sc_mcu7t3v3__fillcap_16
X_3541_ VDD VDD VSS VSS _3544_/B _3541_/A _3541_/B _3541_/C gf180mcu_as_sc_mcu7t3v3__ao21_2
XFILLER_157_1203 VDD VDD VSS VSS gf180mcu_as_sc_mcu7t3v3__fillcap_8
X_3472_ VDD VDD VSS VSS _3473_/B _3474_/A _4591_/Q _3478_/B gf180mcu_as_sc_mcu7t3v3__ao21_2
X_2423_ VDD VDD VSS VSS _2424_/D _2461_/C _2437_/B _2423_/A gf180mcu_as_sc_mcu7t3v3__aoi21b_2
X_2354_ VDD VDD VSS VSS _2405_/A _2418_/A _2388_/A gf180mcu_as_sc_mcu7t3v3__nor2_2
X_5073_ VDD VDD VSS VSS _5073_/A _5073_/Y gf180mcu_as_sc_mcu7t3v3__buff_2
X_2285_ VDD VDD VSS VSS _3212_/B _3608_/A _2287_/C gf180mcu_as_sc_mcu7t3v3__nor2b_2
XFILLER_133_1280 VDD VDD VSS VSS gf180mcu_as_sc_mcu7t3v3__fill_2
X_4024_ VDD VDD VSS VSS _4024_/A _4136_/B _4024_/C _4024_/D _4025_/C gf180mcu_as_sc_mcu7t3v3__ao211_2
XTAP_TAPCELL_ROW_0_669 VDD VSS gf180mcu_as_sc_mcu7t3v3__tap_2
XTAP_TAPCELL_ROW_48_3_1959 VDD VSS gf180mcu_as_sc_mcu7t3v3__tap_2
X_3808_ VDD VDD VSS VSS _4153_/A _3871_/B _3808_/C _4148_/D _3809_/D gf180mcu_as_sc_mcu7t3v3__ao22_2
XFILLER_181_718 VDD VDD VSS VSS gf180mcu_as_sc_mcu7t3v3__fillcap_16
X_4788_ VDD VDD VSS VSS clkload7/A _4788_/D _4788_/Q gf180mcu_as_sc_mcu7t3v3__dfxtp_2
XFILLER_162_932 VDD VDD VSS VSS gf180mcu_as_sc_mcu7t3v3__fill_1
XFILLER_174_792 VDD VDD VSS VSS gf180mcu_as_sc_mcu7t3v3__fill_2
X_3739_ VDD VDD VSS VSS _3739_/B _3748_/A _4667_/D gf180mcu_as_sc_mcu7t3v3__and2_2
XFILLER_161_486 VDD VDD VSS VSS gf180mcu_as_sc_mcu7t3v3__fillcap_4
XFILLER_173_1060 VDD VDD VSS VSS gf180mcu_as_sc_mcu7t3v3__fillcap_4
XFILLER_18_75 VDD VDD VSS VSS gf180mcu_as_sc_mcu7t3v3__fill_1
XFILLER_18_86 VDD VDD VSS VSS gf180mcu_as_sc_mcu7t3v3__fillcap_16
XTAP_TAPCELL_ROW_165_1381 VDD VSS gf180mcu_as_sc_mcu7t3v3__tap_2
XFILLER_95_1326 VDD VDD VSS VSS gf180mcu_as_sc_mcu7t3v3__fill_2
XFILLER_188_317 VDD VDD VSS VSS gf180mcu_as_sc_mcu7t3v3__fill_2
XFILLER_7_202 VDD VDD VSS VSS gf180mcu_as_sc_mcu7t3v3__fillcap_8
XFILLER_4_920 VDD VDD VSS VSS gf180mcu_as_sc_mcu7t3v3__fillcap_16
XFILLER_50_62 VDD VDD VSS VSS gf180mcu_as_sc_mcu7t3v3__fillcap_4
XFILLER_180_773 VDD VDD VSS VSS gf180mcu_as_sc_mcu7t3v3__fill_2
XTAP_TAPCELL_ROW_185_1768 VDD VSS gf180mcu_as_sc_mcu7t3v3__tap_2
XTAP_TAPCELL_ROW_185_1757 VDD VSS gf180mcu_as_sc_mcu7t3v3__tap_2
X_2972_ VDD VDD VSS VSS _2975_/B _4388_/Q _2973_/D gf180mcu_as_sc_mcu7t3v3__and2_2
XFILLER_163_1262 VDD VDD VSS VSS gf180mcu_as_sc_mcu7t3v3__fill_2
X_4711_ VDD VDD VSS VSS _4726_/CLK _4711_/D _4711_/Q gf180mcu_as_sc_mcu7t3v3__dfxtp_2
XFILLER_187_383 VDD VDD VSS VSS gf180mcu_as_sc_mcu7t3v3__fillcap_16
X_4642_ VDD VDD VSS VSS _4808_/CLK _4642_/D _4642_/Q gf180mcu_as_sc_mcu7t3v3__dfxtp_2
XFILLER_156_770 VDD VDD VSS VSS gf180mcu_as_sc_mcu7t3v3__fillcap_4
XFILLER_156_781 VDD VDD VSS VSS gf180mcu_as_sc_mcu7t3v3__fillcap_16
XFILLER_163_729 VDD VDD VSS VSS gf180mcu_as_sc_mcu7t3v3__fillcap_8
XFILLER_175_589 VDD VDD VSS VSS gf180mcu_as_sc_mcu7t3v3__fillcap_8
X_4573_ VDD VDD VSS VSS _4719_/CLK _4573_/D _4573_/Q gf180mcu_as_sc_mcu7t3v3__dfxtp_2
X_3524_ VDD VDD VSS VSS _3527_/D _3527_/A _4604_/Q gf180mcu_as_sc_mcu7t3v3__nor2b_2
X_3455_ VDD VDD VSS VSS _3522_/S _4475_/Q _3541_/A _4578_/D gf180mcu_as_sc_mcu7t3v3__mux2_2
X_2406_ VDD VDD VSS VSS _2406_/Y _2455_/A _2406_/B _2406_/C gf180mcu_as_sc_mcu7t3v3__ao21_2
X_3386_ VDD VDD VSS VSS _3388_/B _3386_/C _3386_/B _3408_/C gf180mcu_as_sc_mcu7t3v3__aoi21_2
X_2337_ VDD VDD VSS VSS _2338_/B _2337_/B _3051_/A _3458_/A _2342_/B gf180mcu_as_sc_mcu7t3v3__ao211_2
X_2268_ VDD VDD VSS VSS _3568_/A _2269_/B _2269_/C _2524_/B _2269_/D gf180mcu_as_sc_mcu7t3v3__aoi31_2
X_4007_ VDD VDD VSS VSS _4007_/Y _4260_/D _4261_/A gf180mcu_as_sc_mcu7t3v3__nor2b_2
X_2199_ VDD VDD VSS VSS _2523_/D _4640_/Q gf180mcu_as_sc_mcu7t3v3__inv_2
XFILLER_111_46 VDD VDD VSS VSS gf180mcu_as_sc_mcu7t3v3__fillcap_4
XFILLER_164_1004 VDD VDD VSS VSS gf180mcu_as_sc_mcu7t3v3__fill_1
XFILLER_20_1291 VDD VDD VSS VSS gf180mcu_as_sc_mcu7t3v3__fill_2
XFILLER_111_68 VDD VDD VSS VSS gf180mcu_as_sc_mcu7t3v3__fill_2
XFILLER_166_501 VDD VDD VSS VSS gf180mcu_as_sc_mcu7t3v3__fillcap_16
XFILLER_16_1316 VDD VDD VSS VSS gf180mcu_as_sc_mcu7t3v3__fillcap_8
XFILLER_185_309 VDD VDD VSS VSS gf180mcu_as_sc_mcu7t3v3__fillcap_8
XFILLER_90_1256 VDD VDD VSS VSS gf180mcu_as_sc_mcu7t3v3__fillcap_16
XFILLER_103_1308 VDD VDD VSS VSS gf180mcu_as_sc_mcu7t3v3__fill_1
XFILLER_181_515 VDD VDD VSS VSS gf180mcu_as_sc_mcu7t3v3__fill_1
XFILLER_5_739 VDD VDD VSS VSS gf180mcu_as_sc_mcu7t3v3__fill_1
XFILLER_175_1122 VDD VDD VSS VSS gf180mcu_as_sc_mcu7t3v3__fillcap_16
XFILLER_1_912 VDD VDD VSS VSS gf180mcu_as_sc_mcu7t3v3__fillcap_8
XFILLER_20_65 VDD VDD VSS VSS gf180mcu_as_sc_mcu7t3v3__fillcap_16
XFILLER_121_103 VDD VDD VSS VSS gf180mcu_as_sc_mcu7t3v3__fill_2
XFILLER_1_934 VDD VDD VSS VSS gf180mcu_as_sc_mcu7t3v3__fillcap_16
Xinput301 VDD VDD VSS VSS west_in[13] _4110_/A gf180mcu_as_sc_mcu7t3v3__buff_12
Xinput312 VDD VDD VSS VSS west_in[23] _4191_/A gf180mcu_as_sc_mcu7t3v3__buff_12
XTAP_TAPCELL_ROW_167_1421 VDD VSS gf180mcu_as_sc_mcu7t3v3__tap_2
XTAP_TAPCELL_ROW_167_1410 VDD VSS gf180mcu_as_sc_mcu7t3v3__tap_2
Xinput323 VDD VDD VSS VSS west_in[33] _3949_/A gf180mcu_as_sc_mcu7t3v3__buff_12
XTAP_TAPCELL_ROW_4_761 VDD VSS gf180mcu_as_sc_mcu7t3v3__tap_2
XFILLER_152_97 VDD VDD VSS VSS gf180mcu_as_sc_mcu7t3v3__fillcap_4
XTAP_TAPCELL_ROW_4_772 VDD VSS gf180mcu_as_sc_mcu7t3v3__tap_2
XTAP_TAPCELL_ROW_180_1665 VDD VSS gf180mcu_as_sc_mcu7t3v3__tap_2
XPHY_EDGE_ROW_114_3_Left_486 VDD VSS gf180mcu_as_sc_mcu7t3v3__tap_2
XPHY_EDGE_ROW_51_3_Left_423 VDD VSS gf180mcu_as_sc_mcu7t3v3__tap_2
XFILLER_61_72 VDD VDD VSS VSS gf180mcu_as_sc_mcu7t3v3__fillcap_16
XFILLER_8_555 VDD VDD VSS VSS gf180mcu_as_sc_mcu7t3v3__fillcap_4
XFILLER_157_578 VDD VDD VSS VSS gf180mcu_as_sc_mcu7t3v3__fillcap_16
XFILLER_177_72 VDD VDD VSS VSS gf180mcu_as_sc_mcu7t3v3__fill_1
XFILLER_6_34 VDD VDD VSS VSS gf180mcu_as_sc_mcu7t3v3__fill_1
XANTENNA_5 VDD VDD VSS VSS _4706_/D gf180mcu_as_sc_mcu7t3v3__diode_2
XFILLER_6_67 VDD VDD VSS VSS gf180mcu_as_sc_mcu7t3v3__fillcap_8
XFILLER_153_762 VDD VDD VSS VSS gf180mcu_as_sc_mcu7t3v3__fillcap_8
XFILLER_119_1326 VDD VDD VSS VSS gf180mcu_as_sc_mcu7t3v3__fillcap_4
XFILLER_4_783 VDD VDD VSS VSS gf180mcu_as_sc_mcu7t3v3__fillcap_16
XTAP_TAPCELL_ROW_187_1808 VDD VSS gf180mcu_as_sc_mcu7t3v3__tap_2
XFILLER_3_282 VDD VDD VSS VSS gf180mcu_as_sc_mcu7t3v3__fillcap_4
X_3240_ VDD VDD VSS VSS _3304_/S _4363_/Q _4392_/Q _3241_/B gf180mcu_as_sc_mcu7t3v3__mux2_2
Xmesh_tile_927 VDD VDD VSS VSS nw_out[27] gf180mcu_as_sc_mcu7t3v3__tiel_4
Xmesh_tile_916 VDD VDD VSS VSS nw_out[16] gf180mcu_as_sc_mcu7t3v3__tiel_4
Xmesh_tile_905 VDD VDD VSS VSS nw_out[5] gf180mcu_as_sc_mcu7t3v3__tiel_4
X_3171_ VDD VDD VSS VSS _3174_/D _3171_/B _3206_/A gf180mcu_as_sc_mcu7t3v3__nor2_2
Xmesh_tile_949 VDD VDD VSS VSS se_out[13] gf180mcu_as_sc_mcu7t3v3__tiel_4
Xmesh_tile_938 VDD VDD VSS VSS se_out[2] gf180mcu_as_sc_mcu7t3v3__tiel_4
XFILLER_130_1272 VDD VDD VSS VSS gf180mcu_as_sc_mcu7t3v3__fillcap_4
XFILLER_165_1313 VDD VDD VSS VSS gf180mcu_as_sc_mcu7t3v3__fillcap_4
XFILLER_179_169 VDD VDD VSS VSS gf180mcu_as_sc_mcu7t3v3__fillcap_4
XFILLER_163_1070 VDD VDD VSS VSS gf180mcu_as_sc_mcu7t3v3__fillcap_16
XFILLER_176_832 VDD VDD VSS VSS gf180mcu_as_sc_mcu7t3v3__fill_1
X_2955_ VDD VDD VSS VSS _4378_/Q _2965_/B _3026_/A _2965_/D _4378_/D gf180mcu_as_sc_mcu7t3v3__ao22_2
X_2886_ VDD VDD VSS VSS _4199_/A _2895_/B _2886_/C _2886_/D _2887_/C gf180mcu_as_sc_mcu7t3v3__ao211_2
X_4625_ VDD VDD VSS VSS _4820_/CLK _4625_/D _4625_/Q gf180mcu_as_sc_mcu7t3v3__dfxtp_2
XFILLER_163_559 VDD VDD VSS VSS gf180mcu_as_sc_mcu7t3v3__fill_1
X_4556_ VDD VDD VSS VSS _4728_/CLK _4556_/D _4556_/Q gf180mcu_as_sc_mcu7t3v3__dfxtp_2
XFILLER_190_356 VDD VDD VSS VSS gf180mcu_as_sc_mcu7t3v3__fill_2
X_3507_ VDD VDD VSS VSS _3507_/D _3507_/A _3507_/B _3507_/C _4603_/D gf180mcu_as_sc_mcu7t3v3__ao31_2
XFILLER_172_1317 VDD VDD VSS VSS gf180mcu_as_sc_mcu7t3v3__fillcap_16
X_4487_ VDD VDD VSS VSS _4720_/CLK _4487_/D _4487_/Q gf180mcu_as_sc_mcu7t3v3__dfxtp_2
Xclkbuf_leaf_9_clk_regs VDD VDD VSS VSS clkbuf_leaf_9_clk_regs/A _4795_/CLK gf180mcu_as_sc_mcu7t3v3__clkbuff_12
X_3438_ VDD VDD VSS VSS _4567_/Q _3439_/B _3439_/C _4566_/Q _4566_/D gf180mcu_as_sc_mcu7t3v3__ao22_2
XFILLER_170_1041 VDD VDD VSS VSS gf180mcu_as_sc_mcu7t3v3__fill_2
X_3369_ VDD VDD VSS VSS _3370_/D _3369_/B _3369_/A gf180mcu_as_sc_mcu7t3v3__nor2_2
XFILLER_106_79 VDD VDD VSS VSS gf180mcu_as_sc_mcu7t3v3__fill_1
XFILLER_122_34 VDD VDD VSS VSS gf180mcu_as_sc_mcu7t3v3__fill_1
X_4751__1021 VDD VDD VSS VSS _4751_/D gf180mcu_as_sc_mcu7t3v3__tiel_4
XFILLER_167_6 VDD VDD VSS VSS gf180mcu_as_sc_mcu7t3v3__fillcap_16
XFILLER_82_27 VDD VDD VSS VSS gf180mcu_as_sc_mcu7t3v3__fill_2
XTAP_TAPCELL_ROW_51_1_1004 VDD VSS gf180mcu_as_sc_mcu7t3v3__tap_2
XFILLER_40_101 VDD VDD VSS VSS gf180mcu_as_sc_mcu7t3v3__fillcap_4
XFILLER_186_629 VDD VDD VSS VSS gf180mcu_as_sc_mcu7t3v3__fillcap_16
XFILLER_185_139 VDD VDD VSS VSS gf180mcu_as_sc_mcu7t3v3__fill_1
Xclkbuf_3_5__f_clk_regs VDD VDD VSS VSS clkbuf_2_2_0_clk_regs/Y clkload1/A gf180mcu_as_sc_mcu7t3v3__clkbuff_12
XFILLER_167_865 VDD VDD VSS VSS gf180mcu_as_sc_mcu7t3v3__fill_1
XFILLER_181_1192 VDD VDD VSS VSS gf180mcu_as_sc_mcu7t3v3__fillcap_8
XFILLER_182_802 VDD VDD VSS VSS gf180mcu_as_sc_mcu7t3v3__fill_2
XFILLER_154_504 VDD VDD VSS VSS gf180mcu_as_sc_mcu7t3v3__fill_1
XFILLER_147_53 VDD VDD VSS VSS gf180mcu_as_sc_mcu7t3v3__fill_1
XFILLER_147_64 VDD VDD VSS VSS gf180mcu_as_sc_mcu7t3v3__fillcap_4
XTAP_TAPCELL_ROW_9_853 VDD VSS gf180mcu_as_sc_mcu7t3v3__tap_2
XTAP_TAPCELL_ROW_9_864 VDD VSS gf180mcu_as_sc_mcu7t3v3__tap_2
XFILLER_27_1264 VDD VDD VSS VSS gf180mcu_as_sc_mcu7t3v3__fill_2
XFILLER_66_1291 VDD VDD VSS VSS gf180mcu_as_sc_mcu7t3v3__fillcap_4
Xinput120 VDD VDD VSS VSS north_in[13] _4110_/D gf180mcu_as_sc_mcu7t3v3__buff_12
XFILLER_27_1297 VDD VDD VSS VSS gf180mcu_as_sc_mcu7t3v3__fill_2
Xinput131 VDD VDD VSS VSS north_in[23] _4189_/D gf180mcu_as_sc_mcu7t3v3__buff_12
Xinput142 VDD VDD VSS VSS north_in[33] _3952_/C gf180mcu_as_sc_mcu7t3v3__buff_12
Xinput153 VDD VDD VSS VSS nw_in[10] _4088_/A gf180mcu_as_sc_mcu7t3v3__buff_12
XTAP_TAPCELL_ROW_182_1705 VDD VSS gf180mcu_as_sc_mcu7t3v3__tap_2
XFILLER_114_1256 VDD VDD VSS VSS gf180mcu_as_sc_mcu7t3v3__fillcap_16
XFILLER_188_1313 VDD VDD VSS VSS gf180mcu_as_sc_mcu7t3v3__fillcap_16
Xinput164 VDD VDD VSS VSS nw_in[20] _4169_/D gf180mcu_as_sc_mcu7t3v3__buff_12
Xinput175 VDD VDD VSS VSS nw_in[30] wire809/A gf180mcu_as_sc_mcu7t3v3__buff_12
Xinput186 VDD VDD VSS VSS nw_in[8] _4072_/A gf180mcu_as_sc_mcu7t3v3__buff_12
XFILLER_149_1308 VDD VDD VSS VSS gf180mcu_as_sc_mcu7t3v3__fill_2
XFILLER_56_83 VDD VDD VSS VSS gf180mcu_as_sc_mcu7t3v3__fill_2
Xinput197 VDD VDD VSS VSS se_in[17] _4145_/A gf180mcu_as_sc_mcu7t3v3__buff_12
XFILLER_188_60 VDD VDD VSS VSS gf180mcu_as_sc_mcu7t3v3__fillcap_8
XFILLER_13_882 VDD VDD VSS VSS gf180mcu_as_sc_mcu7t3v3__fill_2
XFILLER_160_1243 VDD VDD VSS VSS gf180mcu_as_sc_mcu7t3v3__fillcap_4
X_2740_ VDD VDD VSS VSS _4071_/D _2822_/B _2740_/C _2740_/D _2741_/C gf180mcu_as_sc_mcu7t3v3__ao211_2
XFILLER_9_842 VDD VDD VSS VSS gf180mcu_as_sc_mcu7t3v3__fillcap_4
XFILLER_173_835 VDD VDD VSS VSS gf180mcu_as_sc_mcu7t3v3__fillcap_4
X_2671_ VDD VDD VSS VSS _2671_/Y _2772_/D _4122_/D gf180mcu_as_sc_mcu7t3v3__nor2_2
X_4410_ VDD VDD VSS VSS _4445_/CLK _4410_/D _4410_/Q gf180mcu_as_sc_mcu7t3v3__dfxtp_2
XFILLER_153_570 VDD VDD VSS VSS gf180mcu_as_sc_mcu7t3v3__fill_2
X_4341_ VDD VDD VSS VSS _4789_/CLK _4341_/D _4341_/Q gf180mcu_as_sc_mcu7t3v3__dfxtp_2
X_4272_ VDD VDD VSS VSS _4728_/D _4272_/C _4272_/B _4272_/A gf180mcu_as_sc_mcu7t3v3__aoi21_2
X_3223_ VDD VDD VSS VSS _3351_/A _4361_/Q _4390_/Q _3224_/B gf180mcu_as_sc_mcu7t3v3__mux2_2
X_3154_ VDD VDD VSS VSS _4496_/Q _4493_/Q _3155_/C gf180mcu_as_sc_mcu7t3v3__or2_2
X_3085_ VDD VDD VSS VSS _3609_/B _3559_/B _4478_/Q _4478_/D gf180mcu_as_sc_mcu7t3v3__mux2_2
XFILLER_165_1187 VDD VDD VSS VSS gf180mcu_as_sc_mcu7t3v3__fill_2
XFILLER_167_117 VDD VDD VSS VSS gf180mcu_as_sc_mcu7t3v3__fillcap_8
X_3987_ VDD VDD VSS VSS _3988_/B _3987_/A _4264_/C gf180mcu_as_sc_mcu7t3v3__and2_2
XTAP_TAPCELL_ROW_98_1_1051 VDD VSS gf180mcu_as_sc_mcu7t3v3__tap_2
XFILLER_167_139 VDD VDD VSS VSS gf180mcu_as_sc_mcu7t3v3__fill_1
X_2938_ VDD VDD VSS VSS _3016_/A _2945_/B _2945_/C _4368_/Q _4368_/D gf180mcu_as_sc_mcu7t3v3__ao22_2
XTAP_TAPCELL_ROW_112_1_1065 VDD VSS gf180mcu_as_sc_mcu7t3v3__tap_2
XFILLER_191_610 VDD VDD VSS VSS gf180mcu_as_sc_mcu7t3v3__fillcap_16
XFILLER_175_172 VDD VDD VSS VSS gf180mcu_as_sc_mcu7t3v3__fill_2
XFILLER_184_18 VDD VDD VSS VSS gf180mcu_as_sc_mcu7t3v3__fillcap_16
XFILLER_191_632 VDD VDD VSS VSS gf180mcu_as_sc_mcu7t3v3__fillcap_16
X_2869_ VDD VDD VSS VSS _4187_/A _2896_/D _2869_/C _2869_/D _2870_/B gf180mcu_as_sc_mcu7t3v3__ao211_2
X_4608_ VDD VDD VSS VSS _4831_/CLK _4608_/D _4608_/Q gf180mcu_as_sc_mcu7t3v3__dfxtp_2
XFILLER_11_1087 VDD VDD VSS VSS gf180mcu_as_sc_mcu7t3v3__fillcap_4
X_4539_ VDD VDD VSS VSS _4576_/CLK _4539_/D _4539_/Q gf180mcu_as_sc_mcu7t3v3__dfxtp_2
XFILLER_117_56 VDD VDD VSS VSS gf180mcu_as_sc_mcu7t3v3__fillcap_8
XFILLER_137_1256 VDD VDD VSS VSS gf180mcu_as_sc_mcu7t3v3__fillcap_8
XTAP_TAPCELL_ROW_6_812 VDD VSS gf180mcu_as_sc_mcu7t3v3__tap_2
XTAP_TAPCELL_ROW_6_801 VDD VSS gf180mcu_as_sc_mcu7t3v3__tap_2
XFILLER_133_88 VDD VDD VSS VSS gf180mcu_as_sc_mcu7t3v3__fill_2
Xhold1052 VDD VDD VSS VSS hold1083/Y hold1084/A gf180mcu_as_sc_mcu7t3v3__clkbuff_4
Xhold1063 VDD VDD VSS VSS hold1095/Y _4817_/D gf180mcu_as_sc_mcu7t3v3__clkbuff_4
Xhold1074 VDD VDD VSS VSS _4627_/Q _3578_/A gf180mcu_as_sc_mcu7t3v3__clkbuff_4
Xhold1085 VDD VDD VSS VSS _4553_/Q hold1085/Y gf180mcu_as_sc_mcu7t3v3__clkbuff_4
XFILLER_93_37 VDD VDD VSS VSS gf180mcu_as_sc_mcu7t3v3__fill_1
Xhold1096 VDD VDD VSS VSS _4827_/Q hold1096/Y gf180mcu_as_sc_mcu7t3v3__clkbuff_4
XFILLER_26_75 VDD VDD VSS VSS gf180mcu_as_sc_mcu7t3v3__fillcap_16
XFILLER_57_1279 VDD VDD VSS VSS gf180mcu_as_sc_mcu7t3v3__fill_2
XFILLER_167_640 VDD VDD VSS VSS gf180mcu_as_sc_mcu7t3v3__fill_2
XTAP_TAPCELL_ROW_158_1239 VDD VSS gf180mcu_as_sc_mcu7t3v3__tap_2
XFILLER_10_863 VDD VDD VSS VSS gf180mcu_as_sc_mcu7t3v3__fillcap_8
XFILLER_158_30 VDD VDD VSS VSS gf180mcu_as_sc_mcu7t3v3__fillcap_4
XFILLER_42_74 VDD VDD VSS VSS gf180mcu_as_sc_mcu7t3v3__fillcap_4
XTAP_TAPCELL_ROW_175_1564 VDD VSS gf180mcu_as_sc_mcu7t3v3__tap_2
XFILLER_10_885 VDD VDD VSS VSS gf180mcu_as_sc_mcu7t3v3__fillcap_4
XFILLER_10_896 VDD VDD VSS VSS gf180mcu_as_sc_mcu7t3v3__fillcap_16
XFILLER_6_823 VDD VDD VSS VSS gf180mcu_as_sc_mcu7t3v3__fillcap_8
XFILLER_6_845 VDD VDD VSS VSS gf180mcu_as_sc_mcu7t3v3__fillcap_16
XTAP_TAPCELL_ROW_175_1575 VDD VSS gf180mcu_as_sc_mcu7t3v3__tap_2
XFILLER_120_1260 VDD VDD VSS VSS gf180mcu_as_sc_mcu7t3v3__fill_2
XFILLER_181_142 VDD VDD VSS VSS gf180mcu_as_sc_mcu7t3v3__fillcap_16
XFILLER_120_1293 VDD VDD VSS VSS gf180mcu_as_sc_mcu7t3v3__fill_1
XFILLER_170_849 VDD VDD VSS VSS gf180mcu_as_sc_mcu7t3v3__fillcap_4
XFILLER_174_73 VDD VDD VSS VSS gf180mcu_as_sc_mcu7t3v3__fill_1
XFILLER_29_1326 VDD VDD VSS VSS gf180mcu_as_sc_mcu7t3v3__fillcap_4
XPHY_EDGE_ROW_2_Left_195 VDD VSS gf180mcu_as_sc_mcu7t3v3__tap_2
XFILLER_116_1329 VDD VDD VSS VSS gf180mcu_as_sc_mcu7t3v3__fill_1
XFILLER_95_104 VDD VDD VSS VSS gf180mcu_as_sc_mcu7t3v3__fill_1
XFILLER_3_57 VDD VDD VSS VSS gf180mcu_as_sc_mcu7t3v3__fill_1
XFILLER_3_79 VDD VDD VSS VSS gf180mcu_as_sc_mcu7t3v3__fill_1
XFILLER_7_1133 VDD VDD VSS VSS gf180mcu_as_sc_mcu7t3v3__fill_2
XFILLER_188_1154 VDD VDD VSS VSS gf180mcu_as_sc_mcu7t3v3__fill_1
XFILLER_188_1187 VDD VDD VSS VSS gf180mcu_as_sc_mcu7t3v3__fillcap_16
X_3910_ VDD VDD VSS VSS _4242_/A _3927_/C _3910_/C _3910_/D _3912_/C gf180mcu_as_sc_mcu7t3v3__ao211_2
XFILLER_189_297 VDD VDD VSS VSS gf180mcu_as_sc_mcu7t3v3__fill_1
X_3841_ VDD VDD VSS VSS _4184_/A _3867_/B _3841_/C _3867_/D _3844_/B gf180mcu_as_sc_mcu7t3v3__ao211_2
X_3772_ VDD VDD VSS VSS _3772_/D _3796_/B _3772_/B _3772_/C _3773_/D gf180mcu_as_sc_mcu7t3v3__ao31_2
X_2723_ VDD VDD VSS VSS _4056_/A _2823_/B _2723_/C _2823_/D _2725_/C gf180mcu_as_sc_mcu7t3v3__ao211_2
XFILLER_9_661 VDD VDD VSS VSS gf180mcu_as_sc_mcu7t3v3__fill_2
XFILLER_157_183 VDD VDD VSS VSS gf180mcu_as_sc_mcu7t3v3__fill_1
XFILLER_160_1095 VDD VDD VSS VSS gf180mcu_as_sc_mcu7t3v3__fillcap_4
XFILLER_173_632 VDD VDD VSS VSS gf180mcu_as_sc_mcu7t3v3__fillcap_16
XFILLER_185_492 VDD VDD VSS VSS gf180mcu_as_sc_mcu7t3v3__fill_2
XFILLER_9_683 VDD VDD VSS VSS gf180mcu_as_sc_mcu7t3v3__fillcap_4
Xoutput402 VDD VDD VSS VSS _4689_/Q south_out[32] gf180mcu_as_sc_mcu7t3v3__buff_12
X_2654_ VDD VDD VSS VSS _2654_/A _2668_/A _2654_/C _2658_/D gf180mcu_as_sc_mcu7t3v3__nand3_2
XTAP_TAPCELL_ROW_11_891 VDD VSS gf180mcu_as_sc_mcu7t3v3__tap_2
XFILLER_161_838 VDD VDD VSS VSS gf180mcu_as_sc_mcu7t3v3__fill_2
Xoutput413 VDD VDD VSS VSS _4729_/Q west_out[0] gf180mcu_as_sc_mcu7t3v3__buff_12
Xoutput424 VDD VDD VSS VSS _4730_/Q west_out[1] gf180mcu_as_sc_mcu7t3v3__buff_12
Xoutput435 VDD VDD VSS VSS _4731_/Q west_out[2] gf180mcu_as_sc_mcu7t3v3__buff_12
X_2585_ VDD VDD VSS VSS _4830_/D _2585_/B _4637_/Q _4636_/D gf180mcu_as_sc_mcu7t3v3__mux2_2
Xoutput446 VDD VDD VSS VSS _4737_/Q west_out[8] gf180mcu_as_sc_mcu7t3v3__buff_12
X_4324_ VDD VDD VSS VSS _4804_/D _4516_/Q _4801_/D gf180mcu_as_sc_mcu7t3v3__and2_2
XPHY_EDGE_ROW_139_3_Left_511 VDD VSS gf180mcu_as_sc_mcu7t3v3__tap_2
XFILLER_86_104 VDD VDD VSS VSS gf180mcu_as_sc_mcu7t3v3__fill_1
X_4255_ VDD VDD VSS VSS _4255_/B _4265_/D _4258_/C gf180mcu_as_sc_mcu7t3v3__and2_2
X_4186_ VDD VDD VSS VSS _4186_/A _4186_/B _4186_/C _4186_/D _4187_/C gf180mcu_as_sc_mcu7t3v3__ao211_2
X_3206_ VDD VDD VSS VSS _3206_/D _3206_/A _3206_/B _3206_/C _3207_/B gf180mcu_as_sc_mcu7t3v3__ao31_2
X_3137_ VDD VDD VSS VSS _3141_/B _4356_/Q _3205_/A gf180mcu_as_sc_mcu7t3v3__nand2b_2
XTAP_TAPCELL_ROW_131_3_2042 VDD VSS gf180mcu_as_sc_mcu7t3v3__tap_2
XFILLER_103_69 VDD VDD VSS VSS gf180mcu_as_sc_mcu7t3v3__fill_1
X_3068_ VDD VDD VSS VSS _3068_/S _5074_/A _4467_/Q _4467_/D gf180mcu_as_sc_mcu7t3v3__mux2_2
XFILLER_179_18 VDD VDD VSS VSS gf180mcu_as_sc_mcu7t3v3__fill_2
XFILLER_177_982 VDD VDD VSS VSS gf180mcu_as_sc_mcu7t3v3__fillcap_16
XFILLER_176_481 VDD VDD VSS VSS gf180mcu_as_sc_mcu7t3v3__fillcap_8
XFILLER_104_1288 VDD VDD VSS VSS gf180mcu_as_sc_mcu7t3v3__fill_1
XFILLER_12_88 VDD VDD VSS VSS gf180mcu_as_sc_mcu7t3v3__fill_2
XFILLER_163_153 VDD VDD VSS VSS gf180mcu_as_sc_mcu7t3v3__fill_2
XFILLER_178_1345 VDD VDD VSS VSS gf180mcu_as_sc_mcu7t3v3__fill_2
XFILLER_192_985 VDD VDD VSS VSS gf180mcu_as_sc_mcu7t3v3__fill_1
XTAP_TAPCELL_ROW_153_1158 VDD VSS gf180mcu_as_sc_mcu7t3v3__tap_2
XTAP_TAPCELL_ROW_153_1147 VDD VSS gf180mcu_as_sc_mcu7t3v3__tap_2
XFILLER_152_849 VDD VDD VSS VSS gf180mcu_as_sc_mcu7t3v3__fill_1
XFILLER_88_37 VDD VDD VSS VSS gf180mcu_as_sc_mcu7t3v3__fill_1
XTAP_TAPCELL_ROW_170_1483 VDD VSS gf180mcu_as_sc_mcu7t3v3__tap_2
XTAP_TAPCELL_ROW_170_1472 VDD VSS gf180mcu_as_sc_mcu7t3v3__tap_2
XPHY_EDGE_ROW_123_3_Left_495 VDD VSS gf180mcu_as_sc_mcu7t3v3__tap_2
XFILLER_77_104 VDD VDD VSS VSS gf180mcu_as_sc_mcu7t3v3__fill_1
Xfanout640 VDD VDD VSS VSS _4225_/D _4216_/A gf180mcu_as_sc_mcu7t3v3__buff_12
Xfanout651 VDD VDD VSS VSS fanout652/A _3926_/B gf180mcu_as_sc_mcu7t3v3__buff_12
XFILLER_63_1272 VDD VDD VSS VSS gf180mcu_as_sc_mcu7t3v3__fill_1
Xfanout662 VDD VDD VSS VSS _3964_/C _3870_/A gf180mcu_as_sc_mcu7t3v3__buff_12
Xfanout673 VDD VDD VSS VSS fanout674/Y _2892_/B gf180mcu_as_sc_mcu7t3v3__buff_12
Xfanout684 VDD VDD VSS VSS _3614_/Y _3869_/B gf180mcu_as_sc_mcu7t3v3__buff_12
XPHY_EDGE_ROW_60_3_Left_432 VDD VSS gf180mcu_as_sc_mcu7t3v3__tap_2
XFILLER_24_1256 VDD VDD VSS VSS gf180mcu_as_sc_mcu7t3v3__fillcap_16
XFILLER_187_713 VDD VDD VSS VSS gf180mcu_as_sc_mcu7t3v3__fillcap_16
XFILLER_187_735 VDD VDD VSS VSS gf180mcu_as_sc_mcu7t3v3__fill_1
XTAP_TAPCELL_ROW_66_3_1977 VDD VSS gf180mcu_as_sc_mcu7t3v3__tap_2
XTAP_TAPCELL_ROW_177_1615 VDD VSS gf180mcu_as_sc_mcu7t3v3__tap_2
XTAP_TAPCELL_ROW_177_1604 VDD VSS gf180mcu_as_sc_mcu7t3v3__tap_2
XFILLER_186_223 VDD VDD VSS VSS gf180mcu_as_sc_mcu7t3v3__fillcap_8
XFILLER_174_407 VDD VDD VSS VSS gf180mcu_as_sc_mcu7t3v3__fill_2
XFILLER_10_660 VDD VDD VSS VSS gf180mcu_as_sc_mcu7t3v3__fillcap_4
XFILLER_167_470 VDD VDD VSS VSS gf180mcu_as_sc_mcu7t3v3__fillcap_16
XFILLER_167_492 VDD VDD VSS VSS gf180mcu_as_sc_mcu7t3v3__fillcap_8
XFILLER_183_941 VDD VDD VSS VSS gf180mcu_as_sc_mcu7t3v3__fillcap_16
XTAP_TAPCELL_ROW_190_1859 VDD VSS gf180mcu_as_sc_mcu7t3v3__tap_2
XTAP_TAPCELL_ROW_190_1848 VDD VSS gf180mcu_as_sc_mcu7t3v3__tap_2
XFILLER_170_624 VDD VDD VSS VSS gf180mcu_as_sc_mcu7t3v3__fillcap_8
XFILLER_185_72 VDD VDD VSS VSS gf180mcu_as_sc_mcu7t3v3__fillcap_4
XFILLER_2_870 VDD VDD VSS VSS gf180mcu_as_sc_mcu7t3v3__fillcap_4
X_2370_ VDD VDD VSS VSS _2371_/D _3587_/A _4599_/Q gf180mcu_as_sc_mcu7t3v3__nor2_2
XFILLER_42_1301 VDD VDD VSS VSS gf180mcu_as_sc_mcu7t3v3__fill_1
X_4040_ VDD VDD VSS VSS _4040_/A _4153_/B _4040_/C _4040_/D _4041_/C gf180mcu_as_sc_mcu7t3v3__ao211_2
Xclkbuf_leaf_23_clk_regs VDD VDD VSS VSS clkload2/A _4820_/CLK gf180mcu_as_sc_mcu7t3v3__clkbuff_12
XFILLER_177_212 VDD VDD VSS VSS gf180mcu_as_sc_mcu7t3v3__fillcap_8
XFILLER_162_1157 VDD VDD VSS VSS gf180mcu_as_sc_mcu7t3v3__fillcap_16
XFILLER_178_757 VDD VDD VSS VSS gf180mcu_as_sc_mcu7t3v3__fillcap_4
XFILLER_159_982 VDD VDD VSS VSS gf180mcu_as_sc_mcu7t3v3__fill_1
X_3824_ VDD VDD VSS VSS _4792_/Q _3869_/B _3824_/C _3824_/D _3825_/C gf180mcu_as_sc_mcu7t3v3__ao22_2
X_3755_ VDD VDD VSS VSS _4104_/D _3881_/B _3755_/C _3755_/D _3756_/C gf180mcu_as_sc_mcu7t3v3__ao211_2
XFILLER_174_963 VDD VDD VSS VSS gf180mcu_as_sc_mcu7t3v3__fillcap_16
X_3686_ VDD VDD VSS VSS _3916_/B _4044_/D _3687_/C gf180mcu_as_sc_mcu7t3v3__and2_2
X_2706_ VDD VDD VSS VSS _2879_/B _4041_/A _2707_/D gf180mcu_as_sc_mcu7t3v3__or2_2
X_2637_ VDD VDD VSS VSS _2668_/B _2638_/C _2659_/B _2638_/A gf180mcu_as_sc_mcu7t3v3__aoi21_2
XPHY_EDGE_ROW_12_Right_12 VDD VSS gf180mcu_as_sc_mcu7t3v3__tap_2
XFILLER_160_134 VDD VDD VSS VSS gf180mcu_as_sc_mcu7t3v3__fillcap_8
XFILLER_86_1272 VDD VDD VSS VSS gf180mcu_as_sc_mcu7t3v3__fillcap_16
XTAP_TAPCELL_ROW_107_1_1060 VDD VSS gf180mcu_as_sc_mcu7t3v3__tap_2
X_2568_ VDD VDD VSS VSS _4808_/D _2568_/C _3081_/A _3609_/B gf180mcu_as_sc_mcu7t3v3__aoi21_2
X_4307_ VDD VDD VSS VSS _4310_/B _4531_/Q _4784_/D gf180mcu_as_sc_mcu7t3v3__and2_2
X_2499_ VDD VDD VSS VSS _4806_/Q _2499_/B _2499_/A _5074_/A gf180mcu_as_sc_mcu7t3v3__mux2_2
X_4238_ VDD VDD VSS VSS _4238_/S _4238_/B _4238_/A _4239_/B gf180mcu_as_sc_mcu7t3v3__mux2_2
XFILLER_114_79 VDD VDD VSS VSS gf180mcu_as_sc_mcu7t3v3__fill_1
X_4169_ VDD VDD VSS VSS _4169_/A _4210_/B _4236_/C _4169_/D _4170_/D gf180mcu_as_sc_mcu7t3v3__ao22_2
XFILLER_130_34 VDD VDD VSS VSS gf180mcu_as_sc_mcu7t3v3__fill_1
XFILLER_167_1068 VDD VDD VSS VSS gf180mcu_as_sc_mcu7t3v3__fillcap_16
XFILLER_169_702 VDD VDD VSS VSS gf180mcu_as_sc_mcu7t3v3__fillcap_16
XFILLER_12_947 VDD VDD VSS VSS gf180mcu_as_sc_mcu7t3v3__fillcap_8
XFILLER_169_768 VDD VDD VSS VSS gf180mcu_as_sc_mcu7t3v3__fill_2
XFILLER_180_1224 VDD VDD VSS VSS gf180mcu_as_sc_mcu7t3v3__fill_1
XFILLER_93_1276 VDD VDD VSS VSS gf180mcu_as_sc_mcu7t3v3__fill_2
XFILLER_180_1279 VDD VDD VSS VSS gf180mcu_as_sc_mcu7t3v3__fillcap_16
XFILLER_8_918 VDD VDD VSS VSS gf180mcu_as_sc_mcu7t3v3__fill_1
XFILLER_23_76 VDD VDD VSS VSS gf180mcu_as_sc_mcu7t3v3__fill_2
XTAP_TAPCELL_ROW_172_1512 VDD VSS gf180mcu_as_sc_mcu7t3v3__tap_2
XTAP_TAPCELL_ROW_172_1523 VDD VSS gf180mcu_as_sc_mcu7t3v3__tap_2
XFILLER_180_933 VDD VDD VSS VSS gf180mcu_as_sc_mcu7t3v3__fill_1
XFILLER_30_1260 VDD VDD VSS VSS gf180mcu_as_sc_mcu7t3v3__fill_2
XFILLER_152_657 VDD VDD VSS VSS gf180mcu_as_sc_mcu7t3v3__fill_1
XFILLER_155_20 VDD VDD VSS VSS gf180mcu_as_sc_mcu7t3v3__fill_1
XFILLER_174_1017 VDD VDD VSS VSS gf180mcu_as_sc_mcu7t3v3__fillcap_16
XFILLER_180_966 VDD VDD VSS VSS gf180mcu_as_sc_mcu7t3v3__fillcap_8
XFILLER_191_292 VDD VDD VSS VSS gf180mcu_as_sc_mcu7t3v3__fill_1
XFILLER_30_1293 VDD VDD VSS VSS gf180mcu_as_sc_mcu7t3v3__fill_1
XFILLER_3_2 VDD VDD VSS VSS gf180mcu_as_sc_mcu7t3v3__fillcap_16
XFILLER_2_199 VDD VDD VSS VSS gf180mcu_as_sc_mcu7t3v3__fill_2
XFILLER_48_84 VDD VDD VSS VSS gf180mcu_as_sc_mcu7t3v3__fillcap_16
Xfanout470 VDD VDD VSS VSS _2976_/Y _3004_/B gf180mcu_as_sc_mcu7t3v3__buff_12
Xfanout481 VDD VDD VSS VSS _3038_/B _3034_/B gf180mcu_as_sc_mcu7t3v3__buff_12
Xfanout492 VDD VDD VSS VSS _4204_/B _4230_/B gf180mcu_as_sc_mcu7t3v3__buff_12
XFILLER_171_85 VDD VDD VSS VSS gf180mcu_as_sc_mcu7t3v3__fillcap_4
XFILLER_0_36 VDD VDD VSS VSS gf180mcu_as_sc_mcu7t3v3__fillcap_4
XFILLER_185_1135 VDD VDD VSS VSS gf180mcu_as_sc_mcu7t3v3__fillcap_16
XFILLER_64_61 VDD VDD VSS VSS gf180mcu_as_sc_mcu7t3v3__fillcap_4
XFILLER_159_212 VDD VDD VSS VSS gf180mcu_as_sc_mcu7t3v3__fillcap_4
XTAP_TAPCELL_ROW_13_953 VDD VSS gf180mcu_as_sc_mcu7t3v3__tap_2
XTAP_TAPCELL_ROW_13_942 VDD VSS gf180mcu_as_sc_mcu7t3v3__tap_2
XTAP_TAPCELL_ROW_13_931 VDD VSS gf180mcu_as_sc_mcu7t3v3__tap_2
XTAP_TAPCELL_ROW_14_3_1925 VDD VSS gf180mcu_as_sc_mcu7t3v3__tap_2
XTAP_TAPCELL_ROW_13_964 VDD VSS gf180mcu_as_sc_mcu7t3v3__tap_2
X_3540_ VDD VDD VSS VSS _3540_/S _3540_/B _3540_/A _4615_/D gf180mcu_as_sc_mcu7t3v3__mux2_2
XPHY_EDGE_ROW_30_1_Right_539 VDD VSS gf180mcu_as_sc_mcu7t3v3__tap_2
XFILLER_157_1215 VDD VDD VSS VSS gf180mcu_as_sc_mcu7t3v3__fill_2
Xmax_cap615 VDD VDD VSS VSS _4133_/B _4184_/B gf180mcu_as_sc_mcu7t3v3__clkbuff_12
XFILLER_192_1128 VDD VDD VSS VSS gf180mcu_as_sc_mcu7t3v3__fill_2
X_3471_ VDD VDD VSS VSS _3471_/D _3609_/B _3471_/B _3471_/C _3480_/B gf180mcu_as_sc_mcu7t3v3__ao31_2
XFILLER_157_1259 VDD VDD VSS VSS gf180mcu_as_sc_mcu7t3v3__fill_1
X_2422_ VDD VDD VSS VSS _4551_/Q _3602_/B _2426_/C _2422_/D _2424_/C gf180mcu_as_sc_mcu7t3v3__ao211_2
X_2353_ VDD VDD VSS VSS _2356_/B _2353_/B _2411_/S gf180mcu_as_sc_mcu7t3v3__nand2_2
X_5072_ VDD VDD VSS VSS _5072_/A _5072_/Y gf180mcu_as_sc_mcu7t3v3__buff_2
X_4023_ VDD VDD VSS VSS _4023_/A _4218_/B _4225_/B _4023_/D _4024_/D gf180mcu_as_sc_mcu7t3v3__ao22_2
X_2284_ VDD VDD VSS VSS _3568_/A _2552_/A _2287_/C gf180mcu_as_sc_mcu7t3v3__or2_2
XFILLER_100_37 VDD VDD VSS VSS gf180mcu_as_sc_mcu7t3v3__fill_2
X_3807_ VDD VDD VSS VSS _3809_/C _4152_/A _3871_/C _3807_/C gf180mcu_as_sc_mcu7t3v3__ao21_2
X_4787_ VDD VDD VSS VSS clkload7/A _4787_/D _4787_/Q gf180mcu_as_sc_mcu7t3v3__dfxtp_2
XPHY_EDGE_ROW_19_1_Left_211 VDD VSS gf180mcu_as_sc_mcu7t3v3__tap_2
XFILLER_10_1119 VDD VDD VSS VSS gf180mcu_as_sc_mcu7t3v3__fillcap_4
XFILLER_180_207 VDD VDD VSS VSS gf180mcu_as_sc_mcu7t3v3__fillcap_8
X_3738_ VDD VDD VSS VSS _3747_/S _3738_/B _4090_/A _3739_/B gf180mcu_as_sc_mcu7t3v3__mux2_2
XFILLER_49_1318 VDD VDD VSS VSS gf180mcu_as_sc_mcu7t3v3__fillcap_4
X_3669_ VDD VDD VSS VSS _4031_/D _3876_/B _3669_/C _3876_/D _3672_/B gf180mcu_as_sc_mcu7t3v3__ao211_2
XFILLER_161_454 VDD VDD VSS VSS gf180mcu_as_sc_mcu7t3v3__fillcap_16
XFILLER_192_18 VDD VDD VSS VSS gf180mcu_as_sc_mcu7t3v3__fillcap_16
XTAP_TAPCELL_ROW_118_3_2029 VDD VSS gf180mcu_as_sc_mcu7t3v3__tap_2
XFILLER_125_45 VDD VDD VSS VSS gf180mcu_as_sc_mcu7t3v3__fillcap_16
XFILLER_125_89 VDD VDD VSS VSS gf180mcu_as_sc_mcu7t3v3__fill_2
XFILLER_112_1321 VDD VDD VSS VSS gf180mcu_as_sc_mcu7t3v3__fill_2
XFILLER_169_1119 VDD VDD VSS VSS gf180mcu_as_sc_mcu7t3v3__fill_1
XFILLER_141_44 VDD VDD VSS VSS gf180mcu_as_sc_mcu7t3v3__fillcap_16
XTAP_TAPCELL_ROW_165_1382 VDD VSS gf180mcu_as_sc_mcu7t3v3__tap_2
XFILLER_169_543 VDD VDD VSS VSS gf180mcu_as_sc_mcu7t3v3__fillcap_16
XFILLER_34_53 VDD VDD VSS VSS gf180mcu_as_sc_mcu7t3v3__fillcap_8
XFILLER_140_2 VDD VDD VSS VSS gf180mcu_as_sc_mcu7t3v3__fillcap_16
XFILLER_34_86 VDD VDD VSS VSS gf180mcu_as_sc_mcu7t3v3__fillcap_4
XFILLER_34_97 VDD VDD VSS VSS gf180mcu_as_sc_mcu7t3v3__fillcap_8
XFILLER_12_788 VDD VDD VSS VSS gf180mcu_as_sc_mcu7t3v3__fillcap_16
XFILLER_157_749 VDD VDD VSS VSS gf180mcu_as_sc_mcu7t3v3__fillcap_16
XFILLER_180_1087 VDD VDD VSS VSS gf180mcu_as_sc_mcu7t3v3__fillcap_16
XFILLER_184_513 VDD VDD VSS VSS gf180mcu_as_sc_mcu7t3v3__fill_1
XFILLER_8_737 VDD VDD VSS VSS gf180mcu_as_sc_mcu7t3v3__fillcap_16
XFILLER_166_41 VDD VDD VSS VSS gf180mcu_as_sc_mcu7t3v3__fill_2
XFILLER_124_101 VDD VDD VSS VSS gf180mcu_as_sc_mcu7t3v3__fillcap_4
XFILLER_152_410 VDD VDD VSS VSS gf180mcu_as_sc_mcu7t3v3__fillcap_16
XFILLER_153_944 VDD VDD VSS VSS gf180mcu_as_sc_mcu7t3v3__fillcap_16
XFILLER_152_454 VDD VDD VSS VSS gf180mcu_as_sc_mcu7t3v3__fillcap_16
XFILLER_153_977 VDD VDD VSS VSS gf180mcu_as_sc_mcu7t3v3__fill_2
XFILLER_3_475 VDD VDD VSS VSS gf180mcu_as_sc_mcu7t3v3__fill_2
XFILLER_156_1292 VDD VDD VSS VSS gf180mcu_as_sc_mcu7t3v3__fill_2
XFILLER_59_83 VDD VDD VSS VSS gf180mcu_as_sc_mcu7t3v3__fillcap_16
XFILLER_117_1276 VDD VDD VSS VSS gf180mcu_as_sc_mcu7t3v3__fill_1
XTAP_TAPCELL_ROW_185_1769 VDD VSS gf180mcu_as_sc_mcu7t3v3__tap_2
XTAP_TAPCELL_ROW_185_1758 VDD VSS gf180mcu_as_sc_mcu7t3v3__tap_2
XFILLER_187_1219 VDD VDD VSS VSS gf180mcu_as_sc_mcu7t3v3__fillcap_16
XFILLER_8_1080 VDD VDD VSS VSS gf180mcu_as_sc_mcu7t3v3__fillcap_4
XPHY_EDGE_ROW_20_3_Right_61 VDD VSS gf180mcu_as_sc_mcu7t3v3__tap_2
XFILLER_75_60 VDD VDD VSS VSS gf180mcu_as_sc_mcu7t3v3__fillcap_8
XPHY_EDGE_ROW_147_1_Left_339 VDD VSS gf180mcu_as_sc_mcu7t3v3__tap_2
X_2971_ VDD VDD VSS VSS _4387_/Q _2975_/B _3035_/A _2975_/D _4387_/D gf180mcu_as_sc_mcu7t3v3__ao22_2
XPHY_EDGE_ROW_148_3_Left_520 VDD VSS gf180mcu_as_sc_mcu7t3v3__tap_2
XFILLER_188_874 VDD VDD VSS VSS gf180mcu_as_sc_mcu7t3v3__fill_1
X_4710_ VDD VDD VSS VSS _4727_/CLK _4710_/D _4710_/Q gf180mcu_as_sc_mcu7t3v3__dfxtp_2
X_4641_ VDD VDD VSS VSS _4808_/CLK _4641_/D _4641_/Q gf180mcu_as_sc_mcu7t3v3__dfxtp_2
XFILLER_175_557 VDD VDD VSS VSS gf180mcu_as_sc_mcu7t3v3__fill_2
X_4572_ VDD VDD VSS VSS _4728_/CLK _4572_/D _4572_/Q gf180mcu_as_sc_mcu7t3v3__dfxtp_2
XFILLER_155_270 VDD VDD VSS VSS gf180mcu_as_sc_mcu7t3v3__fillcap_8
XFILLER_190_538 VDD VDD VSS VSS gf180mcu_as_sc_mcu7t3v3__fillcap_16
X_3523_ VDD VDD VSS VSS _3529_/S _4609_/Q _3523_/A _4609_/D gf180mcu_as_sc_mcu7t3v3__mux2_2
XFILLER_171_752 VDD VDD VSS VSS gf180mcu_as_sc_mcu7t3v3__fillcap_16
X_3454_ VDD VDD VSS VSS _3520_/S _4474_/Q _3454_/A _4577_/D gf180mcu_as_sc_mcu7t3v3__mux2_2
XFILLER_100_1291 VDD VDD VSS VSS gf180mcu_as_sc_mcu7t3v3__fillcap_4
XFILLER_130_104 VDD VDD VSS VSS gf180mcu_as_sc_mcu7t3v3__fill_1
XFILLER_171_796 VDD VDD VSS VSS gf180mcu_as_sc_mcu7t3v3__fillcap_16
X_2405_ VDD VDD VSS VSS _2406_/C _2405_/C _2405_/B _2405_/A gf180mcu_as_sc_mcu7t3v3__aoi21_2
XFILLER_170_1223 VDD VDD VSS VSS gf180mcu_as_sc_mcu7t3v3__fill_2
XFILLER_83_1264 VDD VDD VSS VSS gf180mcu_as_sc_mcu7t3v3__fillcap_4
X_3385_ VDD VDD VSS VSS _3386_/C _3385_/C _4410_/Q _3408_/A gf180mcu_as_sc_mcu7t3v3__aoi21b_2
X_2336_ VDD VDD VSS VSS _3128_/A _4580_/Q _2337_/B gf180mcu_as_sc_mcu7t3v3__or2_2
X_2267_ VDD VDD VSS VSS _2267_/D _4292_/C _3580_/A _2267_/C _2269_/C gf180mcu_as_sc_mcu7t3v3__ao31_2
X_4006_ VDD VDD VSS VSS _4260_/D _4006_/B _4259_/D gf180mcu_as_sc_mcu7t3v3__nand2_2
XFILLER_168_1152 VDD VDD VSS VSS gf180mcu_as_sc_mcu7t3v3__fill_2
X_2198_ VDD VDD VSS VSS _3478_/A _4583_/Q gf180mcu_as_sc_mcu7t3v3__inv_2
XTAP_TAPCELL_ROW_160_1290 VDD VSS gf180mcu_as_sc_mcu7t3v3__tap_2
XFILLER_181_1352 VDD VDD VSS VSS gf180mcu_as_sc_mcu7t3v3__fill_2
XFILLER_187_18 VDD VDD VSS VSS gf180mcu_as_sc_mcu7t3v3__fillcap_16
Xclkbuf_3_4__f_clk_regs VDD VDD VSS VSS clkbuf_2_2_0_clk_regs/Y clkbuf_3_4__f_clk_regs/Y
+ gf180mcu_as_sc_mcu7t3v3__clkbuff_12
XFILLER_16_1328 VDD VDD VSS VSS gf180mcu_as_sc_mcu7t3v3__fill_2
XPHY_EDGE_ROW_159_Right_21 VDD VSS gf180mcu_as_sc_mcu7t3v3__tap_2
XFILLER_5_718 VDD VDD VSS VSS gf180mcu_as_sc_mcu7t3v3__fill_2
XFILLER_136_66 VDD VDD VSS VSS gf180mcu_as_sc_mcu7t3v3__fill_1
XFILLER_171_1009 VDD VDD VSS VSS gf180mcu_as_sc_mcu7t3v3__fillcap_4
XFILLER_175_1178 VDD VDD VSS VSS gf180mcu_as_sc_mcu7t3v3__fillcap_8
Xinput302 VDD VDD VSS VSS west_in[14] _4118_/A gf180mcu_as_sc_mcu7t3v3__buff_12
XTAP_TAPCELL_ROW_167_1411 VDD VSS gf180mcu_as_sc_mcu7t3v3__tap_2
XFILLER_96_37 VDD VDD VSS VSS gf180mcu_as_sc_mcu7t3v3__fillcap_4
Xinput313 VDD VDD VSS VSS west_in[24] _4199_/A gf180mcu_as_sc_mcu7t3v3__buff_12
Xinput324 VDD VDD VSS VSS west_in[34] _3961_/A gf180mcu_as_sc_mcu7t3v3__buff_12
XTAP_TAPCELL_ROW_167_1422 VDD VSS gf180mcu_as_sc_mcu7t3v3__tap_2
XPHY_EDGE_ROW_168_Right_30 VDD VSS gf180mcu_as_sc_mcu7t3v3__tap_2
XFILLER_188_2 VDD VDD VSS VSS gf180mcu_as_sc_mcu7t3v3__fillcap_16
XTAP_TAPCELL_ROW_149_1_1102 VDD VSS gf180mcu_as_sc_mcu7t3v3__tap_2
XTAP_TAPCELL_ROW_4_773 VDD VSS gf180mcu_as_sc_mcu7t3v3__tap_2
XTAP_TAPCELL_ROW_4_762 VDD VSS gf180mcu_as_sc_mcu7t3v3__tap_2
XTAP_TAPCELL_ROW_180_1666 VDD VSS gf180mcu_as_sc_mcu7t3v3__tap_2
XFILLER_182_1116 VDD VDD VSS VSS gf180mcu_as_sc_mcu7t3v3__fill_1
XFILLER_182_1127 VDD VDD VSS VSS gf180mcu_as_sc_mcu7t3v3__fill_1
XFILLER_182_1149 VDD VDD VSS VSS gf180mcu_as_sc_mcu7t3v3__fill_1
XTAP_TAPCELL_ROW_130_1_1083 VDD VSS gf180mcu_as_sc_mcu7t3v3__tap_2
XFILLER_101_80 VDD VDD VSS VSS gf180mcu_as_sc_mcu7t3v3__fillcap_4
XFILLER_184_310 VDD VDD VSS VSS gf180mcu_as_sc_mcu7t3v3__fillcap_4
XFILLER_172_527 VDD VDD VSS VSS gf180mcu_as_sc_mcu7t3v3__fill_2
XFILLER_184_387 VDD VDD VSS VSS gf180mcu_as_sc_mcu7t3v3__fillcap_16
XANTENNA_6 VDD VDD VSS VSS _4707_/D gf180mcu_as_sc_mcu7t3v3__diode_2
XFILLER_152_240 VDD VDD VSS VSS gf180mcu_as_sc_mcu7t3v3__fillcap_16
XFILLER_180_560 VDD VDD VSS VSS gf180mcu_as_sc_mcu7t3v3__fillcap_4
XFILLER_4_762 VDD VDD VSS VSS gf180mcu_as_sc_mcu7t3v3__fill_1
XFILLER_6_79 VDD VDD VSS VSS gf180mcu_as_sc_mcu7t3v3__fill_1
XFILLER_112_104 VDD VDD VSS VSS gf180mcu_as_sc_mcu7t3v3__fill_1
XFILLER_154_1207 VDD VDD VSS VSS gf180mcu_as_sc_mcu7t3v3__fillcap_4
XFILLER_6_1017 VDD VDD VSS VSS gf180mcu_as_sc_mcu7t3v3__fillcap_8
Xmesh_tile_917 VDD VDD VSS VSS nw_out[17] gf180mcu_as_sc_mcu7t3v3__tiel_4
Xmesh_tile_906 VDD VDD VSS VSS nw_out[6] gf180mcu_as_sc_mcu7t3v3__tiel_4
X_3170_ VDD VDD VSS VSS _3205_/A _4386_/Q _4415_/Q _3171_/B gf180mcu_as_sc_mcu7t3v3__mux2_2
Xmesh_tile_939 VDD VDD VSS VSS se_out[3] gf180mcu_as_sc_mcu7t3v3__tiel_4
Xmesh_tile_928 VDD VDD VSS VSS nw_out[28] gf180mcu_as_sc_mcu7t3v3__tiel_4
XFILLER_187_1049 VDD VDD VSS VSS gf180mcu_as_sc_mcu7t3v3__fill_1
XFILLER_176_800 VDD VDD VSS VSS gf180mcu_as_sc_mcu7t3v3__fill_1
XFILLER_188_671 VDD VDD VSS VSS gf180mcu_as_sc_mcu7t3v3__fill_1
X_2954_ VDD VDD VSS VSS _2995_/A _2966_/A _3026_/A gf180mcu_as_sc_mcu7t3v3__and2_2
XFILLER_176_877 VDD VDD VSS VSS gf180mcu_as_sc_mcu7t3v3__fillcap_4
X_2885_ VDD VDD VSS VSS _4200_/D _2892_/C _2885_/C _2885_/D _2886_/D gf180mcu_as_sc_mcu7t3v3__ao211_2
X_4624_ VDD VDD VSS VSS _4820_/CLK _4624_/D _4624_/Q gf180mcu_as_sc_mcu7t3v3__dfxtp_2
XPHY_EDGE_ROW_6_Right_6 VDD VSS gf180mcu_as_sc_mcu7t3v3__tap_2
XFILLER_156_590 VDD VDD VSS VSS gf180mcu_as_sc_mcu7t3v3__fillcap_4
XFILLER_190_313 VDD VDD VSS VSS gf180mcu_as_sc_mcu7t3v3__fill_2
X_4555_ VDD VDD VSS VSS _4719_/CLK _4555_/D _4555_/Q gf180mcu_as_sc_mcu7t3v3__dfxtp_2
XFILLER_85_1326 VDD VDD VSS VSS gf180mcu_as_sc_mcu7t3v3__fillcap_4
X_3506_ VDD VDD VSS VSS _4457_/Q _3553_/B _3506_/C _4603_/Q _3507_/D gf180mcu_as_sc_mcu7t3v3__ao22_2
XFILLER_103_104 VDD VDD VSS VSS gf180mcu_as_sc_mcu7t3v3__fill_1
X_4486_ VDD VDD VSS VSS _4720_/CLK _4486_/D _4486_/Q gf180mcu_as_sc_mcu7t3v3__dfxtp_2
X_3437_ VDD VDD VSS VSS _4566_/Q _3439_/B _3439_/C _4565_/Q _4565_/D gf180mcu_as_sc_mcu7t3v3__ao22_2
X_3368_ VDD VDD VSS VSS _3368_/S _4379_/Q _4408_/Q _3369_/B gf180mcu_as_sc_mcu7t3v3__mux2_2
X_2319_ VDD VDD VSS VSS _3142_/A _2319_/B _3558_/A gf180mcu_as_sc_mcu7t3v3__nor2_2
X_3299_ VDD VDD VSS VSS _4528_/Q _3315_/B _3315_/C _4529_/Q _3300_/C gf180mcu_as_sc_mcu7t3v3__ao22_2
XTAP_TAPCELL_ROW_1_710 VDD VSS gf180mcu_as_sc_mcu7t3v3__tap_2
XTAP_TAPCELL_ROW_162_1330 VDD VSS gf180mcu_as_sc_mcu7t3v3__tap_2
XFILLER_122_57 VDD VDD VSS VSS gf180mcu_as_sc_mcu7t3v3__fill_1
XFILLER_122_68 VDD VDD VSS VSS gf180mcu_as_sc_mcu7t3v3__fillcap_16
XFILLER_0_1183 VDD VDD VSS VSS gf180mcu_as_sc_mcu7t3v3__fillcap_4
XFILLER_13_338 VDD VDD VSS VSS gf180mcu_as_sc_mcu7t3v3__fill_2
XFILLER_146_1291 VDD VDD VSS VSS gf180mcu_as_sc_mcu7t3v3__fillcap_8
XFILLER_15_88 VDD VDD VSS VSS gf180mcu_as_sc_mcu7t3v3__fillcap_16
XFILLER_167_822 VDD VDD VSS VSS gf180mcu_as_sc_mcu7t3v3__fillcap_8
XFILLER_179_693 VDD VDD VSS VSS gf180mcu_as_sc_mcu7t3v3__fillcap_4
XFILLER_154_516 VDD VDD VSS VSS gf180mcu_as_sc_mcu7t3v3__fillcap_8
XFILLER_167_899 VDD VDD VSS VSS gf180mcu_as_sc_mcu7t3v3__fill_1
XFILLER_181_302 VDD VDD VSS VSS gf180mcu_as_sc_mcu7t3v3__fill_2
XFILLER_166_387 VDD VDD VSS VSS gf180mcu_as_sc_mcu7t3v3__fillcap_8
XFILLER_31_54 VDD VDD VSS VSS gf180mcu_as_sc_mcu7t3v3__fillcap_16
XFILLER_181_368 VDD VDD VSS VSS gf180mcu_as_sc_mcu7t3v3__fillcap_8
XTAP_TAPCELL_ROW_9_865 VDD VSS gf180mcu_as_sc_mcu7t3v3__tap_2
XTAP_TAPCELL_ROW_9_854 VDD VSS gf180mcu_as_sc_mcu7t3v3__tap_2
XFILLER_153_1262 VDD VDD VSS VSS gf180mcu_as_sc_mcu7t3v3__fillcap_16
Xinput110 VDD VDD VSS VSS ne_in[4] _4039_/A gf180mcu_as_sc_mcu7t3v3__buff_12
Xinput121 VDD VDD VSS VSS north_in[14] _4117_/D gf180mcu_as_sc_mcu7t3v3__buff_12
Xinput132 VDD VDD VSS VSS north_in[24] _4200_/D gf180mcu_as_sc_mcu7t3v3__buff_12
Xinput143 VDD VDD VSS VSS north_in[34] _3963_/C gf180mcu_as_sc_mcu7t3v3__buff_12
Xinput154 VDD VDD VSS VSS nw_in[11] _4096_/A gf180mcu_as_sc_mcu7t3v3__buff_12
XTAP_TAPCELL_ROW_182_1706 VDD VSS gf180mcu_as_sc_mcu7t3v3__tap_2
Xinput165 VDD VDD VSS VSS nw_in[21] _4178_/A gf180mcu_as_sc_mcu7t3v3__buff_12
Xinput176 VDD VDD VSS VSS nw_in[31] wire808/A gf180mcu_as_sc_mcu7t3v3__buff_12
Xinput187 VDD VDD VSS VSS nw_in[9] _4080_/A gf180mcu_as_sc_mcu7t3v3__buff_12
Xinput198 VDD VDD VSS VSS se_in[18] _4154_/B gf180mcu_as_sc_mcu7t3v3__buff_12
XFILLER_56_95 VDD VDD VSS VSS gf180mcu_as_sc_mcu7t3v3__fillcap_8
XFILLER_176_118 VDD VDD VSS VSS gf180mcu_as_sc_mcu7t3v3__fillcap_16
XFILLER_72_72 VDD VDD VSS VSS gf180mcu_as_sc_mcu7t3v3__fillcap_4
XFILLER_157_343 VDD VDD VSS VSS gf180mcu_as_sc_mcu7t3v3__fillcap_4
XFILLER_158_855 VDD VDD VSS VSS gf180mcu_as_sc_mcu7t3v3__fillcap_16
XFILLER_188_72 VDD VDD VSS VSS gf180mcu_as_sc_mcu7t3v3__fill_2
XPHY_EDGE_ROW_167_Left_359 VDD VSS gf180mcu_as_sc_mcu7t3v3__tap_2
XFILLER_158_877 VDD VDD VSS VSS gf180mcu_as_sc_mcu7t3v3__fillcap_4
XFILLER_8_342 VDD VDD VSS VSS gf180mcu_as_sc_mcu7t3v3__fillcap_4
X_2670_ VDD VDD VSS VSS _4010_/A _2905_/B _2670_/C _2670_/D _2978_/A gf180mcu_as_sc_mcu7t3v3__ao211_2
XFILLER_172_313 VDD VDD VSS VSS gf180mcu_as_sc_mcu7t3v3__fill_2
XFILLER_185_696 VDD VDD VSS VSS gf180mcu_as_sc_mcu7t3v3__fillcap_4
XFILLER_160_508 VDD VDD VSS VSS gf180mcu_as_sc_mcu7t3v3__fillcap_4
XFILLER_172_357 VDD VDD VSS VSS gf180mcu_as_sc_mcu7t3v3__fill_1
XFILLER_181_891 VDD VDD VSS VSS gf180mcu_as_sc_mcu7t3v3__fill_2
X_4340_ VDD VDD VSS VSS _4533_/CLK _4340_/D _4340_/Q gf180mcu_as_sc_mcu7t3v3__dfxtp_2
X_4271_ VDD VDD VSS VSS _4271_/B _4271_/A _4724_/D gf180mcu_as_sc_mcu7t3v3__and2_2
XFILLER_171_1340 VDD VDD VSS VSS gf180mcu_as_sc_mcu7t3v3__fillcap_4
X_3222_ VDD VDD VSS VSS _3225_/C _4419_/Q _3351_/A gf180mcu_as_sc_mcu7t3v3__nand2_2
XTAP_TAPCELL_ROW_56_1_1009 VDD VSS gf180mcu_as_sc_mcu7t3v3__tap_2
XPHY_EDGE_ROW_176_Left_368 VDD VSS gf180mcu_as_sc_mcu7t3v3__tap_2
XFILLER_132_1313 VDD VDD VSS VSS gf180mcu_as_sc_mcu7t3v3__fill_1
XFILLER_80_1256 VDD VDD VSS VSS gf180mcu_as_sc_mcu7t3v3__fillcap_16
X_3153_ VDD VDD VSS VSS _3158_/A _3153_/B _4482_/Q gf180mcu_as_sc_mcu7t3v3__nor2_2
X_3084_ VDD VDD VSS VSS _3084_/A _3084_/B _3084_/C _3084_/D _3559_/B gf180mcu_as_sc_mcu7t3v3__ao22_2
XPHY_EDGE_ROW_28_1_Left_220 VDD VSS gf180mcu_as_sc_mcu7t3v3__tap_2
XFILLER_165_1122 VDD VDD VSS VSS gf180mcu_as_sc_mcu7t3v3__fillcap_16
XFILLER_165_1177 VDD VDD VSS VSS gf180mcu_as_sc_mcu7t3v3__fillcap_4
XTAP_TAPCELL_ROW_84_3_1995 VDD VSS gf180mcu_as_sc_mcu7t3v3__tap_2
X_3986_ VDD VDD VSS VSS _4184_/B _4216_/A _4118_/B gf180mcu_as_sc_mcu7t3v3__and2_2
XPHY_EDGE_ROW_185_Left_377 VDD VSS gf180mcu_as_sc_mcu7t3v3__tap_2
X_2937_ VDD VDD VSS VSS _4367_/Q _2945_/C _3015_/A _2945_/B _4367_/D gf180mcu_as_sc_mcu7t3v3__ao22_2
XFILLER_176_663 VDD VDD VSS VSS gf180mcu_as_sc_mcu7t3v3__fill_2
XFILLER_163_324 VDD VDD VSS VSS gf180mcu_as_sc_mcu7t3v3__fillcap_16
XFILLER_164_847 VDD VDD VSS VSS gf180mcu_as_sc_mcu7t3v3__fillcap_8
X_4607_ VDD VDD VSS VSS _4831_/CLK _4607_/D _4607_/Q gf180mcu_as_sc_mcu7t3v3__dfxtp_2
X_2868_ VDD VDD VSS VSS _4185_/A _2891_/B _2896_/B _4186_/A _2869_/D gf180mcu_as_sc_mcu7t3v3__ao22_2
X_2799_ VDD VDD VSS VSS _4346_/Q _2826_/B _3023_/A _2808_/D _4346_/D gf180mcu_as_sc_mcu7t3v3__ao22_2
X_4538_ VDD VDD VSS VSS _4576_/CLK _4538_/D _4538_/Q gf180mcu_as_sc_mcu7t3v3__dfxtp_2
XFILLER_117_68 VDD VDD VSS VSS gf180mcu_as_sc_mcu7t3v3__fill_2
XFILLER_172_1115 VDD VDD VSS VSS gf180mcu_as_sc_mcu7t3v3__fillcap_16
Xfanout800 VDD VDD VSS VSS wire807/A _4229_/D gf180mcu_as_sc_mcu7t3v3__buff_12
X_4469_ VDD VDD VSS VSS _4602_/CLK _4469_/D _4469_/Q gf180mcu_as_sc_mcu7t3v3__dfxtp_2
XTAP_TAPCELL_ROW_6_802 VDD VSS gf180mcu_as_sc_mcu7t3v3__tap_2
XFILLER_172_1159 VDD VDD VSS VSS gf180mcu_as_sc_mcu7t3v3__fill_1
XTAP_TAPCELL_ROW_6_813 VDD VSS gf180mcu_as_sc_mcu7t3v3__tap_2
XPHY_EDGE_ROW_121_1_Right_630 VDD VSS gf180mcu_as_sc_mcu7t3v3__tap_2
Xhold1053 VDD VDD VSS VSS hold1085/Y hold1086/A gf180mcu_as_sc_mcu7t3v3__clkbuff_4
Xhold1064 VDD VDD VSS VSS hold1096/Y _4826_/D gf180mcu_as_sc_mcu7t3v3__clkbuff_4
Xhold1075 VDD VDD VSS VSS _4450_/Q _3046_/C gf180mcu_as_sc_mcu7t3v3__clkbuff_4
Xhold1086 VDD VDD VSS VSS hold1086/A _2327_/A gf180mcu_as_sc_mcu7t3v3__clkbuff_4
Xhold1097 VDD VDD VSS VSS _4814_/Q hold1097/Y gf180mcu_as_sc_mcu7t3v3__clkbuff_4
XFILLER_93_49 VDD VDD VSS VSS gf180mcu_as_sc_mcu7t3v3__fill_1
XFILLER_2_1267 VDD VDD VSS VSS gf180mcu_as_sc_mcu7t3v3__fill_1
XFILLER_109_1326 VDD VDD VSS VSS gf180mcu_as_sc_mcu7t3v3__fill_2
XFILLER_158_107 VDD VDD VSS VSS gf180mcu_as_sc_mcu7t3v3__fillcap_8
XFILLER_186_405 VDD VDD VSS VSS gf180mcu_as_sc_mcu7t3v3__fill_1
XFILLER_42_53 VDD VDD VSS VSS gf180mcu_as_sc_mcu7t3v3__fillcap_8
XFILLER_166_151 VDD VDD VSS VSS gf180mcu_as_sc_mcu7t3v3__fillcap_8
XFILLER_167_685 VDD VDD VSS VSS gf180mcu_as_sc_mcu7t3v3__fillcap_8
XTAP_TAPCELL_ROW_175_1565 VDD VSS gf180mcu_as_sc_mcu7t3v3__tap_2
XFILLER_158_64 VDD VDD VSS VSS gf180mcu_as_sc_mcu7t3v3__fillcap_8
XFILLER_182_633 VDD VDD VSS VSS gf180mcu_as_sc_mcu7t3v3__fill_1
XFILLER_6_835 VDD VDD VSS VSS gf180mcu_as_sc_mcu7t3v3__fill_2
XTAP_TAPCELL_ROW_175_1576 VDD VSS gf180mcu_as_sc_mcu7t3v3__tap_2
XTAP_TAPCELL_ROW_192_1890 VDD VSS gf180mcu_as_sc_mcu7t3v3__tap_2
XFILLER_174_30 VDD VDD VSS VSS gf180mcu_as_sc_mcu7t3v3__fillcap_4
XFILLER_68_1343 VDD VDD VSS VSS gf180mcu_as_sc_mcu7t3v3__fillcap_8
XPHY_EDGE_ROW_32_3_Left_404 VDD VSS gf180mcu_as_sc_mcu7t3v3__tap_2
XFILLER_1_562 VDD VDD VSS VSS gf180mcu_as_sc_mcu7t3v3__fill_2
XFILLER_7_1101 VDD VDD VSS VSS gf180mcu_as_sc_mcu7t3v3__fill_1
XFILLER_3_69 VDD VDD VSS VSS gf180mcu_as_sc_mcu7t3v3__fill_1
XFILLER_67_72 VDD VDD VSS VSS gf180mcu_as_sc_mcu7t3v3__fill_1
XFILLER_67_94 VDD VDD VSS VSS gf180mcu_as_sc_mcu7t3v3__fillcap_8
X_3840_ VDD VDD VSS VSS _3866_/B _4183_/D _3841_/C gf180mcu_as_sc_mcu7t3v3__and2_2
X_3771_ VDD VDD VSS VSS _4786_/Q _3806_/B _3808_/C _4117_/D _3772_/D gf180mcu_as_sc_mcu7t3v3__ao22_2
XFILLER_158_652 VDD VDD VSS VSS gf180mcu_as_sc_mcu7t3v3__fillcap_4
X_2722_ VDD VDD VSS VSS _4055_/D _2822_/B _2722_/C _2722_/D _2723_/C gf180mcu_as_sc_mcu7t3v3__ao211_2
XPHY_EDGE_ROW_27_3_Left_399 VDD VSS gf180mcu_as_sc_mcu7t3v3__tap_2
XFILLER_157_195 VDD VDD VSS VSS gf180mcu_as_sc_mcu7t3v3__fillcap_8
XFILLER_66_2 VDD VDD VSS VSS gf180mcu_as_sc_mcu7t3v3__fill_2
XFILLER_8_183 VDD VDD VSS VSS gf180mcu_as_sc_mcu7t3v3__fill_1
X_2653_ VDD VDD VSS VSS _2976_/A _4765_/Q _2653_/Y gf180mcu_as_sc_mcu7t3v3__and2_2
XTAP_TAPCELL_ROW_11_892 VDD VSS gf180mcu_as_sc_mcu7t3v3__tap_2
Xoutput414 VDD VDD VSS VSS _4739_/Q west_out[10] gf180mcu_as_sc_mcu7t3v3__buff_12
Xoutput425 VDD VDD VSS VSS _4749_/Q west_out[20] gf180mcu_as_sc_mcu7t3v3__buff_12
Xoutput403 VDD VDD VSS VSS _4690_/Q south_out[33] gf180mcu_as_sc_mcu7t3v3__buff_12
X_2584_ VDD VDD VSS VSS _4830_/D _2584_/B _4636_/Q _4635_/D gf180mcu_as_sc_mcu7t3v3__mux2_2
Xoutput436 VDD VDD VSS VSS _4759_/Q west_out[30] gf180mcu_as_sc_mcu7t3v3__buff_12
Xoutput447 VDD VDD VSS VSS _4738_/Q west_out[9] gf180mcu_as_sc_mcu7t3v3__buff_12
X_4323_ VDD VDD VSS VSS _4804_/D _4515_/Q _4800_/D gf180mcu_as_sc_mcu7t3v3__and2_2
XPHY_EDGE_ROW_89_3_Left_461 VDD VSS gf180mcu_as_sc_mcu7t3v3__tap_2
X_4254_ VDD VDD VSS VSS _4254_/A _4263_/B _4263_/C _4254_/D _4255_/B gf180mcu_as_sc_mcu7t3v3__ao22_2
X_4185_ VDD VDD VSS VSS _4185_/A _4210_/B _4185_/C _4209_/A _4186_/D gf180mcu_as_sc_mcu7t3v3__ao22_2
X_3205_ VDD VDD VSS VSS _3206_/C _4447_/Q _3205_/A gf180mcu_as_sc_mcu7t3v3__nand2_2
X_3136_ VDD VDD VSS VSS _3574_/D _3142_/B _3136_/Y gf180mcu_as_sc_mcu7t3v3__and2_2
X_3067_ VDD VDD VSS VSS _3068_/S _3520_/B _4466_/Q _4466_/D gf180mcu_as_sc_mcu7t3v3__mux2_2
XFILLER_169_928 VDD VDD VSS VSS gf180mcu_as_sc_mcu7t3v3__fillcap_4
XFILLER_56_1291 VDD VDD VSS VSS gf180mcu_as_sc_mcu7t3v3__fillcap_4
XTAP_TAPCELL_ROW_32_3_1943 VDD VSS gf180mcu_as_sc_mcu7t3v3__tap_2
XFILLER_143_1272 VDD VDD VSS VSS gf180mcu_as_sc_mcu7t3v3__fillcap_4
Xwire508 VDD VDD VSS VSS _2656_/Y wire508/Y gf180mcu_as_sc_mcu7t3v3__clkbuff_12
X_3969_ VDD VDD VSS VSS _4241_/B _3969_/B _4263_/B gf180mcu_as_sc_mcu7t3v3__nor2b_2
XFILLER_104_1256 VDD VDD VSS VSS gf180mcu_as_sc_mcu7t3v3__fillcap_4
XFILLER_12_34 VDD VDD VSS VSS gf180mcu_as_sc_mcu7t3v3__fill_1
XFILLER_178_1313 VDD VDD VSS VSS gf180mcu_as_sc_mcu7t3v3__fillcap_16
XTAP_TAPCELL_ROW_153_1148 VDD VSS gf180mcu_as_sc_mcu7t3v3__tap_2
XTAP_TAPCELL_ROW_153_1159 VDD VSS gf180mcu_as_sc_mcu7t3v3__tap_2
XTAP_TAPCELL_ROW_170_1484 VDD VSS gf180mcu_as_sc_mcu7t3v3__tap_2
XTAP_TAPCELL_ROW_170_1473 VDD VSS gf180mcu_as_sc_mcu7t3v3__tap_2
XFILLER_144_22 VDD VDD VSS VSS gf180mcu_as_sc_mcu7t3v3__fillcap_8
Xfanout630 VDD VDD VSS VSS _2915_/B _2901_/C gf180mcu_as_sc_mcu7t3v3__buff_12
Xfanout641 VDD VDD VSS VSS fanout642/A _4225_/D gf180mcu_as_sc_mcu7t3v3__buff_12
XFILLER_144_77 VDD VDD VSS VSS gf180mcu_as_sc_mcu7t3v3__fillcap_4
Xfanout652 VDD VDD VSS VSS fanout652/A _3808_/C gf180mcu_as_sc_mcu7t3v3__buff_12
Xfanout663 VDD VDD VSS VSS _3616_/Y _3964_/C gf180mcu_as_sc_mcu7t3v3__buff_12
Xfanout674 VDD VDD VSS VSS _2622_/Y fanout674/Y gf180mcu_as_sc_mcu7t3v3__buff_12
Xfanout696 VDD VDD VSS VSS _3850_/D _3876_/D gf180mcu_as_sc_mcu7t3v3__buff_12
XPHY_EDGE_ROW_122_1_Right_631 VDD VSS gf180mcu_as_sc_mcu7t3v3__tap_2
XFILLER_183_1030 VDD VDD VSS VSS gf180mcu_as_sc_mcu7t3v3__fillcap_16
XFILLER_183_1052 VDD VDD VSS VSS gf180mcu_as_sc_mcu7t3v3__fillcap_8
XFILLER_53_52 VDD VDD VSS VSS gf180mcu_as_sc_mcu7t3v3__fillcap_16
XTAP_TAPCELL_ROW_177_1616 VDD VSS gf180mcu_as_sc_mcu7t3v3__tap_2
XTAP_TAPCELL_ROW_177_1605 VDD VSS gf180mcu_as_sc_mcu7t3v3__tap_2
XFILLER_169_63 VDD VDD VSS VSS gf180mcu_as_sc_mcu7t3v3__fillcap_4
XFILLER_175_909 VDD VDD VSS VSS gf180mcu_as_sc_mcu7t3v3__fill_1
XFILLER_187_769 VDD VDD VSS VSS gf180mcu_as_sc_mcu7t3v3__fill_1
XFILLER_168_972 VDD VDD VSS VSS gf180mcu_as_sc_mcu7t3v3__fillcap_8
XFILLER_169_74 VDD VDD VSS VSS gf180mcu_as_sc_mcu7t3v3__fill_1
XFILLER_6_610 VDD VDD VSS VSS gf180mcu_as_sc_mcu7t3v3__fill_1
XFILLER_70_1288 VDD VDD VSS VSS gf180mcu_as_sc_mcu7t3v3__fill_1
XTAP_TAPCELL_ROW_190_1849 VDD VSS gf180mcu_as_sc_mcu7t3v3__tap_2
XFILLER_5_142 VDD VDD VSS VSS gf180mcu_as_sc_mcu7t3v3__fillcap_4
XFILLER_155_1110 VDD VDD VSS VSS gf180mcu_as_sc_mcu7t3v3__fill_1
XFILLER_170_636 VDD VDD VSS VSS gf180mcu_as_sc_mcu7t3v3__fill_2
XTAP_TAPCELL_ROW_136_3_2047 VDD VSS gf180mcu_as_sc_mcu7t3v3__tap_2
XFILLER_155_1187 VDD VDD VSS VSS gf180mcu_as_sc_mcu7t3v3__fill_2
XFILLER_162_1114 VDD VDD VSS VSS gf180mcu_as_sc_mcu7t3v3__fillcap_16
XFILLER_166_1283 VDD VDD VSS VSS gf180mcu_as_sc_mcu7t3v3__fill_2
XFILLER_127_1256 VDD VDD VSS VSS gf180mcu_as_sc_mcu7t3v3__fillcap_4
XFILLER_166_1294 VDD VDD VSS VSS gf180mcu_as_sc_mcu7t3v3__fill_1
X_3823_ VDD VDD VSS VSS _3824_/D _4165_/A _3870_/A _3823_/C gf180mcu_as_sc_mcu7t3v3__ao21_2
XFILLER_165_419 VDD VDD VSS VSS gf180mcu_as_sc_mcu7t3v3__fill_1
XFILLER_177_279 VDD VDD VSS VSS gf180mcu_as_sc_mcu7t3v3__fill_1
X_3754_ VDD VDD VSS VSS _3754_/D _3880_/A _3754_/B _3754_/C _3755_/D gf180mcu_as_sc_mcu7t3v3__ao31_2
X_3685_ VDD VDD VSS VSS _3685_/B _3748_/A _4661_/D gf180mcu_as_sc_mcu7t3v3__and2_2
X_2705_ VDD VDD VSS VSS _4040_/A _2823_/B _2705_/C _2823_/D _2707_/C gf180mcu_as_sc_mcu7t3v3__ao211_2
XTAP_TAPCELL_ROW_79_3_1990 VDD VSS gf180mcu_as_sc_mcu7t3v3__tap_2
XFILLER_9_492 VDD VDD VSS VSS gf180mcu_as_sc_mcu7t3v3__fillcap_4
XFILLER_12_1150 VDD VDD VSS VSS gf180mcu_as_sc_mcu7t3v3__fill_1
XFILLER_161_625 VDD VDD VSS VSS gf180mcu_as_sc_mcu7t3v3__fillcap_4
X_2636_ VDD VDD VSS VSS _2638_/C _2638_/A _2654_/A gf180mcu_as_sc_mcu7t3v3__nor2_2
XFILLER_161_636 VDD VDD VSS VSS gf180mcu_as_sc_mcu7t3v3__fill_2
X_2567_ VDD VDD VSS VSS _2567_/B _3611_/C _2568_/C gf180mcu_as_sc_mcu7t3v3__and2_2
X_4306_ VDD VDD VSS VSS _4313_/B _4530_/Q _4783_/D gf180mcu_as_sc_mcu7t3v3__and2_2
X_2498_ VDD VDD VSS VSS _4806_/Q _2498_/B _2498_/A _5073_/A gf180mcu_as_sc_mcu7t3v3__mux2_2
X_4237_ VDD VDD VSS VSS _4237_/A _4237_/B _4237_/C _4237_/D _4238_/B gf180mcu_as_sc_mcu7t3v3__ao211_2
X_4168_ VDD VDD VSS VSS _4209_/A _4168_/B _4168_/C _4187_/D _4170_/C gf180mcu_as_sc_mcu7t3v3__ao211_2
XFILLER_3_1351 VDD VDD VSS VSS gf180mcu_as_sc_mcu7t3v3__fillcap_4
X_4099_ VDD VDD VSS VSS _4099_/B _4213_/A _4704_/D gf180mcu_as_sc_mcu7t3v3__and2_2
X_3119_ VDD VDD VSS VSS _3120_/S _4507_/Q _4506_/Q _4506_/D gf180mcu_as_sc_mcu7t3v3__mux2_2
XFILLER_145_1312 VDD VDD VSS VSS gf180mcu_as_sc_mcu7t3v3__fill_1
XFILLER_19_1326 VDD VDD VSS VSS gf180mcu_as_sc_mcu7t3v3__fillcap_4
XFILLER_58_1353 VDD VDD VSS VSS gf180mcu_as_sc_mcu7t3v3__fill_2
XFILLER_142_6 VDD VDD VSS VSS gf180mcu_as_sc_mcu7t3v3__fillcap_4
XFILLER_157_909 VDD VDD VSS VSS gf180mcu_as_sc_mcu7t3v3__fill_1
XFILLER_139_22 VDD VDD VSS VSS gf180mcu_as_sc_mcu7t3v3__fill_2
XFILLER_156_419 VDD VDD VSS VSS gf180mcu_as_sc_mcu7t3v3__fillcap_16
XFILLER_165_920 VDD VDD VSS VSS gf180mcu_as_sc_mcu7t3v3__fillcap_4
XFILLER_23_66 VDD VDD VSS VSS gf180mcu_as_sc_mcu7t3v3__fillcap_4
XFILLER_7_418 VDD VDD VSS VSS gf180mcu_as_sc_mcu7t3v3__fill_2
XTAP_TAPCELL_ROW_172_1513 VDD VSS gf180mcu_as_sc_mcu7t3v3__tap_2
XFILLER_139_99 VDD VDD VSS VSS gf180mcu_as_sc_mcu7t3v3__fillcap_4
XFILLER_152_614 VDD VDD VSS VSS gf180mcu_as_sc_mcu7t3v3__fillcap_4
XFILLER_164_452 VDD VDD VSS VSS gf180mcu_as_sc_mcu7t3v3__fill_2
XFILLER_164_463 VDD VDD VSS VSS gf180mcu_as_sc_mcu7t3v3__fill_1
XFILLER_164_485 VDD VDD VSS VSS gf180mcu_as_sc_mcu7t3v3__fillcap_16
XFILLER_178_1154 VDD VDD VSS VSS gf180mcu_as_sc_mcu7t3v3__fill_1
XFILLER_180_923 VDD VDD VSS VSS gf180mcu_as_sc_mcu7t3v3__fillcap_8
XFILLER_191_1310 VDD VDD VSS VSS gf180mcu_as_sc_mcu7t3v3__fillcap_16
XFILLER_191_282 VDD VDD VSS VSS gf180mcu_as_sc_mcu7t3v3__fillcap_8
XFILLER_3_646 VDD VDD VSS VSS gf180mcu_as_sc_mcu7t3v3__fill_2
XFILLER_191_1332 VDD VDD VSS VSS gf180mcu_as_sc_mcu7t3v3__fillcap_16
XFILLER_152_1305 VDD VDD VSS VSS gf180mcu_as_sc_mcu7t3v3__fillcap_16
XFILLER_191_1354 VDD VDD VSS VSS gf180mcu_as_sc_mcu7t3v3__fill_1
Xfanout460 VDD VDD VSS VSS _3633_/Y _3933_/S gf180mcu_as_sc_mcu7t3v3__buff_12
Xfanout471 VDD VDD VSS VSS _2976_/Y _3006_/B gf180mcu_as_sc_mcu7t3v3__buff_12
Xfanout482 VDD VDD VSS VSS _3007_/Y _3038_/B gf180mcu_as_sc_mcu7t3v3__buff_12
XFILLER_185_1103 VDD VDD VSS VSS gf180mcu_as_sc_mcu7t3v3__fillcap_16
XPHY_EDGE_ROW_123_1_Right_632 VDD VSS gf180mcu_as_sc_mcu7t3v3__tap_2
XFILLER_159_268 VDD VDD VSS VSS gf180mcu_as_sc_mcu7t3v3__fillcap_4
XTAP_TAPCELL_ROW_13_943 VDD VSS gf180mcu_as_sc_mcu7t3v3__tap_2
XTAP_TAPCELL_ROW_13_932 VDD VSS gf180mcu_as_sc_mcu7t3v3__tap_2
XFILLER_9_68 VDD VDD VSS VSS gf180mcu_as_sc_mcu7t3v3__fill_2
XFILLER_168_791 VDD VDD VSS VSS gf180mcu_as_sc_mcu7t3v3__fill_1
XTAP_TAPCELL_ROW_13_965 VDD VSS gf180mcu_as_sc_mcu7t3v3__tap_2
XTAP_TAPCELL_ROW_13_954 VDD VSS gf180mcu_as_sc_mcu7t3v3__tap_2
XFILLER_156_942 VDD VDD VSS VSS gf180mcu_as_sc_mcu7t3v3__fill_2
XFILLER_174_238 VDD VDD VSS VSS gf180mcu_as_sc_mcu7t3v3__fillcap_4
XFILLER_156_986 VDD VDD VSS VSS gf180mcu_as_sc_mcu7t3v3__fill_2
XFILLER_183_783 VDD VDD VSS VSS gf180mcu_as_sc_mcu7t3v3__fillcap_8
XFILLER_7_974 VDD VDD VSS VSS gf180mcu_as_sc_mcu7t3v3__fillcap_4
XFILLER_157_1249 VDD VDD VSS VSS gf180mcu_as_sc_mcu7t3v3__fill_1
Xmax_cap649 VDD VDD VSS VSS _3972_/Y fanout648/A gf180mcu_as_sc_mcu7t3v3__clkbuff_12
X_3470_ VDD VDD VSS VSS _3471_/D _4588_/Q _4589_/Q _4589_/D gf180mcu_as_sc_mcu7t3v3__mux2_2
XFILLER_171_978 VDD VDD VSS VSS gf180mcu_as_sc_mcu7t3v3__fill_2
X_2421_ VDD VDD VSS VSS _2425_/B _4487_/Q _2422_/D gf180mcu_as_sc_mcu7t3v3__and2_2
X_2352_ VDD VDD VSS VSS _2494_/A _2352_/B _2352_/C _2352_/D _2352_/Y gf180mcu_as_sc_mcu7t3v3__ao22_2
XFILLER_2_690 VDD VDD VSS VSS gf180mcu_as_sc_mcu7t3v3__fill_1
X_5071_ VDD VDD VSS VSS _5071_/A _5071_/Y gf180mcu_as_sc_mcu7t3v3__buff_2
X_2283_ VDD VDD VSS VSS _3573_/D _3131_/B _3131_/A gf180mcu_as_sc_mcu7t3v3__nand2_2
X_4022_ VDD VDD VSS VSS _4024_/C _4216_/A _4022_/B _4022_/C gf180mcu_as_sc_mcu7t3v3__ao21_2
XFILLER_168_1301 VDD VDD VSS VSS gf180mcu_as_sc_mcu7t3v3__fill_2
Xclkbuf_3_3__f_clk_regs VDD VDD VSS VSS clkbuf_2_1_0_clk_regs/Y clkload0/A gf180mcu_as_sc_mcu7t3v3__clkbuff_12
XFILLER_178_522 VDD VDD VSS VSS gf180mcu_as_sc_mcu7t3v3__fill_2
XFILLER_165_216 VDD VDD VSS VSS gf180mcu_as_sc_mcu7t3v3__fill_2
XFILLER_166_728 VDD VDD VSS VSS gf180mcu_as_sc_mcu7t3v3__fillcap_4
X_4786_ VDD VDD VSS VSS clkload7/A _4786_/D _4786_/Q gf180mcu_as_sc_mcu7t3v3__dfxtp_2
X_3806_ VDD VDD VSS VSS _4790_/Q _3806_/B _3806_/C _3806_/D _3807_/C gf180mcu_as_sc_mcu7t3v3__ao22_2
XFILLER_14_1256 VDD VDD VSS VSS gf180mcu_as_sc_mcu7t3v3__fillcap_8
XFILLER_158_290 VDD VDD VSS VSS gf180mcu_as_sc_mcu7t3v3__fillcap_16
XFILLER_165_249 VDD VDD VSS VSS gf180mcu_as_sc_mcu7t3v3__fill_2
X_3737_ VDD VDD VSS VSS _4089_/A _3800_/B _3737_/C _3737_/D _3738_/B gf180mcu_as_sc_mcu7t3v3__ao211_2
XFILLER_174_772 VDD VDD VSS VSS gf180mcu_as_sc_mcu7t3v3__fill_2
XFILLER_180_219 VDD VDD VSS VSS gf180mcu_as_sc_mcu7t3v3__fill_2
XFILLER_161_422 VDD VDD VSS VSS gf180mcu_as_sc_mcu7t3v3__fillcap_16
XFILLER_173_282 VDD VDD VSS VSS gf180mcu_as_sc_mcu7t3v3__fillcap_16
XFILLER_174_794 VDD VDD VSS VSS gf180mcu_as_sc_mcu7t3v3__fill_1
X_3668_ VDD VDD VSS VSS _3875_/B _4028_/D _3669_/C gf180mcu_as_sc_mcu7t3v3__and2_2
X_3599_ VDD VDD VSS VSS _3603_/A _3599_/B _3599_/C _4652_/D gf180mcu_as_sc_mcu7t3v3__nor3_2
X_2619_ VDD VDD VSS VSS _4798_/Q _4800_/Q _2621_/C gf180mcu_as_sc_mcu7t3v3__or2_2
XPHY_EDGE_ROW_49_3_Right_90 VDD VSS gf180mcu_as_sc_mcu7t3v3__tap_2
XTAP_TAPCELL_ROW_165_1383 VDD VSS gf180mcu_as_sc_mcu7t3v3__tap_2
XTAP_TAPCELL_ROW_165_1372 VDD VSS gf180mcu_as_sc_mcu7t3v3__tap_2
XPHY_EDGE_ROW_104_3_Left_476 VDD VSS gf180mcu_as_sc_mcu7t3v3__tap_2
XFILLER_95_1306 VDD VDD VSS VSS gf180mcu_as_sc_mcu7t3v3__fillcap_16
XFILLER_182_1309 VDD VDD VSS VSS gf180mcu_as_sc_mcu7t3v3__fillcap_8
XFILLER_3_1192 VDD VDD VSS VSS gf180mcu_as_sc_mcu7t3v3__fill_2
XFILLER_180_1000 VDD VDD VSS VSS gf180mcu_as_sc_mcu7t3v3__fillcap_8
XPHY_EDGE_ROW_41_3_Left_413 VDD VSS gf180mcu_as_sc_mcu7t3v3__tap_2
XFILLER_169_566 VDD VDD VSS VSS gf180mcu_as_sc_mcu7t3v3__fill_1
XFILLER_169_577 VDD VDD VSS VSS gf180mcu_as_sc_mcu7t3v3__fillcap_16
XFILLER_180_1033 VDD VDD VSS VSS gf180mcu_as_sc_mcu7t3v3__fillcap_4
XFILLER_34_65 VDD VDD VSS VSS gf180mcu_as_sc_mcu7t3v3__fill_2
XFILLER_156_238 VDD VDD VSS VSS gf180mcu_as_sc_mcu7t3v3__fillcap_4
XFILLER_152_400 VDD VDD VSS VSS gf180mcu_as_sc_mcu7t3v3__fillcap_8
XFILLER_153_912 VDD VDD VSS VSS gf180mcu_as_sc_mcu7t3v3__fillcap_16
XFILLER_165_772 VDD VDD VSS VSS gf180mcu_as_sc_mcu7t3v3__fillcap_8
XFILLER_180_731 VDD VDD VSS VSS gf180mcu_as_sc_mcu7t3v3__fillcap_4
XFILLER_192_591 VDD VDD VSS VSS gf180mcu_as_sc_mcu7t3v3__fillcap_4
XFILLER_4_944 VDD VDD VSS VSS gf180mcu_as_sc_mcu7t3v3__fill_1
XFILLER_180_753 VDD VDD VSS VSS gf180mcu_as_sc_mcu7t3v3__fillcap_16
XFILLER_180_786 VDD VDD VSS VSS gf180mcu_as_sc_mcu7t3v3__fillcap_16
XFILLER_4_988 VDD VDD VSS VSS gf180mcu_as_sc_mcu7t3v3__fill_2
XTAP_TAPCELL_ROW_189_1840 VDD VSS gf180mcu_as_sc_mcu7t3v3__tap_2
XFILLER_152_1124 VDD VDD VSS VSS gf180mcu_as_sc_mcu7t3v3__fillcap_16
XTAP_TAPCELL_ROW_185_1759 VDD VSS gf180mcu_as_sc_mcu7t3v3__tap_2
XPHY_EDGE_ROW_97_1_Left_289 VDD VSS gf180mcu_as_sc_mcu7t3v3__tap_2
XPHY_EDGE_ROW_124_1_Right_633 VDD VSS gf180mcu_as_sc_mcu7t3v3__tap_2
XFILLER_76_1272 VDD VDD VSS VSS gf180mcu_as_sc_mcu7t3v3__fill_2
X_2970_ VDD VDD VSS VSS _3004_/A _2974_/A _3035_/A gf180mcu_as_sc_mcu7t3v3__and2_2
XFILLER_187_352 VDD VDD VSS VSS gf180mcu_as_sc_mcu7t3v3__fillcap_16
XFILLER_37_1256 VDD VDD VSS VSS gf180mcu_as_sc_mcu7t3v3__fillcap_16
XPHY_EDGE_ROW_98_3_Left_470 VDD VSS gf180mcu_as_sc_mcu7t3v3__tap_2
XFILLER_175_525 VDD VDD VSS VSS gf180mcu_as_sc_mcu7t3v3__fill_2
X_4640_ VDD VDD VSS VSS _4808_/CLK _4640_/D _4640_/Q gf180mcu_as_sc_mcu7t3v3__dfxtp_2
X_4571_ VDD VDD VSS VSS _4728_/CLK _4571_/D _4571_/Q gf180mcu_as_sc_mcu7t3v3__dfxtp_2
XFILLER_155_282 VDD VDD VSS VSS gf180mcu_as_sc_mcu7t3v3__fillcap_4
X_3522_ VDD VDD VSS VSS _3522_/S _5074_/A _4610_/Q _3523_/A gf180mcu_as_sc_mcu7t3v3__mux2_2
XFILLER_170_230 VDD VDD VSS VSS gf180mcu_as_sc_mcu7t3v3__fillcap_4
X_3453_ VDD VDD VSS VSS _3520_/S _4473_/Q _4576_/Q _4576_/D gf180mcu_as_sc_mcu7t3v3__mux2_2
XFILLER_157_1068 VDD VDD VSS VSS gf180mcu_as_sc_mcu7t3v3__fill_1
XFILLER_170_263 VDD VDD VSS VSS gf180mcu_as_sc_mcu7t3v3__fillcap_16
X_2404_ VDD VDD VSS VSS _2493_/B _2404_/B _2404_/C _2424_/A _2405_/C gf180mcu_as_sc_mcu7t3v3__ao211_2
X_3384_ VDD VDD VSS VSS _3385_/C _3408_/A _4352_/Q _3408_/C gf180mcu_as_sc_mcu7t3v3__ao21_2
X_2335_ VDD VDD VSS VSS _4480_/Q _4453_/Q _2338_/B gf180mcu_as_sc_mcu7t3v3__xnor2_2
X_2266_ VDD VDD VSS VSS _4292_/C _3580_/A _4616_/Q _2267_/C _2269_/B gf180mcu_as_sc_mcu7t3v3__nand4_2
X_4005_ VDD VDD VSS VSS _4272_/B _4005_/A _4005_/Y gf180mcu_as_sc_mcu7t3v3__or2_2
X_2197_ VDD VDD VSS VSS _2552_/A _3572_/B gf180mcu_as_sc_mcu7t3v3__inv_2
XFILLER_164_1017 VDD VDD VSS VSS gf180mcu_as_sc_mcu7t3v3__fillcap_8
XFILLER_179_842 VDD VDD VSS VSS gf180mcu_as_sc_mcu7t3v3__fillcap_4
XTAP_TAPCELL_ROW_160_1291 VDD VSS gf180mcu_as_sc_mcu7t3v3__tap_2
XTAP_TAPCELL_ROW_160_1280 VDD VSS gf180mcu_as_sc_mcu7t3v3__tap_2
XFILLER_142_1315 VDD VDD VSS VSS gf180mcu_as_sc_mcu7t3v3__fillcap_4
XFILLER_178_330 VDD VDD VSS VSS gf180mcu_as_sc_mcu7t3v3__fill_1
XFILLER_153_208 VDD VDD VSS VSS gf180mcu_as_sc_mcu7t3v3__fill_2
X_4769_ VDD VDD VSS VSS _4803_/CLK _4769_/D _4769_/Q gf180mcu_as_sc_mcu7t3v3__dfxtp_2
XFILLER_20_34 VDD VDD VSS VSS gf180mcu_as_sc_mcu7t3v3__fill_1
XFILLER_136_34 VDD VDD VSS VSS gf180mcu_as_sc_mcu7t3v3__fill_1
Xinput303 VDD VDD VSS VSS west_in[15] _4125_/A gf180mcu_as_sc_mcu7t3v3__buff_12
XTAP_TAPCELL_ROW_74_1_1027 VDD VSS gf180mcu_as_sc_mcu7t3v3__tap_2
XTAP_TAPCELL_ROW_167_1412 VDD VSS gf180mcu_as_sc_mcu7t3v3__tap_2
X_4755__1017 VDD VDD VSS VSS _4755_/D gf180mcu_as_sc_mcu7t3v3__tiel_4
Xinput314 VDD VDD VSS VSS west_in[25] _4206_/A gf180mcu_as_sc_mcu7t3v3__buff_12
Xinput325 VDD VDD VSS VSS west_in[35] _3961_/B gf180mcu_as_sc_mcu7t3v3__buff_12
XTAP_TAPCELL_ROW_167_1423 VDD VSS gf180mcu_as_sc_mcu7t3v3__tap_2
XFILLER_152_33 VDD VDD VSS VSS gf180mcu_as_sc_mcu7t3v3__fill_1
XFILLER_29_76 VDD VDD VSS VSS gf180mcu_as_sc_mcu7t3v3__fill_2
XTAP_TAPCELL_ROW_4_774 VDD VSS gf180mcu_as_sc_mcu7t3v3__tap_2
XTAP_TAPCELL_ROW_4_763 VDD VSS gf180mcu_as_sc_mcu7t3v3__tap_2
XFILLER_186_1220 VDD VDD VSS VSS gf180mcu_as_sc_mcu7t3v3__fillcap_4
XFILLER_5_1287 VDD VDD VSS VSS gf180mcu_as_sc_mcu7t3v3__fill_2
XFILLER_99_1272 VDD VDD VSS VSS gf180mcu_as_sc_mcu7t3v3__fillcap_16
XFILLER_45_64 VDD VDD VSS VSS gf180mcu_as_sc_mcu7t3v3__fillcap_4
XTAP_TAPCELL_ROW_180_1667 VDD VSS gf180mcu_as_sc_mcu7t3v3__tap_2
XFILLER_186_1297 VDD VDD VSS VSS gf180mcu_as_sc_mcu7t3v3__fillcap_16
XFILLER_169_330 VDD VDD VSS VSS gf180mcu_as_sc_mcu7t3v3__fill_2
XFILLER_101_92 VDD VDD VSS VSS gf180mcu_as_sc_mcu7t3v3__fillcap_8
XFILLER_12_597 VDD VDD VSS VSS gf180mcu_as_sc_mcu7t3v3__fillcap_8
XFILLER_157_547 VDD VDD VSS VSS gf180mcu_as_sc_mcu7t3v3__fillcap_8
XFILLER_184_344 VDD VDD VSS VSS gf180mcu_as_sc_mcu7t3v3__fillcap_8
XFILLER_8_524 VDD VDD VSS VSS gf180mcu_as_sc_mcu7t3v3__fill_1
XFILLER_123_1270 VDD VDD VSS VSS gf180mcu_as_sc_mcu7t3v3__fill_1
XFILLER_172_517 VDD VDD VSS VSS gf180mcu_as_sc_mcu7t3v3__fillcap_8
XANTENNA_7 VDD VDD VSS VSS _4708_/D gf180mcu_as_sc_mcu7t3v3__diode_2
XFILLER_152_274 VDD VDD VSS VSS gf180mcu_as_sc_mcu7t3v3__fillcap_16
Xmesh_tile_918 VDD VDD VSS VSS nw_out[18] gf180mcu_as_sc_mcu7t3v3__tiel_4
Xmesh_tile_907 VDD VDD VSS VSS nw_out[7] gf180mcu_as_sc_mcu7t3v3__tiel_4
XFILLER_0_980 VDD VDD VSS VSS gf180mcu_as_sc_mcu7t3v3__fillcap_4
Xmesh_tile_929 VDD VDD VSS VSS nw_out[29] gf180mcu_as_sc_mcu7t3v3__tiel_4
XFILLER_43_1293 VDD VDD VSS VSS gf180mcu_as_sc_mcu7t3v3__fillcap_4
XFILLER_165_1348 VDD VDD VSS VSS gf180mcu_as_sc_mcu7t3v3__fill_2
XFILLER_179_105 VDD VDD VSS VSS gf180mcu_as_sc_mcu7t3v3__fillcap_16
XPHY_EDGE_ROW_125_1_Right_634 VDD VSS gf180mcu_as_sc_mcu7t3v3__tap_2
X_2953_ VDD VDD VSS VSS _4377_/Q _2965_/B _3025_/A _2965_/D _4377_/D gf180mcu_as_sc_mcu7t3v3__ao22_2
XFILLER_176_845 VDD VDD VSS VSS gf180mcu_as_sc_mcu7t3v3__fillcap_16
X_2884_ VDD VDD VSS VSS _2893_/B _4198_/D _2885_/D gf180mcu_as_sc_mcu7t3v3__and2_2
X_4623_ VDD VDD VSS VSS _4820_/CLK _4623_/D _4623_/Q gf180mcu_as_sc_mcu7t3v3__dfxtp_2
XFILLER_175_399 VDD VDD VSS VSS gf180mcu_as_sc_mcu7t3v3__fillcap_16
XFILLER_191_837 VDD VDD VSS VSS gf180mcu_as_sc_mcu7t3v3__fill_2
X_4554_ VDD VDD VSS VSS _4719_/CLK _4554_/D _4554_/Q gf180mcu_as_sc_mcu7t3v3__dfxtp_2
X_3505_ VDD VDD VSS VSS _4611_/Q _3505_/A _3507_/C gf180mcu_as_sc_mcu7t3v3__or2_2
X_4485_ VDD VDD VSS VSS _4720_/CLK _4485_/D _4485_/Q gf180mcu_as_sc_mcu7t3v3__dfxtp_2
XFILLER_170_1010 VDD VDD VSS VSS gf180mcu_as_sc_mcu7t3v3__fillcap_4
X_3436_ VDD VDD VSS VSS _4565_/Q _3439_/B _3439_/C _4564_/Q _4564_/D gf180mcu_as_sc_mcu7t3v3__ao22_2
XFILLER_106_48 VDD VDD VSS VSS gf180mcu_as_sc_mcu7t3v3__fillcap_16
XFILLER_170_1043 VDD VDD VSS VSS gf180mcu_as_sc_mcu7t3v3__fill_1
X_3367_ VDD VDD VSS VSS _3370_/C _4437_/Q _3368_/S gf180mcu_as_sc_mcu7t3v3__nand2_2
X_2318_ VDD VDD VSS VSS _4631_/Q _3611_/C _3558_/B _2319_/B gf180mcu_as_sc_mcu7t3v3__nand3_2
X_3298_ VDD VDD VSS VSS _3330_/A _3298_/B _3298_/C _3300_/B _3298_/D gf180mcu_as_sc_mcu7t3v3__aoi31_2
XTAP_TAPCELL_ROW_1_711 VDD VSS gf180mcu_as_sc_mcu7t3v3__tap_2
XTAP_TAPCELL_ROW_135_1_1088 VDD VSS gf180mcu_as_sc_mcu7t3v3__tap_2
X_2249_ VDD VDD VSS VSS _2267_/C _4576_/Q _3131_/A gf180mcu_as_sc_mcu7t3v3__nor2_2
XTAP_TAPCELL_ROW_162_1331 VDD VSS gf180mcu_as_sc_mcu7t3v3__tap_2
XTAP_TAPCELL_ROW_162_1320 VDD VSS gf180mcu_as_sc_mcu7t3v3__tap_2
XFILLER_167_834 VDD VDD VSS VSS gf180mcu_as_sc_mcu7t3v3__fill_2
XFILLER_166_333 VDD VDD VSS VSS gf180mcu_as_sc_mcu7t3v3__fillcap_8
XTAP_TAPCELL_ROW_93_3_2004 VDD VSS gf180mcu_as_sc_mcu7t3v3__tap_2
XFILLER_166_377 VDD VDD VSS VSS gf180mcu_as_sc_mcu7t3v3__fillcap_8
XFILLER_182_804 VDD VDD VSS VSS gf180mcu_as_sc_mcu7t3v3__fill_1
XFILLER_182_815 VDD VDD VSS VSS gf180mcu_as_sc_mcu7t3v3__fill_2
XFILLER_147_22 VDD VDD VSS VSS gf180mcu_as_sc_mcu7t3v3__fillcap_8
XFILLER_177_1208 VDD VDD VSS VSS gf180mcu_as_sc_mcu7t3v3__fillcap_8
XFILLER_182_848 VDD VDD VSS VSS gf180mcu_as_sc_mcu7t3v3__fill_2
XFILLER_181_347 VDD VDD VSS VSS gf180mcu_as_sc_mcu7t3v3__fill_2
XFILLER_147_88 VDD VDD VSS VSS gf180mcu_as_sc_mcu7t3v3__fillcap_4
XFILLER_0_210 VDD VDD VSS VSS gf180mcu_as_sc_mcu7t3v3__fill_2
XFILLER_66_1260 VDD VDD VSS VSS gf180mcu_as_sc_mcu7t3v3__fill_2
XTAP_TAPCELL_ROW_9_866 VDD VSS gf180mcu_as_sc_mcu7t3v3__tap_2
XTAP_TAPCELL_ROW_9_855 VDD VSS gf180mcu_as_sc_mcu7t3v3__tap_2
XFILLER_163_54 VDD VDD VSS VSS gf180mcu_as_sc_mcu7t3v3__fillcap_16
Xinput100 VDD VDD VSS VSS ne_in[28] _4236_/A gf180mcu_as_sc_mcu7t3v3__buff_12
Xinput111 VDD VDD VSS VSS ne_in[5] _4047_/A gf180mcu_as_sc_mcu7t3v3__buff_12
Xinput122 VDD VDD VSS VSS north_in[15] _4127_/A gf180mcu_as_sc_mcu7t3v3__buff_12
Xinput133 VDD VDD VSS VSS north_in[25] _3869_/D gf180mcu_as_sc_mcu7t3v3__buff_12
Xinput144 VDD VDD VSS VSS north_in[35] _3640_/A gf180mcu_as_sc_mcu7t3v3__buff_12
XTAP_TAPCELL_ROW_182_1707 VDD VSS gf180mcu_as_sc_mcu7t3v3__tap_2
XFILLER_56_41 VDD VDD VSS VSS gf180mcu_as_sc_mcu7t3v3__fill_1
Xinput155 VDD VDD VSS VSS nw_in[12] _4104_/D gf180mcu_as_sc_mcu7t3v3__buff_12
Xinput166 VDD VDD VSS VSS nw_in[22] _4186_/A gf180mcu_as_sc_mcu7t3v3__buff_12
Xinput177 VDD VDD VSS VSS nw_in[32] _3935_/A gf180mcu_as_sc_mcu7t3v3__buff_12
Xinput188 VDD VDD VSS VSS rst input188/Y gf180mcu_as_sc_mcu7t3v3__buff_12
Xinput199 VDD VDD VSS VSS se_in[19] _4162_/A gf180mcu_as_sc_mcu7t3v3__buff_12
XFILLER_186_1072 VDD VDD VSS VSS gf180mcu_as_sc_mcu7t3v3__fillcap_8
XFILLER_158_823 VDD VDD VSS VSS gf180mcu_as_sc_mcu7t3v3__fillcap_16
XFILLER_160_1212 VDD VDD VSS VSS gf180mcu_as_sc_mcu7t3v3__fill_1
XTAP_TAPCELL_ROW_50_3_1961 VDD VSS gf180mcu_as_sc_mcu7t3v3__tap_2
XFILLER_173_815 VDD VDD VSS VSS gf180mcu_as_sc_mcu7t3v3__fillcap_8
XFILLER_185_664 VDD VDD VSS VSS gf180mcu_as_sc_mcu7t3v3__fillcap_16
XFILLER_184_185 VDD VDD VSS VSS gf180mcu_as_sc_mcu7t3v3__fill_2
XFILLER_158_1130 VDD VDD VSS VSS gf180mcu_as_sc_mcu7t3v3__fill_2
XPHY_EDGE_ROW_129_3_Left_501 VDD VSS gf180mcu_as_sc_mcu7t3v3__tap_2
XFILLER_153_572 VDD VDD VSS VSS gf180mcu_as_sc_mcu7t3v3__fill_1
X_4270_ VDD VDD VSS VSS _4270_/B _4270_/A _4271_/B gf180mcu_as_sc_mcu7t3v3__or2_2
X_3221_ VDD VDD VSS VSS _3225_/B _4332_/Q _3351_/A gf180mcu_as_sc_mcu7t3v3__nand2b_2
Xclkbuf_leaf_17_clk_regs VDD VDD VSS VSS clkbuf_3_6__f_clk_regs/Y _4831_/CLK gf180mcu_as_sc_mcu7t3v3__clkbuff_12
X_3152_ VDD VDD VSS VSS _4510_/Q _3152_/B _3152_/C _3152_/D _3153_/B gf180mcu_as_sc_mcu7t3v3__nand4_2
XFILLER_11_2 VDD VDD VSS VSS gf180mcu_as_sc_mcu7t3v3__fillcap_4
X_3083_ VDD VDD VSS VSS _3084_/C _3083_/B _3084_/A gf180mcu_as_sc_mcu7t3v3__nor2_2
XPHY_EDGE_ROW_110_3_Right_151 VDD VSS gf180mcu_as_sc_mcu7t3v3__tap_2
XPHY_EDGE_ROW_187_Right_49 VDD VSS gf180mcu_as_sc_mcu7t3v3__tap_2
XPHY_EDGE_ROW_126_1_Right_635 VDD VSS gf180mcu_as_sc_mcu7t3v3__tap_2
XFILLER_165_1189 VDD VDD VSS VSS gf180mcu_as_sc_mcu7t3v3__fill_1
XFILLER_167_108 VDD VDD VSS VSS gf180mcu_as_sc_mcu7t3v3__fill_2
X_3985_ VDD VDD VSS VSS _4206_/B _4231_/B _4191_/B gf180mcu_as_sc_mcu7t3v3__nor2b_2
XFILLER_176_631 VDD VDD VSS VSS gf180mcu_as_sc_mcu7t3v3__fill_1
X_2936_ VDD VDD VSS VSS _2984_/A _2943_/A _3015_/A gf180mcu_as_sc_mcu7t3v3__and2_2
XFILLER_164_804 VDD VDD VSS VSS gf180mcu_as_sc_mcu7t3v3__fill_1
XFILLER_164_815 VDD VDD VSS VSS gf180mcu_as_sc_mcu7t3v3__fillcap_4
XFILLER_175_152 VDD VDD VSS VSS gf180mcu_as_sc_mcu7t3v3__fillcap_16
X_2867_ VDD VDD VSS VSS _4183_/D _2893_/B _2867_/C _2867_/D _2869_/C gf180mcu_as_sc_mcu7t3v3__ao211_2
X_4606_ VDD VDD VSS VSS _4606_/CLK _4606_/D _4606_/Q gf180mcu_as_sc_mcu7t3v3__dfxtp_2
XFILLER_89_1260 VDD VDD VSS VSS gf180mcu_as_sc_mcu7t3v3__fill_2
X_2798_ VDD VDD VSS VSS _4123_/A _2871_/B _2798_/C _3023_/A _2871_/D gf180mcu_as_sc_mcu7t3v3__aoi211_2
XTAP_TAPCELL_ROW_155_1190 VDD VSS gf180mcu_as_sc_mcu7t3v3__tap_2
XFILLER_190_177 VDD VDD VSS VSS gf180mcu_as_sc_mcu7t3v3__fillcap_4
XFILLER_2_519 VDD VDD VSS VSS gf180mcu_as_sc_mcu7t3v3__fill_2
XFILLER_89_103 VDD VDD VSS VSS gf180mcu_as_sc_mcu7t3v3__fill_2
X_4537_ VDD VDD VSS VSS _4576_/CLK _4537_/D _4537_/Q gf180mcu_as_sc_mcu7t3v3__dfxtp_2
XPHY_EDGE_ROW_113_3_Left_485 VDD VSS gf180mcu_as_sc_mcu7t3v3__tap_2
XFILLER_176_1274 VDD VDD VSS VSS gf180mcu_as_sc_mcu7t3v3__fillcap_8
X_4468_ VDD VDD VSS VSS _4606_/CLK _4468_/D _4468_/Q gf180mcu_as_sc_mcu7t3v3__dfxtp_2
XTAP_TAPCELL_ROW_6_803 VDD VSS gf180mcu_as_sc_mcu7t3v3__tap_2
Xfanout801 VDD VDD VSS VSS _4331_/A _4122_/D gf180mcu_as_sc_mcu7t3v3__buff_12
X_3419_ VDD VDD VSS VSS _4548_/Q _3445_/B _3449_/B _4547_/Q _4547_/D gf180mcu_as_sc_mcu7t3v3__ao22_2
XTAP_TAPCELL_ROW_6_814 VDD VSS gf180mcu_as_sc_mcu7t3v3__tap_2
X_4399_ VDD VDD VSS VSS clkload9/A _4399_/D _4399_/Q gf180mcu_as_sc_mcu7t3v3__dfxtp_2
XPHY_EDGE_ROW_50_3_Left_422 VDD VSS gf180mcu_as_sc_mcu7t3v3__tap_2
Xhold1054 VDD VDD VSS VSS hold1087/Y hold1088/A gf180mcu_as_sc_mcu7t3v3__clkbuff_4
Xhold1065 VDD VDD VSS VSS hold1100/Y _4816_/D gf180mcu_as_sc_mcu7t3v3__clkbuff_4
Xhold1076 VDD VDD VSS VSS _4628_/Q _3579_/A gf180mcu_as_sc_mcu7t3v3__clkbuff_4
XFILLER_148_1310 VDD VDD VSS VSS gf180mcu_as_sc_mcu7t3v3__fillcap_4
XFILLER_172_6 VDD VDD VSS VSS gf180mcu_as_sc_mcu7t3v3__fill_2
Xhold1087 VDD VDD VSS VSS _2327_/Y hold1087/Y gf180mcu_as_sc_mcu7t3v3__clkbuff_4
Xhold1098 VDD VDD VSS VSS _4820_/Q hold1098/Y gf180mcu_as_sc_mcu7t3v3__clkbuff_4
XTAP_TAPCELL_ROW_69_1_1022 VDD VSS gf180mcu_as_sc_mcu7t3v3__tap_2
XFILLER_148_1343 VDD VDD VSS VSS gf180mcu_as_sc_mcu7t3v3__fillcap_8
XFILLER_26_55 VDD VDD VSS VSS gf180mcu_as_sc_mcu7t3v3__fill_2
XFILLER_26_99 VDD VDD VSS VSS gf180mcu_as_sc_mcu7t3v3__fillcap_4
XFILLER_158_119 VDD VDD VSS VSS gf180mcu_as_sc_mcu7t3v3__fill_2
XFILLER_167_642 VDD VDD VSS VSS gf180mcu_as_sc_mcu7t3v3__fill_1
XFILLER_167_653 VDD VDD VSS VSS gf180mcu_as_sc_mcu7t3v3__fillcap_16
XFILLER_154_314 VDD VDD VSS VSS gf180mcu_as_sc_mcu7t3v3__fill_1
XFILLER_166_163 VDD VDD VSS VSS gf180mcu_as_sc_mcu7t3v3__fill_1
XFILLER_167_697 VDD VDD VSS VSS gf180mcu_as_sc_mcu7t3v3__fill_2
XTAP_TAPCELL_ROW_175_1577 VDD VSS gf180mcu_as_sc_mcu7t3v3__tap_2
XTAP_TAPCELL_ROW_175_1566 VDD VSS gf180mcu_as_sc_mcu7t3v3__tap_2
XFILLER_170_807 VDD VDD VSS VSS gf180mcu_as_sc_mcu7t3v3__fillcap_8
XFILLER_182_667 VDD VDD VSS VSS gf180mcu_as_sc_mcu7t3v3__fillcap_4
XFILLER_6_869 VDD VDD VSS VSS gf180mcu_as_sc_mcu7t3v3__fillcap_4
XTAP_TAPCELL_ROW_192_1891 VDD VSS gf180mcu_as_sc_mcu7t3v3__tap_2
XFILLER_5_368 VDD VDD VSS VSS gf180mcu_as_sc_mcu7t3v3__fill_2
XFILLER_174_53 VDD VDD VSS VSS gf180mcu_as_sc_mcu7t3v3__fillcap_16
XFILLER_190_1227 VDD VDD VSS VSS gf180mcu_as_sc_mcu7t3v3__fillcap_16
XFILLER_155_1347 VDD VDD VSS VSS gf180mcu_as_sc_mcu7t3v3__fillcap_4
XFILLER_174_97 VDD VDD VSS VSS gf180mcu_as_sc_mcu7t3v3__fillcap_8
XFILLER_3_26 VDD VDD VSS VSS gf180mcu_as_sc_mcu7t3v3__fillcap_4
XFILLER_7_1135 VDD VDD VSS VSS gf180mcu_as_sc_mcu7t3v3__fill_1
XFILLER_7_1168 VDD VDD VSS VSS gf180mcu_as_sc_mcu7t3v3__fillcap_4
XFILLER_75_1326 VDD VDD VSS VSS gf180mcu_as_sc_mcu7t3v3__fill_2
XFILLER_83_72 VDD VDD VSS VSS gf180mcu_as_sc_mcu7t3v3__fillcap_4
XFILLER_162_1329 VDD VDD VSS VSS gf180mcu_as_sc_mcu7t3v3__fill_1
XFILLER_177_406 VDD VDD VSS VSS gf180mcu_as_sc_mcu7t3v3__fill_2
X_3770_ VDD VDD VSS VSS _3859_/B _4116_/A _3772_/C gf180mcu_as_sc_mcu7t3v3__or2_2
XFILLER_173_601 VDD VDD VSS VSS gf180mcu_as_sc_mcu7t3v3__fillcap_4
X_2721_ VDD VDD VSS VSS _4052_/A _2827_/B _2721_/C _2721_/D _2722_/D gf180mcu_as_sc_mcu7t3v3__ao211_2
XFILLER_185_472 VDD VDD VSS VSS gf180mcu_as_sc_mcu7t3v3__fillcap_16
X_4750__1022 VDD VDD VSS VSS _4750_/D gf180mcu_as_sc_mcu7t3v3__tiel_4
X_2652_ VDD VDD VSS VSS _2976_/A _2871_/D _4764_/Q gf180mcu_as_sc_mcu7t3v3__nor2_2
XTAP_TAPCELL_ROW_11_893 VDD VSS gf180mcu_as_sc_mcu7t3v3__tap_2
XFILLER_154_870 VDD VDD VSS VSS gf180mcu_as_sc_mcu7t3v3__fillcap_4
XFILLER_161_818 VDD VDD VSS VSS gf180mcu_as_sc_mcu7t3v3__fillcap_16
XFILLER_172_177 VDD VDD VSS VSS gf180mcu_as_sc_mcu7t3v3__fill_2
Xoutput415 VDD VDD VSS VSS _4740_/Q west_out[11] gf180mcu_as_sc_mcu7t3v3__buff_12
Xoutput426 VDD VDD VSS VSS _4750_/Q west_out[21] gf180mcu_as_sc_mcu7t3v3__buff_12
Xoutput404 VDD VDD VSS VSS _4691_/Q south_out[34] gf180mcu_as_sc_mcu7t3v3__buff_12
X_2583_ VDD VDD VSS VSS _4830_/D _2583_/B _4635_/Q _4634_/D gf180mcu_as_sc_mcu7t3v3__mux2_2
XFILLER_153_380 VDD VDD VSS VSS gf180mcu_as_sc_mcu7t3v3__fillcap_16
Xoutput437 VDD VDD VSS VSS _4760_/Q west_out[31] gf180mcu_as_sc_mcu7t3v3__buff_12
X_4322_ VDD VDD VSS VSS _4804_/D _4322_/A _4799_/D gf180mcu_as_sc_mcu7t3v3__and2_2
X_4253_ VDD VDD VSS VSS _4262_/A _4253_/B _4253_/A gf180mcu_as_sc_mcu7t3v3__nand2_2
X_3204_ VDD VDD VSS VSS _3206_/B _4360_/Q _3205_/A gf180mcu_as_sc_mcu7t3v3__nand2b_2
XFILLER_136_1291 VDD VDD VSS VSS gf180mcu_as_sc_mcu7t3v3__fillcap_16
XFILLER_171_1182 VDD VDD VSS VSS gf180mcu_as_sc_mcu7t3v3__fillcap_8
X_4184_ VDD VDD VSS VSS _4185_/C _4184_/A _4184_/B _4184_/C gf180mcu_as_sc_mcu7t3v3__ao21_2
X_3135_ VDD VDD VSS VSS _4511_/Q _3191_/A _3574_/D _3135_/D _3166_/C gf180mcu_as_sc_mcu7t3v3__ao211_2
XFILLER_103_27 VDD VDD VSS VSS gf180mcu_as_sc_mcu7t3v3__fillcap_4
X_3066_ VDD VDD VSS VSS _3070_/S _3518_/B _4465_/Q _4465_/D gf180mcu_as_sc_mcu7t3v3__mux2_2
XPHY_EDGE_ROW_111_3_Right_152 VDD VSS gf180mcu_as_sc_mcu7t3v3__tap_2
XFILLER_169_907 VDD VDD VSS VSS gf180mcu_as_sc_mcu7t3v3__fill_2
XFILLER_56_1281 VDD VDD VSS VSS gf180mcu_as_sc_mcu7t3v3__fillcap_8
X_3968_ VDD VDD VSS VSS _4692_/D _4272_/C _3968_/B _3968_/A gf180mcu_as_sc_mcu7t3v3__aoi21_2
XPHY_EDGE_ROW_127_1_Right_636 VDD VSS gf180mcu_as_sc_mcu7t3v3__tap_2
XFILLER_13_1107 VDD VDD VSS VSS gf180mcu_as_sc_mcu7t3v3__fill_2
X_2919_ VDD VDD VSS VSS _4238_/A _2919_/B _2919_/C _2919_/D _3006_/A gf180mcu_as_sc_mcu7t3v3__ao211_2
XTAP_TAPCELL_ROW_157_1230 VDD VSS gf180mcu_as_sc_mcu7t3v3__tap_2
X_3899_ VDD VDD VSS VSS _3916_/B _4234_/A _3900_/B gf180mcu_as_sc_mcu7t3v3__and2_2
XFILLER_164_667 VDD VDD VSS VSS gf180mcu_as_sc_mcu7t3v3__fill_2
XTAP_TAPCELL_ROW_153_1149 VDD VSS gf180mcu_as_sc_mcu7t3v3__tap_2
XFILLER_191_486 VDD VDD VSS VSS gf180mcu_as_sc_mcu7t3v3__fillcap_4
XFILLER_3_828 VDD VDD VSS VSS gf180mcu_as_sc_mcu7t3v3__fillcap_4
XTAP_TAPCELL_ROW_170_1485 VDD VSS gf180mcu_as_sc_mcu7t3v3__tap_2
XTAP_TAPCELL_ROW_170_1474 VDD VSS gf180mcu_as_sc_mcu7t3v3__tap_2
XFILLER_176_1082 VDD VDD VSS VSS gf180mcu_as_sc_mcu7t3v3__fill_2
XTAP_TAPCELL_ROW_102_3_2013 VDD VSS gf180mcu_as_sc_mcu7t3v3__tap_2
XFILLER_144_34 VDD VDD VSS VSS gf180mcu_as_sc_mcu7t3v3__fill_1
XFILLER_160_884 VDD VDD VSS VSS gf180mcu_as_sc_mcu7t3v3__fillcap_16
Xfanout620 VDD VDD VSS VSS _3389_/B _3373_/B gf180mcu_as_sc_mcu7t3v3__buff_12
Xfanout631 VDD VDD VSS VSS fanout632/A _2915_/B gf180mcu_as_sc_mcu7t3v3__buff_12
Xfanout642 VDD VDD VSS VSS fanout642/A _4151_/A gf180mcu_as_sc_mcu7t3v3__buff_12
XFILLER_63_1285 VDD VDD VSS VSS gf180mcu_as_sc_mcu7t3v3__fillcap_4
Xfanout653 VDD VDD VSS VSS _3641_/Y _3869_/C gf180mcu_as_sc_mcu7t3v3__buff_12
Xfanout664 VDD VDD VSS VSS _3540_/S _3583_/A gf180mcu_as_sc_mcu7t3v3__buff_12
Xfanout686 VDD VDD VSS VSS _3070_/S _3068_/S gf180mcu_as_sc_mcu7t3v3__buff_12
Xfanout697 VDD VDD VSS VSS _3867_/D _3795_/D gf180mcu_as_sc_mcu7t3v3__buff_12
XFILLER_98_1326 VDD VDD VSS VSS gf180mcu_as_sc_mcu7t3v3__fillcap_4
XFILLER_160_33 VDD VDD VSS VSS gf180mcu_as_sc_mcu7t3v3__fill_2
XFILLER_37_65 VDD VDD VSS VSS gf180mcu_as_sc_mcu7t3v3__fillcap_4
XFILLER_159_417 VDD VDD VSS VSS gf180mcu_as_sc_mcu7t3v3__fill_2
XFILLER_183_1064 VDD VDD VSS VSS gf180mcu_as_sc_mcu7t3v3__fill_2
XTAP_TAPCELL_ROW_177_1606 VDD VSS gf180mcu_as_sc_mcu7t3v3__tap_2
XFILLER_53_86 VDD VDD VSS VSS gf180mcu_as_sc_mcu7t3v3__fill_1
XTAP_TAPCELL_ROW_177_1617 VDD VSS gf180mcu_as_sc_mcu7t3v3__tap_2
XFILLER_174_409 VDD VDD VSS VSS gf180mcu_as_sc_mcu7t3v3__fill_1
XFILLER_186_247 VDD VDD VSS VSS gf180mcu_as_sc_mcu7t3v3__fillcap_16
XFILLER_70_1256 VDD VDD VSS VSS gf180mcu_as_sc_mcu7t3v3__fillcap_16
XFILLER_182_420 VDD VDD VSS VSS gf180mcu_as_sc_mcu7t3v3__fillcap_8
XFILLER_183_998 VDD VDD VSS VSS gf180mcu_as_sc_mcu7t3v3__fillcap_4
XFILLER_154_188 VDD VDD VSS VSS gf180mcu_as_sc_mcu7t3v3__fill_2
XFILLER_159_1291 VDD VDD VSS VSS gf180mcu_as_sc_mcu7t3v3__fillcap_16
XFILLER_190_1057 VDD VDD VSS VSS gf180mcu_as_sc_mcu7t3v3__fill_1
XTAP_TAPCELL_ROW_37_3_1948 VDD VSS gf180mcu_as_sc_mcu7t3v3__tap_2
Xclkbuf_3_2__f_clk_regs VDD VDD VSS VSS clkbuf_2_1_0_clk_regs/Y clkbuf_leaf_9_clk_regs/A
+ gf180mcu_as_sc_mcu7t3v3__clkbuff_12
X_3822_ VDD VDD VSS VSS _4166_/A _3867_/B _3822_/C _3867_/D _3824_/C gf180mcu_as_sc_mcu7t3v3__ao211_2
XFILLER_145_100 VDD VDD VSS VSS gf180mcu_as_sc_mcu7t3v3__fillcap_4
XFILLER_158_461 VDD VDD VSS VSS gf180mcu_as_sc_mcu7t3v3__fill_2
XFILLER_174_921 VDD VDD VSS VSS gf180mcu_as_sc_mcu7t3v3__fillcap_16
XFILLER_192_206 VDD VDD VSS VSS gf180mcu_as_sc_mcu7t3v3__fillcap_4
X_3753_ VDD VDD VSS VSS _4784_/Q _3852_/B _3879_/B _4102_/D _3754_/D gf180mcu_as_sc_mcu7t3v3__ao22_2
XPHY_EDGE_ROW_51_1_Right_560 VDD VSS gf180mcu_as_sc_mcu7t3v3__tap_2
XFILLER_9_471 VDD VDD VSS VSS gf180mcu_as_sc_mcu7t3v3__fill_1
X_3684_ VDD VDD VSS VSS _3747_/S _3684_/B _4042_/A _3685_/B gf180mcu_as_sc_mcu7t3v3__mux2_2
X_2704_ VDD VDD VSS VSS _4039_/D _2822_/B _2704_/C _2704_/D _2705_/C gf180mcu_as_sc_mcu7t3v3__ao211_2
XFILLER_12_1173 VDD VDD VSS VSS gf180mcu_as_sc_mcu7t3v3__fillcap_8
XFILLER_173_453 VDD VDD VSS VSS gf180mcu_as_sc_mcu7t3v3__fill_2
X_2635_ VDD VDD VSS VSS _2635_/D _2660_/B _2662_/A _2635_/C _2659_/B gf180mcu_as_sc_mcu7t3v3__ao31_2
Xclkbuf_leaf_32_clk_regs VDD VDD VSS VSS clkbuf_3_4__f_clk_regs/Y _4807_/CLK gf180mcu_as_sc_mcu7t3v3__clkbuff_12
XFILLER_0_809 VDD VDD VSS VSS gf180mcu_as_sc_mcu7t3v3__fill_2
X_4305_ VDD VDD VSS VSS _4310_/B _4529_/Q _4782_/D gf180mcu_as_sc_mcu7t3v3__and2_2
X_2566_ VDD VDD VSS VSS _2566_/A _2566_/B _2566_/C _3081_/A _2566_/D gf180mcu_as_sc_mcu7t3v3__aoi31_2
XFILLER_173_1255 VDD VDD VSS VSS gf180mcu_as_sc_mcu7t3v3__fillcap_4
X_2497_ VDD VDD VSS VSS _4806_/Q _2497_/B _2497_/A _5072_/A gf180mcu_as_sc_mcu7t3v3__mux2_2
X_4236_ VDD VDD VSS VSS _4236_/A _4236_/B _4236_/C _4236_/D _4237_/D gf180mcu_as_sc_mcu7t3v3__ao22_2
XTAP_TAPCELL_ROW_149_3_2060 VDD VSS gf180mcu_as_sc_mcu7t3v3__tap_2
XFILLER_114_48 VDD VDD VSS VSS gf180mcu_as_sc_mcu7t3v3__fillcap_4
X_4167_ VDD VDD VSS VSS _4792_/Q _4208_/B _4208_/C _4167_/D _4168_/C gf180mcu_as_sc_mcu7t3v3__ao22_2
X_3118_ VDD VDD VSS VSS _3120_/S _4506_/Q _4505_/Q _4505_/D gf180mcu_as_sc_mcu7t3v3__mux2_2
X_4098_ VDD VDD VSS VSS _4163_/S _4098_/B _4098_/A _4099_/B gf180mcu_as_sc_mcu7t3v3__mux2_2
X_3049_ VDD VDD VSS VSS _3049_/B _3053_/B _3054_/B gf180mcu_as_sc_mcu7t3v3__and2_2
XPHY_EDGE_ROW_112_3_Right_153 VDD VSS gf180mcu_as_sc_mcu7t3v3__tap_2
XFILLER_12_938 VDD VDD VSS VSS gf180mcu_as_sc_mcu7t3v3__fillcap_4
XFILLER_93_1278 VDD VDD VSS VSS gf180mcu_as_sc_mcu7t3v3__fill_1
XFILLER_90_29 VDD VDD VSS VSS gf180mcu_as_sc_mcu7t3v3__fillcap_4
XFILLER_11_437 VDD VDD VSS VSS gf180mcu_as_sc_mcu7t3v3__fillcap_4
XFILLER_168_247 VDD VDD VSS VSS gf180mcu_as_sc_mcu7t3v3__fillcap_16
XPHY_EDGE_ROW_128_1_Right_637 VDD VSS gf180mcu_as_sc_mcu7t3v3__tap_2
XFILLER_23_78 VDD VDD VSS VSS gf180mcu_as_sc_mcu7t3v3__fill_1
XFILLER_139_67 VDD VDD VSS VSS gf180mcu_as_sc_mcu7t3v3__fill_2
XTAP_TAPCELL_ROW_172_1514 VDD VSS gf180mcu_as_sc_mcu7t3v3__tap_2
XFILLER_99_27 VDD VDD VSS VSS gf180mcu_as_sc_mcu7t3v3__fill_2
XFILLER_165_998 VDD VDD VSS VSS gf180mcu_as_sc_mcu7t3v3__fillcap_8
XFILLER_30_1262 VDD VDD VSS VSS gf180mcu_as_sc_mcu7t3v3__fill_1
XFILLER_152_626 VDD VDD VSS VSS gf180mcu_as_sc_mcu7t3v3__fillcap_8
XFILLER_152_1328 VDD VDD VSS VSS gf180mcu_as_sc_mcu7t3v3__fillcap_16
Xfanout450 VDD VDD VSS VSS _2977_/Y _2993_/C gf180mcu_as_sc_mcu7t3v3__buff_12
XFILLER_48_64 VDD VDD VSS VSS gf180mcu_as_sc_mcu7t3v3__fillcap_8
Xfanout461 VDD VDD VSS VSS _3632_/Y _3847_/B gf180mcu_as_sc_mcu7t3v3__buff_12
Xfanout472 VDD VDD VSS VSS _2951_/B _2945_/C gf180mcu_as_sc_mcu7t3v3__buff_12
Xfanout483 VDD VDD VSS VSS _2951_/D _2945_/B gf180mcu_as_sc_mcu7t3v3__buff_12
XTAP_TAPCELL_ROW_187_1790 VDD VSS gf180mcu_as_sc_mcu7t3v3__tap_2
XFILLER_171_76 VDD VDD VSS VSS gf180mcu_as_sc_mcu7t3v3__fill_2
Xfanout494 VDD VDD VSS VSS _4004_/Y _4253_/B gf180mcu_as_sc_mcu7t3v3__buff_12
XPHY_EDGE_ROW_137_1_Left_329 VDD VSS gf180mcu_as_sc_mcu7t3v3__tap_2
XFILLER_189_1262 VDD VDD VSS VSS gf180mcu_as_sc_mcu7t3v3__fill_1
XPHY_EDGE_ROW_90_1_Right_599 VDD VSS gf180mcu_as_sc_mcu7t3v3__tap_2
XPHY_EDGE_ROW_138_3_Left_510 VDD VSS gf180mcu_as_sc_mcu7t3v3__tap_2
XFILLER_120_80 VDD VDD VSS VSS gf180mcu_as_sc_mcu7t3v3__fillcap_16
XFILLER_159_247 VDD VDD VSS VSS gf180mcu_as_sc_mcu7t3v3__fillcap_8
XTAP_TAPCELL_ROW_13_944 VDD VSS gf180mcu_as_sc_mcu7t3v3__tap_2
XTAP_TAPCELL_ROW_13_933 VDD VSS gf180mcu_as_sc_mcu7t3v3__tap_2
XFILLER_156_921 VDD VDD VSS VSS gf180mcu_as_sc_mcu7t3v3__fillcap_8
XFILLER_80_62 VDD VDD VSS VSS gf180mcu_as_sc_mcu7t3v3__fillcap_8
XTAP_TAPCELL_ROW_13_966 VDD VSS gf180mcu_as_sc_mcu7t3v3__tap_2
XTAP_TAPCELL_ROW_13_955 VDD VSS gf180mcu_as_sc_mcu7t3v3__tap_2
XFILLER_11_982 VDD VDD VSS VSS gf180mcu_as_sc_mcu7t3v3__fillcap_16
XFILLER_161_1192 VDD VDD VSS VSS gf180mcu_as_sc_mcu7t3v3__fillcap_16
XFILLER_156_976 VDD VDD VSS VSS gf180mcu_as_sc_mcu7t3v3__fill_1
XFILLER_155_486 VDD VDD VSS VSS gf180mcu_as_sc_mcu7t3v3__fillcap_4
XFILLER_157_1217 VDD VDD VSS VSS gf180mcu_as_sc_mcu7t3v3__fill_1
XFILLER_192_1119 VDD VDD VSS VSS gf180mcu_as_sc_mcu7t3v3__fill_2
XFILLER_6_496 VDD VDD VSS VSS gf180mcu_as_sc_mcu7t3v3__fillcap_4
Xmax_cap639 VDD VDD VSS VSS _3989_/Y fanout638/A gf180mcu_as_sc_mcu7t3v3__clkbuff_12
X_2420_ VDD VDD VSS VSS _2420_/Y _2494_/A _2420_/B _2420_/C _2420_/D gf180mcu_as_sc_mcu7t3v3__aoi22_2
XTAP_TAPCELL_ROW_92_1_1045 VDD VSS gf180mcu_as_sc_mcu7t3v3__tap_2
X_2351_ VDD VDD VSS VSS _2352_/D _2494_/A _2437_/B input1/Y gf180mcu_as_sc_mcu7t3v3__aoi21b_2
X_5070_ VDD VDD VSS VSS _5070_/A _5070_/Y gf180mcu_as_sc_mcu7t3v3__buff_2
X_2282_ VDD VDD VSS VSS _2295_/B _2282_/B _2287_/B gf180mcu_as_sc_mcu7t3v3__nor2b_2
XFILLER_9_1049 VDD VDD VSS VSS gf180mcu_as_sc_mcu7t3v3__fill_1
X_4021_ VDD VDD VSS VSS _4774_/Q _4134_/B _4217_/C _4021_/D _4022_/C gf180mcu_as_sc_mcu7t3v3__ao22_2
XFILLER_168_1346 VDD VDD VSS VSS gf180mcu_as_sc_mcu7t3v3__fillcap_4
XPHY_EDGE_ROW_122_3_Left_494 VDD VSS gf180mcu_as_sc_mcu7t3v3__tap_2
XFILLER_165_206 VDD VDD VSS VSS gf180mcu_as_sc_mcu7t3v3__fillcap_4
X_4785_ VDD VDD VSS VSS clkload7/A _4785_/D _4785_/Q gf180mcu_as_sc_mcu7t3v3__dfxtp_2
X_3805_ VDD VDD VSS VSS _3806_/D _4149_/A _3870_/A _3823_/C gf180mcu_as_sc_mcu7t3v3__ao21_2
X_3736_ VDD VDD VSS VSS _4088_/A _3799_/B _3808_/C _4085_/D _3737_/D gf180mcu_as_sc_mcu7t3v3__ao22_2
XFILLER_140_1287 VDD VDD VSS VSS gf180mcu_as_sc_mcu7t3v3__fill_2
XPHY_EDGE_ROW_52_1_Right_561 VDD VSS gf180mcu_as_sc_mcu7t3v3__tap_2
X_3667_ VDD VDD VSS VSS _3667_/B _3748_/A _4659_/D gf180mcu_as_sc_mcu7t3v3__and2_2
X_3598_ VDD VDD VSS VSS _3598_/B _4652_/Q _3599_/C gf180mcu_as_sc_mcu7t3v3__xnor2_2
X_2618_ VDD VDD VSS VSS _3614_/B _4804_/Q _4264_/B gf180mcu_as_sc_mcu7t3v3__and2_2
XFILLER_173_1052 VDD VDD VSS VSS gf180mcu_as_sc_mcu7t3v3__fillcap_8
X_2549_ VDD VDD VSS VSS _3131_/B _4625_/Q _2549_/C _4624_/Q _3555_/B gf180mcu_as_sc_mcu7t3v3__ao22_2
XFILLER_125_69 VDD VDD VSS VSS gf180mcu_as_sc_mcu7t3v3__fill_1
X_4219_ VDD VDD VSS VSS _4219_/A _4227_/C _4219_/C _4219_/D _4220_/D gf180mcu_as_sc_mcu7t3v3__ao211_2
XFILLER_18_56 VDD VDD VSS VSS gf180mcu_as_sc_mcu7t3v3__fillcap_4
XFILLER_18_67 VDD VDD VSS VSS gf180mcu_as_sc_mcu7t3v3__fillcap_8
XFILLER_60_1299 VDD VDD VSS VSS gf180mcu_as_sc_mcu7t3v3__fillcap_4
XTAP_TAPCELL_ROW_165_1384 VDD VSS gf180mcu_as_sc_mcu7t3v3__tap_2
XTAP_TAPCELL_ROW_165_1373 VDD VSS gf180mcu_as_sc_mcu7t3v3__tap_2
XFILLER_141_68 VDD VDD VSS VSS gf180mcu_as_sc_mcu7t3v3__fill_2
XFILLER_180_1012 VDD VDD VSS VSS gf180mcu_as_sc_mcu7t3v3__fill_2
XPHY_EDGE_ROW_113_3_Right_154 VDD VSS gf180mcu_as_sc_mcu7t3v3__tap_2
XFILLER_180_1067 VDD VDD VSS VSS gf180mcu_as_sc_mcu7t3v3__fillcap_16
XPHY_EDGE_ROW_129_1_Right_638 VDD VSS gf180mcu_as_sc_mcu7t3v3__tap_2
XFILLER_32_1324 VDD VDD VSS VSS gf180mcu_as_sc_mcu7t3v3__fillcap_4
XFILLER_7_216 VDD VDD VSS VSS gf180mcu_as_sc_mcu7t3v3__fill_2
XFILLER_165_762 VDD VDD VSS VSS gf180mcu_as_sc_mcu7t3v3__fillcap_8
XFILLER_50_54 VDD VDD VSS VSS gf180mcu_as_sc_mcu7t3v3__fillcap_8
XFILLER_152_434 VDD VDD VSS VSS gf180mcu_as_sc_mcu7t3v3__fillcap_4
XFILLER_165_784 VDD VDD VSS VSS gf180mcu_as_sc_mcu7t3v3__fill_2
XFILLER_153_979 VDD VDD VSS VSS gf180mcu_as_sc_mcu7t3v3__fill_1
XFILLER_3_422 VDD VDD VSS VSS gf180mcu_as_sc_mcu7t3v3__fill_1
XFILLER_152_478 VDD VDD VSS VSS gf180mcu_as_sc_mcu7t3v3__fillcap_16
XFILLER_156_1250 VDD VDD VSS VSS gf180mcu_as_sc_mcu7t3v3__fillcap_8
XFILLER_3_477 VDD VDD VSS VSS gf180mcu_as_sc_mcu7t3v3__fill_1
XFILLER_69_1291 VDD VDD VSS VSS gf180mcu_as_sc_mcu7t3v3__fillcap_8
XTAP_TAPCELL_ROW_189_1841 VDD VSS gf180mcu_as_sc_mcu7t3v3__tap_2
XTAP_TAPCELL_ROW_189_1830 VDD VSS gf180mcu_as_sc_mcu7t3v3__tap_2
XFILLER_117_1256 VDD VDD VSS VSS gf180mcu_as_sc_mcu7t3v3__fillcap_4
XFILLER_156_1294 VDD VDD VSS VSS gf180mcu_as_sc_mcu7t3v3__fill_1
XFILLER_152_1158 VDD VDD VSS VSS gf180mcu_as_sc_mcu7t3v3__fill_2
XFILLER_189_1092 VDD VDD VSS VSS gf180mcu_as_sc_mcu7t3v3__fillcap_16
XFILLER_163_1221 VDD VDD VSS VSS gf180mcu_as_sc_mcu7t3v3__fill_2
XFILLER_91_72 VDD VDD VSS VSS gf180mcu_as_sc_mcu7t3v3__fillcap_4
XPHY_EDGE_ROW_7_Left_200 VDD VSS gf180mcu_as_sc_mcu7t3v3__tap_2
XFILLER_175_559 VDD VDD VSS VSS gf180mcu_as_sc_mcu7t3v3__fill_1
X_4570_ VDD VDD VSS VSS _4728_/CLK _4570_/D _4570_/Q gf180mcu_as_sc_mcu7t3v3__dfxtp_2
XFILLER_156_762 VDD VDD VSS VSS gf180mcu_as_sc_mcu7t3v3__fillcap_8
X_3521_ VDD VDD VSS VSS _3529_/S _4608_/Q _3521_/A _4608_/D gf180mcu_as_sc_mcu7t3v3__mux2_2
XFILLER_7_772 VDD VDD VSS VSS gf180mcu_as_sc_mcu7t3v3__fillcap_16
XFILLER_157_1047 VDD VDD VSS VSS gf180mcu_as_sc_mcu7t3v3__fill_2
XFILLER_171_776 VDD VDD VSS VSS gf180mcu_as_sc_mcu7t3v3__fill_1
X_3452_ VDD VDD VSS VSS _3520_/S _4472_/Q _4575_/Q _4575_/D gf180mcu_as_sc_mcu7t3v3__mux2_2
XFILLER_135_1301 VDD VDD VSS VSS gf180mcu_as_sc_mcu7t3v3__fillcap_16
X_3383_ VDD VDD VSS VSS _3386_/B _3383_/A gf180mcu_as_sc_mcu7t3v3__inv_2
X_2403_ VDD VDD VSS VSS _2404_/C _2403_/B _2426_/C gf180mcu_as_sc_mcu7t3v3__nor2_2
X_2334_ VDD VDD VSS VSS _3610_/A _4653_/Q _4650_/Q _2334_/Y gf180mcu_as_sc_mcu7t3v3__nor3_2
XFILLER_83_1299 VDD VDD VSS VSS gf180mcu_as_sc_mcu7t3v3__fillcap_8
X_2265_ VDD VDD VSS VSS _3541_/B _4575_/Q _3131_/A gf180mcu_as_sc_mcu7t3v3__nor2_2
X_4004_ VDD VDD VSS VSS _4004_/Y _4272_/B _4005_/A gf180mcu_as_sc_mcu7t3v3__nor2_2
X_2196_ VDD VDD VSS VSS _3474_/A _4622_/Q gf180mcu_as_sc_mcu7t3v3__inv_2
XFILLER_1_92 VDD VDD VSS VSS gf180mcu_as_sc_mcu7t3v3__fill_1
XFILLER_111_38 VDD VDD VSS VSS gf180mcu_as_sc_mcu7t3v3__fillcap_8
XFILLER_168_1154 VDD VDD VSS VSS gf180mcu_as_sc_mcu7t3v3__fill_1
XTAP_TAPCELL_ROW_160_1281 VDD VSS gf180mcu_as_sc_mcu7t3v3__tap_2
XFILLER_181_1354 VDD VDD VSS VSS gf180mcu_as_sc_mcu7t3v3__fill_1
XTAP_TAPCELL_ROW_160_1292 VDD VSS gf180mcu_as_sc_mcu7t3v3__tap_2
XFILLER_166_559 VDD VDD VSS VSS gf180mcu_as_sc_mcu7t3v3__fillcap_16
X_4768_ VDD VDD VSS VSS _4803_/CLK _4768_/D _4768_/Q gf180mcu_as_sc_mcu7t3v3__dfxtp_2
XFILLER_162_710 VDD VDD VSS VSS gf180mcu_as_sc_mcu7t3v3__fillcap_16
X_4699_ VDD VDD VSS VSS _4726_/CLK _4699_/D _4699_/Q gf180mcu_as_sc_mcu7t3v3__dfxtp_2
X_3719_ VDD VDD VSS VSS _4073_/A _3800_/B _3719_/C _3719_/D _3720_/B gf180mcu_as_sc_mcu7t3v3__ao211_2
XPHY_EDGE_ROW_53_1_Right_562 VDD VSS gf180mcu_as_sc_mcu7t3v3__tap_2
XFILLER_20_57 VDD VDD VSS VSS gf180mcu_as_sc_mcu7t3v3__fill_1
XTAP_TAPCELL_ROW_36_1_989 VDD VSS gf180mcu_as_sc_mcu7t3v3__tap_2
XFILLER_161_253 VDD VDD VSS VSS gf180mcu_as_sc_mcu7t3v3__fillcap_16
XFILLER_162_787 VDD VDD VSS VSS gf180mcu_as_sc_mcu7t3v3__fillcap_4
XFILLER_1_904 VDD VDD VSS VSS gf180mcu_as_sc_mcu7t3v3__fillcap_4
XFILLER_0_414 VDD VDD VSS VSS gf180mcu_as_sc_mcu7t3v3__fill_2
Xinput304 VDD VDD VSS VSS west_in[16] _4133_/A gf180mcu_as_sc_mcu7t3v3__buff_12
Xinput315 VDD VDD VSS VSS west_in[26] _4217_/A gf180mcu_as_sc_mcu7t3v3__buff_12
Xinput326 VDD VDD VSS VSS west_in[3] _4031_/D gf180mcu_as_sc_mcu7t3v3__buff_12
XTAP_TAPCELL_ROW_167_1424 VDD VSS gf180mcu_as_sc_mcu7t3v3__tap_2
XTAP_TAPCELL_ROW_167_1413 VDD VSS gf180mcu_as_sc_mcu7t3v3__tap_2
XFILLER_29_88 VDD VDD VSS VSS gf180mcu_as_sc_mcu7t3v3__fillcap_16
XTAP_TAPCELL_ROW_4_775 VDD VSS gf180mcu_as_sc_mcu7t3v3__tap_2
XTAP_TAPCELL_ROW_4_764 VDD VSS gf180mcu_as_sc_mcu7t3v3__tap_2
XTAP_TAPCELL_ROW_180_1657 VDD VSS gf180mcu_as_sc_mcu7t3v3__tap_2
XFILLER_186_1243 VDD VDD VSS VSS gf180mcu_as_sc_mcu7t3v3__fillcap_16
XTAP_TAPCELL_ROW_180_1668 VDD VSS gf180mcu_as_sc_mcu7t3v3__tap_2
XFILLER_186_1287 VDD VDD VSS VSS gf180mcu_as_sc_mcu7t3v3__fillcap_8
XFILLER_45_98 VDD VDD VSS VSS gf180mcu_as_sc_mcu7t3v3__fillcap_4
XFILLER_12_521 VDD VDD VSS VSS gf180mcu_as_sc_mcu7t3v3__fillcap_4
XFILLER_157_515 VDD VDD VSS VSS gf180mcu_as_sc_mcu7t3v3__fillcap_16
XFILLER_185_824 VDD VDD VSS VSS gf180mcu_as_sc_mcu7t3v3__fill_2
XPHY_EDGE_ROW_114_3_Right_155 VDD VSS gf180mcu_as_sc_mcu7t3v3__tap_2
XFILLER_157_559 VDD VDD VSS VSS gf180mcu_as_sc_mcu7t3v3__fill_1
XFILLER_185_846 VDD VDD VSS VSS gf180mcu_as_sc_mcu7t3v3__fill_2
XFILLER_123_1260 VDD VDD VSS VSS gf180mcu_as_sc_mcu7t3v3__fillcap_8
XFILLER_177_64 VDD VDD VSS VSS gf180mcu_as_sc_mcu7t3v3__fillcap_4
XFILLER_184_356 VDD VDD VSS VSS gf180mcu_as_sc_mcu7t3v3__fill_1
XANTENNA_8 VDD VDD VSS VSS _4708_/D gf180mcu_as_sc_mcu7t3v3__diode_2
XFILLER_158_1323 VDD VDD VSS VSS gf180mcu_as_sc_mcu7t3v3__fillcap_16
XFILLER_6_37 VDD VDD VSS VSS gf180mcu_as_sc_mcu7t3v3__fillcap_16
Xmesh_tile_908 VDD VDD VSS VSS nw_out[8] gf180mcu_as_sc_mcu7t3v3__tiel_4
Xmesh_tile_919 VDD VDD VSS VSS nw_out[19] gf180mcu_as_sc_mcu7t3v3__tiel_4
XFILLER_187_1018 VDD VDD VSS VSS gf180mcu_as_sc_mcu7t3v3__fillcap_4
XFILLER_43_1272 VDD VDD VSS VSS gf180mcu_as_sc_mcu7t3v3__fillcap_4
XTAP_TAPCELL_ROW_87_1_1040 VDD VSS gf180mcu_as_sc_mcu7t3v3__tap_2
XPHY_EDGE_ROW_18_1_Left_210 VDD VSS gf180mcu_as_sc_mcu7t3v3__tap_2
XTAP_TAPCELL_ROW_101_1_1054 VDD VSS gf180mcu_as_sc_mcu7t3v3__tap_2
XFILLER_165_1305 VDD VDD VSS VSS gf180mcu_as_sc_mcu7t3v3__fillcap_8
X_2952_ VDD VDD VSS VSS _2994_/A _2966_/A _3025_/A gf180mcu_as_sc_mcu7t3v3__and2_2
XFILLER_188_662 VDD VDD VSS VSS gf180mcu_as_sc_mcu7t3v3__fill_2
XFILLER_188_684 VDD VDD VSS VSS gf180mcu_as_sc_mcu7t3v3__fill_2
XFILLER_89_2 VDD VDD VSS VSS gf180mcu_as_sc_mcu7t3v3__fillcap_4
X_2883_ VDD VDD VSS VSS _4796_/Q _2892_/B _2894_/B _4198_/A _2885_/C gf180mcu_as_sc_mcu7t3v3__ao22_2
XFILLER_102_1311 VDD VDD VSS VSS gf180mcu_as_sc_mcu7t3v3__fillcap_8
XFILLER_11_1205 VDD VDD VSS VSS gf180mcu_as_sc_mcu7t3v3__fillcap_4
X_4622_ VDD VDD VSS VSS _4820_/CLK _4622_/D _4622_/Q gf180mcu_as_sc_mcu7t3v3__dfxtp_2
X_4553_ VDD VDD VSS VSS _4719_/CLK _4553_/D _4553_/Q gf180mcu_as_sc_mcu7t3v3__dfxtp_2
X_4484_ VDD VDD VSS VSS _4720_/CLK _4484_/D _4484_/Q gf180mcu_as_sc_mcu7t3v3__dfxtp_2
X_3504_ VDD VDD VSS VSS _3507_/B _3504_/C _3525_/B _3505_/A gf180mcu_as_sc_mcu7t3v3__aoi21_2
XFILLER_171_562 VDD VDD VSS VSS gf180mcu_as_sc_mcu7t3v3__fillcap_4
XFILLER_172_1309 VDD VDD VSS VSS gf180mcu_as_sc_mcu7t3v3__fill_1
X_3435_ VDD VDD VSS VSS _4564_/Q _3439_/B _3439_/C _4563_/Q _4563_/D gf180mcu_as_sc_mcu7t3v3__ao22_2
XFILLER_170_1033 VDD VDD VSS VSS gf180mcu_as_sc_mcu7t3v3__fillcap_8
X_3366_ VDD VDD VSS VSS _3370_/B _4350_/Q _3368_/S gf180mcu_as_sc_mcu7t3v3__nand2b_2
X_3297_ VDD VDD VSS VSS _3298_/D _3297_/B _3314_/A gf180mcu_as_sc_mcu7t3v3__nor2_2
X_2317_ VDD VDD VSS VSS _3558_/B _3131_/A _3571_/D gf180mcu_as_sc_mcu7t3v3__nor2_2
X_2248_ VDD VDD VSS VSS _4292_/C _3580_/D _3474_/C gf180mcu_as_sc_mcu7t3v3__and2_2
XTAP_TAPCELL_ROW_1_701 VDD VSS gf180mcu_as_sc_mcu7t3v3__tap_2
XFILLER_122_37 VDD VDD VSS VSS gf180mcu_as_sc_mcu7t3v3__fillcap_16
XTAP_TAPCELL_ROW_1_712 VDD VSS gf180mcu_as_sc_mcu7t3v3__tap_2
XTAP_TAPCELL_ROW_162_1332 VDD VSS gf180mcu_as_sc_mcu7t3v3__tap_2
XTAP_TAPCELL_ROW_162_1321 VDD VSS gf180mcu_as_sc_mcu7t3v3__tap_2
X_2179_ VDD VDD VSS VSS _4280_/A _4768_/Q gf180mcu_as_sc_mcu7t3v3__inv_2
XFILLER_15_57 VDD VDD VSS VSS gf180mcu_as_sc_mcu7t3v3__fill_2
XFILLER_179_651 VDD VDD VSS VSS gf180mcu_as_sc_mcu7t3v3__fill_1
XFILLER_146_1260 VDD VDD VSS VSS gf180mcu_as_sc_mcu7t3v3__fill_2
XFILLER_181_1162 VDD VDD VSS VSS gf180mcu_as_sc_mcu7t3v3__fillcap_16
XFILLER_167_857 VDD VDD VSS VSS gf180mcu_as_sc_mcu7t3v3__fillcap_8
XPHY_EDGE_ROW_146_1_Left_338 VDD VSS gf180mcu_as_sc_mcu7t3v3__tap_2
XFILLER_190_893 VDD VDD VSS VSS gf180mcu_as_sc_mcu7t3v3__fill_1
XPHY_EDGE_ROW_54_1_Right_563 VDD VSS gf180mcu_as_sc_mcu7t3v3__tap_2
XFILLER_163_22 VDD VDD VSS VSS gf180mcu_as_sc_mcu7t3v3__fillcap_16
XTAP_TAPCELL_ROW_9_867 VDD VSS gf180mcu_as_sc_mcu7t3v3__tap_2
XTAP_TAPCELL_ROW_9_856 VDD VSS gf180mcu_as_sc_mcu7t3v3__tap_2
XFILLER_153_1231 VDD VDD VSS VSS gf180mcu_as_sc_mcu7t3v3__fillcap_4
XFILLER_153_1242 VDD VDD VSS VSS gf180mcu_as_sc_mcu7t3v3__fillcap_4
XFILLER_27_1256 VDD VDD VSS VSS gf180mcu_as_sc_mcu7t3v3__fillcap_8
Xinput101 VDD VDD VSS VSS ne_in[29] _4242_/D gf180mcu_as_sc_mcu7t3v3__buff_12
Xinput112 VDD VDD VSS VSS ne_in[6] _4055_/A gf180mcu_as_sc_mcu7t3v3__buff_12
Xinput123 VDD VDD VSS VSS north_in[16] _4134_/D gf180mcu_as_sc_mcu7t3v3__buff_12
Xinput134 VDD VDD VSS VSS north_in[26] _4217_/D gf180mcu_as_sc_mcu7t3v3__buff_12
Xinput145 VDD VDD VSS VSS north_in[3] _4029_/D gf180mcu_as_sc_mcu7t3v3__buff_12
XTAP_TAPCELL_ROW_182_1708 VDD VSS gf180mcu_as_sc_mcu7t3v3__tap_2
XFILLER_5_1041 VDD VDD VSS VSS gf180mcu_as_sc_mcu7t3v3__fill_1
Xinput156 VDD VDD VSS VSS nw_in[13] _4112_/D gf180mcu_as_sc_mcu7t3v3__buff_12
Xinput167 VDD VDD VSS VSS nw_in[23] _4194_/A gf180mcu_as_sc_mcu7t3v3__buff_12
Xinput178 VDD VDD VSS VSS nw_in[33] _3947_/A gf180mcu_as_sc_mcu7t3v3__buff_12
XFILLER_56_53 VDD VDD VSS VSS gf180mcu_as_sc_mcu7t3v3__fillcap_4
Xinput189 VDD VDD VSS VSS se_in[0] _4008_/D gf180mcu_as_sc_mcu7t3v3__buff_12
XFILLER_186_1084 VDD VDD VSS VSS gf180mcu_as_sc_mcu7t3v3__fill_1
XFILLER_31_104 VDD VDD VSS VSS gf180mcu_as_sc_mcu7t3v3__fill_1
XFILLER_13_852 VDD VDD VSS VSS gf180mcu_as_sc_mcu7t3v3__fill_1
XFILLER_38_1352 VDD VDD VSS VSS gf180mcu_as_sc_mcu7t3v3__fill_2
XPHY_EDGE_ROW_17_3_Left_389 VDD VSS gf180mcu_as_sc_mcu7t3v3__tap_2
XFILLER_185_632 VDD VDD VSS VSS gf180mcu_as_sc_mcu7t3v3__fillcap_16
XFILLER_72_96 VDD VDD VSS VSS gf180mcu_as_sc_mcu7t3v3__fillcap_8
XPHY_EDGE_ROW_115_3_Right_156 VDD VSS gf180mcu_as_sc_mcu7t3v3__tap_2
XFILLER_153_540 VDD VDD VSS VSS gf180mcu_as_sc_mcu7t3v3__fillcap_16
XFILLER_153_562 VDD VDD VSS VSS gf180mcu_as_sc_mcu7t3v3__fillcap_4
XFILLER_158_1153 VDD VDD VSS VSS gf180mcu_as_sc_mcu7t3v3__fill_2
XTAP_TAPCELL_ROW_120_3_2031 VDD VSS gf180mcu_as_sc_mcu7t3v3__tap_2
XPHY_EDGE_ROW_79_3_Left_451 VDD VSS gf180mcu_as_sc_mcu7t3v3__tap_2
XFILLER_98_104 VDD VDD VSS VSS gf180mcu_as_sc_mcu7t3v3__fill_1
XFILLER_181_893 VDD VDD VSS VSS gf180mcu_as_sc_mcu7t3v3__fill_1
X_3220_ VDD VDD VSS VSS _3373_/B _4470_/Q _3228_/D gf180mcu_as_sc_mcu7t3v3__and2_2
X_3151_ VDD VDD VSS VSS _3152_/D _4489_/Q _4509_/Q gf180mcu_as_sc_mcu7t3v3__nor2_2
X_3082_ VDD VDD VSS VSS _3083_/B _3082_/B _4478_/Q gf180mcu_as_sc_mcu7t3v3__nor2_2
XTAP_TAPCELL_ROW_98_3_2009 VDD VSS gf180mcu_as_sc_mcu7t3v3__tap_2
XTAP_TAPCELL_ROW_35_1_988 VDD VSS gf180mcu_as_sc_mcu7t3v3__tap_2
X_3984_ VDD VDD VSS VSS _3989_/B _4241_/B _4191_/B gf180mcu_as_sc_mcu7t3v3__and2_2
XFILLER_176_621 VDD VDD VSS VSS gf180mcu_as_sc_mcu7t3v3__fillcap_8
X_2935_ VDD VDD VSS VSS _4366_/Q _2945_/C _3014_/A _2945_/B _4366_/D gf180mcu_as_sc_mcu7t3v3__ao22_2
XFILLER_52_1349 VDD VDD VSS VSS gf180mcu_as_sc_mcu7t3v3__fillcap_4
X_2866_ VDD VDD VSS VSS _2895_/B _4184_/A _2867_/D gf180mcu_as_sc_mcu7t3v3__and2_2
X_4605_ VDD VDD VSS VSS _4606_/CLK _4605_/D _4605_/Q gf180mcu_as_sc_mcu7t3v3__dfxtp_2
XFILLER_163_348 VDD VDD VSS VSS gf180mcu_as_sc_mcu7t3v3__fill_2
XFILLER_163_359 VDD VDD VSS VSS gf180mcu_as_sc_mcu7t3v3__fillcap_16
XFILLER_176_1220 VDD VDD VSS VSS gf180mcu_as_sc_mcu7t3v3__fillcap_4
X_2797_ VDD VDD VSS VSS _2798_/C _2797_/C _2823_/D _4121_/A gf180mcu_as_sc_mcu7t3v3__aoi21_2
XFILLER_11_1068 VDD VDD VSS VSS gf180mcu_as_sc_mcu7t3v3__fill_1
XFILLER_11_1079 VDD VDD VSS VSS gf180mcu_as_sc_mcu7t3v3__fillcap_8
X_4536_ VDD VDD VSS VSS _4795_/CLK _4536_/D _4536_/Q gf180mcu_as_sc_mcu7t3v3__dfxtp_2
XTAP_TAPCELL_ROW_155_1191 VDD VSS gf180mcu_as_sc_mcu7t3v3__tap_2
XFILLER_172_893 VDD VDD VSS VSS gf180mcu_as_sc_mcu7t3v3__fill_2
X_4467_ VDD VDD VSS VSS _4606_/CLK _4467_/D _4467_/Q gf180mcu_as_sc_mcu7t3v3__dfxtp_2
XFILLER_172_1139 VDD VDD VSS VSS gf180mcu_as_sc_mcu7t3v3__fillcap_4
Xfanout802 VDD VDD VSS VSS wire807/Y _4331_/A gf180mcu_as_sc_mcu7t3v3__buff_12
X_4398_ VDD VDD VSS VSS clkload9/A _4398_/D _4398_/Q gf180mcu_as_sc_mcu7t3v3__dfxtp_2
X_3418_ VDD VDD VSS VSS _4547_/Q _3449_/D _3449_/B _4546_/Q _4546_/D gf180mcu_as_sc_mcu7t3v3__ao22_2
XTAP_TAPCELL_ROW_6_804 VDD VSS gf180mcu_as_sc_mcu7t3v3__tap_2
X_3349_ VDD VDD VSS VSS _3397_/B _4454_/Q _3356_/D gf180mcu_as_sc_mcu7t3v3__and2_2
XFILLER_133_69 VDD VDD VSS VSS gf180mcu_as_sc_mcu7t3v3__fill_1
Xhold1055 VDD VDD VSS VSS _4329_/B _2333_/A gf180mcu_as_sc_mcu7t3v3__clkbuff_4
Xhold1066 VDD VDD VSS VSS hold1097/Y _4813_/D gf180mcu_as_sc_mcu7t3v3__clkbuff_4
XTAP_TAPCELL_ROW_55_3_1966 VDD VSS gf180mcu_as_sc_mcu7t3v3__tap_2
Xhold1077 VDD VDD VSS VSS _4648_/Q _3575_/C gf180mcu_as_sc_mcu7t3v3__clkbuff_4
Xhold1088 VDD VDD VSS VSS hold1088/A _2329_/C gf180mcu_as_sc_mcu7t3v3__clkbuff_4
Xhold1099 VDD VDD VSS VSS _4819_/Q hold1099/Y gf180mcu_as_sc_mcu7t3v3__clkbuff_4
XFILLER_165_6 VDD VDD VSS VSS gf180mcu_as_sc_mcu7t3v3__fillcap_16
XFILLER_13_104 VDD VDD VSS VSS gf180mcu_as_sc_mcu7t3v3__fillcap_16
XFILLER_183_1235 VDD VDD VSS VSS gf180mcu_as_sc_mcu7t3v3__fillcap_4
XFILLER_187_908 VDD VDD VSS VSS gf180mcu_as_sc_mcu7t3v3__fill_2
XFILLER_167_621 VDD VDD VSS VSS gf180mcu_as_sc_mcu7t3v3__fillcap_8
XFILLER_167_632 VDD VDD VSS VSS gf180mcu_as_sc_mcu7t3v3__fillcap_8
XFILLER_179_492 VDD VDD VSS VSS gf180mcu_as_sc_mcu7t3v3__fillcap_16
XFILLER_10_844 VDD VDD VSS VSS gf180mcu_as_sc_mcu7t3v3__fill_1
XFILLER_158_22 VDD VDD VSS VSS gf180mcu_as_sc_mcu7t3v3__fillcap_8
XFILLER_10_877 VDD VDD VSS VSS gf180mcu_as_sc_mcu7t3v3__fillcap_8
XFILLER_177_1006 VDD VDD VSS VSS gf180mcu_as_sc_mcu7t3v3__fill_1
XFILLER_182_613 VDD VDD VSS VSS gf180mcu_as_sc_mcu7t3v3__fillcap_16
XFILLER_6_804 VDD VDD VSS VSS gf180mcu_as_sc_mcu7t3v3__fill_1
XFILLER_6_837 VDD VDD VSS VSS gf180mcu_as_sc_mcu7t3v3__fill_1
XTAP_TAPCELL_ROW_175_1578 VDD VSS gf180mcu_as_sc_mcu7t3v3__tap_2
XTAP_TAPCELL_ROW_175_1567 VDD VSS gf180mcu_as_sc_mcu7t3v3__tap_2
XFILLER_158_99 VDD VDD VSS VSS gf180mcu_as_sc_mcu7t3v3__fillcap_4
XTAP_TAPCELL_ROW_192_1892 VDD VSS gf180mcu_as_sc_mcu7t3v3__tap_2
XFILLER_155_1326 VDD VDD VSS VSS gf180mcu_as_sc_mcu7t3v3__fillcap_4
XPHY_EDGE_ROW_55_1_Right_564 VDD VSS gf180mcu_as_sc_mcu7t3v3__tap_2
XFILLER_1_564 VDD VDD VSS VSS gf180mcu_as_sc_mcu7t3v3__fill_1
XFILLER_188_1146 VDD VDD VSS VSS gf180mcu_as_sc_mcu7t3v3__fillcap_8
XFILLER_188_1157 VDD VDD VSS VSS gf180mcu_as_sc_mcu7t3v3__fillcap_4
XFILLER_40_1264 VDD VDD VSS VSS gf180mcu_as_sc_mcu7t3v3__fillcap_4
Xclkbuf_3_1__f_clk_regs VDD VDD VSS VSS clkbuf_2_0_0_clk_regs/Y clkbuf_leaf_8_clk_regs/A
+ gf180mcu_as_sc_mcu7t3v3__clkbuff_12
XFILLER_189_234 VDD VDD VSS VSS gf180mcu_as_sc_mcu7t3v3__fill_2
XFILLER_12_170 VDD VDD VSS VSS gf180mcu_as_sc_mcu7t3v3__fillcap_4
XFILLER_13_682 VDD VDD VSS VSS gf180mcu_as_sc_mcu7t3v3__fillcap_4
X_2720_ VDD VDD VSS VSS _2829_/B _4052_/D _2721_/D gf180mcu_as_sc_mcu7t3v3__and2_2
XFILLER_160_1087 VDD VDD VSS VSS gf180mcu_as_sc_mcu7t3v3__fillcap_8
X_2651_ VDD VDD VSS VSS _4278_/A _4331_/A _2871_/D gf180mcu_as_sc_mcu7t3v3__or2_2
XPHY_EDGE_ROW_116_3_Right_157 VDD VSS gf180mcu_as_sc_mcu7t3v3__tap_2
XFILLER_172_123 VDD VDD VSS VSS gf180mcu_as_sc_mcu7t3v3__fillcap_16
XTAP_TAPCELL_ROW_11_894 VDD VSS gf180mcu_as_sc_mcu7t3v3__tap_2
XFILLER_160_307 VDD VDD VSS VSS gf180mcu_as_sc_mcu7t3v3__fillcap_8
Xoutput416 VDD VDD VSS VSS _4741_/Q west_out[12] gf180mcu_as_sc_mcu7t3v3__buff_12
Xoutput405 VDD VDD VSS VSS _4692_/Q south_out[35] gf180mcu_as_sc_mcu7t3v3__buff_12
X_2582_ VDD VDD VSS VSS _4829_/Q _2582_/B _4634_/Q _4633_/D gf180mcu_as_sc_mcu7t3v3__mux2_2
XFILLER_154_893 VDD VDD VSS VSS gf180mcu_as_sc_mcu7t3v3__fill_2
Xoutput427 VDD VDD VSS VSS _4751_/Q west_out[22] gf180mcu_as_sc_mcu7t3v3__buff_12
Xoutput438 VDD VDD VSS VSS _4761_/Q west_out[32] gf180mcu_as_sc_mcu7t3v3__buff_12
X_4321_ VDD VDD VSS VSS _4804_/D _4513_/Q _4798_/D gf180mcu_as_sc_mcu7t3v3__and2_2
X_4252_ VDD VDD VSS VSS _4722_/D _4272_/C _4252_/B _4252_/A gf180mcu_as_sc_mcu7t3v3__aoi21_2
X_3203_ VDD VDD VSS VSS _3206_/D _3203_/B _3206_/A gf180mcu_as_sc_mcu7t3v3__nor2_2
X_4183_ VDD VDD VSS VSS _4183_/A _4207_/B _4207_/C _4183_/D _4184_/C gf180mcu_as_sc_mcu7t3v3__ao22_2
X_3134_ VDD VDD VSS VSS _3135_/D _3191_/A _4512_/Q gf180mcu_as_sc_mcu7t3v3__nor2_2
X_3065_ VDD VDD VSS VSS _3070_/S _3516_/B _4464_/Q _4464_/D gf180mcu_as_sc_mcu7t3v3__mux2_2
X_3967_ VDD VDD VSS VSS _3967_/B _4051_/A _4691_/D gf180mcu_as_sc_mcu7t3v3__and2_2
XFILLER_176_440 VDD VDD VSS VSS gf180mcu_as_sc_mcu7t3v3__fill_1
X_2918_ VDD VDD VSS VSS _4234_/A _2918_/B _2918_/C _2918_/D _2919_/D gf180mcu_as_sc_mcu7t3v3__ao211_2
XTAP_TAPCELL_ROW_157_1231 VDD VSS gf180mcu_as_sc_mcu7t3v3__tap_2
XTAP_TAPCELL_ROW_157_1220 VDD VSS gf180mcu_as_sc_mcu7t3v3__tap_2
X_3898_ VDD VDD VSS VSS _3928_/B _4235_/A _3903_/C gf180mcu_as_sc_mcu7t3v3__or2_2
XFILLER_163_123 VDD VDD VSS VSS gf180mcu_as_sc_mcu7t3v3__fill_2
X_2849_ VDD VDD VSS VSS _4165_/A _2894_/B _2849_/C _2849_/D _2850_/D gf180mcu_as_sc_mcu7t3v3__ao211_2
XFILLER_128_69 VDD VDD VSS VSS gf180mcu_as_sc_mcu7t3v3__fillcap_16
XFILLER_191_454 VDD VDD VSS VSS gf180mcu_as_sc_mcu7t3v3__fillcap_16
XFILLER_2_317 VDD VDD VSS VSS gf180mcu_as_sc_mcu7t3v3__fill_2
XFILLER_88_29 VDD VDD VSS VSS gf180mcu_as_sc_mcu7t3v3__fill_2
X_4519_ VDD VDD VSS VSS _4795_/CLK _4519_/D _4519_/Q gf180mcu_as_sc_mcu7t3v3__dfxtp_2
XTAP_TAPCELL_ROW_170_1475 VDD VSS gf180mcu_as_sc_mcu7t3v3__tap_2
XFILLER_160_874 VDD VDD VSS VSS gf180mcu_as_sc_mcu7t3v3__fill_1
Xfanout610 VDD VDD VSS VSS fanout611/A _4226_/B gf180mcu_as_sc_mcu7t3v3__buff_12
Xfanout621 VDD VDD VSS VSS _3397_/B _3389_/B gf180mcu_as_sc_mcu7t3v3__buff_12
Xfanout632 VDD VDD VSS VSS fanout632/A _2828_/C gf180mcu_as_sc_mcu7t3v3__buff_12
Xfanout643 VDD VDD VSS VSS _3974_/Y _4209_/A gf180mcu_as_sc_mcu7t3v3__buff_12
Xfanout665 VDD VDD VSS VSS _3522_/S _3520_/S gf180mcu_as_sc_mcu7t3v3__buff_12
Xfanout676 VDD VDD VSS VSS _4231_/B _4214_/B gf180mcu_as_sc_mcu7t3v3__buff_12
XFILLER_150_1256 VDD VDD VSS VSS gf180mcu_as_sc_mcu7t3v3__fill_2
Xfanout687 VDD VDD VSS VSS _2430_/Y _3070_/S gf180mcu_as_sc_mcu7t3v3__buff_12
Xfanout698 VDD VDD VSS VSS _3850_/D _3867_/D gf180mcu_as_sc_mcu7t3v3__buff_12
XFILLER_160_45 VDD VDD VSS VSS gf180mcu_as_sc_mcu7t3v3__fillcap_4
XFILLER_37_88 VDD VDD VSS VSS gf180mcu_as_sc_mcu7t3v3__fillcap_16
Xclkbuf_leaf_2_clk_regs VDD VDD VSS VSS clkbuf_leaf_8_clk_regs/A clkload7/A gf180mcu_as_sc_mcu7t3v3__clkbuff_12
XTAP_TAPCELL_ROW_177_1607 VDD VSS gf180mcu_as_sc_mcu7t3v3__tap_2
XFILLER_35_1311 VDD VDD VSS VSS gf180mcu_as_sc_mcu7t3v3__fill_2
XTAP_TAPCELL_ROW_177_1618 VDD VSS gf180mcu_as_sc_mcu7t3v3__tap_2
XFILLER_168_941 VDD VDD VSS VSS gf180mcu_as_sc_mcu7t3v3__fillcap_4
XFILLER_154_123 VDD VDD VSS VSS gf180mcu_as_sc_mcu7t3v3__fillcap_8
XFILLER_155_668 VDD VDD VSS VSS gf180mcu_as_sc_mcu7t3v3__fill_1
XFILLER_183_977 VDD VDD VSS VSS gf180mcu_as_sc_mcu7t3v3__fill_2
XFILLER_185_64 VDD VDD VSS VSS gf180mcu_as_sc_mcu7t3v3__fillcap_4
XTAP_TAPCELL_ROW_34_1_987 VDD VSS gf180mcu_as_sc_mcu7t3v3__tap_2
XFILLER_2_862 VDD VDD VSS VSS gf180mcu_as_sc_mcu7t3v3__fillcap_8
XFILLER_78_62 VDD VDD VSS VSS gf180mcu_as_sc_mcu7t3v3__fill_1
XPHY_EDGE_ROW_56_1_Right_565 VDD VSS gf180mcu_as_sc_mcu7t3v3__tap_2
XFILLER_155_1189 VDD VDD VSS VSS gf180mcu_as_sc_mcu7t3v3__fill_1
XFILLER_79_1293 VDD VDD VSS VSS gf180mcu_as_sc_mcu7t3v3__fillcap_4
XFILLER_178_716 VDD VDD VSS VSS gf180mcu_as_sc_mcu7t3v3__fillcap_16
XFILLER_162_1138 VDD VDD VSS VSS gf180mcu_as_sc_mcu7t3v3__fill_2
XFILLER_178_749 VDD VDD VSS VSS gf180mcu_as_sc_mcu7t3v3__fillcap_8
X_3821_ VDD VDD VSS VSS _3866_/B _4165_/D _3822_/C gf180mcu_as_sc_mcu7t3v3__and2_2
XFILLER_71_2 VDD VDD VSS VSS gf180mcu_as_sc_mcu7t3v3__fill_1
X_3752_ VDD VDD VSS VSS _3890_/S _4100_/A _3754_/C gf180mcu_as_sc_mcu7t3v3__or2_2
XTAP_TAPCELL_ROW_107_3_2018 VDD VSS gf180mcu_as_sc_mcu7t3v3__tap_2
XFILLER_12_1130 VDD VDD VSS VSS gf180mcu_as_sc_mcu7t3v3__fill_2
X_3683_ VDD VDD VSS VSS _4041_/A _3800_/B _3683_/C _3683_/D _3684_/B gf180mcu_as_sc_mcu7t3v3__ao211_2
X_2703_ VDD VDD VSS VSS _4036_/A _2827_/B _2703_/C _2703_/D _2704_/D gf180mcu_as_sc_mcu7t3v3__ao211_2
XPHY_EDGE_ROW_117_3_Right_158 VDD VSS gf180mcu_as_sc_mcu7t3v3__tap_2
X_2634_ VDD VDD VSS VSS _2635_/D _2660_/B _2654_/A gf180mcu_as_sc_mcu7t3v3__nor2_2
XFILLER_12_1185 VDD VDD VSS VSS gf180mcu_as_sc_mcu7t3v3__fill_2
XFILLER_160_104 VDD VDD VSS VSS gf180mcu_as_sc_mcu7t3v3__fill_1
X_2565_ VDD VDD VSS VSS _4820_/D _4543_/Q _3608_/D _3481_/A gf180mcu_as_sc_mcu7t3v3__ao21_2
X_4304_ VDD VDD VSS VSS _4310_/B _4528_/Q _4781_/D gf180mcu_as_sc_mcu7t3v3__and2_2
XPHY_EDGE_ROW_39_3_Right_80 VDD VSS gf180mcu_as_sc_mcu7t3v3__tap_2
XFILLER_173_1278 VDD VDD VSS VSS gf180mcu_as_sc_mcu7t3v3__fillcap_16
X_2496_ VDD VDD VSS VSS _4806_/Q _2496_/B _2496_/A _5071_/A gf180mcu_as_sc_mcu7t3v3__mux2_2
X_4235_ VDD VDD VSS VSS _4237_/C _4235_/A _4235_/B _4235_/C gf180mcu_as_sc_mcu7t3v3__ao21_2
X_4166_ VDD VDD VSS VSS _4168_/B _4166_/A _4184_/B _4166_/C gf180mcu_as_sc_mcu7t3v3__ao21_2
X_3117_ VDD VDD VSS VSS _3117_/S _4505_/Q _4504_/Q _4504_/D gf180mcu_as_sc_mcu7t3v3__mux2_2
X_4097_ VDD VDD VSS VSS _4097_/A _4154_/S _4097_/C _4097_/D _4098_/B gf180mcu_as_sc_mcu7t3v3__ao211_2
XFILLER_167_1049 VDD VDD VSS VSS gf180mcu_as_sc_mcu7t3v3__fill_1
X_3048_ VDD VDD VSS VSS _4450_/D _3048_/B _3048_/A gf180mcu_as_sc_mcu7t3v3__nor2_2
XFILLER_130_37 VDD VDD VSS VSS gf180mcu_as_sc_mcu7t3v3__fill_1
XPHY_EDGE_ROW_31_3_Left_403 VDD VSS gf180mcu_as_sc_mcu7t3v3__tap_2
XFILLER_12_917 VDD VDD VSS VSS gf180mcu_as_sc_mcu7t3v3__fill_2
XFILLER_180_1216 VDD VDD VSS VSS gf180mcu_as_sc_mcu7t3v3__fillcap_8
XPHY_EDGE_ROW_79_3_Right_120 VDD VSS gf180mcu_as_sc_mcu7t3v3__tap_2
XFILLER_93_1268 VDD VDD VSS VSS gf180mcu_as_sc_mcu7t3v3__fillcap_8
XFILLER_180_1249 VDD VDD VSS VSS gf180mcu_as_sc_mcu7t3v3__fillcap_4
XFILLER_139_35 VDD VDD VSS VSS gf180mcu_as_sc_mcu7t3v3__fillcap_16
XFILLER_136_101 VDD VDD VSS VSS gf180mcu_as_sc_mcu7t3v3__fillcap_4
XFILLER_165_966 VDD VDD VSS VSS gf180mcu_as_sc_mcu7t3v3__fill_2
XFILLER_192_741 VDD VDD VSS VSS gf180mcu_as_sc_mcu7t3v3__fillcap_4
XTAP_TAPCELL_ROW_172_1515 VDD VSS gf180mcu_as_sc_mcu7t3v3__tap_2
XFILLER_164_454 VDD VDD VSS VSS gf180mcu_as_sc_mcu7t3v3__fill_1
XFILLER_151_104 VDD VDD VSS VSS gf180mcu_as_sc_mcu7t3v3__fill_1
XFILLER_152_638 VDD VDD VSS VSS gf180mcu_as_sc_mcu7t3v3__fill_1
XFILLER_180_947 VDD VDD VSS VSS gf180mcu_as_sc_mcu7t3v3__fillcap_8
XFILLER_155_56 VDD VDD VSS VSS gf180mcu_as_sc_mcu7t3v3__fill_2
XFILLER_65_1326 VDD VDD VSS VSS gf180mcu_as_sc_mcu7t3v3__fillcap_4
XFILLER_171_22 VDD VDD VSS VSS gf180mcu_as_sc_mcu7t3v3__fillcap_4
Xfanout451 VDD VDD VSS VSS _2977_/Y _3004_/C gf180mcu_as_sc_mcu7t3v3__buff_12
Xfanout473 VDD VDD VSS VSS _2924_/Y _2951_/B gf180mcu_as_sc_mcu7t3v3__buff_12
Xfanout484 VDD VDD VSS VSS _2922_/Y _2951_/D gf180mcu_as_sc_mcu7t3v3__buff_12
XTAP_TAPCELL_ROW_187_1791 VDD VSS gf180mcu_as_sc_mcu7t3v3__tap_2
XPHY_EDGE_ROW_26_3_Left_398 VDD VSS gf180mcu_as_sc_mcu7t3v3__tap_2
XFILLER_171_66 VDD VDD VSS VSS gf180mcu_as_sc_mcu7t3v3__fillcap_4
XFILLER_8_1297 VDD VDD VSS VSS gf180mcu_as_sc_mcu7t3v3__fillcap_4
XPHY_EDGE_ROW_87_1_Left_279 VDD VSS gf180mcu_as_sc_mcu7t3v3__tap_2
XFILLER_64_53 VDD VDD VSS VSS gf180mcu_as_sc_mcu7t3v3__fillcap_8
XFILLER_64_86 VDD VDD VSS VSS gf180mcu_as_sc_mcu7t3v3__fillcap_4
XFILLER_187_524 VDD VDD VSS VSS gf180mcu_as_sc_mcu7t3v3__fillcap_16
XPHY_EDGE_ROW_88_3_Left_460 VDD VSS gf180mcu_as_sc_mcu7t3v3__tap_2
XTAP_TAPCELL_ROW_13_934 VDD VSS gf180mcu_as_sc_mcu7t3v3__tap_2
XFILLER_126_1291 VDD VDD VSS VSS gf180mcu_as_sc_mcu7t3v3__fill_2
XTAP_TAPCELL_ROW_13_967 VDD VSS gf180mcu_as_sc_mcu7t3v3__tap_2
XTAP_TAPCELL_ROW_13_956 VDD VSS gf180mcu_as_sc_mcu7t3v3__tap_2
XTAP_TAPCELL_ROW_13_945 VDD VSS gf180mcu_as_sc_mcu7t3v3__tap_2
XFILLER_156_944 VDD VDD VSS VSS gf180mcu_as_sc_mcu7t3v3__fill_1
XFILLER_161_1182 VDD VDD VSS VSS gf180mcu_as_sc_mcu7t3v3__fillcap_8
XFILLER_167_292 VDD VDD VSS VSS gf180mcu_as_sc_mcu7t3v3__fill_2
XFILLER_155_454 VDD VDD VSS VSS gf180mcu_as_sc_mcu7t3v3__fillcap_16
XFILLER_156_988 VDD VDD VSS VSS gf180mcu_as_sc_mcu7t3v3__fill_1
Xmax_cap618 VDD VDD VSS VSS _3965_/C _3823_/C gf180mcu_as_sc_mcu7t3v3__clkbuff_12
XFILLER_142_104 VDD VDD VSS VSS gf180mcu_as_sc_mcu7t3v3__fill_1
XFILLER_7_998 VDD VDD VSS VSS gf180mcu_as_sc_mcu7t3v3__fillcap_8
Xmax_cap629 VDD VDD VSS VSS _2665_/Y fanout627/A gf180mcu_as_sc_mcu7t3v3__clkbuff_12
XFILLER_170_457 VDD VDD VSS VSS gf180mcu_as_sc_mcu7t3v3__fillcap_16
XFILLER_89_72 VDD VDD VSS VSS gf180mcu_as_sc_mcu7t3v3__fill_2
X_2350_ VDD VDD VSS VSS _3071_/B _3053_/B _2350_/C _2408_/A _2352_/C gf180mcu_as_sc_mcu7t3v3__ao211_2
X_2281_ VDD VDD VSS VSS _2287_/A _3571_/D _4622_/Q _2282_/B gf180mcu_as_sc_mcu7t3v3__nor3_2
XPHY_EDGE_ROW_57_1_Right_566 VDD VSS gf180mcu_as_sc_mcu7t3v3__tap_2
X_4020_ VDD VDD VSS VSS _4020_/A _4214_/B _4214_/C _4020_/D _4022_/B gf180mcu_as_sc_mcu7t3v3__ao22_2
XFILLER_168_1303 VDD VDD VSS VSS gf180mcu_as_sc_mcu7t3v3__fill_1
XFILLER_168_1314 VDD VDD VSS VSS gf180mcu_as_sc_mcu7t3v3__fillcap_16
XFILLER_178_524 VDD VDD VSS VSS gf180mcu_as_sc_mcu7t3v3__fill_1
XFILLER_178_535 VDD VDD VSS VSS gf180mcu_as_sc_mcu7t3v3__fillcap_4
XFILLER_18_1350 VDD VDD VSS VSS gf180mcu_as_sc_mcu7t3v3__fillcap_4
XFILLER_159_760 VDD VDD VSS VSS gf180mcu_as_sc_mcu7t3v3__fillcap_8
X_4784_ VDD VDD VSS VSS clkload7/A _4784_/D _4784_/Q gf180mcu_as_sc_mcu7t3v3__dfxtp_2
X_3804_ VDD VDD VSS VSS _4150_/A _3867_/B _3804_/C _3867_/D _3806_/C gf180mcu_as_sc_mcu7t3v3__ao211_2
XFILLER_165_229 VDD VDD VSS VSS gf180mcu_as_sc_mcu7t3v3__fillcap_16
XFILLER_174_741 VDD VDD VSS VSS gf180mcu_as_sc_mcu7t3v3__fill_2
X_3735_ VDD VDD VSS VSS _3737_/C _4087_/A _3798_/B _3735_/C gf180mcu_as_sc_mcu7t3v3__ao21_2
XFILLER_109_38 VDD VDD VSS VSS gf180mcu_as_sc_mcu7t3v3__fillcap_16
XFILLER_173_251 VDD VDD VSS VSS gf180mcu_as_sc_mcu7t3v3__fill_1
XFILLER_174_774 VDD VDD VSS VSS gf180mcu_as_sc_mcu7t3v3__fill_1
XFILLER_88_1337 VDD VDD VSS VSS gf180mcu_as_sc_mcu7t3v3__fillcap_16
XFILLER_161_413 VDD VDD VSS VSS gf180mcu_as_sc_mcu7t3v3__fillcap_4
X_3666_ VDD VDD VSS VSS _3747_/S _3666_/B _4026_/A _3667_/B gf180mcu_as_sc_mcu7t3v3__mux2_2
XPHY_EDGE_ROW_118_3_Right_159 VDD VSS gf180mcu_as_sc_mcu7t3v3__tap_2
X_3597_ VDD VDD VSS VSS _3603_/A _3599_/B _3597_/C _4651_/D gf180mcu_as_sc_mcu7t3v3__nor3_2
X_2617_ VDD VDD VSS VSS _4802_/Q _4801_/Q _4803_/Q _3614_/B gf180mcu_as_sc_mcu7t3v3__nor3_2
X_2548_ VDD VDD VSS VSS _4479_/Q _3560_/D _4527_/Q _2551_/B _2548_/D gf180mcu_as_sc_mcu7t3v3__aoi31_2
XFILLER_173_1064 VDD VDD VSS VSS gf180mcu_as_sc_mcu7t3v3__fill_1
X_4218_ VDD VDD VSS VSS _4218_/B _4218_/A _4220_/C gf180mcu_as_sc_mcu7t3v3__and2_2
X_2479_ VDD VDD VSS VSS _2479_/B _2494_/A _2486_/D gf180mcu_as_sc_mcu7t3v3__and2_2
XFILLER_60_1256 VDD VDD VSS VSS gf180mcu_as_sc_mcu7t3v3__fillcap_4
X_4149_ VDD VDD VSS VSS _4149_/A _4149_/B _4149_/C _4149_/D _4150_/C gf180mcu_as_sc_mcu7t3v3__ao22_2
XTAP_TAPCELL_ROW_165_1385 VDD VSS gf180mcu_as_sc_mcu7t3v3__tap_2
XTAP_TAPCELL_ROW_165_1374 VDD VSS gf180mcu_as_sc_mcu7t3v3__tap_2
XFILLER_70_102 VDD VDD VSS VSS gf180mcu_as_sc_mcu7t3v3__fill_2
XTAP_TAPCELL_ROW_33_1_986 VDD VSS gf180mcu_as_sc_mcu7t3v3__tap_2
XFILLER_34_78 VDD VDD VSS VSS gf180mcu_as_sc_mcu7t3v3__fillcap_8
XFILLER_11_257 VDD VDD VSS VSS gf180mcu_as_sc_mcu7t3v3__fill_2
XFILLER_184_505 VDD VDD VSS VSS gf180mcu_as_sc_mcu7t3v3__fillcap_8
XFILLER_184_527 VDD VDD VSS VSS gf180mcu_as_sc_mcu7t3v3__fillcap_16
XFILLER_8_718 VDD VDD VSS VSS gf180mcu_as_sc_mcu7t3v3__fillcap_16
XFILLER_50_33 VDD VDD VSS VSS gf180mcu_as_sc_mcu7t3v3__fill_2
Xclkload0 VDD VDD VSS VSS clkload0/A clkload0/Y gf180mcu_as_sc_mcu7t3v3__clkbuff_12
XFILLER_50_66 VDD VDD VSS VSS gf180mcu_as_sc_mcu7t3v3__fill_1
XFILLER_156_1262 VDD VDD VSS VSS gf180mcu_as_sc_mcu7t3v3__fill_2
XFILLER_1_2 VDD VDD VSS VSS gf180mcu_as_sc_mcu7t3v3__fillcap_8
XTAP_TAPCELL_ROW_189_1842 VDD VSS gf180mcu_as_sc_mcu7t3v3__tap_2
XTAP_TAPCELL_ROW_189_1831 VDD VSS gf180mcu_as_sc_mcu7t3v3__tap_2
XFILLER_191_1186 VDD VDD VSS VSS gf180mcu_as_sc_mcu7t3v3__fillcap_4
XFILLER_8_1050 VDD VDD VSS VSS gf180mcu_as_sc_mcu7t3v3__fill_1
XFILLER_8_1072 VDD VDD VSS VSS gf180mcu_as_sc_mcu7t3v3__fillcap_8
XFILLER_76_1274 VDD VDD VSS VSS gf180mcu_as_sc_mcu7t3v3__fill_1
XFILLER_128_1353 VDD VDD VSS VSS gf180mcu_as_sc_mcu7t3v3__fill_2
XFILLER_175_527 VDD VDD VSS VSS gf180mcu_as_sc_mcu7t3v3__fill_1
X_3520_ VDD VDD VSS VSS _3520_/S _3520_/B _4609_/Q _3521_/A gf180mcu_as_sc_mcu7t3v3__mux2_2
XFILLER_115_104 VDD VDD VSS VSS gf180mcu_as_sc_mcu7t3v3__fill_1
XFILLER_171_722 VDD VDD VSS VSS gf180mcu_as_sc_mcu7t3v3__fill_2
XFILLER_6_261 VDD VDD VSS VSS gf180mcu_as_sc_mcu7t3v3__fillcap_4
X_3451_ VDD VDD VSS VSS _3540_/S _3602_/B _4451_/Q gf180mcu_as_sc_mcu7t3v3__nand2_2
XFILLER_100_1283 VDD VDD VSS VSS gf180mcu_as_sc_mcu7t3v3__fillcap_4
X_3382_ VDD VDD VSS VSS _3408_/A _4439_/Q _4381_/Q _3383_/A gf180mcu_as_sc_mcu7t3v3__mux2_2
X_2402_ VDD VDD VSS VSS _2425_/B _4484_/Q _4548_/Q _2403_/B gf180mcu_as_sc_mcu7t3v3__mux2_2
XFILLER_170_1215 VDD VDD VSS VSS gf180mcu_as_sc_mcu7t3v3__fillcap_8
XFILLER_83_1256 VDD VDD VSS VSS gf180mcu_as_sc_mcu7t3v3__fillcap_8
X_2333_ VDD VDD VSS VSS _2333_/Y _2333_/B _2333_/A gf180mcu_as_sc_mcu7t3v3__nand2b_2
XFILLER_170_1259 VDD VDD VSS VSS gf180mcu_as_sc_mcu7t3v3__fillcap_16
XPHY_EDGE_ROW_58_1_Right_567 VDD VSS gf180mcu_as_sc_mcu7t3v3__tap_2
X_2264_ VDD VDD VSS VSS _2269_/D _3568_/A _3484_/A _4594_/Q gf180mcu_as_sc_mcu7t3v3__aoi21_2
X_4003_ VDD VDD VSS VSS _4272_/B _4269_/B _4003_/A gf180mcu_as_sc_mcu7t3v3__nand2b_2
X_2195_ VDD VDD VSS VSS _3610_/A _4649_/Q gf180mcu_as_sc_mcu7t3v3__inv_2
XFILLER_0_1323 VDD VDD VSS VSS gf180mcu_as_sc_mcu7t3v3__fill_2
XFILLER_168_1188 VDD VDD VSS VSS gf180mcu_as_sc_mcu7t3v3__fillcap_4
XFILLER_179_811 VDD VDD VSS VSS gf180mcu_as_sc_mcu7t3v3__fillcap_16
XFILLER_20_1284 VDD VDD VSS VSS gf180mcu_as_sc_mcu7t3v3__fillcap_4
XTAP_TAPCELL_ROW_160_1282 VDD VSS gf180mcu_as_sc_mcu7t3v3__tap_2
XFILLER_181_1344 VDD VDD VSS VSS gf180mcu_as_sc_mcu7t3v3__fillcap_8
XTAP_TAPCELL_ROW_160_1293 VDD VSS gf180mcu_as_sc_mcu7t3v3__tap_2
XFILLER_166_527 VDD VDD VSS VSS gf180mcu_as_sc_mcu7t3v3__fillcap_16
XFILLER_178_387 VDD VDD VSS VSS gf180mcu_as_sc_mcu7t3v3__fillcap_4
X_4767_ VDD VDD VSS VSS _4783_/CLK _4767_/D _4767_/Q gf180mcu_as_sc_mcu7t3v3__dfxtp_2
XFILLER_179_1262 VDD VDD VSS VSS gf180mcu_as_sc_mcu7t3v3__fillcap_16
X_4698_ VDD VDD VSS VSS _4708_/CLK _4698_/D _4698_/Q gf180mcu_as_sc_mcu7t3v3__dfxtp_2
X_3718_ VDD VDD VSS VSS _4072_/A _3799_/B _3808_/C _4069_/D _3719_/D gf180mcu_as_sc_mcu7t3v3__ao22_2
XFILLER_174_593 VDD VDD VSS VSS gf180mcu_as_sc_mcu7t3v3__fill_2
X_3649_ VDD VDD VSS VSS _3649_/B _3884_/A _4657_/D gf180mcu_as_sc_mcu7t3v3__and2_2
XFILLER_161_298 VDD VDD VSS VSS gf180mcu_as_sc_mcu7t3v3__fillcap_8
Xinput305 VDD VDD VSS VSS west_in[17] _4142_/A gf180mcu_as_sc_mcu7t3v3__buff_12
Xinput316 VDD VDD VSS VSS west_in[27] _4225_/A gf180mcu_as_sc_mcu7t3v3__buff_12
Xinput327 VDD VDD VSS VSS west_in[4] _4039_/D gf180mcu_as_sc_mcu7t3v3__buff_12
XTAP_TAPCELL_ROW_167_1425 VDD VSS gf180mcu_as_sc_mcu7t3v3__tap_2
XTAP_TAPCELL_ROW_167_1414 VDD VSS gf180mcu_as_sc_mcu7t3v3__tap_2
XFILLER_29_67 VDD VDD VSS VSS gf180mcu_as_sc_mcu7t3v3__fill_2
XTAP_TAPCELL_ROW_4_776 VDD VSS gf180mcu_as_sc_mcu7t3v3__tap_2
XTAP_TAPCELL_ROW_4_765 VDD VSS gf180mcu_as_sc_mcu7t3v3__tap_2
XTAP_TAPCELL_ROW_184_1750 VDD VSS gf180mcu_as_sc_mcu7t3v3__tap_2
XFILLER_5_1289 VDD VDD VSS VSS gf180mcu_as_sc_mcu7t3v3__fill_1
XFILLER_43_102 VDD VDD VSS VSS gf180mcu_as_sc_mcu7t3v3__fill_2
XTAP_TAPCELL_ROW_180_1669 VDD VSS gf180mcu_as_sc_mcu7t3v3__tap_2
XTAP_TAPCELL_ROW_180_1658 VDD VSS gf180mcu_as_sc_mcu7t3v3__tap_2
XFILLER_99_1296 VDD VDD VSS VSS gf180mcu_as_sc_mcu7t3v3__fill_2
XFILLER_188_107 VDD VDD VSS VSS gf180mcu_as_sc_mcu7t3v3__fillcap_4
XFILLER_101_72 VDD VDD VSS VSS gf180mcu_as_sc_mcu7t3v3__fillcap_8
XFILLER_184_302 VDD VDD VSS VSS gf180mcu_as_sc_mcu7t3v3__fillcap_8
XFILLER_36_1291 VDD VDD VSS VSS gf180mcu_as_sc_mcu7t3v3__fill_1
XFILLER_61_54 VDD VDD VSS VSS gf180mcu_as_sc_mcu7t3v3__fillcap_16
XFILLER_8_559 VDD VDD VSS VSS gf180mcu_as_sc_mcu7t3v3__fill_2
XANTENNA_9 VDD VDD VSS VSS _4709_/D gf180mcu_as_sc_mcu7t3v3__diode_2
XFILLER_165_582 VDD VDD VSS VSS gf180mcu_as_sc_mcu7t3v3__fill_1
XFILLER_152_210 VDD VDD VSS VSS gf180mcu_as_sc_mcu7t3v3__fill_1
XFILLER_153_788 VDD VDD VSS VSS gf180mcu_as_sc_mcu7t3v3__fillcap_16
XFILLER_10_91 VDD VDD VSS VSS gf180mcu_as_sc_mcu7t3v3__fill_2
XFILLER_3_286 VDD VDD VSS VSS gf180mcu_as_sc_mcu7t3v3__fill_1
XFILLER_126_80 VDD VDD VSS VSS gf180mcu_as_sc_mcu7t3v3__fillcap_4
Xmesh_tile_909 VDD VDD VSS VSS nw_out[9] gf180mcu_as_sc_mcu7t3v3__tiel_4
XFILLER_86_62 VDD VDD VSS VSS gf180mcu_as_sc_mcu7t3v3__fillcap_4
XTAP_TAPCELL_ROW_73_3_1984 VDD VSS gf180mcu_as_sc_mcu7t3v3__tap_2
XFILLER_130_1276 VDD VDD VSS VSS gf180mcu_as_sc_mcu7t3v3__fill_2
XFILLER_165_1317 VDD VDD VSS VSS gf180mcu_as_sc_mcu7t3v3__fill_2
X_2951_ VDD VDD VSS VSS _4376_/Q _2951_/B _3024_/A _2951_/D _4376_/D gf180mcu_as_sc_mcu7t3v3__ao22_2
XFILLER_163_1052 VDD VDD VSS VSS gf180mcu_as_sc_mcu7t3v3__fillcap_8
XFILLER_175_324 VDD VDD VSS VSS gf180mcu_as_sc_mcu7t3v3__fillcap_16
X_4621_ VDD VDD VSS VSS _4820_/CLK _4621_/D _4621_/Q gf180mcu_as_sc_mcu7t3v3__dfxtp_2
X_2882_ VDD VDD VSS VSS _2891_/B _4202_/A _2886_/C gf180mcu_as_sc_mcu7t3v3__and2_2
XFILLER_175_368 VDD VDD VSS VSS gf180mcu_as_sc_mcu7t3v3__fillcap_4
XFILLER_176_869 VDD VDD VSS VSS gf180mcu_as_sc_mcu7t3v3__fillcap_4
XFILLER_156_582 VDD VDD VSS VSS gf180mcu_as_sc_mcu7t3v3__fillcap_8
XFILLER_163_519 VDD VDD VSS VSS gf180mcu_as_sc_mcu7t3v3__fillcap_16
XFILLER_191_839 VDD VDD VSS VSS gf180mcu_as_sc_mcu7t3v3__fill_1
X_4552_ VDD VDD VSS VSS _4719_/CLK _4552_/D _4552_/Q gf180mcu_as_sc_mcu7t3v3__dfxtp_2
XPHY_EDGE_ROW_103_3_Left_475 VDD VSS gf180mcu_as_sc_mcu7t3v3__tap_2
X_4483_ VDD VDD VSS VSS _4720_/CLK _4483_/D _4483_/Q gf180mcu_as_sc_mcu7t3v3__dfxtp_2
X_3503_ VDD VDD VSS VSS _4602_/D _4602_/Q _3503_/B _3503_/C gf180mcu_as_sc_mcu7t3v3__ao21_2
X_3434_ VDD VDD VSS VSS _4563_/Q _3439_/B _3439_/C _4562_/Q _4562_/D gf180mcu_as_sc_mcu7t3v3__ao22_2
XTAP_TAPCELL_ROW_32_1_985 VDD VSS gf180mcu_as_sc_mcu7t3v3__tap_2
XPHY_EDGE_ROW_40_3_Left_412 VDD VSS gf180mcu_as_sc_mcu7t3v3__tap_2
X_3365_ VDD VDD VSS VSS _3373_/B _4456_/Q _3372_/D gf180mcu_as_sc_mcu7t3v3__and2_2
X_3296_ VDD VDD VSS VSS _3296_/S _4370_/Q _4399_/Q _3297_/B gf180mcu_as_sc_mcu7t3v3__mux2_2
X_2316_ VDD VDD VSS VSS _3458_/A _4480_/Q _2563_/D _3128_/A _3558_/A gf180mcu_as_sc_mcu7t3v3__ao22_2
X_2247_ VDD VDD VSS VSS _4809_/D _3414_/A _2247_/A gf180mcu_as_sc_mcu7t3v3__nor2b_2
XTAP_TAPCELL_ROW_1_702 VDD VSS gf180mcu_as_sc_mcu7t3v3__tap_2
XPHY_EDGE_ROW_59_1_Right_568 VDD VSS gf180mcu_as_sc_mcu7t3v3__tap_2
XTAP_TAPCELL_ROW_1_713 VDD VSS gf180mcu_as_sc_mcu7t3v3__tap_2
XTAP_TAPCELL_ROW_162_1333 VDD VSS gf180mcu_as_sc_mcu7t3v3__tap_2
XTAP_TAPCELL_ROW_162_1322 VDD VSS gf180mcu_as_sc_mcu7t3v3__tap_2
XFILLER_0_1153 VDD VDD VSS VSS gf180mcu_as_sc_mcu7t3v3__fill_2
XFILLER_13_308 VDD VDD VSS VSS gf180mcu_as_sc_mcu7t3v3__fillcap_4
XFILLER_107_1256 VDD VDD VSS VSS gf180mcu_as_sc_mcu7t3v3__fillcap_8
XFILLER_178_173 VDD VDD VSS VSS gf180mcu_as_sc_mcu7t3v3__fill_2
X_4819_ VDD VDD VSS VSS _4820_/CLK _4819_/D _4819_/Q gf180mcu_as_sc_mcu7t3v3__dfxtp_2
XFILLER_147_68 VDD VDD VSS VSS gf180mcu_as_sc_mcu7t3v3__fill_2
XFILLER_179_1081 VDD VDD VSS VSS gf180mcu_as_sc_mcu7t3v3__fillcap_16
XFILLER_181_349 VDD VDD VSS VSS gf180mcu_as_sc_mcu7t3v3__fill_1
XPHY_EDGE_ROW_96_1_Left_288 VDD VSS gf180mcu_as_sc_mcu7t3v3__tap_2
XFILLER_1_702 VDD VDD VSS VSS gf180mcu_as_sc_mcu7t3v3__fill_1
XFILLER_0_212 VDD VDD VSS VSS gf180mcu_as_sc_mcu7t3v3__fill_1
XTAP_TAPCELL_ROW_9_868 VDD VSS gf180mcu_as_sc_mcu7t3v3__tap_2
XTAP_TAPCELL_ROW_9_857 VDD VSS gf180mcu_as_sc_mcu7t3v3__tap_2
XTAP_TAPCELL_ROW_106_1_1059 VDD VSS gf180mcu_as_sc_mcu7t3v3__tap_2
XFILLER_66_1295 VDD VDD VSS VSS gf180mcu_as_sc_mcu7t3v3__fill_2
Xinput102 VDD VDD VSS VSS ne_in[2] wire812/A gf180mcu_as_sc_mcu7t3v3__buff_12
XFILLER_7_1329 VDD VDD VSS VSS gf180mcu_as_sc_mcu7t3v3__fill_1
Xinput113 VDD VDD VSS VSS ne_in[7] _4064_/A gf180mcu_as_sc_mcu7t3v3__buff_12
Xinput124 VDD VDD VSS VSS north_in[17] _4140_/D gf180mcu_as_sc_mcu7t3v3__buff_12
Xinput135 VDD VDD VSS VSS north_in[27] _4226_/A gf180mcu_as_sc_mcu7t3v3__buff_12
Xinput146 VDD VDD VSS VSS north_in[4] _4037_/D gf180mcu_as_sc_mcu7t3v3__buff_12
Xinput157 VDD VDD VSS VSS nw_in[14] _4120_/D gf180mcu_as_sc_mcu7t3v3__buff_12
Xinput168 VDD VDD VSS VSS nw_in[24] _4203_/A gf180mcu_as_sc_mcu7t3v3__buff_12
XTAP_TAPCELL_ROW_182_1709 VDD VSS gf180mcu_as_sc_mcu7t3v3__tap_2
XFILLER_186_2 VDD VDD VSS VSS gf180mcu_as_sc_mcu7t3v3__fillcap_16
Xclkbuf_3_0__f_clk_regs VDD VDD VSS VSS clkbuf_2_0_0_clk_regs/Y clkbuf_leaf_1_clk_regs/A
+ gf180mcu_as_sc_mcu7t3v3__clkbuff_12
Xinput179 VDD VDD VSS VSS nw_in[34] _3960_/A gf180mcu_as_sc_mcu7t3v3__buff_12
XFILLER_186_1041 VDD VDD VSS VSS gf180mcu_as_sc_mcu7t3v3__fill_2
XFILLER_189_416 VDD VDD VSS VSS gf180mcu_as_sc_mcu7t3v3__fillcap_4
XFILLER_189_449 VDD VDD VSS VSS gf180mcu_as_sc_mcu7t3v3__fillcap_4
XFILLER_158_803 VDD VDD VSS VSS gf180mcu_as_sc_mcu7t3v3__fill_2
XFILLER_72_64 VDD VDD VSS VSS gf180mcu_as_sc_mcu7t3v3__fillcap_8
XFILLER_13_886 VDD VDD VSS VSS gf180mcu_as_sc_mcu7t3v3__fillcap_16
XFILLER_157_302 VDD VDD VSS VSS gf180mcu_as_sc_mcu7t3v3__fill_2
XFILLER_160_1247 VDD VDD VSS VSS gf180mcu_as_sc_mcu7t3v3__fill_2
XFILLER_9_824 VDD VDD VSS VSS gf180mcu_as_sc_mcu7t3v3__fillcap_4
XFILLER_157_368 VDD VDD VSS VSS gf180mcu_as_sc_mcu7t3v3__fillcap_16
XFILLER_188_97 VDD VDD VSS VSS gf180mcu_as_sc_mcu7t3v3__fillcap_8
XFILLER_9_868 VDD VDD VSS VSS gf180mcu_as_sc_mcu7t3v3__fillcap_4
XFILLER_9_846 VDD VDD VSS VSS gf180mcu_as_sc_mcu7t3v3__fill_2
XFILLER_172_305 VDD VDD VSS VSS gf180mcu_as_sc_mcu7t3v3__fillcap_8
XFILLER_173_839 VDD VDD VSS VSS gf180mcu_as_sc_mcu7t3v3__fill_1
XFILLER_153_530 VDD VDD VSS VSS gf180mcu_as_sc_mcu7t3v3__fill_2
XFILLER_158_1132 VDD VDD VSS VSS gf180mcu_as_sc_mcu7t3v3__fill_1
XFILLER_158_1165 VDD VDD VSS VSS gf180mcu_as_sc_mcu7t3v3__fillcap_4
XFILLER_181_850 VDD VDD VSS VSS gf180mcu_as_sc_mcu7t3v3__fillcap_4
XFILLER_181_883 VDD VDD VSS VSS gf180mcu_as_sc_mcu7t3v3__fillcap_8
XFILLER_4_562 VDD VDD VSS VSS gf180mcu_as_sc_mcu7t3v3__fill_1
XFILLER_171_1332 VDD VDD VSS VSS gf180mcu_as_sc_mcu7t3v3__fillcap_8
XFILLER_97_72 VDD VDD VSS VSS gf180mcu_as_sc_mcu7t3v3__fillcap_16
XFILLER_132_1327 VDD VDD VSS VSS gf180mcu_as_sc_mcu7t3v3__fill_2
X_3150_ VDD VDD VSS VSS _3152_/C _4487_/Q _4486_/Q gf180mcu_as_sc_mcu7t3v3__nor2_2
X_3081_ VDD VDD VSS VSS _3081_/B _3081_/A _3084_/B gf180mcu_as_sc_mcu7t3v3__xnor2_2
XTAP_TAPCELL_ROW_21_3_1932 VDD VSS gf180mcu_as_sc_mcu7t3v3__tap_2
XFILLER_169_1294 VDD VDD VSS VSS gf180mcu_as_sc_mcu7t3v3__fillcap_8
XFILLER_165_1169 VDD VDD VSS VSS gf180mcu_as_sc_mcu7t3v3__fillcap_8
Xclkbuf_leaf_26_clk_regs VDD VDD VSS VSS clkload1/A _4726_/CLK gf180mcu_as_sc_mcu7t3v3__clkbuff_12
X_3983_ VDD VDD VSS VSS _4009_/A _4218_/B _3983_/A gf180mcu_as_sc_mcu7t3v3__nand2b_2
X_2934_ VDD VDD VSS VSS _2983_/A _2943_/A _3014_/A gf180mcu_as_sc_mcu7t3v3__and2_2
X_4754__1018 VDD VDD VSS VSS _4754_/D gf180mcu_as_sc_mcu7t3v3__tiel_4
X_2865_ VDD VDD VSS VSS _2867_/C _4183_/A _2894_/B _2865_/C gf180mcu_as_sc_mcu7t3v3__ao21_2
X_4604_ VDD VDD VSS VSS _4828_/CLK _4604_/D _4604_/Q gf180mcu_as_sc_mcu7t3v3__dfxtp_2
XPHY_EDGE_ROW_154_Left_346 VDD VSS gf180mcu_as_sc_mcu7t3v3__tap_2
XFILLER_11_1047 VDD VDD VSS VSS gf180mcu_as_sc_mcu7t3v3__fill_2
XFILLER_89_1262 VDD VDD VSS VSS gf180mcu_as_sc_mcu7t3v3__fill_1
X_4535_ VDD VDD VSS VSS _4804_/CLK _4535_/D _4535_/Q gf180mcu_as_sc_mcu7t3v3__dfxtp_2
X_2796_ VDD VDD VSS VSS _4120_/D _2823_/B _2796_/C _2796_/D _2797_/C gf180mcu_as_sc_mcu7t3v3__ao211_2
XFILLER_117_27 VDD VDD VSS VSS gf180mcu_as_sc_mcu7t3v3__fill_2
XFILLER_172_872 VDD VDD VSS VSS gf180mcu_as_sc_mcu7t3v3__fill_2
XFILLER_176_1243 VDD VDD VSS VSS gf180mcu_as_sc_mcu7t3v3__fillcap_8
XFILLER_190_146 VDD VDD VSS VSS gf180mcu_as_sc_mcu7t3v3__fill_2
XTAP_TAPCELL_ROW_155_1192 VDD VSS gf180mcu_as_sc_mcu7t3v3__tap_2
X_4466_ VDD VDD VSS VSS _4606_/CLK _4466_/D _4466_/Q gf180mcu_as_sc_mcu7t3v3__dfxtp_2
Xfanout803 VDD VDD VSS VSS wire807/A _4272_/C gf180mcu_as_sc_mcu7t3v3__buff_12
X_4397_ VDD VDD VSS VSS clkload8/A _4397_/D _4397_/Q gf180mcu_as_sc_mcu7t3v3__dfxtp_2
X_3417_ VDD VDD VSS VSS _4546_/Q _3449_/D _3584_/D _4545_/Q _4545_/D gf180mcu_as_sc_mcu7t3v3__ao22_2
XTAP_TAPCELL_ROW_6_805 VDD VSS gf180mcu_as_sc_mcu7t3v3__tap_2
X_3348_ VDD VDD VSS VSS _3348_/A _3348_/B _3348_/C _3348_/D _4534_/D gf180mcu_as_sc_mcu7t3v3__ao211_2
XFILLER_133_37 VDD VDD VSS VSS gf180mcu_as_sc_mcu7t3v3__fillcap_16
XPHY_EDGE_ROW_163_Left_355 VDD VSS gf180mcu_as_sc_mcu7t3v3__tap_2
Xhold1056 VDD VDD VSS VSS _2333_/Y hold1056/Y gf180mcu_as_sc_mcu7t3v3__clkbuff_4
Xhold1067 VDD VDD VSS VSS hold1099/Y _4818_/D gf180mcu_as_sc_mcu7t3v3__clkbuff_4
X_3279_ VDD VDD VSS VSS _3282_/C _4426_/Q _3296_/S gf180mcu_as_sc_mcu7t3v3__nand2_2
Xhold1078 VDD VDD VSS VSS _4514_/Q _4322_/A gf180mcu_as_sc_mcu7t3v3__clkbuff_4
Xhold1089 VDD VDD VSS VSS _4816_/Q hold1089/Y gf180mcu_as_sc_mcu7t3v3__clkbuff_4
XFILLER_158_6 VDD VDD VSS VSS gf180mcu_as_sc_mcu7t3v3__fillcap_16
XFILLER_13_138 VDD VDD VSS VSS gf180mcu_as_sc_mcu7t3v3__fillcap_16
XFILLER_183_1269 VDD VDD VSS VSS gf180mcu_as_sc_mcu7t3v3__fill_1
XTAP_TAPCELL_ROW_125_3_2036 VDD VSS gf180mcu_as_sc_mcu7t3v3__tap_2
XFILLER_158_34 VDD VDD VSS VSS gf180mcu_as_sc_mcu7t3v3__fill_1
XFILLER_42_78 VDD VDD VSS VSS gf180mcu_as_sc_mcu7t3v3__fill_1
XPHY_EDGE_ROW_172_Left_364 VDD VSS gf180mcu_as_sc_mcu7t3v3__tap_2
XFILLER_167_699 VDD VDD VSS VSS gf180mcu_as_sc_mcu7t3v3__fill_1
XTAP_TAPCELL_ROW_175_1579 VDD VSS gf180mcu_as_sc_mcu7t3v3__tap_2
XTAP_TAPCELL_ROW_175_1568 VDD VSS gf180mcu_as_sc_mcu7t3v3__tap_2
XFILLER_181_113 VDD VDD VSS VSS gf180mcu_as_sc_mcu7t3v3__fillcap_16
XTAP_TAPCELL_ROW_192_1893 VDD VSS gf180mcu_as_sc_mcu7t3v3__tap_2
XFILLER_174_22 VDD VDD VSS VSS gf180mcu_as_sc_mcu7t3v3__fillcap_8
XFILLER_163_883 VDD VDD VSS VSS gf180mcu_as_sc_mcu7t3v3__fillcap_16
XFILLER_190_1218 VDD VDD VSS VSS gf180mcu_as_sc_mcu7t3v3__fillcap_4
XPHY_EDGE_ROW_181_Left_373 VDD VSS gf180mcu_as_sc_mcu7t3v3__tap_2
XFILLER_75_1306 VDD VDD VSS VSS gf180mcu_as_sc_mcu7t3v3__fillcap_4
XFILLER_177_408 VDD VDD VSS VSS gf180mcu_as_sc_mcu7t3v3__fill_1
XFILLER_189_279 VDD VDD VSS VSS gf180mcu_as_sc_mcu7t3v3__fill_1
XTAP_TAPCELL_ROW_31_1_984 VDD VSS gf180mcu_as_sc_mcu7t3v3__tap_2
XPHY_EDGE_ROW_190_Left_382 VDD VSS gf180mcu_as_sc_mcu7t3v3__tap_2
XFILLER_186_942 VDD VDD VSS VSS gf180mcu_as_sc_mcu7t3v3__fill_2
XFILLER_9_632 VDD VDD VSS VSS gf180mcu_as_sc_mcu7t3v3__fill_1
XFILLER_9_621 VDD VDD VSS VSS gf180mcu_as_sc_mcu7t3v3__fill_2
X_2650_ VDD VDD VSS VSS _2650_/Y _4278_/A _4331_/A gf180mcu_as_sc_mcu7t3v3__nor2_2
XFILLER_9_687 VDD VDD VSS VSS gf180mcu_as_sc_mcu7t3v3__fill_2
XFILLER_160_1099 VDD VDD VSS VSS gf180mcu_as_sc_mcu7t3v3__fill_1
Xoutput417 VDD VDD VSS VSS _4742_/Q west_out[13] gf180mcu_as_sc_mcu7t3v3__buff_12
Xoutput406 VDD VDD VSS VSS _4660_/Q south_out[3] gf180mcu_as_sc_mcu7t3v3__buff_12
X_2581_ VDD VDD VSS VSS _3587_/A _2587_/B _4647_/Q _4646_/D gf180mcu_as_sc_mcu7t3v3__mux2_2
XTAP_TAPCELL_ROW_11_895 VDD VSS gf180mcu_as_sc_mcu7t3v3__tap_2
XFILLER_172_179 VDD VDD VSS VSS gf180mcu_as_sc_mcu7t3v3__fill_1
Xoutput428 VDD VDD VSS VSS _4752_/Q west_out[23] gf180mcu_as_sc_mcu7t3v3__buff_12
Xoutput439 VDD VDD VSS VSS _4762_/Q west_out[33] gf180mcu_as_sc_mcu7t3v3__buff_12
X_4320_ VDD VDD VSS VSS _4804_/D _4512_/Q _4797_/D gf180mcu_as_sc_mcu7t3v3__and2_2
X_4251_ VDD VDD VSS VSS _4252_/B _4251_/C _4251_/B _4261_/A gf180mcu_as_sc_mcu7t3v3__ao21b_2
X_3202_ VDD VDD VSS VSS _3205_/A _4389_/Q _4418_/Q _3203_/B gf180mcu_as_sc_mcu7t3v3__mux2_2
X_4182_ VDD VDD VSS VSS _4794_/Q _4208_/B _4208_/C _4182_/D _4186_/C gf180mcu_as_sc_mcu7t3v3__ao22_2
X_3133_ VDD VDD VSS VSS _3395_/B _3201_/S _3133_/Y gf180mcu_as_sc_mcu7t3v3__and2_2
X_3064_ VDD VDD VSS VSS _3070_/S _3514_/B _4463_/Q _4463_/D gf180mcu_as_sc_mcu7t3v3__mux2_2
XFILLER_169_909 VDD VDD VSS VSS gf180mcu_as_sc_mcu7t3v3__fill_1
X_3966_ VDD VDD VSS VSS _3967_/B _3966_/A _3966_/B _3966_/C gf180mcu_as_sc_mcu7t3v3__ao21_2
XFILLER_17_1267 VDD VDD VSS VSS gf180mcu_as_sc_mcu7t3v3__fillcap_4
X_2917_ VDD VDD VSS VSS _4236_/A _2917_/B _2917_/C _4236_/D _2918_/D gf180mcu_as_sc_mcu7t3v3__ao22_2
XTAP_TAPCELL_ROW_157_1232 VDD VSS gf180mcu_as_sc_mcu7t3v3__tap_2
XTAP_TAPCELL_ROW_157_1221 VDD VSS gf180mcu_as_sc_mcu7t3v3__tap_2
XFILLER_13_1109 VDD VDD VSS VSS gf180mcu_as_sc_mcu7t3v3__fill_1
XFILLER_176_452 VDD VDD VSS VSS gf180mcu_as_sc_mcu7t3v3__fill_2
X_3897_ VDD VDD VSS VSS _3930_/B _4236_/D _3904_/C gf180mcu_as_sc_mcu7t3v3__and2_2
XFILLER_128_37 VDD VDD VSS VSS gf180mcu_as_sc_mcu7t3v3__fillcap_16
XFILLER_12_48 VDD VDD VSS VSS gf180mcu_as_sc_mcu7t3v3__fillcap_16
XFILLER_191_422 VDD VDD VSS VSS gf180mcu_as_sc_mcu7t3v3__fillcap_16
XFILLER_192_945 VDD VDD VSS VSS gf180mcu_as_sc_mcu7t3v3__fillcap_4
X_2848_ VDD VDD VSS VSS _2893_/B _4165_/D _2849_/D gf180mcu_as_sc_mcu7t3v3__and2_2
X_2779_ VDD VDD VSS VSS _2780_/D _4104_/D _2904_/B _2779_/C gf180mcu_as_sc_mcu7t3v3__ao21_2
X_4518_ VDD VDD VSS VSS _4606_/CLK _4518_/D _4518_/Q gf180mcu_as_sc_mcu7t3v3__dfxtp_2
XTAP_TAPCELL_ROW_170_1476 VDD VSS gf180mcu_as_sc_mcu7t3v3__tap_2
XFILLER_176_1084 VDD VDD VSS VSS gf180mcu_as_sc_mcu7t3v3__fill_1
XFILLER_176_1095 VDD VDD VSS VSS gf180mcu_as_sc_mcu7t3v3__fillcap_4
X_4449_ VDD VDD VSS VSS _4783_/CLK _4449_/D _4449_/Q gf180mcu_as_sc_mcu7t3v3__dfxtp_2
Xfanout600 VDD VDD VSS VSS _3445_/B _3443_/B gf180mcu_as_sc_mcu7t3v3__buff_12
Xfanout611 VDD VDD VSS VSS fanout611/A _4148_/C gf180mcu_as_sc_mcu7t3v3__buff_12
Xfanout622 VDD VDD VSS VSS _3136_/Y _3397_/B gf180mcu_as_sc_mcu7t3v3__buff_12
Xfanout633 VDD VDD VSS VSS _2663_/Y _2892_/C gf180mcu_as_sc_mcu7t3v3__buff_12
XFILLER_144_69 VDD VDD VSS VSS gf180mcu_as_sc_mcu7t3v3__fillcap_8
Xfanout655 VDD VDD VSS VSS _3886_/B _3876_/B gf180mcu_as_sc_mcu7t3v3__buff_12
Xfanout666 VDD VDD VSS VSS _3544_/C _3522_/S gf180mcu_as_sc_mcu7t3v3__buff_12
XPHY_EDGE_ROW_127_1_Left_319 VDD VSS gf180mcu_as_sc_mcu7t3v3__tap_2
Xfanout677 VDD VDD VSS VSS fanout678/A _4231_/B gf180mcu_as_sc_mcu7t3v3__buff_12
Xfanout688 VDD VDD VSS VSS _2334_/Y _3587_/A gf180mcu_as_sc_mcu7t3v3__buff_12
Xfanout699 VDD VDD VSS VSS _3617_/Y _3850_/D gf180mcu_as_sc_mcu7t3v3__buff_12
XFILLER_2_1012 VDD VDD VSS VSS gf180mcu_as_sc_mcu7t3v3__fill_2
XFILLER_160_57 VDD VDD VSS VSS gf180mcu_as_sc_mcu7t3v3__fillcap_16
XPHY_EDGE_ROW_128_3_Left_500 VDD VSS gf180mcu_as_sc_mcu7t3v3__tap_2
XFILLER_159_419 VDD VDD VSS VSS gf180mcu_as_sc_mcu7t3v3__fill_1
XFILLER_169_22 VDD VDD VSS VSS gf180mcu_as_sc_mcu7t3v3__fillcap_16
XFILLER_74_1350 VDD VDD VSS VSS gf180mcu_as_sc_mcu7t3v3__fillcap_4
XTAP_TAPCELL_ROW_177_1608 VDD VSS gf180mcu_as_sc_mcu7t3v3__tap_2
XFILLER_183_912 VDD VDD VSS VSS gf180mcu_as_sc_mcu7t3v3__fillcap_4
XFILLER_10_664 VDD VDD VSS VSS gf180mcu_as_sc_mcu7t3v3__fill_1
XFILLER_10_675 VDD VDD VSS VSS gf180mcu_as_sc_mcu7t3v3__fill_1
XFILLER_185_76 VDD VDD VSS VSS gf180mcu_as_sc_mcu7t3v3__fill_1
XFILLER_185_87 VDD VDD VSS VSS gf180mcu_as_sc_mcu7t3v3__fill_2
XFILLER_2_830 VDD VDD VSS VSS gf180mcu_as_sc_mcu7t3v3__fillcap_16
XFILLER_155_1157 VDD VDD VSS VSS gf180mcu_as_sc_mcu7t3v3__fillcap_4
XFILLER_2_874 VDD VDD VSS VSS gf180mcu_as_sc_mcu7t3v3__fill_1
XFILLER_78_85 VDD VDD VSS VSS gf180mcu_as_sc_mcu7t3v3__fillcap_16
XPHY_EDGE_ROW_112_3_Left_484 VDD VSS gf180mcu_as_sc_mcu7t3v3__tap_2
XFILLER_166_1275 VDD VDD VSS VSS gf180mcu_as_sc_mcu7t3v3__fillcap_8
XFILLER_166_1297 VDD VDD VSS VSS gf180mcu_as_sc_mcu7t3v3__fillcap_8
X_3820_ VDD VDD VSS VSS _3820_/B _3945_/A _4676_/D gf180mcu_as_sc_mcu7t3v3__and2_2
XFILLER_158_441 VDD VDD VSS VSS gf180mcu_as_sc_mcu7t3v3__fillcap_4
XFILLER_159_964 VDD VDD VSS VSS gf180mcu_as_sc_mcu7t3v3__fill_2
XFILLER_177_249 VDD VDD VSS VSS gf180mcu_as_sc_mcu7t3v3__fillcap_16
X_3751_ VDD VDD VSS VSS _4102_/A _3876_/B _3751_/C _3876_/D _3754_/B gf180mcu_as_sc_mcu7t3v3__ao211_2
XFILLER_158_474 VDD VDD VSS VSS gf180mcu_as_sc_mcu7t3v3__fill_2
X_2702_ VDD VDD VSS VSS _2829_/B _4036_/D _2703_/D gf180mcu_as_sc_mcu7t3v3__and2_2
XFILLER_9_440 VDD VDD VSS VSS gf180mcu_as_sc_mcu7t3v3__fill_2
XFILLER_173_433 VDD VDD VSS VSS gf180mcu_as_sc_mcu7t3v3__fillcap_16
XFILLER_185_293 VDD VDD VSS VSS gf180mcu_as_sc_mcu7t3v3__fillcap_16
X_3682_ VDD VDD VSS VSS _4040_/A _3799_/B _3798_/B _4039_/A _3683_/D gf180mcu_as_sc_mcu7t3v3__ao22_2
XFILLER_12_1142 VDD VDD VSS VSS gf180mcu_as_sc_mcu7t3v3__fillcap_8
XFILLER_173_455 VDD VDD VSS VSS gf180mcu_as_sc_mcu7t3v3__fill_1
X_2633_ VDD VDD VSS VSS _2660_/C _2635_/C _2662_/A gf180mcu_as_sc_mcu7t3v3__nand2_2
XFILLER_138_1311 VDD VDD VSS VSS gf180mcu_as_sc_mcu7t3v3__fillcap_4
X_2564_ VDD VDD VSS VSS _3481_/A _3047_/C _3608_/D gf180mcu_as_sc_mcu7t3v3__nor2_2
XTAP_TAPCELL_ROW_152_1140 VDD VSS gf180mcu_as_sc_mcu7t3v3__tap_2
XFILLER_173_1224 VDD VDD VSS VSS gf180mcu_as_sc_mcu7t3v3__fillcap_4
X_4303_ VDD VDD VSS VSS _4310_/B _4527_/Q _4780_/D gf180mcu_as_sc_mcu7t3v3__and2_2
X_2495_ VDD VDD VSS VSS _4806_/Q _2495_/B _2495_/A _5070_/A gf180mcu_as_sc_mcu7t3v3__mux2_2
X_4234_ VDD VDD VSS VSS _4234_/D _4234_/A _4247_/B _4234_/C _4235_/C gf180mcu_as_sc_mcu7t3v3__ao31_2
X_4165_ VDD VDD VSS VSS _4165_/A _4207_/B _4207_/C _4165_/D _4166_/C gf180mcu_as_sc_mcu7t3v3__ao22_2
X_3116_ VDD VDD VSS VSS _3116_/S _4504_/Q _4503_/Q _4503_/D gf180mcu_as_sc_mcu7t3v3__mux2_2
XFILLER_3_1343 VDD VDD VSS VSS gf180mcu_as_sc_mcu7t3v3__fillcap_8
X_4096_ VDD VDD VSS VSS _4096_/A _4153_/B _4096_/C _4096_/D _4097_/D gf180mcu_as_sc_mcu7t3v3__ao211_2
X_3047_ VDD VDD VSS VSS _3608_/D _3465_/A _3471_/C _3047_/C _3048_/B gf180mcu_as_sc_mcu7t3v3__ao31_2
XFILLER_110_1285 VDD VDD VSS VSS gf180mcu_as_sc_mcu7t3v3__fillcap_4
XFILLER_184_1353 VDD VDD VSS VSS gf180mcu_as_sc_mcu7t3v3__fill_2
XFILLER_58_1345 VDD VDD VSS VSS gf180mcu_as_sc_mcu7t3v3__fillcap_8
XFILLER_145_1326 VDD VDD VSS VSS gf180mcu_as_sc_mcu7t3v3__fillcap_16
XFILLER_168_227 VDD VDD VSS VSS gf180mcu_as_sc_mcu7t3v3__fillcap_16
XFILLER_11_417 VDD VDD VSS VSS gf180mcu_as_sc_mcu7t3v3__fill_2
XFILLER_165_912 VDD VDD VSS VSS gf180mcu_as_sc_mcu7t3v3__fill_1
XFILLER_177_772 VDD VDD VSS VSS gf180mcu_as_sc_mcu7t3v3__fillcap_16
X_3949_ VDD VDD VSS VSS _3949_/A _3961_/B _3949_/C _3961_/D _3950_/C gf180mcu_as_sc_mcu7t3v3__ao22_2
XFILLER_139_69 VDD VDD VSS VSS gf180mcu_as_sc_mcu7t3v3__fill_1
XTAP_TAPCELL_ROW_172_1516 VDD VSS gf180mcu_as_sc_mcu7t3v3__tap_2
XTAP_TAPCELL_ROW_172_1505 VDD VSS gf180mcu_as_sc_mcu7t3v3__tap_2
XFILLER_178_1135 VDD VDD VSS VSS gf180mcu_as_sc_mcu7t3v3__fillcap_4
XFILLER_192_775 VDD VDD VSS VSS gf180mcu_as_sc_mcu7t3v3__fillcap_4
XFILLER_178_1157 VDD VDD VSS VSS gf180mcu_as_sc_mcu7t3v3__fill_2
XFILLER_3_627 VDD VDD VSS VSS gf180mcu_as_sc_mcu7t3v3__fill_2
XTAP_TAPCELL_ROW_30_1_983 VDD VSS gf180mcu_as_sc_mcu7t3v3__tap_2
Xfanout452 VDD VDD VSS VSS _2977_/Y _3006_/C gf180mcu_as_sc_mcu7t3v3__buff_12
Xfanout463 VDD VDD VSS VSS _3632_/Y _3846_/D gf180mcu_as_sc_mcu7t3v3__buff_12
Xfanout474 VDD VDD VSS VSS _2924_/Y _2965_/B gf180mcu_as_sc_mcu7t3v3__buff_12
XTAP_TAPCELL_ROW_187_1792 VDD VSS gf180mcu_as_sc_mcu7t3v3__tap_2
Xfanout485 VDD VDD VSS VSS _2922_/Y _2965_/D gf180mcu_as_sc_mcu7t3v3__buff_12
Xfanout496 VDD VDD VSS VSS _3921_/B _3882_/B gf180mcu_as_sc_mcu7t3v3__buff_12
XFILLER_189_1286 VDD VDD VSS VSS gf180mcu_as_sc_mcu7t3v3__fillcap_16
XFILLER_159_216 VDD VDD VSS VSS gf180mcu_as_sc_mcu7t3v3__fill_1
XTAP_TAPCELL_ROW_13_935 VDD VSS gf180mcu_as_sc_mcu7t3v3__tap_2
XFILLER_9_49 VDD VDD VSS VSS gf180mcu_as_sc_mcu7t3v3__fillcap_4
XFILLER_161_1150 VDD VDD VSS VSS gf180mcu_as_sc_mcu7t3v3__fillcap_16
XFILLER_174_208 VDD VDD VSS VSS gf180mcu_as_sc_mcu7t3v3__fillcap_4
XTAP_TAPCELL_ROW_13_957 VDD VSS gf180mcu_as_sc_mcu7t3v3__tap_2
XTAP_TAPCELL_ROW_13_946 VDD VSS gf180mcu_as_sc_mcu7t3v3__tap_2
XFILLER_155_422 VDD VDD VSS VSS gf180mcu_as_sc_mcu7t3v3__fillcap_16
XFILLER_168_783 VDD VDD VSS VSS gf180mcu_as_sc_mcu7t3v3__fillcap_8
XFILLER_7_966 VDD VDD VSS VSS gf180mcu_as_sc_mcu7t3v3__fillcap_8
X_2280_ VDD VDD VSS VSS _3478_/B _4622_/Q _3608_/D gf180mcu_as_sc_mcu7t3v3__or2_2
XFILLER_100_19 VDD VDD VSS VSS gf180mcu_as_sc_mcu7t3v3__fillcap_4
X_3803_ VDD VDD VSS VSS _3866_/B _4149_/D _3804_/C gf180mcu_as_sc_mcu7t3v3__and2_2
XFILLER_159_772 VDD VDD VSS VSS gf180mcu_as_sc_mcu7t3v3__fillcap_16
X_4783_ VDD VDD VSS VSS _4783_/CLK _4783_/D _4783_/Q gf180mcu_as_sc_mcu7t3v3__dfxtp_2
X_3734_ VDD VDD VSS VSS _4782_/Q _3806_/B _3734_/C _3734_/D _3735_/C gf180mcu_as_sc_mcu7t3v3__ao22_2
XTAP_TAPCELL_ROW_63_1_1016 VDD VSS gf180mcu_as_sc_mcu7t3v3__tap_2
X_3665_ VDD VDD VSS VSS _4025_/A _3882_/B _3665_/C _3665_/D _3666_/B gf180mcu_as_sc_mcu7t3v3__ao211_2
XFILLER_175_1319 VDD VDD VSS VSS gf180mcu_as_sc_mcu7t3v3__fill_1
X_2616_ VDD VDD VSS VSS _2665_/A _2632_/A _2660_/A gf180mcu_as_sc_mcu7t3v3__nor2_2
X_3596_ VDD VDD VSS VSS _3596_/B _4651_/Q _3597_/C gf180mcu_as_sc_mcu7t3v3__xnor2_2
X_2547_ VDD VDD VSS VSS _4511_/Q _4480_/Q _2548_/D gf180mcu_as_sc_mcu7t3v3__and2_2
X_2478_ VDD VDD VSS VSS _2478_/A _2478_/B _2478_/C _2478_/D _2478_/Y gf180mcu_as_sc_mcu7t3v3__ao22_2
X_4217_ VDD VDD VSS VSS _4217_/A _4225_/B _4217_/C _4217_/D _4219_/D gf180mcu_as_sc_mcu7t3v3__ao22_2
X_4148_ VDD VDD VSS VSS _4790_/Q _4148_/B _4148_/C _4148_/D _4152_/C gf180mcu_as_sc_mcu7t3v3__ao22_2
XTAP_TAPCELL_ROW_165_1375 VDD VSS gf180mcu_as_sc_mcu7t3v3__tap_2
X_4079_ VDD VDD VSS VSS _4082_/B _4154_/S _4079_/A gf180mcu_as_sc_mcu7t3v3__nand2_2
XTAP_TAPCELL_ROW_165_1386 VDD VSS gf180mcu_as_sc_mcu7t3v3__tap_2
XFILLER_184_1150 VDD VDD VSS VSS gf180mcu_as_sc_mcu7t3v3__fillcap_4
XFILLER_12_737 VDD VDD VSS VSS gf180mcu_as_sc_mcu7t3v3__fill_1
XFILLER_180_1014 VDD VDD VSS VSS gf180mcu_as_sc_mcu7t3v3__fill_1
XFILLER_109_102 VDD VDD VSS VSS gf180mcu_as_sc_mcu7t3v3__fill_2
Xclkload1 VDD VDD VSS VSS clkload1/A clkload1/Y gf180mcu_as_sc_mcu7t3v3__clkbuff_12
XFILLER_164_263 VDD VDD VSS VSS gf180mcu_as_sc_mcu7t3v3__fillcap_16
XFILLER_165_797 VDD VDD VSS VSS gf180mcu_as_sc_mcu7t3v3__fillcap_16
XFILLER_50_78 VDD VDD VSS VSS gf180mcu_as_sc_mcu7t3v3__fill_2
XFILLER_4_936 VDD VDD VSS VSS gf180mcu_as_sc_mcu7t3v3__fillcap_8
XFILLER_191_1110 VDD VDD VSS VSS gf180mcu_as_sc_mcu7t3v3__fillcap_8
XTAP_TAPCELL_ROW_189_1843 VDD VSS gf180mcu_as_sc_mcu7t3v3__tap_2
XTAP_TAPCELL_ROW_189_1832 VDD VSS gf180mcu_as_sc_mcu7t3v3__tap_2
XFILLER_160_480 VDD VDD VSS VSS gf180mcu_as_sc_mcu7t3v3__fill_1
XFILLER_191_1154 VDD VDD VSS VSS gf180mcu_as_sc_mcu7t3v3__fillcap_16
XFILLER_59_54 VDD VDD VSS VSS gf180mcu_as_sc_mcu7t3v3__fillcap_4
XFILLER_182_77 VDD VDD VSS VSS gf180mcu_as_sc_mcu7t3v3__fillcap_16
XFILLER_8_1084 VDD VDD VSS VSS gf180mcu_as_sc_mcu7t3v3__fill_1
XFILLER_75_31 VDD VDD VSS VSS gf180mcu_as_sc_mcu7t3v3__fill_2
XFILLER_8_1095 VDD VDD VSS VSS gf180mcu_as_sc_mcu7t3v3__fillcap_4
XFILLER_75_97 VDD VDD VSS VSS gf180mcu_as_sc_mcu7t3v3__fillcap_8
XFILLER_163_1234 VDD VDD VSS VSS gf180mcu_as_sc_mcu7t3v3__fillcap_16
XFILLER_163_1278 VDD VDD VSS VSS gf180mcu_as_sc_mcu7t3v3__fillcap_16
XFILLER_175_517 VDD VDD VSS VSS gf180mcu_as_sc_mcu7t3v3__fillcap_8
XFILLER_188_889 VDD VDD VSS VSS gf180mcu_as_sc_mcu7t3v3__fillcap_8
XFILLER_187_399 VDD VDD VSS VSS gf180mcu_as_sc_mcu7t3v3__fillcap_8
XFILLER_190_509 VDD VDD VSS VSS gf180mcu_as_sc_mcu7t3v3__fillcap_16
XFILLER_156_797 VDD VDD VSS VSS gf180mcu_as_sc_mcu7t3v3__fillcap_8
XFILLER_157_1027 VDD VDD VSS VSS gf180mcu_as_sc_mcu7t3v3__fillcap_16
XFILLER_170_222 VDD VDD VSS VSS gf180mcu_as_sc_mcu7t3v3__fillcap_8
XFILLER_7_796 VDD VDD VSS VSS gf180mcu_as_sc_mcu7t3v3__fillcap_16
X_3450_ VDD VDD VSS VSS _3602_/B _4451_/Q _3450_/Y gf180mcu_as_sc_mcu7t3v3__and2_2
XTAP_TAPCELL_ROW_124_1_1077 VDD VSS gf180mcu_as_sc_mcu7t3v3__tap_2
XFILLER_100_1295 VDD VDD VSS VSS gf180mcu_as_sc_mcu7t3v3__fill_2
XFILLER_157_1049 VDD VDD VSS VSS gf180mcu_as_sc_mcu7t3v3__fill_1
X_3381_ VDD VDD VSS VSS _3389_/B _4458_/Q _3388_/D gf180mcu_as_sc_mcu7t3v3__and2_2
X_2401_ VDD VDD VSS VSS _4619_/Q _2407_/C _2401_/C _2407_/B _2405_/B gf180mcu_as_sc_mcu7t3v3__ao22_2
XFILLER_83_1268 VDD VDD VSS VSS gf180mcu_as_sc_mcu7t3v3__fill_2
X_2332_ VDD VDD VSS VSS _2332_/Y _2333_/B _2333_/A gf180mcu_as_sc_mcu7t3v3__nand2_2
XFILLER_170_1227 VDD VDD VSS VSS gf180mcu_as_sc_mcu7t3v3__fillcap_16
X_4002_ VDD VDD VSS VSS _4272_/A _4005_/A gf180mcu_as_sc_mcu7t3v3__inv_2
X_2263_ VDD VDD VSS VSS _3525_/B _3484_/A _4594_/Q gf180mcu_as_sc_mcu7t3v3__nand2_2
X_2194_ VDD VDD VSS VSS _3560_/D _4480_/Q gf180mcu_as_sc_mcu7t3v3__inv_2
XFILLER_1_72 VDD VDD VSS VSS gf180mcu_as_sc_mcu7t3v3__fillcap_16
XFILLER_52_103 VDD VDD VSS VSS gf180mcu_as_sc_mcu7t3v3__fill_2
XFILLER_178_311 VDD VDD VSS VSS gf180mcu_as_sc_mcu7t3v3__fillcap_4
XFILLER_55_1326 VDD VDD VSS VSS gf180mcu_as_sc_mcu7t3v3__fillcap_4
XTAP_TAPCELL_ROW_160_1294 VDD VSS gf180mcu_as_sc_mcu7t3v3__tap_2
XTAP_TAPCELL_ROW_160_1283 VDD VSS gf180mcu_as_sc_mcu7t3v3__tap_2
XFILLER_142_1307 VDD VDD VSS VSS gf180mcu_as_sc_mcu7t3v3__fillcap_8
XFILLER_166_517 VDD VDD VSS VSS gf180mcu_as_sc_mcu7t3v3__fillcap_8
X_4766_ VDD VDD VSS VSS _4783_/CLK _4766_/D _4766_/Q gf180mcu_as_sc_mcu7t3v3__dfxtp_2
X_3717_ VDD VDD VSS VSS _3719_/C _4071_/A _3798_/B _3717_/C gf180mcu_as_sc_mcu7t3v3__ao21_2
XPHY_EDGE_ROW_136_1_Left_328 VDD VSS gf180mcu_as_sc_mcu7t3v3__tap_2
X_4697_ VDD VDD VSS VSS _4726_/CLK _4697_/D _4697_/Q gf180mcu_as_sc_mcu7t3v3__dfxtp_2
XFILLER_162_734 VDD VDD VSS VSS gf180mcu_as_sc_mcu7t3v3__fill_1
XFILLER_175_1116 VDD VDD VSS VSS gf180mcu_as_sc_mcu7t3v3__fillcap_4
XFILLER_175_1138 VDD VDD VSS VSS gf180mcu_as_sc_mcu7t3v3__fillcap_4
XFILLER_179_1296 VDD VDD VSS VSS gf180mcu_as_sc_mcu7t3v3__fillcap_16
XFILLER_20_37 VDD VDD VSS VSS gf180mcu_as_sc_mcu7t3v3__fillcap_16
X_3648_ VDD VDD VSS VSS _3810_/S _3648_/B _4010_/A _3649_/B gf180mcu_as_sc_mcu7t3v3__mux2_2
XFILLER_136_48 VDD VDD VSS VSS gf180mcu_as_sc_mcu7t3v3__fillcap_16
XFILLER_161_244 VDD VDD VSS VSS gf180mcu_as_sc_mcu7t3v3__fill_2
X_3579_ VDD VDD VSS VSS _3582_/A _3579_/A _4629_/D gf180mcu_as_sc_mcu7t3v3__and2_2
XFILLER_0_416 VDD VDD VSS VSS gf180mcu_as_sc_mcu7t3v3__fill_1
XFILLER_161_277 VDD VDD VSS VSS gf180mcu_as_sc_mcu7t3v3__fill_2
Xinput306 VDD VDD VSS VSS west_in[18] _4150_/A gf180mcu_as_sc_mcu7t3v3__buff_12
Xinput317 VDD VDD VSS VSS west_in[28] _4235_/A gf180mcu_as_sc_mcu7t3v3__buff_12
XTAP_TAPCELL_ROW_167_1426 VDD VSS gf180mcu_as_sc_mcu7t3v3__tap_2
XTAP_TAPCELL_ROW_167_1415 VDD VSS gf180mcu_as_sc_mcu7t3v3__tap_2
XFILLER_152_36 VDD VDD VSS VSS gf180mcu_as_sc_mcu7t3v3__fillcap_16
Xinput328 VDD VDD VSS VSS west_in[5] _4047_/D gf180mcu_as_sc_mcu7t3v3__buff_12
XTAP_TAPCELL_ROW_184_1740 VDD VSS gf180mcu_as_sc_mcu7t3v3__tap_2
XTAP_TAPCELL_ROW_4_766 VDD VSS gf180mcu_as_sc_mcu7t3v3__tap_2
XTAP_TAPCELL_ROW_184_1751 VDD VSS gf180mcu_as_sc_mcu7t3v3__tap_2
XFILLER_186_1267 VDD VDD VSS VSS gf180mcu_as_sc_mcu7t3v3__fill_2
XTAP_TAPCELL_ROW_180_1659 VDD VSS gf180mcu_as_sc_mcu7t3v3__tap_2
XFILLER_169_322 VDD VDD VSS VSS gf180mcu_as_sc_mcu7t3v3__fill_1
XFILLER_101_62 VDD VDD VSS VSS gf180mcu_as_sc_mcu7t3v3__fillcap_8
XFILLER_101_84 VDD VDD VSS VSS gf180mcu_as_sc_mcu7t3v3__fill_1
XFILLER_185_826 VDD VDD VSS VSS gf180mcu_as_sc_mcu7t3v3__fill_1
XFILLER_169_377 VDD VDD VSS VSS gf180mcu_as_sc_mcu7t3v3__fillcap_4
XFILLER_177_22 VDD VDD VSS VSS gf180mcu_as_sc_mcu7t3v3__fillcap_4
XFILLER_184_314 VDD VDD VSS VSS gf180mcu_as_sc_mcu7t3v3__fill_1
XFILLER_185_848 VDD VDD VSS VSS gf180mcu_as_sc_mcu7t3v3__fill_1
XFILLER_36_1281 VDD VDD VSS VSS gf180mcu_as_sc_mcu7t3v3__fillcap_8
XFILLER_8_527 VDD VDD VSS VSS gf180mcu_as_sc_mcu7t3v3__fill_2
XFILLER_61_88 VDD VDD VSS VSS gf180mcu_as_sc_mcu7t3v3__fillcap_16
XFILLER_152_200 VDD VDD VSS VSS gf180mcu_as_sc_mcu7t3v3__fillcap_4
XFILLER_158_1347 VDD VDD VSS VSS gf180mcu_as_sc_mcu7t3v3__fillcap_4
XFILLER_192_380 VDD VDD VSS VSS gf180mcu_as_sc_mcu7t3v3__fill_2
XPHY_EDGE_ROW_69_3_Left_441 VDD VSS gf180mcu_as_sc_mcu7t3v3__tap_2
XFILLER_180_564 VDD VDD VSS VSS gf180mcu_as_sc_mcu7t3v3__fill_2
XPHY_EDGE_ROW_121_3_Left_493 VDD VSS gf180mcu_as_sc_mcu7t3v3__tap_2
XFILLER_180_597 VDD VDD VSS VSS gf180mcu_as_sc_mcu7t3v3__fillcap_16
XFILLER_4_799 VDD VDD VSS VSS gf180mcu_as_sc_mcu7t3v3__fillcap_4
XFILLER_156_1082 VDD VDD VSS VSS gf180mcu_as_sc_mcu7t3v3__fill_2
XFILLER_43_1285 VDD VDD VSS VSS gf180mcu_as_sc_mcu7t3v3__fillcap_8
XFILLER_130_1299 VDD VDD VSS VSS gf180mcu_as_sc_mcu7t3v3__fill_1
XFILLER_142_80 VDD VDD VSS VSS gf180mcu_as_sc_mcu7t3v3__fillcap_16
X_2950_ VDD VDD VSS VSS _2993_/A _2974_/A _3024_/A gf180mcu_as_sc_mcu7t3v3__and2_2
XTAP_TAPCELL_ROW_143_3_2054 VDD VSS gf180mcu_as_sc_mcu7t3v3__tap_2
XFILLER_188_664 VDD VDD VSS VSS gf180mcu_as_sc_mcu7t3v3__fill_1
X_2881_ VDD VDD VSS VSS _4355_/Q _2906_/B _3001_/A _2906_/D _4355_/D gf180mcu_as_sc_mcu7t3v3__ao22_2
XFILLER_163_1086 VDD VDD VSS VSS gf180mcu_as_sc_mcu7t3v3__fillcap_16
XFILLER_176_826 VDD VDD VSS VSS gf180mcu_as_sc_mcu7t3v3__fillcap_4
X_4620_ VDD VDD VSS VSS _4830_/CLK _4620_/D _4620_/Q gf180mcu_as_sc_mcu7t3v3__dfxtp_2
XFILLER_187_196 VDD VDD VSS VSS gf180mcu_as_sc_mcu7t3v3__fill_2
XFILLER_184_881 VDD VDD VSS VSS gf180mcu_as_sc_mcu7t3v3__fill_2
XFILLER_190_317 VDD VDD VSS VSS gf180mcu_as_sc_mcu7t3v3__fillcap_8
XFILLER_191_829 VDD VDD VSS VSS gf180mcu_as_sc_mcu7t3v3__fillcap_8
X_4551_ VDD VDD VSS VSS _4719_/CLK _4551_/D _4551_/Q gf180mcu_as_sc_mcu7t3v3__dfxtp_2
XFILLER_156_594 VDD VDD VSS VSS gf180mcu_as_sc_mcu7t3v3__fill_1
XFILLER_183_391 VDD VDD VSS VSS gf180mcu_as_sc_mcu7t3v3__fill_2
X_4482_ VDD VDD VSS VSS _4720_/CLK _4482_/D _4482_/Q gf180mcu_as_sc_mcu7t3v3__dfxtp_2
X_3502_ VDD VDD VSS VSS _4456_/Q _3504_/C _3502_/C _4603_/Q _3503_/C gf180mcu_as_sc_mcu7t3v3__ao22_2
X_3433_ VDD VDD VSS VSS _4562_/Q _3439_/B _3439_/C _4561_/Q _4561_/D gf180mcu_as_sc_mcu7t3v3__ao22_2
XTAP_TAPCELL_ROW_58_1_1011 VDD VSS gf180mcu_as_sc_mcu7t3v3__tap_2
X_3364_ VDD VDD VSS VSS _3364_/A _3364_/B _3364_/C _3364_/D _4536_/D gf180mcu_as_sc_mcu7t3v3__ao211_2
X_3295_ VDD VDD VSS VSS _3298_/C _4428_/Q _3344_/S gf180mcu_as_sc_mcu7t3v3__nand2_2
X_2315_ VDD VDD VSS VSS _3126_/B _3604_/A _4632_/Q gf180mcu_as_sc_mcu7t3v3__nand2_2
XFILLER_170_1079 VDD VDD VSS VSS gf180mcu_as_sc_mcu7t3v3__fillcap_4
XFILLER_22_1303 VDD VDD VSS VSS gf180mcu_as_sc_mcu7t3v3__fill_2
X_2246_ VDD VDD VSS VSS _2247_/A _4809_/Q _4543_/Q _2553_/A gf180mcu_as_sc_mcu7t3v3__maj3_2
XTAP_TAPCELL_ROW_1_714 VDD VSS gf180mcu_as_sc_mcu7t3v3__tap_2
XTAP_TAPCELL_ROW_1_703 VDD VSS gf180mcu_as_sc_mcu7t3v3__tap_2
XTAP_TAPCELL_ROW_162_1323 VDD VSS gf180mcu_as_sc_mcu7t3v3__tap_2
XFILLER_4_1290 VDD VDD VSS VSS gf180mcu_as_sc_mcu7t3v3__fillcap_4
XFILLER_0_1187 VDD VDD VSS VSS gf180mcu_as_sc_mcu7t3v3__fill_2
XFILLER_107_1268 VDD VDD VSS VSS gf180mcu_as_sc_mcu7t3v3__fillcap_16
XFILLER_179_697 VDD VDD VSS VSS gf180mcu_as_sc_mcu7t3v3__fill_2
XFILLER_181_1186 VDD VDD VSS VSS gf180mcu_as_sc_mcu7t3v3__fillcap_4
XFILLER_182_807 VDD VDD VSS VSS gf180mcu_as_sc_mcu7t3v3__fillcap_8
X_4818_ VDD VDD VSS VSS _4826_/CLK _4818_/D _4818_/Q gf180mcu_as_sc_mcu7t3v3__dfxtp_2
X_4749_ VDD VDD VSS VSS _4751_/CLK _4749_/D _4749_/Q gf180mcu_as_sc_mcu7t3v3__dfxtp_2
XTAP_TAPCELL_ROW_78_3_1989 VDD VSS gf180mcu_as_sc_mcu7t3v3__tap_2
XFILLER_190_873 VDD VDD VSS VSS gf180mcu_as_sc_mcu7t3v3__fill_2
XFILLER_162_597 VDD VDD VSS VSS gf180mcu_as_sc_mcu7t3v3__fillcap_16
XTAP_TAPCELL_ROW_9_869 VDD VSS gf180mcu_as_sc_mcu7t3v3__tap_2
XTAP_TAPCELL_ROW_9_858 VDD VSS gf180mcu_as_sc_mcu7t3v3__tap_2
XFILLER_192_1260 VDD VDD VSS VSS gf180mcu_as_sc_mcu7t3v3__fillcap_16
Xinput103 VDD VDD VSS VSS ne_in[30] _4254_/D gf180mcu_as_sc_mcu7t3v3__buff_12
Xinput114 VDD VDD VSS VSS ne_in[8] _4071_/A gf180mcu_as_sc_mcu7t3v3__buff_12
Xinput125 VDD VDD VSS VSS north_in[18] _4148_/D gf180mcu_as_sc_mcu7t3v3__buff_12
Xinput136 VDD VDD VSS VSS north_in[28] _3901_/A gf180mcu_as_sc_mcu7t3v3__buff_12
Xinput147 VDD VDD VSS VSS north_in[5] _4045_/D gf180mcu_as_sc_mcu7t3v3__buff_12
Xinput158 VDD VDD VSS VSS nw_in[15] _4128_/A gf180mcu_as_sc_mcu7t3v3__buff_12
Xinput169 VDD VDD VSS VSS nw_in[25] _4211_/A gf180mcu_as_sc_mcu7t3v3__buff_12
XFILLER_188_1329 VDD VDD VSS VSS gf180mcu_as_sc_mcu7t3v3__fillcap_16
XFILLER_56_33 VDD VDD VSS VSS gf180mcu_as_sc_mcu7t3v3__fill_2
XFILLER_179_2 VDD VDD VSS VSS gf180mcu_as_sc_mcu7t3v3__fillcap_16
XFILLER_112_83 VDD VDD VSS VSS gf180mcu_as_sc_mcu7t3v3__fillcap_4
XFILLER_112_94 VDD VDD VSS VSS gf180mcu_as_sc_mcu7t3v3__fillcap_8
XFILLER_38_1354 VDD VDD VSS VSS gf180mcu_as_sc_mcu7t3v3__fill_1
XFILLER_72_76 VDD VDD VSS VSS gf180mcu_as_sc_mcu7t3v3__fill_2
XFILLER_73_1256 VDD VDD VSS VSS gf180mcu_as_sc_mcu7t3v3__fillcap_8
XFILLER_157_347 VDD VDD VSS VSS gf180mcu_as_sc_mcu7t3v3__fill_2
XFILLER_184_144 VDD VDD VSS VSS gf180mcu_as_sc_mcu7t3v3__fillcap_4
XFILLER_172_317 VDD VDD VSS VSS gf180mcu_as_sc_mcu7t3v3__fillcap_16
XFILLER_184_177 VDD VDD VSS VSS gf180mcu_as_sc_mcu7t3v3__fillcap_8
XFILLER_158_1199 VDD VDD VSS VSS gf180mcu_as_sc_mcu7t3v3__fillcap_4
XFILLER_171_1344 VDD VDD VSS VSS gf180mcu_as_sc_mcu7t3v3__fill_2
X_3080_ VDD VDD VSS VSS _3080_/A _3080_/B _3080_/C _3080_/D _3081_/B gf180mcu_as_sc_mcu7t3v3__nand4_2
XTAP_TAPCELL_ROW_119_1_1072 VDD VSS gf180mcu_as_sc_mcu7t3v3__tap_2
XFILLER_169_1262 VDD VDD VSS VSS gf180mcu_as_sc_mcu7t3v3__fillcap_16
X_3982_ VDD VDD VSS VSS _3982_/Y _3982_/B _4241_/B gf180mcu_as_sc_mcu7t3v3__nor2_2
X_2933_ VDD VDD VSS VSS _4365_/Q _2945_/C _3013_/A _2951_/D _4365_/D gf180mcu_as_sc_mcu7t3v3__ao22_2
XPHY_EDGE_ROW_156_Right_18 VDD VSS gf180mcu_as_sc_mcu7t3v3__tap_2
XFILLER_164_807 VDD VDD VSS VSS gf180mcu_as_sc_mcu7t3v3__fillcap_8
X_4762__1010 VDD VDD VSS VSS _4762_/D gf180mcu_as_sc_mcu7t3v3__tiel_4
X_2864_ VDD VDD VSS VSS _4794_/Q _2892_/B _2892_/C _4182_/D _2865_/C gf180mcu_as_sc_mcu7t3v3__ao22_2
XFILLER_157_881 VDD VDD VSS VSS gf180mcu_as_sc_mcu7t3v3__fillcap_4
XFILLER_191_626 VDD VDD VSS VSS gf180mcu_as_sc_mcu7t3v3__fillcap_4
X_4603_ VDD VDD VSS VSS _4828_/CLK _4603_/D _4603_/Q gf180mcu_as_sc_mcu7t3v3__dfxtp_2
X_2795_ VDD VDD VSS VSS _4120_/A _2818_/B _2795_/C _2795_/D _2796_/C gf180mcu_as_sc_mcu7t3v3__ao211_2
XFILLER_11_1015 VDD VDD VSS VSS gf180mcu_as_sc_mcu7t3v3__fillcap_16
XFILLER_191_648 VDD VDD VSS VSS gf180mcu_as_sc_mcu7t3v3__fillcap_16
X_4534_ VDD VDD VSS VSS _4795_/CLK _4534_/D _4534_/Q gf180mcu_as_sc_mcu7t3v3__dfxtp_2
XFILLER_8_891 VDD VDD VSS VSS gf180mcu_as_sc_mcu7t3v3__fillcap_16
XTAP_TAPCELL_ROW_155_1193 VDD VSS gf180mcu_as_sc_mcu7t3v3__tap_2
XTAP_TAPCELL_ROW_155_1182 VDD VSS gf180mcu_as_sc_mcu7t3v3__tap_2
XFILLER_172_895 VDD VDD VSS VSS gf180mcu_as_sc_mcu7t3v3__fill_1
X_4465_ VDD VDD VSS VSS _4602_/CLK _4465_/D _4465_/Q gf180mcu_as_sc_mcu7t3v3__dfxtp_2
X_4396_ VDD VDD VSS VSS clkload8/A _4396_/D _4396_/Q gf180mcu_as_sc_mcu7t3v3__dfxtp_2
X_3416_ VDD VDD VSS VSS _4545_/Q _3449_/D _3584_/D _4544_/Q _4544_/D gf180mcu_as_sc_mcu7t3v3__ao22_2
XTAP_TAPCELL_ROW_6_806 VDD VSS gf180mcu_as_sc_mcu7t3v3__tap_2
X_3347_ VDD VDD VSS VSS _4534_/Q _3347_/B _3347_/C _4535_/Q _3348_/C gf180mcu_as_sc_mcu7t3v3__ao22_2
XPHY_EDGE_ROW_165_Right_27 VDD VSS gf180mcu_as_sc_mcu7t3v3__tap_2
XFILLER_26_1291 VDD VDD VSS VSS gf180mcu_as_sc_mcu7t3v3__fill_2
Xhold1057 VDD VDD VSS VSS hold1090/Y _4812_/D gf180mcu_as_sc_mcu7t3v3__clkbuff_4
X_3278_ VDD VDD VSS VSS _3282_/B _4339_/Q _3296_/S gf180mcu_as_sc_mcu7t3v3__nand2b_2
XFILLER_113_1272 VDD VDD VSS VSS gf180mcu_as_sc_mcu7t3v3__fillcap_16
Xhold1068 VDD VDD VSS VSS hold1098/Y _4819_/D gf180mcu_as_sc_mcu7t3v3__clkbuff_4
Xhold1079 VDD VDD VSS VSS _4807_/Q hold1079/Y gf180mcu_as_sc_mcu7t3v3__clkbuff_4
X_2229_ VDD VDD VSS VSS _2420_/B _2229_/A gf180mcu_as_sc_mcu7t3v3__inv_2
XFILLER_148_1302 VDD VDD VSS VSS gf180mcu_as_sc_mcu7t3v3__fillcap_8
XFILLER_183_1215 VDD VDD VSS VSS gf180mcu_as_sc_mcu7t3v3__fillcap_4
XFILLER_26_47 VDD VDD VSS VSS gf180mcu_as_sc_mcu7t3v3__fillcap_8
XPHY_EDGE_ROW_174_Right_36 VDD VSS gf180mcu_as_sc_mcu7t3v3__tap_2
XTAP_TAPCELL_ROW_179_1650 VDD VSS gf180mcu_as_sc_mcu7t3v3__tap_2
XFILLER_154_317 VDD VDD VSS VSS gf180mcu_as_sc_mcu7t3v3__fillcap_16
XTAP_TAPCELL_ROW_175_1569 VDD VSS gf180mcu_as_sc_mcu7t3v3__tap_2
XFILLER_181_158 VDD VDD VSS VSS gf180mcu_as_sc_mcu7t3v3__fillcap_16
XTAP_TAPCELL_ROW_192_1894 VDD VSS gf180mcu_as_sc_mcu7t3v3__tap_2
XFILLER_174_34 VDD VDD VSS VSS gf180mcu_as_sc_mcu7t3v3__fill_1
XTAP_TAPCELL_ROW_26_3_1937 VDD VSS gf180mcu_as_sc_mcu7t3v3__tap_2
XPHY_EDGE_ROW_183_Right_45 VDD VSS gf180mcu_as_sc_mcu7t3v3__tap_2
XFILLER_155_1339 VDD VDD VSS VSS gf180mcu_as_sc_mcu7t3v3__fillcap_8
XFILLER_1_533 VDD VDD VSS VSS gf180mcu_as_sc_mcu7t3v3__fill_2
XFILLER_3_18 VDD VDD VSS VSS gf180mcu_as_sc_mcu7t3v3__fillcap_8
XFILLER_107_72 VDD VDD VSS VSS gf180mcu_as_sc_mcu7t3v3__fillcap_8
XFILLER_192_1090 VDD VDD VSS VSS gf180mcu_as_sc_mcu7t3v3__fill_1
XPHY_EDGE_ROW_192_Right_54 VDD VSS gf180mcu_as_sc_mcu7t3v3__tap_2
XFILLER_158_656 VDD VDD VSS VSS gf180mcu_as_sc_mcu7t3v3__fill_2
XFILLER_186_954 VDD VDD VSS VSS gf180mcu_as_sc_mcu7t3v3__fillcap_4
XFILLER_9_644 VDD VDD VSS VSS gf180mcu_as_sc_mcu7t3v3__fillcap_4
XFILLER_158_667 VDD VDD VSS VSS gf180mcu_as_sc_mcu7t3v3__fillcap_4
XFILLER_186_998 VDD VDD VSS VSS gf180mcu_as_sc_mcu7t3v3__fillcap_8
XFILLER_173_648 VDD VDD VSS VSS gf180mcu_as_sc_mcu7t3v3__fillcap_16
XFILLER_154_851 VDD VDD VSS VSS gf180mcu_as_sc_mcu7t3v3__fill_1
XFILLER_5_850 VDD VDD VSS VSS gf180mcu_as_sc_mcu7t3v3__fillcap_4
Xoutput407 VDD VDD VSS VSS _4661_/Q south_out[4] gf180mcu_as_sc_mcu7t3v3__buff_12
X_2580_ VDD VDD VSS VSS _3528_/A _3585_/A _2587_/B gf180mcu_as_sc_mcu7t3v3__and2_2
XTAP_TAPCELL_ROW_11_896 VDD VSS gf180mcu_as_sc_mcu7t3v3__tap_2
XPHY_EDGE_ROW_29_3_Right_70 VDD VSS gf180mcu_as_sc_mcu7t3v3__tap_2
XFILLER_154_895 VDD VDD VSS VSS gf180mcu_as_sc_mcu7t3v3__fill_1
XFILLER_181_681 VDD VDD VSS VSS gf180mcu_as_sc_mcu7t3v3__fillcap_4
Xoutput418 VDD VDD VSS VSS _4743_/Q west_out[14] gf180mcu_as_sc_mcu7t3v3__buff_12
Xoutput429 VDD VDD VSS VSS _4753_/Q west_out[24] gf180mcu_as_sc_mcu7t3v3__buff_12
XFILLER_5_894 VDD VDD VSS VSS gf180mcu_as_sc_mcu7t3v3__fillcap_16
X_4250_ VDD VDD VSS VSS _4250_/A _4268_/C _4250_/C _4260_/D _4251_/C gf180mcu_as_sc_mcu7t3v3__ao22_2
X_4181_ VDD VDD VSS VSS _4714_/D _4181_/B _4204_/C gf180mcu_as_sc_mcu7t3v3__nor2_2
X_3201_ VDD VDD VSS VSS _3201_/S _4516_/Q _3201_/A _3209_/B gf180mcu_as_sc_mcu7t3v3__mux2_2
XFILLER_136_1272 VDD VDD VSS VSS gf180mcu_as_sc_mcu7t3v3__fillcap_16
XFILLER_171_1152 VDD VDD VSS VSS gf180mcu_as_sc_mcu7t3v3__fillcap_4
X_3132_ VDD VDD VSS VSS _3226_/B _3218_/B _3411_/B gf180mcu_as_sc_mcu7t3v3__and2_2
X_3063_ VDD VDD VSS VSS _3070_/S _3540_/A _4462_/Q _4462_/D gf180mcu_as_sc_mcu7t3v3__mux2_2
XPHY_EDGE_ROW_145_1_Left_337 VDD VSS gf180mcu_as_sc_mcu7t3v3__tap_2
X_3965_ VDD VDD VSS VSS _3965_/D _3965_/A _3965_/B _3965_/C _3966_/C gf180mcu_as_sc_mcu7t3v3__ao31_2
XFILLER_108_1352 VDD VDD VSS VSS gf180mcu_as_sc_mcu7t3v3__fill_2
XFILLER_56_1295 VDD VDD VSS VSS gf180mcu_as_sc_mcu7t3v3__fill_2
X_3896_ VDD VDD VSS VSS _3896_/B _3945_/A _4684_/D gf180mcu_as_sc_mcu7t3v3__and2_2
X_2916_ VDD VDD VSS VSS _2918_/C _4235_/A _2916_/B _2916_/C gf180mcu_as_sc_mcu7t3v3__ao21_2
XTAP_TAPCELL_ROW_157_1222 VDD VSS gf180mcu_as_sc_mcu7t3v3__tap_2
XFILLER_177_998 VDD VDD VSS VSS gf180mcu_as_sc_mcu7t3v3__fillcap_8
X_2847_ VDD VDD VSS VSS _4792_/Q _2892_/B _2892_/C _4167_/D _2849_/C gf180mcu_as_sc_mcu7t3v3__ao22_2
XTAP_TAPCELL_ROW_157_1233 VDD VSS gf180mcu_as_sc_mcu7t3v3__tap_2
XFILLER_128_27 VDD VDD VSS VSS gf180mcu_as_sc_mcu7t3v3__fillcap_8
XFILLER_163_125 VDD VDD VSS VSS gf180mcu_as_sc_mcu7t3v3__fill_1
X_2778_ VDD VDD VSS VSS _4102_/A _2902_/B _2778_/C _2778_/D _2779_/C gf180mcu_as_sc_mcu7t3v3__ao211_2
XFILLER_2_319 VDD VDD VSS VSS gf180mcu_as_sc_mcu7t3v3__fill_1
X_4517_ VDD VDD VSS VSS _4606_/CLK _4517_/D _4517_/Q gf180mcu_as_sc_mcu7t3v3__dfxtp_2
XTAP_TAPCELL_ROW_170_1477 VDD VSS gf180mcu_as_sc_mcu7t3v3__tap_2
XFILLER_160_843 VDD VDD VSS VSS gf180mcu_as_sc_mcu7t3v3__fillcap_4
X_4448_ VDD VDD VSS VSS _4783_/CLK _4448_/D _4448_/Q gf180mcu_as_sc_mcu7t3v3__dfxtp_2
XFILLER_115_1301 VDD VDD VSS VSS gf180mcu_as_sc_mcu7t3v3__fillcap_8
XFILLER_144_37 VDD VDD VSS VSS gf180mcu_as_sc_mcu7t3v3__fillcap_16
Xfanout601 VDD VDD VSS VSS _3449_/D _3445_/B gf180mcu_as_sc_mcu7t3v3__buff_12
Xfanout612 VDD VDD VSS VSS _3988_/Y _4208_/C gf180mcu_as_sc_mcu7t3v3__buff_12
Xfanout623 VDD VDD VSS VSS _3333_/B _3405_/B gf180mcu_as_sc_mcu7t3v3__buff_12
XPHY_EDGE_ROW_16_3_Left_388 VDD VSS gf180mcu_as_sc_mcu7t3v3__tap_2
Xfanout645 VDD VDD VSS VSS _4244_/C _4134_/B gf180mcu_as_sc_mcu7t3v3__buff_12
Xfanout656 VDD VDD VSS VSS _3636_/Y _3886_/B gf180mcu_as_sc_mcu7t3v3__buff_12
Xfanout667 VDD VDD VSS VSS _3553_/B _3504_/C gf180mcu_as_sc_mcu7t3v3__buff_12
X_4379_ VDD VDD VSS VSS _4440_/CLK _4379_/D _4379_/Q gf180mcu_as_sc_mcu7t3v3__dfxtp_2
Xfanout678 VDD VDD VSS VSS fanout678/A _4149_/B gf180mcu_as_sc_mcu7t3v3__buff_12
Xfanout689 VDD VDD VSS VSS _2334_/Y _4829_/D gf180mcu_as_sc_mcu7t3v3__buff_12
XPHY_EDGE_ROW_77_1_Left_269 VDD VSS gf180mcu_as_sc_mcu7t3v3__tap_2
XFILLER_150_1269 VDD VDD VSS VSS gf180mcu_as_sc_mcu7t3v3__fillcap_16
XFILLER_170_6 VDD VDD VSS VSS gf180mcu_as_sc_mcu7t3v3__fillcap_16
XFILLER_2_1024 VDD VDD VSS VSS gf180mcu_as_sc_mcu7t3v3__fill_2
XFILLER_187_1192 VDD VDD VSS VSS gf180mcu_as_sc_mcu7t3v3__fillcap_8
XPHY_EDGE_ROW_78_3_Left_450 VDD VSS gf180mcu_as_sc_mcu7t3v3__tap_2
XFILLER_187_729 VDD VDD VSS VSS gf180mcu_as_sc_mcu7t3v3__fillcap_4
XTAP_TAPCELL_ROW_177_1609 VDD VSS gf180mcu_as_sc_mcu7t3v3__tap_2
XFILLER_169_67 VDD VDD VSS VSS gf180mcu_as_sc_mcu7t3v3__fill_2
XTAP_TAPCELL_ROW_81_1_1034 VDD VSS gf180mcu_as_sc_mcu7t3v3__tap_2
XFILLER_167_486 VDD VDD VSS VSS gf180mcu_as_sc_mcu7t3v3__fillcap_4
XFILLER_183_957 VDD VDD VSS VSS gf180mcu_as_sc_mcu7t3v3__fillcap_16
XFILLER_154_158 VDD VDD VSS VSS gf180mcu_as_sc_mcu7t3v3__fillcap_16
XFILLER_183_979 VDD VDD VSS VSS gf180mcu_as_sc_mcu7t3v3__fill_1
XFILLER_5_146 VDD VDD VSS VSS gf180mcu_as_sc_mcu7t3v3__fill_1
XFILLER_190_1049 VDD VDD VSS VSS gf180mcu_as_sc_mcu7t3v3__fillcap_8
Xmesh_tile_1000 VDD VDD VSS VSS sw_out[28] gf180mcu_as_sc_mcu7t3v3__tiel_4
XFILLER_166_1210 VDD VDD VSS VSS gf180mcu_as_sc_mcu7t3v3__fill_1
XFILLER_166_1243 VDD VDD VSS VSS gf180mcu_as_sc_mcu7t3v3__fillcap_16
X_3750_ VDD VDD VSS VSS _3875_/B _4100_/D _3751_/C gf180mcu_as_sc_mcu7t3v3__and2_2
X_2701_ VDD VDD VSS VSS _4776_/Q _2828_/B _2828_/C _4037_/D _2703_/C gf180mcu_as_sc_mcu7t3v3__ao22_2
X_3681_ VDD VDD VSS VSS _3681_/D _3796_/B _3681_/B _3681_/C _3683_/C gf180mcu_as_sc_mcu7t3v3__ao31_2
XFILLER_174_979 VDD VDD VSS VSS gf180mcu_as_sc_mcu7t3v3__fillcap_16
X_2632_ VDD VDD VSS VSS _2632_/A _2665_/B _2632_/C _2632_/D _2635_/C gf180mcu_as_sc_mcu7t3v3__ao211_2
XFILLER_9_496 VDD VDD VSS VSS gf180mcu_as_sc_mcu7t3v3__fill_1
XFILLER_161_629 VDD VDD VSS VSS gf180mcu_as_sc_mcu7t3v3__fill_1
XFILLER_173_489 VDD VDD VSS VSS gf180mcu_as_sc_mcu7t3v3__fill_1
XFILLER_57_2 VDD VDD VSS VSS gf180mcu_as_sc_mcu7t3v3__fillcap_4
X_2563_ VDD VDD VSS VSS _3047_/C _2563_/A _2563_/B _2563_/C _2563_/D gf180mcu_as_sc_mcu7t3v3__aoi22_2
XTAP_TAPCELL_ROW_152_1141 VDD VSS gf180mcu_as_sc_mcu7t3v3__tap_2
XTAP_TAPCELL_ROW_152_1130 VDD VSS gf180mcu_as_sc_mcu7t3v3__tap_2
X_4302_ VDD VDD VSS VSS _4313_/B _4526_/Q _4779_/D gf180mcu_as_sc_mcu7t3v3__and2_2
XFILLER_173_1247 VDD VDD VSS VSS gf180mcu_as_sc_mcu7t3v3__fill_1
XFILLER_86_1288 VDD VDD VSS VSS gf180mcu_as_sc_mcu7t3v3__fill_1
X_4233_ VDD VDD VSS VSS _4800_/Q _4264_/B _4233_/C _4233_/D _4234_/D gf180mcu_as_sc_mcu7t3v3__ao22_2
X_2494_ VDD VDD VSS VSS _2494_/A _2494_/B _2494_/C _2494_/D _2494_/Y gf180mcu_as_sc_mcu7t3v3__ao22_2
X_4164_ VDD VDD VSS VSS _4164_/B _4213_/A _4712_/D gf180mcu_as_sc_mcu7t3v3__and2_2
X_4095_ VDD VDD VSS VSS _4143_/B _4095_/A _4097_/C gf180mcu_as_sc_mcu7t3v3__and2_2
X_3115_ VDD VDD VSS VSS _3116_/S _4503_/Q _4502_/Q _4502_/D gf180mcu_as_sc_mcu7t3v3__mux2_2
XFILLER_167_1018 VDD VDD VSS VSS gf180mcu_as_sc_mcu7t3v3__fillcap_4
XFILLER_23_1272 VDD VDD VSS VSS gf180mcu_as_sc_mcu7t3v3__fillcap_16
X_3046_ VDD VDD VSS VSS _3048_/A _3046_/C _3471_/C _3465_/A gf180mcu_as_sc_mcu7t3v3__aoi21_2
XFILLER_110_1264 VDD VDD VSS VSS gf180mcu_as_sc_mcu7t3v3__fillcap_4
XFILLER_169_718 VDD VDD VSS VSS gf180mcu_as_sc_mcu7t3v3__fillcap_16
XFILLER_11_429 VDD VDD VSS VSS gf180mcu_as_sc_mcu7t3v3__fillcap_8
Xclkbuf_leaf_10_clk_regs VDD VDD VSS VSS clkbuf_leaf_9_clk_regs/A _4440_/CLK gf180mcu_as_sc_mcu7t3v3__clkbuff_12
XFILLER_177_751 VDD VDD VSS VSS gf180mcu_as_sc_mcu7t3v3__fillcap_4
X_3948_ VDD VDD VSS VSS _3948_/D _3948_/A _3959_/B _3960_/C _3950_/B gf180mcu_as_sc_mcu7t3v3__ao31_2
XFILLER_165_924 VDD VDD VSS VSS gf180mcu_as_sc_mcu7t3v3__fill_2
XFILLER_178_1103 VDD VDD VSS VSS gf180mcu_as_sc_mcu7t3v3__fillcap_16
X_3879_ VDD VDD VSS VSS _3880_/D _4217_/D _3879_/B _3910_/D gf180mcu_as_sc_mcu7t3v3__ao21_2
XTAP_TAPCELL_ROW_172_1517 VDD VSS gf180mcu_as_sc_mcu7t3v3__tap_2
XTAP_TAPCELL_ROW_172_1506 VDD VSS gf180mcu_as_sc_mcu7t3v3__tap_2
XTAP_TAPCELL_ROW_142_1_1095 VDD VSS gf180mcu_as_sc_mcu7t3v3__tap_2
XPHY_EDGE_ROW_139_3_Right_180 VDD VSS gf180mcu_as_sc_mcu7t3v3__tap_2
XFILLER_152_618 VDD VDD VSS VSS gf180mcu_as_sc_mcu7t3v3__fill_1
XFILLER_155_14 VDD VDD VSS VSS gf180mcu_as_sc_mcu7t3v3__fillcap_4
XFILLER_178_1169 VDD VDD VSS VSS gf180mcu_as_sc_mcu7t3v3__fillcap_16
XFILLER_30_1276 VDD VDD VSS VSS gf180mcu_as_sc_mcu7t3v3__fillcap_4
XFILLER_155_58 VDD VDD VSS VSS gf180mcu_as_sc_mcu7t3v3__fill_1
XFILLER_173_990 VDD VDD VSS VSS gf180mcu_as_sc_mcu7t3v3__fill_2
Xfanout453 VDD VDD VSS VSS _2826_/B _2772_/B gf180mcu_as_sc_mcu7t3v3__buff_12
Xfanout464 VDD VDD VSS VSS _3024_/C _3020_/S gf180mcu_as_sc_mcu7t3v3__buff_12
Xfanout475 VDD VDD VSS VSS _2924_/Y _2975_/B gf180mcu_as_sc_mcu7t3v3__buff_12
XTAP_TAPCELL_ROW_187_1793 VDD VSS gf180mcu_as_sc_mcu7t3v3__tap_2
Xfanout486 VDD VDD VSS VSS _2922_/Y _2975_/D gf180mcu_as_sc_mcu7t3v3__buff_12
Xfanout497 VDD VDD VSS VSS _3634_/Y _3932_/S gf180mcu_as_sc_mcu7t3v3__buff_12
Xmesh_tile_890 VDD VDD VSS VSS north_out[26] gf180mcu_as_sc_mcu7t3v3__tiel_4
XFILLER_104_73 VDD VDD VSS VSS gf180mcu_as_sc_mcu7t3v3__fill_2
XFILLER_159_239 VDD VDD VSS VSS gf180mcu_as_sc_mcu7t3v3__fill_1
XFILLER_187_548 VDD VDD VSS VSS gf180mcu_as_sc_mcu7t3v3__fillcap_4
XFILLER_39_1290 VDD VDD VSS VSS gf180mcu_as_sc_mcu7t3v3__fill_2
Xwire810 VDD VDD VSS VSS wire810/A _3911_/A gf180mcu_as_sc_mcu7t3v3__clkbuff_12
XTAP_TAPCELL_ROW_13_958 VDD VSS gf180mcu_as_sc_mcu7t3v3__tap_2
XTAP_TAPCELL_ROW_13_947 VDD VSS gf180mcu_as_sc_mcu7t3v3__tap_2
XTAP_TAPCELL_ROW_13_936 VDD VSS gf180mcu_as_sc_mcu7t3v3__tap_2
XFILLER_7_923 VDD VDD VSS VSS gf180mcu_as_sc_mcu7t3v3__fill_2
XFILLER_171_905 VDD VDD VSS VSS gf180mcu_as_sc_mcu7t3v3__fillcap_4
XFILLER_182_231 VDD VDD VSS VSS gf180mcu_as_sc_mcu7t3v3__fill_2
XFILLER_7_978 VDD VDD VSS VSS gf180mcu_as_sc_mcu7t3v3__fill_2
XFILLER_145_80 VDD VDD VSS VSS gf180mcu_as_sc_mcu7t3v3__fill_1
X_3802_ VDD VDD VSS VSS _3802_/B _3945_/A _4674_/D gf180mcu_as_sc_mcu7t3v3__and2_2
XFILLER_105_1300 VDD VDD VSS VSS gf180mcu_as_sc_mcu7t3v3__fill_1
XFILLER_105_1322 VDD VDD VSS VSS gf180mcu_as_sc_mcu7t3v3__fill_2
X_4782_ VDD VDD VSS VSS _4783_/CLK _4782_/D _4782_/Q gf180mcu_as_sc_mcu7t3v3__dfxtp_2
XPHY_EDGE_ROW_110_1_Right_619 VDD VSS gf180mcu_as_sc_mcu7t3v3__tap_2
XFILLER_186_592 VDD VDD VSS VSS gf180mcu_as_sc_mcu7t3v3__fill_2
X_3733_ VDD VDD VSS VSS _3734_/D _4084_/A _3796_/B _3823_/C gf180mcu_as_sc_mcu7t3v3__ao21_2
X_3664_ VDD VDD VSS VSS _4774_/Q _3852_/B _3881_/B _4024_/A _3665_/D gf180mcu_as_sc_mcu7t3v3__ao22_2
X_2615_ VDD VDD VSS VSS _3964_/B _3618_/A _3975_/B _2632_/A gf180mcu_as_sc_mcu7t3v3__nand3_2
X_3595_ VDD VDD VSS VSS _3596_/B _4651_/Q _3598_/B gf180mcu_as_sc_mcu7t3v3__and2_2
XFILLER_173_1022 VDD VDD VSS VSS gf180mcu_as_sc_mcu7t3v3__fill_1
X_2546_ VDD VDD VSS VSS _2551_/A _3560_/D _2546_/B _3128_/A gf180mcu_as_sc_mcu7t3v3__ao21_2
X_2477_ VDD VDD VSS VSS _2478_/D _2493_/C _4807_/D _2477_/A gf180mcu_as_sc_mcu7t3v3__aoi21b_2
XFILLER_151_1320 VDD VDD VSS VSS gf180mcu_as_sc_mcu7t3v3__fillcap_4
X_4216_ VDD VDD VSS VSS _4219_/C _4216_/A _4216_/B _4246_/C gf180mcu_as_sc_mcu7t3v3__ao21_2
XFILLER_151_1353 VDD VDD VSS VSS gf180mcu_as_sc_mcu7t3v3__fill_2
X_4147_ VDD VDD VSS VSS _4147_/B _4213_/A _4710_/D gf180mcu_as_sc_mcu7t3v3__and2_2
XFILLER_18_48 VDD VDD VSS VSS gf180mcu_as_sc_mcu7t3v3__fillcap_8
XTAP_TAPCELL_ROW_165_1376 VDD VSS gf180mcu_as_sc_mcu7t3v3__tap_2
X_4078_ VDD VDD VSS VSS _4078_/A _4235_/B _4078_/C _4151_/A _4080_/D gf180mcu_as_sc_mcu7t3v3__ao22_2
XTAP_TAPCELL_ROW_165_1387 VDD VSS gf180mcu_as_sc_mcu7t3v3__tap_2
XFILLER_70_104 VDD VDD VSS VSS gf180mcu_as_sc_mcu7t3v3__fill_1
X_3029_ VDD VDD VSS VSS _3029_/A _3034_/B _4276_/A _4439_/Q _4439_/D gf180mcu_as_sc_mcu7t3v3__ao22_2
XFILLER_169_559 VDD VDD VSS VSS gf180mcu_as_sc_mcu7t3v3__fill_1
XFILLER_180_1037 VDD VDD VSS VSS gf180mcu_as_sc_mcu7t3v3__fill_2
XFILLER_156_209 VDD VDD VSS VSS gf180mcu_as_sc_mcu7t3v3__fill_2
Xclkload2 VDD VDD VSS VSS clkload2/A clkload2/Y gf180mcu_as_sc_mcu7t3v3__clkbuff_12
XFILLER_192_551 VDD VDD VSS VSS gf180mcu_as_sc_mcu7t3v3__fillcap_4
XFILLER_192_584 VDD VDD VSS VSS gf180mcu_as_sc_mcu7t3v3__fill_2
XFILLER_4_904 VDD VDD VSS VSS gf180mcu_as_sc_mcu7t3v3__fillcap_16
XFILLER_152_426 VDD VDD VSS VSS gf180mcu_as_sc_mcu7t3v3__fillcap_8
XFILLER_3_414 VDD VDD VSS VSS gf180mcu_as_sc_mcu7t3v3__fillcap_4
XFILLER_191_1122 VDD VDD VSS VSS gf180mcu_as_sc_mcu7t3v3__fillcap_16
XTAP_TAPCELL_ROW_189_1844 VDD VSS gf180mcu_as_sc_mcu7t3v3__tap_2
XTAP_TAPCELL_ROW_189_1833 VDD VSS gf180mcu_as_sc_mcu7t3v3__tap_2
XFILLER_152_1106 VDD VDD VSS VSS gf180mcu_as_sc_mcu7t3v3__fillcap_16
XFILLER_156_1264 VDD VDD VSS VSS gf180mcu_as_sc_mcu7t3v3__fill_1
XFILLER_161_982 VDD VDD VSS VSS gf180mcu_as_sc_mcu7t3v3__fillcap_16
XFILLER_182_34 VDD VDD VSS VSS gf180mcu_as_sc_mcu7t3v3__fill_1
XFILLER_182_45 VDD VDD VSS VSS gf180mcu_as_sc_mcu7t3v3__fillcap_4
XFILLER_156_1297 VDD VDD VSS VSS gf180mcu_as_sc_mcu7t3v3__fillcap_16
XFILLER_160_492 VDD VDD VSS VSS gf180mcu_as_sc_mcu7t3v3__fillcap_16
XFILLER_59_99 VDD VDD VSS VSS gf180mcu_as_sc_mcu7t3v3__fillcap_4
XFILLER_115_72 VDD VDD VSS VSS gf180mcu_as_sc_mcu7t3v3__fillcap_16
XFILLER_61_104 VDD VDD VSS VSS gf180mcu_as_sc_mcu7t3v3__fill_1
XFILLER_188_802 VDD VDD VSS VSS gf180mcu_as_sc_mcu7t3v3__fill_2
XFILLER_163_1257 VDD VDD VSS VSS gf180mcu_as_sc_mcu7t3v3__fill_2
XFILLER_11_760 VDD VDD VSS VSS gf180mcu_as_sc_mcu7t3v3__fillcap_8
XFILLER_168_581 VDD VDD VSS VSS gf180mcu_as_sc_mcu7t3v3__fillcap_8
XFILLER_155_220 VDD VDD VSS VSS gf180mcu_as_sc_mcu7t3v3__fill_2
XFILLER_7_731 VDD VDD VSS VSS gf180mcu_as_sc_mcu7t3v3__fillcap_16
XFILLER_13_1260 VDD VDD VSS VSS gf180mcu_as_sc_mcu7t3v3__fillcap_4
XFILLER_171_702 VDD VDD VSS VSS gf180mcu_as_sc_mcu7t3v3__fillcap_16
XFILLER_171_724 VDD VDD VSS VSS gf180mcu_as_sc_mcu7t3v3__fill_1
XFILLER_155_286 VDD VDD VSS VSS gf180mcu_as_sc_mcu7t3v3__fill_2
XFILLER_183_595 VDD VDD VSS VSS gf180mcu_as_sc_mcu7t3v3__fillcap_8
Xwire695 VDD VDD VSS VSS wire695/A _3859_/B gf180mcu_as_sc_mcu7t3v3__clkbuff_12
X_2400_ VDD VDD VSS VSS _3587_/A _4614_/Q _4602_/Q _2401_/C gf180mcu_as_sc_mcu7t3v3__mux2_2
XFILLER_171_768 VDD VDD VSS VSS gf180mcu_as_sc_mcu7t3v3__fill_2
X_3380_ VDD VDD VSS VSS _3396_/A _3380_/B _3380_/C _3380_/D _4538_/D gf180mcu_as_sc_mcu7t3v3__ao211_2
XPHY_EDGE_ROW_30_3_Left_402 VDD VSS gf180mcu_as_sc_mcu7t3v3__tap_2
XFILLER_135_1326 VDD VDD VSS VSS gf180mcu_as_sc_mcu7t3v3__fillcap_4
X_2331_ VDD VDD VSS VSS _4329_/S _2331_/B _2424_/A gf180mcu_as_sc_mcu7t3v3__nand2b_2
X_2262_ VDD VDD VSS VSS _2510_/D _3131_/A _3572_/B _3484_/A gf180mcu_as_sc_mcu7t3v3__nand3_2
X_4001_ VDD VDD VSS VSS _4259_/D _4261_/A _4001_/C _4005_/A gf180mcu_as_sc_mcu7t3v3__nand3_2
X_2193_ VDD VDD VSS VSS _2550_/A _3128_/A gf180mcu_as_sc_mcu7t3v3__inv_2
XFILLER_0_1325 VDD VDD VSS VSS gf180mcu_as_sc_mcu7t3v3__fill_1
XFILLER_168_1157 VDD VDD VSS VSS gf180mcu_as_sc_mcu7t3v3__fill_2
XFILLER_181_1302 VDD VDD VSS VSS gf180mcu_as_sc_mcu7t3v3__fill_2
XFILLER_179_835 VDD VDD VSS VSS gf180mcu_as_sc_mcu7t3v3__fillcap_4
XFILLER_179_846 VDD VDD VSS VSS gf180mcu_as_sc_mcu7t3v3__fill_2
XTAP_TAPCELL_ROW_160_1295 VDD VSS gf180mcu_as_sc_mcu7t3v3__tap_2
XTAP_TAPCELL_ROW_160_1284 VDD VSS gf180mcu_as_sc_mcu7t3v3__tap_2
XFILLER_142_1319 VDD VDD VSS VSS gf180mcu_as_sc_mcu7t3v3__fill_1
X_4765_ VDD VDD VSS VSS _4795_/CLK _4765_/D _4765_/Q gf180mcu_as_sc_mcu7t3v3__dfxtp_2
XPHY_EDGE_ROW_25_3_Left_397 VDD VSS gf180mcu_as_sc_mcu7t3v3__tap_2
X_3716_ VDD VDD VSS VSS _4780_/Q _3806_/B _3716_/C _3716_/D _3717_/C gf180mcu_as_sc_mcu7t3v3__ao22_2
X_4696_ VDD VDD VSS VSS _4719_/CLK _4696_/D _4696_/Q gf180mcu_as_sc_mcu7t3v3__dfxtp_2
XPHY_EDGE_ROW_86_1_Left_278 VDD VSS gf180mcu_as_sc_mcu7t3v3__tap_2
XFILLER_161_201 VDD VDD VSS VSS gf180mcu_as_sc_mcu7t3v3__fill_2
XFILLER_161_212 VDD VDD VSS VSS gf180mcu_as_sc_mcu7t3v3__fillcap_16
XFILLER_179_1286 VDD VDD VSS VSS gf180mcu_as_sc_mcu7t3v3__fill_2
X_3647_ VDD VDD VSS VSS _4008_/D _3882_/B _3647_/C _3647_/D _3648_/B gf180mcu_as_sc_mcu7t3v3__ao211_2
X_3578_ VDD VDD VSS VSS _3604_/A _3578_/A _4628_/D gf180mcu_as_sc_mcu7t3v3__and2_2
XFILLER_170_790 VDD VDD VSS VSS gf180mcu_as_sc_mcu7t3v3__fillcap_8
X_2529_ VDD VDD VSS VSS _2529_/D _3080_/B _3080_/C _2529_/C _2530_/D gf180mcu_as_sc_mcu7t3v3__ao31_2
Xinput307 VDD VDD VSS VSS west_in[19] _4159_/A gf180mcu_as_sc_mcu7t3v3__buff_12
Xinput318 VDD VDD VSS VSS west_in[29] _4242_/A gf180mcu_as_sc_mcu7t3v3__buff_12
XTAP_TAPCELL_ROW_167_1427 VDD VSS gf180mcu_as_sc_mcu7t3v3__tap_2
XTAP_TAPCELL_ROW_167_1416 VDD VSS gf180mcu_as_sc_mcu7t3v3__tap_2
XFILLER_29_69 VDD VDD VSS VSS gf180mcu_as_sc_mcu7t3v3__fill_1
Xinput329 VDD VDD VSS VSS west_in[6] _4055_/D gf180mcu_as_sc_mcu7t3v3__buff_12
XTAP_TAPCELL_ROW_137_1_1090 VDD VSS gf180mcu_as_sc_mcu7t3v3__tap_2
XFILLER_28_101 VDD VDD VSS VSS gf180mcu_as_sc_mcu7t3v3__fillcap_4
XTAP_TAPCELL_ROW_4_767 VDD VSS gf180mcu_as_sc_mcu7t3v3__tap_2
XTAP_TAPCELL_ROW_184_1741 VDD VSS gf180mcu_as_sc_mcu7t3v3__tap_2
XFILLER_186_1224 VDD VDD VSS VSS gf180mcu_as_sc_mcu7t3v3__fill_1
XFILLER_43_104 VDD VDD VSS VSS gf180mcu_as_sc_mcu7t3v3__fill_1
XFILLER_99_1298 VDD VDD VSS VSS gf180mcu_as_sc_mcu7t3v3__fill_1
XFILLER_45_68 VDD VDD VSS VSS gf180mcu_as_sc_mcu7t3v3__fill_2
XFILLER_124_2 VDD VDD VSS VSS gf180mcu_as_sc_mcu7t3v3__fillcap_4
XFILLER_177_56 VDD VDD VSS VSS gf180mcu_as_sc_mcu7t3v3__fillcap_8
XFILLER_165_562 VDD VDD VSS VSS gf180mcu_as_sc_mcu7t3v3__fillcap_16
XFILLER_6_18 VDD VDD VSS VSS gf180mcu_as_sc_mcu7t3v3__fillcap_16
XFILLER_153_735 VDD VDD VSS VSS gf180mcu_as_sc_mcu7t3v3__fill_2
XFILLER_180_510 VDD VDD VSS VSS gf180mcu_as_sc_mcu7t3v3__fillcap_8
XFILLER_152_234 VDD VDD VSS VSS gf180mcu_as_sc_mcu7t3v3__fillcap_4
XFILLER_152_256 VDD VDD VSS VSS gf180mcu_as_sc_mcu7t3v3__fillcap_16
XFILLER_4_767 VDD VDD VSS VSS gf180mcu_as_sc_mcu7t3v3__fillcap_16
XFILLER_156_1072 VDD VDD VSS VSS gf180mcu_as_sc_mcu7t3v3__fill_1
XFILLER_3_299 VDD VDD VSS VSS gf180mcu_as_sc_mcu7t3v3__fill_1
XFILLER_0_984 VDD VDD VSS VSS gf180mcu_as_sc_mcu7t3v3__fill_2
XFILLER_82_1280 VDD VDD VSS VSS gf180mcu_as_sc_mcu7t3v3__fill_2
XFILLER_82_1291 VDD VDD VSS VSS gf180mcu_as_sc_mcu7t3v3__fillcap_8
XFILLER_130_1256 VDD VDD VSS VSS gf180mcu_as_sc_mcu7t3v3__fillcap_16
XFILLER_43_1297 VDD VDD VSS VSS gf180mcu_as_sc_mcu7t3v3__fill_2
XFILLER_165_1319 VDD VDD VSS VSS gf180mcu_as_sc_mcu7t3v3__fill_1
XFILLER_187_142 VDD VDD VSS VSS gf180mcu_as_sc_mcu7t3v3__fillcap_4
X_2880_ VDD VDD VSS VSS _4196_/A _2919_/B _2880_/C _2880_/D _3001_/A gf180mcu_as_sc_mcu7t3v3__ao22_2
XFILLER_156_540 VDD VDD VSS VSS gf180mcu_as_sc_mcu7t3v3__fill_1
XFILLER_175_348 VDD VDD VSS VSS gf180mcu_as_sc_mcu7t3v3__fill_2
X_4550_ VDD VDD VSS VSS _4719_/CLK _4550_/D _4550_/Q gf180mcu_as_sc_mcu7t3v3__dfxtp_2
XFILLER_171_510 VDD VDD VSS VSS gf180mcu_as_sc_mcu7t3v3__fillcap_4
X_4481_ VDD VDD VSS VSS _4727_/CLK _4481_/D _4481_/Q gf180mcu_as_sc_mcu7t3v3__dfxtp_2
X_3501_ VDD VDD VSS VSS _4601_/D _4601_/Q _3503_/B _3501_/C gf180mcu_as_sc_mcu7t3v3__ao21_2
XFILLER_13_1090 VDD VDD VSS VSS gf180mcu_as_sc_mcu7t3v3__fill_1
X_3432_ VDD VDD VSS VSS _4561_/Q _3439_/B _3439_/C _4560_/Q _4560_/D gf180mcu_as_sc_mcu7t3v3__ao22_2
XTAP_TAPCELL_ROW_44_3_1955 VDD VSS gf180mcu_as_sc_mcu7t3v3__tap_2
XFILLER_139_1270 VDD VDD VSS VSS gf180mcu_as_sc_mcu7t3v3__fillcap_16
XFILLER_171_598 VDD VDD VSS VSS gf180mcu_as_sc_mcu7t3v3__fillcap_4
X_3363_ VDD VDD VSS VSS _4536_/Q _3395_/B _3403_/C _4537_/Q _3364_/C gf180mcu_as_sc_mcu7t3v3__ao22_2
XFILLER_170_1014 VDD VDD VSS VSS gf180mcu_as_sc_mcu7t3v3__fill_1
X_3294_ VDD VDD VSS VSS _3298_/B _4341_/Q _3296_/S gf180mcu_as_sc_mcu7t3v3__nand2b_2
X_2314_ VDD VDD VSS VSS _3604_/A _4632_/Q _3602_/B gf180mcu_as_sc_mcu7t3v3__and2_2
X_2245_ VDD VDD VSS VSS _4543_/Q _4809_/Q _2553_/B gf180mcu_as_sc_mcu7t3v3__xnor2_2
XTAP_TAPCELL_ROW_1_715 VDD VSS gf180mcu_as_sc_mcu7t3v3__tap_2
XTAP_TAPCELL_ROW_1_704 VDD VSS gf180mcu_as_sc_mcu7t3v3__tap_2
XTAP_TAPCELL_ROW_162_1324 VDD VSS gf180mcu_as_sc_mcu7t3v3__tap_2
XFILLER_25_104 VDD VDD VSS VSS gf180mcu_as_sc_mcu7t3v3__fill_1
XFILLER_0_1155 VDD VDD VSS VSS gf180mcu_as_sc_mcu7t3v3__fill_1
XFILLER_15_27 VDD VDD VSS VSS gf180mcu_as_sc_mcu7t3v3__fillcap_4
XFILLER_179_643 VDD VDD VSS VSS gf180mcu_as_sc_mcu7t3v3__fillcap_8
X_4817_ VDD VDD VSS VSS _4826_/CLK _4817_/D _4817_/Q gf180mcu_as_sc_mcu7t3v3__dfxtp_2
X_4748_ VDD VDD VSS VSS _4751_/CLK _4748_/D _4748_/Q gf180mcu_as_sc_mcu7t3v3__dfxtp_2
XFILLER_174_370 VDD VDD VSS VSS gf180mcu_as_sc_mcu7t3v3__fillcap_4
X_4679_ VDD VDD VSS VSS clkload4/A _4679_/D _4679_/Q gf180mcu_as_sc_mcu7t3v3__dfxtp_2
XFILLER_162_543 VDD VDD VSS VSS gf180mcu_as_sc_mcu7t3v3__fillcap_16
XPHY_EDGE_ROW_1_Right_1 VDD VSS gf180mcu_as_sc_mcu7t3v3__tap_2
XTAP_TAPCELL_ROW_9_859 VDD VSS gf180mcu_as_sc_mcu7t3v3__tap_2
XFILLER_153_1223 VDD VDD VSS VSS gf180mcu_as_sc_mcu7t3v3__fillcap_8
XFILLER_192_1294 VDD VDD VSS VSS gf180mcu_as_sc_mcu7t3v3__fillcap_16
XFILLER_66_1297 VDD VDD VSS VSS gf180mcu_as_sc_mcu7t3v3__fill_1
Xinput104 VDD VDD VSS VSS ne_in[31] _4263_/D gf180mcu_as_sc_mcu7t3v3__buff_12
Xinput115 VDD VDD VSS VSS ne_in[9] _4081_/A gf180mcu_as_sc_mcu7t3v3__buff_12
Xinput126 VDD VDD VSS VSS north_in[19] _4157_/D gf180mcu_as_sc_mcu7t3v3__buff_12
XFILLER_153_1278 VDD VDD VSS VSS gf180mcu_as_sc_mcu7t3v3__fillcap_4
Xinput137 VDD VDD VSS VSS north_in[29] _4246_/A gf180mcu_as_sc_mcu7t3v3__buff_12
Xinput148 VDD VDD VSS VSS north_in[6] _4053_/D gf180mcu_as_sc_mcu7t3v3__buff_12
Xinput159 VDD VDD VSS VSS nw_in[16] _4136_/A gf180mcu_as_sc_mcu7t3v3__buff_12
XTAP_TAPCELL_ROW_148_3_2059 VDD VSS gf180mcu_as_sc_mcu7t3v3__tap_2
XFILLER_16_104 VDD VDD VSS VSS gf180mcu_as_sc_mcu7t3v3__fill_1
XFILLER_56_67 VDD VDD VSS VSS gf180mcu_as_sc_mcu7t3v3__fillcap_16
XFILLER_186_1043 VDD VDD VSS VSS gf180mcu_as_sc_mcu7t3v3__fill_1
XFILLER_186_1087 VDD VDD VSS VSS gf180mcu_as_sc_mcu7t3v3__fillcap_16
XFILLER_164_1341 VDD VDD VSS VSS gf180mcu_as_sc_mcu7t3v3__fillcap_8
XFILLER_169_142 VDD VDD VSS VSS gf180mcu_as_sc_mcu7t3v3__fillcap_16
XFILLER_38_1344 VDD VDD VSS VSS gf180mcu_as_sc_mcu7t3v3__fillcap_8
XFILLER_157_304 VDD VDD VSS VSS gf180mcu_as_sc_mcu7t3v3__fill_1
XFILLER_160_1227 VDD VDD VSS VSS gf180mcu_as_sc_mcu7t3v3__fillcap_16
XFILLER_8_303 VDD VDD VSS VSS gf180mcu_as_sc_mcu7t3v3__fill_1
XFILLER_9_815 VDD VDD VSS VSS gf180mcu_as_sc_mcu7t3v3__fill_2
XFILLER_160_1249 VDD VDD VSS VSS gf180mcu_as_sc_mcu7t3v3__fill_1
XFILLER_9_848 VDD VDD VSS VSS gf180mcu_as_sc_mcu7t3v3__fill_1
XFILLER_12_398 VDD VDD VSS VSS gf180mcu_as_sc_mcu7t3v3__fill_1
XFILLER_153_532 VDD VDD VSS VSS gf180mcu_as_sc_mcu7t3v3__fill_1
XFILLER_153_598 VDD VDD VSS VSS gf180mcu_as_sc_mcu7t3v3__fillcap_8
XFILLER_180_384 VDD VDD VSS VSS gf180mcu_as_sc_mcu7t3v3__fill_1
XFILLER_132_1307 VDD VDD VSS VSS gf180mcu_as_sc_mcu7t3v3__fillcap_4
XFILLER_0_781 VDD VDD VSS VSS gf180mcu_as_sc_mcu7t3v3__fill_1
XFILLER_132_1329 VDD VDD VSS VSS gf180mcu_as_sc_mcu7t3v3__fill_1
XFILLER_11_6 VDD VDD VSS VSS gf180mcu_as_sc_mcu7t3v3__fill_2
XFILLER_169_1241 VDD VDD VSS VSS gf180mcu_as_sc_mcu7t3v3__fillcap_16
XFILLER_165_1138 VDD VDD VSS VSS gf180mcu_as_sc_mcu7t3v3__fillcap_4
X_3981_ VDD VDD VSS VSS _3992_/D _3982_/B gf180mcu_as_sc_mcu7t3v3__inv_2
X_2932_ VDD VDD VSS VSS _2982_/A _2943_/A _3013_/A gf180mcu_as_sc_mcu7t3v3__and2_2
XFILLER_176_613 VDD VDD VSS VSS gf180mcu_as_sc_mcu7t3v3__fillcap_4
XFILLER_188_484 VDD VDD VSS VSS gf180mcu_as_sc_mcu7t3v3__fillcap_16
XFILLER_175_134 VDD VDD VSS VSS gf180mcu_as_sc_mcu7t3v3__fillcap_4
X_2863_ VDD VDD VSS VSS _4353_/Q _2906_/B _2999_/A _2906_/D _4353_/D gf180mcu_as_sc_mcu7t3v3__ao22_2
XFILLER_164_819 VDD VDD VSS VSS gf180mcu_as_sc_mcu7t3v3__fill_1
X_4602_ VDD VDD VSS VSS _4602_/CLK _4602_/D _4602_/Q gf180mcu_as_sc_mcu7t3v3__dfxtp_2
X_2794_ VDD VDD VSS VSS _2822_/B _4118_/A _2795_/D gf180mcu_as_sc_mcu7t3v3__and2_2
XFILLER_106_1291 VDD VDD VSS VSS gf180mcu_as_sc_mcu7t3v3__fillcap_8
XFILLER_156_381 VDD VDD VSS VSS gf180mcu_as_sc_mcu7t3v3__fillcap_4
XFILLER_7_50 VDD VDD VSS VSS gf180mcu_as_sc_mcu7t3v3__fillcap_16
XFILLER_7_72 VDD VDD VSS VSS gf180mcu_as_sc_mcu7t3v3__fillcap_4
X_4533_ VDD VDD VSS VSS _4533_/CLK _4533_/D _4533_/Q gf180mcu_as_sc_mcu7t3v3__dfxtp_2
XFILLER_11_1049 VDD VDD VSS VSS gf180mcu_as_sc_mcu7t3v3__fill_1
XFILLER_7_83 VDD VDD VSS VSS gf180mcu_as_sc_mcu7t3v3__fillcap_4
XTAP_TAPCELL_ROW_155_1194 VDD VSS gf180mcu_as_sc_mcu7t3v3__tap_2
XTAP_TAPCELL_ROW_155_1183 VDD VSS gf180mcu_as_sc_mcu7t3v3__tap_2
XFILLER_172_874 VDD VDD VSS VSS gf180mcu_as_sc_mcu7t3v3__fill_1
X_4464_ VDD VDD VSS VSS _4602_/CLK _4464_/D _4464_/Q gf180mcu_as_sc_mcu7t3v3__dfxtp_2
Xclkbuf_leaf_35_clk_regs VDD VDD VSS VSS clkbuf_leaf_1_clk_regs/A clkload5/A gf180mcu_as_sc_mcu7t3v3__clkbuff_12
Xfanout805 VDD VDD VSS VSS wire807/Y _4327_/A gf180mcu_as_sc_mcu7t3v3__buff_12
X_4395_ VDD VDD VSS VSS _4783_/CLK _4395_/D _4395_/Q gf180mcu_as_sc_mcu7t3v3__dfxtp_2
X_3415_ VDD VDD VSS VSS _4544_/Q _3449_/D _3584_/D _4543_/Q _4543_/D gf180mcu_as_sc_mcu7t3v3__ao22_2
XTAP_TAPCELL_ROW_6_807 VDD VSS gf180mcu_as_sc_mcu7t3v3__tap_2
X_3346_ VDD VDD VSS VSS _3346_/A _3346_/B _3346_/C _3348_/B _3346_/D gf180mcu_as_sc_mcu7t3v3__aoi31_2
XPHY_EDGE_ROW_117_1_Left_309 VDD VSS gf180mcu_as_sc_mcu7t3v3__tap_2
Xhold1058 VDD VDD VSS VSS hold1089/Y _4815_/D gf180mcu_as_sc_mcu7t3v3__clkbuff_4
X_3277_ VDD VDD VSS VSS _3405_/B _4477_/Q _3284_/D gf180mcu_as_sc_mcu7t3v3__and2_2
Xhold1069 VDD VDD VSS VSS hold1101/Y _4823_/D gf180mcu_as_sc_mcu7t3v3__clkbuff_4
X_2228_ VDD VDD VSS VSS _2404_/B input7/Y gf180mcu_as_sc_mcu7t3v3__inv_2
XFILLER_148_1314 VDD VDD VSS VSS gf180mcu_as_sc_mcu7t3v3__fill_2
XFILLER_187_1352 VDD VDD VSS VSS gf180mcu_as_sc_mcu7t3v3__fill_2
XTAP_TAPCELL_ROW_179_1640 VDD VSS gf180mcu_as_sc_mcu7t3v3__tap_2
XTAP_TAPCELL_ROW_179_1651 VDD VSS gf180mcu_as_sc_mcu7t3v3__tap_2
XFILLER_166_123 VDD VDD VSS VSS gf180mcu_as_sc_mcu7t3v3__fill_1
XFILLER_155_808 VDD VDD VSS VSS gf180mcu_as_sc_mcu7t3v3__fillcap_4
XFILLER_6_807 VDD VDD VSS VSS gf180mcu_as_sc_mcu7t3v3__fillcap_16
XFILLER_166_189 VDD VDD VSS VSS gf180mcu_as_sc_mcu7t3v3__fillcap_16
XFILLER_181_137 VDD VDD VSS VSS gf180mcu_as_sc_mcu7t3v3__fill_2
XTAP_TAPCELL_ROW_192_1895 VDD VSS gf180mcu_as_sc_mcu7t3v3__tap_2
XFILLER_162_373 VDD VDD VSS VSS gf180mcu_as_sc_mcu7t3v3__fill_1
XFILLER_190_34 VDD VDD VSS VSS gf180mcu_as_sc_mcu7t3v3__fill_1
XFILLER_191_2 VDD VDD VSS VSS gf180mcu_as_sc_mcu7t3v3__fillcap_16
XFILLER_67_55 VDD VDD VSS VSS gf180mcu_as_sc_mcu7t3v3__fillcap_4
XFILLER_153_1097 VDD VDD VSS VSS gf180mcu_as_sc_mcu7t3v3__fillcap_16
XFILLER_40_1256 VDD VDD VSS VSS gf180mcu_as_sc_mcu7t3v3__fillcap_8
XPHY_EDGE_ROW_102_3_Left_474 VDD VSS gf180mcu_as_sc_mcu7t3v3__tap_2
XFILLER_123_72 VDD VDD VSS VSS gf180mcu_as_sc_mcu7t3v3__fillcap_16
XFILLER_189_226 VDD VDD VSS VSS gf180mcu_as_sc_mcu7t3v3__fillcap_8
XFILLER_83_76 VDD VDD VSS VSS gf180mcu_as_sc_mcu7t3v3__fill_1
XFILLER_13_652 VDD VDD VSS VSS gf180mcu_as_sc_mcu7t3v3__fill_2
XFILLER_158_613 VDD VDD VSS VSS gf180mcu_as_sc_mcu7t3v3__fillcap_16
XFILLER_186_944 VDD VDD VSS VSS gf180mcu_as_sc_mcu7t3v3__fill_1
XFILLER_157_167 VDD VDD VSS VSS gf180mcu_as_sc_mcu7t3v3__fillcap_16
XFILLER_8_177 VDD VDD VSS VSS gf180mcu_as_sc_mcu7t3v3__fillcap_4
XFILLER_148_91 VDD VDD VSS VSS gf180mcu_as_sc_mcu7t3v3__fillcap_8
Xoutput408 VDD VDD VSS VSS _4662_/Q south_out[5] gf180mcu_as_sc_mcu7t3v3__buff_12
XTAP_TAPCELL_ROW_11_897 VDD VSS gf180mcu_as_sc_mcu7t3v3__tap_2
XFILLER_154_874 VDD VDD VSS VSS gf180mcu_as_sc_mcu7t3v3__fill_1
Xoutput419 VDD VDD VSS VSS _4744_/Q west_out[15] gf180mcu_as_sc_mcu7t3v3__buff_12
X_4180_ VDD VDD VSS VSS _4181_/B _4180_/C _4187_/D _4180_/A gf180mcu_as_sc_mcu7t3v3__aoi21_2
X_3200_ VDD VDD VSS VSS _3200_/B _4515_/Q _3201_/A gf180mcu_as_sc_mcu7t3v3__xnor2_2
X_3131_ VDD VDD VSS VSS _3131_/D _3131_/A _3131_/B _3131_/C _3226_/B gf180mcu_as_sc_mcu7t3v3__ao31_2
XTAP_TAPCELL_ROW_39_3_1950 VDD VSS gf180mcu_as_sc_mcu7t3v3__tap_2
X_3062_ VDD VDD VSS VSS _3062_/S _3585_/B _4461_/Q _4461_/D gf180mcu_as_sc_mcu7t3v3__mux2_2
XPHY_EDGE_ROW_95_1_Left_287 VDD VSS gf180mcu_as_sc_mcu7t3v3__tap_2
X_3964_ VDD VDD VSS VSS _3964_/D _3964_/A _3964_/B _3964_/C _3965_/D gf180mcu_as_sc_mcu7t3v3__ao31_2
X_3895_ VDD VDD VSS VSS _3933_/S _3895_/B _4230_/A _3896_/B gf180mcu_as_sc_mcu7t3v3__mux2_2
X_2915_ VDD VDD VSS VSS _3901_/A _2915_/B _2915_/C _4231_/A _2916_/C gf180mcu_as_sc_mcu7t3v3__ao22_2
XTAP_TAPCELL_ROW_157_1223 VDD VSS gf180mcu_as_sc_mcu7t3v3__tap_2
XFILLER_164_616 VDD VDD VSS VSS gf180mcu_as_sc_mcu7t3v3__fill_2
XFILLER_176_454 VDD VDD VSS VSS gf180mcu_as_sc_mcu7t3v3__fill_1
XFILLER_176_465 VDD VDD VSS VSS gf180mcu_as_sc_mcu7t3v3__fillcap_4
X_2846_ VDD VDD VSS VSS _2891_/B _4169_/A _2850_/C gf180mcu_as_sc_mcu7t3v3__and2_2
XTAP_TAPCELL_ROW_157_1234 VDD VSS gf180mcu_as_sc_mcu7t3v3__tap_2
XFILLER_163_115 VDD VDD VSS VSS gf180mcu_as_sc_mcu7t3v3__fillcap_8
XFILLER_178_1329 VDD VDD VSS VSS gf180mcu_as_sc_mcu7t3v3__fillcap_16
X_2777_ VDD VDD VSS VSS _2903_/B _4104_/A _2778_/D gf180mcu_as_sc_mcu7t3v3__and2_2
X_4516_ VDD VDD VSS VSS _4602_/CLK _4516_/D _4516_/Q gf180mcu_as_sc_mcu7t3v3__dfxtp_2
XTAP_TAPCELL_ROW_170_1467 VDD VSS gf180mcu_as_sc_mcu7t3v3__tap_2
XFILLER_171_170 VDD VDD VSS VSS gf180mcu_as_sc_mcu7t3v3__fill_2
X_4447_ VDD VDD VSS VSS _4447_/CLK _4447_/D _4447_/Q gf180mcu_as_sc_mcu7t3v3__dfxtp_2
XTAP_TAPCELL_ROW_170_1478 VDD VSS gf180mcu_as_sc_mcu7t3v3__tap_2
XFILLER_160_866 VDD VDD VSS VSS gf180mcu_as_sc_mcu7t3v3__fillcap_8
Xfanout602 VDD VDD VSS VSS _3413_/Y _3449_/D gf180mcu_as_sc_mcu7t3v3__buff_12
Xfanout624 VDD VDD VSS VSS _3136_/Y _3333_/B gf180mcu_as_sc_mcu7t3v3__buff_12
XFILLER_63_1256 VDD VDD VSS VSS gf180mcu_as_sc_mcu7t3v3__fillcap_16
Xfanout635 VDD VDD VSS VSS _4224_/C _4214_/C gf180mcu_as_sc_mcu7t3v3__buff_12
Xfanout646 VDD VDD VSS VSS fanout648/A _4244_/C gf180mcu_as_sc_mcu7t3v3__buff_12
Xfanout657 VDD VDD VSS VSS _3867_/B _3795_/B gf180mcu_as_sc_mcu7t3v3__buff_12
X_4378_ VDD VDD VSS VSS _4440_/CLK _4378_/D _4378_/Q gf180mcu_as_sc_mcu7t3v3__dfxtp_2
XFILLER_63_1289 VDD VDD VSS VSS gf180mcu_as_sc_mcu7t3v3__fill_2
Xfanout668 VDD VDD VSS VSS _3544_/C _3553_/B gf180mcu_as_sc_mcu7t3v3__buff_12
Xfanout679 VDD VDD VSS VSS _3975_/Y _4207_/B gf180mcu_as_sc_mcu7t3v3__buff_12
X_3329_ VDD VDD VSS VSS _3330_/D _3329_/B _3330_/A gf180mcu_as_sc_mcu7t3v3__nor2_2
XFILLER_2_1014 VDD VDD VSS VSS gf180mcu_as_sc_mcu7t3v3__fill_1
XFILLER_160_37 VDD VDD VSS VSS gf180mcu_as_sc_mcu7t3v3__fillcap_8
XFILLER_37_69 VDD VDD VSS VSS gf180mcu_as_sc_mcu7t3v3__fill_1
XFILLER_163_6 VDD VDD VSS VSS gf180mcu_as_sc_mcu7t3v3__fillcap_16
XFILLER_183_1002 VDD VDD VSS VSS gf180mcu_as_sc_mcu7t3v3__fill_1
XFILLER_183_1046 VDD VDD VSS VSS gf180mcu_as_sc_mcu7t3v3__fillcap_4
XFILLER_53_68 VDD VDD VSS VSS gf180mcu_as_sc_mcu7t3v3__fill_2
XFILLER_167_454 VDD VDD VSS VSS gf180mcu_as_sc_mcu7t3v3__fillcap_16
XFILLER_182_457 VDD VDD VSS VSS gf180mcu_as_sc_mcu7t3v3__fill_1
XFILLER_185_56 VDD VDD VSS VSS gf180mcu_as_sc_mcu7t3v3__fillcap_8
XFILLER_159_1262 VDD VDD VSS VSS gf180mcu_as_sc_mcu7t3v3__fill_2
XFILLER_5_158 VDD VDD VSS VSS gf180mcu_as_sc_mcu7t3v3__fill_2
XFILLER_155_1104 VDD VDD VSS VSS gf180mcu_as_sc_mcu7t3v3__fillcap_4
Xmesh_tile_1001 VDD VDD VSS VSS sw_out[29] gf180mcu_as_sc_mcu7t3v3__tiel_4
X_4753__1019 VDD VDD VSS VSS _4753_/D gf180mcu_as_sc_mcu7t3v3__tiel_4
XFILLER_91_102 VDD VDD VSS VSS gf180mcu_as_sc_mcu7t3v3__fill_2
XFILLER_166_1222 VDD VDD VSS VSS gf180mcu_as_sc_mcu7t3v3__fill_2
XFILLER_27_80 VDD VDD VSS VSS gf180mcu_as_sc_mcu7t3v3__fillcap_16
XPHY_EDGE_ROW_60_3_Right_101 VDD VSS gf180mcu_as_sc_mcu7t3v3__tap_2
X_2700_ VDD VDD VSS VSS _2818_/B _4039_/A _2704_/C gf180mcu_as_sc_mcu7t3v3__and2_2
XFILLER_9_442 VDD VDD VSS VSS gf180mcu_as_sc_mcu7t3v3__fill_1
XFILLER_145_104 VDD VDD VSS VSS gf180mcu_as_sc_mcu7t3v3__fill_1
XFILLER_158_476 VDD VDD VSS VSS gf180mcu_as_sc_mcu7t3v3__fill_1
XFILLER_174_947 VDD VDD VSS VSS gf180mcu_as_sc_mcu7t3v3__fillcap_16
X_3680_ VDD VDD VSS VSS _4776_/Q _3806_/B _3808_/C _4037_/D _3681_/D gf180mcu_as_sc_mcu7t3v3__ao22_2
X_2631_ VDD VDD VSS VSS _2632_/C _2632_/A _2654_/A gf180mcu_as_sc_mcu7t3v3__nor2_2
XTAP_TAPCELL_ROW_152_1120 VDD VSS gf180mcu_as_sc_mcu7t3v3__tap_2
X_2562_ VDD VDD VSS VSS _3080_/D _2562_/A _2563_/C gf180mcu_as_sc_mcu7t3v3__and2_2
XTAP_TAPCELL_ROW_152_1142 VDD VSS gf180mcu_as_sc_mcu7t3v3__tap_2
XTAP_TAPCELL_ROW_152_1131 VDD VSS gf180mcu_as_sc_mcu7t3v3__tap_2
XFILLER_154_693 VDD VDD VSS VSS gf180mcu_as_sc_mcu7t3v3__fillcap_4
XFILLER_86_1256 VDD VDD VSS VSS gf180mcu_as_sc_mcu7t3v3__fillcap_16
X_4301_ VDD VDD VSS VSS _4313_/B _4525_/Q _4778_/D gf180mcu_as_sc_mcu7t3v3__and2_2
XFILLER_153_192 VDD VDD VSS VSS gf180mcu_as_sc_mcu7t3v3__fillcap_16
XFILLER_173_1259 VDD VDD VSS VSS gf180mcu_as_sc_mcu7t3v3__fill_1
X_4232_ VDD VDD VSS VSS _4232_/A _4244_/B _4246_/C _4233_/D _4257_/C gf180mcu_as_sc_mcu7t3v3__aoi211_2
X_2493_ VDD VDD VSS VSS _2494_/D _2493_/C _2493_/B _2493_/A gf180mcu_as_sc_mcu7t3v3__aoi21b_2
X_4163_ VDD VDD VSS VSS _4163_/S _4163_/B _4163_/A _4164_/B gf180mcu_as_sc_mcu7t3v3__mux2_2
XFILLER_82_102 VDD VDD VSS VSS gf180mcu_as_sc_mcu7t3v3__fill_2
X_4729__1043 VDD VDD VSS VSS _4729_/D gf180mcu_as_sc_mcu7t3v3__tiel_4
X_4094_ VDD VDD VSS VSS _4094_/A _4235_/B _4094_/C _4151_/A _4096_/D gf180mcu_as_sc_mcu7t3v3__ao22_2
X_3114_ VDD VDD VSS VSS _3120_/S _4502_/Q _4501_/Q _4501_/D gf180mcu_as_sc_mcu7t3v3__mux2_2
X_3045_ VDD VDD VSS VSS _4449_/D _4331_/B _4122_/D gf180mcu_as_sc_mcu7t3v3__nor2_2
XTAP_TAPCELL_ROW_86_1_1039 VDD VSS gf180mcu_as_sc_mcu7t3v3__tap_2
XFILLER_145_1306 VDD VDD VSS VSS gf180mcu_as_sc_mcu7t3v3__fillcap_4
XFILLER_12_909 VDD VDD VSS VSS gf180mcu_as_sc_mcu7t3v3__fillcap_8
XFILLER_11_419 VDD VDD VSS VSS gf180mcu_as_sc_mcu7t3v3__fill_1
X_3947_ VDD VDD VSS VSS _3960_/B _3947_/A _3948_/D gf180mcu_as_sc_mcu7t3v3__and2_2
XFILLER_23_38 VDD VDD VSS VSS gf180mcu_as_sc_mcu7t3v3__fillcap_4
XPHY_EDGE_ROW_12_Left_205 VDD VSS gf180mcu_as_sc_mcu7t3v3__tap_2
X_3878_ VDD VDD VSS VSS _3927_/B _4798_/Q _3910_/D gf180mcu_as_sc_mcu7t3v3__and2_2
XTAP_TAPCELL_ROW_172_1518 VDD VSS gf180mcu_as_sc_mcu7t3v3__tap_2
XTAP_TAPCELL_ROW_172_1507 VDD VSS gf180mcu_as_sc_mcu7t3v3__tap_2
XFILLER_164_457 VDD VDD VSS VSS gf180mcu_as_sc_mcu7t3v3__fillcap_4
X_2829_ VDD VDD VSS VSS _4149_/D _2829_/B _2829_/C _2829_/D _2830_/C gf180mcu_as_sc_mcu7t3v3__ao211_2
XFILLER_155_48 VDD VDD VSS VSS gf180mcu_as_sc_mcu7t3v3__fillcap_8
XFILLER_3_629 VDD VDD VSS VSS gf180mcu_as_sc_mcu7t3v3__fill_1
XFILLER_191_1326 VDD VDD VSS VSS gf180mcu_as_sc_mcu7t3v3__fillcap_4
XFILLER_191_1348 VDD VDD VSS VSS gf180mcu_as_sc_mcu7t3v3__fillcap_4
XFILLER_189_1200 VDD VDD VSS VSS gf180mcu_as_sc_mcu7t3v3__fillcap_4
Xfanout454 VDD VDD VSS VSS _2920_/B _2826_/B gf180mcu_as_sc_mcu7t3v3__buff_12
Xfanout465 VDD VDD VSS VSS _3008_/Y _3024_/C gf180mcu_as_sc_mcu7t3v3__buff_12
XFILLER_189_1233 VDD VDD VSS VSS gf180mcu_as_sc_mcu7t3v3__fillcap_4
Xfanout476 VDD VDD VSS VSS _2808_/D _2772_/D gf180mcu_as_sc_mcu7t3v3__buff_12
Xfanout487 VDD VDD VSS VSS _4238_/S _4221_/S gf180mcu_as_sc_mcu7t3v3__buff_12
XTAP_TAPCELL_ROW_187_1794 VDD VSS gf180mcu_as_sc_mcu7t3v3__tap_2
Xmesh_tile_880 VDD VDD VSS VSS north_out[16] gf180mcu_as_sc_mcu7t3v3__tiel_4
XFILLER_104_85 VDD VDD VSS VSS gf180mcu_as_sc_mcu7t3v3__fillcap_16
XFILLER_185_1119 VDD VDD VSS VSS gf180mcu_as_sc_mcu7t3v3__fill_1
Xmesh_tile_891 VDD VDD VSS VSS north_out[27] gf180mcu_as_sc_mcu7t3v3__tiel_4
XPHY_EDGE_ROW_169_Left_361 VDD VSS gf180mcu_as_sc_mcu7t3v3__tap_2
XTAP_TAPCELL_ROW_13_959 VDD VSS gf180mcu_as_sc_mcu7t3v3__tap_2
XTAP_TAPCELL_ROW_13_948 VDD VSS gf180mcu_as_sc_mcu7t3v3__tap_2
XTAP_TAPCELL_ROW_13_937 VDD VSS gf180mcu_as_sc_mcu7t3v3__tap_2
XFILLER_10_441 VDD VDD VSS VSS gf180mcu_as_sc_mcu7t3v3__fill_2
XFILLER_11_975 VDD VDD VSS VSS gf180mcu_as_sc_mcu7t3v3__fillcap_4
XFILLER_126_1283 VDD VDD VSS VSS gf180mcu_as_sc_mcu7t3v3__fillcap_4
XFILLER_127_104 VDD VDD VSS VSS gf180mcu_as_sc_mcu7t3v3__fill_1
Xwire811 VDD VDD VSS VSS wire811/A _4031_/A gf180mcu_as_sc_mcu7t3v3__clkbuff_12
XFILLER_183_766 VDD VDD VSS VSS gf180mcu_as_sc_mcu7t3v3__fillcap_4
XPHY_EDGE_ROW_178_Left_370 VDD VSS gf180mcu_as_sc_mcu7t3v3__tap_2
XFILLER_182_298 VDD VDD VSS VSS gf180mcu_as_sc_mcu7t3v3__fillcap_4
XFILLER_89_53 VDD VDD VSS VSS gf180mcu_as_sc_mcu7t3v3__fill_2
XFILLER_159_1092 VDD VDD VSS VSS gf180mcu_as_sc_mcu7t3v3__fill_2
XFILLER_1_150 VDD VDD VSS VSS gf180mcu_as_sc_mcu7t3v3__fillcap_4
XFILLER_145_92 VDD VDD VSS VSS gf180mcu_as_sc_mcu7t3v3__fillcap_8
XFILLER_172_1270 VDD VDD VSS VSS gf180mcu_as_sc_mcu7t3v3__fillcap_8
XFILLER_133_1276 VDD VDD VSS VSS gf180mcu_as_sc_mcu7t3v3__fillcap_4
Xclkbuf_2_3_0_clk_regs VDD VDD VSS VSS clkbuf_0_clk_regs/Y clkbuf_2_3_0_clk_regs/Y
+ gf180mcu_as_sc_mcu7t3v3__clkbuff_12
XFILLER_178_527 VDD VDD VSS VSS gf180mcu_as_sc_mcu7t3v3__fillcap_8
X_3801_ VDD VDD VSS VSS _3883_/S _3801_/B _4146_/A _3802_/B gf180mcu_as_sc_mcu7t3v3__mux2_2
X_4781_ VDD VDD VSS VSS clkload7/A _4781_/D _4781_/Q gf180mcu_as_sc_mcu7t3v3__dfxtp_2
XPHY_EDGE_ROW_61_3_Right_102 VDD VSS gf180mcu_as_sc_mcu7t3v3__tap_2
XPHY_EDGE_ROW_126_1_Left_318 VDD VSS gf180mcu_as_sc_mcu7t3v3__tap_2
XFILLER_186_560 VDD VDD VSS VSS gf180mcu_as_sc_mcu7t3v3__fillcap_16
X_3732_ VDD VDD VSS VSS _4087_/D _3795_/B _3732_/C _3795_/D _3734_/C gf180mcu_as_sc_mcu7t3v3__ao211_2
XFILLER_88_1307 VDD VDD VSS VSS gf180mcu_as_sc_mcu7t3v3__fill_2
Xclkload20 VDD VDD VSS VSS clkload20/Y _4809_/CLK gf180mcu_as_sc_mcu7t3v3__inv_4
X_3663_ VDD VDD VSS VSS _3665_/C _4023_/A _3881_/C _3663_/C gf180mcu_as_sc_mcu7t3v3__ao21_2
XFILLER_161_405 VDD VDD VSS VSS gf180mcu_as_sc_mcu7t3v3__fillcap_8
XFILLER_162_928 VDD VDD VSS VSS gf180mcu_as_sc_mcu7t3v3__fillcap_4
X_2614_ VDD VDD VSS VSS _4256_/A _4245_/A _4266_/A _3975_/B gf180mcu_as_sc_mcu7t3v3__nor3_2
XFILLER_161_438 VDD VDD VSS VSS gf180mcu_as_sc_mcu7t3v3__fillcap_16
XFILLER_173_298 VDD VDD VSS VSS gf180mcu_as_sc_mcu7t3v3__fillcap_16
X_3594_ VDD VDD VSS VSS _3603_/A _3599_/B _3594_/C _4650_/D gf180mcu_as_sc_mcu7t3v3__nor3_2
XFILLER_177_1192 VDD VDD VSS VSS gf180mcu_as_sc_mcu7t3v3__fillcap_16
X_2545_ VDD VDD VSS VSS _2545_/D _3609_/B _3471_/C _2545_/C _2563_/A gf180mcu_as_sc_mcu7t3v3__ao31_2
XFILLER_170_994 VDD VDD VSS VSS gf180mcu_as_sc_mcu7t3v3__fillcap_16
X_2476_ VDD VDD VSS VSS _2476_/D _3071_/A _2492_/B _2476_/C _2478_/C gf180mcu_as_sc_mcu7t3v3__ao31_2
X_4215_ VDD VDD VSS VSS _4264_/B _4798_/Q _4246_/C gf180mcu_as_sc_mcu7t3v3__and2_2
X_4146_ VDD VDD VSS VSS _4163_/S _4146_/B _4146_/A _4147_/B gf180mcu_as_sc_mcu7t3v3__mux2_2
XFILLER_18_27 VDD VDD VSS VSS gf180mcu_as_sc_mcu7t3v3__fillcap_8
X_4077_ VDD VDD VSS VSS _4077_/A _4149_/B _4149_/C _4077_/D _4078_/C gf180mcu_as_sc_mcu7t3v3__ao22_2
XTAP_TAPCELL_ROW_165_1388 VDD VSS gf180mcu_as_sc_mcu7t3v3__tap_2
XTAP_TAPCELL_ROW_165_1377 VDD VSS gf180mcu_as_sc_mcu7t3v3__tap_2
X_3028_ VDD VDD VSS VSS _3028_/A _3034_/B _4276_/A _4438_/Q _4438_/D gf180mcu_as_sc_mcu7t3v3__ao22_2
XFILLER_149_1272 VDD VDD VSS VSS gf180mcu_as_sc_mcu7t3v3__fillcap_16
XFILLER_34_37 VDD VDD VSS VSS gf180mcu_as_sc_mcu7t3v3__fillcap_16
XFILLER_169_527 VDD VDD VSS VSS gf180mcu_as_sc_mcu7t3v3__fillcap_16
XFILLER_184_1185 VDD VDD VSS VSS gf180mcu_as_sc_mcu7t3v3__fill_2
XFILLER_109_104 VDD VDD VSS VSS gf180mcu_as_sc_mcu7t3v3__fill_1
XFILLER_32_1328 VDD VDD VSS VSS gf180mcu_as_sc_mcu7t3v3__fill_2
Xclkload3 VDD VDD VSS VSS clkload3/A clkload3/Y gf180mcu_as_sc_mcu7t3v3__clkbuff_12
XPHY_EDGE_ROW_59_3_Left_431 VDD VSS gf180mcu_as_sc_mcu7t3v3__tap_2
XFILLER_153_928 VDD VDD VSS VSS gf180mcu_as_sc_mcu7t3v3__fillcap_16
XTAP_TAPCELL_ROW_62_3_1973 VDD VSS gf180mcu_as_sc_mcu7t3v3__tap_2
XFILLER_152_438 VDD VDD VSS VSS gf180mcu_as_sc_mcu7t3v3__fill_2
XFILLER_164_287 VDD VDD VSS VSS gf180mcu_as_sc_mcu7t3v3__fill_2
XPHY_EDGE_ROW_111_3_Left_483 VDD VSS gf180mcu_as_sc_mcu7t3v3__tap_2
XFILLER_180_769 VDD VDD VSS VSS gf180mcu_as_sc_mcu7t3v3__fillcap_4
XTAP_TAPCELL_ROW_189_1834 VDD VSS gf180mcu_as_sc_mcu7t3v3__tap_2
XTAP_TAPCELL_ROW_189_1845 VDD VSS gf180mcu_as_sc_mcu7t3v3__tap_2
XFILLER_115_40 VDD VDD VSS VSS gf180mcu_as_sc_mcu7t3v3__fill_1
XFILLER_115_51 VDD VDD VSS VSS gf180mcu_as_sc_mcu7t3v3__fillcap_4
XFILLER_189_1052 VDD VDD VSS VSS gf180mcu_as_sc_mcu7t3v3__fillcap_16
XFILLER_131_72 VDD VDD VSS VSS gf180mcu_as_sc_mcu7t3v3__fill_2
XFILLER_167_1350 VDD VDD VSS VSS gf180mcu_as_sc_mcu7t3v3__fill_1
XFILLER_187_335 VDD VDD VSS VSS gf180mcu_as_sc_mcu7t3v3__fill_1
XFILLER_91_76 VDD VDD VSS VSS gf180mcu_as_sc_mcu7t3v3__fill_1
XFILLER_187_368 VDD VDD VSS VSS gf180mcu_as_sc_mcu7t3v3__fillcap_4
XFILLER_156_722 VDD VDD VSS VSS gf180mcu_as_sc_mcu7t3v3__fill_1
XFILLER_168_593 VDD VDD VSS VSS gf180mcu_as_sc_mcu7t3v3__fill_2
XFILLER_13_1294 VDD VDD VSS VSS gf180mcu_as_sc_mcu7t3v3__fillcap_4
XFILLER_100_1264 VDD VDD VSS VSS gf180mcu_as_sc_mcu7t3v3__fillcap_4
XFILLER_174_1343 VDD VDD VSS VSS gf180mcu_as_sc_mcu7t3v3__fillcap_8
XFILLER_170_279 VDD VDD VSS VSS gf180mcu_as_sc_mcu7t3v3__fill_1
XFILLER_3_960 VDD VDD VSS VSS gf180mcu_as_sc_mcu7t3v3__fillcap_4
XFILLER_3_982 VDD VDD VSS VSS gf180mcu_as_sc_mcu7t3v3__fill_2
X_2330_ VDD VDD VSS VSS _4807_/D _2344_/B _2330_/A _2330_/Y gf180mcu_as_sc_mcu7t3v3__mux2_2
X_2261_ VDD VDD VSS VSS _4629_/Q _4623_/Q _4624_/Q _4625_/Q _3568_/A gf180mcu_as_sc_mcu7t3v3__nand4_2
X_4000_ VDD VDD VSS VSS _4001_/C _4006_/B gf180mcu_as_sc_mcu7t3v3__inv_2
X_2192_ VDD VDD VSS VSS _3131_/B _3458_/A gf180mcu_as_sc_mcu7t3v3__inv_2
XFILLER_168_1103 VDD VDD VSS VSS gf180mcu_as_sc_mcu7t3v3__fillcap_16
XFILLER_168_1136 VDD VDD VSS VSS gf180mcu_as_sc_mcu7t3v3__fillcap_16
XFILLER_20_1265 VDD VDD VSS VSS gf180mcu_as_sc_mcu7t3v3__fill_2
XFILLER_20_1276 VDD VDD VSS VSS gf180mcu_as_sc_mcu7t3v3__fillcap_8
XTAP_TAPCELL_ROW_160_1285 VDD VSS gf180mcu_as_sc_mcu7t3v3__tap_2
X_4764_ VDD VDD VSS VSS _4803_/CLK _4764_/D _4764_/Q gf180mcu_as_sc_mcu7t3v3__dfxtp_2
XPHY_EDGE_ROW_62_3_Right_103 VDD VSS gf180mcu_as_sc_mcu7t3v3__tap_2
XFILLER_159_582 VDD VDD VSS VSS gf180mcu_as_sc_mcu7t3v3__fillcap_4
X_3715_ VDD VDD VSS VSS _3716_/D _4068_/A _3796_/B _3823_/C gf180mcu_as_sc_mcu7t3v3__ao21_2
XFILLER_174_574 VDD VDD VSS VSS gf180mcu_as_sc_mcu7t3v3__fill_2
XFILLER_179_1232 VDD VDD VSS VSS gf180mcu_as_sc_mcu7t3v3__fillcap_4
X_4695_ VDD VDD VSS VSS _4719_/CLK _4695_/D _4695_/Q gf180mcu_as_sc_mcu7t3v3__dfxtp_2
X_3646_ VDD VDD VSS VSS _4008_/A _3881_/B _3881_/C _3983_/A _3647_/D gf180mcu_as_sc_mcu7t3v3__ao22_2
XFILLER_1_908 VDD VDD VSS VSS gf180mcu_as_sc_mcu7t3v3__fill_2
X_3577_ VDD VDD VSS VSS _3604_/A _4626_/Q _4627_/D gf180mcu_as_sc_mcu7t3v3__and2_2
XFILLER_161_279 VDD VDD VSS VSS gf180mcu_as_sc_mcu7t3v3__fill_1
XFILLER_170_780 VDD VDD VSS VSS gf180mcu_as_sc_mcu7t3v3__fill_2
X_2528_ VDD VDD VSS VSS _2528_/D _4478_/Q _3082_/B _3571_/B _2529_/D gf180mcu_as_sc_mcu7t3v3__ao31_2
Xinput308 VDD VDD VSS VSS west_in[1] _4015_/D gf180mcu_as_sc_mcu7t3v3__buff_12
XTAP_TAPCELL_ROW_167_1428 VDD VSS gf180mcu_as_sc_mcu7t3v3__tap_2
XTAP_TAPCELL_ROW_167_1417 VDD VSS gf180mcu_as_sc_mcu7t3v3__tap_2
Xinput319 VDD VDD VSS VSS west_in[2] _4023_/D gf180mcu_as_sc_mcu7t3v3__buff_12
X_2459_ VDD VDD VSS VSS _4538_/Q _3068_/S _3061_/S _4514_/Q _2460_/C gf180mcu_as_sc_mcu7t3v3__ao22_2
XTAP_TAPCELL_ROW_150_1_1103 VDD VSS gf180mcu_as_sc_mcu7t3v3__tap_2
XFILLER_116_1282 VDD VDD VSS VSS gf180mcu_as_sc_mcu7t3v3__fillcap_4
XTAP_TAPCELL_ROW_4_768 VDD VSS gf180mcu_as_sc_mcu7t3v3__tap_2
XTAP_TAPCELL_ROW_184_1742 VDD VSS gf180mcu_as_sc_mcu7t3v3__tap_2
X_4129_ VDD VDD VSS VSS _4787_/Q _4244_/C _4138_/B _4129_/D _4131_/A gf180mcu_as_sc_mcu7t3v3__ao211_2
XFILLER_99_1288 VDD VDD VSS VSS gf180mcu_as_sc_mcu7t3v3__fillcap_8
XFILLER_186_1269 VDD VDD VSS VSS gf180mcu_as_sc_mcu7t3v3__fill_1
XFILLER_185_839 VDD VDD VSS VSS gf180mcu_as_sc_mcu7t3v3__fill_1
XFILLER_177_68 VDD VDD VSS VSS gf180mcu_as_sc_mcu7t3v3__fill_2
XFILLER_178_891 VDD VDD VSS VSS gf180mcu_as_sc_mcu7t3v3__fillcap_4
XFILLER_8_529 VDD VDD VSS VSS gf180mcu_as_sc_mcu7t3v3__fill_1
XFILLER_180_522 VDD VDD VSS VSS gf180mcu_as_sc_mcu7t3v3__fill_2
XFILLER_192_382 VDD VDD VSS VSS gf180mcu_as_sc_mcu7t3v3__fill_1
XFILLER_0_941 VDD VDD VSS VSS gf180mcu_as_sc_mcu7t3v3__fill_2
XFILLER_156_1084 VDD VDD VSS VSS gf180mcu_as_sc_mcu7t3v3__fill_1
XPHY_EDGE_ROW_5_Left_198 VDD VSS gf180mcu_as_sc_mcu7t3v3__tap_2
XFILLER_43_1276 VDD VDD VSS VSS gf180mcu_as_sc_mcu7t3v3__fill_2
XPHY_EDGE_ROW_40_1_Right_549 VDD VSS gf180mcu_as_sc_mcu7t3v3__tap_2
XFILLER_163_1033 VDD VDD VSS VSS gf180mcu_as_sc_mcu7t3v3__fillcap_4
XFILLER_35_80 VDD VDD VSS VSS gf180mcu_as_sc_mcu7t3v3__fillcap_4
XFILLER_187_198 VDD VDD VSS VSS gf180mcu_as_sc_mcu7t3v3__fill_1
XFILLER_11_1209 VDD VDD VSS VSS gf180mcu_as_sc_mcu7t3v3__fill_1
X_3500_ VDD VDD VSS VSS _4455_/Q _3504_/C _3502_/C _4602_/Q _3501_/C gf180mcu_as_sc_mcu7t3v3__ao22_2
XFILLER_7_562 VDD VDD VSS VSS gf180mcu_as_sc_mcu7t3v3__fill_1
Xwire493 VDD VDD VSS VSS _4230_/B _4187_/D gf180mcu_as_sc_mcu7t3v3__clkbuff_12
X_4480_ VDD VDD VSS VSS _4826_/CLK _4480_/D _4480_/Q gf180mcu_as_sc_mcu7t3v3__dfxtp_2
XFILLER_171_544 VDD VDD VSS VSS gf180mcu_as_sc_mcu7t3v3__fillcap_16
X_3431_ VDD VDD VSS VSS _4560_/Q _3443_/B _3439_/C _4559_/Q _4559_/D gf180mcu_as_sc_mcu7t3v3__ao22_2
X_3362_ VDD VDD VSS VSS _3369_/A _3362_/B _3362_/C _3364_/B _3362_/D gf180mcu_as_sc_mcu7t3v3__aoi31_2
XFILLER_174_1173 VDD VDD VSS VSS gf180mcu_as_sc_mcu7t3v3__fillcap_4
X_2313_ VDD VDD VSS VSS _2313_/B _2408_/A _3603_/C gf180mcu_as_sc_mcu7t3v3__or2_2
X_3293_ VDD VDD VSS VSS _3333_/B _4463_/Q _3300_/D gf180mcu_as_sc_mcu7t3v3__and2_2
X_2244_ VDD VDD VSS VSS _3471_/B _4628_/Q _2553_/A gf180mcu_as_sc_mcu7t3v3__and2_2
XTAP_TAPCELL_ROW_1_716 VDD VSS gf180mcu_as_sc_mcu7t3v3__tap_2
XTAP_TAPCELL_ROW_1_705 VDD VSS gf180mcu_as_sc_mcu7t3v3__tap_2
XTAP_TAPCELL_ROW_114_3_2025 VDD VSS gf180mcu_as_sc_mcu7t3v3__tap_2
XTAP_TAPCELL_ROW_162_1325 VDD VSS gf180mcu_as_sc_mcu7t3v3__tap_2
XFILLER_59_1272 VDD VDD VSS VSS gf180mcu_as_sc_mcu7t3v3__fillcap_16
XFILLER_0_1189 VDD VDD VSS VSS gf180mcu_as_sc_mcu7t3v3__fill_1
XFILLER_167_806 VDD VDD VSS VSS gf180mcu_as_sc_mcu7t3v3__fill_2
XFILLER_181_1133 VDD VDD VSS VSS gf180mcu_as_sc_mcu7t3v3__fill_2
XFILLER_179_677 VDD VDD VSS VSS gf180mcu_as_sc_mcu7t3v3__fillcap_16
XFILLER_179_699 VDD VDD VSS VSS gf180mcu_as_sc_mcu7t3v3__fill_1
X_4816_ VDD VDD VSS VSS _4830_/CLK _4816_/D _4816_/Q gf180mcu_as_sc_mcu7t3v3__dfxtp_2
XFILLER_31_38 VDD VDD VSS VSS gf180mcu_as_sc_mcu7t3v3__fillcap_16
X_4747_ VDD VDD VSS VSS _4751_/CLK _4747_/D _4747_/Q gf180mcu_as_sc_mcu7t3v3__dfxtp_2
XPHY_EDGE_ROW_63_3_Right_104 VDD VSS gf180mcu_as_sc_mcu7t3v3__tap_2
XFILLER_147_49 VDD VDD VSS VSS gf180mcu_as_sc_mcu7t3v3__fillcap_4
XFILLER_162_500 VDD VDD VSS VSS gf180mcu_as_sc_mcu7t3v3__fillcap_16
X_4678_ VDD VDD VSS VSS clkload4/A _4678_/D _4678_/Q gf180mcu_as_sc_mcu7t3v3__dfxtp_2
X_3629_ VDD VDD VSS VSS _3968_/A _3957_/B _3955_/B gf180mcu_as_sc_mcu7t3v3__and2_2
XFILLER_153_1246 VDD VDD VSS VSS gf180mcu_as_sc_mcu7t3v3__fill_2
Xinput105 VDD VDD VSS VSS ne_in[32] _3939_/A gf180mcu_as_sc_mcu7t3v3__buff_12
Xinput116 VDD VDD VSS VSS north_in[0] _3992_/A gf180mcu_as_sc_mcu7t3v3__buff_12
Xinput127 VDD VDD VSS VSS north_in[1] _4013_/D gf180mcu_as_sc_mcu7t3v3__buff_12
Xinput138 VDD VDD VSS VSS north_in[2] _4021_/D gf180mcu_as_sc_mcu7t3v3__buff_12
Xinput149 VDD VDD VSS VSS north_in[7] _4062_/D gf180mcu_as_sc_mcu7t3v3__buff_12
XFILLER_9_1192 VDD VDD VSS VSS gf180mcu_as_sc_mcu7t3v3__fill_2
XFILLER_189_408 VDD VDD VSS VSS gf180mcu_as_sc_mcu7t3v3__fillcap_8
XFILLER_164_1353 VDD VDD VSS VSS gf180mcu_as_sc_mcu7t3v3__fill_2
XFILLER_188_34 VDD VDD VSS VSS gf180mcu_as_sc_mcu7t3v3__fill_1
XFILLER_125_1326 VDD VDD VSS VSS gf180mcu_as_sc_mcu7t3v3__fill_2
XFILLER_13_878 VDD VDD VSS VSS gf180mcu_as_sc_mcu7t3v3__fillcap_4
XFILLER_158_839 VDD VDD VSS VSS gf180mcu_as_sc_mcu7t3v3__fillcap_16
XFILLER_160_1217 VDD VDD VSS VSS gf180mcu_as_sc_mcu7t3v3__fillcap_8
XFILLER_188_45 VDD VDD VSS VSS gf180mcu_as_sc_mcu7t3v3__fill_2
Xclkbuf_leaf_5_clk_regs VDD VDD VSS VSS clkbuf_leaf_9_clk_regs/A _4429_/CLK gf180mcu_as_sc_mcu7t3v3__clkbuff_12
XFILLER_157_327 VDD VDD VSS VSS gf180mcu_as_sc_mcu7t3v3__fillcap_16
XFILLER_157_349 VDD VDD VSS VSS gf180mcu_as_sc_mcu7t3v3__fill_1
XFILLER_184_102 VDD VDD VSS VSS gf180mcu_as_sc_mcu7t3v3__fill_2
XFILLER_166_861 VDD VDD VSS VSS gf180mcu_as_sc_mcu7t3v3__fill_2
XFILLER_158_1102 VDD VDD VSS VSS gf180mcu_as_sc_mcu7t3v3__fillcap_4
XFILLER_4_510 VDD VDD VSS VSS gf180mcu_as_sc_mcu7t3v3__fill_1
XPHY_EDGE_ROW_19_3_Right_60 VDD VSS gf180mcu_as_sc_mcu7t3v3__tap_2
XFILLER_180_341 VDD VDD VSS VSS gf180mcu_as_sc_mcu7t3v3__fill_2
XFILLER_181_842 VDD VDD VSS VSS gf180mcu_as_sc_mcu7t3v3__fillcap_8
XFILLER_153_566 VDD VDD VSS VSS gf180mcu_as_sc_mcu7t3v3__fill_2
XFILLER_158_1157 VDD VDD VSS VSS gf180mcu_as_sc_mcu7t3v3__fillcap_8
XFILLER_10_1297 VDD VDD VSS VSS gf180mcu_as_sc_mcu7t3v3__fillcap_4
XFILLER_171_1313 VDD VDD VSS VSS gf180mcu_as_sc_mcu7t3v3__fillcap_16
XFILLER_171_1346 VDD VDD VSS VSS gf180mcu_as_sc_mcu7t3v3__fill_1
XFILLER_153_92 VDD VDD VSS VSS gf180mcu_as_sc_mcu7t3v3__fill_2
XPHY_EDGE_ROW_135_1_Left_327 VDD VSS gf180mcu_as_sc_mcu7t3v3__tap_2
XFILLER_169_1220 VDD VDD VSS VSS gf180mcu_as_sc_mcu7t3v3__fill_2
X_3980_ VDD VDD VSS VSS _3982_/B _4265_/D _3996_/B gf180mcu_as_sc_mcu7t3v3__nand2_2
X_2931_ VDD VDD VSS VSS _4364_/Q _2945_/C _3012_/A _2945_/B _4364_/D gf180mcu_as_sc_mcu7t3v3__ao22_2
Xclkbuf_0_clk VDD VDD VSS VSS clkbuf_0_clk/A clkbuf_0_clk/Y gf180mcu_as_sc_mcu7t3v3__clkbuff_12
XFILLER_175_102 VDD VDD VSS VSS gf180mcu_as_sc_mcu7t3v3__fillcap_16
X_4601_ VDD VDD VSS VSS _4602_/CLK _4601_/D _4601_/Q gf180mcu_as_sc_mcu7t3v3__dfxtp_2
X_2862_ VDD VDD VSS VSS _4179_/B _2896_/D _2862_/C _2862_/D _2999_/A gf180mcu_as_sc_mcu7t3v3__ao211_2
XFILLER_157_850 VDD VDD VSS VSS gf180mcu_as_sc_mcu7t3v3__fillcap_4
XFILLER_175_168 VDD VDD VSS VSS gf180mcu_as_sc_mcu7t3v3__fillcap_4
X_2793_ VDD VDD VSS VSS _4116_/D _2829_/B _2793_/C _2793_/D _2795_/C gf180mcu_as_sc_mcu7t3v3__ao211_2
XFILLER_11_1006 VDD VDD VSS VSS gf180mcu_as_sc_mcu7t3v3__fill_2
X_4532_ VDD VDD VSS VSS _4533_/CLK _4532_/D _4532_/Q gf180mcu_as_sc_mcu7t3v3__dfxtp_2
XFILLER_8_860 VDD VDD VSS VSS gf180mcu_as_sc_mcu7t3v3__fillcap_8
XFILLER_172_864 VDD VDD VSS VSS gf180mcu_as_sc_mcu7t3v3__fillcap_8
XFILLER_176_1224 VDD VDD VSS VSS gf180mcu_as_sc_mcu7t3v3__fill_1
XFILLER_190_138 VDD VDD VSS VSS gf180mcu_as_sc_mcu7t3v3__fillcap_8
X_4463_ VDD VDD VSS VSS _4830_/CLK _4463_/D _4463_/Q gf180mcu_as_sc_mcu7t3v3__dfxtp_2
XTAP_TAPCELL_ROW_155_1195 VDD VSS gf180mcu_as_sc_mcu7t3v3__tap_2
XTAP_TAPCELL_ROW_155_1184 VDD VSS gf180mcu_as_sc_mcu7t3v3__tap_2
XFILLER_171_352 VDD VDD VSS VSS gf180mcu_as_sc_mcu7t3v3__fillcap_16
X_3414_ VDD VDD VSS VSS _3604_/A _3414_/A _3414_/Y gf180mcu_as_sc_mcu7t3v3__and2_2
Xfanout806 VDD VDD VSS VSS input188/Y wire807/A gf180mcu_as_sc_mcu7t3v3__buff_12
X_4394_ VDD VDD VSS VSS _4429_/CLK _4394_/D _4394_/Q gf180mcu_as_sc_mcu7t3v3__dfxtp_2
XTAP_TAPCELL_ROW_6_808 VDD VSS gf180mcu_as_sc_mcu7t3v3__tap_2
X_3345_ VDD VDD VSS VSS _3346_/D _3345_/B _3346_/A gf180mcu_as_sc_mcu7t3v3__nor2_2
X_3276_ VDD VDD VSS VSS _3348_/A _3276_/B _3276_/C _3276_/D _4525_/D gf180mcu_as_sc_mcu7t3v3__ao211_2
XPHY_EDGE_ROW_67_1_Left_259 VDD VSS gf180mcu_as_sc_mcu7t3v3__tap_2
XFILLER_26_1293 VDD VDD VSS VSS gf180mcu_as_sc_mcu7t3v3__fill_1
X_2227_ VDD VDD VSS VSS _2358_/B input3/Y gf180mcu_as_sc_mcu7t3v3__inv_2
Xhold1059 VDD VDD VSS VSS hold1091/Y _4821_/D gf180mcu_as_sc_mcu7t3v3__clkbuff_4
XFILLER_113_1296 VDD VDD VSS VSS gf180mcu_as_sc_mcu7t3v3__fill_1
XFILLER_26_27 VDD VDD VSS VSS gf180mcu_as_sc_mcu7t3v3__fillcap_8
XPHY_EDGE_ROW_68_3_Left_440 VDD VSS gf180mcu_as_sc_mcu7t3v3__tap_2
XFILLER_183_1239 VDD VDD VSS VSS gf180mcu_as_sc_mcu7t3v3__fill_2
XPHY_EDGE_ROW_120_3_Left_492 VDD VSS gf180mcu_as_sc_mcu7t3v3__tap_2
XFILLER_179_463 VDD VDD VSS VSS gf180mcu_as_sc_mcu7t3v3__fillcap_16
XTAP_TAPCELL_ROW_179_1652 VDD VSS gf180mcu_as_sc_mcu7t3v3__tap_2
XTAP_TAPCELL_ROW_179_1641 VDD VSS gf180mcu_as_sc_mcu7t3v3__tap_2
XFILLER_166_102 VDD VDD VSS VSS gf180mcu_as_sc_mcu7t3v3__fill_2
XFILLER_42_37 VDD VDD VSS VSS gf180mcu_as_sc_mcu7t3v3__fillcap_16
XFILLER_166_135 VDD VDD VSS VSS gf180mcu_as_sc_mcu7t3v3__fillcap_16
XFILLER_167_669 VDD VDD VSS VSS gf180mcu_as_sc_mcu7t3v3__fillcap_16
XFILLER_72_1291 VDD VDD VSS VSS gf180mcu_as_sc_mcu7t3v3__fillcap_8
XPHY_EDGE_ROW_64_3_Right_105 VDD VSS gf180mcu_as_sc_mcu7t3v3__tap_2
XFILLER_120_1256 VDD VDD VSS VSS gf180mcu_as_sc_mcu7t3v3__fillcap_4
XFILLER_163_842 VDD VDD VSS VSS gf180mcu_as_sc_mcu7t3v3__fillcap_16
XTAP_TAPCELL_ROW_192_1896 VDD VSS gf180mcu_as_sc_mcu7t3v3__tap_2
XTAP_TAPCELL_ROW_192_1885 VDD VSS gf180mcu_as_sc_mcu7t3v3__tap_2
XFILLER_190_661 VDD VDD VSS VSS gf180mcu_as_sc_mcu7t3v3__fillcap_4
XFILLER_174_69 VDD VDD VSS VSS gf180mcu_as_sc_mcu7t3v3__fillcap_4
XFILLER_153_1021 VDD VDD VSS VSS gf180mcu_as_sc_mcu7t3v3__fill_1
XFILLER_184_2 VDD VDD VSS VSS gf180mcu_as_sc_mcu7t3v3__fillcap_16
XFILLER_40_1268 VDD VDD VSS VSS gf180mcu_as_sc_mcu7t3v3__fill_1
XFILLER_164_1172 VDD VDD VSS VSS gf180mcu_as_sc_mcu7t3v3__fillcap_8
XFILLER_13_686 VDD VDD VSS VSS gf180mcu_as_sc_mcu7t3v3__fill_2
XFILLER_158_647 VDD VDD VSS VSS gf180mcu_as_sc_mcu7t3v3__fill_2
XFILLER_185_422 VDD VDD VSS VSS gf180mcu_as_sc_mcu7t3v3__fillcap_4
XFILLER_12_174 VDD VDD VSS VSS gf180mcu_as_sc_mcu7t3v3__fill_1
XFILLER_12_196 VDD VDD VSS VSS gf180mcu_as_sc_mcu7t3v3__fill_1
XFILLER_160_1069 VDD VDD VSS VSS gf180mcu_as_sc_mcu7t3v3__fillcap_16
XFILLER_9_657 VDD VDD VSS VSS gf180mcu_as_sc_mcu7t3v3__fillcap_4
XFILLER_12_1326 VDD VDD VSS VSS gf180mcu_as_sc_mcu7t3v3__fillcap_4
XFILLER_173_628 VDD VDD VSS VSS gf180mcu_as_sc_mcu7t3v3__fill_2
XFILLER_185_488 VDD VDD VSS VSS gf180mcu_as_sc_mcu7t3v3__fill_2
XFILLER_165_190 VDD VDD VSS VSS gf180mcu_as_sc_mcu7t3v3__fillcap_16
XTAP_TAPCELL_ROW_11_898 VDD VSS gf180mcu_as_sc_mcu7t3v3__tap_2
XFILLER_153_352 VDD VDD VSS VSS gf180mcu_as_sc_mcu7t3v3__fillcap_16
XFILLER_181_661 VDD VDD VSS VSS gf180mcu_as_sc_mcu7t3v3__fill_1
Xoutput409 VDD VDD VSS VSS _4663_/Q south_out[6] gf180mcu_as_sc_mcu7t3v3__buff_12
XFILLER_153_396 VDD VDD VSS VSS gf180mcu_as_sc_mcu7t3v3__fillcap_16
X_3130_ VDD VDD VSS VSS _3130_/B _3611_/C _3131_/D gf180mcu_as_sc_mcu7t3v3__or2_2
X_3061_ VDD VDD VSS VSS _3061_/S _3528_/A _4460_/Q _4460_/D gf180mcu_as_sc_mcu7t3v3__mux2_2
XFILLER_108_1332 VDD VDD VSS VSS gf180mcu_as_sc_mcu7t3v3__fillcap_16
XFILLER_177_912 VDD VDD VSS VSS gf180mcu_as_sc_mcu7t3v3__fill_2
XFILLER_182_1261 VDD VDD VSS VSS gf180mcu_as_sc_mcu7t3v3__fillcap_4
XFILLER_189_772 VDD VDD VSS VSS gf180mcu_as_sc_mcu7t3v3__fillcap_4
X_3963_ VDD VDD VSS VSS _4803_/Q _4804_/Q _3963_/C _3963_/D _3964_/D gf180mcu_as_sc_mcu7t3v3__ao22_2
XTAP_TAPCELL_ROW_109_3_2020 VDD VSS gf180mcu_as_sc_mcu7t3v3__tap_2
XFILLER_108_1354 VDD VDD VSS VSS gf180mcu_as_sc_mcu7t3v3__fill_1
XFILLER_182_1294 VDD VDD VSS VSS gf180mcu_as_sc_mcu7t3v3__fill_1
X_3894_ VDD VDD VSS VSS _4228_/A _3921_/B _3894_/C _3894_/D _3895_/B gf180mcu_as_sc_mcu7t3v3__ao211_2
X_2914_ VDD VDD VSS VSS _2914_/B _4237_/A _2919_/C gf180mcu_as_sc_mcu7t3v3__and2_2
XFILLER_143_1256 VDD VDD VSS VSS gf180mcu_as_sc_mcu7t3v3__fillcap_16
XFILLER_192_915 VDD VDD VSS VSS gf180mcu_as_sc_mcu7t3v3__fill_2
X_2845_ VDD VDD VSS VSS _4351_/Q _2906_/B _2997_/A _2906_/D _4351_/D gf180mcu_as_sc_mcu7t3v3__ao22_2
XTAP_TAPCELL_ROW_157_1235 VDD VSS gf180mcu_as_sc_mcu7t3v3__tap_2
XTAP_TAPCELL_ROW_157_1224 VDD VSS gf180mcu_as_sc_mcu7t3v3__tap_2
XTAP_TAPCELL_ROW_174_1560 VDD VSS gf180mcu_as_sc_mcu7t3v3__tap_2
XFILLER_163_149 VDD VDD VSS VSS gf180mcu_as_sc_mcu7t3v3__fillcap_4
XFILLER_176_1010 VDD VDD VSS VSS gf180mcu_as_sc_mcu7t3v3__fillcap_4
X_4515_ VDD VDD VSS VSS _4606_/CLK _4515_/D _4515_/Q gf180mcu_as_sc_mcu7t3v3__dfxtp_2
X_2776_ VDD VDD VSS VSS _4102_/D _2901_/C _2776_/C _2776_/D _2778_/C gf180mcu_as_sc_mcu7t3v3__ao211_2
XFILLER_160_801 VDD VDD VSS VSS gf180mcu_as_sc_mcu7t3v3__fillcap_4
XTAP_TAPCELL_ROW_170_1468 VDD VSS gf180mcu_as_sc_mcu7t3v3__tap_2
XFILLER_172_683 VDD VDD VSS VSS gf180mcu_as_sc_mcu7t3v3__fillcap_4
XFILLER_176_1065 VDD VDD VSS VSS gf180mcu_as_sc_mcu7t3v3__fillcap_4
XFILLER_176_1087 VDD VDD VSS VSS gf180mcu_as_sc_mcu7t3v3__fillcap_8
X_4446_ VDD VDD VSS VSS _4447_/CLK _4446_/D _4446_/Q gf180mcu_as_sc_mcu7t3v3__dfxtp_2
XTAP_TAPCELL_ROW_170_1479 VDD VSS gf180mcu_as_sc_mcu7t3v3__tap_2
Xfanout603 VDD VDD VSS VSS _2918_/B _2901_/B gf180mcu_as_sc_mcu7t3v3__buff_12
Xfanout614 VDD VDD VSS VSS _4206_/B _4133_/B gf180mcu_as_sc_mcu7t3v3__buff_12
X_4377_ VDD VDD VSS VSS _4445_/CLK _4377_/D _4377_/Q gf180mcu_as_sc_mcu7t3v3__dfxtp_2
Xfanout625 VDD VDD VSS VSS _2915_/C _2902_/C gf180mcu_as_sc_mcu7t3v3__buff_12
Xfanout636 VDD VDD VSS VSS fanout638/A _4224_/C gf180mcu_as_sc_mcu7t3v3__buff_12
Xfanout647 VDD VDD VSS VSS _3972_/Y _4148_/B gf180mcu_as_sc_mcu7t3v3__buff_12
Xfanout658 VDD VDD VSS VSS _3636_/Y _3867_/B gf180mcu_as_sc_mcu7t3v3__buff_12
X_3328_ VDD VDD VSS VSS _3328_/S _4374_/Q _4403_/Q _3329_/B gf180mcu_as_sc_mcu7t3v3__mux2_2
Xfanout669 VDD VDD VSS VSS _3544_/C _3600_/A gf180mcu_as_sc_mcu7t3v3__buff_12
XFILLER_6_1173 VDD VDD VSS VSS gf180mcu_as_sc_mcu7t3v3__fillcap_4
X_3259_ VDD VDD VSS VSS _4523_/Q _3347_/B _3347_/C _4524_/Q _3260_/C gf180mcu_as_sc_mcu7t3v3__ao22_2
XFILLER_160_49 VDD VDD VSS VSS gf180mcu_as_sc_mcu7t3v3__fill_1
XFILLER_156_6 VDD VDD VSS VSS gf180mcu_as_sc_mcu7t3v3__fillcap_16
XFILLER_167_422 VDD VDD VSS VSS gf180mcu_as_sc_mcu7t3v3__fillcap_16
XFILLER_169_69 VDD VDD VSS VSS gf180mcu_as_sc_mcu7t3v3__fill_1
XFILLER_10_667 VDD VDD VSS VSS gf180mcu_as_sc_mcu7t3v3__fillcap_8
XFILLER_155_639 VDD VDD VSS VSS gf180mcu_as_sc_mcu7t3v3__fillcap_4
XFILLER_185_68 VDD VDD VSS VSS gf180mcu_as_sc_mcu7t3v3__fill_2
XFILLER_191_970 VDD VDD VSS VSS gf180mcu_as_sc_mcu7t3v3__fill_1
XPHY_EDGE_ROW_65_3_Right_106 VDD VSS gf180mcu_as_sc_mcu7t3v3__tap_2
XFILLER_162_171 VDD VDD VSS VSS gf180mcu_as_sc_mcu7t3v3__fillcap_4
XFILLER_155_1149 VDD VDD VSS VSS gf180mcu_as_sc_mcu7t3v3__fillcap_8
XFILLER_1_387 VDD VDD VSS VSS gf180mcu_as_sc_mcu7t3v3__fill_1
Xmesh_tile_1002 VDD VDD VSS VSS sw_out[30] gf180mcu_as_sc_mcu7t3v3__tiel_4
X_4761__1011 VDD VDD VSS VSS _4761_/D gf180mcu_as_sc_mcu7t3v3__tiel_4
XFILLER_94_65 VDD VDD VSS VSS gf180mcu_as_sc_mcu7t3v3__fillcap_4
XFILLER_79_1264 VDD VDD VSS VSS gf180mcu_as_sc_mcu7t3v3__fill_2
XTAP_TAPCELL_ROW_52_1_1005 VDD VSS gf180mcu_as_sc_mcu7t3v3__tap_2
XFILLER_79_1297 VDD VDD VSS VSS gf180mcu_as_sc_mcu7t3v3__fill_2
XFILLER_159_912 VDD VDD VSS VSS gf180mcu_as_sc_mcu7t3v3__fillcap_16
XFILLER_177_208 VDD VDD VSS VSS gf180mcu_as_sc_mcu7t3v3__fill_2
XFILLER_13_450 VDD VDD VSS VSS gf180mcu_as_sc_mcu7t3v3__fill_1
XFILLER_186_731 VDD VDD VSS VSS gf180mcu_as_sc_mcu7t3v3__fillcap_4
XFILLER_186_753 VDD VDD VSS VSS gf180mcu_as_sc_mcu7t3v3__fillcap_16
XFILLER_12_1101 VDD VDD VSS VSS gf180mcu_as_sc_mcu7t3v3__fillcap_16
XFILLER_158_499 VDD VDD VSS VSS gf180mcu_as_sc_mcu7t3v3__fillcap_8
XFILLER_174_937 VDD VDD VSS VSS gf180mcu_as_sc_mcu7t3v3__fillcap_8
X_2630_ VDD VDD VSS VSS _2662_/C _2665_/B _2632_/A gf180mcu_as_sc_mcu7t3v3__nor2b_2
XTAP_TAPCELL_ROW_80_3_1991 VDD VSS gf180mcu_as_sc_mcu7t3v3__tap_2
XTAP_TAPCELL_ROW_152_1110 VDD VSS gf180mcu_as_sc_mcu7t3v3__tap_2
XFILLER_138_1303 VDD VDD VSS VSS gf180mcu_as_sc_mcu7t3v3__fillcap_8
XFILLER_161_609 VDD VDD VSS VSS gf180mcu_as_sc_mcu7t3v3__fillcap_16
XFILLER_177_1352 VDD VDD VSS VSS gf180mcu_as_sc_mcu7t3v3__fill_2
X_2561_ VDD VDD VSS VSS _3080_/D _4581_/Q _4580_/Q gf180mcu_as_sc_mcu7t3v3__nand2_2
XTAP_TAPCELL_ROW_152_1143 VDD VSS gf180mcu_as_sc_mcu7t3v3__tap_2
XTAP_TAPCELL_ROW_152_1132 VDD VSS gf180mcu_as_sc_mcu7t3v3__tap_2
XTAP_TAPCELL_ROW_152_1121 VDD VSS gf180mcu_as_sc_mcu7t3v3__tap_2
XFILLER_173_1216 VDD VDD VSS VSS gf180mcu_as_sc_mcu7t3v3__fill_1
X_4300_ VDD VDD VSS VSS _4313_/B _4524_/Q _4777_/D gf180mcu_as_sc_mcu7t3v3__and2_2
X_2492_ VDD VDD VSS VSS _2492_/D _3071_/A _2492_/B _2492_/C _2494_/C gf180mcu_as_sc_mcu7t3v3__ao31_2
XFILLER_4_181 VDD VDD VSS VSS gf180mcu_as_sc_mcu7t3v3__fill_2
X_4231_ VDD VDD VSS VSS _4233_/C _4231_/A _4231_/B _4244_/B gf180mcu_as_sc_mcu7t3v3__ao21_2
X_4162_ VDD VDD VSS VSS _4163_/B _4162_/A _4187_/B _4162_/C gf180mcu_as_sc_mcu7t3v3__ao21_2
X_4093_ VDD VDD VSS VSS _4093_/A _4149_/B _4149_/C _4093_/D _4094_/C gf180mcu_as_sc_mcu7t3v3__ao22_2
X_3113_ VDD VDD VSS VSS _3120_/S _4501_/Q _4500_/Q _4500_/D gf180mcu_as_sc_mcu7t3v3__mux2_2
X_3044_ VDD VDD VSS VSS _4330_/C _4767_/Q _4331_/B gf180mcu_as_sc_mcu7t3v3__xnor2_2
XFILLER_110_1299 VDD VDD VSS VSS gf180mcu_as_sc_mcu7t3v3__fillcap_4
XFILLER_184_1345 VDD VDD VSS VSS gf180mcu_as_sc_mcu7t3v3__fillcap_8
XFILLER_177_720 VDD VDD VSS VSS gf180mcu_as_sc_mcu7t3v3__fillcap_4
X_3946_ VDD VDD VSS VSS _3959_/C _3959_/B _3948_/A gf180mcu_as_sc_mcu7t3v3__nand2_2
XPHY_EDGE_ROW_131_1_Right_640 VDD VSS gf180mcu_as_sc_mcu7t3v3__tap_2
XFILLER_164_403 VDD VDD VSS VSS gf180mcu_as_sc_mcu7t3v3__fillcap_4
XFILLER_165_926 VDD VDD VSS VSS gf180mcu_as_sc_mcu7t3v3__fill_1
X_3877_ VDD VDD VSS VSS _3890_/S _4214_/A _3880_/C gf180mcu_as_sc_mcu7t3v3__or2_2
XTAP_TAPCELL_ROW_172_1519 VDD VSS gf180mcu_as_sc_mcu7t3v3__tap_2
XTAP_TAPCELL_ROW_172_1508 VDD VSS gf180mcu_as_sc_mcu7t3v3__tap_2
XFILLER_164_436 VDD VDD VSS VSS gf180mcu_as_sc_mcu7t3v3__fillcap_16
XFILLER_180_907 VDD VDD VSS VSS gf180mcu_as_sc_mcu7t3v3__fillcap_16
XFILLER_192_745 VDD VDD VSS VSS gf180mcu_as_sc_mcu7t3v3__fill_2
X_2828_ VDD VDD VSS VSS _4790_/Q _2828_/B _2828_/C _4148_/D _2829_/D gf180mcu_as_sc_mcu7t3v3__ao22_2
XFILLER_30_1256 VDD VDD VSS VSS gf180mcu_as_sc_mcu7t3v3__fillcap_4
X_2759_ VDD VDD VSS VSS _4088_/A _2823_/B _2759_/C _2823_/D _2761_/C gf180mcu_as_sc_mcu7t3v3__ao211_2
XFILLER_2_107 VDD VDD VSS VSS gf180mcu_as_sc_mcu7t3v3__fill_2
X_4429_ VDD VDD VSS VSS _4429_/CLK _4429_/D _4429_/Q gf180mcu_as_sc_mcu7t3v3__dfxtp_2
XFILLER_171_26 VDD VDD VSS VSS gf180mcu_as_sc_mcu7t3v3__fill_2
Xfanout455 VDD VDD VSS VSS _2920_/B _2906_/B gf180mcu_as_sc_mcu7t3v3__buff_12
Xfanout466 VDD VDD VSS VSS _3008_/Y _4276_/A gf180mcu_as_sc_mcu7t3v3__buff_12
Xfanout477 VDD VDD VSS VSS _2920_/D _2808_/D gf180mcu_as_sc_mcu7t3v3__buff_12
Xfanout488 VDD VDD VSS VSS _4212_/S _4163_/S gf180mcu_as_sc_mcu7t3v3__buff_12
Xfanout499 VDD VDD VSS VSS _3872_/B _3800_/B gf180mcu_as_sc_mcu7t3v3__buff_12
XTAP_TAPCELL_ROW_187_1795 VDD VSS gf180mcu_as_sc_mcu7t3v3__tap_2
XFILLER_104_53 VDD VDD VSS VSS gf180mcu_as_sc_mcu7t3v3__fillcap_16
XFILLER_73_103 VDD VDD VSS VSS gf180mcu_as_sc_mcu7t3v3__fill_2
Xmesh_tile_881 VDD VDD VSS VSS north_out[17] gf180mcu_as_sc_mcu7t3v3__tiel_4
Xmesh_tile_870 VDD VDD VSS VSS north_out[6] gf180mcu_as_sc_mcu7t3v3__tiel_4
Xmesh_tile_892 VDD VDD VSS VSS north_out[28] gf180mcu_as_sc_mcu7t3v3__tiel_4
XFILLER_168_731 VDD VDD VSS VSS gf180mcu_as_sc_mcu7t3v3__fillcap_4
XTAP_TAPCELL_ROW_99_1_1052 VDD VSS gf180mcu_as_sc_mcu7t3v3__tap_2
XTAP_TAPCELL_ROW_113_1_1066 VDD VSS gf180mcu_as_sc_mcu7t3v3__tap_2
XFILLER_11_932 VDD VDD VSS VSS gf180mcu_as_sc_mcu7t3v3__fillcap_16
XFILLER_120_96 VDD VDD VSS VSS gf180mcu_as_sc_mcu7t3v3__fillcap_8
XFILLER_167_230 VDD VDD VSS VSS gf180mcu_as_sc_mcu7t3v3__fillcap_16
XTAP_TAPCELL_ROW_13_949 VDD VSS gf180mcu_as_sc_mcu7t3v3__tap_2
XTAP_TAPCELL_ROW_13_938 VDD VSS gf180mcu_as_sc_mcu7t3v3__tap_2
Xwire812 VDD VDD VSS VSS wire812/A _4023_/A gf180mcu_as_sc_mcu7t3v3__clkbuff_12
XFILLER_11_998 VDD VDD VSS VSS gf180mcu_as_sc_mcu7t3v3__fillcap_8
XFILLER_129_50 VDD VDD VSS VSS gf180mcu_as_sc_mcu7t3v3__fillcap_8
XPHY_EDGE_ROW_144_1_Left_336 VDD VSS gf180mcu_as_sc_mcu7t3v3__tap_2
XFILLER_129_83 VDD VDD VSS VSS gf180mcu_as_sc_mcu7t3v3__fill_2
XFILLER_182_244 VDD VDD VSS VSS gf180mcu_as_sc_mcu7t3v3__fill_1
XFILLER_6_468 VDD VDD VSS VSS gf180mcu_as_sc_mcu7t3v3__fill_2
XFILLER_170_428 VDD VDD VSS VSS gf180mcu_as_sc_mcu7t3v3__fill_2
XPHY_EDGE_ROW_66_3_Right_107 VDD VSS gf180mcu_as_sc_mcu7t3v3__tap_2
XFILLER_172_1293 VDD VDD VSS VSS gf180mcu_as_sc_mcu7t3v3__fill_2
XPHY_EDGE_ROW_189_Right_51 VDD VSS gf180mcu_as_sc_mcu7t3v3__tap_2
XFILLER_166_1053 VDD VDD VSS VSS gf180mcu_as_sc_mcu7t3v3__fillcap_4
XFILLER_178_539 VDD VDD VSS VSS gf180mcu_as_sc_mcu7t3v3__fill_2
X_4780_ VDD VDD VSS VSS clkload7/A _4780_/D _4780_/Q gf180mcu_as_sc_mcu7t3v3__dfxtp_2
X_3800_ VDD VDD VSS VSS _4145_/A _3800_/B _3800_/C _3800_/D _3801_/B gf180mcu_as_sc_mcu7t3v3__ao211_2
XPHY_EDGE_ROW_15_3_Left_387 VDD VSS gf180mcu_as_sc_mcu7t3v3__tap_2
XFILLER_18_1354 VDD VDD VSS VSS gf180mcu_as_sc_mcu7t3v3__fill_1
X_3731_ VDD VDD VSS VSS _3794_/B _4084_/D _3732_/C gf180mcu_as_sc_mcu7t3v3__and2_2
XFILLER_158_263 VDD VDD VSS VSS gf180mcu_as_sc_mcu7t3v3__fillcap_4
XFILLER_158_274 VDD VDD VSS VSS gf180mcu_as_sc_mcu7t3v3__fillcap_16
XFILLER_53_1256 VDD VDD VSS VSS gf180mcu_as_sc_mcu7t3v3__fillcap_8
XPHY_EDGE_ROW_76_1_Left_268 VDD VSS gf180mcu_as_sc_mcu7t3v3__tap_2
XFILLER_174_734 VDD VDD VSS VSS gf180mcu_as_sc_mcu7t3v3__fill_1
XFILLER_186_594 VDD VDD VSS VSS gf180mcu_as_sc_mcu7t3v3__fill_1
Xclkload10 VDD VDD VSS VSS clkload10/Y _4789_/CLK gf180mcu_as_sc_mcu7t3v3__inv_6
X_3662_ VDD VDD VSS VSS _4021_/D _3879_/B _3662_/C _3662_/D _3663_/C gf180mcu_as_sc_mcu7t3v3__ao22_2
Xclkload21 VDD VDD VSS VSS _4727_/CLK clkload21/Y gf180mcu_as_sc_mcu7t3v3__clkbuff_4
X_3593_ VDD VDD VSS VSS _3593_/B _4650_/Q _3594_/C gf180mcu_as_sc_mcu7t3v3__xnor2_2
X_2613_ VDD VDD VSS VSS _4244_/A _3618_/A _3964_/B gf180mcu_as_sc_mcu7t3v3__nand2_2
XFILLER_161_417 VDD VDD VSS VSS gf180mcu_as_sc_mcu7t3v3__fill_2
X_2544_ VDD VDD VSS VSS _2544_/D _2544_/A _2544_/B _3564_/B _2545_/D gf180mcu_as_sc_mcu7t3v3__ao31_2
XFILLER_170_940 VDD VDD VSS VSS gf180mcu_as_sc_mcu7t3v3__fillcap_4
XFILLER_170_951 VDD VDD VSS VSS gf180mcu_as_sc_mcu7t3v3__fill_1
XFILLER_170_962 VDD VDD VSS VSS gf180mcu_as_sc_mcu7t3v3__fillcap_16
XFILLER_173_1002 VDD VDD VSS VSS gf180mcu_as_sc_mcu7t3v3__fillcap_16
X_2475_ VDD VDD VSS VSS _2491_/S _4532_/Q _4524_/Q _2476_/C gf180mcu_as_sc_mcu7t3v3__mux2_2
X_4214_ VDD VDD VSS VSS _4214_/A _4214_/B _4214_/C _4214_/D _4216_/B gf180mcu_as_sc_mcu7t3v3__ao22_2
X_4145_ VDD VDD VSS VSS _4146_/B _4145_/A _4187_/B _4145_/C gf180mcu_as_sc_mcu7t3v3__ao21_2
X_4076_ VDD VDD VSS VSS _4781_/Q _4148_/B _4148_/C _4076_/D _4080_/C gf180mcu_as_sc_mcu7t3v3__ao22_2
XTAP_TAPCELL_ROW_165_1389 VDD VSS gf180mcu_as_sc_mcu7t3v3__tap_2
XTAP_TAPCELL_ROW_165_1378 VDD VSS gf180mcu_as_sc_mcu7t3v3__tap_2
X_3027_ VDD VDD VSS VSS _4276_/A _4437_/Q _3027_/A _4437_/D gf180mcu_as_sc_mcu7t3v3__mux2_2
XFILLER_184_1142 VDD VDD VSS VSS gf180mcu_as_sc_mcu7t3v3__fillcap_8
XFILLER_34_27 VDD VDD VSS VSS gf180mcu_as_sc_mcu7t3v3__fill_1
XFILLER_180_1017 VDD VDD VSS VSS gf180mcu_as_sc_mcu7t3v3__fillcap_16
XFILLER_180_1039 VDD VDD VSS VSS gf180mcu_as_sc_mcu7t3v3__fill_1
Xclkload4 VDD VDD VSS VSS clkload4/A clkload4/Y gf180mcu_as_sc_mcu7t3v3__clkbuff_12
X_3929_ VDD VDD VSS VSS _3929_/B _4263_/D _3931_/C gf180mcu_as_sc_mcu7t3v3__and2_2
XPHY_EDGE_ROW_132_1_Right_641 VDD VSS gf180mcu_as_sc_mcu7t3v3__tap_2
XFILLER_164_244 VDD VDD VSS VSS gf180mcu_as_sc_mcu7t3v3__fill_1
XFILLER_166_37 VDD VDD VSS VSS gf180mcu_as_sc_mcu7t3v3__fillcap_4
XFILLER_180_715 VDD VDD VSS VSS gf180mcu_as_sc_mcu7t3v3__fillcap_16
XFILLER_192_575 VDD VDD VSS VSS gf180mcu_as_sc_mcu7t3v3__fill_2
XFILLER_156_1211 VDD VDD VSS VSS gf180mcu_as_sc_mcu7t3v3__fillcap_8
XFILLER_180_737 VDD VDD VSS VSS gf180mcu_as_sc_mcu7t3v3__fillcap_16
XFILLER_192_586 VDD VDD VSS VSS gf180mcu_as_sc_mcu7t3v3__fill_1
XTAP_TAPCELL_ROW_189_1835 VDD VSS gf180mcu_as_sc_mcu7t3v3__tap_2
XFILLER_161_973 VDD VDD VSS VSS gf180mcu_as_sc_mcu7t3v3__fillcap_4
XTAP_TAPCELL_ROW_189_1846 VDD VSS gf180mcu_as_sc_mcu7t3v3__tap_2
XTAP_TAPCELL_ROW_132_3_2043 VDD VSS gf180mcu_as_sc_mcu7t3v3__tap_2
XFILLER_46_103 VDD VDD VSS VSS gf180mcu_as_sc_mcu7t3v3__fill_2
XFILLER_8_1087 VDD VDD VSS VSS gf180mcu_as_sc_mcu7t3v3__fillcap_8
XFILLER_131_51 VDD VDD VSS VSS gf180mcu_as_sc_mcu7t3v3__fillcap_16
XFILLER_188_804 VDD VDD VSS VSS gf180mcu_as_sc_mcu7t3v3__fill_1
XFILLER_76_1256 VDD VDD VSS VSS gf180mcu_as_sc_mcu7t3v3__fillcap_16
XFILLER_163_1259 VDD VDD VSS VSS gf180mcu_as_sc_mcu7t3v3__fill_1
XFILLER_168_550 VDD VDD VSS VSS gf180mcu_as_sc_mcu7t3v3__fillcap_4
XTAP_TAPCELL_ROW_47_1_1000 VDD VSS gf180mcu_as_sc_mcu7t3v3__tap_2
XFILLER_155_222 VDD VDD VSS VSS gf180mcu_as_sc_mcu7t3v3__fill_1
XFILLER_156_734 VDD VDD VSS VSS gf180mcu_as_sc_mcu7t3v3__fill_1
XFILLER_183_531 VDD VDD VSS VSS gf180mcu_as_sc_mcu7t3v3__fillcap_8
XFILLER_7_755 VDD VDD VSS VSS gf180mcu_as_sc_mcu7t3v3__fillcap_4
XFILLER_155_299 VDD VDD VSS VSS gf180mcu_as_sc_mcu7t3v3__fillcap_4
XFILLER_7_788 VDD VDD VSS VSS gf180mcu_as_sc_mcu7t3v3__fill_1
XFILLER_170_247 VDD VDD VSS VSS gf180mcu_as_sc_mcu7t3v3__fillcap_16
XFILLER_100_1287 VDD VDD VSS VSS gf180mcu_as_sc_mcu7t3v3__fill_2
XPHY_EDGE_ROW_67_3_Right_108 VDD VSS gf180mcu_as_sc_mcu7t3v3__tap_2
X_2260_ VDD VDD VSS VSS _3569_/B _4625_/Q _3465_/A gf180mcu_as_sc_mcu7t3v3__and2_2
X_2191_ VDD VDD VSS VSS _3483_/S _3131_/A gf180mcu_as_sc_mcu7t3v3__inv_2
XFILLER_1_42 VDD VDD VSS VSS gf180mcu_as_sc_mcu7t3v3__fill_1
XFILLER_20_1288 VDD VDD VSS VSS gf180mcu_as_sc_mcu7t3v3__fill_1
XFILLER_181_1304 VDD VDD VSS VSS gf180mcu_as_sc_mcu7t3v3__fill_1
XTAP_TAPCELL_ROW_67_3_1978 VDD VSS gf180mcu_as_sc_mcu7t3v3__tap_2
XTAP_TAPCELL_ROW_160_1286 VDD VSS gf180mcu_as_sc_mcu7t3v3__tap_2
X_4763_ VDD VDD VSS VSS clkload3/A _4763_/D _4763_/Q gf180mcu_as_sc_mcu7t3v3__dfxtp_2
Xclkbuf_leaf_29_clk_regs VDD VDD VSS VSS clkbuf_3_4__f_clk_regs/Y _4720_/CLK gf180mcu_as_sc_mcu7t3v3__clkbuff_12
X_4694_ VDD VDD VSS VSS _4719_/CLK _4694_/D _4694_/Q gf180mcu_as_sc_mcu7t3v3__dfxtp_2
X_3714_ VDD VDD VSS VSS _4071_/D _3795_/B _3714_/C _3795_/D _3716_/C gf180mcu_as_sc_mcu7t3v3__ao211_2
XFILLER_162_726 VDD VDD VSS VSS gf180mcu_as_sc_mcu7t3v3__fillcap_8
XFILLER_162_737 VDD VDD VSS VSS gf180mcu_as_sc_mcu7t3v3__fill_2
XFILLER_174_597 VDD VDD VSS VSS gf180mcu_as_sc_mcu7t3v3__fillcap_16
XFILLER_175_1108 VDD VDD VSS VSS gf180mcu_as_sc_mcu7t3v3__fillcap_8
XFILLER_179_1288 VDD VDD VSS VSS gf180mcu_as_sc_mcu7t3v3__fill_1
X_3645_ VDD VDD VSS VSS _3645_/B _3966_/A _3645_/Y gf180mcu_as_sc_mcu7t3v3__and2_2
X_3576_ VDD VDD VSS VSS _4626_/D _3603_/C _3576_/B _3603_/A gf180mcu_as_sc_mcu7t3v3__aoi21b_2
XFILLER_161_269 VDD VDD VSS VSS gf180mcu_as_sc_mcu7t3v3__fillcap_8
X_2527_ VDD VDD VSS VSS _2552_/A _3458_/A _3571_/B gf180mcu_as_sc_mcu7t3v3__and2_2
Xinput309 VDD VDD VSS VSS west_in[20] _4166_/A gf180mcu_as_sc_mcu7t3v3__buff_12
X_2458_ VDD VDD VSS VSS _2491_/S _4530_/Q _4522_/Q _2460_/B gf180mcu_as_sc_mcu7t3v3__mux2_2
XTAP_TAPCELL_ROW_167_1418 VDD VSS gf180mcu_as_sc_mcu7t3v3__tap_2
XFILLER_29_27 VDD VDD VSS VSS gf180mcu_as_sc_mcu7t3v3__fill_2
XFILLER_5_1205 VDD VDD VSS VSS gf180mcu_as_sc_mcu7t3v3__fillcap_4
X_2389_ VDD VDD VSS VSS _2390_/C _2389_/C _2389_/B _2426_/C gf180mcu_as_sc_mcu7t3v3__aoi21b_2
XTAP_TAPCELL_ROW_4_758 VDD VSS gf180mcu_as_sc_mcu7t3v3__tap_2
XTAP_TAPCELL_ROW_184_1743 VDD VSS gf180mcu_as_sc_mcu7t3v3__tap_2
X_4128_ VDD VDD VSS VSS _4128_/A _4136_/B _4128_/C _4128_/D _4129_/D gf180mcu_as_sc_mcu7t3v3__ao211_2
XTAP_TAPCELL_ROW_4_769 VDD VSS gf180mcu_as_sc_mcu7t3v3__tap_2
XFILLER_99_1256 VDD VDD VSS VSS gf180mcu_as_sc_mcu7t3v3__fillcap_16
X_4059_ VDD VDD VSS VSS _4059_/B _4213_/A _4699_/D gf180mcu_as_sc_mcu7t3v3__and2_2
XFILLER_186_1259 VDD VDD VSS VSS gf180mcu_as_sc_mcu7t3v3__fillcap_8
XFILLER_45_48 VDD VDD VSS VSS gf180mcu_as_sc_mcu7t3v3__fillcap_16
XFILLER_169_314 VDD VDD VSS VSS gf180mcu_as_sc_mcu7t3v3__fillcap_8
XFILLER_169_347 VDD VDD VSS VSS gf180mcu_as_sc_mcu7t3v3__fill_2
XFILLER_177_380 VDD VDD VSS VSS gf180mcu_as_sc_mcu7t3v3__fillcap_4
XPHY_EDGE_ROW_133_1_Right_642 VDD VSS gf180mcu_as_sc_mcu7t3v3__tap_2
XFILLER_123_1298 VDD VDD VSS VSS gf180mcu_as_sc_mcu7t3v3__fill_1
XFILLER_158_1339 VDD VDD VSS VSS gf180mcu_as_sc_mcu7t3v3__fillcap_8
XTAP_TAPCELL_ROW_108_1_1061 VDD VSS gf180mcu_as_sc_mcu7t3v3__tap_2
Xclkbuf_regs_0_clk VDD VDD VSS VSS clk clkbuf_regs_0_clk/Y gf180mcu_as_sc_mcu7t3v3__clkbuff_12
XFILLER_126_84 VDD VDD VSS VSS gf180mcu_as_sc_mcu7t3v3__fill_2
XFILLER_188_612 VDD VDD VSS VSS gf180mcu_as_sc_mcu7t3v3__fillcap_16
XFILLER_167_1192 VDD VDD VSS VSS gf180mcu_as_sc_mcu7t3v3__fillcap_8
XFILLER_188_667 VDD VDD VSS VSS gf180mcu_as_sc_mcu7t3v3__fillcap_4
XFILLER_176_818 VDD VDD VSS VSS gf180mcu_as_sc_mcu7t3v3__fillcap_8
XFILLER_184_873 VDD VDD VSS VSS gf180mcu_as_sc_mcu7t3v3__fill_2
XFILLER_156_597 VDD VDD VSS VSS gf180mcu_as_sc_mcu7t3v3__fillcap_8
XFILLER_13_1081 VDD VDD VSS VSS gf180mcu_as_sc_mcu7t3v3__fill_2
X_3430_ VDD VDD VSS VSS _4559_/Q _3439_/B _3442_/C _4558_/Q _4558_/D gf180mcu_as_sc_mcu7t3v3__ao22_2
X_3361_ VDD VDD VSS VSS _3362_/D _3361_/B _3369_/A gf180mcu_as_sc_mcu7t3v3__nor2_2
XFILLER_174_1152 VDD VDD VSS VSS gf180mcu_as_sc_mcu7t3v3__fill_2
X_2312_ VDD VDD VSS VSS _2312_/Y _2313_/B _2408_/A gf180mcu_as_sc_mcu7t3v3__nor2_2
XPHY_EDGE_ROW_68_3_Right_109 VDD VSS gf180mcu_as_sc_mcu7t3v3__tap_2
X_3292_ VDD VDD VSS VSS _3348_/A _3292_/B _3292_/C _3292_/D _4527_/D gf180mcu_as_sc_mcu7t3v3__ao211_2
X_2243_ VDD VDD VSS VSS _3471_/B _3211_/A _4623_/Q gf180mcu_as_sc_mcu7t3v3__nor2_2
XTAP_TAPCELL_ROW_1_717 VDD VSS gf180mcu_as_sc_mcu7t3v3__tap_2
XTAP_TAPCELL_ROW_1_706 VDD VSS gf180mcu_as_sc_mcu7t3v3__tap_2
XTAP_TAPCELL_ROW_162_1315 VDD VSS gf180mcu_as_sc_mcu7t3v3__tap_2
XTAP_TAPCELL_ROW_162_1326 VDD VSS gf180mcu_as_sc_mcu7t3v3__tap_2
XFILLER_146_1287 VDD VDD VSS VSS gf180mcu_as_sc_mcu7t3v3__fill_2
XFILLER_181_1178 VDD VDD VSS VSS gf180mcu_as_sc_mcu7t3v3__fillcap_8
X_4815_ VDD VDD VSS VSS _4830_/CLK _4815_/D _4815_/Q gf180mcu_as_sc_mcu7t3v3__dfxtp_2
XFILLER_166_317 VDD VDD VSS VSS gf180mcu_as_sc_mcu7t3v3__fillcap_16
XFILLER_178_188 VDD VDD VSS VSS gf180mcu_as_sc_mcu7t3v3__fillcap_16
XTAP_TAPCELL_ROW_15_3_1926 VDD VSS gf180mcu_as_sc_mcu7t3v3__tap_2
X_4746_ VDD VDD VSS VSS _4751_/CLK _4746_/D _4746_/Q gf180mcu_as_sc_mcu7t3v3__dfxtp_2
XFILLER_179_1052 VDD VDD VSS VSS gf180mcu_as_sc_mcu7t3v3__fillcap_4
X_4677_ VDD VDD VSS VSS clkload4/A _4677_/D _4677_/Q gf180mcu_as_sc_mcu7t3v3__dfxtp_2
X_3628_ VDD VDD VSS VSS _3634_/B _3634_/A _3968_/A gf180mcu_as_sc_mcu7t3v3__and2_2
XFILLER_157_1350 VDD VDD VSS VSS gf180mcu_as_sc_mcu7t3v3__fill_1
XFILLER_162_567 VDD VDD VSS VSS gf180mcu_as_sc_mcu7t3v3__fill_2
Xmax_cap761 VDD VDD VSS VSS _3956_/A _4274_/A gf180mcu_as_sc_mcu7t3v3__clkbuff_12
XFILLER_163_38 VDD VDD VSS VSS gf180mcu_as_sc_mcu7t3v3__fillcap_16
X_3559_ VDD VDD VSS VSS _3559_/B _4580_/Q _3580_/B gf180mcu_as_sc_mcu7t3v3__xnor2_2
Xinput106 VDD VDD VSS VSS ne_in[33] _3949_/C gf180mcu_as_sc_mcu7t3v3__buff_12
Xinput117 VDD VDD VSS VSS north_in[10] _4085_/D gf180mcu_as_sc_mcu7t3v3__buff_12
Xinput128 VDD VDD VSS VSS north_in[20] _4167_/D gf180mcu_as_sc_mcu7t3v3__buff_12
Xinput139 VDD VDD VSS VSS north_in[30] _4257_/A gf180mcu_as_sc_mcu7t3v3__buff_12
XFILLER_186_1056 VDD VDD VSS VSS gf180mcu_as_sc_mcu7t3v3__fillcap_16
XFILLER_112_53 VDD VDD VSS VSS gf180mcu_as_sc_mcu7t3v3__fill_2
XFILLER_169_100 VDD VDD VSS VSS gf180mcu_as_sc_mcu7t3v3__fill_2
XFILLER_158_807 VDD VDD VSS VSS gf180mcu_as_sc_mcu7t3v3__fillcap_16
XFILLER_188_68 VDD VDD VSS VSS gf180mcu_as_sc_mcu7t3v3__fillcap_4
XFILLER_185_648 VDD VDD VSS VSS gf180mcu_as_sc_mcu7t3v3__fillcap_16
XFILLER_9_828 VDD VDD VSS VSS gf180mcu_as_sc_mcu7t3v3__fill_1
XPHY_EDGE_ROW_134_1_Right_643 VDD VSS gf180mcu_as_sc_mcu7t3v3__tap_2
XFILLER_153_556 VDD VDD VSS VSS gf180mcu_as_sc_mcu7t3v3__fillcap_4
XFILLER_181_854 VDD VDD VSS VSS gf180mcu_as_sc_mcu7t3v3__fill_2
XFILLER_21_72 VDD VDD VSS VSS gf180mcu_as_sc_mcu7t3v3__fillcap_16
XFILLER_137_72 VDD VDD VSS VSS gf180mcu_as_sc_mcu7t3v3__fillcap_4
XFILLER_158_1169 VDD VDD VSS VSS gf180mcu_as_sc_mcu7t3v3__fill_2
XTAP_TAPCELL_ROW_8_850 VDD VSS gf180mcu_as_sc_mcu7t3v3__tap_2
XPHY_EDGE_ROW_24_3_Left_396 VDD VSS gf180mcu_as_sc_mcu7t3v3__tap_2
XPHY_EDGE_ROW_85_1_Left_277 VDD VSS gf180mcu_as_sc_mcu7t3v3__tap_2
XFILLER_165_1118 VDD VDD VSS VSS gf180mcu_as_sc_mcu7t3v3__fill_2
X_2930_ VDD VDD VSS VSS _2981_/A _2943_/A _3012_/A gf180mcu_as_sc_mcu7t3v3__and2_2
XFILLER_91_1326 VDD VDD VSS VSS gf180mcu_as_sc_mcu7t3v3__fillcap_4
X_4600_ VDD VDD VSS VSS _4602_/CLK _4600_/D _4600_/Q gf180mcu_as_sc_mcu7t3v3__dfxtp_2
X_2861_ VDD VDD VSS VSS _2862_/D _4178_/A _2896_/B _2861_/C gf180mcu_as_sc_mcu7t3v3__ao21_2
XFILLER_176_659 VDD VDD VSS VSS gf180mcu_as_sc_mcu7t3v3__fillcap_4
X_2792_ VDD VDD VSS VSS _4786_/Q _2828_/B _2828_/C _4117_/D _2793_/D gf180mcu_as_sc_mcu7t3v3__ao22_2
XFILLER_157_895 VDD VDD VSS VSS gf180mcu_as_sc_mcu7t3v3__fillcap_8
X_4531_ VDD VDD VSS VSS _4795_/CLK _4531_/D _4531_/Q gf180mcu_as_sc_mcu7t3v3__dfxtp_2
XFILLER_8_872 VDD VDD VSS VSS gf180mcu_as_sc_mcu7t3v3__fill_2
XFILLER_184_692 VDD VDD VSS VSS gf180mcu_as_sc_mcu7t3v3__fill_1
X_4462_ VDD VDD VSS VSS _4602_/CLK _4462_/D _4462_/Q gf180mcu_as_sc_mcu7t3v3__dfxtp_2
XTAP_TAPCELL_ROW_155_1196 VDD VSS gf180mcu_as_sc_mcu7t3v3__tap_2
XTAP_TAPCELL_ROW_155_1185 VDD VSS gf180mcu_as_sc_mcu7t3v3__tap_2
XFILLER_176_1258 VDD VDD VSS VSS gf180mcu_as_sc_mcu7t3v3__fillcap_16
X_3413_ VDD VDD VSS VSS _3413_/Y _3603_/C _3414_/A gf180mcu_as_sc_mcu7t3v3__nor2_2
X_4393_ VDD VDD VSS VSS _4429_/CLK _4393_/D _4393_/Q gf180mcu_as_sc_mcu7t3v3__dfxtp_2
XTAP_TAPCELL_ROW_6_809 VDD VSS gf180mcu_as_sc_mcu7t3v3__tap_2
X_3344_ VDD VDD VSS VSS _3344_/S _4376_/Q _4405_/Q _3345_/B gf180mcu_as_sc_mcu7t3v3__mux2_2
X_3275_ VDD VDD VSS VSS _4525_/Q _3315_/B _3315_/C _4526_/Q _3276_/C gf180mcu_as_sc_mcu7t3v3__ao22_2
XFILLER_152_1280 VDD VDD VSS VSS gf180mcu_as_sc_mcu7t3v3__fill_1
XFILLER_26_1272 VDD VDD VSS VSS gf180mcu_as_sc_mcu7t3v3__fillcap_16
Xhold1049 VDD VDD VSS VSS hold1079/Y hold1080/A gf180mcu_as_sc_mcu7t3v3__clkbuff_4
X_2226_ VDD VDD VSS VSS _2345_/B _2226_/A gf180mcu_as_sc_mcu7t3v3__inv_2
XFILLER_187_1332 VDD VDD VSS VSS gf180mcu_as_sc_mcu7t3v3__fillcap_16
XTAP_TAPCELL_ROW_70_1_1023 VDD VSS gf180mcu_as_sc_mcu7t3v3__tap_2
XFILLER_187_1354 VDD VDD VSS VSS gf180mcu_as_sc_mcu7t3v3__fill_1
XTAP_TAPCELL_ROW_179_1653 VDD VSS gf180mcu_as_sc_mcu7t3v3__tap_2
XTAP_TAPCELL_ROW_179_1642 VDD VSS gf180mcu_as_sc_mcu7t3v3__tap_2
XFILLER_42_27 VDD VDD VSS VSS gf180mcu_as_sc_mcu7t3v3__fill_1
XFILLER_182_629 VDD VDD VSS VSS gf180mcu_as_sc_mcu7t3v3__fillcap_4
X_4729_ VDD VDD VSS VSS clkload6/A _4729_/D _4729_/Q gf180mcu_as_sc_mcu7t3v3__dfxtp_2
XFILLER_181_139 VDD VDD VSS VSS gf180mcu_as_sc_mcu7t3v3__fill_1
XTAP_TAPCELL_ROW_192_1897 VDD VSS gf180mcu_as_sc_mcu7t3v3__tap_2
XTAP_TAPCELL_ROW_192_1886 VDD VSS gf180mcu_as_sc_mcu7t3v3__tap_2
XFILLER_174_37 VDD VDD VSS VSS gf180mcu_as_sc_mcu7t3v3__fillcap_16
XFILLER_192_1071 VDD VDD VSS VSS gf180mcu_as_sc_mcu7t3v3__fillcap_4
XPHY_EDGE_ROW_152_Right_14 VDD VSS gf180mcu_as_sc_mcu7t3v3__tap_2
XPHY_EDGE_ROW_161_Right_23 VDD VSS gf180mcu_as_sc_mcu7t3v3__tap_2
XFILLER_157_125 VDD VDD VSS VSS gf180mcu_as_sc_mcu7t3v3__fillcap_4
XFILLER_185_467 VDD VDD VSS VSS gf180mcu_as_sc_mcu7t3v3__fill_1
XFILLER_32_60 VDD VDD VSS VSS gf180mcu_as_sc_mcu7t3v3__fillcap_8
XFILLER_148_71 VDD VDD VSS VSS gf180mcu_as_sc_mcu7t3v3__fill_2
XFILLER_172_139 VDD VDD VSS VSS gf180mcu_as_sc_mcu7t3v3__fillcap_8
XFILLER_5_831 VDD VDD VSS VSS gf180mcu_as_sc_mcu7t3v3__fillcap_8
XFILLER_5_842 VDD VDD VSS VSS gf180mcu_as_sc_mcu7t3v3__fillcap_8
XTAP_TAPCELL_ROW_46_1_999 VDD VSS gf180mcu_as_sc_mcu7t3v3__tap_2
XTAP_TAPCELL_ROW_11_899 VDD VSS gf180mcu_as_sc_mcu7t3v3__tap_2
XFILLER_181_673 VDD VDD VSS VSS gf180mcu_as_sc_mcu7t3v3__fillcap_8
XPHY_EDGE_ROW_135_1_Right_644 VDD VSS gf180mcu_as_sc_mcu7t3v3__tap_2
XFILLER_10_1084 VDD VDD VSS VSS gf180mcu_as_sc_mcu7t3v3__fill_1
XPHY_EDGE_ROW_170_Right_32 VDD VSS gf180mcu_as_sc_mcu7t3v3__tap_2
X_3060_ VDD VDD VSS VSS _3062_/S _5074_/A _4459_/Q _4459_/D gf180mcu_as_sc_mcu7t3v3__mux2_2
X_3962_ VDD VDD VSS VSS _3966_/B _3962_/A _3962_/B _3962_/C gf180mcu_as_sc_mcu7t3v3__ao21_2
XTAP_TAPCELL_ROW_131_1_1084 VDD VSS gf180mcu_as_sc_mcu7t3v3__tap_2
XFILLER_148_103 VDD VDD VSS VSS gf180mcu_as_sc_mcu7t3v3__fill_2
XFILLER_176_412 VDD VDD VSS VSS gf180mcu_as_sc_mcu7t3v3__fill_2
X_3893_ VDD VDD VSS VSS _4227_/D _3930_/B _3929_/B _4227_/A _3894_/D gf180mcu_as_sc_mcu7t3v3__ao22_2
X_2913_ VDD VDD VSS VSS _4359_/Q _2920_/B _3037_/B _2920_/D _4359_/D gf180mcu_as_sc_mcu7t3v3__ao22_2
X_2844_ VDD VDD VSS VSS _4163_/A _2871_/B _2844_/C _2844_/D _2997_/A gf180mcu_as_sc_mcu7t3v3__ao22_2
XTAP_TAPCELL_ROW_157_1236 VDD VSS gf180mcu_as_sc_mcu7t3v3__tap_2
XTAP_TAPCELL_ROW_157_1225 VDD VSS gf180mcu_as_sc_mcu7t3v3__tap_2
XFILLER_164_618 VDD VDD VSS VSS gf180mcu_as_sc_mcu7t3v3__fill_1
XFILLER_192_949 VDD VDD VSS VSS gf180mcu_as_sc_mcu7t3v3__fill_2
XTAP_TAPCELL_ROW_174_1561 VDD VSS gf180mcu_as_sc_mcu7t3v3__tap_2
XTAP_TAPCELL_ROW_174_1550 VDD VSS gf180mcu_as_sc_mcu7t3v3__tap_2
X_4514_ VDD VDD VSS VSS _4804_/CLK _4514_/D _4514_/Q gf180mcu_as_sc_mcu7t3v3__dfxtp_2
X_2775_ VDD VDD VSS VSS _2901_/B _4100_/D _2776_/D gf180mcu_as_sc_mcu7t3v3__and2_2
XFILLER_172_662 VDD VDD VSS VSS gf180mcu_as_sc_mcu7t3v3__fill_2
XFILLER_160_835 VDD VDD VSS VSS gf180mcu_as_sc_mcu7t3v3__fillcap_8
XFILLER_171_150 VDD VDD VSS VSS gf180mcu_as_sc_mcu7t3v3__fill_1
XFILLER_171_172 VDD VDD VSS VSS gf180mcu_as_sc_mcu7t3v3__fill_1
X_4445_ VDD VDD VSS VSS _4445_/CLK _4445_/D _4445_/Q gf180mcu_as_sc_mcu7t3v3__dfxtp_2
XTAP_TAPCELL_ROW_170_1469 VDD VSS gf180mcu_as_sc_mcu7t3v3__tap_2
XFILLER_176_1099 VDD VDD VSS VSS gf180mcu_as_sc_mcu7t3v3__fill_1
Xfanout604 VDD VDD VSS VSS _2662_/Y _2918_/B gf180mcu_as_sc_mcu7t3v3__buff_12
X_4376_ VDD VDD VSS VSS _4533_/CLK _4376_/D _4376_/Q gf180mcu_as_sc_mcu7t3v3__dfxtp_2
XFILLER_115_1326 VDD VDD VSS VSS gf180mcu_as_sc_mcu7t3v3__fill_2
Xfanout626 VDD VDD VSS VSS fanout627/A _2915_/C gf180mcu_as_sc_mcu7t3v3__buff_12
Xfanout637 VDD VDD VSS VSS _3989_/Y _4149_/C gf180mcu_as_sc_mcu7t3v3__buff_12
Xfanout648 VDD VDD VSS VSS fanout648/A _4208_/B gf180mcu_as_sc_mcu7t3v3__buff_12
X_3327_ VDD VDD VSS VSS _3330_/C _4432_/Q _3328_/S gf180mcu_as_sc_mcu7t3v3__nand2_2
Xfanout659 VDD VDD VSS VSS _3926_/D _3880_/A gf180mcu_as_sc_mcu7t3v3__buff_12
XFILLER_37_49 VDD VDD VSS VSS gf180mcu_as_sc_mcu7t3v3__fillcap_16
X_3258_ VDD VDD VSS VSS _3330_/A _3258_/B _3258_/C _3260_/B _3258_/D gf180mcu_as_sc_mcu7t3v3__aoi31_2
X_3189_ VDD VDD VSS VSS _3189_/B _3199_/A _3191_/C gf180mcu_as_sc_mcu7t3v3__or2_2
X_2209_ VDD VDD VSS VSS _3210_/A _4515_/Q gf180mcu_as_sc_mcu7t3v3__inv_2
XFILLER_187_1162 VDD VDD VSS VSS gf180mcu_as_sc_mcu7t3v3__fill_2
XFILLER_74_1354 VDD VDD VSS VSS gf180mcu_as_sc_mcu7t3v3__fill_1
XFILLER_139_103 VDD VDD VSS VSS gf180mcu_as_sc_mcu7t3v3__fill_2
XFILLER_149_6 VDD VDD VSS VSS gf180mcu_as_sc_mcu7t3v3__fillcap_16
XFILLER_179_294 VDD VDD VSS VSS gf180mcu_as_sc_mcu7t3v3__fill_2
XFILLER_182_404 VDD VDD VSS VSS gf180mcu_as_sc_mcu7t3v3__fillcap_16
XFILLER_183_916 VDD VDD VSS VSS gf180mcu_as_sc_mcu7t3v3__fill_1
XFILLER_159_1242 VDD VDD VSS VSS gf180mcu_as_sc_mcu7t3v3__fillcap_4
XFILLER_163_651 VDD VDD VSS VSS gf180mcu_as_sc_mcu7t3v3__fill_2
XFILLER_159_1264 VDD VDD VSS VSS gf180mcu_as_sc_mcu7t3v3__fill_1
XFILLER_159_1275 VDD VDD VSS VSS gf180mcu_as_sc_mcu7t3v3__fillcap_16
XFILLER_163_684 VDD VDD VSS VSS gf180mcu_as_sc_mcu7t3v3__fill_2
XFILLER_190_481 VDD VDD VSS VSS gf180mcu_as_sc_mcu7t3v3__fill_1
XFILLER_134_73 VDD VDD VSS VSS gf180mcu_as_sc_mcu7t3v3__fillcap_4
Xmesh_tile_1003 VDD VDD VSS VSS sw_out[31] gf180mcu_as_sc_mcu7t3v3__tiel_4
XFILLER_91_104 VDD VDD VSS VSS gf180mcu_as_sc_mcu7t3v3__fill_1
XFILLER_166_1224 VDD VDD VSS VSS gf180mcu_as_sc_mcu7t3v3__fill_1
XFILLER_13_440 VDD VDD VSS VSS gf180mcu_as_sc_mcu7t3v3__fill_2
XPHY_EDGE_ROW_116_1_Left_308 VDD VSS gf180mcu_as_sc_mcu7t3v3__tap_2
XFILLER_158_445 VDD VDD VSS VSS gf180mcu_as_sc_mcu7t3v3__fill_2
XFILLER_159_979 VDD VDD VSS VSS gf180mcu_as_sc_mcu7t3v3__fill_1
XFILLER_9_422 VDD VDD VSS VSS gf180mcu_as_sc_mcu7t3v3__fillcap_4
XFILLER_185_264 VDD VDD VSS VSS gf180mcu_as_sc_mcu7t3v3__fillcap_16
XTAP_TAPCELL_ROW_152_1111 VDD VSS gf180mcu_as_sc_mcu7t3v3__tap_2
XPHY_EDGE_ROW_120_3_Right_161 VDD VSS gf180mcu_as_sc_mcu7t3v3__tap_2
XFILLER_12_1157 VDD VDD VSS VSS gf180mcu_as_sc_mcu7t3v3__fillcap_16
XFILLER_154_662 VDD VDD VSS VSS gf180mcu_as_sc_mcu7t3v3__fill_2
X_2560_ VDD VDD VSS VSS _2563_/B _2560_/B _2563_/D gf180mcu_as_sc_mcu7t3v3__nand2_2
XTAP_TAPCELL_ROW_152_1133 VDD VSS gf180mcu_as_sc_mcu7t3v3__tap_2
XTAP_TAPCELL_ROW_152_1122 VDD VSS gf180mcu_as_sc_mcu7t3v3__tap_2
XFILLER_138_1315 VDD VDD VSS VSS gf180mcu_as_sc_mcu7t3v3__fill_1
X_2491_ VDD VDD VSS VSS _2491_/S _4534_/Q _4526_/Q _2492_/C gf180mcu_as_sc_mcu7t3v3__mux2_2
XPHY_EDGE_ROW_136_1_Right_645 VDD VSS gf180mcu_as_sc_mcu7t3v3__tap_2
XFILLER_173_1228 VDD VDD VSS VSS gf180mcu_as_sc_mcu7t3v3__fill_1
XFILLER_173_1239 VDD VDD VSS VSS gf180mcu_as_sc_mcu7t3v3__fillcap_8
X_4230_ VDD VDD VSS VSS _4720_/D _4230_/C _4230_/B _4230_/A gf180mcu_as_sc_mcu7t3v3__aoi21b_2
XFILLER_4_53 VDD VDD VSS VSS gf180mcu_as_sc_mcu7t3v3__fill_2
X_4161_ VDD VDD VSS VSS _4161_/A _4186_/B _4161_/C _4161_/D _4162_/C gf180mcu_as_sc_mcu7t3v3__ao211_2
XTAP_TAPCELL_ROW_150_3_2061 VDD VSS gf180mcu_as_sc_mcu7t3v3__tap_2
XFILLER_3_1303 VDD VDD VSS VSS gf180mcu_as_sc_mcu7t3v3__fill_2
X_4092_ VDD VDD VSS VSS _4783_/Q _4148_/B _4148_/C _4092_/D _4096_/C gf180mcu_as_sc_mcu7t3v3__ao22_2
X_3112_ VDD VDD VSS VSS _3120_/S _4500_/Q _4499_/Q _4499_/D gf180mcu_as_sc_mcu7t3v3__mux2_2
XFILLER_62_1291 VDD VDD VSS VSS gf180mcu_as_sc_mcu7t3v3__fillcap_4
XFILLER_82_104 VDD VDD VSS VSS gf180mcu_as_sc_mcu7t3v3__fill_1
X_3043_ VDD VDD VSS VSS _4122_/D _4330_/B _4330_/C _4448_/D gf180mcu_as_sc_mcu7t3v3__nor3_2
XFILLER_97_1321 VDD VDD VSS VSS gf180mcu_as_sc_mcu7t3v3__fill_2
XFILLER_110_1256 VDD VDD VSS VSS gf180mcu_as_sc_mcu7t3v3__fillcap_8
XFILLER_184_1313 VDD VDD VSS VSS gf180mcu_as_sc_mcu7t3v3__fillcap_16
X_3945_ VDD VDD VSS VSS _3945_/B _3945_/A _4689_/D gf180mcu_as_sc_mcu7t3v3__and2_2
XFILLER_182_1081 VDD VDD VSS VSS gf180mcu_as_sc_mcu7t3v3__fillcap_4
X_3876_ VDD VDD VSS VSS _4217_/A _3876_/B _3876_/C _3876_/D _3880_/B gf180mcu_as_sc_mcu7t3v3__ao211_2
XTAP_TAPCELL_ROW_172_1509 VDD VSS gf180mcu_as_sc_mcu7t3v3__tap_2
XPHY_EDGE_ROW_49_3_Left_421 VDD VSS gf180mcu_as_sc_mcu7t3v3__tap_2
X_2827_ VDD VDD VSS VSS _2827_/B _4149_/A _2829_/C gf180mcu_as_sc_mcu7t3v3__and2_2
XPHY_EDGE_ROW_101_3_Left_473 VDD VSS gf180mcu_as_sc_mcu7t3v3__tap_2
XFILLER_178_1139 VDD VDD VSS VSS gf180mcu_as_sc_mcu7t3v3__fill_2
XFILLER_192_779 VDD VDD VSS VSS gf180mcu_as_sc_mcu7t3v3__fill_2
X_2758_ VDD VDD VSS VSS _4087_/D _2822_/B _2758_/C _2758_/D _2759_/C gf180mcu_as_sc_mcu7t3v3__ao211_2
XFILLER_173_982 VDD VDD VSS VSS gf180mcu_as_sc_mcu7t3v3__fillcap_8
X_4428_ VDD VDD VSS VSS clkload9/A _4428_/D _4428_/Q gf180mcu_as_sc_mcu7t3v3__dfxtp_2
X_2689_ VDD VDD VSS VSS _4026_/A _2905_/B _2689_/C _2689_/D _2980_/A gf180mcu_as_sc_mcu7t3v3__ao22_2
XFILLER_119_1270 VDD VDD VSS VSS gf180mcu_as_sc_mcu7t3v3__fill_1
XFILLER_154_1183 VDD VDD VSS VSS gf180mcu_as_sc_mcu7t3v3__fillcap_16
XFILLER_48_37 VDD VDD VSS VSS gf180mcu_as_sc_mcu7t3v3__fillcap_4
XFILLER_48_48 VDD VDD VSS VSS gf180mcu_as_sc_mcu7t3v3__fillcap_16
XFILLER_58_101 VDD VDD VSS VSS gf180mcu_as_sc_mcu7t3v3__fillcap_4
Xfanout456 VDD VDD VSS VSS _2671_/Y _2920_/B gf180mcu_as_sc_mcu7t3v3__buff_12
X_4359_ VDD VDD VSS VSS _4447_/CLK _4359_/D _4359_/Q gf180mcu_as_sc_mcu7t3v3__dfxtp_2
Xfanout467 VDD VDD VSS VSS _3008_/Y _3038_/C gf180mcu_as_sc_mcu7t3v3__buff_12
Xfanout478 VDD VDD VSS VSS _2920_/D _2906_/D gf180mcu_as_sc_mcu7t3v3__buff_12
Xfanout489 VDD VDD VSS VSS _4005_/Y _4238_/S gf180mcu_as_sc_mcu7t3v3__buff_12
XTAP_TAPCELL_ROW_187_1796 VDD VSS gf180mcu_as_sc_mcu7t3v3__tap_2
Xmesh_tile_871 VDD VDD VSS VSS north_out[7] gf180mcu_as_sc_mcu7t3v3__tiel_4
Xmesh_tile_860 VDD VDD VSS VSS ne_out[32] gf180mcu_as_sc_mcu7t3v3__tiel_4
Xmesh_tile_893 VDD VDD VSS VSS north_out[29] gf180mcu_as_sc_mcu7t3v3__tiel_4
Xmesh_tile_882 VDD VDD VSS VSS north_out[18] gf180mcu_as_sc_mcu7t3v3__tiel_4
XTAP_TAPCELL_ROW_85_3_1996 VDD VSS gf180mcu_as_sc_mcu7t3v3__tap_2
XTAP_TAPCELL_ROW_45_1_998 VDD VSS gf180mcu_as_sc_mcu7t3v3__tap_2
XFILLER_120_64 VDD VDD VSS VSS gf180mcu_as_sc_mcu7t3v3__fillcap_16
XTAP_TAPCELL_ROW_13_939 VDD VSS gf180mcu_as_sc_mcu7t3v3__tap_2
XFILLER_156_938 VDD VDD VSS VSS gf180mcu_as_sc_mcu7t3v3__fillcap_4
XFILLER_183_713 VDD VDD VSS VSS gf180mcu_as_sc_mcu7t3v3__fillcap_4
XFILLER_10_454 VDD VDD VSS VSS gf180mcu_as_sc_mcu7t3v3__fill_1
XFILLER_167_275 VDD VDD VSS VSS gf180mcu_as_sc_mcu7t3v3__fillcap_4
XFILLER_89_22 VDD VDD VSS VSS gf180mcu_as_sc_mcu7t3v3__fillcap_4
XPHY_EDGE_ROW_94_1_Left_286 VDD VSS gf180mcu_as_sc_mcu7t3v3__tap_2
XFILLER_129_95 VDD VDD VSS VSS gf180mcu_as_sc_mcu7t3v3__fillcap_8
XFILLER_89_55 VDD VDD VSS VSS gf180mcu_as_sc_mcu7t3v3__fill_1
XFILLER_159_1094 VDD VDD VSS VSS gf180mcu_as_sc_mcu7t3v3__fill_1
XFILLER_163_492 VDD VDD VSS VSS gf180mcu_as_sc_mcu7t3v3__fillcap_16
XFILLER_89_99 VDD VDD VSS VSS gf180mcu_as_sc_mcu7t3v3__fillcap_4
XFILLER_145_72 VDD VDD VSS VSS gf180mcu_as_sc_mcu7t3v3__fillcap_8
XFILLER_1_130 VDD VDD VSS VSS gf180mcu_as_sc_mcu7t3v3__fill_1
XFILLER_85_1280 VDD VDD VSS VSS gf180mcu_as_sc_mcu7t3v3__fillcap_4
XFILLER_133_1256 VDD VDD VSS VSS gf180mcu_as_sc_mcu7t3v3__fill_2
XFILLER_38_70 VDD VDD VSS VSS gf180mcu_as_sc_mcu7t3v3__fill_2
XFILLER_64_104 VDD VDD VSS VSS gf180mcu_as_sc_mcu7t3v3__fill_1
XFILLER_166_1087 VDD VDD VSS VSS gf180mcu_as_sc_mcu7t3v3__fillcap_16
XFILLER_178_518 VDD VDD VSS VSS gf180mcu_as_sc_mcu7t3v3__fillcap_4
X_3730_ VDD VDD VSS VSS _4083_/A _3846_/D _3730_/C _4666_/D _4122_/D gf180mcu_as_sc_mcu7t3v3__aoi211_2
XFILLER_88_1309 VDD VDD VSS VSS gf180mcu_as_sc_mcu7t3v3__fill_1
X_3661_ VDD VDD VSS VSS _3662_/D _4020_/A _3880_/A _3953_/C gf180mcu_as_sc_mcu7t3v3__ao21_2
XFILLER_174_768 VDD VDD VSS VSS gf180mcu_as_sc_mcu7t3v3__fillcap_4
XFILLER_70_90 VDD VDD VSS VSS gf180mcu_as_sc_mcu7t3v3__fillcap_8
Xclkload11 VDD VDD VSS VSS _4533_/CLK clkload11/Y gf180mcu_as_sc_mcu7t3v3__clkbuff_4
Xclkload22 VDD VDD VSS VSS clkload22/Y _4708_/CLK gf180mcu_as_sc_mcu7t3v3__inv_2
X_3592_ VDD VDD VSS VSS _3593_/B _4650_/Q _3596_/B gf180mcu_as_sc_mcu7t3v3__and2_2
X_2612_ VDD VDD VSS VSS _3954_/A _3942_/A _3964_/A _3618_/A gf180mcu_as_sc_mcu7t3v3__nor3_2
XPHY_EDGE_ROW_121_3_Right_162 VDD VSS gf180mcu_as_sc_mcu7t3v3__tap_2
XFILLER_155_982 VDD VDD VSS VSS gf180mcu_as_sc_mcu7t3v3__fillcap_4
X_2543_ VDD VDD VSS VSS _2543_/D _4588_/Q _2544_/A _2543_/C _2544_/D gf180mcu_as_sc_mcu7t3v3__ao31_2
XFILLER_173_1047 VDD VDD VSS VSS gf180mcu_as_sc_mcu7t3v3__fill_2
X_2474_ VDD VDD VSS VSS _2476_/D _2474_/C _2490_/B _2474_/A gf180mcu_as_sc_mcu7t3v3__aoi21b_2
XPHY_EDGE_ROW_137_1_Right_646 VDD VSS gf180mcu_as_sc_mcu7t3v3__tap_2
XFILLER_151_1312 VDD VDD VSS VSS gf180mcu_as_sc_mcu7t3v3__fillcap_8
XFILLER_25_1326 VDD VDD VSS VSS gf180mcu_as_sc_mcu7t3v3__fillcap_4
X_4213_ VDD VDD VSS VSS _4213_/B _4213_/A _4718_/D gf180mcu_as_sc_mcu7t3v3__and2_2
XTAP_TAPCELL_ROW_169_1460 VDD VSS gf180mcu_as_sc_mcu7t3v3__tap_2
X_4144_ VDD VDD VSS VSS _4144_/A _4186_/B _4144_/C _4144_/D _4145_/C gf180mcu_as_sc_mcu7t3v3__ao211_2
XFILLER_55_104 VDD VDD VSS VSS gf180mcu_as_sc_mcu7t3v3__fill_1
X_4075_ VDD VDD VSS VSS _4075_/B _4213_/A _4701_/D gf180mcu_as_sc_mcu7t3v3__and2_2
XTAP_TAPCELL_ROW_165_1379 VDD VSS gf180mcu_as_sc_mcu7t3v3__tap_2
XFILLER_184_1110 VDD VDD VSS VSS gf180mcu_as_sc_mcu7t3v3__fillcap_16
X_3026_ VDD VDD VSS VSS _3026_/A _3034_/B _4276_/A _4436_/Q _4436_/D gf180mcu_as_sc_mcu7t3v3__ao22_2
XFILLER_184_1154 VDD VDD VSS VSS gf180mcu_as_sc_mcu7t3v3__fill_1
XFILLER_184_1187 VDD VDD VSS VSS gf180mcu_as_sc_mcu7t3v3__fill_1
XFILLER_184_1198 VDD VDD VSS VSS gf180mcu_as_sc_mcu7t3v3__fillcap_8
XFILLER_165_702 VDD VDD VSS VSS gf180mcu_as_sc_mcu7t3v3__fill_1
XFILLER_177_562 VDD VDD VSS VSS gf180mcu_as_sc_mcu7t3v3__fillcap_4
Xclkload5 VDD VDD VSS VSS clkload5/A clkload5/Y gf180mcu_as_sc_mcu7t3v3__clkbuff_4
X_3928_ VDD VDD VSS VSS _3928_/B _4263_/A _3931_/B gf180mcu_as_sc_mcu7t3v3__or2_2
XFILLER_164_201 VDD VDD VSS VSS gf180mcu_as_sc_mcu7t3v3__fillcap_16
X_3859_ VDD VDD VSS VSS _3859_/B _4198_/A _3861_/C gf180mcu_as_sc_mcu7t3v3__or2_2
XFILLER_192_543 VDD VDD VSS VSS gf180mcu_as_sc_mcu7t3v3__fill_1
XFILLER_164_289 VDD VDD VSS VSS gf180mcu_as_sc_mcu7t3v3__fill_1
XFILLER_156_1223 VDD VDD VSS VSS gf180mcu_as_sc_mcu7t3v3__fill_2
XFILLER_156_1234 VDD VDD VSS VSS gf180mcu_as_sc_mcu7t3v3__fillcap_16
XFILLER_59_58 VDD VDD VSS VSS gf180mcu_as_sc_mcu7t3v3__fill_1
XTAP_TAPCELL_ROW_189_1836 VDD VSS gf180mcu_as_sc_mcu7t3v3__tap_2
XFILLER_182_37 VDD VDD VSS VSS gf180mcu_as_sc_mcu7t3v3__fillcap_8
XFILLER_8_1099 VDD VDD VSS VSS gf180mcu_as_sc_mcu7t3v3__fill_1
XFILLER_189_1076 VDD VDD VSS VSS gf180mcu_as_sc_mcu7t3v3__fillcap_4
XFILLER_75_68 VDD VDD VSS VSS gf180mcu_as_sc_mcu7t3v3__fill_2
XFILLER_75_79 VDD VDD VSS VSS gf180mcu_as_sc_mcu7t3v3__fillcap_4
XFILLER_131_74 VDD VDD VSS VSS gf180mcu_as_sc_mcu7t3v3__fill_1
XFILLER_91_56 VDD VDD VSS VSS gf180mcu_as_sc_mcu7t3v3__fill_2
XFILLER_187_348 VDD VDD VSS VSS gf180mcu_as_sc_mcu7t3v3__fill_2
XTAP_TAPCELL_ROW_33_3_1944 VDD VSS gf180mcu_as_sc_mcu7t3v3__tap_2
XFILLER_155_201 VDD VDD VSS VSS gf180mcu_as_sc_mcu7t3v3__fillcap_8
XFILLER_155_212 VDD VDD VSS VSS gf180mcu_as_sc_mcu7t3v3__fillcap_8
XFILLER_13_1230 VDD VDD VSS VSS gf180mcu_as_sc_mcu7t3v3__fill_2
XFILLER_155_256 VDD VDD VSS VSS gf180mcu_as_sc_mcu7t3v3__fill_2
XFILLER_183_554 VDD VDD VSS VSS gf180mcu_as_sc_mcu7t3v3__fillcap_4
XFILLER_155_278 VDD VDD VSS VSS gf180mcu_as_sc_mcu7t3v3__fill_2
XFILLER_87_1353 VDD VDD VSS VSS gf180mcu_as_sc_mcu7t3v3__fill_2
XFILLER_152_985 VDD VDD VSS VSS gf180mcu_as_sc_mcu7t3v3__fill_1
XFILLER_3_984 VDD VDD VSS VSS gf180mcu_as_sc_mcu7t3v3__fill_1
X_2190_ VDD VDD VSS VSS _3580_/D _2510_/D gf180mcu_as_sc_mcu7t3v3__inv_2
XPHY_EDGE_ROW_61_1_Right_570 VDD VSS gf180mcu_as_sc_mcu7t3v3__tap_2
XFILLER_1_10 VDD VDD VSS VSS gf180mcu_as_sc_mcu7t3v3__fillcap_4
XFILLER_37_104 VDD VDD VSS VSS gf180mcu_as_sc_mcu7t3v3__fill_1
XFILLER_168_1127 VDD VDD VSS VSS gf180mcu_as_sc_mcu7t3v3__fill_2
XFILLER_94_1302 VDD VDD VSS VSS gf180mcu_as_sc_mcu7t3v3__fill_2
XFILLER_179_827 VDD VDD VSS VSS gf180mcu_as_sc_mcu7t3v3__fillcap_8
X_4831_ VDD VDD VSS VSS _4831_/CLK _4831_/D _4831_/Q gf180mcu_as_sc_mcu7t3v3__dfxtp_2
XTAP_TAPCELL_ROW_160_1287 VDD VSS gf180mcu_as_sc_mcu7t3v3__tap_2
XFILLER_159_540 VDD VDD VSS VSS gf180mcu_as_sc_mcu7t3v3__fill_2
XFILLER_159_562 VDD VDD VSS VSS gf180mcu_as_sc_mcu7t3v3__fill_2
X_4762_ VDD VDD VSS VSS clkload3/A _4762_/D _4762_/Q gf180mcu_as_sc_mcu7t3v3__dfxtp_2
X_4693_ VDD VDD VSS VSS _4719_/CLK _4693_/D _4693_/Q gf180mcu_as_sc_mcu7t3v3__dfxtp_2
X_3713_ VDD VDD VSS VSS _3794_/B _4068_/D _3714_/C gf180mcu_as_sc_mcu7t3v3__and2_2
XFILLER_179_1223 VDD VDD VSS VSS gf180mcu_as_sc_mcu7t3v3__fill_2
X_3644_ VDD VDD VSS VSS _3645_/B _3644_/C _3644_/B _3961_/B gf180mcu_as_sc_mcu7t3v3__aoi21_2
XFILLER_179_1256 VDD VDD VSS VSS gf180mcu_as_sc_mcu7t3v3__fillcap_4
XFILLER_179_1278 VDD VDD VSS VSS gf180mcu_as_sc_mcu7t3v3__fillcap_8
XTAP_TAPCELL_ROW_137_3_2048 VDD VSS gf180mcu_as_sc_mcu7t3v3__tap_2
X_3575_ VDD VDD VSS VSS _3576_/B _3575_/C _3575_/B _4629_/Q gf180mcu_as_sc_mcu7t3v3__aoi21_2
XTAP_TAPCELL_ROW_44_1_997 VDD VSS gf180mcu_as_sc_mcu7t3v3__tap_2
XPHY_EDGE_ROW_122_3_Right_163 VDD VSS gf180mcu_as_sc_mcu7t3v3__tap_2
X_2526_ VDD VDD VSS VSS _2528_/D _3080_/B _3080_/A gf180mcu_as_sc_mcu7t3v3__nor2_2
XFILLER_170_782 VDD VDD VSS VSS gf180mcu_as_sc_mcu7t3v3__fill_1
X_2457_ VDD VDD VSS VSS _2481_/A _4824_/Q _2481_/C _2457_/D _2462_/A gf180mcu_as_sc_mcu7t3v3__ao211_2
XTAP_TAPCELL_ROW_167_1419 VDD VSS gf180mcu_as_sc_mcu7t3v3__tap_2
XPHY_EDGE_ROW_138_1_Right_647 VDD VSS gf180mcu_as_sc_mcu7t3v3__tap_2
XFILLER_152_29 VDD VDD VSS VSS gf180mcu_as_sc_mcu7t3v3__fillcap_4
X_2388_ VDD VDD VSS VSS _2388_/A input5/Y _2388_/C _2397_/D _2389_/C gf180mcu_as_sc_mcu7t3v3__ao211_2
XTAP_TAPCELL_ROW_4_759 VDD VSS gf180mcu_as_sc_mcu7t3v3__tap_2
XTAP_TAPCELL_ROW_184_1744 VDD VSS gf180mcu_as_sc_mcu7t3v3__tap_2
XTAP_TAPCELL_ROW_184_1733 VDD VSS gf180mcu_as_sc_mcu7t3v3__tap_2
X_4127_ VDD VDD VSS VSS _4127_/A _4226_/B _4136_/C _4127_/D _4128_/D gf180mcu_as_sc_mcu7t3v3__ao22_2
XFILLER_186_1227 VDD VDD VSS VSS gf180mcu_as_sc_mcu7t3v3__fillcap_16
X_4058_ VDD VDD VSS VSS _4163_/S _4058_/B _4058_/A _4059_/B gf180mcu_as_sc_mcu7t3v3__mux2_2
X_3009_ VDD VDD VSS VSS _3009_/A _3034_/B _4276_/A _4419_/Q _4419_/D gf180mcu_as_sc_mcu7t3v3__ao22_2
XFILLER_177_26 VDD VDD VSS VSS gf180mcu_as_sc_mcu7t3v3__fill_2
XFILLER_165_532 VDD VDD VSS VSS gf180mcu_as_sc_mcu7t3v3__fill_1
XFILLER_153_727 VDD VDD VSS VSS gf180mcu_as_sc_mcu7t3v3__fillcap_8
XFILLER_158_1307 VDD VDD VSS VSS gf180mcu_as_sc_mcu7t3v3__fillcap_16
XFILLER_180_524 VDD VDD VSS VSS gf180mcu_as_sc_mcu7t3v3__fill_1
XFILLER_10_63 VDD VDD VSS VSS gf180mcu_as_sc_mcu7t3v3__fillcap_16
XFILLER_0_954 VDD VDD VSS VSS gf180mcu_as_sc_mcu7t3v3__fill_1
XFILLER_82_1272 VDD VDD VSS VSS gf180mcu_as_sc_mcu7t3v3__fillcap_8
Xoutput390 VDD VDD VSS VSS _4678_/Q south_out[21] gf180mcu_as_sc_mcu7t3v3__buff_12
XPHY_EDGE_ROW_125_1_Left_317 VDD VSS gf180mcu_as_sc_mcu7t3v3__tap_2
XFILLER_43_1256 VDD VDD VSS VSS gf180mcu_as_sc_mcu7t3v3__fillcap_16
XFILLER_19_83 VDD VDD VSS VSS gf180mcu_as_sc_mcu7t3v3__fillcap_16
XFILLER_141_1311 VDD VDD VSS VSS gf180mcu_as_sc_mcu7t3v3__fillcap_4
XFILLER_171_502 VDD VDD VSS VSS gf180mcu_as_sc_mcu7t3v3__fillcap_8
Xwire462 VDD VDD VSS VSS _3847_/B _3855_/B gf180mcu_as_sc_mcu7t3v3__clkbuff_12
Xwire495 VDD VDD VSS VSS _4253_/B _4204_/B gf180mcu_as_sc_mcu7t3v3__clkbuff_12
X_3360_ VDD VDD VSS VSS _3368_/S _4378_/Q _4407_/Q _3361_/B gf180mcu_as_sc_mcu7t3v3__mux2_2
XFILLER_3_781 VDD VDD VSS VSS gf180mcu_as_sc_mcu7t3v3__fillcap_16
X_2311_ VDD VDD VSS VSS _2311_/B _4272_/C _2313_/B gf180mcu_as_sc_mcu7t3v3__or2_2
XPHY_EDGE_ROW_57_1_Left_249 VDD VSS gf180mcu_as_sc_mcu7t3v3__tap_2
XFILLER_170_1017 VDD VDD VSS VSS gf180mcu_as_sc_mcu7t3v3__fillcap_16
X_3291_ VDD VDD VSS VSS _4527_/Q _3347_/B _3347_/C _4528_/Q _3292_/C gf180mcu_as_sc_mcu7t3v3__ao22_2
X_2242_ VDD VDD VSS VSS _4625_/Q _4624_/Q _3211_/A gf180mcu_as_sc_mcu7t3v3__or2_2
XTAP_TAPCELL_ROW_1_707 VDD VSS gf180mcu_as_sc_mcu7t3v3__tap_2
XPHY_EDGE_ROW_62_1_Right_571 VDD VSS gf180mcu_as_sc_mcu7t3v3__tap_2
XPHY_EDGE_ROW_58_3_Left_430 VDD VSS gf180mcu_as_sc_mcu7t3v3__tap_2
XTAP_TAPCELL_ROW_1_718 VDD VSS gf180mcu_as_sc_mcu7t3v3__tap_2
XTAP_TAPCELL_ROW_162_1327 VDD VSS gf180mcu_as_sc_mcu7t3v3__tap_2
XTAP_TAPCELL_ROW_162_1316 VDD VSS gf180mcu_as_sc_mcu7t3v3__tap_2
XFILLER_4_1294 VDD VDD VSS VSS gf180mcu_as_sc_mcu7t3v3__fill_1
XPHY_EDGE_ROW_110_3_Left_482 VDD VSS gf180mcu_as_sc_mcu7t3v3__tap_2
XFILLER_179_613 VDD VDD VSS VSS gf180mcu_as_sc_mcu7t3v3__fillcap_16
XFILLER_146_1299 VDD VDD VSS VSS gf180mcu_as_sc_mcu7t3v3__fill_1
XFILLER_181_1146 VDD VDD VSS VSS gf180mcu_as_sc_mcu7t3v3__fillcap_16
X_4814_ VDD VDD VSS VSS _4830_/CLK _4814_/D _4814_/Q gf180mcu_as_sc_mcu7t3v3__dfxtp_2
X_4745_ VDD VDD VSS VSS _4751_/CLK _4745_/D _4745_/Q gf180mcu_as_sc_mcu7t3v3__dfxtp_2
XFILLER_174_362 VDD VDD VSS VSS gf180mcu_as_sc_mcu7t3v3__fillcap_8
XFILLER_175_885 VDD VDD VSS VSS gf180mcu_as_sc_mcu7t3v3__fillcap_16
X_4676_ VDD VDD VSS VSS clkload4/A _4676_/D _4676_/Q gf180mcu_as_sc_mcu7t3v3__dfxtp_2
XFILLER_162_524 VDD VDD VSS VSS gf180mcu_as_sc_mcu7t3v3__fill_1
XFILLER_179_1097 VDD VDD VSS VSS gf180mcu_as_sc_mcu7t3v3__fillcap_8
X_3627_ VDD VDD VSS VSS _3634_/B _3959_/B _4267_/C gf180mcu_as_sc_mcu7t3v3__nand2b_2
XFILLER_157_1340 VDD VDD VSS VSS gf180mcu_as_sc_mcu7t3v3__fillcap_8
XFILLER_192_1231 VDD VDD VSS VSS gf180mcu_as_sc_mcu7t3v3__fillcap_4
X_3558_ VDD VDD VSS VSS _3561_/A _3558_/B _3558_/A gf180mcu_as_sc_mcu7t3v3__nand2_2
XPHY_EDGE_ROW_123_3_Right_164 VDD VSS gf180mcu_as_sc_mcu7t3v3__tap_2
XFILLER_0_206 VDD VDD VSS VSS gf180mcu_as_sc_mcu7t3v3__fillcap_4
XFILLER_66_1256 VDD VDD VSS VSS gf180mcu_as_sc_mcu7t3v3__fillcap_4
X_2509_ VDD VDD VSS VSS _2521_/A _2566_/A _2566_/D gf180mcu_as_sc_mcu7t3v3__nand2b_2
XFILLER_153_1259 VDD VDD VSS VSS gf180mcu_as_sc_mcu7t3v3__fill_1
Xinput107 VDD VDD VSS VSS ne_in[34] _3961_/C gf180mcu_as_sc_mcu7t3v3__buff_12
Xinput118 VDD VDD VSS VSS north_in[11] _4092_/D gf180mcu_as_sc_mcu7t3v3__buff_12
X_3489_ VDD VDD VSS VSS _4595_/D _4595_/Q _3503_/B _3489_/C gf180mcu_as_sc_mcu7t3v3__ao21_2
Xinput129 VDD VDD VSS VSS north_in[21] _4173_/D gf180mcu_as_sc_mcu7t3v3__buff_12
XPHY_EDGE_ROW_139_1_Right_648 VDD VSS gf180mcu_as_sc_mcu7t3v3__tap_2
XFILLER_56_37 VDD VDD VSS VSS gf180mcu_as_sc_mcu7t3v3__fillcap_4
XFILLER_9_1194 VDD VDD VSS VSS gf180mcu_as_sc_mcu7t3v3__fill_1
XFILLER_38_1303 VDD VDD VSS VSS gf180mcu_as_sc_mcu7t3v3__fill_2
XFILLER_188_47 VDD VDD VSS VSS gf180mcu_as_sc_mcu7t3v3__fill_1
XFILLER_9_807 VDD VDD VSS VSS gf180mcu_as_sc_mcu7t3v3__fillcap_8
XFILLER_184_104 VDD VDD VSS VSS gf180mcu_as_sc_mcu7t3v3__fill_1
XFILLER_166_863 VDD VDD VSS VSS gf180mcu_as_sc_mcu7t3v3__fill_1
XFILLER_153_502 VDD VDD VSS VSS gf180mcu_as_sc_mcu7t3v3__fill_2
XFILLER_158_1126 VDD VDD VSS VSS gf180mcu_as_sc_mcu7t3v3__fillcap_4
XFILLER_21_51 VDD VDD VSS VSS gf180mcu_as_sc_mcu7t3v3__fillcap_4
XFILLER_137_62 VDD VDD VSS VSS gf180mcu_as_sc_mcu7t3v3__fillcap_8
XFILLER_180_387 VDD VDD VSS VSS gf180mcu_as_sc_mcu7t3v3__fillcap_8
XTAP_TAPCELL_ROW_8_840 VDD VSS gf180mcu_as_sc_mcu7t3v3__tap_2
XTAP_TAPCELL_ROW_8_851 VDD VSS gf180mcu_as_sc_mcu7t3v3__tap_2
XFILLER_97_88 VDD VDD VSS VSS gf180mcu_as_sc_mcu7t3v3__fillcap_16
XFILLER_153_72 VDD VDD VSS VSS gf180mcu_as_sc_mcu7t3v3__fillcap_16
XFILLER_169_1222 VDD VDD VSS VSS gf180mcu_as_sc_mcu7t3v3__fill_1
XFILLER_46_70 VDD VDD VSS VSS gf180mcu_as_sc_mcu7t3v3__fill_1
XTAP_TAPCELL_ROW_43_1_996 VDD VSS gf180mcu_as_sc_mcu7t3v3__tap_2
XFILLER_188_454 VDD VDD VSS VSS gf180mcu_as_sc_mcu7t3v3__fill_1
XFILLER_189_966 VDD VDD VSS VSS gf180mcu_as_sc_mcu7t3v3__fill_2
X_2860_ VDD VDD VSS VSS _4175_/A _2895_/B _2860_/C _2860_/D _2861_/C gf180mcu_as_sc_mcu7t3v3__ao211_2
XFILLER_106_1272 VDD VDD VSS VSS gf180mcu_as_sc_mcu7t3v3__fill_2
X_2791_ VDD VDD VSS VSS _2827_/B _4116_/A _2793_/C gf180mcu_as_sc_mcu7t3v3__and2_2
XFILLER_8_840 VDD VDD VSS VSS gf180mcu_as_sc_mcu7t3v3__fillcap_8
XFILLER_156_373 VDD VDD VSS VSS gf180mcu_as_sc_mcu7t3v3__fillcap_8
XFILLER_157_885 VDD VDD VSS VSS gf180mcu_as_sc_mcu7t3v3__fill_2
XFILLER_190_107 VDD VDD VSS VSS gf180mcu_as_sc_mcu7t3v3__fillcap_4
X_4530_ VDD VDD VSS VSS _4789_/CLK _4530_/D _4530_/Q gf180mcu_as_sc_mcu7t3v3__dfxtp_2
XFILLER_176_1204 VDD VDD VSS VSS gf180mcu_as_sc_mcu7t3v3__fillcap_16
XFILLER_183_181 VDD VDD VSS VSS gf180mcu_as_sc_mcu7t3v3__fill_2
XFILLER_89_1256 VDD VDD VSS VSS gf180mcu_as_sc_mcu7t3v3__fillcap_4
X_4461_ VDD VDD VSS VSS _4602_/CLK _4461_/D _4461_/Q gf180mcu_as_sc_mcu7t3v3__dfxtp_2
XTAP_TAPCELL_ROW_155_1197 VDD VSS gf180mcu_as_sc_mcu7t3v3__tap_2
XTAP_TAPCELL_ROW_155_1186 VDD VSS gf180mcu_as_sc_mcu7t3v3__tap_2
XFILLER_171_343 VDD VDD VSS VSS gf180mcu_as_sc_mcu7t3v3__fillcap_4
XFILLER_172_877 VDD VDD VSS VSS gf180mcu_as_sc_mcu7t3v3__fillcap_16
X_3412_ VDD VDD VSS VSS _3412_/A _3412_/B _3412_/C _3412_/D _4542_/D gf180mcu_as_sc_mcu7t3v3__ao211_2
X_4392_ VDD VDD VSS VSS _4429_/CLK _4392_/D _4392_/Q gf180mcu_as_sc_mcu7t3v3__dfxtp_2
X_3343_ VDD VDD VSS VSS _3346_/C _4434_/Q _3344_/S gf180mcu_as_sc_mcu7t3v3__nand2_2
XFILLER_6_1301 VDD VDD VSS VSS gf180mcu_as_sc_mcu7t3v3__fill_2
X_3274_ VDD VDD VSS VSS _3314_/A _3274_/B _3274_/C _3276_/B _3274_/D gf180mcu_as_sc_mcu7t3v3__aoi31_2
X_2225_ VDD VDD VSS VSS _4232_/A _3901_/A gf180mcu_as_sc_mcu7t3v3__inv_2
XFILLER_187_1311 VDD VDD VSS VSS gf180mcu_as_sc_mcu7t3v3__fillcap_16
XPHY_EDGE_ROW_63_1_Right_572 VDD VSS gf180mcu_as_sc_mcu7t3v3__tap_2
XFILLER_183_1219 VDD VDD VSS VSS gf180mcu_as_sc_mcu7t3v3__fill_2
XPHY_EDGE_ROW_5_Right_5 VDD VSS gf180mcu_as_sc_mcu7t3v3__tap_2
XFILLER_179_410 VDD VDD VSS VSS gf180mcu_as_sc_mcu7t3v3__fillcap_8
XFILLER_167_605 VDD VDD VSS VSS gf180mcu_as_sc_mcu7t3v3__fillcap_16
XTAP_TAPCELL_ROW_179_1654 VDD VSS gf180mcu_as_sc_mcu7t3v3__tap_2
XTAP_TAPCELL_ROW_179_1643 VDD VSS gf180mcu_as_sc_mcu7t3v3__tap_2
XFILLER_166_104 VDD VDD VSS VSS gf180mcu_as_sc_mcu7t3v3__fill_1
XFILLER_179_487 VDD VDD VSS VSS gf180mcu_as_sc_mcu7t3v3__fill_2
Xclkbuf_leaf_13_clk_regs VDD VDD VSS VSS clkload0/A _4803_/CLK gf180mcu_as_sc_mcu7t3v3__clkbuff_12
X_2989_ VDD VDD VSS VSS _3020_/A _2989_/B _2989_/C _4401_/Q _4401_/D gf180mcu_as_sc_mcu7t3v3__ao22_2
XFILLER_163_811 VDD VDD VSS VSS gf180mcu_as_sc_mcu7t3v3__fillcap_16
XFILLER_166_159 VDD VDD VSS VSS gf180mcu_as_sc_mcu7t3v3__fillcap_4
X_4728_ VDD VDD VSS VSS _4728_/CLK _4728_/D _4728_/Q gf180mcu_as_sc_mcu7t3v3__dfxtp_2
XFILLER_174_181 VDD VDD VSS VSS gf180mcu_as_sc_mcu7t3v3__fill_2
XFILLER_175_682 VDD VDD VSS VSS gf180mcu_as_sc_mcu7t3v3__fillcap_4
XFILLER_181_129 VDD VDD VSS VSS gf180mcu_as_sc_mcu7t3v3__fillcap_8
X_4659_ VDD VDD VSS VSS clkload5/A _4659_/D _4659_/Q gf180mcu_as_sc_mcu7t3v3__dfxtp_2
XTAP_TAPCELL_ROW_192_1898 VDD VSS gf180mcu_as_sc_mcu7t3v3__tap_2
XTAP_TAPCELL_ROW_192_1887 VDD VSS gf180mcu_as_sc_mcu7t3v3__tap_2
XFILLER_162_398 VDD VDD VSS VSS gf180mcu_as_sc_mcu7t3v3__fillcap_8
XFILLER_163_899 VDD VDD VSS VSS gf180mcu_as_sc_mcu7t3v3__fillcap_8
XFILLER_157_1192 VDD VDD VSS VSS gf180mcu_as_sc_mcu7t3v3__fill_1
XPHY_EDGE_ROW_124_3_Right_165 VDD VSS gf180mcu_as_sc_mcu7t3v3__tap_2
XFILLER_190_37 VDD VDD VSS VSS gf180mcu_as_sc_mcu7t3v3__fill_2
XFILLER_123_53 VDD VDD VSS VSS gf180mcu_as_sc_mcu7t3v3__fillcap_4
XFILLER_16_62 VDD VDD VSS VSS gf180mcu_as_sc_mcu7t3v3__fillcap_16
XFILLER_186_947 VDD VDD VSS VSS gf180mcu_as_sc_mcu7t3v3__fill_2
XFILLER_13_688 VDD VDD VSS VSS gf180mcu_as_sc_mcu7t3v3__fill_1
XFILLER_158_649 VDD VDD VSS VSS gf180mcu_as_sc_mcu7t3v3__fill_1
XFILLER_186_958 VDD VDD VSS VSS gf180mcu_as_sc_mcu7t3v3__fill_1
XFILLER_51_1311 VDD VDD VSS VSS gf180mcu_as_sc_mcu7t3v3__fill_2
XFILLER_9_648 VDD VDD VSS VSS gf180mcu_as_sc_mcu7t3v3__fill_2
XFILLER_154_811 VDD VDD VSS VSS gf180mcu_as_sc_mcu7t3v3__fill_2
XFILLER_172_107 VDD VDD VSS VSS gf180mcu_as_sc_mcu7t3v3__fillcap_16
XFILLER_153_310 VDD VDD VSS VSS gf180mcu_as_sc_mcu7t3v3__fillcap_4
XFILLER_5_810 VDD VDD VSS VSS gf180mcu_as_sc_mcu7t3v3__fillcap_4
XFILLER_154_877 VDD VDD VSS VSS gf180mcu_as_sc_mcu7t3v3__fillcap_16
XFILLER_5_854 VDD VDD VSS VSS gf180mcu_as_sc_mcu7t3v3__fill_1
XFILLER_10_1063 VDD VDD VSS VSS gf180mcu_as_sc_mcu7t3v3__fill_2
XFILLER_180_173 VDD VDD VSS VSS gf180mcu_as_sc_mcu7t3v3__fill_2
XTAP_TAPCELL_ROW_75_1_1028 VDD VSS gf180mcu_as_sc_mcu7t3v3__tap_2
XFILLER_171_1101 VDD VDD VSS VSS gf180mcu_as_sc_mcu7t3v3__fillcap_16
XFILLER_175_1281 VDD VDD VSS VSS gf180mcu_as_sc_mcu7t3v3__fillcap_4
XFILLER_164_71 VDD VDD VSS VSS gf180mcu_as_sc_mcu7t3v3__fill_1
XFILLER_171_1156 VDD VDD VSS VSS gf180mcu_as_sc_mcu7t3v3__fill_1
XFILLER_169_1030 VDD VDD VSS VSS gf180mcu_as_sc_mcu7t3v3__fillcap_16
XFILLER_169_1052 VDD VDD VSS VSS gf180mcu_as_sc_mcu7t3v3__fillcap_16
XFILLER_1_1242 VDD VDD VSS VSS gf180mcu_as_sc_mcu7t3v3__fill_2
XFILLER_169_1096 VDD VDD VSS VSS gf180mcu_as_sc_mcu7t3v3__fillcap_8
XFILLER_189_730 VDD VDD VSS VSS gf180mcu_as_sc_mcu7t3v3__fill_1
X_3961_ VDD VDD VSS VSS _3961_/A _3961_/B _3961_/C _3961_/D _3962_/C gf180mcu_as_sc_mcu7t3v3__ao22_2
X_2912_ VDD VDD VSS VSS _3037_/B _4228_/A _2912_/B _2912_/C gf180mcu_as_sc_mcu7t3v3__ao21_2
X_3892_ VDD VDD VSS VSS _3894_/C _3892_/C _3892_/B _3919_/A gf180mcu_as_sc_mcu7t3v3__aoi21_2
XFILLER_176_457 VDD VDD VSS VSS gf180mcu_as_sc_mcu7t3v3__fill_1
X_2843_ VDD VDD VSS VSS _2897_/B _4162_/A _2844_/D gf180mcu_as_sc_mcu7t3v3__or2_2
XTAP_TAPCELL_ROW_157_1237 VDD VSS gf180mcu_as_sc_mcu7t3v3__tap_2
XTAP_TAPCELL_ROW_157_1226 VDD VSS gf180mcu_as_sc_mcu7t3v3__tap_2
XFILLER_157_660 VDD VDD VSS VSS gf180mcu_as_sc_mcu7t3v3__fill_2
XFILLER_157_671 VDD VDD VSS VSS gf180mcu_as_sc_mcu7t3v3__fillcap_4
XFILLER_164_608 VDD VDD VSS VSS gf180mcu_as_sc_mcu7t3v3__fillcap_8
XFILLER_191_416 VDD VDD VSS VSS gf180mcu_as_sc_mcu7t3v3__fillcap_4
XFILLER_192_917 VDD VDD VSS VSS gf180mcu_as_sc_mcu7t3v3__fill_1
X_2774_ VDD VDD VSS VSS _4784_/Q _2810_/B _2902_/C _4100_/A _2776_/C gf180mcu_as_sc_mcu7t3v3__ao22_2
XTAP_TAPCELL_ROW_174_1551 VDD VSS gf180mcu_as_sc_mcu7t3v3__tap_2
XFILLER_191_438 VDD VDD VSS VSS gf180mcu_as_sc_mcu7t3v3__fillcap_16
X_4513_ VDD VDD VSS VSS _4804_/CLK _4513_/D _4513_/Q gf180mcu_as_sc_mcu7t3v3__dfxtp_2
XFILLER_160_847 VDD VDD VSS VSS gf180mcu_as_sc_mcu7t3v3__fill_1
XFILLER_171_162 VDD VDD VSS VSS gf180mcu_as_sc_mcu7t3v3__fillcap_8
X_4444_ VDD VDD VSS VSS _4447_/CLK _4444_/D _4444_/Q gf180mcu_as_sc_mcu7t3v3__dfxtp_2
Xfanout605 VDD VDD VSS VSS fanout605/A _2829_/B gf180mcu_as_sc_mcu7t3v3__buff_12
X_4375_ VDD VDD VSS VSS _4533_/CLK _4375_/D _4375_/Q gf180mcu_as_sc_mcu7t3v3__dfxtp_2
Xfanout616 VDD VDD VSS VSS _3965_/C _3953_/C gf180mcu_as_sc_mcu7t3v3__buff_12
Xfanout627 VDD VDD VSS VSS fanout627/A _2827_/B gf180mcu_as_sc_mcu7t3v3__buff_12
Xfanout638 VDD VDD VSS VSS fanout638/A _4207_/C gf180mcu_as_sc_mcu7t3v3__buff_12
X_3326_ VDD VDD VSS VSS _3330_/B _4345_/Q _3328_/S gf180mcu_as_sc_mcu7t3v3__nand2b_2
XFILLER_85_102 VDD VDD VSS VSS gf180mcu_as_sc_mcu7t3v3__fill_2
X_3257_ VDD VDD VSS VSS _3258_/D _3257_/B _3306_/A gf180mcu_as_sc_mcu7t3v3__nor2_2
XFILLER_187_1130 VDD VDD VSS VSS gf180mcu_as_sc_mcu7t3v3__fillcap_4
X_3188_ VDD VDD VSS VSS _4513_/D _3188_/A _3210_/B _3188_/C _3188_/D gf180mcu_as_sc_mcu7t3v3__aoi22_2
X_2208_ VDD VDD VSS VSS _3166_/A _4511_/Q gf180mcu_as_sc_mcu7t3v3__inv_2
XPHY_EDGE_ROW_64_1_Right_573 VDD VSS gf180mcu_as_sc_mcu7t3v3__tap_2
XFILLER_161_1325 VDD VDD VSS VSS gf180mcu_as_sc_mcu7t3v3__fillcap_4
XFILLER_168_925 VDD VDD VSS VSS gf180mcu_as_sc_mcu7t3v3__fillcap_16
XFILLER_10_647 VDD VDD VSS VSS gf180mcu_as_sc_mcu7t3v3__fill_2
XFILLER_154_107 VDD VDD VSS VSS gf180mcu_as_sc_mcu7t3v3__fillcap_16
XPHY_EDGE_ROW_134_1_Left_326 VDD VSS gf180mcu_as_sc_mcu7t3v3__tap_2
XFILLER_185_26 VDD VDD VSS VSS gf180mcu_as_sc_mcu7t3v3__fill_2
XFILLER_118_64 VDD VDD VSS VSS gf180mcu_as_sc_mcu7t3v3__fillcap_4
XFILLER_162_184 VDD VDD VSS VSS gf180mcu_as_sc_mcu7t3v3__fillcap_16
XFILLER_2_846 VDD VDD VSS VSS gf180mcu_as_sc_mcu7t3v3__fillcap_16
XTAP_TAPCELL_ROW_42_1_995 VDD VSS gf180mcu_as_sc_mcu7t3v3__tap_2
XFILLER_81_1326 VDD VDD VSS VSS gf180mcu_as_sc_mcu7t3v3__fill_2
XPHY_EDGE_ROW_125_3_Right_166 VDD VSS gf180mcu_as_sc_mcu7t3v3__tap_2
Xmesh_tile_1004 VDD VDD VSS VSS sw_out[32] gf180mcu_as_sc_mcu7t3v3__tiel_4
XTAP_TAPCELL_ROW_136_1_1089 VDD VSS gf180mcu_as_sc_mcu7t3v3__tap_2
XFILLER_27_72 VDD VDD VSS VSS gf180mcu_as_sc_mcu7t3v3__fill_1
XTAP_TAPCELL_ROW_94_3_2005 VDD VSS gf180mcu_as_sc_mcu7t3v3__tap_2
XPHY_EDGE_ROW_66_1_Left_258 VDD VSS gf180mcu_as_sc_mcu7t3v3__tap_2
XFILLER_158_457 VDD VDD VSS VSS gf180mcu_as_sc_mcu7t3v3__fillcap_4
XFILLER_186_777 VDD VDD VSS VSS gf180mcu_as_sc_mcu7t3v3__fill_2
XFILLER_9_445 VDD VDD VSS VSS gf180mcu_as_sc_mcu7t3v3__fill_1
XFILLER_142_1291 VDD VDD VSS VSS gf180mcu_as_sc_mcu7t3v3__fillcap_16
XFILLER_173_449 VDD VDD VSS VSS gf180mcu_as_sc_mcu7t3v3__fillcap_4
XFILLER_177_1332 VDD VDD VSS VSS gf180mcu_as_sc_mcu7t3v3__fillcap_4
XTAP_TAPCELL_ROW_152_1134 VDD VSS gf180mcu_as_sc_mcu7t3v3__tap_2
XTAP_TAPCELL_ROW_152_1123 VDD VSS gf180mcu_as_sc_mcu7t3v3__tap_2
XTAP_TAPCELL_ROW_152_1112 VDD VSS gf180mcu_as_sc_mcu7t3v3__tap_2
XFILLER_177_1354 VDD VDD VSS VSS gf180mcu_as_sc_mcu7t3v3__fill_1
XFILLER_4_10 VDD VDD VSS VSS gf180mcu_as_sc_mcu7t3v3__fillcap_4
X_2490_ VDD VDD VSS VSS _2492_/D _2490_/C _2490_/B _2490_/A gf180mcu_as_sc_mcu7t3v3__aoi21b_2
XFILLER_4_183 VDD VDD VSS VSS gf180mcu_as_sc_mcu7t3v3__fill_1
XFILLER_4_32 VDD VDD VSS VSS gf180mcu_as_sc_mcu7t3v3__fill_2
X_4160_ VDD VDD VSS VSS _4160_/A _4210_/B _4160_/C _4209_/A _4161_/D gf180mcu_as_sc_mcu7t3v3__ao22_2
XFILLER_67_102 VDD VDD VSS VSS gf180mcu_as_sc_mcu7t3v3__fill_2
X_3111_ VDD VDD VSS VSS _3120_/S _4499_/Q _4498_/Q _4498_/D gf180mcu_as_sc_mcu7t3v3__mux2_2
X_4091_ VDD VDD VSS VSS _4091_/B _4213_/A _4703_/D gf180mcu_as_sc_mcu7t3v3__and2_2
Xinput290 VDD VDD VSS VSS sw_in[3] _4034_/A gf180mcu_as_sc_mcu7t3v3__buff_12
X_3042_ VDD VDD VSS VSS _4278_/B _4766_/Q _4330_/C gf180mcu_as_sc_mcu7t3v3__and2_2
XTAP_TAPCELL_ROW_51_3_1962 VDD VSS gf180mcu_as_sc_mcu7t3v3__tap_2
X_3944_ VDD VDD VSS VSS _3944_/A _3955_/B _3944_/C _3944_/D _3945_/B gf180mcu_as_sc_mcu7t3v3__ao211_2
XFILLER_177_755 VDD VDD VSS VSS gf180mcu_as_sc_mcu7t3v3__fill_2
X_3875_ VDD VDD VSS VSS _3875_/B _4214_/D _3876_/C gf180mcu_as_sc_mcu7t3v3__and2_2
XFILLER_177_788 VDD VDD VSS VSS gf180mcu_as_sc_mcu7t3v3__fill_1
X_2826_ VDD VDD VSS VSS _4349_/Q _2826_/B _2995_/A _2920_/D _4349_/D gf180mcu_as_sc_mcu7t3v3__ao22_2
XFILLER_192_747 VDD VDD VSS VSS gf180mcu_as_sc_mcu7t3v3__fill_1
X_2757_ VDD VDD VSS VSS _4084_/A _2827_/B _2757_/C _2757_/D _2758_/D gf180mcu_as_sc_mcu7t3v3__ao211_2
XFILLER_155_18 VDD VDD VSS VSS gf180mcu_as_sc_mcu7t3v3__fill_2
X_2688_ VDD VDD VSS VSS _2879_/B _4025_/A _2689_/D gf180mcu_as_sc_mcu7t3v3__or2_2
X_4427_ VDD VDD VSS VSS _4533_/CLK _4427_/D _4427_/Q gf180mcu_as_sc_mcu7t3v3__dfxtp_2
XFILLER_48_27 VDD VDD VSS VSS gf180mcu_as_sc_mcu7t3v3__fillcap_8
Xfanout457 VDD VDD VSS VSS _3810_/S _3747_/S gf180mcu_as_sc_mcu7t3v3__buff_12
X_4358_ VDD VDD VSS VSS _4445_/CLK _4358_/D _4358_/Q gf180mcu_as_sc_mcu7t3v3__dfxtp_2
XFILLER_41_1321 VDD VDD VSS VSS gf180mcu_as_sc_mcu7t3v3__fill_2
Xfanout468 VDD VDD VSS VSS _2993_/B _2989_/B gf180mcu_as_sc_mcu7t3v3__buff_12
Xfanout479 VDD VDD VSS VSS _2653_/Y _2920_/D gf180mcu_as_sc_mcu7t3v3__buff_12
X_4289_ VDD VDD VSS VSS _4289_/B _4770_/Q _4290_/B gf180mcu_as_sc_mcu7t3v3__xnor2_2
X_3309_ VDD VDD VSS VSS _3333_/B _4465_/Q _3316_/D gf180mcu_as_sc_mcu7t3v3__and2_2
XTAP_TAPCELL_ROW_187_1797 VDD VSS gf180mcu_as_sc_mcu7t3v3__tap_2
Xmesh_tile_872 VDD VDD VSS VSS north_out[8] gf180mcu_as_sc_mcu7t3v3__tiel_4
Xmesh_tile_861 VDD VDD VSS VSS ne_out[33] gf180mcu_as_sc_mcu7t3v3__tiel_4
Xmesh_tile_850 VDD VDD VSS VSS ne_out[22] gf180mcu_as_sc_mcu7t3v3__tiel_4
Xmesh_tile_894 VDD VDD VSS VSS north_out[30] gf180mcu_as_sc_mcu7t3v3__tiel_4
Xmesh_tile_883 VDD VDD VSS VSS north_out[19] gf180mcu_as_sc_mcu7t3v3__tiel_4
XFILLER_161_6 VDD VDD VSS VSS gf180mcu_as_sc_mcu7t3v3__fillcap_16
XFILLER_64_37 VDD VDD VSS VSS gf180mcu_as_sc_mcu7t3v3__fillcap_16
XPHY_EDGE_ROW_65_1_Right_574 VDD VSS gf180mcu_as_sc_mcu7t3v3__tap_2
XFILLER_187_508 VDD VDD VSS VSS gf180mcu_as_sc_mcu7t3v3__fillcap_16
XFILLER_161_1100 VDD VDD VSS VSS gf180mcu_as_sc_mcu7t3v3__fillcap_16
XFILLER_11_912 VDD VDD VSS VSS gf180mcu_as_sc_mcu7t3v3__fillcap_4
XFILLER_126_1264 VDD VDD VSS VSS gf180mcu_as_sc_mcu7t3v3__fill_2
XTAP_TAPCELL_ROW_13_929 VDD VSS gf180mcu_as_sc_mcu7t3v3__tap_2
XFILLER_161_1166 VDD VDD VSS VSS gf180mcu_as_sc_mcu7t3v3__fillcap_16
XFILLER_155_438 VDD VDD VSS VSS gf180mcu_as_sc_mcu7t3v3__fillcap_16
XFILLER_171_909 VDD VDD VSS VSS gf180mcu_as_sc_mcu7t3v3__fill_1
XFILLER_183_758 VDD VDD VSS VSS gf180mcu_as_sc_mcu7t3v3__fillcap_8
XFILLER_11_1180 VDD VDD VSS VSS gf180mcu_as_sc_mcu7t3v3__fill_1
XFILLER_163_482 VDD VDD VSS VSS gf180mcu_as_sc_mcu7t3v3__fillcap_8
XFILLER_1_120 VDD VDD VSS VSS gf180mcu_as_sc_mcu7t3v3__fillcap_8
XFILLER_1_142 VDD VDD VSS VSS gf180mcu_as_sc_mcu7t3v3__fillcap_8
XFILLER_46_1287 VDD VDD VSS VSS gf180mcu_as_sc_mcu7t3v3__fill_2
XPHY_EDGE_ROW_126_3_Right_167 VDD VSS gf180mcu_as_sc_mcu7t3v3__tap_2
XFILLER_133_1268 VDD VDD VSS VSS gf180mcu_as_sc_mcu7t3v3__fillcap_8
XFILLER_161_72 VDD VDD VSS VSS gf180mcu_as_sc_mcu7t3v3__fillcap_4
XFILLER_54_92 VDD VDD VSS VSS gf180mcu_as_sc_mcu7t3v3__fill_1
XFILLER_158_221 VDD VDD VSS VSS gf180mcu_as_sc_mcu7t3v3__fillcap_16
XFILLER_18_1334 VDD VDD VSS VSS gf180mcu_as_sc_mcu7t3v3__fillcap_16
XFILLER_92_1285 VDD VDD VSS VSS gf180mcu_as_sc_mcu7t3v3__fill_2
XFILLER_105_1326 VDD VDD VSS VSS gf180mcu_as_sc_mcu7t3v3__fillcap_4
XFILLER_173_202 VDD VDD VSS VSS gf180mcu_as_sc_mcu7t3v3__fill_1
X_3660_ VDD VDD VSS VSS _4023_/D _3876_/B _3660_/C _3876_/D _3662_/C gf180mcu_as_sc_mcu7t3v3__ao211_2
XFILLER_173_235 VDD VDD VSS VSS gf180mcu_as_sc_mcu7t3v3__fillcap_16
Xclkload12 VDD VDD VSS VSS _4795_/CLK clkload12/Y gf180mcu_as_sc_mcu7t3v3__clkbuff_4
Xclkload23 VDD VDD VSS VSS clkload23/Y _4606_/CLK gf180mcu_as_sc_mcu7t3v3__inv_4
X_3591_ VDD VDD VSS VSS _4653_/Q _4649_/Q _3593_/B gf180mcu_as_sc_mcu7t3v3__and2_2
X_2611_ VDD VDD VSS VSS _2662_/A _2632_/D _2654_/A gf180mcu_as_sc_mcu7t3v3__nand2_2
XFILLER_161_419 VDD VDD VSS VSS gf180mcu_as_sc_mcu7t3v3__fill_1
XFILLER_173_279 VDD VDD VSS VSS gf180mcu_as_sc_mcu7t3v3__fill_1
X_2542_ VDD VDD VSS VSS _4590_/Q _3471_/B _3465_/A _4450_/Q _2545_/C gf180mcu_as_sc_mcu7t3v3__ao22_2
XFILLER_177_1173 VDD VDD VSS VSS gf180mcu_as_sc_mcu7t3v3__fillcap_4
XFILLER_5_492 VDD VDD VSS VSS gf180mcu_as_sc_mcu7t3v3__fillcap_4
X_4212_ VDD VDD VSS VSS _4212_/S _4212_/B _4212_/A _4213_/B gf180mcu_as_sc_mcu7t3v3__mux2_2
X_2473_ VDD VDD VSS VSS _2474_/C _2473_/B _2489_/A gf180mcu_as_sc_mcu7t3v3__nor2_2
XTAP_TAPCELL_ROW_169_1450 VDD VSS gf180mcu_as_sc_mcu7t3v3__tap_2
X_4143_ VDD VDD VSS VSS _4143_/A _4143_/B _4143_/C _4151_/A _4144_/D gf180mcu_as_sc_mcu7t3v3__ao22_2
XTAP_TAPCELL_ROW_169_1461 VDD VSS gf180mcu_as_sc_mcu7t3v3__tap_2
X_4074_ VDD VDD VSS VSS _4163_/S _4074_/B _4074_/A _4075_/B gf180mcu_as_sc_mcu7t3v3__mux2_2
X_3025_ VDD VDD VSS VSS _3025_/A _3034_/B _4276_/A _4435_/Q _4435_/D gf180mcu_as_sc_mcu7t3v3__ao22_2
XFILLER_180_1008 VDD VDD VSS VSS gf180mcu_as_sc_mcu7t3v3__fillcap_4
XTAP_TAPCELL_ROW_41_1_994 VDD VSS gf180mcu_as_sc_mcu7t3v3__tap_2
XFILLER_11_219 VDD VDD VSS VSS gf180mcu_as_sc_mcu7t3v3__fill_2
XFILLER_177_541 VDD VDD VSS VSS gf180mcu_as_sc_mcu7t3v3__fillcap_8
X_3927_ VDD VDD VSS VSS _4800_/Q _3927_/B _3927_/C _3927_/D _3931_/A gf180mcu_as_sc_mcu7t3v3__ao211_2
Xclkload6 VDD VDD VSS VSS clkload6/Y clkload6/A gf180mcu_as_sc_mcu7t3v3__inv_6
X_3858_ VDD VDD VSS VSS _4199_/A _3867_/B _3858_/C _3867_/D _3861_/B gf180mcu_as_sc_mcu7t3v3__ao211_2
X_4760__1012 VDD VDD VSS VSS _4760_/D gf180mcu_as_sc_mcu7t3v3__tiel_4
X_3789_ VDD VDD VSS VSS _3791_/C _4137_/A _3881_/C _3789_/C gf180mcu_as_sc_mcu7t3v3__ao21_2
X_2809_ VDD VDD VSS VSS _2903_/B _4137_/A _2813_/C gf180mcu_as_sc_mcu7t3v3__and2_2
XFILLER_164_279 VDD VDD VSS VSS gf180mcu_as_sc_mcu7t3v3__fillcap_8
XFILLER_192_577 VDD VDD VSS VSS gf180mcu_as_sc_mcu7t3v3__fill_1
XFILLER_192_599 VDD VDD VSS VSS gf180mcu_as_sc_mcu7t3v3__fillcap_4
XFILLER_3_418 VDD VDD VSS VSS gf180mcu_as_sc_mcu7t3v3__fill_2
XTAP_TAPCELL_ROW_189_1837 VDD VSS gf180mcu_as_sc_mcu7t3v3__tap_2
XFILLER_182_49 VDD VDD VSS VSS gf180mcu_as_sc_mcu7t3v3__fill_1
XFILLER_115_65 VDD VDD VSS VSS gf180mcu_as_sc_mcu7t3v3__fillcap_4
XFILLER_189_1033 VDD VDD VSS VSS gf180mcu_as_sc_mcu7t3v3__fillcap_4
XFILLER_131_86 VDD VDD VSS VSS gf180mcu_as_sc_mcu7t3v3__fillcap_16
XFILLER_163_1217 VDD VDD VSS VSS gf180mcu_as_sc_mcu7t3v3__fillcap_4
XPHY_EDGE_ROW_66_1_Right_575 VDD VSS gf180mcu_as_sc_mcu7t3v3__tap_2
XFILLER_24_73 VDD VDD VSS VSS gf180mcu_as_sc_mcu7t3v3__fill_2
XFILLER_183_500 VDD VDD VSS VSS gf180mcu_as_sc_mcu7t3v3__fillcap_4
XFILLER_7_702 VDD VDD VSS VSS gf180mcu_as_sc_mcu7t3v3__fill_1
XFILLER_52_1291 VDD VDD VSS VSS gf180mcu_as_sc_mcu7t3v3__fillcap_4
XFILLER_13_1264 VDD VDD VSS VSS gf180mcu_as_sc_mcu7t3v3__fill_1
XFILLER_152_920 VDD VDD VSS VSS gf180mcu_as_sc_mcu7t3v3__fillcap_16
XFILLER_40_61 VDD VDD VSS VSS gf180mcu_as_sc_mcu7t3v3__fillcap_4
XFILLER_100_1256 VDD VDD VSS VSS gf180mcu_as_sc_mcu7t3v3__fillcap_8
XTAP_TAPCELL_ROW_89_3_2000 VDD VSS gf180mcu_as_sc_mcu7t3v3__tap_2
XTAP_TAPCELL_ROW_103_3_2014 VDD VSS gf180mcu_as_sc_mcu7t3v3__tap_2
XFILLER_3_952 VDD VDD VSS VSS gf180mcu_as_sc_mcu7t3v3__fill_1
XPHY_EDGE_ROW_127_3_Right_168 VDD VSS gf180mcu_as_sc_mcu7t3v3__tap_2
XFILLER_1_88 VDD VDD VSS VSS gf180mcu_as_sc_mcu7t3v3__fillcap_4
XFILLER_179_839 VDD VDD VSS VSS gf180mcu_as_sc_mcu7t3v3__fill_1
X_4830_ VDD VDD VSS VSS _4830_/CLK _4830_/D _4830_/Q gf180mcu_as_sc_mcu7t3v3__dfxtp_2
XTAP_TAPCELL_ROW_160_1288 VDD VSS gf180mcu_as_sc_mcu7t3v3__tap_2
XTAP_TAPCELL_ROW_160_1277 VDD VSS gf180mcu_as_sc_mcu7t3v3__tap_2
XFILLER_109_1270 VDD VDD VSS VSS gf180mcu_as_sc_mcu7t3v3__fill_1
X_4761_ VDD VDD VSS VSS clkload3/A _4761_/D _4761_/Q gf180mcu_as_sc_mcu7t3v3__dfxtp_2
XFILLER_174_522 VDD VDD VSS VSS gf180mcu_as_sc_mcu7t3v3__fill_2
X_4692_ VDD VDD VSS VSS _4692_/CLK _4692_/D _4692_/Q gf180mcu_as_sc_mcu7t3v3__dfxtp_2
X_3712_ VDD VDD VSS VSS _4067_/A _3855_/B _3712_/C _4664_/D _4138_/C gf180mcu_as_sc_mcu7t3v3__aoi211_2
X_3643_ VDD VDD VSS VSS _3643_/D _3880_/A _3643_/B _3643_/C _3647_/C gf180mcu_as_sc_mcu7t3v3__ao31_2
XFILLER_155_780 VDD VDD VSS VSS gf180mcu_as_sc_mcu7t3v3__fill_1
X_3574_ VDD VDD VSS VSS _3582_/B _3574_/B _3574_/C _3574_/D _3603_/A gf180mcu_as_sc_mcu7t3v3__ao211_2
X_2525_ VDD VDD VSS VSS _2529_/C _2552_/A _4580_/Q gf180mcu_as_sc_mcu7t3v3__nor2_2
X_2456_ VDD VDD VSS VSS _4815_/Q _2487_/S _2457_/D gf180mcu_as_sc_mcu7t3v3__and2_2
XPHY_EDGE_ROW_89_3_Right_130 VDD VSS gf180mcu_as_sc_mcu7t3v3__tap_2
XFILLER_9_1354 VDD VDD VSS VSS gf180mcu_as_sc_mcu7t3v3__fill_1
X_4126_ VDD VDD VSS VSS _4126_/A _4236_/B _4126_/C _4225_/D _4128_/C gf180mcu_as_sc_mcu7t3v3__ao22_2
X_2387_ VDD VDD VSS VSS _2425_/B _4482_/Q _4546_/Q _2389_/B gf180mcu_as_sc_mcu7t3v3__mux2_2
XTAP_TAPCELL_ROW_184_1745 VDD VSS gf180mcu_as_sc_mcu7t3v3__tap_2
XTAP_TAPCELL_ROW_184_1734 VDD VSS gf180mcu_as_sc_mcu7t3v3__tap_2
XTAP_TAPCELL_ROW_38_3_1949 VDD VSS gf180mcu_as_sc_mcu7t3v3__tap_2
XPHY_EDGE_ROW_143_1_Left_335 VDD VSS gf180mcu_as_sc_mcu7t3v3__tap_2
X_4057_ VDD VDD VSS VSS _4058_/B _4057_/A _4154_/S _4057_/C gf180mcu_as_sc_mcu7t3v3__ao21_2
X_3008_ VDD VDD VSS VSS _3008_/Y _3019_/B _4122_/D gf180mcu_as_sc_mcu7t3v3__nor2_2
XFILLER_169_349 VDD VDD VSS VSS gf180mcu_as_sc_mcu7t3v3__fill_1
XFILLER_124_6 VDD VDD VSS VSS gf180mcu_as_sc_mcu7t3v3__fill_2
Xclkbuf_2_2_0_clk_regs VDD VDD VSS VSS clkbuf_0_clk_regs/Y clkbuf_2_2_0_clk_regs/Y
+ gf180mcu_as_sc_mcu7t3v3__clkbuff_12
XFILLER_0_911 VDD VDD VSS VSS gf180mcu_as_sc_mcu7t3v3__fill_2
XFILLER_126_64 VDD VDD VSS VSS gf180mcu_as_sc_mcu7t3v3__fillcap_16
XFILLER_161_772 VDD VDD VSS VSS gf180mcu_as_sc_mcu7t3v3__fillcap_4
XFILLER_161_783 VDD VDD VSS VSS gf180mcu_as_sc_mcu7t3v3__fillcap_8
Xoutput380 VDD VDD VSS VSS _4669_/Q south_out[12] gf180mcu_as_sc_mcu7t3v3__buff_12
XPHY_EDGE_ROW_14_3_Left_386 VDD VSS gf180mcu_as_sc_mcu7t3v3__tap_2
XFILLER_156_1087 VDD VDD VSS VSS gf180mcu_as_sc_mcu7t3v3__fillcap_16
Xoutput391 VDD VDD VSS VSS _4679_/Q south_out[22] gf180mcu_as_sc_mcu7t3v3__buff_12
XPHY_EDGE_ROW_75_1_Left_267 VDD VSS gf180mcu_as_sc_mcu7t3v3__tap_2
XFILLER_142_96 VDD VDD VSS VSS gf180mcu_as_sc_mcu7t3v3__fillcap_8
XFILLER_167_1150 VDD VDD VSS VSS gf180mcu_as_sc_mcu7t3v3__fill_2
XFILLER_163_1025 VDD VDD VSS VSS gf180mcu_as_sc_mcu7t3v3__fillcap_8
XFILLER_35_72 VDD VDD VSS VSS gf180mcu_as_sc_mcu7t3v3__fillcap_8
XPHY_EDGE_ROW_67_1_Right_576 VDD VSS gf180mcu_as_sc_mcu7t3v3__tap_2
XFILLER_156_511 VDD VDD VSS VSS gf180mcu_as_sc_mcu7t3v3__fill_1
XFILLER_15_1326 VDD VDD VSS VSS gf180mcu_as_sc_mcu7t3v3__fill_2
XFILLER_156_522 VDD VDD VSS VSS gf180mcu_as_sc_mcu7t3v3__fill_2
XFILLER_156_566 VDD VDD VSS VSS gf180mcu_as_sc_mcu7t3v3__fillcap_16
XFILLER_167_82 VDD VDD VSS VSS gf180mcu_as_sc_mcu7t3v3__fill_1
XFILLER_171_514 VDD VDD VSS VSS gf180mcu_as_sc_mcu7t3v3__fill_2
XFILLER_183_352 VDD VDD VSS VSS gf180mcu_as_sc_mcu7t3v3__fillcap_8
XFILLER_13_1083 VDD VDD VSS VSS gf180mcu_as_sc_mcu7t3v3__fill_1
XFILLER_152_761 VDD VDD VSS VSS gf180mcu_as_sc_mcu7t3v3__fill_1
XFILLER_174_1154 VDD VDD VSS VSS gf180mcu_as_sc_mcu7t3v3__fill_1
X_3290_ VDD VDD VSS VSS _3346_/A _3290_/B _3290_/C _3292_/B _3290_/D gf180mcu_as_sc_mcu7t3v3__aoi31_2
X_2310_ VDD VDD VSS VSS _2310_/B _3124_/S _4811_/D gf180mcu_as_sc_mcu7t3v3__and2_2
XFILLER_174_1187 VDD VDD VSS VSS gf180mcu_as_sc_mcu7t3v3__fillcap_16
X_2241_ VDD VDD VSS VSS _3414_/A _3608_/A _3609_/B gf180mcu_as_sc_mcu7t3v3__nand2_2
XTAP_TAPCELL_ROW_40_1_993 VDD VSS gf180mcu_as_sc_mcu7t3v3__tap_2
XTAP_TAPCELL_ROW_1_708 VDD VSS gf180mcu_as_sc_mcu7t3v3__tap_2
XTAP_TAPCELL_ROW_1_719 VDD VSS gf180mcu_as_sc_mcu7t3v3__tap_2
XTAP_TAPCELL_ROW_162_1328 VDD VSS gf180mcu_as_sc_mcu7t3v3__tap_2
XTAP_TAPCELL_ROW_162_1317 VDD VSS gf180mcu_as_sc_mcu7t3v3__tap_2
XPHY_EDGE_ROW_128_3_Right_169 VDD VSS gf180mcu_as_sc_mcu7t3v3__tap_2
XFILLER_98_1291 VDD VDD VSS VSS gf180mcu_as_sc_mcu7t3v3__fillcap_8
XFILLER_146_1256 VDD VDD VSS VSS gf180mcu_as_sc_mcu7t3v3__fillcap_4
XFILLER_178_102 VDD VDD VSS VSS gf180mcu_as_sc_mcu7t3v3__fill_2
XFILLER_185_1294 VDD VDD VSS VSS gf180mcu_as_sc_mcu7t3v3__fillcap_16
X_4813_ VDD VDD VSS VSS _4830_/CLK _4813_/D _4813_/Q gf180mcu_as_sc_mcu7t3v3__dfxtp_2
X_4744_ VDD VDD VSS VSS _4751_/CLK _4744_/D _4744_/Q gf180mcu_as_sc_mcu7t3v3__dfxtp_2
XPHY_EDGE_ROW_1_Left_194 VDD VSS gf180mcu_as_sc_mcu7t3v3__tap_2
XFILLER_175_842 VDD VDD VSS VSS gf180mcu_as_sc_mcu7t3v3__fill_2
XFILLER_179_1032 VDD VDD VSS VSS gf180mcu_as_sc_mcu7t3v3__fillcap_8
X_4675_ VDD VDD VSS VSS clkload4/A _4675_/D _4675_/Q gf180mcu_as_sc_mcu7t3v3__dfxtp_2
XFILLER_179_1065 VDD VDD VSS VSS gf180mcu_as_sc_mcu7t3v3__fillcap_16
X_3626_ VDD VDD VSS VSS _3960_/C _3635_/A _3634_/A gf180mcu_as_sc_mcu7t3v3__and2_2
XFILLER_162_569 VDD VDD VSS VSS gf180mcu_as_sc_mcu7t3v3__fill_1
XFILLER_190_889 VDD VDD VSS VSS gf180mcu_as_sc_mcu7t3v3__fillcap_4
X_3557_ VDD VDD VSS VSS _3580_/C _3582_/B gf180mcu_as_sc_mcu7t3v3__inv_2
XTAP_TAPCELL_ROW_93_1_1046 VDD VSS gf180mcu_as_sc_mcu7t3v3__tap_2
X_2508_ VDD VDD VSS VSS _4808_/Q _4640_/Q _2566_/A gf180mcu_as_sc_mcu7t3v3__or2_2
XFILLER_192_1276 VDD VDD VSS VSS gf180mcu_as_sc_mcu7t3v3__fillcap_16
Xinput108 VDD VDD VSS VSS ne_in[35] _3937_/A gf180mcu_as_sc_mcu7t3v3__buff_12
X_3488_ VDD VDD VSS VSS _4458_/Q _3504_/C _3502_/C _4596_/Q _3489_/C gf180mcu_as_sc_mcu7t3v3__ao22_2
XFILLER_9_1140 VDD VDD VSS VSS gf180mcu_as_sc_mcu7t3v3__fill_2
Xinput119 VDD VDD VSS VSS north_in[12] _4102_/D gf180mcu_as_sc_mcu7t3v3__buff_12
X_2439_ VDD VDD VSS VSS _2487_/S _4813_/Q _4822_/Q _2442_/A gf180mcu_as_sc_mcu7t3v3__mux2_2
XFILLER_5_1048 VDD VDD VSS VSS gf180mcu_as_sc_mcu7t3v3__fill_2
X_4109_ VDD VDD VSS VSS _4785_/Q _4134_/B _4225_/D _4109_/D _4111_/A gf180mcu_as_sc_mcu7t3v3__ao22_2
X_4727__1044 VDD VDD VSS VSS _4727_/D gf180mcu_as_sc_mcu7t3v3__tiel_4
XFILLER_112_55 VDD VDD VSS VSS gf180mcu_as_sc_mcu7t3v3__fill_1
XFILLER_13_826 VDD VDD VSS VSS gf180mcu_as_sc_mcu7t3v3__fill_2
XFILLER_188_37 VDD VDD VSS VSS gf180mcu_as_sc_mcu7t3v3__fillcap_8
XFILLER_166_853 VDD VDD VSS VSS gf180mcu_as_sc_mcu7t3v3__fillcap_8
XANTENNA_70 VDD VDD VSS VSS _4033_/A gf180mcu_as_sc_mcu7t3v3__diode_2
XFILLER_165_352 VDD VDD VSS VSS gf180mcu_as_sc_mcu7t3v3__fillcap_16
XFILLER_166_897 VDD VDD VSS VSS gf180mcu_as_sc_mcu7t3v3__fillcap_4
XFILLER_180_333 VDD VDD VSS VSS gf180mcu_as_sc_mcu7t3v3__fillcap_8
XFILLER_4_535 VDD VDD VSS VSS gf180mcu_as_sc_mcu7t3v3__fill_2
XTAP_TAPCELL_ROW_8_852 VDD VSS gf180mcu_as_sc_mcu7t3v3__tap_2
XTAP_TAPCELL_ROW_8_841 VDD VSS gf180mcu_as_sc_mcu7t3v3__tap_2
XFILLER_97_67 VDD VDD VSS VSS gf180mcu_as_sc_mcu7t3v3__fill_2
XFILLER_153_62 VDD VDD VSS VSS gf180mcu_as_sc_mcu7t3v3__fillcap_8
XFILLER_169_1212 VDD VDD VSS VSS gf180mcu_as_sc_mcu7t3v3__fill_1
XFILLER_169_1278 VDD VDD VSS VSS gf180mcu_as_sc_mcu7t3v3__fillcap_16
XFILLER_46_82 VDD VDD VSS VSS gf180mcu_as_sc_mcu7t3v3__fill_2
XPHY_EDGE_ROW_68_1_Right_577 VDD VSS gf180mcu_as_sc_mcu7t3v3__tap_2
XFILLER_157_842 VDD VDD VSS VSS gf180mcu_as_sc_mcu7t3v3__fillcap_8
XFILLER_175_138 VDD VDD VSS VSS gf180mcu_as_sc_mcu7t3v3__fill_2
X_2790_ VDD VDD VSS VSS _4345_/Q _2826_/B _3022_/A _2808_/D _4345_/D gf180mcu_as_sc_mcu7t3v3__ao22_2
XFILLER_156_341 VDD VDD VSS VSS gf180mcu_as_sc_mcu7t3v3__fillcap_16
XFILLER_172_801 VDD VDD VSS VSS gf180mcu_as_sc_mcu7t3v3__fillcap_4
XFILLER_8_874 VDD VDD VSS VSS gf180mcu_as_sc_mcu7t3v3__fill_1
XFILLER_176_1227 VDD VDD VSS VSS gf180mcu_as_sc_mcu7t3v3__fillcap_16
XFILLER_7_87 VDD VDD VSS VSS gf180mcu_as_sc_mcu7t3v3__fill_2
X_4460_ VDD VDD VSS VSS _4602_/CLK _4460_/D _4460_/Q gf180mcu_as_sc_mcu7t3v3__dfxtp_2
XTAP_TAPCELL_ROW_155_1187 VDD VSS gf180mcu_as_sc_mcu7t3v3__tap_2
X_4391_ VDD VDD VSS VSS clkload8/A _4391_/D _4391_/Q gf180mcu_as_sc_mcu7t3v3__dfxtp_2
X_3411_ VDD VDD VSS VSS _4542_/Q _3411_/B _3411_/C _4511_/Q _3412_/C gf180mcu_as_sc_mcu7t3v3__ao22_2
XTAP_TAPCELL_ROW_155_1198 VDD VSS gf180mcu_as_sc_mcu7t3v3__tap_2
X_3342_ VDD VDD VSS VSS _3346_/B _4347_/Q _3344_/S gf180mcu_as_sc_mcu7t3v3__nand2b_2
XFILLER_152_580 VDD VDD VSS VSS gf180mcu_as_sc_mcu7t3v3__fillcap_4
X_3273_ VDD VDD VSS VSS _3274_/D _3273_/B _3314_/A gf180mcu_as_sc_mcu7t3v3__nor2_2
XFILLER_152_1260 VDD VDD VSS VSS gf180mcu_as_sc_mcu7t3v3__fillcap_8
X_2224_ VDD VDD VSS VSS _4208_/D _3869_/D gf180mcu_as_sc_mcu7t3v3__inv_2
XFILLER_113_1288 VDD VDD VSS VSS gf180mcu_as_sc_mcu7t3v3__fillcap_8
XTAP_TAPCELL_ROW_179_1655 VDD VSS gf180mcu_as_sc_mcu7t3v3__tap_2
XTAP_TAPCELL_ROW_179_1644 VDD VSS gf180mcu_as_sc_mcu7t3v3__tap_2
XFILLER_10_807 VDD VDD VSS VSS gf180mcu_as_sc_mcu7t3v3__fill_1
X_2988_ VDD VDD VSS VSS _2988_/A _2989_/B _2989_/C _4400_/Q _4400_/D gf180mcu_as_sc_mcu7t3v3__ao22_2
XFILLER_159_190 VDD VDD VSS VSS gf180mcu_as_sc_mcu7t3v3__fillcap_4
XFILLER_33_1256 VDD VDD VSS VSS gf180mcu_as_sc_mcu7t3v3__fillcap_16
X_4727_ VDD VDD VSS VSS _4727_/CLK _4727_/D _4727_/Q gf180mcu_as_sc_mcu7t3v3__dfxtp_2
X_4658_ VDD VDD VSS VSS clkload5/A _4658_/D _4658_/Q gf180mcu_as_sc_mcu7t3v3__dfxtp_2
XTAP_TAPCELL_ROW_192_1899 VDD VSS gf180mcu_as_sc_mcu7t3v3__tap_2
XTAP_TAPCELL_ROW_192_1888 VDD VSS gf180mcu_as_sc_mcu7t3v3__tap_2
XFILLER_190_653 VDD VDD VSS VSS gf180mcu_as_sc_mcu7t3v3__fillcap_8
Xinput90 VDD VDD VSS VSS ne_in[19] _4160_/A gf180mcu_as_sc_mcu7t3v3__buff_12
X_3609_ VDD VDD VSS VSS _3609_/B _4649_/Q _3610_/D gf180mcu_as_sc_mcu7t3v3__and2_2
X_4589_ VDD VDD VSS VSS _4829_/CLK _4589_/D _4589_/Q gf180mcu_as_sc_mcu7t3v3__dfxtp_2
XFILLER_192_1051 VDD VDD VSS VSS gf180mcu_as_sc_mcu7t3v3__fill_2
Xmax_cap593 VDD VDD VSS VSS fanout592/Y _4235_/B gf180mcu_as_sc_mcu7t3v3__clkbuff_12
XFILLER_192_1095 VDD VDD VSS VSS gf180mcu_as_sc_mcu7t3v3__fillcap_4
Xsram2048.u_bank1_821 VDD VDD VSS VSS sram2048.u_bank1/WEN[0] gf180mcu_as_sc_mcu7t3v3__tiel_4
XPHY_EDGE_ROW_11_Right_11 VDD VSS gf180mcu_as_sc_mcu7t3v3__tap_2
XFILLER_13_645 VDD VDD VSS VSS gf180mcu_as_sc_mcu7t3v3__fill_1
XFILLER_164_1197 VDD VDD VSS VSS gf180mcu_as_sc_mcu7t3v3__fillcap_16
XFILLER_12_188 VDD VDD VSS VSS gf180mcu_as_sc_mcu7t3v3__fillcap_8
XFILLER_148_51 VDD VDD VSS VSS gf180mcu_as_sc_mcu7t3v3__fillcap_4
XFILLER_32_95 VDD VDD VSS VSS gf180mcu_as_sc_mcu7t3v3__fillcap_8
XFILLER_153_344 VDD VDD VSS VSS gf180mcu_as_sc_mcu7t3v3__fillcap_4
XFILLER_165_182 VDD VDD VSS VSS gf180mcu_as_sc_mcu7t3v3__fill_1
XFILLER_164_61 VDD VDD VSS VSS gf180mcu_as_sc_mcu7t3v3__fillcap_8
XFILLER_180_185 VDD VDD VSS VSS gf180mcu_as_sc_mcu7t3v3__fillcap_4
XFILLER_4_387 VDD VDD VSS VSS gf180mcu_as_sc_mcu7t3v3__fill_2
XFILLER_136_1288 VDD VDD VSS VSS gf180mcu_as_sc_mcu7t3v3__fill_1
X_3960_ VDD VDD VSS VSS _3960_/A _3960_/B _3960_/C _3960_/D _3962_/B gf180mcu_as_sc_mcu7t3v3__ao22_2
XFILLER_182_1253 VDD VDD VSS VSS gf180mcu_as_sc_mcu7t3v3__fillcap_8
XFILLER_189_764 VDD VDD VSS VSS gf180mcu_as_sc_mcu7t3v3__fillcap_4
XFILLER_1_1287 VDD VDD VSS VSS gf180mcu_as_sc_mcu7t3v3__fill_2
X_2911_ VDD VDD VSS VSS _4230_/A _2919_/B _2911_/C _2911_/D _2912_/C gf180mcu_as_sc_mcu7t3v3__ao211_2
XFILLER_176_414 VDD VDD VSS VSS gf180mcu_as_sc_mcu7t3v3__fill_1
XFILLER_188_263 VDD VDD VSS VSS gf180mcu_as_sc_mcu7t3v3__fill_2
X_3891_ VDD VDD VSS VSS _3892_/B _4226_/A _3926_/B _3891_/C _3926_/D gf180mcu_as_sc_mcu7t3v3__aoi22_2
XPHY_EDGE_ROW_39_3_Left_411 VDD VSS gf180mcu_as_sc_mcu7t3v3__tap_2
X_2842_ VDD VDD VSS VSS _4161_/A _2896_/B _2842_/C _2896_/D _2844_/C gf180mcu_as_sc_mcu7t3v3__ao211_2
XTAP_TAPCELL_ROW_157_1238 VDD VSS gf180mcu_as_sc_mcu7t3v3__tap_2
XTAP_TAPCELL_ROW_157_1227 VDD VSS gf180mcu_as_sc_mcu7t3v3__tap_2
XPHY_EDGE_ROW_69_1_Right_578 VDD VSS gf180mcu_as_sc_mcu7t3v3__tap_2
X_2773_ VDD VDD VSS VSS _2905_/B _2773_/A _2780_/C gf180mcu_as_sc_mcu7t3v3__and2_2
XTAP_TAPCELL_ROW_174_1552 VDD VSS gf180mcu_as_sc_mcu7t3v3__tap_2
XFILLER_176_1002 VDD VDD VSS VSS gf180mcu_as_sc_mcu7t3v3__fillcap_8
X_4512_ VDD VDD VSS VSS _4804_/CLK _4512_/D _4512_/Q gf180mcu_as_sc_mcu7t3v3__dfxtp_2
XFILLER_156_193 VDD VDD VSS VSS gf180mcu_as_sc_mcu7t3v3__fillcap_16
XFILLER_172_664 VDD VDD VSS VSS gf180mcu_as_sc_mcu7t3v3__fill_1
XTAP_TAPCELL_ROW_10_890 VDD VSS gf180mcu_as_sc_mcu7t3v3__tap_2
XFILLER_160_815 VDD VDD VSS VSS gf180mcu_as_sc_mcu7t3v3__fill_2
XFILLER_176_1057 VDD VDD VSS VSS gf180mcu_as_sc_mcu7t3v3__fillcap_8
X_4443_ VDD VDD VSS VSS _4447_/CLK _4443_/D _4443_/Q gf180mcu_as_sc_mcu7t3v3__dfxtp_2
XFILLER_28_1325 VDD VDD VSS VSS gf180mcu_as_sc_mcu7t3v3__fill_2
Xfanout606 VDD VDD VSS VSS fanout606/A _2893_/B gf180mcu_as_sc_mcu7t3v3__buff_12
X_4374_ VDD VDD VSS VSS _4429_/CLK _4374_/D _4374_/Q gf180mcu_as_sc_mcu7t3v3__dfxtp_2
Xfanout617 VDD VDD VSS VSS _3832_/C _3965_/C gf180mcu_as_sc_mcu7t3v3__buff_12
Xfanout628 VDD VDD VSS VSS _2665_/Y _2894_/B gf180mcu_as_sc_mcu7t3v3__buff_12
X_3325_ VDD VDD VSS VSS _3333_/B _4467_/Q _3332_/D gf180mcu_as_sc_mcu7t3v3__and2_2
XFILLER_6_1121 VDD VDD VSS VSS gf180mcu_as_sc_mcu7t3v3__fill_1
X_3256_ VDD VDD VSS VSS _3328_/S _4365_/Q _4394_/Q _3257_/B gf180mcu_as_sc_mcu7t3v3__mux2_2
XFILLER_152_1090 VDD VDD VSS VSS gf180mcu_as_sc_mcu7t3v3__fillcap_16
X_2207_ VDD VDD VSS VSS _3199_/A _4514_/Q gf180mcu_as_sc_mcu7t3v3__inv_2
XTAP_TAPCELL_ROW_88_1_1041 VDD VSS gf180mcu_as_sc_mcu7t3v3__tap_2
XTAP_TAPCELL_ROW_102_1_1055 VDD VSS gf180mcu_as_sc_mcu7t3v3__tap_2
X_3187_ VDD VDD VSS VSS _3188_/D _3187_/B _3210_/B gf180mcu_as_sc_mcu7t3v3__nor2_2
XFILLER_187_1164 VDD VDD VSS VSS gf180mcu_as_sc_mcu7t3v3__fill_1
XFILLER_74_1334 VDD VDD VSS VSS gf180mcu_as_sc_mcu7t3v3__fillcap_16
XFILLER_179_263 VDD VDD VSS VSS gf180mcu_as_sc_mcu7t3v3__fillcap_4
XFILLER_35_1307 VDD VDD VSS VSS gf180mcu_as_sc_mcu7t3v3__fillcap_4
XFILLER_179_296 VDD VDD VSS VSS gf180mcu_as_sc_mcu7t3v3__fill_1
XPHY_EDGE_ROW_23_3_Left_395 VDD VSS gf180mcu_as_sc_mcu7t3v3__tap_2
XFILLER_6_608 VDD VDD VSS VSS gf180mcu_as_sc_mcu7t3v3__fill_2
XFILLER_175_480 VDD VDD VSS VSS gf180mcu_as_sc_mcu7t3v3__fill_2
XPHY_EDGE_ROW_84_1_Left_276 VDD VSS gf180mcu_as_sc_mcu7t3v3__tap_2
XFILLER_163_653 VDD VDD VSS VSS gf180mcu_as_sc_mcu7t3v3__fill_1
XFILLER_191_962 VDD VDD VSS VSS gf180mcu_as_sc_mcu7t3v3__fillcap_8
XFILLER_155_1108 VDD VDD VSS VSS gf180mcu_as_sc_mcu7t3v3__fill_2
XFILLER_163_686 VDD VDD VSS VSS gf180mcu_as_sc_mcu7t3v3__fill_1
XFILLER_163_697 VDD VDD VSS VSS gf180mcu_as_sc_mcu7t3v3__fill_2
XFILLER_2_814 VDD VDD VSS VSS gf180mcu_as_sc_mcu7t3v3__fillcap_16
XFILLER_76_103 VDD VDD VSS VSS gf180mcu_as_sc_mcu7t3v3__fill_2
Xmesh_tile_1005 VDD VDD VSS VSS sw_out[33] gf180mcu_as_sc_mcu7t3v3__tiel_4
XFILLER_182_2 VDD VDD VSS VSS gf180mcu_as_sc_mcu7t3v3__fillcap_16
XFILLER_150_30 VDD VDD VSS VSS gf180mcu_as_sc_mcu7t3v3__fillcap_4
XFILLER_79_1256 VDD VDD VSS VSS gf180mcu_as_sc_mcu7t3v3__fillcap_8
XFILLER_150_85 VDD VDD VSS VSS gf180mcu_as_sc_mcu7t3v3__fillcap_16
XFILLER_166_1259 VDD VDD VSS VSS gf180mcu_as_sc_mcu7t3v3__fillcap_16
XFILLER_158_447 VDD VDD VSS VSS gf180mcu_as_sc_mcu7t3v3__fill_1
XFILLER_43_72 VDD VDD VSS VSS gf180mcu_as_sc_mcu7t3v3__fill_2
XFILLER_13_497 VDD VDD VSS VSS gf180mcu_as_sc_mcu7t3v3__fill_2
XFILLER_159_72 VDD VDD VSS VSS gf180mcu_as_sc_mcu7t3v3__fillcap_16
XTAP_TAPCELL_ROW_152_1135 VDD VSS gf180mcu_as_sc_mcu7t3v3__tap_2
XTAP_TAPCELL_ROW_152_1124 VDD VSS gf180mcu_as_sc_mcu7t3v3__tap_2
XTAP_TAPCELL_ROW_152_1113 VDD VSS gf180mcu_as_sc_mcu7t3v3__tap_2
XFILLER_154_664 VDD VDD VSS VSS gf180mcu_as_sc_mcu7t3v3__fill_1
XFILLER_173_1208 VDD VDD VSS VSS gf180mcu_as_sc_mcu7t3v3__fillcap_8
XFILLER_154_697 VDD VDD VSS VSS gf180mcu_as_sc_mcu7t3v3__fill_1
XFILLER_1_880 VDD VDD VSS VSS gf180mcu_as_sc_mcu7t3v3__fill_1
X_3110_ VDD VDD VSS VSS _3121_/S _4498_/Q _4497_/Q _4497_/D gf180mcu_as_sc_mcu7t3v3__mux2_2
X_4090_ VDD VDD VSS VSS _4163_/S _4090_/B _4090_/A _4091_/B gf180mcu_as_sc_mcu7t3v3__mux2_2
Xinput280 VDD VDD VSS VSS sw_in[27] _4230_/A gf180mcu_as_sc_mcu7t3v3__buff_12
X_3041_ VDD VDD VSS VSS _4330_/B _4278_/B _4766_/Q gf180mcu_as_sc_mcu7t3v3__nor2_2
Xinput291 VDD VDD VSS VSS sw_in[4] _4042_/A gf180mcu_as_sc_mcu7t3v3__buff_12
XFILLER_97_1323 VDD VDD VSS VSS gf180mcu_as_sc_mcu7t3v3__fill_1
XFILLER_177_712 VDD VDD VSS VSS gf180mcu_as_sc_mcu7t3v3__fillcap_8
XFILLER_182_1061 VDD VDD VSS VSS gf180mcu_as_sc_mcu7t3v3__fillcap_8
X_3943_ VDD VDD VSS VSS _3943_/D _3943_/A _3965_/B _3953_/C _3944_/D gf180mcu_as_sc_mcu7t3v3__ao31_2
X_3874_ VDD VDD VSS VSS _3874_/B _3945_/A _4682_/D gf180mcu_as_sc_mcu7t3v3__and2_2
X_2825_ VDD VDD VSS VSS _4146_/A _2871_/B _2825_/C _2825_/D _2995_/A gf180mcu_as_sc_mcu7t3v3__ao22_2
XFILLER_158_981 VDD VDD VSS VSS gf180mcu_as_sc_mcu7t3v3__fillcap_16
XFILLER_178_1119 VDD VDD VSS VSS gf180mcu_as_sc_mcu7t3v3__fillcap_16
XFILLER_173_940 VDD VDD VSS VSS gf180mcu_as_sc_mcu7t3v3__fillcap_4
X_2756_ VDD VDD VSS VSS _2829_/B _4084_/D _2757_/D gf180mcu_as_sc_mcu7t3v3__and2_2
XFILLER_160_601 VDD VDD VSS VSS gf180mcu_as_sc_mcu7t3v3__fill_2
X_2687_ VDD VDD VSS VSS _4024_/A _2904_/B _2687_/C _2900_/B _2689_/C gf180mcu_as_sc_mcu7t3v3__ao211_2
XTAP_TAPCELL_ROW_121_3_2032 VDD VSS gf180mcu_as_sc_mcu7t3v3__tap_2
X_4426_ VDD VDD VSS VSS clkload7/A _4426_/D _4426_/Q gf180mcu_as_sc_mcu7t3v3__dfxtp_2
XFILLER_154_1152 VDD VDD VSS VSS gf180mcu_as_sc_mcu7t3v3__fill_2
X_4357_ VDD VDD VSS VSS _4576_/CLK _4357_/D _4357_/Q gf180mcu_as_sc_mcu7t3v3__dfxtp_2
XFILLER_189_1204 VDD VDD VSS VSS gf180mcu_as_sc_mcu7t3v3__fill_2
Xfanout458 VDD VDD VSS VSS _3883_/S _3810_/S gf180mcu_as_sc_mcu7t3v3__buff_12
Xfanout469 VDD VDD VSS VSS _2976_/Y _2993_/B gf180mcu_as_sc_mcu7t3v3__buff_12
X_4288_ VDD VDD VSS VSS _4288_/D _4770_/Q _4771_/Q _4288_/C _4289_/B gf180mcu_as_sc_mcu7t3v3__ao31_2
X_3308_ VDD VDD VSS VSS _3348_/A _3308_/B _3308_/C _3308_/D _4529_/D gf180mcu_as_sc_mcu7t3v3__ao211_2
XTAP_TAPCELL_ROW_187_1798 VDD VSS gf180mcu_as_sc_mcu7t3v3__tap_2
XFILLER_104_34 VDD VDD VSS VSS gf180mcu_as_sc_mcu7t3v3__fill_1
XFILLER_189_1237 VDD VDD VSS VSS gf180mcu_as_sc_mcu7t3v3__fill_2
Xmesh_tile_862 VDD VDD VSS VSS ne_out[34] gf180mcu_as_sc_mcu7t3v3__tiel_4
Xmesh_tile_851 VDD VDD VSS VSS ne_out[23] gf180mcu_as_sc_mcu7t3v3__tiel_4
Xmesh_tile_840 VDD VDD VSS VSS ne_out[12] gf180mcu_as_sc_mcu7t3v3__tiel_4
X_3239_ VDD VDD VSS VSS _3242_/C _4421_/Q _3304_/S gf180mcu_as_sc_mcu7t3v3__nand2_2
Xmesh_tile_895 VDD VDD VSS VSS north_out[31] gf180mcu_as_sc_mcu7t3v3__tiel_4
Xmesh_tile_884 VDD VDD VSS VSS north_out[20] gf180mcu_as_sc_mcu7t3v3__tiel_4
Xmesh_tile_873 VDD VDD VSS VSS north_out[9] gf180mcu_as_sc_mcu7t3v3__tiel_4
XFILLER_154_6 VDD VDD VSS VSS gf180mcu_as_sc_mcu7t3v3__fillcap_16
XFILLER_161_1134 VDD VDD VSS VSS gf180mcu_as_sc_mcu7t3v3__fillcap_16
XFILLER_126_1287 VDD VDD VSS VSS gf180mcu_as_sc_mcu7t3v3__fill_2
XFILLER_13_31 VDD VDD VSS VSS gf180mcu_as_sc_mcu7t3v3__fill_2
XFILLER_155_406 VDD VDD VSS VSS gf180mcu_as_sc_mcu7t3v3__fill_2
XFILLER_156_929 VDD VDD VSS VSS gf180mcu_as_sc_mcu7t3v3__fill_2
XFILLER_11_979 VDD VDD VSS VSS gf180mcu_as_sc_mcu7t3v3__fill_1
XFILLER_182_247 VDD VDD VSS VSS gf180mcu_as_sc_mcu7t3v3__fillcap_16
XFILLER_11_1192 VDD VDD VSS VSS gf180mcu_as_sc_mcu7t3v3__fill_2
XFILLER_8_2 VDD VDD VSS VSS gf180mcu_as_sc_mcu7t3v3__fillcap_8
XFILLER_145_52 VDD VDD VSS VSS gf180mcu_as_sc_mcu7t3v3__fillcap_4
XFILLER_1_154 VDD VDD VSS VSS gf180mcu_as_sc_mcu7t3v3__fill_2
XFILLER_2_688 VDD VDD VSS VSS gf180mcu_as_sc_mcu7t3v3__fill_2
XFILLER_172_1285 VDD VDD VSS VSS gf180mcu_as_sc_mcu7t3v3__fillcap_8
XTAP_TAPCELL_ROW_56_3_1967 VDD VSS gf180mcu_as_sc_mcu7t3v3__tap_2
XFILLER_38_72 VDD VDD VSS VSS gf180mcu_as_sc_mcu7t3v3__fill_1
XFILLER_166_1012 VDD VDD VSS VSS gf180mcu_as_sc_mcu7t3v3__fill_2
XPHY_EDGE_ROW_158_Right_20 VDD VSS gf180mcu_as_sc_mcu7t3v3__tap_2
XFILLER_166_1045 VDD VDD VSS VSS gf180mcu_as_sc_mcu7t3v3__fillcap_8
XFILLER_18_1302 VDD VDD VSS VSS gf180mcu_as_sc_mcu7t3v3__fillcap_4
XFILLER_54_60 VDD VDD VSS VSS gf180mcu_as_sc_mcu7t3v3__fillcap_16
XFILLER_13_261 VDD VDD VSS VSS gf180mcu_as_sc_mcu7t3v3__fill_1
XFILLER_144_1332 VDD VDD VSS VSS gf180mcu_as_sc_mcu7t3v3__fillcap_4
XFILLER_92_1264 VDD VDD VSS VSS gf180mcu_as_sc_mcu7t3v3__fill_2
XFILLER_174_726 VDD VDD VSS VSS gf180mcu_as_sc_mcu7t3v3__fillcap_8
XFILLER_174_737 VDD VDD VSS VSS gf180mcu_as_sc_mcu7t3v3__fillcap_4
XFILLER_186_597 VDD VDD VSS VSS gf180mcu_as_sc_mcu7t3v3__fillcap_16
Xclkload13 VDD VDD VSS VSS _4440_/CLK clkload13/Y gf180mcu_as_sc_mcu7t3v3__clkbuff_4
Xclkload24 VDD VDD VSS VSS clkload24/Y _4831_/CLK gf180mcu_as_sc_mcu7t3v3__inv_2
X_3590_ VDD VDD VSS VSS _4649_/Q _3603_/A _3599_/B _4649_/D gf180mcu_as_sc_mcu7t3v3__nor3_2
X_2610_ VDD VDD VSS VSS _3978_/B _4247_/A _2632_/D gf180mcu_as_sc_mcu7t3v3__and2_2
XTAP_TAPCELL_ROW_171_1500 VDD VSS gf180mcu_as_sc_mcu7t3v3__tap_2
XFILLER_154_461 VDD VDD VSS VSS gf180mcu_as_sc_mcu7t3v3__fill_2
XFILLER_155_973 VDD VDD VSS VSS gf180mcu_as_sc_mcu7t3v3__fillcap_4
XFILLER_170_921 VDD VDD VSS VSS gf180mcu_as_sc_mcu7t3v3__fillcap_4
X_2541_ VDD VDD VSS VSS _2543_/C _2544_/A _3469_/A gf180mcu_as_sc_mcu7t3v3__and2_2
X_2472_ VDD VDD VSS VSS _4540_/Q _3068_/S _3061_/S _4516_/Q _2473_/B gf180mcu_as_sc_mcu7t3v3__ao22_2
XFILLER_173_1049 VDD VDD VSS VSS gf180mcu_as_sc_mcu7t3v3__fill_1
X_4211_ VDD VDD VSS VSS _4211_/A _4236_/C _4211_/C _4211_/D _4212_/B gf180mcu_as_sc_mcu7t3v3__ao211_2
XTAP_TAPCELL_ROW_169_1451 VDD VSS gf180mcu_as_sc_mcu7t3v3__tap_2
X_4142_ VDD VDD VSS VSS _4143_/C _4142_/A _4184_/B _4142_/C gf180mcu_as_sc_mcu7t3v3__ao21_2
XTAP_TAPCELL_ROW_169_1462 VDD VSS gf180mcu_as_sc_mcu7t3v3__tap_2
X_4073_ VDD VDD VSS VSS _4074_/B _4073_/A _4154_/S _4073_/C gf180mcu_as_sc_mcu7t3v3__ao21_2
XFILLER_3_1113 VDD VDD VSS VSS gf180mcu_as_sc_mcu7t3v3__fillcap_4
X_3024_ VDD VDD VSS VSS _3024_/A _3038_/B _3024_/C _4434_/Q _4434_/D gf180mcu_as_sc_mcu7t3v3__ao22_2
XFILLER_188_1270 VDD VDD VSS VSS gf180mcu_as_sc_mcu7t3v3__fillcap_16
XTAP_TAPCELL_ROW_182_1695 VDD VSS gf180mcu_as_sc_mcu7t3v3__tap_2
XFILLER_71_1326 VDD VDD VSS VSS gf180mcu_as_sc_mcu7t3v3__fillcap_4
X_3926_ VDD VDD VSS VSS _4264_/D _3926_/B _3926_/C _3926_/D _3927_/D gf180mcu_as_sc_mcu7t3v3__ao22_2
XFILLER_192_512 VDD VDD VSS VSS gf180mcu_as_sc_mcu7t3v3__fill_2
Xclkload7 VDD VDD VSS VSS clkload7/Y clkload7/A gf180mcu_as_sc_mcu7t3v3__inv_6
X_3857_ VDD VDD VSS VSS _3866_/B _4198_/D _3858_/C gf180mcu_as_sc_mcu7t3v3__and2_2
XFILLER_164_247 VDD VDD VSS VSS gf180mcu_as_sc_mcu7t3v3__fillcap_16
X_3788_ VDD VDD VSS VSS _4788_/Q _3852_/B _3788_/C _3788_/D _3789_/C gf180mcu_as_sc_mcu7t3v3__ao22_2
X_2808_ VDD VDD VSS VSS _4347_/Q _2826_/B _2993_/A _2808_/D _4347_/D gf180mcu_as_sc_mcu7t3v3__ao22_2
XFILLER_192_567 VDD VDD VSS VSS gf180mcu_as_sc_mcu7t3v3__fillcap_4
X_2739_ VDD VDD VSS VSS _4068_/A _2827_/B _2739_/C _2739_/D _2740_/D gf180mcu_as_sc_mcu7t3v3__ao211_2
XFILLER_156_1258 VDD VDD VSS VSS gf180mcu_as_sc_mcu7t3v3__fillcap_4
XFILLER_160_453 VDD VDD VSS VSS gf180mcu_as_sc_mcu7t3v3__fill_2
XFILLER_191_1138 VDD VDD VSS VSS gf180mcu_as_sc_mcu7t3v3__fillcap_16
XTAP_TAPCELL_ROW_189_1838 VDD VSS gf180mcu_as_sc_mcu7t3v3__tap_2
XFILLER_161_998 VDD VDD VSS VSS gf180mcu_as_sc_mcu7t3v3__fillcap_8
XFILLER_8_1002 VDD VDD VSS VSS gf180mcu_as_sc_mcu7t3v3__fill_1
X_4409_ VDD VDD VSS VSS _4440_/CLK _4409_/D _4409_/Q gf180mcu_as_sc_mcu7t3v3__dfxtp_2
XPHY_EDGE_ROW_115_1_Left_307 VDD VSS gf180mcu_as_sc_mcu7t3v3__tap_2
XFILLER_115_55 VDD VDD VSS VSS gf180mcu_as_sc_mcu7t3v3__fill_2
XFILLER_115_88 VDD VDD VSS VSS gf180mcu_as_sc_mcu7t3v3__fillcap_16
XFILLER_132_1291 VDD VDD VSS VSS gf180mcu_as_sc_mcu7t3v3__fillcap_16
XFILLER_167_1332 VDD VDD VSS VSS gf180mcu_as_sc_mcu7t3v3__fillcap_16
XFILLER_91_58 VDD VDD VSS VSS gf180mcu_as_sc_mcu7t3v3__fill_1
XFILLER_168_597 VDD VDD VSS VSS gf180mcu_as_sc_mcu7t3v3__fillcap_8
Xclkbuf_leaf_8_clk_regs VDD VDD VSS VSS clkbuf_leaf_8_clk_regs/A _4789_/CLK gf180mcu_as_sc_mcu7t3v3__clkbuff_12
XFILLER_13_1232 VDD VDD VSS VSS gf180mcu_as_sc_mcu7t3v3__fill_1
XFILLER_52_1281 VDD VDD VSS VSS gf180mcu_as_sc_mcu7t3v3__fill_1
XFILLER_7_747 VDD VDD VSS VSS gf180mcu_as_sc_mcu7t3v3__fillcap_8
XFILLER_171_718 VDD VDD VSS VSS gf180mcu_as_sc_mcu7t3v3__fillcap_4
XFILLER_100_1268 VDD VDD VSS VSS gf180mcu_as_sc_mcu7t3v3__fill_1
XFILLER_13_1298 VDD VDD VSS VSS gf180mcu_as_sc_mcu7t3v3__fill_1
XFILLER_164_792 VDD VDD VSS VSS gf180mcu_as_sc_mcu7t3v3__fillcap_8
XFILLER_3_920 VDD VDD VSS VSS gf180mcu_as_sc_mcu7t3v3__fill_1
XFILLER_152_954 VDD VDD VSS VSS gf180mcu_as_sc_mcu7t3v3__fillcap_4
XFILLER_3_964 VDD VDD VSS VSS gf180mcu_as_sc_mcu7t3v3__fill_2
XPHY_EDGE_ROW_47_1_Left_239 VDD VSS gf180mcu_as_sc_mcu7t3v3__tap_2
XPHY_EDGE_ROW_48_3_Left_420 VDD VSS gf180mcu_as_sc_mcu7t3v3__tap_2
XPHY_EDGE_ROW_100_3_Left_472 VDD VSS gf180mcu_as_sc_mcu7t3v3__tap_2
XFILLER_0_1319 VDD VDD VSS VSS gf180mcu_as_sc_mcu7t3v3__fillcap_4
XTAP_TAPCELL_ROW_164_1370 VDD VSS gf180mcu_as_sc_mcu7t3v3__tap_2
XFILLER_94_1304 VDD VDD VSS VSS gf180mcu_as_sc_mcu7t3v3__fill_1
XTAP_TAPCELL_ROW_160_1278 VDD VSS gf180mcu_as_sc_mcu7t3v3__tap_2
XFILLER_178_328 VDD VDD VSS VSS gf180mcu_as_sc_mcu7t3v3__fill_2
XTAP_TAPCELL_ROW_160_1289 VDD VSS gf180mcu_as_sc_mcu7t3v3__tap_2
XFILLER_159_553 VDD VDD VSS VSS gf180mcu_as_sc_mcu7t3v3__fillcap_4
X_4760_ VDD VDD VSS VSS clkload3/A _4760_/D _4760_/Q gf180mcu_as_sc_mcu7t3v3__dfxtp_2
XFILLER_159_597 VDD VDD VSS VSS gf180mcu_as_sc_mcu7t3v3__fillcap_4
XFILLER_179_1203 VDD VDD VSS VSS gf180mcu_as_sc_mcu7t3v3__fillcap_16
X_4691_ VDD VDD VSS VSS _4692_/CLK _4691_/D _4691_/Q gf180mcu_as_sc_mcu7t3v3__dfxtp_2
X_3711_ VDD VDD VSS VSS _4065_/A _3921_/B _3711_/C _3712_/C _3855_/B gf180mcu_as_sc_mcu7t3v3__aoi211_2
XFILLER_179_1236 VDD VDD VSS VSS gf180mcu_as_sc_mcu7t3v3__fill_2
XFILLER_186_383 VDD VDD VSS VSS gf180mcu_as_sc_mcu7t3v3__fill_2
X_3642_ VDD VDD VSS VSS _4772_/Q _3852_/B _3879_/B _3992_/A _3643_/D gf180mcu_as_sc_mcu7t3v3__ao22_2
XFILLER_174_589 VDD VDD VSS VSS gf180mcu_as_sc_mcu7t3v3__fillcap_4
XPHY_EDGE_ROW_157_Left_349 VDD VSS gf180mcu_as_sc_mcu7t3v3__tap_2
XFILLER_161_228 VDD VDD VSS VSS gf180mcu_as_sc_mcu7t3v3__fillcap_16
X_3573_ VDD VDD VSS VSS _4582_/Q _3573_/B _3573_/C _3574_/C _3573_/D gf180mcu_as_sc_mcu7t3v3__aoi211_2
XFILLER_154_291 VDD VDD VSS VSS gf180mcu_as_sc_mcu7t3v3__fill_1
X_2524_ VDD VDD VSS VSS _3513_/A _2524_/B _2524_/C _4640_/Q _3080_/C gf180mcu_as_sc_mcu7t3v3__ao211_2
X_2455_ VDD VDD VSS VSS _2455_/B _2455_/A _2462_/D gf180mcu_as_sc_mcu7t3v3__and2_2
X_2386_ VDD VDD VSS VSS _2388_/C _2386_/B _2481_/C gf180mcu_as_sc_mcu7t3v3__nor2_2
X_4125_ VDD VDD VSS VSS _4126_/C _4125_/A _4184_/B _4125_/C gf180mcu_as_sc_mcu7t3v3__ao21_2
XTAP_TAPCELL_ROW_184_1746 VDD VSS gf180mcu_as_sc_mcu7t3v3__tap_2
XTAP_TAPCELL_ROW_184_1735 VDD VSS gf180mcu_as_sc_mcu7t3v3__tap_2
XFILLER_116_1286 VDD VDD VSS VSS gf180mcu_as_sc_mcu7t3v3__fill_2
X_4056_ VDD VDD VSS VSS _4056_/A _4153_/B _4056_/C _4056_/D _4057_/C gf180mcu_as_sc_mcu7t3v3__ao211_2
XPHY_EDGE_ROW_93_1_Left_285 VDD VSS gf180mcu_as_sc_mcu7t3v3__tap_2
XPHY_EDGE_ROW_166_Left_358 VDD VSS gf180mcu_as_sc_mcu7t3v3__tap_2
X_3007_ VDD VDD VSS VSS _4275_/B _4765_/Q _3007_/Y gf180mcu_as_sc_mcu7t3v3__and2_2
XFILLER_169_339 VDD VDD VSS VSS gf180mcu_as_sc_mcu7t3v3__fillcap_8
XTAP_TAPCELL_ROW_108_3_2019 VDD VSS gf180mcu_as_sc_mcu7t3v3__tap_2
XFILLER_177_28 VDD VDD VSS VSS gf180mcu_as_sc_mcu7t3v3__fill_1
XFILLER_178_895 VDD VDD VSS VSS gf180mcu_as_sc_mcu7t3v3__fill_1
X_3909_ VDD VDD VSS VSS _4246_/A _3926_/B _3909_/C _3926_/D _3910_/C gf180mcu_as_sc_mcu7t3v3__ao22_2
XFILLER_123_1268 VDD VDD VSS VSS gf180mcu_as_sc_mcu7t3v3__fill_2
XFILLER_177_394 VDD VDD VSS VSS gf180mcu_as_sc_mcu7t3v3__fillcap_8
XPHY_EDGE_ROW_175_Left_367 VDD VSS gf180mcu_as_sc_mcu7t3v3__tap_2
XFILLER_152_206 VDD VDD VSS VSS gf180mcu_as_sc_mcu7t3v3__fillcap_4
XFILLER_165_578 VDD VDD VSS VSS gf180mcu_as_sc_mcu7t3v3__fillcap_4
XFILLER_192_342 VDD VDD VSS VSS gf180mcu_as_sc_mcu7t3v3__fillcap_4
XFILLER_105_100 VDD VDD VSS VSS gf180mcu_as_sc_mcu7t3v3__fillcap_4
XFILLER_10_87 VDD VDD VSS VSS gf180mcu_as_sc_mcu7t3v3__fillcap_4
Xoutput370 VDD VDD VSS VSS _4696_/Q east_out[3] gf180mcu_as_sc_mcu7t3v3__buff_12
Xoutput392 VDD VDD VSS VSS _4680_/Q south_out[23] gf180mcu_as_sc_mcu7t3v3__buff_12
Xoutput381 VDD VDD VSS VSS _4670_/Q south_out[13] gf180mcu_as_sc_mcu7t3v3__buff_12
XPHY_EDGE_ROW_184_Left_376 VDD VSS gf180mcu_as_sc_mcu7t3v3__tap_2
XFILLER_142_64 VDD VDD VSS VSS gf180mcu_as_sc_mcu7t3v3__fillcap_16
XTAP_TAPCELL_ROW_3_750 VDD VSS gf180mcu_as_sc_mcu7t3v3__tap_2
XFILLER_163_1037 VDD VDD VSS VSS gf180mcu_as_sc_mcu7t3v3__fill_2
XFILLER_35_84 VDD VDD VSS VSS gf180mcu_as_sc_mcu7t3v3__fill_2
XFILLER_169_895 VDD VDD VSS VSS gf180mcu_as_sc_mcu7t3v3__fillcap_8
XFILLER_168_383 VDD VDD VSS VSS gf180mcu_as_sc_mcu7t3v3__fill_2
XFILLER_51_72 VDD VDD VSS VSS gf180mcu_as_sc_mcu7t3v3__fillcap_16
XFILLER_167_72 VDD VDD VSS VSS gf180mcu_as_sc_mcu7t3v3__fill_2
XFILLER_152_784 VDD VDD VSS VSS gf180mcu_as_sc_mcu7t3v3__fillcap_16
XFILLER_3_772 VDD VDD VSS VSS gf180mcu_as_sc_mcu7t3v3__fill_2
X_2240_ VDD VDD VSS VSS _3608_/A _2287_/B _2287_/A gf180mcu_as_sc_mcu7t3v3__nand2_2
XTAP_TAPCELL_ROW_1_709 VDD VSS gf180mcu_as_sc_mcu7t3v3__tap_2
XTAP_TAPCELL_ROW_162_1329 VDD VSS gf180mcu_as_sc_mcu7t3v3__tap_2
XTAP_TAPCELL_ROW_162_1318 VDD VSS gf180mcu_as_sc_mcu7t3v3__tap_2
XFILLER_0_1149 VDD VDD VSS VSS gf180mcu_as_sc_mcu7t3v3__fillcap_4
XFILLER_185_1262 VDD VDD VSS VSS gf180mcu_as_sc_mcu7t3v3__fillcap_16
XFILLER_181_1115 VDD VDD VSS VSS gf180mcu_as_sc_mcu7t3v3__fillcap_4
XFILLER_146_1279 VDD VDD VSS VSS gf180mcu_as_sc_mcu7t3v3__fillcap_8
XFILLER_178_125 VDD VDD VSS VSS gf180mcu_as_sc_mcu7t3v3__fill_1
X_4812_ VDD VDD VSS VSS _4830_/CLK _4812_/D _4812_/Q gf180mcu_as_sc_mcu7t3v3__dfxtp_2
XFILLER_159_372 VDD VDD VSS VSS gf180mcu_as_sc_mcu7t3v3__fillcap_4
XFILLER_175_810 VDD VDD VSS VSS gf180mcu_as_sc_mcu7t3v3__fillcap_16
XFILLER_178_169 VDD VDD VSS VSS gf180mcu_as_sc_mcu7t3v3__fillcap_4
X_4743_ VDD VDD VSS VSS _4751_/CLK _4743_/D _4743_/Q gf180mcu_as_sc_mcu7t3v3__dfxtp_2
XFILLER_190_802 VDD VDD VSS VSS gf180mcu_as_sc_mcu7t3v3__fill_2
X_4674_ VDD VDD VSS VSS clkload4/A _4674_/D _4674_/Q gf180mcu_as_sc_mcu7t3v3__dfxtp_2
Xmax_cap720 VDD VDD VSS VSS _4770_/Q _3039_/A gf180mcu_as_sc_mcu7t3v3__clkbuff_12
X_3625_ VDD VDD VSS VSS _3960_/C _3960_/B _3625_/A gf180mcu_as_sc_mcu7t3v3__nand2b_2
XFILLER_162_559 VDD VDD VSS VSS gf180mcu_as_sc_mcu7t3v3__fillcap_8
X_3556_ VDD VDD VSS VSS _3582_/B _3568_/A _3608_/A gf180mcu_as_sc_mcu7t3v3__nor2_2
XFILLER_170_570 VDD VDD VSS VSS gf180mcu_as_sc_mcu7t3v3__fill_1
XFILLER_192_1255 VDD VDD VSS VSS gf180mcu_as_sc_mcu7t3v3__fill_2
X_2507_ VDD VDD VSS VSS _4808_/Q _4640_/Q _2566_/D gf180mcu_as_sc_mcu7t3v3__and2_2
Xinput109 VDD VDD VSS VSS ne_in[3] wire811/A gf180mcu_as_sc_mcu7t3v3__buff_12
X_3487_ VDD VDD VSS VSS _3487_/B _3583_/A _3502_/C gf180mcu_as_sc_mcu7t3v3__and2_2
X_2438_ VDD VDD VSS VSS _2455_/A _2438_/B _2438_/C _2438_/D _2438_/Y gf180mcu_as_sc_mcu7t3v3__ao22_2
X_2369_ VDD VDD VSS VSS _2371_/C _3608_/D _2369_/B _3611_/B gf180mcu_as_sc_mcu7t3v3__aoi21b_2
X_4108_ VDD VDD VSS VSS _4108_/A _4231_/B _4224_/C _4108_/D _4109_/D gf180mcu_as_sc_mcu7t3v3__ao22_2
XFILLER_112_34 VDD VDD VSS VSS gf180mcu_as_sc_mcu7t3v3__fill_1
XFILLER_186_1037 VDD VDD VSS VSS gf180mcu_as_sc_mcu7t3v3__fillcap_4
XFILLER_42_1291 VDD VDD VSS VSS gf180mcu_as_sc_mcu7t3v3__fillcap_8
X_4039_ VDD VDD VSS VSS _4039_/A _4143_/B _4235_/B _4039_/D _4040_/D gf180mcu_as_sc_mcu7t3v3__ao22_2
XFILLER_112_67 VDD VDD VSS VSS gf180mcu_as_sc_mcu7t3v3__fillcap_16
XFILLER_38_1305 VDD VDD VSS VSS gf180mcu_as_sc_mcu7t3v3__fill_1
XFILLER_77_1354 VDD VDD VSS VSS gf180mcu_as_sc_mcu7t3v3__fill_1
XFILLER_164_1313 VDD VDD VSS VSS gf180mcu_as_sc_mcu7t3v3__fillcap_4
XFILLER_72_27 VDD VDD VSS VSS gf180mcu_as_sc_mcu7t3v3__fillcap_4
XFILLER_169_169 VDD VDD VSS VSS gf180mcu_as_sc_mcu7t3v3__fillcap_16
XFILLER_184_128 VDD VDD VSS VSS gf180mcu_as_sc_mcu7t3v3__fillcap_16
XANTENNA_60 VDD VDD VSS VSS _2462_/A gf180mcu_as_sc_mcu7t3v3__diode_2
XFILLER_153_504 VDD VDD VSS VSS gf180mcu_as_sc_mcu7t3v3__fill_1
XFILLER_165_397 VDD VDD VSS VSS gf180mcu_as_sc_mcu7t3v3__fillcap_16
XFILLER_192_172 VDD VDD VSS VSS gf180mcu_as_sc_mcu7t3v3__fillcap_4
XFILLER_108_2 VDD VDD VSS VSS gf180mcu_as_sc_mcu7t3v3__fillcap_4
XFILLER_137_86 VDD VDD VSS VSS gf180mcu_as_sc_mcu7t3v3__fillcap_16
XFILLER_161_570 VDD VDD VSS VSS gf180mcu_as_sc_mcu7t3v3__fill_2
XTAP_TAPCELL_ROW_8_842 VDD VSS gf180mcu_as_sc_mcu7t3v3__tap_2
XTAP_TAPCELL_ROW_120_1_1073 VDD VSS gf180mcu_as_sc_mcu7t3v3__tap_2
XFILLER_169_1257 VDD VDD VSS VSS gf180mcu_as_sc_mcu7t3v3__fill_2
XFILLER_189_924 VDD VDD VSS VSS gf180mcu_as_sc_mcu7t3v3__fill_2
XFILLER_176_629 VDD VDD VSS VSS gf180mcu_as_sc_mcu7t3v3__fill_2
XFILLER_145_1290 VDD VDD VSS VSS gf180mcu_as_sc_mcu7t3v3__fillcap_16
XFILLER_157_854 VDD VDD VSS VSS gf180mcu_as_sc_mcu7t3v3__fill_1
XFILLER_180_1181 VDD VDD VSS VSS gf180mcu_as_sc_mcu7t3v3__fill_1
XFILLER_12_893 VDD VDD VSS VSS gf180mcu_as_sc_mcu7t3v3__fillcap_16
XFILLER_157_865 VDD VDD VSS VSS gf180mcu_as_sc_mcu7t3v3__fillcap_16
XFILLER_157_887 VDD VDD VSS VSS gf180mcu_as_sc_mcu7t3v3__fill_1
XFILLER_7_352 VDD VDD VSS VSS gf180mcu_as_sc_mcu7t3v3__fill_1
XFILLER_7_66 VDD VDD VSS VSS gf180mcu_as_sc_mcu7t3v3__fillcap_4
XTAP_TAPCELL_ROW_155_1188 VDD VSS gf180mcu_as_sc_mcu7t3v3__tap_2
X_4390_ VDD VDD VSS VSS _4795_/CLK _4390_/D _4390_/Q gf180mcu_as_sc_mcu7t3v3__dfxtp_2
X_3410_ VDD VDD VSS VSS _3412_/B _3410_/C _3410_/B _3410_/A gf180mcu_as_sc_mcu7t3v3__aoi21_2
XTAP_TAPCELL_ROW_155_1199 VDD VSS gf180mcu_as_sc_mcu7t3v3__tap_2
X_3341_ VDD VDD VSS VSS _3405_/B _4469_/Q _3348_/D gf180mcu_as_sc_mcu7t3v3__and2_2
X_3272_ VDD VDD VSS VSS _3312_/S _4367_/Q _4396_/Q _3273_/B gf180mcu_as_sc_mcu7t3v3__mux2_2
X_2223_ VDD VDD VSS VSS _4208_/A _4797_/Q gf180mcu_as_sc_mcu7t3v3__inv_2
XFILLER_113_1256 VDD VDD VSS VSS gf180mcu_as_sc_mcu7t3v3__fillcap_16
XFILLER_152_1294 VDD VDD VSS VSS gf180mcu_as_sc_mcu7t3v3__fill_1
XTAP_TAPCELL_ROW_179_1645 VDD VSS gf180mcu_as_sc_mcu7t3v3__tap_2
XFILLER_167_629 VDD VDD VSS VSS gf180mcu_as_sc_mcu7t3v3__fill_1
XFILLER_179_489 VDD VDD VSS VSS gf180mcu_as_sc_mcu7t3v3__fill_1
XTAP_TAPCELL_ROW_179_1656 VDD VSS gf180mcu_as_sc_mcu7t3v3__tap_2
XPHY_EDGE_ROW_124_1_Left_316 VDD VSS gf180mcu_as_sc_mcu7t3v3__tap_2
X_2987_ VDD VDD VSS VSS _2987_/A _2989_/B _2989_/C _4399_/Q _4399_/D gf180mcu_as_sc_mcu7t3v3__ao22_2
XFILLER_175_640 VDD VDD VSS VSS gf180mcu_as_sc_mcu7t3v3__fill_1
X_4726_ VDD VDD VSS VSS _4726_/CLK _4726_/D _4726_/Q gf180mcu_as_sc_mcu7t3v3__dfxtp_2
XFILLER_163_835 VDD VDD VSS VSS gf180mcu_as_sc_mcu7t3v3__fillcap_4
XFILLER_174_161 VDD VDD VSS VSS gf180mcu_as_sc_mcu7t3v3__fillcap_8
XFILLER_190_621 VDD VDD VSS VSS gf180mcu_as_sc_mcu7t3v3__fillcap_4
X_4657_ VDD VDD VSS VSS clkload4/A _4657_/D _4657_/Q gf180mcu_as_sc_mcu7t3v3__dfxtp_2
XTAP_TAPCELL_ROW_192_1889 VDD VSS gf180mcu_as_sc_mcu7t3v3__tap_2
Xinput80 VDD VDD VSS VSS ne_in[0] _3983_/A gf180mcu_as_sc_mcu7t3v3__buff_12
Xinput91 VDD VDD VSS VSS ne_in[1] _4015_/A gf180mcu_as_sc_mcu7t3v3__buff_12
X_3608_ VDD VDD VSS VSS _3608_/D _3608_/A _3608_/B _3608_/C _3610_/C gf180mcu_as_sc_mcu7t3v3__ao31_2
X_4588_ VDD VDD VSS VSS _4820_/CLK _4588_/D _4588_/Q gf180mcu_as_sc_mcu7t3v3__dfxtp_2
X_3539_ VDD VDD VSS VSS _3539_/S _4615_/Q _4605_/Q _3540_/B gf180mcu_as_sc_mcu7t3v3__mux2_2
XFILLER_67_27 VDD VDD VSS VSS gf180mcu_as_sc_mcu7t3v3__fill_1
Xclkbuf_leaf_22_clk_regs VDD VDD VSS VSS clkload2/A _4829_/CLK gf180mcu_as_sc_mcu7t3v3__clkbuff_12
XFILLER_190_39 VDD VDD VSS VSS gf180mcu_as_sc_mcu7t3v3__fill_1
XFILLER_123_88 VDD VDD VSS VSS gf180mcu_as_sc_mcu7t3v3__fillcap_16
XFILLER_16_86 VDD VDD VSS VSS gf180mcu_as_sc_mcu7t3v3__fillcap_4
XPHY_EDGE_ROW_56_1_Left_248 VDD VSS gf180mcu_as_sc_mcu7t3v3__tap_2
XFILLER_12_123 VDD VDD VSS VSS gf180mcu_as_sc_mcu7t3v3__fillcap_16
XFILLER_158_629 VDD VDD VSS VSS gf180mcu_as_sc_mcu7t3v3__fillcap_8
XFILLER_186_927 VDD VDD VSS VSS gf180mcu_as_sc_mcu7t3v3__fillcap_8
Xsram2048.u_bank1_822 VDD VDD VSS VSS sram2048.u_bank1/WEN[1] gf180mcu_as_sc_mcu7t3v3__tiel_4
XFILLER_13_679 VDD VDD VSS VSS gf180mcu_as_sc_mcu7t3v3__fill_1
XFILLER_185_426 VDD VDD VSS VSS gf180mcu_as_sc_mcu7t3v3__fill_1
XFILLER_186_949 VDD VDD VSS VSS gf180mcu_as_sc_mcu7t3v3__fill_1
XFILLER_185_459 VDD VDD VSS VSS gf180mcu_as_sc_mcu7t3v3__fillcap_8
XFILLER_148_63 VDD VDD VSS VSS gf180mcu_as_sc_mcu7t3v3__fillcap_8
XFILLER_154_813 VDD VDD VSS VSS gf180mcu_as_sc_mcu7t3v3__fill_1
XFILLER_154_835 VDD VDD VSS VSS gf180mcu_as_sc_mcu7t3v3__fillcap_16
XFILLER_181_632 VDD VDD VSS VSS gf180mcu_as_sc_mcu7t3v3__fillcap_4
XFILLER_10_1076 VDD VDD VSS VSS gf180mcu_as_sc_mcu7t3v3__fillcap_8
XFILLER_180_153 VDD VDD VSS VSS gf180mcu_as_sc_mcu7t3v3__fillcap_16
XFILLER_88_1291 VDD VDD VSS VSS gf180mcu_as_sc_mcu7t3v3__fillcap_16
XFILLER_10_1087 VDD VDD VSS VSS gf180mcu_as_sc_mcu7t3v3__fillcap_16
XFILLER_136_1256 VDD VDD VSS VSS gf180mcu_as_sc_mcu7t3v3__fillcap_16
XFILLER_171_1136 VDD VDD VSS VSS gf180mcu_as_sc_mcu7t3v3__fillcap_16
XFILLER_108_1303 VDD VDD VSS VSS gf180mcu_as_sc_mcu7t3v3__fill_2
XFILLER_182_1243 VDD VDD VSS VSS gf180mcu_as_sc_mcu7t3v3__fill_2
X_2910_ VDD VDD VSS VSS _4227_/A _2917_/B _2910_/C _2910_/D _2911_/D gf180mcu_as_sc_mcu7t3v3__ao211_2
XFILLER_182_1265 VDD VDD VSS VSS gf180mcu_as_sc_mcu7t3v3__fill_1
XFILLER_189_776 VDD VDD VSS VSS gf180mcu_as_sc_mcu7t3v3__fill_2
X_3890_ VDD VDD VSS VSS _3890_/S _3890_/B _4224_/A _3891_/C gf180mcu_as_sc_mcu7t3v3__mux2_2
X_2841_ VDD VDD VSS VSS _4159_/A _2895_/B _2841_/C _2841_/D _2842_/C gf180mcu_as_sc_mcu7t3v3__ao211_2
XTAP_TAPCELL_ROW_157_1228 VDD VSS gf180mcu_as_sc_mcu7t3v3__tap_2
X_2772_ VDD VDD VSS VSS _4343_/Q _2772_/B _3020_/A _2772_/D _4343_/D gf180mcu_as_sc_mcu7t3v3__ao22_2
X_4511_ VDD VDD VSS VSS _4576_/CLK _4511_/D _4511_/Q gf180mcu_as_sc_mcu7t3v3__dfxtp_2
XTAP_TAPCELL_ROW_174_1553 VDD VSS gf180mcu_as_sc_mcu7t3v3__tap_2
XFILLER_176_1014 VDD VDD VSS VSS gf180mcu_as_sc_mcu7t3v3__fill_1
XFILLER_176_1025 VDD VDD VSS VSS gf180mcu_as_sc_mcu7t3v3__fillcap_4
X_4442_ VDD VDD VSS VSS _4445_/CLK _4442_/D _4442_/Q gf180mcu_as_sc_mcu7t3v3__dfxtp_2
XTAP_TAPCELL_ROW_10_880 VDD VSS gf180mcu_as_sc_mcu7t3v3__tap_2
XFILLER_171_142 VDD VDD VSS VSS gf180mcu_as_sc_mcu7t3v3__fillcap_8
XFILLER_172_687 VDD VDD VSS VSS gf180mcu_as_sc_mcu7t3v3__fill_2
XFILLER_176_1069 VDD VDD VSS VSS gf180mcu_as_sc_mcu7t3v3__fill_1
XFILLER_154_1323 VDD VDD VSS VSS gf180mcu_as_sc_mcu7t3v3__fillcap_16
X_4373_ VDD VDD VSS VSS _4533_/CLK _4373_/D _4373_/Q gf180mcu_as_sc_mcu7t3v3__dfxtp_2
X_3324_ VDD VDD VSS VSS _3340_/A _3324_/B _3324_/C _3324_/D _4531_/D gf180mcu_as_sc_mcu7t3v3__ao211_2
XFILLER_6_1111 VDD VDD VSS VSS gf180mcu_as_sc_mcu7t3v3__fillcap_8
XFILLER_85_104 VDD VDD VSS VSS gf180mcu_as_sc_mcu7t3v3__fill_1
X_3255_ VDD VDD VSS VSS _3258_/C _4423_/Q _3328_/S gf180mcu_as_sc_mcu7t3v3__nand2_2
XTAP_TAPCELL_ROW_74_3_1985 VDD VSS gf180mcu_as_sc_mcu7t3v3__tap_2
X_2206_ VDD VDD VSS VSS _3188_/A _4513_/Q gf180mcu_as_sc_mcu7t3v3__inv_2
X_3186_ VDD VDD VSS VSS _3516_/B _3373_/B _3412_/A _3186_/D _3187_/B gf180mcu_as_sc_mcu7t3v3__ao22_2
XFILLER_179_231 VDD VDD VSS VSS gf180mcu_as_sc_mcu7t3v3__fillcap_16
XFILLER_183_908 VDD VDD VSS VSS gf180mcu_as_sc_mcu7t3v3__fill_2
XFILLER_185_28 VDD VDD VSS VSS gf180mcu_as_sc_mcu7t3v3__fill_1
X_4709_ VDD VDD VSS VSS _4719_/CLK _4709_/D _4709_/Q gf180mcu_as_sc_mcu7t3v3__dfxtp_2
XFILLER_159_1234 VDD VDD VSS VSS gf180mcu_as_sc_mcu7t3v3__fillcap_8
XFILLER_162_131 VDD VDD VSS VSS gf180mcu_as_sc_mcu7t3v3__fill_2
XFILLER_163_632 VDD VDD VSS VSS gf180mcu_as_sc_mcu7t3v3__fillcap_4
XFILLER_11_1352 VDD VDD VSS VSS gf180mcu_as_sc_mcu7t3v3__fill_2
XFILLER_163_676 VDD VDD VSS VSS gf180mcu_as_sc_mcu7t3v3__fillcap_8
XFILLER_190_473 VDD VDD VSS VSS gf180mcu_as_sc_mcu7t3v3__fillcap_8
XFILLER_134_65 VDD VDD VSS VSS gf180mcu_as_sc_mcu7t3v3__fillcap_8
Xmesh_tile_1006 VDD VDD VSS VSS sw_out[34] gf180mcu_as_sc_mcu7t3v3__tiel_4
XFILLER_150_53 VDD VDD VSS VSS gf180mcu_as_sc_mcu7t3v3__fillcap_16
XFILLER_166_1227 VDD VDD VSS VSS gf180mcu_as_sc_mcu7t3v3__fillcap_16
XFILLER_27_96 VDD VDD VSS VSS gf180mcu_as_sc_mcu7t3v3__fillcap_8
XFILLER_13_410 VDD VDD VSS VSS gf180mcu_as_sc_mcu7t3v3__fillcap_4
XFILLER_158_426 VDD VDD VSS VSS gf180mcu_as_sc_mcu7t3v3__fillcap_4
XFILLER_185_212 VDD VDD VSS VSS gf180mcu_as_sc_mcu7t3v3__fillcap_16
XFILLER_43_51 VDD VDD VSS VSS gf180mcu_as_sc_mcu7t3v3__fillcap_8
XFILLER_186_779 VDD VDD VSS VSS gf180mcu_as_sc_mcu7t3v3__fill_1
XFILLER_16_1285 VDD VDD VSS VSS gf180mcu_as_sc_mcu7t3v3__fillcap_4
XTAP_TAPCELL_ROW_152_1125 VDD VSS gf180mcu_as_sc_mcu7t3v3__tap_2
XTAP_TAPCELL_ROW_152_1114 VDD VSS gf180mcu_as_sc_mcu7t3v3__tap_2
XFILLER_153_142 VDD VDD VSS VSS gf180mcu_as_sc_mcu7t3v3__fillcap_16
XFILLER_181_462 VDD VDD VSS VSS gf180mcu_as_sc_mcu7t3v3__fill_2
XTAP_TAPCELL_ROW_152_1136 VDD VSS gf180mcu_as_sc_mcu7t3v3__tap_2
XFILLER_175_72 VDD VDD VSS VSS gf180mcu_as_sc_mcu7t3v3__fillcap_4
XFILLER_4_174 VDD VDD VSS VSS gf180mcu_as_sc_mcu7t3v3__fill_1
XFILLER_4_34 VDD VDD VSS VSS gf180mcu_as_sc_mcu7t3v3__fill_1
XFILLER_67_104 VDD VDD VSS VSS gf180mcu_as_sc_mcu7t3v3__fill_1
XFILLER_62_1272 VDD VDD VSS VSS gf180mcu_as_sc_mcu7t3v3__fill_1
XFILLER_23_1256 VDD VDD VSS VSS gf180mcu_as_sc_mcu7t3v3__fillcap_16
Xinput270 VDD VDD VSS VSS sw_in[18] _4155_/A gf180mcu_as_sc_mcu7t3v3__buff_12
Xinput281 VDD VDD VSS VSS sw_in[28] _4238_/A gf180mcu_as_sc_mcu7t3v3__buff_12
X_3040_ VDD VDD VSS VSS _3162_/A _4771_/Q _4278_/B gf180mcu_as_sc_mcu7t3v3__and2_2
Xinput292 VDD VDD VSS VSS sw_in[5] _4050_/A gf180mcu_as_sc_mcu7t3v3__buff_12
XFILLER_189_562 VDD VDD VSS VSS gf180mcu_as_sc_mcu7t3v3__fillcap_16
X_3942_ VDD VDD VSS VSS _3942_/D _3942_/A _3964_/B _3964_/C _3943_/D gf180mcu_as_sc_mcu7t3v3__ao31_2
X_3873_ VDD VDD VSS VSS _3933_/S _3873_/B _4212_/A _3874_/B gf180mcu_as_sc_mcu7t3v3__mux2_2
X_2824_ VDD VDD VSS VSS _2897_/B _4145_/A _2825_/D gf180mcu_as_sc_mcu7t3v3__or2_2
XFILLER_164_407 VDD VDD VSS VSS gf180mcu_as_sc_mcu7t3v3__fill_2
X_2755_ VDD VDD VSS VSS _4782_/Q _2828_/B _2828_/C _4085_/D _2757_/C gf180mcu_as_sc_mcu7t3v3__ao22_2
X_2686_ VDD VDD VSS VSS _4023_/D _2902_/B _2686_/C _2686_/D _2687_/C gf180mcu_as_sc_mcu7t3v3__ao211_2
X_4425_ VDD VDD VSS VSS clkload8/A _4425_/D _4425_/Q gf180mcu_as_sc_mcu7t3v3__dfxtp_2
X_4356_ VDD VDD VSS VSS _4576_/CLK _4356_/D _4356_/Q gf180mcu_as_sc_mcu7t3v3__dfxtp_2
X_3307_ VDD VDD VSS VSS _4529_/Q _3315_/B _3315_/C _4530_/Q _3308_/C gf180mcu_as_sc_mcu7t3v3__ao22_2
Xfanout459 VDD VDD VSS VSS _3933_/S _3883_/S gf180mcu_as_sc_mcu7t3v3__buff_12
X_4287_ VDD VDD VSS VSS _4288_/D _4287_/B _4287_/A gf180mcu_as_sc_mcu7t3v3__nor2_2
XTAP_TAPCELL_ROW_187_1799 VDD VSS gf180mcu_as_sc_mcu7t3v3__tap_2
XFILLER_41_1323 VDD VDD VSS VSS gf180mcu_as_sc_mcu7t3v3__fill_1
Xmesh_tile_863 VDD VDD VSS VSS ne_out[35] gf180mcu_as_sc_mcu7t3v3__tiel_4
Xmesh_tile_852 VDD VDD VSS VSS ne_out[24] gf180mcu_as_sc_mcu7t3v3__tiel_4
Xmesh_tile_841 VDD VDD VSS VSS ne_out[13] gf180mcu_as_sc_mcu7t3v3__tiel_4
Xmesh_tile_830 VDD VDD VSS VSS ne_out[2] gf180mcu_as_sc_mcu7t3v3__tiel_4
X_3238_ VDD VDD VSS VSS _3242_/B _4334_/Q _3304_/S gf180mcu_as_sc_mcu7t3v3__nand2b_2
XTAP_TAPCELL_ROW_22_3_1933 VDD VSS gf180mcu_as_sc_mcu7t3v3__tap_2
Xmesh_tile_896 VDD VDD VSS VSS north_out[32] gf180mcu_as_sc_mcu7t3v3__tiel_4
Xmesh_tile_885 VDD VDD VSS VSS north_out[21] gf180mcu_as_sc_mcu7t3v3__tiel_4
Xmesh_tile_874 VDD VDD VSS VSS north_out[10] gf180mcu_as_sc_mcu7t3v3__tiel_4
X_3169_ VDD VDD VSS VSS _3176_/B _3169_/C _3201_/S _3188_/A gf180mcu_as_sc_mcu7t3v3__aoi21_2
XFILLER_147_6 VDD VDD VSS VSS gf180mcu_as_sc_mcu7t3v3__fillcap_16
XFILLER_167_212 VDD VDD VSS VSS gf180mcu_as_sc_mcu7t3v3__fillcap_4
XFILLER_168_746 VDD VDD VSS VSS gf180mcu_as_sc_mcu7t3v3__fill_1
XFILLER_7_907 VDD VDD VSS VSS gf180mcu_as_sc_mcu7t3v3__fill_2
XFILLER_10_457 VDD VDD VSS VSS gf180mcu_as_sc_mcu7t3v3__fill_1
XFILLER_13_87 VDD VDD VSS VSS gf180mcu_as_sc_mcu7t3v3__fillcap_4
XFILLER_13_98 VDD VDD VSS VSS gf180mcu_as_sc_mcu7t3v3__fillcap_4
XFILLER_164_941 VDD VDD VSS VSS gf180mcu_as_sc_mcu7t3v3__fillcap_4
XFILLER_89_14 VDD VDD VSS VSS gf180mcu_as_sc_mcu7t3v3__fillcap_8
XFILLER_164_963 VDD VDD VSS VSS gf180mcu_as_sc_mcu7t3v3__fill_1
XFILLER_150_101 VDD VDD VSS VSS gf180mcu_as_sc_mcu7t3v3__fillcap_4
XFILLER_2_612 VDD VDD VSS VSS gf180mcu_as_sc_mcu7t3v3__fill_2
XFILLER_85_1272 VDD VDD VSS VSS gf180mcu_as_sc_mcu7t3v3__fillcap_8
XFILLER_172_1242 VDD VDD VSS VSS gf180mcu_as_sc_mcu7t3v3__fill_2
XFILLER_46_1267 VDD VDD VSS VSS gf180mcu_as_sc_mcu7t3v3__fillcap_8
XFILLER_49_104 VDD VDD VSS VSS gf180mcu_as_sc_mcu7t3v3__fill_1
XFILLER_172_1297 VDD VDD VSS VSS gf180mcu_as_sc_mcu7t3v3__fillcap_8
XFILLER_38_84 VDD VDD VSS VSS gf180mcu_as_sc_mcu7t3v3__fillcap_16
XFILLER_166_1057 VDD VDD VSS VSS gf180mcu_as_sc_mcu7t3v3__fill_2
XFILLER_13_240 VDD VDD VSS VSS gf180mcu_as_sc_mcu7t3v3__fill_1
XFILLER_144_1344 VDD VDD VSS VSS gf180mcu_as_sc_mcu7t3v3__fill_2
XFILLER_159_724 VDD VDD VSS VSS gf180mcu_as_sc_mcu7t3v3__fill_2
XTAP_TAPCELL_ROW_126_3_2037 VDD VSS gf180mcu_as_sc_mcu7t3v3__tap_2
XFILLER_159_768 VDD VDD VSS VSS gf180mcu_as_sc_mcu7t3v3__fill_2
XTAP_TAPCELL_ROW_12_920 VDD VSS gf180mcu_as_sc_mcu7t3v3__tap_2
XFILLER_186_576 VDD VDD VSS VSS gf180mcu_as_sc_mcu7t3v3__fillcap_16
Xclkload14 VDD VDD VSS VSS _4445_/CLK clkload14/Y gf180mcu_as_sc_mcu7t3v3__clkbuff_4
Xclkload25 VDD VDD VSS VSS _4830_/CLK clkload25/Y gf180mcu_as_sc_mcu7t3v3__clkbuff_4
XTAP_TAPCELL_ROW_171_1501 VDD VSS gf180mcu_as_sc_mcu7t3v3__tap_2
XFILLER_6_951 VDD VDD VSS VSS gf180mcu_as_sc_mcu7t3v3__fill_1
X_2540_ VDD VDD VSS VSS _3471_/B _4629_/Q _2543_/C gf180mcu_as_sc_mcu7t3v3__and2_2
XFILLER_170_944 VDD VDD VSS VSS gf180mcu_as_sc_mcu7t3v3__fill_1
XFILLER_182_782 VDD VDD VSS VSS gf180mcu_as_sc_mcu7t3v3__fillcap_16
X_2471_ VDD VDD VSS VSS _2487_/S _4817_/Q _4826_/Q _2474_/A gf180mcu_as_sc_mcu7t3v3__mux2_2
X_4210_ VDD VDD VSS VSS _4210_/A _4210_/B _4237_/B _4210_/D _4211_/D gf180mcu_as_sc_mcu7t3v3__ao22_2
XFILLER_190_1353 VDD VDD VSS VSS gf180mcu_as_sc_mcu7t3v3__fill_2
X_4141_ VDD VDD VSS VSS _4141_/A _4149_/B _4149_/C _4141_/D _4142_/C gf180mcu_as_sc_mcu7t3v3__ao22_2
XTAP_TAPCELL_ROW_169_1463 VDD VSS gf180mcu_as_sc_mcu7t3v3__tap_2
XTAP_TAPCELL_ROW_169_1452 VDD VSS gf180mcu_as_sc_mcu7t3v3__tap_2
X_4072_ VDD VDD VSS VSS _4072_/A _4153_/B _4072_/C _4072_/D _4073_/C gf180mcu_as_sc_mcu7t3v3__ao211_2
XPHY_EDGE_ROW_133_1_Left_325 VDD VSS gf180mcu_as_sc_mcu7t3v3__tap_2
X_3023_ VDD VDD VSS VSS _3024_/C _4433_/Q _3023_/A _4433_/D gf180mcu_as_sc_mcu7t3v3__mux2_2
XTAP_TAPCELL_ROW_182_1696 VDD VSS gf180mcu_as_sc_mcu7t3v3__tap_2
XTAP_TAPCELL_ROW_69_3_1980 VDD VSS gf180mcu_as_sc_mcu7t3v3__tap_2
XFILLER_149_1288 VDD VDD VSS VSS gf180mcu_as_sc_mcu7t3v3__fill_2
XFILLER_184_1157 VDD VDD VSS VSS gf180mcu_as_sc_mcu7t3v3__fill_1
X_3925_ VDD VDD VSS VSS _3925_/S _3925_/B _4266_/A _3926_/C gf180mcu_as_sc_mcu7t3v3__mux2_2
Xclkload8 VDD VDD VSS VSS clkload8/A clkload8/Y gf180mcu_as_sc_mcu7t3v3__clkbuff_12
X_3856_ VDD VDD VSS VSS _4680_/D _4229_/D _3856_/B _3856_/A gf180mcu_as_sc_mcu7t3v3__aoi21_2
XFILLER_158_790 VDD VDD VSS VSS gf180mcu_as_sc_mcu7t3v3__fillcap_4
XFILLER_192_535 VDD VDD VSS VSS gf180mcu_as_sc_mcu7t3v3__fillcap_4
XFILLER_192_546 VDD VDD VSS VSS gf180mcu_as_sc_mcu7t3v3__fill_1
X_3787_ VDD VDD VSS VSS _3788_/D _4132_/A _3880_/A _3953_/C gf180mcu_as_sc_mcu7t3v3__ao21_2
X_2807_ VDD VDD VSS VSS _4130_/A _2919_/B _2807_/C _2807_/D _2993_/A gf180mcu_as_sc_mcu7t3v3__ao22_2
X_2738_ VDD VDD VSS VSS _2829_/B _4068_/D _2739_/D gf180mcu_as_sc_mcu7t3v3__and2_2
XFILLER_69_1256 VDD VDD VSS VSS gf180mcu_as_sc_mcu7t3v3__fillcap_8
XFILLER_161_977 VDD VDD VSS VSS gf180mcu_as_sc_mcu7t3v3__fill_2
XFILLER_182_18 VDD VDD VSS VSS gf180mcu_as_sc_mcu7t3v3__fillcap_16
X_4408_ VDD VDD VSS VSS _4440_/CLK _4408_/D _4408_/Q gf180mcu_as_sc_mcu7t3v3__dfxtp_2
X_2669_ VDD VDD VSS VSS _4008_/A _2904_/B _2669_/C _2669_/D _2670_/C gf180mcu_as_sc_mcu7t3v3__ao211_2
XTAP_TAPCELL_ROW_189_1839 VDD VSS gf180mcu_as_sc_mcu7t3v3__tap_2
XTAP_TAPCELL_ROW_189_1828 VDD VSS gf180mcu_as_sc_mcu7t3v3__tap_2
XFILLER_160_476 VDD VDD VSS VSS gf180mcu_as_sc_mcu7t3v3__fillcap_4
XFILLER_115_34 VDD VDD VSS VSS gf180mcu_as_sc_mcu7t3v3__fillcap_4
X_4339_ VDD VDD VSS VSS clkload7/A _4339_/D _4339_/Q gf180mcu_as_sc_mcu7t3v3__dfxtp_2
XPHY_EDGE_ROW_65_1_Left_257 VDD VSS gf180mcu_as_sc_mcu7t3v3__tap_2
XFILLER_75_27 VDD VDD VSS VSS gf180mcu_as_sc_mcu7t3v3__fillcap_4
XFILLER_189_1068 VDD VDD VSS VSS gf180mcu_as_sc_mcu7t3v3__fillcap_8
XFILLER_188_819 VDD VDD VSS VSS gf180mcu_as_sc_mcu7t3v3__fill_1
XFILLER_13_1211 VDD VDD VSS VSS gf180mcu_as_sc_mcu7t3v3__fill_1
XFILLER_24_97 VDD VDD VSS VSS gf180mcu_as_sc_mcu7t3v3__fillcap_8
XFILLER_7_715 VDD VDD VSS VSS gf180mcu_as_sc_mcu7t3v3__fillcap_16
XFILLER_104_1350 VDD VDD VSS VSS gf180mcu_as_sc_mcu7t3v3__fillcap_4
XFILLER_7_759 VDD VDD VSS VSS gf180mcu_as_sc_mcu7t3v3__fill_1
XFILLER_156_30 VDD VDD VSS VSS gf180mcu_as_sc_mcu7t3v3__fillcap_4
XFILLER_6_247 VDD VDD VSS VSS gf180mcu_as_sc_mcu7t3v3__fill_2
XFILLER_40_85 VDD VDD VSS VSS gf180mcu_as_sc_mcu7t3v3__fillcap_16
XFILLER_152_977 VDD VDD VSS VSS gf180mcu_as_sc_mcu7t3v3__fillcap_8
XFILLER_152_988 VDD VDD VSS VSS gf180mcu_as_sc_mcu7t3v3__fillcap_16
Xload_slew607 VDD VDD VSS VSS _2662_/Y fanout605/A gf180mcu_as_sc_mcu7t3v3__clkbuff_12
XFILLER_172_1072 VDD VDD VSS VSS gf180mcu_as_sc_mcu7t3v3__fillcap_4
XFILLER_49_72 VDD VDD VSS VSS gf180mcu_as_sc_mcu7t3v3__fillcap_16
XFILLER_172_1083 VDD VDD VSS VSS gf180mcu_as_sc_mcu7t3v3__fill_2
XFILLER_168_1119 VDD VDD VSS VSS gf180mcu_as_sc_mcu7t3v3__fillcap_8
XTAP_TAPCELL_ROW_164_1371 VDD VSS gf180mcu_as_sc_mcu7t3v3__tap_2
XTAP_TAPCELL_ROW_164_1360 VDD VSS gf180mcu_as_sc_mcu7t3v3__tap_2
XTAP_TAPCELL_ROW_160_1279 VDD VSS gf180mcu_as_sc_mcu7t3v3__tap_2
XFILLER_159_532 VDD VDD VSS VSS gf180mcu_as_sc_mcu7t3v3__fillcap_8
X_3710_ VDD VDD VSS VSS _4064_/D _3930_/B _3710_/C _3710_/D _3711_/C gf180mcu_as_sc_mcu7t3v3__ao211_2
XFILLER_109_1294 VDD VDD VSS VSS gf180mcu_as_sc_mcu7t3v3__fill_2
X_4690_ VDD VDD VSS VSS _4692_/CLK _4690_/D _4690_/Q gf180mcu_as_sc_mcu7t3v3__dfxtp_2
XFILLER_174_524 VDD VDD VSS VSS gf180mcu_as_sc_mcu7t3v3__fill_1
X_3641_ VDD VDD VSS VSS _3641_/Y _3869_/B _3641_/A gf180mcu_as_sc_mcu7t3v3__nor2b_2
XFILLER_179_1248 VDD VDD VSS VSS gf180mcu_as_sc_mcu7t3v3__fillcap_8
X_3572_ VDD VDD VSS VSS _4631_/Q _3572_/B _3611_/C _3573_/C _3582_/B gf180mcu_as_sc_mcu7t3v3__aoi31_2
X_2523_ VDD VDD VSS VSS _3513_/A _2523_/B _2523_/C _2523_/D _3080_/B gf180mcu_as_sc_mcu7t3v3__ao211_2
XFILLER_170_730 VDD VDD VSS VSS gf180mcu_as_sc_mcu7t3v3__fillcap_4
X_2454_ VDD VDD VSS VSS _2455_/A _2454_/B _2454_/C _2454_/D _2454_/Y gf180mcu_as_sc_mcu7t3v3__ao22_2
XFILLER_9_1323 VDD VDD VSS VSS gf180mcu_as_sc_mcu7t3v3__fillcap_4
XFILLER_190_1161 VDD VDD VSS VSS gf180mcu_as_sc_mcu7t3v3__fill_2
X_2385_ VDD VDD VSS VSS _2393_/C _2385_/B _2385_/A _2386_/B gf180mcu_as_sc_mcu7t3v3__mux2_2
XFILLER_5_1209 VDD VDD VSS VSS gf180mcu_as_sc_mcu7t3v3__fill_1
X_4124_ VDD VDD VSS VSS _4124_/A _4214_/B _4214_/C _4124_/D _4125_/C gf180mcu_as_sc_mcu7t3v3__ao22_2
XTAP_TAPCELL_ROW_184_1747 VDD VSS gf180mcu_as_sc_mcu7t3v3__tap_2
XTAP_TAPCELL_ROW_184_1736 VDD VSS gf180mcu_as_sc_mcu7t3v3__tap_2
Xinput1 VDD VDD VSS VSS boot_addr[0] input1/Y gf180mcu_as_sc_mcu7t3v3__buff_12
XPHY_EDGE_ROW_149_3_Right_190 VDD VSS gf180mcu_as_sc_mcu7t3v3__tap_2
X_4055_ VDD VDD VSS VSS _4055_/A _4143_/B _4235_/B _4055_/D _4056_/D gf180mcu_as_sc_mcu7t3v3__ao22_2
X_3006_ VDD VDD VSS VSS _3006_/A _3006_/B _3006_/C _4418_/Q _4418_/D gf180mcu_as_sc_mcu7t3v3__ao22_2
XPHY_EDGE_ROW_177_Right_39 VDD VSS gf180mcu_as_sc_mcu7t3v3__tap_2
X_3908_ VDD VDD VSS VSS _3925_/S _3908_/B _4245_/A _3909_/C gf180mcu_as_sc_mcu7t3v3__mux2_2
XFILLER_165_524 VDD VDD VSS VSS gf180mcu_as_sc_mcu7t3v3__fillcap_8
X_3839_ VDD VDD VSS VSS _3871_/C _4185_/A _3845_/C gf180mcu_as_sc_mcu7t3v3__and2_2
XFILLER_152_218 VDD VDD VSS VSS gf180mcu_as_sc_mcu7t3v3__fillcap_16
XFILLER_156_1001 VDD VDD VSS VSS gf180mcu_as_sc_mcu7t3v3__fillcap_8
XFILLER_180_527 VDD VDD VSS VSS gf180mcu_as_sc_mcu7t3v3__fill_2
XFILLER_192_376 VDD VDD VSS VSS gf180mcu_as_sc_mcu7t3v3__fillcap_4
Xoutput371 VDD VDD VSS VSS _4697_/Q east_out[4] gf180mcu_as_sc_mcu7t3v3__buff_12
Xoutput360 VDD VDD VSS VSS _4720_/Q east_out[27] gf180mcu_as_sc_mcu7t3v3__buff_12
XFILLER_0_924 VDD VDD VSS VSS gf180mcu_as_sc_mcu7t3v3__fill_1
XFILLER_0_935 VDD VDD VSS VSS gf180mcu_as_sc_mcu7t3v3__fill_2
XFILLER_120_104 VDD VDD VSS VSS gf180mcu_as_sc_mcu7t3v3__fill_1
XFILLER_134_1310 VDD VDD VSS VSS gf180mcu_as_sc_mcu7t3v3__fill_1
XFILLER_160_273 VDD VDD VSS VSS gf180mcu_as_sc_mcu7t3v3__fill_2
XFILLER_47_1351 VDD VDD VSS VSS gf180mcu_as_sc_mcu7t3v3__fillcap_4
Xoutput393 VDD VDD VSS VSS _4681_/Q south_out[24] gf180mcu_as_sc_mcu7t3v3__buff_12
Xoutput382 VDD VDD VSS VSS _4671_/Q south_out[14] gf180mcu_as_sc_mcu7t3v3__buff_12
XPHY_EDGE_ROW_186_Right_48 VDD VSS gf180mcu_as_sc_mcu7t3v3__tap_2
XFILLER_134_1354 VDD VDD VSS VSS gf180mcu_as_sc_mcu7t3v3__fill_1
XFILLER_142_10 VDD VDD VSS VSS gf180mcu_as_sc_mcu7t3v3__fill_1
XTAP_TAPCELL_ROW_3_751 VDD VSS gf180mcu_as_sc_mcu7t3v3__tap_2
XTAP_TAPCELL_ROW_3_740 VDD VSS gf180mcu_as_sc_mcu7t3v3__tap_2
XFILLER_167_1152 VDD VDD VSS VSS gf180mcu_as_sc_mcu7t3v3__fill_1
XFILLER_167_1163 VDD VDD VSS VSS gf180mcu_as_sc_mcu7t3v3__fillcap_16
XFILLER_141_1303 VDD VDD VSS VSS gf180mcu_as_sc_mcu7t3v3__fillcap_8
XFILLER_156_524 VDD VDD VSS VSS gf180mcu_as_sc_mcu7t3v3__fill_1
XFILLER_184_877 VDD VDD VSS VSS gf180mcu_as_sc_mcu7t3v3__fillcap_4
XFILLER_171_516 VDD VDD VSS VSS gf180mcu_as_sc_mcu7t3v3__fill_1
XFILLER_183_387 VDD VDD VSS VSS gf180mcu_as_sc_mcu7t3v3__fillcap_4
XFILLER_152_774 VDD VDD VSS VSS gf180mcu_as_sc_mcu7t3v3__fillcap_8
XFILLER_183_50 VDD VDD VSS VSS gf180mcu_as_sc_mcu7t3v3__fillcap_16
XFILLER_183_72 VDD VDD VSS VSS gf180mcu_as_sc_mcu7t3v3__fillcap_4
XFILLER_61_1326 VDD VDD VSS VSS gf180mcu_as_sc_mcu7t3v3__fill_2
XTAP_TAPCELL_ROW_166_1400 VDD VSS gf180mcu_as_sc_mcu7t3v3__tap_2
XPHY_EDGE_ROW_120_1_Right_629 VDD VSS gf180mcu_as_sc_mcu7t3v3__tap_2
XFILLER_4_1220 VDD VDD VSS VSS gf180mcu_as_sc_mcu7t3v3__fillcap_4
XTAP_TAPCELL_ROW_162_1319 VDD VSS gf180mcu_as_sc_mcu7t3v3__tap_2
XFILLER_178_104 VDD VDD VSS VSS gf180mcu_as_sc_mcu7t3v3__fill_1
XFILLER_178_115 VDD VDD VSS VSS gf180mcu_as_sc_mcu7t3v3__fill_2
XFILLER_59_1288 VDD VDD VSS VSS gf180mcu_as_sc_mcu7t3v3__fillcap_16
X_4811_ VDD VDD VSS VSS _4829_/CLK _4811_/D _4811_/Q gf180mcu_as_sc_mcu7t3v3__dfxtp_2
XFILLER_175_800 VDD VDD VSS VSS gf180mcu_as_sc_mcu7t3v3__fill_2
X_4742_ VDD VDD VSS VSS _4751_/CLK _4742_/D _4742_/Q gf180mcu_as_sc_mcu7t3v3__dfxtp_2
X_4673_ VDD VDD VSS VSS clkload5/A _4673_/D _4673_/Q gf180mcu_as_sc_mcu7t3v3__dfxtp_2
XFILLER_175_877 VDD VDD VSS VSS gf180mcu_as_sc_mcu7t3v3__fill_1
X_3624_ VDD VDD VSS VSS _3962_/A _3966_/A _3635_/A gf180mcu_as_sc_mcu7t3v3__and2_2
XFILLER_122_1280 VDD VDD VSS VSS gf180mcu_as_sc_mcu7t3v3__fill_2
XFILLER_122_1291 VDD VDD VSS VSS gf180mcu_as_sc_mcu7t3v3__fillcap_4
XFILLER_162_516 VDD VDD VSS VSS gf180mcu_as_sc_mcu7t3v3__fillcap_8
XFILLER_162_527 VDD VDD VSS VSS gf180mcu_as_sc_mcu7t3v3__fillcap_16
XFILLER_174_387 VDD VDD VSS VSS gf180mcu_as_sc_mcu7t3v3__fillcap_16
XFILLER_179_1056 VDD VDD VSS VSS gf180mcu_as_sc_mcu7t3v3__fill_2
XFILLER_157_1332 VDD VDD VSS VSS gf180mcu_as_sc_mcu7t3v3__fill_1
XFILLER_190_869 VDD VDD VSS VSS gf180mcu_as_sc_mcu7t3v3__fillcap_4
XFILLER_192_1223 VDD VDD VSS VSS gf180mcu_as_sc_mcu7t3v3__fill_1
X_3555_ VDD VDD VSS VSS _4621_/D _4621_/Q _3555_/B _3555_/C gf180mcu_as_sc_mcu7t3v3__ao21_2
Xmax_cap765 VDD VDD VSS VSS _2189_/Y _4292_/A gf180mcu_as_sc_mcu7t3v3__clkbuff_12
X_3486_ VDD VDD VSS VSS _3507_/A _3503_/B gf180mcu_as_sc_mcu7t3v3__inv_2
X_2506_ VDD VDD VSS VSS _2506_/B _3454_/A _3571_/A gf180mcu_as_sc_mcu7t3v3__and2_2
XFILLER_102_104 VDD VDD VSS VSS gf180mcu_as_sc_mcu7t3v3__fill_1
XFILLER_170_593 VDD VDD VSS VSS gf180mcu_as_sc_mcu7t3v3__fill_2
X_2437_ VDD VDD VSS VSS _2438_/D _2461_/C _2437_/B _2437_/A gf180mcu_as_sc_mcu7t3v3__aoi21b_2
XFILLER_56_29 VDD VDD VSS VSS gf180mcu_as_sc_mcu7t3v3__fillcap_4
XFILLER_5_1028 VDD VDD VSS VSS gf180mcu_as_sc_mcu7t3v3__fillcap_4
XFILLER_5_1039 VDD VDD VSS VSS gf180mcu_as_sc_mcu7t3v3__fill_2
X_2368_ VDD VDD VSS VSS _2371_/B _2391_/A _4611_/Q gf180mcu_as_sc_mcu7t3v3__nand2_2
X_4107_ VDD VDD VSS VSS _4705_/D _4107_/C _4138_/B _4107_/A gf180mcu_as_sc_mcu7t3v3__aoi21_2
X_2299_ VDD VDD VSS VSS _4810_/D _3414_/A _2299_/A gf180mcu_as_sc_mcu7t3v3__nor2b_2
XFILLER_42_1281 VDD VDD VSS VSS gf180mcu_as_sc_mcu7t3v3__fillcap_8
X_4038_ VDD VDD VSS VSS _4040_/C _4151_/A _4038_/B _4038_/C gf180mcu_as_sc_mcu7t3v3__ao21_2
XFILLER_164_1325 VDD VDD VSS VSS gf180mcu_as_sc_mcu7t3v3__fillcap_16
XFILLER_13_828 VDD VDD VSS VSS gf180mcu_as_sc_mcu7t3v3__fill_1
XFILLER_185_619 VDD VDD VSS VSS gf180mcu_as_sc_mcu7t3v3__fill_1
XANTENNA_50 VDD VDD VSS VSS _4715_/D gf180mcu_as_sc_mcu7t3v3__diode_2
XTAP_TAPCELL_ROW_64_1_1017 VDD VSS gf180mcu_as_sc_mcu7t3v3__tap_2
XANTENNA_61 VDD VDD VSS VSS _3828_/B gf180mcu_as_sc_mcu7t3v3__diode_2
XFILLER_177_192 VDD VDD VSS VSS gf180mcu_as_sc_mcu7t3v3__fillcap_16
XFILLER_181_803 VDD VDD VSS VSS gf180mcu_as_sc_mcu7t3v3__fillcap_8
XFILLER_158_1118 VDD VDD VSS VSS gf180mcu_as_sc_mcu7t3v3__fillcap_8
XFILLER_181_836 VDD VDD VSS VSS gf180mcu_as_sc_mcu7t3v3__fillcap_4
XFILLER_21_65 VDD VDD VSS VSS gf180mcu_as_sc_mcu7t3v3__fillcap_4
XFILLER_137_76 VDD VDD VSS VSS gf180mcu_as_sc_mcu7t3v3__fill_2
XFILLER_180_368 VDD VDD VSS VSS gf180mcu_as_sc_mcu7t3v3__fillcap_16
XFILLER_161_582 VDD VDD VSS VSS gf180mcu_as_sc_mcu7t3v3__fillcap_16
XFILLER_171_1329 VDD VDD VSS VSS gf180mcu_as_sc_mcu7t3v3__fill_1
Xdelaybuf_2_clk VDD VDD VSS VSS delaybuf_2_clk/A clkbuf_0_clk/A gf180mcu_as_sc_mcu7t3v3__clkbuff_12
XTAP_TAPCELL_ROW_8_843 VDD VSS gf180mcu_as_sc_mcu7t3v3__tap_2
XFILLER_97_69 VDD VDD VSS VSS gf180mcu_as_sc_mcu7t3v3__fill_1
XFILLER_46_95 VDD VDD VSS VSS gf180mcu_as_sc_mcu7t3v3__fillcap_8
XFILLER_188_446 VDD VDD VSS VSS gf180mcu_as_sc_mcu7t3v3__fillcap_8
XFILLER_189_958 VDD VDD VSS VSS gf180mcu_as_sc_mcu7t3v3__fillcap_8
XFILLER_30_102 VDD VDD VSS VSS gf180mcu_as_sc_mcu7t3v3__fill_2
XPHY_EDGE_ROW_29_3_Left_401 VDD VSS gf180mcu_as_sc_mcu7t3v3__tap_2
XFILLER_62_61 VDD VDD VSS VSS gf180mcu_as_sc_mcu7t3v3__fillcap_4
XFILLER_12_872 VDD VDD VSS VSS gf180mcu_as_sc_mcu7t3v3__fill_2
XFILLER_169_693 VDD VDD VSS VSS gf180mcu_as_sc_mcu7t3v3__fillcap_4
XFILLER_175_118 VDD VDD VSS VSS gf180mcu_as_sc_mcu7t3v3__fillcap_16
XFILLER_184_630 VDD VDD VSS VSS gf180mcu_as_sc_mcu7t3v3__fillcap_8
XFILLER_62_94 VDD VDD VSS VSS gf180mcu_as_sc_mcu7t3v3__fillcap_8
XTAP_TAPCELL_ROW_159_1270 VDD VSS gf180mcu_as_sc_mcu7t3v3__tap_2
XFILLER_7_34 VDD VDD VSS VSS gf180mcu_as_sc_mcu7t3v3__fillcap_16
XPHY_EDGE_ROW_142_1_Left_334 VDD VSS gf180mcu_as_sc_mcu7t3v3__tap_2
XFILLER_156_387 VDD VDD VSS VSS gf180mcu_as_sc_mcu7t3v3__fillcap_16
XFILLER_7_89 VDD VDD VSS VSS gf180mcu_as_sc_mcu7t3v3__fill_1
XTAP_TAPCELL_ROW_155_1189 VDD VSS gf180mcu_as_sc_mcu7t3v3__tap_2
XFILLER_171_368 VDD VDD VSS VSS gf180mcu_as_sc_mcu7t3v3__fill_2
X_3340_ VDD VDD VSS VSS _3340_/A _3340_/B _3340_/C _3340_/D _4533_/D gf180mcu_as_sc_mcu7t3v3__ao211_2
XFILLER_65_1270 VDD VDD VSS VSS gf180mcu_as_sc_mcu7t3v3__fill_1
X_3271_ VDD VDD VSS VSS _3274_/C _4425_/Q _3296_/S gf180mcu_as_sc_mcu7t3v3__nand2_2
X_2222_ VDD VDD VSS VSS _4188_/A _2222_/A gf180mcu_as_sc_mcu7t3v3__inv_2
XFILLER_185_1071 VDD VDD VSS VSS gf180mcu_as_sc_mcu7t3v3__fillcap_16
XTAP_TAPCELL_ROW_179_1646 VDD VSS gf180mcu_as_sc_mcu7t3v3__tap_2
XFILLER_166_107 VDD VDD VSS VSS gf180mcu_as_sc_mcu7t3v3__fillcap_16
XFILLER_179_479 VDD VDD VSS VSS gf180mcu_as_sc_mcu7t3v3__fillcap_8
X_2986_ VDD VDD VSS VSS _2986_/A _2993_/B _2993_/C _4398_/Q _4398_/D gf180mcu_as_sc_mcu7t3v3__ao22_2
XPHY_EDGE_ROW_74_1_Left_266 VDD VSS gf180mcu_as_sc_mcu7t3v3__tap_2
X_4725_ VDD VDD VSS VSS _4726_/CLK _4725_/D _4725_/Q gf180mcu_as_sc_mcu7t3v3__dfxtp_2
XFILLER_162_313 VDD VDD VSS VSS gf180mcu_as_sc_mcu7t3v3__fill_2
XFILLER_174_173 VDD VDD VSS VSS gf180mcu_as_sc_mcu7t3v3__fill_2
X_4656_ VDD VDD VSS VSS _4826_/CLK _4656_/D _4656_/Q gf180mcu_as_sc_mcu7t3v3__dfxtp_2
X_4587_ VDD VDD VSS VSS _4826_/CLK _4587_/D _4587_/Q gf180mcu_as_sc_mcu7t3v3__dfxtp_2
Xinput70 VDD VDD VSS VSS east_in[33] _3953_/A gf180mcu_as_sc_mcu7t3v3__buff_12
Xinput81 VDD VDD VSS VSS ne_in[10] _4087_/A gf180mcu_as_sc_mcu7t3v3__buff_12
X_3607_ VDD VDD VSS VSS _3608_/C _3607_/B _3607_/A gf180mcu_as_sc_mcu7t3v3__nand2_2
XTAP_TAPCELL_ROW_125_1_1078 VDD VSS gf180mcu_as_sc_mcu7t3v3__tap_2
XFILLER_157_1140 VDD VDD VSS VSS gf180mcu_as_sc_mcu7t3v3__fill_1
XFILLER_162_357 VDD VDD VSS VSS gf180mcu_as_sc_mcu7t3v3__fillcap_16
Xinput92 VDD VDD VSS VSS ne_in[20] _4169_/A gf180mcu_as_sc_mcu7t3v3__buff_12
X_3538_ VDD VDD VSS VSS _3583_/A _3538_/B _4461_/Q _4614_/D gf180mcu_as_sc_mcu7t3v3__mux2_2
XFILLER_157_1184 VDD VDD VSS VSS gf180mcu_as_sc_mcu7t3v3__fillcap_4
XFILLER_192_1053 VDD VDD VSS VSS gf180mcu_as_sc_mcu7t3v3__fill_1
XFILLER_192_1064 VDD VDD VSS VSS gf180mcu_as_sc_mcu7t3v3__fill_2
X_3469_ VDD VDD VSS VSS _4588_/D _3469_/A _3481_/A _3469_/C gf180mcu_as_sc_mcu7t3v3__ao21_2
XFILLER_190_18 VDD VDD VSS VSS gf180mcu_as_sc_mcu7t3v3__fillcap_16
XFILLER_177_6 VDD VDD VSS VSS gf180mcu_as_sc_mcu7t3v3__fillcap_16
XFILLER_164_1133 VDD VDD VSS VSS gf180mcu_as_sc_mcu7t3v3__fill_2
XFILLER_129_1297 VDD VDD VSS VSS gf180mcu_as_sc_mcu7t3v3__fillcap_4
Xsram2048.u_bank1_823 VDD VDD VSS VSS sram2048.u_bank1/WEN[2] gf180mcu_as_sc_mcu7t3v3__tiel_4
XFILLER_157_129 VDD VDD VSS VSS gf180mcu_as_sc_mcu7t3v3__fill_1
XFILLER_8_117 VDD VDD VSS VSS gf180mcu_as_sc_mcu7t3v3__fillcap_8
XFILLER_154_803 VDD VDD VSS VSS gf180mcu_as_sc_mcu7t3v3__fill_2
XFILLER_178_490 VDD VDD VSS VSS gf180mcu_as_sc_mcu7t3v3__fill_2
XFILLER_181_655 VDD VDD VSS VSS gf180mcu_as_sc_mcu7t3v3__fillcap_4
XFILLER_153_368 VDD VDD VSS VSS gf180mcu_as_sc_mcu7t3v3__fill_2
XFILLER_88_1281 VDD VDD VSS VSS gf180mcu_as_sc_mcu7t3v3__fill_1
XFILLER_175_1273 VDD VDD VSS VSS gf180mcu_as_sc_mcu7t3v3__fillcap_8
XFILLER_181_699 VDD VDD VSS VSS gf180mcu_as_sc_mcu7t3v3__fill_1
XFILLER_4_389 VDD VDD VSS VSS gf180mcu_as_sc_mcu7t3v3__fill_1
XFILLER_175_1295 VDD VDD VSS VSS gf180mcu_as_sc_mcu7t3v3__fillcap_16
XTAP_TAPCELL_ROW_40_3_1951 VDD VSS gf180mcu_as_sc_mcu7t3v3__tap_2
XFILLER_57_61 VDD VDD VSS VSS gf180mcu_as_sc_mcu7t3v3__fillcap_8
XFILLER_180_73 VDD VDD VSS VSS gf180mcu_as_sc_mcu7t3v3__fillcap_4
XFILLER_57_72 VDD VDD VSS VSS gf180mcu_as_sc_mcu7t3v3__fillcap_16
XFILLER_147_1342 VDD VDD VSS VSS gf180mcu_as_sc_mcu7t3v3__fillcap_4
XFILLER_1_1289 VDD VDD VSS VSS gf180mcu_as_sc_mcu7t3v3__fill_1
XFILLER_73_82 VDD VDD VSS VSS gf180mcu_as_sc_mcu7t3v3__fill_2
XFILLER_108_1348 VDD VDD VSS VSS gf180mcu_as_sc_mcu7t3v3__fillcap_4
XFILLER_189_82 VDD VDD VSS VSS gf180mcu_as_sc_mcu7t3v3__fill_2
X_2840_ VDD VDD VSS VSS _4158_/A _2894_/B _2840_/C _2840_/D _2841_/D gf180mcu_as_sc_mcu7t3v3__ao211_2
XTAP_TAPCELL_ROW_157_1229 VDD VSS gf180mcu_as_sc_mcu7t3v3__tap_2
XFILLER_191_408 VDD VDD VSS VSS gf180mcu_as_sc_mcu7t3v3__fillcap_8
X_2771_ VDD VDD VSS VSS _2771_/B _2943_/A _3020_/A gf180mcu_as_sc_mcu7t3v3__and2_2
XTAP_TAPCELL_ROW_174_1543 VDD VSS gf180mcu_as_sc_mcu7t3v3__tap_2
XFILLER_156_162 VDD VDD VSS VSS gf180mcu_as_sc_mcu7t3v3__fill_2
X_4510_ VDD VDD VSS VSS _4809_/CLK _4510_/D _4510_/Q gf180mcu_as_sc_mcu7t3v3__dfxtp_2
XTAP_TAPCELL_ROW_174_1554 VDD VSS gf180mcu_as_sc_mcu7t3v3__tap_2
XFILLER_32_1291 VDD VDD VSS VSS gf180mcu_as_sc_mcu7t3v3__fillcap_8
X_4726__1045 VDD VDD VSS VSS _4726_/D gf180mcu_as_sc_mcu7t3v3__tiel_4
X_4441_ VDD VDD VSS VSS _4447_/CLK _4441_/D _4441_/Q gf180mcu_as_sc_mcu7t3v3__dfxtp_2
XTAP_TAPCELL_ROW_10_881 VDD VSS gf180mcu_as_sc_mcu7t3v3__tap_2
XPHY_EDGE_ROW_9_Right_9 VDD VSS gf180mcu_as_sc_mcu7t3v3__tap_2
XFILLER_153_880 VDD VDD VSS VSS gf180mcu_as_sc_mcu7t3v3__fillcap_16
XFILLER_154_1313 VDD VDD VSS VSS gf180mcu_as_sc_mcu7t3v3__fill_2
XFILLER_28_1327 VDD VDD VSS VSS gf180mcu_as_sc_mcu7t3v3__fill_1
X_4372_ VDD VDD VSS VSS clkload8/A _4372_/D _4372_/Q gf180mcu_as_sc_mcu7t3v3__dfxtp_2
Xfanout619 VDD VDD VSS VSS _3506_/C _3503_/B gf180mcu_as_sc_mcu7t3v3__buff_12
X_3323_ VDD VDD VSS VSS _4531_/Q _3347_/B _3347_/C _4532_/Q _3324_/C gf180mcu_as_sc_mcu7t3v3__ao22_2
X_3254_ VDD VDD VSS VSS _3258_/B _4336_/Q _3328_/S gf180mcu_as_sc_mcu7t3v3__nand2b_2
XFILLER_152_1081 VDD VDD VSS VSS gf180mcu_as_sc_mcu7t3v3__fillcap_4
X_2205_ VDD VDD VSS VSS _2293_/B _4517_/Q gf180mcu_as_sc_mcu7t3v3__inv_2
XFILLER_187_1122 VDD VDD VSS VSS gf180mcu_as_sc_mcu7t3v3__fillcap_8
X_3185_ VDD VDD VSS VSS _3369_/A _3185_/B _3185_/C _3186_/D _3185_/D gf180mcu_as_sc_mcu7t3v3__aoi31_2
XTAP_TAPCELL_ROW_144_3_2055 VDD VSS gf180mcu_as_sc_mcu7t3v3__tap_2
XFILLER_161_1317 VDD VDD VSS VSS gf180mcu_as_sc_mcu7t3v3__fillcap_8
XFILLER_161_1339 VDD VDD VSS VSS gf180mcu_as_sc_mcu7t3v3__fillcap_8
XFILLER_167_438 VDD VDD VSS VSS gf180mcu_as_sc_mcu7t3v3__fillcap_16
X_2969_ VDD VDD VSS VSS _4386_/Q _2975_/B _3034_/A _2975_/D _4386_/D gf180mcu_as_sc_mcu7t3v3__ao22_2
XFILLER_185_18 VDD VDD VSS VSS gf180mcu_as_sc_mcu7t3v3__fillcap_8
X_4708_ VDD VDD VSS VSS _4708_/CLK _4708_/D _4708_/Q gf180mcu_as_sc_mcu7t3v3__dfxtp_2
XFILLER_159_1224 VDD VDD VSS VSS gf180mcu_as_sc_mcu7t3v3__fill_2
XFILLER_175_482 VDD VDD VSS VSS gf180mcu_as_sc_mcu7t3v3__fill_1
XFILLER_159_1257 VDD VDD VSS VSS gf180mcu_as_sc_mcu7t3v3__fill_2
XFILLER_191_975 VDD VDD VSS VSS gf180mcu_as_sc_mcu7t3v3__fill_1
X_4639_ VDD VDD VSS VSS _4831_/CLK _4639_/D _4639_/Q gf180mcu_as_sc_mcu7t3v3__dfxtp_2
XFILLER_163_699 VDD VDD VSS VSS gf180mcu_as_sc_mcu7t3v3__fill_1
XTAP_TAPCELL_ROW_59_1_1012 VDD VSS gf180mcu_as_sc_mcu7t3v3__tap_2
XFILLER_134_77 VDD VDD VSS VSS gf180mcu_as_sc_mcu7t3v3__fill_1
Xmesh_tile_1007 VDD VDD VSS VSS sw_out[35] gf180mcu_as_sc_mcu7t3v3__tiel_4
XFILLER_94_37 VDD VDD VSS VSS gf180mcu_as_sc_mcu7t3v3__fill_2
XFILLER_159_928 VDD VDD VSS VSS gf180mcu_as_sc_mcu7t3v3__fill_2
XFILLER_13_444 VDD VDD VSS VSS gf180mcu_as_sc_mcu7t3v3__fillcap_4
XFILLER_43_74 VDD VDD VSS VSS gf180mcu_as_sc_mcu7t3v3__fill_1
XFILLER_9_426 VDD VDD VSS VSS gf180mcu_as_sc_mcu7t3v3__fill_2
XFILLER_186_769 VDD VDD VSS VSS gf180mcu_as_sc_mcu7t3v3__fillcap_8
XFILLER_12_1117 VDD VDD VSS VSS gf180mcu_as_sc_mcu7t3v3__fillcap_4
XFILLER_142_1272 VDD VDD VSS VSS gf180mcu_as_sc_mcu7t3v3__fillcap_4
XFILLER_154_611 VDD VDD VSS VSS gf180mcu_as_sc_mcu7t3v3__fill_1
XFILLER_167_994 VDD VDD VSS VSS gf180mcu_as_sc_mcu7t3v3__fillcap_16
XFILLER_153_121 VDD VDD VSS VSS gf180mcu_as_sc_mcu7t3v3__fillcap_16
XFILLER_177_1313 VDD VDD VSS VSS gf180mcu_as_sc_mcu7t3v3__fillcap_16
XFILLER_181_430 VDD VDD VSS VSS gf180mcu_as_sc_mcu7t3v3__fillcap_4
XFILLER_5_632 VDD VDD VSS VSS gf180mcu_as_sc_mcu7t3v3__fill_1
XTAP_TAPCELL_ROW_152_1126 VDD VSS gf180mcu_as_sc_mcu7t3v3__tap_2
XTAP_TAPCELL_ROW_152_1115 VDD VSS gf180mcu_as_sc_mcu7t3v3__tap_2
XFILLER_5_665 VDD VDD VSS VSS gf180mcu_as_sc_mcu7t3v3__fillcap_4
XTAP_TAPCELL_ROW_152_1137 VDD VSS gf180mcu_as_sc_mcu7t3v3__tap_2
XFILLER_4_24 VDD VDD VSS VSS gf180mcu_as_sc_mcu7t3v3__fillcap_8
XFILLER_5_698 VDD VDD VSS VSS gf180mcu_as_sc_mcu7t3v3__fill_2
XFILLER_191_50 VDD VDD VSS VSS gf180mcu_as_sc_mcu7t3v3__fillcap_16
XFILLER_191_72 VDD VDD VSS VSS gf180mcu_as_sc_mcu7t3v3__fillcap_16
Xinput260 VDD VDD VSS VSS south_in[9] _4077_/A gf180mcu_as_sc_mcu7t3v3__buff_12
Xinput271 VDD VDD VSS VSS sw_in[19] _4163_/A gf180mcu_as_sc_mcu7t3v3__buff_12
Xinput282 VDD VDD VSS VSS sw_in[29] _4240_/A gf180mcu_as_sc_mcu7t3v3__buff_12
Xinput293 VDD VDD VSS VSS sw_in[6] _4058_/A gf180mcu_as_sc_mcu7t3v3__buff_12
XFILLER_182_1030 VDD VDD VSS VSS gf180mcu_as_sc_mcu7t3v3__fill_2
X_3941_ VDD VDD VSS VSS _4801_/Q _4804_/Q _3941_/C _3963_/D _3942_/D gf180mcu_as_sc_mcu7t3v3__ao22_2
X_3872_ VDD VDD VSS VSS _4210_/D _3872_/B _3872_/C _3872_/D _3873_/B gf180mcu_as_sc_mcu7t3v3__ao211_2
X_2823_ VDD VDD VSS VSS _4144_/A _2823_/B _2823_/C _2823_/D _2825_/C gf180mcu_as_sc_mcu7t3v3__ao211_2
X_2754_ VDD VDD VSS VSS _2818_/B _4087_/A _2758_/C gf180mcu_as_sc_mcu7t3v3__and2_2
XFILLER_191_227 VDD VDD VSS VSS gf180mcu_as_sc_mcu7t3v3__fill_2
XFILLER_9_982 VDD VDD VSS VSS gf180mcu_as_sc_mcu7t3v3__fill_1
XFILLER_160_603 VDD VDD VSS VSS gf180mcu_as_sc_mcu7t3v3__fill_1
XFILLER_172_441 VDD VDD VSS VSS gf180mcu_as_sc_mcu7t3v3__fill_2
X_2685_ VDD VDD VSS VSS _4020_/A _2902_/C _2685_/C _2685_/D _2686_/D gf180mcu_as_sc_mcu7t3v3__ao211_2
XFILLER_172_485 VDD VDD VSS VSS gf180mcu_as_sc_mcu7t3v3__fillcap_16
X_4424_ VDD VDD VSS VSS _4783_/CLK _4424_/D _4424_/Q gf180mcu_as_sc_mcu7t3v3__dfxtp_2
X_4355_ VDD VDD VSS VSS _4445_/CLK _4355_/D _4355_/Q gf180mcu_as_sc_mcu7t3v3__dfxtp_2
XFILLER_154_1154 VDD VDD VSS VSS gf180mcu_as_sc_mcu7t3v3__fill_1
X_3306_ VDD VDD VSS VSS _3306_/A _3306_/B _3306_/C _3308_/B _3306_/D gf180mcu_as_sc_mcu7t3v3__aoi31_2
XFILLER_119_1296 VDD VDD VSS VSS gf180mcu_as_sc_mcu7t3v3__fill_2
Xfanout449 VDD VDD VSS VSS _2993_/C _2989_/C gf180mcu_as_sc_mcu7t3v3__buff_12
X_4286_ VDD VDD VSS VSS _4769_/D _4327_/A _4286_/B _4286_/A gf180mcu_as_sc_mcu7t3v3__aoi21_2
Xmesh_tile_853 VDD VDD VSS VSS ne_out[25] gf180mcu_as_sc_mcu7t3v3__tiel_4
Xmesh_tile_842 VDD VDD VSS VSS ne_out[14] gf180mcu_as_sc_mcu7t3v3__tiel_4
Xmesh_tile_831 VDD VDD VSS VSS ne_out[3] gf180mcu_as_sc_mcu7t3v3__tiel_4
X_3237_ VDD VDD VSS VSS _3373_/B _4472_/Q _3244_/D gf180mcu_as_sc_mcu7t3v3__and2_2
XFILLER_104_69 VDD VDD VSS VSS gf180mcu_as_sc_mcu7t3v3__fillcap_4
Xmesh_tile_886 VDD VDD VSS VSS north_out[22] gf180mcu_as_sc_mcu7t3v3__tiel_4
Xmesh_tile_875 VDD VDD VSS VSS north_out[11] gf180mcu_as_sc_mcu7t3v3__tiel_4
Xmesh_tile_864 VDD VDD VSS VSS north_out[0] gf180mcu_as_sc_mcu7t3v3__tiel_4
X_3168_ VDD VDD VSS VSS _3574_/D _3191_/A _3178_/B _3168_/C _3169_/C gf180mcu_as_sc_mcu7t3v3__ao31_2
Xmesh_tile_897 VDD VDD VSS VSS north_out[33] gf180mcu_as_sc_mcu7t3v3__tiel_4
X_3099_ VDD VDD VSS VSS _3116_/S _4487_/Q _4486_/Q _4486_/D gf180mcu_as_sc_mcu7t3v3__mux2_2
XFILLER_78_1291 VDD VDD VSS VSS gf180mcu_as_sc_mcu7t3v3__fillcap_8
XFILLER_11_904 VDD VDD VSS VSS gf180mcu_as_sc_mcu7t3v3__fillcap_4
XFILLER_39_1286 VDD VDD VSS VSS gf180mcu_as_sc_mcu7t3v3__fillcap_4
XFILLER_11_948 VDD VDD VSS VSS gf180mcu_as_sc_mcu7t3v3__fillcap_16
XFILLER_126_1256 VDD VDD VSS VSS gf180mcu_as_sc_mcu7t3v3__fillcap_8
XFILLER_13_33 VDD VDD VSS VSS gf180mcu_as_sc_mcu7t3v3__fill_1
XFILLER_167_246 VDD VDD VSS VSS gf180mcu_as_sc_mcu7t3v3__fill_2
XFILLER_13_66 VDD VDD VSS VSS gf180mcu_as_sc_mcu7t3v3__fill_2
XFILLER_155_408 VDD VDD VSS VSS gf180mcu_as_sc_mcu7t3v3__fill_1
XFILLER_167_279 VDD VDD VSS VSS gf180mcu_as_sc_mcu7t3v3__fill_1
XFILLER_183_717 VDD VDD VSS VSS gf180mcu_as_sc_mcu7t3v3__fill_2
XFILLER_7_919 VDD VDD VSS VSS gf180mcu_as_sc_mcu7t3v3__fillcap_4
XFILLER_182_227 VDD VDD VSS VSS gf180mcu_as_sc_mcu7t3v3__fillcap_4
XFILLER_175_290 VDD VDD VSS VSS gf180mcu_as_sc_mcu7t3v3__fillcap_4
XFILLER_191_772 VDD VDD VSS VSS gf180mcu_as_sc_mcu7t3v3__fillcap_4
XPHY_EDGE_ROW_37_1_Left_229 VDD VSS gf180mcu_as_sc_mcu7t3v3__tap_2
XPHY_EDGE_ROW_38_3_Left_410 VDD VSS gf180mcu_as_sc_mcu7t3v3__tap_2
XFILLER_161_42 VDD VDD VSS VSS gf180mcu_as_sc_mcu7t3v3__fill_1
XFILLER_166_1014 VDD VDD VSS VSS gf180mcu_as_sc_mcu7t3v3__fill_1
XPHY_EDGE_ROW_151_1_Left_343 VDD VSS gf180mcu_as_sc_mcu7t3v3__tap_2
XFILLER_57_1320 VDD VDD VSS VSS gf180mcu_as_sc_mcu7t3v3__fillcap_4
XFILLER_54_84 VDD VDD VSS VSS gf180mcu_as_sc_mcu7t3v3__fill_1
XFILLER_158_213 VDD VDD VSS VSS gf180mcu_as_sc_mcu7t3v3__fill_1
XFILLER_13_274 VDD VDD VSS VSS gf180mcu_as_sc_mcu7t3v3__fill_2
XTAP_TAPCELL_ROW_12_921 VDD VSS gf180mcu_as_sc_mcu7t3v3__tap_2
XTAP_TAPCELL_ROW_12_910 VDD VSS gf180mcu_as_sc_mcu7t3v3__tap_2
Xclkload15 VDD VDD VSS VSS _4803_/CLK clkload15/Y gf180mcu_as_sc_mcu7t3v3__clkbuff_12
Xclkload26 VDD VDD VSS VSS clkload26/Y _4828_/CLK gf180mcu_as_sc_mcu7t3v3__inv_4
XTAP_TAPCELL_ROW_171_1502 VDD VSS gf180mcu_as_sc_mcu7t3v3__tap_2
XFILLER_154_430 VDD VDD VSS VSS gf180mcu_as_sc_mcu7t3v3__fill_2
XFILLER_155_986 VDD VDD VSS VSS gf180mcu_as_sc_mcu7t3v3__fill_2
XFILLER_182_750 VDD VDD VSS VSS gf180mcu_as_sc_mcu7t3v3__fillcap_16
XFILLER_6_963 VDD VDD VSS VSS gf180mcu_as_sc_mcu7t3v3__fillcap_16
XFILLER_141_102 VDD VDD VSS VSS gf180mcu_as_sc_mcu7t3v3__fill_2
XFILLER_154_463 VDD VDD VSS VSS gf180mcu_as_sc_mcu7t3v3__fill_1
X_2470_ VDD VDD VSS VSS _2478_/A _2470_/B _2470_/C _2470_/D _2470_/Y gf180mcu_as_sc_mcu7t3v3__ao22_2
XTAP_TAPCELL_ROW_27_3_1938 VDD VSS gf180mcu_as_sc_mcu7t3v3__tap_2
XFILLER_170_978 VDD VDD VSS VSS gf180mcu_as_sc_mcu7t3v3__fillcap_16
XFILLER_173_1018 VDD VDD VSS VSS gf180mcu_as_sc_mcu7t3v3__fillcap_4
XFILLER_181_282 VDD VDD VSS VSS gf180mcu_as_sc_mcu7t3v3__fillcap_16
X_4140_ VDD VDD VSS VSS _4789_/Q _4148_/B _4148_/C _4140_/D _4144_/C gf180mcu_as_sc_mcu7t3v3__ao22_2
XTAP_TAPCELL_ROW_169_1464 VDD VSS gf180mcu_as_sc_mcu7t3v3__tap_2
XTAP_TAPCELL_ROW_169_1453 VDD VSS gf180mcu_as_sc_mcu7t3v3__tap_2
XPHY_EDGE_ROW_22_3_Left_394 VDD VSS gf180mcu_as_sc_mcu7t3v3__tap_2
X_4071_ VDD VDD VSS VSS _4071_/A _4143_/B _4235_/B _4071_/D _4072_/D gf180mcu_as_sc_mcu7t3v3__ao22_2
X_3022_ VDD VDD VSS VSS _3024_/C _4432_/Q _3022_/A _4432_/D gf180mcu_as_sc_mcu7t3v3__mux2_2
XPHY_EDGE_ROW_83_1_Left_275 VDD VSS gf180mcu_as_sc_mcu7t3v3__tap_2
XFILLER_188_1250 VDD VDD VSS VSS gf180mcu_as_sc_mcu7t3v3__fillcap_8
XFILLER_149_1256 VDD VDD VSS VSS gf180mcu_as_sc_mcu7t3v3__fillcap_16
XFILLER_188_1294 VDD VDD VSS VSS gf180mcu_as_sc_mcu7t3v3__fill_1
XTAP_TAPCELL_ROW_182_1697 VDD VSS gf180mcu_as_sc_mcu7t3v3__tap_2
XFILLER_184_1169 VDD VDD VSS VSS gf180mcu_as_sc_mcu7t3v3__fillcap_16
XFILLER_177_511 VDD VDD VSS VSS gf180mcu_as_sc_mcu7t3v3__fill_2
X_3924_ VDD VDD VSS VSS _3924_/B _4265_/A _3925_/B gf180mcu_as_sc_mcu7t3v3__and2_2
XFILLER_177_566 VDD VDD VSS VSS gf180mcu_as_sc_mcu7t3v3__fill_2
XFILLER_192_503 VDD VDD VSS VSS gf180mcu_as_sc_mcu7t3v3__fill_2
XFILLER_192_514 VDD VDD VSS VSS gf180mcu_as_sc_mcu7t3v3__fill_1
Xclkload9 VDD VDD VSS VSS clkload9/A clkload9/Y gf180mcu_as_sc_mcu7t3v3__clkbuff_4
X_3855_ VDD VDD VSS VSS _4196_/A _3855_/B _3855_/C _3856_/B _3855_/D gf180mcu_as_sc_mcu7t3v3__aoi211_2
XFILLER_160_1180 VDD VDD VSS VSS gf180mcu_as_sc_mcu7t3v3__fillcap_16
X_3786_ VDD VDD VSS VSS _4133_/A _3876_/B _3786_/C _3876_/D _3788_/C gf180mcu_as_sc_mcu7t3v3__ao211_2
X_2806_ VDD VDD VSS VSS _2879_/B _4127_/D _2807_/D gf180mcu_as_sc_mcu7t3v3__or2_2
XTAP_TAPCELL_ROW_139_3_2050 VDD VSS gf180mcu_as_sc_mcu7t3v3__tap_2
X_2737_ VDD VDD VSS VSS _4780_/Q _2828_/B _2828_/C _4069_/D _2739_/C gf180mcu_as_sc_mcu7t3v3__ao22_2
XFILLER_161_912 VDD VDD VSS VSS gf180mcu_as_sc_mcu7t3v3__fillcap_16
X_2668_ VDD VDD VSS VSS _2668_/Y _2668_/B _2668_/A gf180mcu_as_sc_mcu7t3v3__nor2_2
XFILLER_172_293 VDD VDD VSS VSS gf180mcu_as_sc_mcu7t3v3__fill_1
XFILLER_191_1118 VDD VDD VSS VSS gf180mcu_as_sc_mcu7t3v3__fill_2
X_4407_ VDD VDD VSS VSS _4440_/CLK _4407_/D _4407_/Q gf180mcu_as_sc_mcu7t3v3__dfxtp_2
XTAP_TAPCELL_ROW_189_1829 VDD VSS gf180mcu_as_sc_mcu7t3v3__tap_2
X_2599_ VDD VDD VSS VSS _2638_/A _3970_/B _4241_/A gf180mcu_as_sc_mcu7t3v3__nand2b_2
X_4338_ VDD VDD VSS VSS clkload8/A _4338_/D _4338_/Q gf180mcu_as_sc_mcu7t3v3__dfxtp_2
XFILLER_115_57 VDD VDD VSS VSS gf180mcu_as_sc_mcu7t3v3__fill_1
X_4269_ VDD VDD VSS VSS _4269_/D _4269_/A _4269_/B _4272_/A _4270_/B gf180mcu_as_sc_mcu7t3v3__ao31_2
XFILLER_189_1025 VDD VDD VSS VSS gf180mcu_as_sc_mcu7t3v3__fillcap_8
XFILLER_167_1301 VDD VDD VSS VSS gf180mcu_as_sc_mcu7t3v3__fill_1
XFILLER_131_67 VDD VDD VSS VSS gf180mcu_as_sc_mcu7t3v3__fill_2
XFILLER_164_761 VDD VDD VSS VSS gf180mcu_as_sc_mcu7t3v3__fillcap_4
XFILLER_183_558 VDD VDD VSS VSS gf180mcu_as_sc_mcu7t3v3__fill_2
XFILLER_183_569 VDD VDD VSS VSS gf180mcu_as_sc_mcu7t3v3__fill_1
XFILLER_40_53 VDD VDD VSS VSS gf180mcu_as_sc_mcu7t3v3__fillcap_8
XFILLER_156_53 VDD VDD VSS VSS gf180mcu_as_sc_mcu7t3v3__fill_2
XFILLER_174_1305 VDD VDD VSS VSS gf180mcu_as_sc_mcu7t3v3__fill_2
XFILLER_163_282 VDD VDD VSS VSS gf180mcu_as_sc_mcu7t3v3__fillcap_4
XFILLER_174_1327 VDD VDD VSS VSS gf180mcu_as_sc_mcu7t3v3__fillcap_16
XFILLER_3_944 VDD VDD VSS VSS gf180mcu_as_sc_mcu7t3v3__fillcap_8
XPHY_EDGE_ROW_70_3_Right_111 VDD VSS gf180mcu_as_sc_mcu7t3v3__tap_2
XFILLER_2_454 VDD VDD VSS VSS gf180mcu_as_sc_mcu7t3v3__fill_1
XFILLER_3_966 VDD VDD VSS VSS gf180mcu_as_sc_mcu7t3v3__fill_1
Xload_slew608 VDD VDD VSS VSS _2662_/Y fanout606/A gf180mcu_as_sc_mcu7t3v3__clkbuff_12
XFILLER_172_41 VDD VDD VSS VSS gf180mcu_as_sc_mcu7t3v3__fill_2
XFILLER_1_14 VDD VDD VSS VSS gf180mcu_as_sc_mcu7t3v3__fill_1
Xfanout780 VDD VDD VSS VSS _2478_/A _2455_/A gf180mcu_as_sc_mcu7t3v3__buff_12
XTAP_TAPCELL_ROW_164_1361 VDD VSS gf180mcu_as_sc_mcu7t3v3__tap_2
XFILLER_65_72 VDD VDD VSS VSS gf180mcu_as_sc_mcu7t3v3__fillcap_4
XFILLER_81_60 VDD VDD VSS VSS gf180mcu_as_sc_mcu7t3v3__fill_2
XTAP_TAPCELL_ROW_82_1_1035 VDD VSS gf180mcu_as_sc_mcu7t3v3__tap_2
XFILLER_186_363 VDD VDD VSS VSS gf180mcu_as_sc_mcu7t3v3__fillcap_16
X_3640_ VDD VDD VSS VSS _3963_/D _3869_/B _3640_/A gf180mcu_as_sc_mcu7t3v3__nor2b_2
X_3571_ VDD VDD VSS VSS _3571_/A _3571_/B _3571_/C _3571_/D _3574_/B gf180mcu_as_sc_mcu7t3v3__ao22_2
XFILLER_155_772 VDD VDD VSS VSS gf180mcu_as_sc_mcu7t3v3__fillcap_8
XFILLER_182_580 VDD VDD VSS VSS gf180mcu_as_sc_mcu7t3v3__fill_2
X_2522_ VDD VDD VSS VSS _2530_/C _3084_/D _2522_/A gf180mcu_as_sc_mcu7t3v3__nor2b_2
X_2453_ VDD VDD VSS VSS _2454_/D _2461_/C _4807_/D _2453_/A gf180mcu_as_sc_mcu7t3v3__aoi21b_2
XFILLER_155_1282 VDD VDD VSS VSS gf180mcu_as_sc_mcu7t3v3__fill_2
X_2384_ VDD VDD VSS VSS _4829_/D _2384_/B _4600_/Q _2385_/B gf180mcu_as_sc_mcu7t3v3__mux2_2
X_4123_ VDD VDD VSS VSS _4707_/D _4123_/C _4187_/D _4123_/A gf180mcu_as_sc_mcu7t3v3__aoi21_2
XTAP_TAPCELL_ROW_184_1737 VDD VSS gf180mcu_as_sc_mcu7t3v3__tap_2
XFILLER_116_1288 VDD VDD VSS VSS gf180mcu_as_sc_mcu7t3v3__fill_1
Xinput2 VDD VDD VSS VSS boot_addr[10] input2/Y gf180mcu_as_sc_mcu7t3v3__buff_12
X_4054_ VDD VDD VSS VSS _4056_/C _4151_/A _4054_/B _4054_/C gf180mcu_as_sc_mcu7t3v3__ao21_2
XTAP_TAPCELL_ROW_184_1748 VDD VSS gf180mcu_as_sc_mcu7t3v3__tap_2
X_3005_ VDD VDD VSS VSS _3037_/B _3006_/B _3006_/C _4417_/Q _4417_/D gf180mcu_as_sc_mcu7t3v3__ao22_2
XFILLER_162_1242 VDD VDD VSS VSS gf180mcu_as_sc_mcu7t3v3__fill_2
XFILLER_75_1272 VDD VDD VSS VSS gf180mcu_as_sc_mcu7t3v3__fill_1
XFILLER_177_352 VDD VDD VSS VSS gf180mcu_as_sc_mcu7t3v3__fillcap_16
X_3907_ VDD VDD VSS VSS _3916_/B _4248_/A _3908_/B gf180mcu_as_sc_mcu7t3v3__and2_2
XFILLER_162_1297 VDD VDD VSS VSS gf180mcu_as_sc_mcu7t3v3__fillcap_16
X_3838_ VDD VDD VSS VSS _3838_/B _3945_/A _4678_/D gf180mcu_as_sc_mcu7t3v3__and2_2
XFILLER_4_708 VDD VDD VSS VSS gf180mcu_as_sc_mcu7t3v3__fillcap_4
Xclkbuf_leaf_16_clk_regs VDD VDD VSS VSS clkbuf_3_6__f_clk_regs/Y _4606_/CLK gf180mcu_as_sc_mcu7t3v3__clkbuff_12
X_3769_ VDD VDD VSS VSS _4118_/A _3795_/B _3769_/C _3795_/D _3772_/B gf180mcu_as_sc_mcu7t3v3__ao211_2
XFILLER_10_34 VDD VDD VSS VSS gf180mcu_as_sc_mcu7t3v3__fill_1
XFILLER_156_1013 VDD VDD VSS VSS gf180mcu_as_sc_mcu7t3v3__fill_2
XFILLER_161_742 VDD VDD VSS VSS gf180mcu_as_sc_mcu7t3v3__fill_2
XFILLER_126_34 VDD VDD VSS VSS gf180mcu_as_sc_mcu7t3v3__fill_1
Xoutput361 VDD VDD VSS VSS _4721_/Q east_out[28] gf180mcu_as_sc_mcu7t3v3__buff_12
Xoutput350 VDD VDD VSS VSS _4711_/Q east_out[18] gf180mcu_as_sc_mcu7t3v3__buff_12
XFILLER_0_947 VDD VDD VSS VSS gf180mcu_as_sc_mcu7t3v3__fill_1
Xoutput394 VDD VDD VSS VSS _4682_/Q south_out[25] gf180mcu_as_sc_mcu7t3v3__buff_12
Xoutput383 VDD VDD VSS VSS _4672_/Q south_out[15] gf180mcu_as_sc_mcu7t3v3__buff_12
Xoutput372 VDD VDD VSS VSS _4698_/Q east_out[5] gf180mcu_as_sc_mcu7t3v3__buff_12
XTAP_TAPCELL_ROW_3_752 VDD VSS gf180mcu_as_sc_mcu7t3v3__tap_2
XTAP_TAPCELL_ROW_3_741 VDD VSS gf180mcu_as_sc_mcu7t3v3__tap_2
XFILLER_35_42 VDD VDD VSS VSS gf180mcu_as_sc_mcu7t3v3__fill_2
XFILLER_188_628 VDD VDD VSS VSS gf180mcu_as_sc_mcu7t3v3__fillcap_16
XFILLER_169_842 VDD VDD VSS VSS gf180mcu_as_sc_mcu7t3v3__fillcap_16
XFILLER_35_86 VDD VDD VSS VSS gf180mcu_as_sc_mcu7t3v3__fill_1
XFILLER_11_531 VDD VDD VSS VSS gf180mcu_as_sc_mcu7t3v3__fill_2
XFILLER_141_1315 VDD VDD VSS VSS gf180mcu_as_sc_mcu7t3v3__fill_2
XFILLER_141_1326 VDD VDD VSS VSS gf180mcu_as_sc_mcu7t3v3__fillcap_4
XFILLER_11_575 VDD VDD VSS VSS gf180mcu_as_sc_mcu7t3v3__fillcap_4
XFILLER_51_52 VDD VDD VSS VSS gf180mcu_as_sc_mcu7t3v3__fillcap_16
XFILLER_183_344 VDD VDD VSS VSS gf180mcu_as_sc_mcu7t3v3__fillcap_4
XTAP_TAPCELL_ROW_143_1_1096 VDD VSS gf180mcu_as_sc_mcu7t3v3__tap_2
XFILLER_167_74 VDD VDD VSS VSS gf180mcu_as_sc_mcu7t3v3__fill_1
XFILLER_164_591 VDD VDD VSS VSS gf180mcu_as_sc_mcu7t3v3__fillcap_4
XFILLER_174_1157 VDD VDD VSS VSS gf180mcu_as_sc_mcu7t3v3__fillcap_16
XPHY_EDGE_ROW_71_3_Right_112 VDD VSS gf180mcu_as_sc_mcu7t3v3__tap_2
XTAP_TAPCELL_ROW_166_1401 VDD VSS gf180mcu_as_sc_mcu7t3v3__tap_2
XFILLER_76_71 VDD VDD VSS VSS gf180mcu_as_sc_mcu7t3v3__fill_1
XFILLER_0_1118 VDD VDD VSS VSS gf180mcu_as_sc_mcu7t3v3__fillcap_4
XFILLER_98_1272 VDD VDD VSS VSS gf180mcu_as_sc_mcu7t3v3__fillcap_16
XFILLER_185_1231 VDD VDD VSS VSS gf180mcu_as_sc_mcu7t3v3__fillcap_8
XFILLER_59_1256 VDD VDD VSS VSS gf180mcu_as_sc_mcu7t3v3__fillcap_16
X_4810_ VDD VDD VSS VSS _4826_/CLK _4810_/D _4810_/Q gf180mcu_as_sc_mcu7t3v3__dfxtp_2
XFILLER_178_138 VDD VDD VSS VSS gf180mcu_as_sc_mcu7t3v3__fillcap_4
XPHY_EDGE_ROW_114_1_Left_306 VDD VSS gf180mcu_as_sc_mcu7t3v3__tap_2
XFILLER_159_352 VDD VDD VSS VSS gf180mcu_as_sc_mcu7t3v3__fill_1
X_4741_ VDD VDD VSS VSS _4751_/CLK _4741_/D _4741_/Q gf180mcu_as_sc_mcu7t3v3__dfxtp_2
XFILLER_174_311 VDD VDD VSS VSS gf180mcu_as_sc_mcu7t3v3__fillcap_4
XFILLER_175_834 VDD VDD VSS VSS gf180mcu_as_sc_mcu7t3v3__fillcap_4
XFILLER_179_1002 VDD VDD VSS VSS gf180mcu_as_sc_mcu7t3v3__fill_2
XFILLER_187_683 VDD VDD VSS VSS gf180mcu_as_sc_mcu7t3v3__fillcap_4
X_4672_ VDD VDD VSS VSS clkload5/A _4672_/D _4672_/Q gf180mcu_as_sc_mcu7t3v3__dfxtp_2
XFILLER_174_333 VDD VDD VSS VSS gf180mcu_as_sc_mcu7t3v3__fill_2
XFILLER_186_193 VDD VDD VSS VSS gf180mcu_as_sc_mcu7t3v3__fill_2
XFILLER_190_804 VDD VDD VSS VSS gf180mcu_as_sc_mcu7t3v3__fill_1
X_3623_ VDD VDD VSS VSS _3937_/B _3644_/C _3962_/A gf180mcu_as_sc_mcu7t3v3__and2_2
XFILLER_190_815 VDD VDD VSS VSS gf180mcu_as_sc_mcu7t3v3__fill_2
XFILLER_155_580 VDD VDD VSS VSS gf180mcu_as_sc_mcu7t3v3__fill_1
XFILLER_155_591 VDD VDD VSS VSS gf180mcu_as_sc_mcu7t3v3__fill_2
XFILLER_157_1322 VDD VDD VSS VSS gf180mcu_as_sc_mcu7t3v3__fillcap_8
X_3554_ VDD VDD VSS VSS _4620_/D _4605_/Q _3554_/B _3554_/C gf180mcu_as_sc_mcu7t3v3__ao21_2
X_3485_ VDD VDD VSS VSS _3506_/C _3487_/B _3504_/C gf180mcu_as_sc_mcu7t3v3__nor2_2
X_2505_ VDD VDD VSS VSS _2557_/A _3571_/D _3446_/B _2505_/C gf180mcu_as_sc_mcu7t3v3__ao21_2
XFILLER_192_1257 VDD VDD VSS VSS gf180mcu_as_sc_mcu7t3v3__fill_1
X_2436_ VDD VDD VSS VSS _2436_/D _3071_/A _3053_/B _2436_/C _2438_/C gf180mcu_as_sc_mcu7t3v3__ao31_2
XFILLER_155_1090 VDD VDD VSS VSS gf180mcu_as_sc_mcu7t3v3__fillcap_4
XFILLER_9_1132 VDD VDD VSS VSS gf180mcu_as_sc_mcu7t3v3__fillcap_8
X_2367_ VDD VDD VSS VSS _3448_/S _3611_/B _2391_/A gf180mcu_as_sc_mcu7t3v3__and2_2
XFILLER_186_1006 VDD VDD VSS VSS gf180mcu_as_sc_mcu7t3v3__fill_2
X_4106_ VDD VDD VSS VSS _4138_/C _4221_/S _4106_/B _4106_/C _4107_/C gf180mcu_as_sc_mcu7t3v3__ao31_2
X_2298_ VDD VDD VSS VSS _2299_/A _4810_/Q _2298_/B _2298_/C gf180mcu_as_sc_mcu7t3v3__maj3_2
X_4037_ VDD VDD VSS VSS _4776_/Q _4148_/B _4148_/C _4037_/D _4038_/C gf180mcu_as_sc_mcu7t3v3__ao22_2
XTAP_TAPCELL_ROW_0_700 VDD VSS gf180mcu_as_sc_mcu7t3v3__tap_2
XPHY_EDGE_ROW_46_1_Left_238 VDD VSS gf180mcu_as_sc_mcu7t3v3__tap_2
XFILLER_12_317 VDD VDD VSS VSS gf180mcu_as_sc_mcu7t3v3__fill_1
XFILLER_13_818 VDD VDD VSS VSS gf180mcu_as_sc_mcu7t3v3__fillcap_8
XFILLER_169_138 VDD VDD VSS VSS gf180mcu_as_sc_mcu7t3v3__fill_2
XFILLER_188_18 VDD VDD VSS VSS gf180mcu_as_sc_mcu7t3v3__fillcap_16
XANTENNA_40 VDD VDD VSS VSS _4193_/A gf180mcu_as_sc_mcu7t3v3__diode_2
XFILLER_166_812 VDD VDD VSS VSS gf180mcu_as_sc_mcu7t3v3__fillcap_16
XFILLER_177_160 VDD VDD VSS VSS gf180mcu_as_sc_mcu7t3v3__fillcap_16
XANTENNA_51 VDD VDD VSS VSS _4237_/B gf180mcu_as_sc_mcu7t3v3__diode_2
XANTENNA_62 VDD VDD VSS VSS _3828_/B gf180mcu_as_sc_mcu7t3v3__diode_2
XFILLER_166_889 VDD VDD VSS VSS gf180mcu_as_sc_mcu7t3v3__fillcap_8
XFILLER_180_314 VDD VDD VSS VSS gf180mcu_as_sc_mcu7t3v3__fill_1
XFILLER_21_88 VDD VDD VSS VSS gf180mcu_as_sc_mcu7t3v3__fillcap_16
XFILLER_4_527 VDD VDD VSS VSS gf180mcu_as_sc_mcu7t3v3__fillcap_8
XFILLER_171_1308 VDD VDD VSS VSS gf180mcu_as_sc_mcu7t3v3__fill_1
XTAP_TAPCELL_ROW_8_844 VDD VSS gf180mcu_as_sc_mcu7t3v3__tap_2
XFILLER_153_10 VDD VDD VSS VSS gf180mcu_as_sc_mcu7t3v3__fillcap_8
XFILLER_169_1259 VDD VDD VSS VSS gf180mcu_as_sc_mcu7t3v3__fill_1
XFILLER_189_926 VDD VDD VSS VSS gf180mcu_as_sc_mcu7t3v3__fill_1
XFILLER_102_80 VDD VDD VSS VSS gf180mcu_as_sc_mcu7t3v3__fillcap_4
XPHY_EDGE_ROW_58_3_Right_99 VDD VSS gf180mcu_as_sc_mcu7t3v3__tap_2
XTAP_TAPCELL_ROW_159_1271 VDD VSS gf180mcu_as_sc_mcu7t3v3__tap_2
XTAP_TAPCELL_ROW_159_1260 VDD VSS gf180mcu_as_sc_mcu7t3v3__tap_2
XFILLER_172_815 VDD VDD VSS VSS gf180mcu_as_sc_mcu7t3v3__fill_1
XPHY_EDGE_ROW_92_1_Left_284 VDD VSS gf180mcu_as_sc_mcu7t3v3__tap_2
XFILLER_171_347 VDD VDD VSS VSS gf180mcu_as_sc_mcu7t3v3__fill_2
XFILLER_172_848 VDD VDD VSS VSS gf180mcu_as_sc_mcu7t3v3__fillcap_16
XTAP_TAPCELL_ROW_77_1_1030 VDD VSS gf180mcu_as_sc_mcu7t3v3__tap_2
X_3270_ VDD VDD VSS VSS _3274_/B _4338_/Q _3312_/S gf180mcu_as_sc_mcu7t3v3__nand2b_2
X_2221_ VDD VDD VSS VSS _4123_/A _2221_/A gf180mcu_as_sc_mcu7t3v3__inv_2
XPHY_EDGE_ROW_72_3_Right_113 VDD VSS gf180mcu_as_sc_mcu7t3v3__tap_2
XFILLER_26_1288 VDD VDD VSS VSS gf180mcu_as_sc_mcu7t3v3__fill_1
Xclkbuf_2_1_0_clk_regs VDD VDD VSS VSS clkbuf_0_clk_regs/Y clkbuf_2_1_0_clk_regs/Y
+ gf180mcu_as_sc_mcu7t3v3__clkbuff_12
XFILLER_187_1348 VDD VDD VSS VSS gf180mcu_as_sc_mcu7t3v3__fillcap_4
XFILLER_179_447 VDD VDD VSS VSS gf180mcu_as_sc_mcu7t3v3__fillcap_16
XTAP_TAPCELL_ROW_179_1647 VDD VSS gf180mcu_as_sc_mcu7t3v3__tap_2
XFILLER_72_1264 VDD VDD VSS VSS gf180mcu_as_sc_mcu7t3v3__fillcap_4
X_4724_ VDD VDD VSS VSS _4728_/CLK _4724_/D _4724_/Q gf180mcu_as_sc_mcu7t3v3__dfxtp_2
X_2985_ VDD VDD VSS VSS _3016_/A _2989_/B _2989_/C _4397_/Q _4397_/D gf180mcu_as_sc_mcu7t3v3__ao22_2
XFILLER_175_686 VDD VDD VSS VSS gf180mcu_as_sc_mcu7t3v3__fill_2
X_4655_ VDD VDD VSS VSS _4826_/CLK _4655_/D _4655_/Q gf180mcu_as_sc_mcu7t3v3__dfxtp_2
X_4586_ VDD VDD VSS VSS _4828_/CLK _4586_/D _4586_/Q gf180mcu_as_sc_mcu7t3v3__dfxtp_2
Xinput60 VDD VDD VSS VSS east_in[24] _4198_/D gf180mcu_as_sc_mcu7t3v3__buff_12
Xinput71 VDD VDD VSS VSS east_in[34] _3965_/A gf180mcu_as_sc_mcu7t3v3__buff_12
Xinput82 VDD VDD VSS VSS ne_in[11] _4095_/A gf180mcu_as_sc_mcu7t3v3__buff_12
X_3606_ VDD VDD VSS VSS _3607_/B _4616_/Q _4617_/Q gf180mcu_as_sc_mcu7t3v3__nor2_2
XFILLER_190_667 VDD VDD VSS VSS gf180mcu_as_sc_mcu7t3v3__fill_2
Xinput93 VDD VDD VSS VSS ne_in[21] _4177_/A gf180mcu_as_sc_mcu7t3v3__buff_12
Xmax_cap552 VDD VDD VSS VSS _2405_/A _2490_/B gf180mcu_as_sc_mcu7t3v3__clkbuff_12
X_3537_ VDD VDD VSS VSS _3539_/S _4614_/Q _4615_/Q _3538_/B gf180mcu_as_sc_mcu7t3v3__mux2_2
XFILLER_107_58 VDD VDD VSS VSS gf180mcu_as_sc_mcu7t3v3__fill_1
XFILLER_153_1049 VDD VDD VSS VSS gf180mcu_as_sc_mcu7t3v3__fill_1
XFILLER_170_391 VDD VDD VSS VSS gf180mcu_as_sc_mcu7t3v3__fill_2
XFILLER_192_1087 VDD VDD VSS VSS gf180mcu_as_sc_mcu7t3v3__fill_1
X_3468_ VDD VDD VSS VSS _3468_/D _3474_/A _4589_/Q _3468_/C _3469_/C gf180mcu_as_sc_mcu7t3v3__ao31_2
X_3399_ VDD VDD VSS VSS _3402_/C _4441_/Q _3410_/A gf180mcu_as_sc_mcu7t3v3__nand2_2
X_2419_ VDD VDD VSS VSS _2420_/D _2494_/A input9/Y _2437_/B gf180mcu_as_sc_mcu7t3v3__aoi21_2
XFILLER_123_57 VDD VDD VSS VSS gf180mcu_as_sc_mcu7t3v3__fill_2
X_5069_ VDD VDD VSS VSS _5069_/A _5069_/Y gf180mcu_as_sc_mcu7t3v3__buff_2
XFILLER_168_1281 VDD VDD VSS VSS gf180mcu_as_sc_mcu7t3v3__fillcap_8
XFILLER_13_648 VDD VDD VSS VSS gf180mcu_as_sc_mcu7t3v3__fillcap_4
XFILLER_185_406 VDD VDD VSS VSS gf180mcu_as_sc_mcu7t3v3__fill_2
Xclkbuf_leaf_31_clk_regs VDD VDD VSS VSS clkbuf_3_4__f_clk_regs/Y _4728_/CLK gf180mcu_as_sc_mcu7t3v3__clkbuff_12
Xsram2048.u_bank1_824 VDD VDD VSS VSS sram2048.u_bank1/WEN[3] gf180mcu_as_sc_mcu7t3v3__tiel_4
XFILLER_51_1326 VDD VDD VSS VSS gf180mcu_as_sc_mcu7t3v3__fillcap_4
XFILLER_8_107 VDD VDD VSS VSS gf180mcu_as_sc_mcu7t3v3__fill_2
XPHY_EDGE_ROW_50_1_Right_559 VDD VSS gf180mcu_as_sc_mcu7t3v3__tap_2
XFILLER_166_653 VDD VDD VSS VSS gf180mcu_as_sc_mcu7t3v3__fillcap_4
XFILLER_5_814 VDD VDD VSS VSS gf180mcu_as_sc_mcu7t3v3__fill_2
XFILLER_10_1001 VDD VDD VSS VSS gf180mcu_as_sc_mcu7t3v3__fillcap_4
XFILLER_153_314 VDD VDD VSS VSS gf180mcu_as_sc_mcu7t3v3__fill_1
XFILLER_153_336 VDD VDD VSS VSS gf180mcu_as_sc_mcu7t3v3__fillcap_8
XFILLER_165_174 VDD VDD VSS VSS gf180mcu_as_sc_mcu7t3v3__fillcap_8
XFILLER_180_177 VDD VDD VSS VSS gf180mcu_as_sc_mcu7t3v3__fillcap_8
XFILLER_180_199 VDD VDD VSS VSS gf180mcu_as_sc_mcu7t3v3__fill_1
XFILLER_79_103 VDD VDD VSS VSS gf180mcu_as_sc_mcu7t3v3__fill_2
XFILLER_175_1285 VDD VDD VSS VSS gf180mcu_as_sc_mcu7t3v3__fill_2
XTAP_TAPCELL_ROW_138_1_1091 VDD VSS gf180mcu_as_sc_mcu7t3v3__tap_2
XFILLER_112_1291 VDD VDD VSS VSS gf180mcu_as_sc_mcu7t3v3__fillcap_8
XFILLER_147_1310 VDD VDD VSS VSS gf180mcu_as_sc_mcu7t3v3__fillcap_8
XFILLER_182_1201 VDD VDD VSS VSS gf180mcu_as_sc_mcu7t3v3__fillcap_16
XFILLER_182_1245 VDD VDD VSS VSS gf180mcu_as_sc_mcu7t3v3__fill_1
XFILLER_189_72 VDD VDD VSS VSS gf180mcu_as_sc_mcu7t3v3__fill_2
XFILLER_189_756 VDD VDD VSS VSS gf180mcu_as_sc_mcu7t3v3__fillcap_8
XFILLER_189_778 VDD VDD VSS VSS gf180mcu_as_sc_mcu7t3v3__fill_1
XTAP_TAPCELL_ROW_110_3_2021 VDD VSS gf180mcu_as_sc_mcu7t3v3__tap_2
XFILLER_182_1278 VDD VDD VSS VSS gf180mcu_as_sc_mcu7t3v3__fillcap_16
X_2770_ VDD VDD VSS VSS _4097_/A _2823_/D _2770_/C _2770_/D _2771_/B gf180mcu_as_sc_mcu7t3v3__ao211_2
XFILLER_172_601 VDD VDD VSS VSS gf180mcu_as_sc_mcu7t3v3__fill_1
XTAP_TAPCELL_ROW_174_1555 VDD VSS gf180mcu_as_sc_mcu7t3v3__tap_2
XTAP_TAPCELL_ROW_174_1544 VDD VSS gf180mcu_as_sc_mcu7t3v3__tap_2
XFILLER_171_100 VDD VDD VSS VSS gf180mcu_as_sc_mcu7t3v3__fill_2
XFILLER_172_645 VDD VDD VSS VSS gf180mcu_as_sc_mcu7t3v3__fill_2
X_4440_ VDD VDD VSS VSS _4440_/CLK _4440_/D _4440_/Q gf180mcu_as_sc_mcu7t3v3__dfxtp_2
XTAP_TAPCELL_ROW_191_1880 VDD VSS gf180mcu_as_sc_mcu7t3v3__tap_2
XFILLER_160_807 VDD VDD VSS VSS gf180mcu_as_sc_mcu7t3v3__fillcap_8
XFILLER_172_667 VDD VDD VSS VSS gf180mcu_as_sc_mcu7t3v3__fillcap_16
XTAP_TAPCELL_ROW_10_882 VDD VSS gf180mcu_as_sc_mcu7t3v3__tap_2
XFILLER_172_689 VDD VDD VSS VSS gf180mcu_as_sc_mcu7t3v3__fill_1
X_4371_ VDD VDD VSS VSS _4429_/CLK _4371_/D _4371_/Q gf180mcu_as_sc_mcu7t3v3__dfxtp_2
XFILLER_154_1347 VDD VDD VSS VSS gf180mcu_as_sc_mcu7t3v3__fillcap_4
Xfanout609 VDD VDD VSS VSS _4226_/B _4217_/C gf180mcu_as_sc_mcu7t3v3__buff_12
X_3322_ VDD VDD VSS VSS _3346_/A _3322_/B _3322_/C _3324_/B _3322_/D gf180mcu_as_sc_mcu7t3v3__aoi31_2
XFILLER_115_1309 VDD VDD VSS VSS gf180mcu_as_sc_mcu7t3v3__fill_1
X_3253_ VDD VDD VSS VSS _3389_/B _4474_/Q _3260_/D gf180mcu_as_sc_mcu7t3v3__and2_2
X_3184_ VDD VDD VSS VSS _3185_/C _4445_/Q _3408_/C gf180mcu_as_sc_mcu7t3v3__nand2_2
X_2204_ VDD VDD VSS VSS _3526_/A _4576_/Q gf180mcu_as_sc_mcu7t3v3__inv_2
XPHY_EDGE_ROW_73_3_Right_114 VDD VSS gf180mcu_as_sc_mcu7t3v3__tap_2
XFILLER_6_1157 VDD VDD VSS VSS gf180mcu_as_sc_mcu7t3v3__fill_2
XFILLER_187_1134 VDD VDD VSS VSS gf180mcu_as_sc_mcu7t3v3__fill_1
XFILLER_161_1329 VDD VDD VSS VSS gf180mcu_as_sc_mcu7t3v3__fill_1
XFILLER_167_417 VDD VDD VSS VSS gf180mcu_as_sc_mcu7t3v3__fill_2
X_2968_ VDD VDD VSS VSS _3003_/A _2974_/A _3034_/A gf180mcu_as_sc_mcu7t3v3__and2_2
X_4707_ VDD VDD VSS VSS _4727_/CLK _4707_/D _4707_/Q gf180mcu_as_sc_mcu7t3v3__dfxtp_2
XFILLER_11_1332 VDD VDD VSS VSS gf180mcu_as_sc_mcu7t3v3__fillcap_16
X_4638_ VDD VDD VSS VSS _4831_/CLK _4638_/D _4638_/Q gf180mcu_as_sc_mcu7t3v3__dfxtp_2
X_2899_ VDD VDD VSS VSS _4357_/Q _2920_/B _3003_/A _2920_/D _4357_/D gf180mcu_as_sc_mcu7t3v3__ao22_2
XTAP_TAPCELL_ROW_45_3_1956 VDD VSS gf180mcu_as_sc_mcu7t3v3__tap_2
XFILLER_11_1354 VDD VDD VSS VSS gf180mcu_as_sc_mcu7t3v3__fill_1
XFILLER_162_133 VDD VDD VSS VSS gf180mcu_as_sc_mcu7t3v3__fill_1
XFILLER_190_453 VDD VDD VSS VSS gf180mcu_as_sc_mcu7t3v3__fill_2
XFILLER_118_68 VDD VDD VSS VSS gf180mcu_as_sc_mcu7t3v3__fill_2
X_4569_ VDD VDD VSS VSS _4728_/CLK _4569_/D _4569_/Q gf180mcu_as_sc_mcu7t3v3__dfxtp_2
Xmesh_tile_1008 VDD VDD VSS VSS west_out[35] gf180mcu_as_sc_mcu7t3v3__tiel_4
XFILLER_94_27 VDD VDD VSS VSS gf180mcu_as_sc_mcu7t3v3__fill_1
XFILLER_134_89 VDD VDD VSS VSS gf180mcu_as_sc_mcu7t3v3__fillcap_16
XFILLER_150_22 VDD VDD VSS VSS gf180mcu_as_sc_mcu7t3v3__fillcap_8
XFILLER_166_1218 VDD VDD VSS VSS gf180mcu_as_sc_mcu7t3v3__fillcap_4
XFILLER_27_65 VDD VDD VSS VSS gf180mcu_as_sc_mcu7t3v3__fillcap_4
XFILLER_186_715 VDD VDD VSS VSS gf180mcu_as_sc_mcu7t3v3__fillcap_16
XFILLER_186_737 VDD VDD VSS VSS gf180mcu_as_sc_mcu7t3v3__fillcap_16
XFILLER_9_405 VDD VDD VSS VSS gf180mcu_as_sc_mcu7t3v3__fill_2
XFILLER_13_478 VDD VDD VSS VSS gf180mcu_as_sc_mcu7t3v3__fill_2
XFILLER_159_42 VDD VDD VSS VSS gf180mcu_as_sc_mcu7t3v3__fillcap_4
XFILLER_185_236 VDD VDD VSS VSS gf180mcu_as_sc_mcu7t3v3__fill_1
XFILLER_43_86 VDD VDD VSS VSS gf180mcu_as_sc_mcu7t3v3__fillcap_16
XFILLER_167_962 VDD VDD VSS VSS gf180mcu_as_sc_mcu7t3v3__fillcap_16
XFILLER_182_943 VDD VDD VSS VSS gf180mcu_as_sc_mcu7t3v3__fill_2
XTAP_TAPCELL_ROW_152_1116 VDD VSS gf180mcu_as_sc_mcu7t3v3__tap_2
XTAP_TAPCELL_ROW_152_1105 VDD VSS gf180mcu_as_sc_mcu7t3v3__tap_2
XFILLER_154_667 VDD VDD VSS VSS gf180mcu_as_sc_mcu7t3v3__fill_1
XFILLER_177_1336 VDD VDD VSS VSS gf180mcu_as_sc_mcu7t3v3__fill_2
XFILLER_181_464 VDD VDD VSS VSS gf180mcu_as_sc_mcu7t3v3__fill_1
XTAP_TAPCELL_ROW_152_1138 VDD VSS gf180mcu_as_sc_mcu7t3v3__tap_2
XTAP_TAPCELL_ROW_152_1127 VDD VSS gf180mcu_as_sc_mcu7t3v3__tap_2
XFILLER_153_166 VDD VDD VSS VSS gf180mcu_as_sc_mcu7t3v3__fill_2
XFILLER_181_486 VDD VDD VSS VSS gf180mcu_as_sc_mcu7t3v3__fillcap_4
XFILLER_4_14 VDD VDD VSS VSS gf180mcu_as_sc_mcu7t3v3__fill_2
XFILLER_175_1060 VDD VDD VSS VSS gf180mcu_as_sc_mcu7t3v3__fillcap_4
XFILLER_68_61 VDD VDD VSS VSS gf180mcu_as_sc_mcu7t3v3__fillcap_16
XPHY_EDGE_ROW_123_1_Left_315 VDD VSS gf180mcu_as_sc_mcu7t3v3__tap_2
XFILLER_62_1285 VDD VDD VSS VSS gf180mcu_as_sc_mcu7t3v3__fillcap_4
Xinput250 VDD VDD VSS VSS south_in[32] _3942_/A gf180mcu_as_sc_mcu7t3v3__buff_12
Xinput261 VDD VDD VSS VSS sw_in[0] _4010_/A gf180mcu_as_sc_mcu7t3v3__buff_12
Xinput272 VDD VDD VSS VSS sw_in[1] _4018_/A gf180mcu_as_sc_mcu7t3v3__buff_12
Xinput283 VDD VDD VSS VSS sw_in[2] _4026_/A gf180mcu_as_sc_mcu7t3v3__buff_12
Xinput294 VDD VDD VSS VSS sw_in[7] _2217_/A gf180mcu_as_sc_mcu7t3v3__buff_12
XFILLER_97_1326 VDD VDD VSS VSS gf180mcu_as_sc_mcu7t3v3__fillcap_4
XFILLER_184_1329 VDD VDD VSS VSS gf180mcu_as_sc_mcu7t3v3__fillcap_16
XFILLER_1_1032 VDD VDD VSS VSS gf180mcu_as_sc_mcu7t3v3__fill_2
X_3940_ VDD VDD VSS VSS _3940_/B _3966_/A _3944_/C gf180mcu_as_sc_mcu7t3v3__and2_2
XFILLER_189_586 VDD VDD VSS VSS gf180mcu_as_sc_mcu7t3v3__fill_1
X_3871_ VDD VDD VSS VSS _4211_/A _3871_/B _3871_/C _4210_/A _3872_/D gf180mcu_as_sc_mcu7t3v3__ao22_2
XFILLER_158_940 VDD VDD VSS VSS gf180mcu_as_sc_mcu7t3v3__fillcap_4
X_2822_ VDD VDD VSS VSS _4142_/A _2822_/B _2822_/C _2822_/D _2823_/C gf180mcu_as_sc_mcu7t3v3__ao211_2
X_2753_ VDD VDD VSS VSS _4341_/Q _2772_/B _2987_/A _2772_/D _4341_/D gf180mcu_as_sc_mcu7t3v3__ao22_2
XFILLER_9_994 VDD VDD VSS VSS gf180mcu_as_sc_mcu7t3v3__fill_2
X_2684_ VDD VDD VSS VSS _2901_/B _4020_/D _2685_/D gf180mcu_as_sc_mcu7t3v3__and2_2
X_4423_ VDD VDD VSS VSS clkload9/A _4423_/D _4423_/Q gf180mcu_as_sc_mcu7t3v3__dfxtp_2
X_4354_ VDD VDD VSS VSS _4803_/CLK _4354_/D _4354_/Q gf180mcu_as_sc_mcu7t3v3__dfxtp_2
XPHY_EDGE_ROW_55_1_Left_247 VDD VSS gf180mcu_as_sc_mcu7t3v3__tap_2
XPHY_EDGE_ROW_119_3_Left_491 VDD VSS gf180mcu_as_sc_mcu7t3v3__tap_2
XFILLER_119_1264 VDD VDD VSS VSS gf180mcu_as_sc_mcu7t3v3__fillcap_4
X_3305_ VDD VDD VSS VSS _3306_/D _3305_/B _3306_/A gf180mcu_as_sc_mcu7t3v3__nor2_2
XFILLER_154_1199 VDD VDD VSS VSS gf180mcu_as_sc_mcu7t3v3__fillcap_8
X_4285_ VDD VDD VSS VSS _4285_/S _4285_/B _4287_/A _4286_/B gf180mcu_as_sc_mcu7t3v3__mux2_2
Xmesh_tile_854 VDD VDD VSS VSS ne_out[26] gf180mcu_as_sc_mcu7t3v3__tiel_4
Xmesh_tile_843 VDD VDD VSS VSS ne_out[15] gf180mcu_as_sc_mcu7t3v3__tiel_4
Xmesh_tile_832 VDD VDD VSS VSS ne_out[4] gf180mcu_as_sc_mcu7t3v3__tiel_4
X_3236_ VDD VDD VSS VSS _3348_/A _3236_/B _3236_/C _3236_/D _4520_/D gf180mcu_as_sc_mcu7t3v3__ao211_2
XPHY_EDGE_ROW_74_3_Right_115 VDD VSS gf180mcu_as_sc_mcu7t3v3__tap_2
XFILLER_104_37 VDD VDD VSS VSS gf180mcu_as_sc_mcu7t3v3__fillcap_16
Xmesh_tile_887 VDD VDD VSS VSS north_out[23] gf180mcu_as_sc_mcu7t3v3__tiel_4
Xmesh_tile_876 VDD VDD VSS VSS north_out[12] gf180mcu_as_sc_mcu7t3v3__tiel_4
Xmesh_tile_865 VDD VDD VSS VSS north_out[1] gf180mcu_as_sc_mcu7t3v3__tiel_4
X_3167_ VDD VDD VSS VSS _3168_/C _4512_/Q _4511_/Q gf180mcu_as_sc_mcu7t3v3__nand2_2
Xmesh_tile_898 VDD VDD VSS VSS north_out[34] gf180mcu_as_sc_mcu7t3v3__tiel_4
X_3098_ VDD VDD VSS VSS _3116_/S _4486_/Q _4485_/Q _4485_/D gf180mcu_as_sc_mcu7t3v3__mux2_2
XFILLER_78_1270 VDD VDD VSS VSS gf180mcu_as_sc_mcu7t3v3__fill_1
XFILLER_11_916 VDD VDD VSS VSS gf180mcu_as_sc_mcu7t3v3__fill_2
XFILLER_165_1262 VDD VDD VSS VSS gf180mcu_as_sc_mcu7t3v3__fillcap_16
XFILLER_168_715 VDD VDD VSS VSS gf180mcu_as_sc_mcu7t3v3__fillcap_16
Xwire807 VDD VDD VSS VSS wire807/A wire807/Y gf180mcu_as_sc_mcu7t3v3__clkbuff_12
XFILLER_10_437 VDD VDD VSS VSS gf180mcu_as_sc_mcu7t3v3__fillcap_4
XFILLER_7_909 VDD VDD VSS VSS gf180mcu_as_sc_mcu7t3v3__fill_1
XFILLER_11_1162 VDD VDD VSS VSS gf180mcu_as_sc_mcu7t3v3__fill_1
XFILLER_164_998 VDD VDD VSS VSS gf180mcu_as_sc_mcu7t3v3__fillcap_4
XFILLER_2_614 VDD VDD VSS VSS gf180mcu_as_sc_mcu7t3v3__fill_1
XFILLER_145_22 VDD VDD VSS VSS gf180mcu_as_sc_mcu7t3v3__fill_2
XFILLER_159_1088 VDD VDD VSS VSS gf180mcu_as_sc_mcu7t3v3__fillcap_4
XFILLER_172_1222 VDD VDD VSS VSS gf180mcu_as_sc_mcu7t3v3__fill_2
XFILLER_172_1244 VDD VDD VSS VSS gf180mcu_as_sc_mcu7t3v3__fill_1
XFILLER_180_2 VDD VDD VSS VSS gf180mcu_as_sc_mcu7t3v3__fillcap_16
XFILLER_22_1291 VDD VDD VSS VSS gf180mcu_as_sc_mcu7t3v3__fillcap_8
XFILLER_166_1059 VDD VDD VSS VSS gf180mcu_as_sc_mcu7t3v3__fill_1
XFILLER_159_726 VDD VDD VSS VSS gf180mcu_as_sc_mcu7t3v3__fill_1
XFILLER_92_1256 VDD VDD VSS VSS gf180mcu_as_sc_mcu7t3v3__fillcap_8
XFILLER_110_80 VDD VDD VSS VSS gf180mcu_as_sc_mcu7t3v3__fillcap_4
XFILLER_144_1346 VDD VDD VSS VSS gf180mcu_as_sc_mcu7t3v3__fill_1
XFILLER_158_247 VDD VDD VSS VSS gf180mcu_as_sc_mcu7t3v3__fillcap_16
XFILLER_186_545 VDD VDD VSS VSS gf180mcu_as_sc_mcu7t3v3__fill_1
XTAP_TAPCELL_ROW_12_922 VDD VSS gf180mcu_as_sc_mcu7t3v3__tap_2
XTAP_TAPCELL_ROW_12_911 VDD VSS gf180mcu_as_sc_mcu7t3v3__tap_2
XFILLER_70_62 VDD VDD VSS VSS gf180mcu_as_sc_mcu7t3v3__fillcap_4
XFILLER_10_960 VDD VDD VSS VSS gf180mcu_as_sc_mcu7t3v3__fillcap_8
XFILLER_126_100 VDD VDD VSS VSS gf180mcu_as_sc_mcu7t3v3__fillcap_4
XFILLER_6_920 VDD VDD VSS VSS gf180mcu_as_sc_mcu7t3v3__fillcap_4
XFILLER_6_931 VDD VDD VSS VSS gf180mcu_as_sc_mcu7t3v3__fillcap_8
Xclkload16 VDD VDD VSS VSS _4804_/CLK clkload16/Y gf180mcu_as_sc_mcu7t3v3__clkbuff_4
XTAP_TAPCELL_ROW_171_1503 VDD VSS gf180mcu_as_sc_mcu7t3v3__tap_2
Xclkload27 VDD VDD VSS VSS clkload27/Y _4820_/CLK gf180mcu_as_sc_mcu7t3v3__inv_2
XFILLER_154_486 VDD VDD VSS VSS gf180mcu_as_sc_mcu7t3v3__fillcap_16
XFILLER_181_250 VDD VDD VSS VSS gf180mcu_as_sc_mcu7t3v3__fillcap_8
XFILLER_177_1177 VDD VDD VSS VSS gf180mcu_as_sc_mcu7t3v3__fill_2
XFILLER_5_496 VDD VDD VSS VSS gf180mcu_as_sc_mcu7t3v3__fill_2
XTAP_TAPCELL_ROW_169_1465 VDD VSS gf180mcu_as_sc_mcu7t3v3__tap_2
XTAP_TAPCELL_ROW_169_1454 VDD VSS gf180mcu_as_sc_mcu7t3v3__tap_2
X_4070_ VDD VDD VSS VSS _4072_/C _4151_/A _4070_/B _4070_/C gf180mcu_as_sc_mcu7t3v3__ao21_2
XFILLER_7_1296 VDD VDD VSS VSS gf180mcu_as_sc_mcu7t3v3__fillcap_4
X_3021_ VDD VDD VSS VSS _3021_/A _3038_/B _3024_/C _4431_/Q _4431_/D gf180mcu_as_sc_mcu7t3v3__ao22_2
XFILLER_184_1126 VDD VDD VSS VSS gf180mcu_as_sc_mcu7t3v3__fillcap_16
XTAP_TAPCELL_ROW_182_1698 VDD VSS gf180mcu_as_sc_mcu7t3v3__tap_2
X_3923_ VDD VDD VSS VSS _3923_/B _4051_/A _4687_/D gf180mcu_as_sc_mcu7t3v3__and2_2
X_3854_ VDD VDD VSS VSS _4194_/A _3881_/B _3881_/C _4193_/A _3855_/D gf180mcu_as_sc_mcu7t3v3__ao22_2
X_2805_ VDD VDD VSS VSS _4128_/A _2917_/C _2805_/C _2914_/B _2807_/C gf180mcu_as_sc_mcu7t3v3__ao211_2
X_3785_ VDD VDD VSS VSS _3875_/B _4132_/D _3786_/C gf180mcu_as_sc_mcu7t3v3__and2_2
XFILLER_9_780 VDD VDD VSS VSS gf180mcu_as_sc_mcu7t3v3__fillcap_4
XFILLER_192_559 VDD VDD VSS VSS gf180mcu_as_sc_mcu7t3v3__fillcap_4
X_2736_ VDD VDD VSS VSS _2818_/B _4071_/A _2740_/C gf180mcu_as_sc_mcu7t3v3__and2_2
X_2667_ VDD VDD VSS VSS _3983_/A _2903_/B _2667_/C _2667_/D _2669_/C gf180mcu_as_sc_mcu7t3v3__ao211_2
XFILLER_160_445 VDD VDD VSS VSS gf180mcu_as_sc_mcu7t3v3__fillcap_8
XFILLER_161_957 VDD VDD VSS VSS gf180mcu_as_sc_mcu7t3v3__fillcap_16
X_4406_ VDD VDD VSS VSS _4795_/CLK _4406_/D _4406_/Q gf180mcu_as_sc_mcu7t3v3__dfxtp_2
XFILLER_161_979 VDD VDD VSS VSS gf180mcu_as_sc_mcu7t3v3__fill_1
X_2598_ VDD VDD VSS VSS _4254_/D _4242_/D _4263_/D _3970_/B gf180mcu_as_sc_mcu7t3v3__nor3_2
X_4337_ VDD VDD VSS VSS _4783_/CLK _4337_/D _4337_/Q gf180mcu_as_sc_mcu7t3v3__dfxtp_2
XFILLER_115_69 VDD VDD VSS VSS gf180mcu_as_sc_mcu7t3v3__fill_1
X_4268_ VDD VDD VSS VSS _4268_/A _4268_/B _4268_/C _4268_/D _4269_/D gf180mcu_as_sc_mcu7t3v3__ao22_2
XFILLER_189_1037 VDD VDD VSS VSS gf180mcu_as_sc_mcu7t3v3__fill_1
X_3219_ VDD VDD VSS VSS _3219_/S _4518_/Q _3219_/A _4518_/D gf180mcu_as_sc_mcu7t3v3__mux2_2
X_4199_ VDD VDD VSS VSS _4201_/B _4199_/A _4206_/B _4199_/C gf180mcu_as_sc_mcu7t3v3__ao21_2
XPHY_EDGE_ROW_75_3_Right_116 VDD VSS gf180mcu_as_sc_mcu7t3v3__tap_2
XFILLER_168_534 VDD VDD VSS VSS gf180mcu_as_sc_mcu7t3v3__fillcap_16
XFILLER_156_718 VDD VDD VSS VSS gf180mcu_as_sc_mcu7t3v3__fillcap_4
XFILLER_11_768 VDD VDD VSS VSS gf180mcu_as_sc_mcu7t3v3__fill_2
XFILLER_168_589 VDD VDD VSS VSS gf180mcu_as_sc_mcu7t3v3__fillcap_4
XFILLER_52_1295 VDD VDD VSS VSS gf180mcu_as_sc_mcu7t3v3__fill_2
XFILLER_152_913 VDD VDD VSS VSS gf180mcu_as_sc_mcu7t3v3__fillcap_4
XFILLER_163_250 VDD VDD VSS VSS gf180mcu_as_sc_mcu7t3v3__fill_1
XFILLER_3_912 VDD VDD VSS VSS gf180mcu_as_sc_mcu7t3v3__fillcap_8
XFILLER_40_65 VDD VDD VSS VSS gf180mcu_as_sc_mcu7t3v3__fill_2
XFILLER_6_2 VDD VDD VSS VSS gf180mcu_as_sc_mcu7t3v3__fillcap_16
XFILLER_49_52 VDD VDD VSS VSS gf180mcu_as_sc_mcu7t3v3__fillcap_16
XFILLER_172_97 VDD VDD VSS VSS gf180mcu_as_sc_mcu7t3v3__fillcap_8
Xfanout781 VDD VDD VSS VSS _2397_/D _2494_/A gf180mcu_as_sc_mcu7t3v3__buff_12
Xfanout792 VDD VDD VSS VSS _2493_/B _2437_/B gf180mcu_as_sc_mcu7t3v3__buff_12
XTAP_TAPCELL_ROW_164_1362 VDD VSS gf180mcu_as_sc_mcu7t3v3__tap_2
XFILLER_60_101 VDD VDD VSS VSS gf180mcu_as_sc_mcu7t3v3__fillcap_4
XFILLER_81_72 VDD VDD VSS VSS gf180mcu_as_sc_mcu7t3v3__fill_1
XFILLER_109_1296 VDD VDD VSS VSS gf180mcu_as_sc_mcu7t3v3__fill_1
X_3570_ VDD VDD VSS VSS _3570_/B _3584_/B _4625_/D gf180mcu_as_sc_mcu7t3v3__and2_2
X_2521_ VDD VDD VSS VSS _2521_/B _2521_/A _3084_/D gf180mcu_as_sc_mcu7t3v3__xnor2_2
XFILLER_5_282 VDD VDD VSS VSS gf180mcu_as_sc_mcu7t3v3__fill_2
XFILLER_68_1291 VDD VDD VSS VSS gf180mcu_as_sc_mcu7t3v3__fillcap_8
X_2452_ VDD VDD VSS VSS _2452_/D _3071_/A _2492_/B _2452_/C _2454_/C gf180mcu_as_sc_mcu7t3v3__ao31_2
XFILLER_155_1250 VDD VDD VSS VSS gf180mcu_as_sc_mcu7t3v3__fillcap_8
XFILLER_170_798 VDD VDD VSS VSS gf180mcu_as_sc_mcu7t3v3__fillcap_4
XFILLER_29_1275 VDD VDD VSS VSS gf180mcu_as_sc_mcu7t3v3__fillcap_4
X_2383_ VDD VDD VSS VSS _4612_/Q _2391_/A _2383_/C _3468_/C _2384_/B gf180mcu_as_sc_mcu7t3v3__ao211_2
XPHY_EDGE_ROW_141_1_Right_650 VDD VSS gf180mcu_as_sc_mcu7t3v3__tap_2
XFILLER_116_1256 VDD VDD VSS VSS gf180mcu_as_sc_mcu7t3v3__fillcap_8
X_4763__1009 VDD VDD VSS VSS _4763_/D gf180mcu_as_sc_mcu7t3v3__tiel_4
X_4122_ VDD VDD VSS VSS _4122_/D _4163_/S _4122_/B _4122_/C _4123_/C gf180mcu_as_sc_mcu7t3v3__ao31_2
XTAP_TAPCELL_ROW_184_1738 VDD VSS gf180mcu_as_sc_mcu7t3v3__tap_2
X_4053_ VDD VDD VSS VSS _4778_/Q _4148_/B _4148_/C _4053_/D _4054_/C gf180mcu_as_sc_mcu7t3v3__ao22_2
XTAP_TAPCELL_ROW_184_1749 VDD VSS gf180mcu_as_sc_mcu7t3v3__tap_2
Xinput3 VDD VDD VSS VSS boot_addr[1] input3/Y gf180mcu_as_sc_mcu7t3v3__buff_12
X_3004_ VDD VDD VSS VSS _3004_/A _3004_/B _3004_/C _4416_/Q _4416_/D gf180mcu_as_sc_mcu7t3v3__ao22_2
XFILLER_101_27 VDD VDD VSS VSS gf180mcu_as_sc_mcu7t3v3__fill_2
X_3906_ VDD VDD VSS VSS _3906_/B _3945_/A _4685_/D gf180mcu_as_sc_mcu7t3v3__and2_2
XFILLER_192_312 VDD VDD VSS VSS gf180mcu_as_sc_mcu7t3v3__fill_2
X_3837_ VDD VDD VSS VSS _3883_/S _3837_/B _4180_/A _3838_/B gf180mcu_as_sc_mcu7t3v3__mux2_2
X_3768_ VDD VDD VSS VSS _3794_/B _4116_/D _3769_/C gf180mcu_as_sc_mcu7t3v3__and2_2
XFILLER_180_518 VDD VDD VSS VSS gf180mcu_as_sc_mcu7t3v3__fillcap_4
X_2719_ VDD VDD VSS VSS _4778_/Q _2828_/B _2828_/C _4053_/D _2721_/C gf180mcu_as_sc_mcu7t3v3__ao22_2
X_3699_ VDD VDD VSS VSS _3699_/D _3796_/B _3699_/B _3699_/C _3701_/C gf180mcu_as_sc_mcu7t3v3__ao31_2
XFILLER_10_79 VDD VDD VSS VSS gf180mcu_as_sc_mcu7t3v3__fillcap_8
Xoutput362 VDD VDD VSS VSS _4722_/Q east_out[29] gf180mcu_as_sc_mcu7t3v3__buff_12
Xoutput351 VDD VDD VSS VSS _4712_/Q east_out[19] gf180mcu_as_sc_mcu7t3v3__buff_12
Xoutput340 VDD VDD VSS VSS _5076_/Y dft_rdata[7] gf180mcu_as_sc_mcu7t3v3__buff_12
XFILLER_173_1350 VDD VDD VSS VSS gf180mcu_as_sc_mcu7t3v3__fill_1
Xoutput395 VDD VDD VSS VSS _4683_/Q south_out[26] gf180mcu_as_sc_mcu7t3v3__buff_12
Xoutput384 VDD VDD VSS VSS _4673_/Q south_out[16] gf180mcu_as_sc_mcu7t3v3__buff_12
Xoutput373 VDD VDD VSS VSS _4699_/Q east_out[6] gf180mcu_as_sc_mcu7t3v3__buff_12
XFILLER_82_1299 VDD VDD VSS VSS gf180mcu_as_sc_mcu7t3v3__fillcap_4
X_4739__1033 VDD VDD VSS VSS _4739_/D gf180mcu_as_sc_mcu7t3v3__tiel_4
XPHY_EDGE_ROW_15_1_Right_524 VDD VSS gf180mcu_as_sc_mcu7t3v3__tap_2
XTAP_TAPCELL_ROW_3_753 VDD VSS gf180mcu_as_sc_mcu7t3v3__tap_2
XTAP_TAPCELL_ROW_3_742 VDD VSS gf180mcu_as_sc_mcu7t3v3__tap_2
XFILLER_19_99 VDD VDD VSS VSS gf180mcu_as_sc_mcu7t3v3__fill_2
XPHY_EDGE_ROW_76_3_Right_117 VDD VSS gf180mcu_as_sc_mcu7t3v3__tap_2
XPHY_EDGE_ROW_153_Left_345 VDD VSS gf180mcu_as_sc_mcu7t3v3__tap_2
XFILLER_167_1187 VDD VDD VSS VSS gf180mcu_as_sc_mcu7t3v3__fill_2
XFILLER_35_65 VDD VDD VSS VSS gf180mcu_as_sc_mcu7t3v3__fillcap_4
XFILLER_35_98 VDD VDD VSS VSS gf180mcu_as_sc_mcu7t3v3__fillcap_4
XFILLER_168_375 VDD VDD VSS VSS gf180mcu_as_sc_mcu7t3v3__fillcap_8
XPHY_EDGE_ROW_132_1_Left_324 VDD VSS gf180mcu_as_sc_mcu7t3v3__tap_2
XPHY_EDGE_ROW_162_Left_354 VDD VSS gf180mcu_as_sc_mcu7t3v3__tap_2
XFILLER_174_1103 VDD VDD VSS VSS gf180mcu_as_sc_mcu7t3v3__fillcap_4
XFILLER_178_1283 VDD VDD VSS VSS gf180mcu_as_sc_mcu7t3v3__fill_2
XFILLER_139_1256 VDD VDD VSS VSS gf180mcu_as_sc_mcu7t3v3__fill_2
XFILLER_174_1136 VDD VDD VSS VSS gf180mcu_as_sc_mcu7t3v3__fillcap_16
XFILLER_2_274 VDD VDD VSS VSS gf180mcu_as_sc_mcu7t3v3__fill_2
XFILLER_3_797 VDD VDD VSS VSS gf180mcu_as_sc_mcu7t3v3__fillcap_8
XFILLER_183_96 VDD VDD VSS VSS gf180mcu_as_sc_mcu7t3v3__fillcap_4
XTAP_TAPCELL_ROW_166_1402 VDD VSS gf180mcu_as_sc_mcu7t3v3__tap_2
XFILLER_76_61 VDD VDD VSS VSS gf180mcu_as_sc_mcu7t3v3__fillcap_8
XFILLER_76_83 VDD VDD VSS VSS gf180mcu_as_sc_mcu7t3v3__fillcap_16
XPHY_EDGE_ROW_171_Left_363 VDD VSS gf180mcu_as_sc_mcu7t3v3__tap_2
XFILLER_185_1243 VDD VDD VSS VSS gf180mcu_as_sc_mcu7t3v3__fill_2
XFILLER_179_629 VDD VDD VSS VSS gf180mcu_as_sc_mcu7t3v3__fill_1
XFILLER_181_1107 VDD VDD VSS VSS gf180mcu_as_sc_mcu7t3v3__fillcap_8
XFILLER_178_117 VDD VDD VSS VSS gf180mcu_as_sc_mcu7t3v3__fill_1
XFILLER_175_802 VDD VDD VSS VSS gf180mcu_as_sc_mcu7t3v3__fill_1
X_4740_ VDD VDD VSS VSS _4751_/CLK _4740_/D _4740_/Q gf180mcu_as_sc_mcu7t3v3__dfxtp_2
XPHY_EDGE_ROW_64_1_Left_256 VDD VSS gf180mcu_as_sc_mcu7t3v3__tap_2
XFILLER_159_364 VDD VDD VSS VSS gf180mcu_as_sc_mcu7t3v3__fillcap_8
X_4671_ VDD VDD VSS VSS clkload5/A _4671_/D _4671_/Q gf180mcu_as_sc_mcu7t3v3__dfxtp_2
XFILLER_159_397 VDD VDD VSS VSS gf180mcu_as_sc_mcu7t3v3__fillcap_16
X_3622_ VDD VDD VSS VSS _3937_/B _3644_/B _3961_/B gf180mcu_as_sc_mcu7t3v3__nand2_2
XPHY_EDGE_ROW_180_Left_372 VDD VSS gf180mcu_as_sc_mcu7t3v3__tap_2
X_3553_ VDD VDD VSS VSS _4465_/Q _3553_/B _3553_/C _4620_/Q _3554_/C gf180mcu_as_sc_mcu7t3v3__ao22_2
XFILLER_170_551 VDD VDD VSS VSS gf180mcu_as_sc_mcu7t3v3__fillcap_4
XFILLER_192_1247 VDD VDD VSS VSS gf180mcu_as_sc_mcu7t3v3__fillcap_4
X_3484_ VDD VDD VSS VSS _3487_/B _3611_/C _3484_/B _3484_/A gf180mcu_as_sc_mcu7t3v3__aoi21_2
X_2504_ VDD VDD VSS VSS _3611_/A _3580_/D _3128_/A _3124_/S _2505_/C gf180mcu_as_sc_mcu7t3v3__ao31_2
X_2435_ VDD VDD VSS VSS _3071_/B _4527_/Q _4519_/Q _2436_/C gf180mcu_as_sc_mcu7t3v3__mux2_2
XPHY_EDGE_ROW_147_3_Left_519 VDD VSS gf180mcu_as_sc_mcu7t3v3__tap_2
X_4105_ VDD VDD VSS VSS _4106_/C _4105_/C _4136_/C _4105_/A gf180mcu_as_sc_mcu7t3v3__aoi21_2
X_2366_ VDD VDD VSS VSS _3448_/S _2382_/B _4622_/Q gf180mcu_as_sc_mcu7t3v3__nor2_2
XPHY_EDGE_ROW_142_1_Right_651 VDD VSS gf180mcu_as_sc_mcu7t3v3__tap_2
X_2297_ VDD VDD VSS VSS _2298_/C _2502_/B gf180mcu_as_sc_mcu7t3v3__inv_2
XFILLER_186_1029 VDD VDD VSS VSS gf180mcu_as_sc_mcu7t3v3__fillcap_8
X_4036_ VDD VDD VSS VSS _4036_/A _4149_/B _4149_/C _4036_/D _4038_/B gf180mcu_as_sc_mcu7t3v3__ao22_2
XFILLER_112_37 VDD VDD VSS VSS gf180mcu_as_sc_mcu7t3v3__fillcap_16
XFILLER_164_1349 VDD VDD VSS VSS gf180mcu_as_sc_mcu7t3v3__fillcap_4
XANTENNA_30 VDD VDD VSS VSS _4059_/B gf180mcu_as_sc_mcu7t3v3__diode_2
XANTENNA_41 VDD VDD VSS VSS _4227_/A gf180mcu_as_sc_mcu7t3v3__diode_2
XFILLER_162_1073 VDD VDD VSS VSS gf180mcu_as_sc_mcu7t3v3__fill_1
XANTENNA_52 VDD VDD VSS VSS _4237_/B gf180mcu_as_sc_mcu7t3v3__diode_2
XANTENNA_63 VDD VDD VSS VSS _2408_/B gf180mcu_as_sc_mcu7t3v3__diode_2
XFILLER_14_1352 VDD VDD VSS VSS gf180mcu_as_sc_mcu7t3v3__fill_2
XFILLER_165_334 VDD VDD VSS VSS gf180mcu_as_sc_mcu7t3v3__fillcap_16
XFILLER_192_142 VDD VDD VSS VSS gf180mcu_as_sc_mcu7t3v3__fill_2
XFILLER_21_23 VDD VDD VSS VSS gf180mcu_as_sc_mcu7t3v3__fill_2
XFILLER_10_1227 VDD VDD VSS VSS gf180mcu_as_sc_mcu7t3v3__fillcap_4
XFILLER_137_78 VDD VDD VSS VSS gf180mcu_as_sc_mcu7t3v3__fill_1
XFILLER_97_27 VDD VDD VSS VSS gf180mcu_as_sc_mcu7t3v3__fillcap_4
XFILLER_161_562 VDD VDD VSS VSS gf180mcu_as_sc_mcu7t3v3__fillcap_8
XTAP_TAPCELL_ROW_8_845 VDD VSS gf180mcu_as_sc_mcu7t3v3__tap_2
XTAP_TAPCELL_ROW_8_834 VDD VSS gf180mcu_as_sc_mcu7t3v3__tap_2
XFILLER_0_745 VDD VDD VSS VSS gf180mcu_as_sc_mcu7t3v3__fill_2
XFILLER_153_88 VDD VDD VSS VSS gf180mcu_as_sc_mcu7t3v3__fillcap_4
XTAP_TAPCELL_ROW_161_1310 VDD VSS gf180mcu_as_sc_mcu7t3v3__tap_2
XPHY_EDGE_ROW_16_1_Right_525 VDD VSS gf180mcu_as_sc_mcu7t3v3__tap_2
XFILLER_46_64 VDD VDD VSS VSS gf180mcu_as_sc_mcu7t3v3__fillcap_4
XPHY_EDGE_ROW_77_3_Right_118 VDD VSS gf180mcu_as_sc_mcu7t3v3__tap_2
XFILLER_188_415 VDD VDD VSS VSS gf180mcu_as_sc_mcu7t3v3__fillcap_4
XFILLER_178_30 VDD VDD VSS VSS gf180mcu_as_sc_mcu7t3v3__fillcap_4
XFILLER_30_104 VDD VDD VSS VSS gf180mcu_as_sc_mcu7t3v3__fill_1
XFILLER_12_874 VDD VDD VSS VSS gf180mcu_as_sc_mcu7t3v3__fill_1
XFILLER_157_824 VDD VDD VSS VSS gf180mcu_as_sc_mcu7t3v3__fillcap_16
XFILLER_180_1173 VDD VDD VSS VSS gf180mcu_as_sc_mcu7t3v3__fillcap_8
XTAP_TAPCELL_ROW_159_1261 VDD VSS gf180mcu_as_sc_mcu7t3v3__tap_2
XFILLER_106_1288 VDD VDD VSS VSS gf180mcu_as_sc_mcu7t3v3__fill_1
XTAP_TAPCELL_ROW_159_1272 VDD VSS gf180mcu_as_sc_mcu7t3v3__tap_2
XFILLER_106_1299 VDD VDD VSS VSS gf180mcu_as_sc_mcu7t3v3__fillcap_4
XTAP_TAPCELL_ROW_63_3_1974 VDD VSS gf180mcu_as_sc_mcu7t3v3__tap_2
XFILLER_152_562 VDD VDD VSS VSS gf180mcu_as_sc_mcu7t3v3__fillcap_4
XFILLER_152_584 VDD VDD VSS VSS gf180mcu_as_sc_mcu7t3v3__fill_2
XFILLER_180_893 VDD VDD VSS VSS gf180mcu_as_sc_mcu7t3v3__fill_2
XFILLER_97_104 VDD VDD VSS VSS gf180mcu_as_sc_mcu7t3v3__fill_1
X_2220_ VDD VDD VSS VSS _4115_/A _2220_/A gf180mcu_as_sc_mcu7t3v3__inv_2
XFILLER_26_1256 VDD VDD VSS VSS gf180mcu_as_sc_mcu7t3v3__fillcap_16
XFILLER_65_1294 VDD VDD VSS VSS gf180mcu_as_sc_mcu7t3v3__fillcap_4
Xclkbuf_leaf_1_clk_regs VDD VDD VSS VSS clkbuf_leaf_1_clk_regs/A clkload3/A gf180mcu_as_sc_mcu7t3v3__clkbuff_12
XFILLER_187_1327 VDD VDD VSS VSS gf180mcu_as_sc_mcu7t3v3__fill_2
XFILLER_21_104 VDD VDD VSS VSS gf180mcu_as_sc_mcu7t3v3__fill_1
X_2984_ VDD VDD VSS VSS _2984_/A _2989_/B _2989_/C _4396_/Q _4396_/D gf180mcu_as_sc_mcu7t3v3__ao22_2
XTAP_TAPCELL_ROW_179_1648 VDD VSS gf180mcu_as_sc_mcu7t3v3__tap_2
X_4723_ VDD VDD VSS VSS _4728_/CLK _4723_/D _4723_/Q gf180mcu_as_sc_mcu7t3v3__dfxtp_2
XFILLER_159_194 VDD VDD VSS VSS gf180mcu_as_sc_mcu7t3v3__fill_2
XFILLER_175_632 VDD VDD VSS VSS gf180mcu_as_sc_mcu7t3v3__fillcap_8
XFILLER_187_492 VDD VDD VSS VSS gf180mcu_as_sc_mcu7t3v3__fillcap_16
XFILLER_163_827 VDD VDD VSS VSS gf180mcu_as_sc_mcu7t3v3__fillcap_8
XFILLER_190_613 VDD VDD VSS VSS gf180mcu_as_sc_mcu7t3v3__fillcap_8
X_4654_ VDD VDD VSS VSS _4809_/CLK _4654_/D _4654_/Q gf180mcu_as_sc_mcu7t3v3__dfxtp_2
XFILLER_175_698 VDD VDD VSS VSS gf180mcu_as_sc_mcu7t3v3__fill_2
X_4585_ VDD VDD VSS VSS _4828_/CLK _4585_/D _4585_/Q gf180mcu_as_sc_mcu7t3v3__dfxtp_2
Xinput50 VDD VDD VSS VSS east_in[15] _4124_/D gf180mcu_as_sc_mcu7t3v3__buff_12
Xinput61 VDD VDD VSS VSS east_in[25] _4207_/D gf180mcu_as_sc_mcu7t3v3__buff_12
Xinput72 VDD VDD VSS VSS east_in[35] _3965_/B gf180mcu_as_sc_mcu7t3v3__buff_12
X_3605_ VDD VDD VSS VSS _4619_/Q _4618_/Q _4620_/Q _3607_/A gf180mcu_as_sc_mcu7t3v3__nor3_2
Xinput83 VDD VDD VSS VSS ne_in[12] wire769/A gf180mcu_as_sc_mcu7t3v3__buff_12
Xinput94 VDD VDD VSS VSS ne_in[22] _4185_/A gf180mcu_as_sc_mcu7t3v3__buff_12
X_3536_ VDD VDD VSS VSS _3583_/A _3536_/B _4460_/Q _4613_/D gf180mcu_as_sc_mcu7t3v3__mux2_2
Xmax_cap564 VDD VDD VSS VSS _3920_/C _3929_/B gf180mcu_as_sc_mcu7t3v3__clkbuff_12
XFILLER_153_1017 VDD VDD VSS VSS gf180mcu_as_sc_mcu7t3v3__fillcap_4
XFILLER_192_1066 VDD VDD VSS VSS gf180mcu_as_sc_mcu7t3v3__fill_1
X_3467_ VDD VDD VSS VSS _3467_/B _4588_/Q _3468_/D gf180mcu_as_sc_mcu7t3v3__and2_2
X_3398_ VDD VDD VSS VSS _3402_/B _4354_/Q _3410_/A gf180mcu_as_sc_mcu7t3v3__nand2b_2
X_2418_ VDD VDD VSS VSS _2418_/D _2418_/A _2418_/B _2418_/C _2420_/C gf180mcu_as_sc_mcu7t3v3__ao31_2
XFILLER_131_1326 VDD VDD VSS VSS gf180mcu_as_sc_mcu7t3v3__fillcap_4
X_2349_ VDD VDD VSS VSS _2350_/C _2349_/B _3053_/B gf180mcu_as_sc_mcu7t3v3__nor2_2
XPHY_EDGE_ROW_143_1_Right_652 VDD VSS gf180mcu_as_sc_mcu7t3v3__tap_2
X_4019_ VDD VDD VSS VSS _4019_/B _4271_/A _4694_/D gf180mcu_as_sc_mcu7t3v3__and2_2
XFILLER_168_1293 VDD VDD VSS VSS gf180mcu_as_sc_mcu7t3v3__fill_2
XFILLER_16_78 VDD VDD VSS VSS gf180mcu_as_sc_mcu7t3v3__fillcap_8
XPHY_EDGE_ROW_0_Right_0 VDD VSS gf180mcu_as_sc_mcu7t3v3__tap_2
XFILLER_164_1157 VDD VDD VSS VSS gf180mcu_as_sc_mcu7t3v3__fill_2
Xsram2048.u_bank1_825 VDD VDD VSS VSS sram2048.u_bank1/WEN[4] gf180mcu_as_sc_mcu7t3v3__tiel_4
XFILLER_179_982 VDD VDD VSS VSS gf180mcu_as_sc_mcu7t3v3__fillcap_16
XFILLER_166_621 VDD VDD VSS VSS gf180mcu_as_sc_mcu7t3v3__fillcap_4
XFILLER_178_492 VDD VDD VSS VSS gf180mcu_as_sc_mcu7t3v3__fill_1
XFILLER_32_44 VDD VDD VSS VSS gf180mcu_as_sc_mcu7t3v3__fillcap_16
XFILLER_148_33 VDD VDD VSS VSS gf180mcu_as_sc_mcu7t3v3__fill_2
XFILLER_148_55 VDD VDD VSS VSS gf180mcu_as_sc_mcu7t3v3__fill_1
XFILLER_165_131 VDD VDD VSS VSS gf180mcu_as_sc_mcu7t3v3__fill_2
XFILLER_165_142 VDD VDD VSS VSS gf180mcu_as_sc_mcu7t3v3__fillcap_16
XFILLER_148_99 VDD VDD VSS VSS gf180mcu_as_sc_mcu7t3v3__fillcap_4
XFILLER_10_1035 VDD VDD VSS VSS gf180mcu_as_sc_mcu7t3v3__fill_2
XFILLER_153_348 VDD VDD VSS VSS gf180mcu_as_sc_mcu7t3v3__fill_2
XFILLER_175_1220 VDD VDD VSS VSS gf180mcu_as_sc_mcu7t3v3__fill_1
XTAP_TAPCELL_ROW_154_1180 VDD VSS gf180mcu_as_sc_mcu7t3v3__tap_2
XFILLER_171_1117 VDD VDD VSS VSS gf180mcu_as_sc_mcu7t3v3__fill_2
XTAP_TAPCELL_ROW_151_1_1104 VDD VSS gf180mcu_as_sc_mcu7t3v3__tap_2
XFILLER_169_1046 VDD VDD VSS VSS gf180mcu_as_sc_mcu7t3v3__fillcap_4
XPHY_EDGE_ROW_17_1_Right_526 VDD VSS gf180mcu_as_sc_mcu7t3v3__tap_2
XFILLER_113_80 VDD VDD VSS VSS gf180mcu_as_sc_mcu7t3v3__fillcap_4
XFILLER_169_1068 VDD VDD VSS VSS gf180mcu_as_sc_mcu7t3v3__fill_1
XFILLER_189_702 VDD VDD VSS VSS gf180mcu_as_sc_mcu7t3v3__fill_1
XFILLER_147_1322 VDD VDD VSS VSS gf180mcu_as_sc_mcu7t3v3__fill_2
XPHY_EDGE_ROW_78_3_Right_119 VDD VSS gf180mcu_as_sc_mcu7t3v3__tap_2
XFILLER_189_768 VDD VDD VSS VSS gf180mcu_as_sc_mcu7t3v3__fill_2
XFILLER_73_84 VDD VDD VSS VSS gf180mcu_as_sc_mcu7t3v3__fill_1
XFILLER_73_95 VDD VDD VSS VSS gf180mcu_as_sc_mcu7t3v3__fillcap_8
XFILLER_157_610 VDD VDD VSS VSS gf180mcu_as_sc_mcu7t3v3__fillcap_16
XFILLER_169_470 VDD VDD VSS VSS gf180mcu_as_sc_mcu7t3v3__fillcap_4
XFILLER_12_671 VDD VDD VSS VSS gf180mcu_as_sc_mcu7t3v3__fill_2
XFILLER_157_632 VDD VDD VSS VSS gf180mcu_as_sc_mcu7t3v3__fillcap_4
XFILLER_184_451 VDD VDD VSS VSS gf180mcu_as_sc_mcu7t3v3__fillcap_4
XFILLER_8_664 VDD VDD VSS VSS gf180mcu_as_sc_mcu7t3v3__fill_1
XTAP_TAPCELL_ROW_174_1556 VDD VSS gf180mcu_as_sc_mcu7t3v3__tap_2
XTAP_TAPCELL_ROW_174_1545 VDD VSS gf180mcu_as_sc_mcu7t3v3__tap_2
XFILLER_176_1017 VDD VDD VSS VSS gf180mcu_as_sc_mcu7t3v3__fillcap_8
XFILLER_184_473 VDD VDD VSS VSS gf180mcu_as_sc_mcu7t3v3__fillcap_16
XFILLER_8_686 VDD VDD VSS VSS gf180mcu_as_sc_mcu7t3v3__fillcap_16
XTAP_TAPCELL_ROW_191_1870 VDD VSS gf180mcu_as_sc_mcu7t3v3__tap_2
XTAP_TAPCELL_ROW_10_872 VDD VSS gf180mcu_as_sc_mcu7t3v3__tap_2
X_4370_ VDD VDD VSS VSS clkload9/A _4370_/D _4370_/Q gf180mcu_as_sc_mcu7t3v3__dfxtp_2
XTAP_TAPCELL_ROW_191_1881 VDD VSS gf180mcu_as_sc_mcu7t3v3__tap_2
XTAP_TAPCELL_ROW_10_883 VDD VSS gf180mcu_as_sc_mcu7t3v3__tap_2
XFILLER_154_1315 VDD VDD VSS VSS gf180mcu_as_sc_mcu7t3v3__fill_1
XFILLER_4_870 VDD VDD VSS VSS gf180mcu_as_sc_mcu7t3v3__fillcap_4
X_3321_ VDD VDD VSS VSS _3322_/D _3321_/B _3346_/A gf180mcu_as_sc_mcu7t3v3__nor2_2
X_3252_ VDD VDD VSS VSS _3340_/A _3252_/B _3252_/C _3252_/D _4522_/D gf180mcu_as_sc_mcu7t3v3__ao211_2
X_3183_ VDD VDD VSS VSS _3185_/B _4358_/Q _3368_/S gf180mcu_as_sc_mcu7t3v3__nand2b_2
X_2203_ VDD VDD VSS VSS _2363_/A _4616_/Q gf180mcu_as_sc_mcu7t3v3__inv_2
XFILLER_179_212 VDD VDD VSS VSS gf180mcu_as_sc_mcu7t3v3__fillcap_8
XFILLER_179_267 VDD VDD VSS VSS gf180mcu_as_sc_mcu7t3v3__fill_2
XFILLER_176_941 VDD VDD VSS VSS gf180mcu_as_sc_mcu7t3v3__fillcap_4
X_2967_ VDD VDD VSS VSS _4385_/Q _2975_/B _3033_/A _2975_/D _4385_/D gf180mcu_as_sc_mcu7t3v3__ao22_2
XFILLER_175_462 VDD VDD VSS VSS gf180mcu_as_sc_mcu7t3v3__fillcap_4
XFILLER_176_974 VDD VDD VSS VSS gf180mcu_as_sc_mcu7t3v3__fill_1
X_4706_ VDD VDD VSS VSS _4727_/CLK _4706_/D _4706_/Q gf180mcu_as_sc_mcu7t3v3__dfxtp_2
X_2898_ VDD VDD VSS VSS _4212_/A _2898_/B _2898_/C _2898_/D _3003_/A gf180mcu_as_sc_mcu7t3v3__ao22_2
XFILLER_11_1300 VDD VDD VSS VSS gf180mcu_as_sc_mcu7t3v3__fill_1
XFILLER_159_1226 VDD VDD VSS VSS gf180mcu_as_sc_mcu7t3v3__fill_1
XFILLER_163_613 VDD VDD VSS VSS gf180mcu_as_sc_mcu7t3v3__fillcap_16
X_4637_ VDD VDD VSS VSS _4831_/CLK _4637_/D _4637_/Q gf180mcu_as_sc_mcu7t3v3__dfxtp_2
XPHY_EDGE_ROW_27_1_Left_219 VDD VSS gf180mcu_as_sc_mcu7t3v3__tap_2
XFILLER_159_1259 VDD VDD VSS VSS gf180mcu_as_sc_mcu7t3v3__fill_1
XFILLER_162_123 VDD VDD VSS VSS gf180mcu_as_sc_mcu7t3v3__fillcap_8
XFILLER_78_29 VDD VDD VSS VSS gf180mcu_as_sc_mcu7t3v3__fill_2
X_4568_ VDD VDD VSS VSS _4807_/CLK _4568_/D _4568_/Q gf180mcu_as_sc_mcu7t3v3__dfxtp_2
X_4499_ VDD VDD VSS VSS _4708_/CLK _4499_/D _4499_/Q gf180mcu_as_sc_mcu7t3v3__dfxtp_2
X_3519_ VDD VDD VSS VSS _3529_/S _4607_/Q _3519_/A _4607_/D gf180mcu_as_sc_mcu7t3v3__mux2_2
XPHY_EDGE_ROW_28_3_Left_400 VDD VSS gf180mcu_as_sc_mcu7t3v3__tap_2
XFILLER_135_1292 VDD VDD VSS VSS gf180mcu_as_sc_mcu7t3v3__fill_2
XTAP_TAPCELL_ROW_115_3_2026 VDD VSS gf180mcu_as_sc_mcu7t3v3__tap_2
XPHY_EDGE_ROW_141_1_Left_333 VDD VSS gf180mcu_as_sc_mcu7t3v3__tap_2
XFILLER_94_39 VDD VDD VSS VSS gf180mcu_as_sc_mcu7t3v3__fill_1
XPHY_EDGE_ROW_144_1_Right_653 VDD VSS gf180mcu_as_sc_mcu7t3v3__tap_2
XFILLER_150_34 VDD VDD VSS VSS gf180mcu_as_sc_mcu7t3v3__fill_1
XFILLER_166_1208 VDD VDD VSS VSS gf180mcu_as_sc_mcu7t3v3__fill_2
XFILLER_0_1291 VDD VDD VSS VSS gf180mcu_as_sc_mcu7t3v3__fill_1
XFILLER_159_54 VDD VDD VSS VSS gf180mcu_as_sc_mcu7t3v3__fillcap_16
XFILLER_9_428 VDD VDD VSS VSS gf180mcu_as_sc_mcu7t3v3__fill_1
XTAP_TAPCELL_ROW_152_1117 VDD VSS gf180mcu_as_sc_mcu7t3v3__tap_2
XTAP_TAPCELL_ROW_152_1106 VDD VSS gf180mcu_as_sc_mcu7t3v3__tap_2
XTAP_TAPCELL_ROW_152_1139 VDD VSS gf180mcu_as_sc_mcu7t3v3__tap_2
XTAP_TAPCELL_ROW_152_1128 VDD VSS gf180mcu_as_sc_mcu7t3v3__tap_2
XFILLER_175_86 VDD VDD VSS VSS gf180mcu_as_sc_mcu7t3v3__fillcap_16
XFILLER_4_166 VDD VDD VSS VSS gf180mcu_as_sc_mcu7t3v3__fillcap_8
XFILLER_4_177 VDD VDD VSS VSS gf180mcu_as_sc_mcu7t3v3__fillcap_4
XFILLER_4_37 VDD VDD VSS VSS gf180mcu_as_sc_mcu7t3v3__fillcap_16
XFILLER_175_1094 VDD VDD VSS VSS gf180mcu_as_sc_mcu7t3v3__fill_2
XFILLER_27_1351 VDD VDD VSS VSS gf180mcu_as_sc_mcu7t3v3__fillcap_4
XPHY_EDGE_ROW_73_1_Left_265 VDD VSS gf180mcu_as_sc_mcu7t3v3__tap_2
Xinput240 VDD VDD VSS VSS south_in[23] _4192_/A gf180mcu_as_sc_mcu7t3v3__buff_12
Xinput251 VDD VDD VSS VSS south_in[33] _3954_/A gf180mcu_as_sc_mcu7t3v3__buff_12
Xinput262 VDD VDD VSS VSS sw_in[10] _4090_/A gf180mcu_as_sc_mcu7t3v3__buff_12
Xinput273 VDD VDD VSS VSS sw_in[20] _4171_/A gf180mcu_as_sc_mcu7t3v3__buff_12
Xinput284 VDD VDD VSS VSS sw_in[30] _4253_/A gf180mcu_as_sc_mcu7t3v3__buff_12
Xinput295 VDD VDD VSS VSS sw_in[8] _4074_/A gf180mcu_as_sc_mcu7t3v3__buff_12
XPHY_EDGE_ROW_18_1_Right_527 VDD VSS gf180mcu_as_sc_mcu7t3v3__tap_2
XFILLER_189_543 VDD VDD VSS VSS gf180mcu_as_sc_mcu7t3v3__fill_2
X_3870_ VDD VDD VSS VSS _3870_/D _3870_/A _3870_/B _3870_/C _3872_/C gf180mcu_as_sc_mcu7t3v3__ao31_2
XFILLER_182_1087 VDD VDD VSS VSS gf180mcu_as_sc_mcu7t3v3__fillcap_4
X_2821_ VDD VDD VSS VSS _4141_/A _2827_/B _2821_/C _2821_/D _2822_/D gf180mcu_as_sc_mcu7t3v3__ao211_2
XFILLER_158_963 VDD VDD VSS VSS gf180mcu_as_sc_mcu7t3v3__fillcap_8
X_2752_ VDD VDD VSS VSS _4079_/A _2823_/D _2752_/C _2752_/D _2987_/A gf180mcu_as_sc_mcu7t3v3__ao211_2
XFILLER_157_462 VDD VDD VSS VSS gf180mcu_as_sc_mcu7t3v3__fillcap_4
XFILLER_157_484 VDD VDD VSS VSS gf180mcu_as_sc_mcu7t3v3__fillcap_4
XFILLER_173_944 VDD VDD VSS VSS gf180mcu_as_sc_mcu7t3v3__fill_2
XFILLER_191_229 VDD VDD VSS VSS gf180mcu_as_sc_mcu7t3v3__fill_1
XFILLER_9_973 VDD VDD VSS VSS gf180mcu_as_sc_mcu7t3v3__fillcap_4
XFILLER_172_443 VDD VDD VSS VSS gf180mcu_as_sc_mcu7t3v3__fill_1
XFILLER_173_977 VDD VDD VSS VSS gf180mcu_as_sc_mcu7t3v3__fill_2
XFILLER_69_2 VDD VDD VSS VSS gf180mcu_as_sc_mcu7t3v3__fill_1
X_4422_ VDD VDD VSS VSS _4429_/CLK _4422_/D _4422_/Q gf180mcu_as_sc_mcu7t3v3__dfxtp_2
X_2683_ VDD VDD VSS VSS _4774_/Q _2810_/B _2901_/C _4021_/D _2685_/C gf180mcu_as_sc_mcu7t3v3__ao22_2
XFILLER_158_1292 VDD VDD VSS VSS gf180mcu_as_sc_mcu7t3v3__fill_2
X_4353_ VDD VDD VSS VSS _4440_/CLK _4353_/D _4353_/Q gf180mcu_as_sc_mcu7t3v3__dfxtp_2
X_4284_ VDD VDD VSS VSS _4285_/S _4287_/B _4284_/A gf180mcu_as_sc_mcu7t3v3__nand2b_2
X_3304_ VDD VDD VSS VSS _3304_/S _4371_/Q _4400_/Q _3305_/B gf180mcu_as_sc_mcu7t3v3__mux2_2
XFILLER_119_1298 VDD VDD VSS VSS gf180mcu_as_sc_mcu7t3v3__fill_1
XFILLER_80_1353 VDD VDD VSS VSS gf180mcu_as_sc_mcu7t3v3__fill_2
X_3235_ VDD VDD VSS VSS _4520_/Q _3315_/B _3315_/C _4521_/Q _3236_/C gf180mcu_as_sc_mcu7t3v3__ao22_2
XFILLER_41_1326 VDD VDD VSS VSS gf180mcu_as_sc_mcu7t3v3__fillcap_4
Xmesh_tile_844 VDD VDD VSS VSS ne_out[16] gf180mcu_as_sc_mcu7t3v3__tiel_4
Xmesh_tile_833 VDD VDD VSS VSS ne_out[5] gf180mcu_as_sc_mcu7t3v3__tiel_4
Xmesh_tile_877 VDD VDD VSS VSS north_out[13] gf180mcu_as_sc_mcu7t3v3__tiel_4
Xmesh_tile_866 VDD VDD VSS VSS north_out[2] gf180mcu_as_sc_mcu7t3v3__tiel_4
Xmesh_tile_855 VDD VDD VSS VSS ne_out[27] gf180mcu_as_sc_mcu7t3v3__tiel_4
X_3166_ VDD VDD VSS VSS _4511_/D _3166_/A _3210_/B _3166_/C _3166_/D gf180mcu_as_sc_mcu7t3v3__aoi22_2
Xmesh_tile_899 VDD VDD VSS VSS north_out[35] gf180mcu_as_sc_mcu7t3v3__tiel_4
Xmesh_tile_888 VDD VDD VSS VSS north_out[24] gf180mcu_as_sc_mcu7t3v3__tiel_4
X_3097_ VDD VDD VSS VSS _3116_/S _4485_/Q _4484_/Q _4484_/D gf180mcu_as_sc_mcu7t3v3__mux2_2
XFILLER_120_48 VDD VDD VSS VSS gf180mcu_as_sc_mcu7t3v3__fillcap_16
XFILLER_165_1230 VDD VDD VSS VSS gf180mcu_as_sc_mcu7t3v3__fillcap_16
XFILLER_161_1116 VDD VDD VSS VSS gf180mcu_as_sc_mcu7t3v3__fillcap_4
X_3999_ VDD VDD VSS VSS _4006_/B _3999_/B _3999_/A gf180mcu_as_sc_mcu7t3v3__nor2b_2
XFILLER_167_259 VDD VDD VSS VSS gf180mcu_as_sc_mcu7t3v3__fillcap_16
XFILLER_183_719 VDD VDD VSS VSS gf180mcu_as_sc_mcu7t3v3__fill_1
Xwire808 VDD VDD VSS VSS wire808/A _4268_/A gf180mcu_as_sc_mcu7t3v3__clkbuff_12
XFILLER_129_35 VDD VDD VSS VSS gf180mcu_as_sc_mcu7t3v3__fillcap_4
XFILLER_13_79 VDD VDD VSS VSS gf180mcu_as_sc_mcu7t3v3__fillcap_8
XFILLER_11_1130 VDD VDD VSS VSS gf180mcu_as_sc_mcu7t3v3__fill_2
XFILLER_129_79 VDD VDD VSS VSS gf180mcu_as_sc_mcu7t3v3__fillcap_4
XFILLER_163_454 VDD VDD VSS VSS gf180mcu_as_sc_mcu7t3v3__fill_1
XFILLER_102_1291 VDD VDD VSS VSS gf180mcu_as_sc_mcu7t3v3__fillcap_4
XFILLER_137_1321 VDD VDD VSS VSS gf180mcu_as_sc_mcu7t3v3__fill_2
XFILLER_145_56 VDD VDD VSS VSS gf180mcu_as_sc_mcu7t3v3__fill_2
XFILLER_172_1234 VDD VDD VSS VSS gf180mcu_as_sc_mcu7t3v3__fillcap_8
XFILLER_161_22 VDD VDD VSS VSS gf180mcu_as_sc_mcu7t3v3__fillcap_16
XPHY_EDGE_ROW_145_1_Right_654 VDD VSS gf180mcu_as_sc_mcu7t3v3__tap_2
XFILLER_2_1353 VDD VDD VSS VSS gf180mcu_as_sc_mcu7t3v3__fill_2
XFILLER_54_31 VDD VDD VSS VSS gf180mcu_as_sc_mcu7t3v3__fillcap_4
X_4725__1046 VDD VDD VSS VSS _4725_/D gf180mcu_as_sc_mcu7t3v3__tiel_4
XFILLER_144_1303 VDD VDD VSS VSS gf180mcu_as_sc_mcu7t3v3__fill_2
XFILLER_144_1336 VDD VDD VSS VSS gf180mcu_as_sc_mcu7t3v3__fill_1
XFILLER_183_1352 VDD VDD VSS VSS gf180mcu_as_sc_mcu7t3v3__fill_2
XFILLER_18_1306 VDD VDD VSS VSS gf180mcu_as_sc_mcu7t3v3__fill_1
XFILLER_13_276 VDD VDD VSS VSS gf180mcu_as_sc_mcu7t3v3__fill_1
XFILLER_158_237 VDD VDD VSS VSS gf180mcu_as_sc_mcu7t3v3__fillcap_8
XFILLER_186_524 VDD VDD VSS VSS gf180mcu_as_sc_mcu7t3v3__fill_1
XTAP_TAPCELL_ROW_12_912 VDD VSS gf180mcu_as_sc_mcu7t3v3__tap_2
XTAP_TAPCELL_ROW_12_923 VDD VSS gf180mcu_as_sc_mcu7t3v3__tap_2
XFILLER_70_74 VDD VDD VSS VSS gf180mcu_as_sc_mcu7t3v3__fillcap_16
Xclkload17 VDD VDD VSS VSS _4719_/CLK clkload17/Y gf180mcu_as_sc_mcu7t3v3__clkbuff_4
XTAP_TAPCELL_ROW_171_1504 VDD VSS gf180mcu_as_sc_mcu7t3v3__tap_2
XFILLER_154_443 VDD VDD VSS VSS gf180mcu_as_sc_mcu7t3v3__fill_1
XFILLER_155_977 VDD VDD VSS VSS gf180mcu_as_sc_mcu7t3v3__fill_2
XFILLER_182_741 VDD VDD VSS VSS gf180mcu_as_sc_mcu7t3v3__fill_2
XFILLER_186_85 VDD VDD VSS VSS gf180mcu_as_sc_mcu7t3v3__fillcap_16
XFILLER_6_943 VDD VDD VSS VSS gf180mcu_as_sc_mcu7t3v3__fill_2
XFILLER_170_925 VDD VDD VSS VSS gf180mcu_as_sc_mcu7t3v3__fill_2
XFILLER_181_262 VDD VDD VSS VSS gf180mcu_as_sc_mcu7t3v3__fill_2
XFILLER_6_987 VDD VDD VSS VSS gf180mcu_as_sc_mcu7t3v3__fill_1
XFILLER_6_998 VDD VDD VSS VSS gf180mcu_as_sc_mcu7t3v3__fill_2
XFILLER_141_104 VDD VDD VSS VSS gf180mcu_as_sc_mcu7t3v3__fill_1
XFILLER_170_947 VDD VDD VSS VSS gf180mcu_as_sc_mcu7t3v3__fillcap_4
XFILLER_79_72 VDD VDD VSS VSS gf180mcu_as_sc_mcu7t3v3__fill_2
XFILLER_190_1345 VDD VDD VSS VSS gf180mcu_as_sc_mcu7t3v3__fillcap_8
XTAP_TAPCELL_ROW_169_1466 VDD VSS gf180mcu_as_sc_mcu7t3v3__tap_2
XTAP_TAPCELL_ROW_169_1455 VDD VSS gf180mcu_as_sc_mcu7t3v3__tap_2
XFILLER_3_1117 VDD VDD VSS VSS gf180mcu_as_sc_mcu7t3v3__fill_2
X_3020_ VDD VDD VSS VSS _3020_/S _4430_/Q _3020_/A _4430_/D gf180mcu_as_sc_mcu7t3v3__mux2_2
XTAP_TAPCELL_ROW_186_1780 VDD VSS gf180mcu_as_sc_mcu7t3v3__tap_2
XFILLER_95_82 VDD VDD VSS VSS gf180mcu_as_sc_mcu7t3v3__fillcap_4
XTAP_TAPCELL_ROW_182_1699 VDD VSS gf180mcu_as_sc_mcu7t3v3__tap_2
XPHY_EDGE_ROW_19_1_Right_528 VDD VSS gf180mcu_as_sc_mcu7t3v3__tap_2
XFILLER_177_513 VDD VDD VSS VSS gf180mcu_as_sc_mcu7t3v3__fill_1
X_3922_ VDD VDD VSS VSS _3933_/S _3922_/B _4253_/A _3923_/B gf180mcu_as_sc_mcu7t3v3__mux2_2
XFILLER_189_395 VDD VDD VSS VSS gf180mcu_as_sc_mcu7t3v3__fillcap_4
X_3853_ VDD VDD VSS VSS _3853_/D _3926_/D _3853_/B _3853_/C _3855_/C gf180mcu_as_sc_mcu7t3v3__ao31_2
XFILLER_192_505 VDD VDD VSS VSS gf180mcu_as_sc_mcu7t3v3__fill_1
X_2804_ VDD VDD VSS VSS _4125_/A _2902_/B _2804_/C _2804_/D _2805_/C gf180mcu_as_sc_mcu7t3v3__ao211_2
XFILLER_117_101 VDD VDD VSS VSS gf180mcu_as_sc_mcu7t3v3__fillcap_4
XFILLER_192_527 VDD VDD VSS VSS gf180mcu_as_sc_mcu7t3v3__fillcap_4
X_3784_ VDD VDD VSS VSS _3784_/B _3884_/A _4672_/D gf180mcu_as_sc_mcu7t3v3__and2_2
XFILLER_173_752 VDD VDD VSS VSS gf180mcu_as_sc_mcu7t3v3__fillcap_16
X_2735_ VDD VDD VSS VSS _4339_/Q _2772_/B _3016_/A _2772_/D _4339_/D gf180mcu_as_sc_mcu7t3v3__ao22_2
X_2666_ VDD VDD VSS VSS _3990_/D _2901_/B _2902_/C _3990_/A _2667_/D gf180mcu_as_sc_mcu7t3v3__ao22_2
XFILLER_132_104 VDD VDD VSS VSS gf180mcu_as_sc_mcu7t3v3__fill_1
X_4405_ VDD VDD VSS VSS _4533_/CLK _4405_/D _4405_/Q gf180mcu_as_sc_mcu7t3v3__dfxtp_2
XFILLER_160_468 VDD VDD VSS VSS gf180mcu_as_sc_mcu7t3v3__fillcap_8
X_4336_ VDD VDD VSS VSS clkload9/A _4336_/D _4336_/Q gf180mcu_as_sc_mcu7t3v3__dfxtp_2
X_2597_ VDD VDD VSS VSS _4241_/A _3621_/A _3937_/A gf180mcu_as_sc_mcu7t3v3__nand2_2
XFILLER_8_1017 VDD VDD VSS VSS gf180mcu_as_sc_mcu7t3v3__fill_1
X_4267_ VDD VDD VSS VSS _4267_/A _4267_/B _4267_/C _4268_/D gf180mcu_as_sc_mcu7t3v3__nand3_2
X_4198_ VDD VDD VSS VSS _4198_/A _4207_/B _4207_/C _4198_/D _4199_/C gf180mcu_as_sc_mcu7t3v3__ao22_2
X_3218_ VDD VDD VSS VSS _3218_/A _3218_/B _3405_/B _3585_/B _3219_/A gf180mcu_as_sc_mcu7t3v3__ao22_2
XFILLER_132_1273 VDD VDD VSS VSS gf180mcu_as_sc_mcu7t3v3__fill_2
XFILLER_132_1284 VDD VDD VSS VSS gf180mcu_as_sc_mcu7t3v3__fillcap_4
X_3149_ VDD VDD VSS VSS _3152_/B _4488_/Q _4485_/Q gf180mcu_as_sc_mcu7t3v3__nor2_2
XFILLER_131_69 VDD VDD VSS VSS gf180mcu_as_sc_mcu7t3v3__fill_1
XFILLER_165_1060 VDD VDD VSS VSS gf180mcu_as_sc_mcu7t3v3__fill_1
XFILLER_145_6 VDD VDD VSS VSS gf180mcu_as_sc_mcu7t3v3__fillcap_16
XFILLER_24_45 VDD VDD VSS VSS gf180mcu_as_sc_mcu7t3v3__fillcap_4
XFILLER_156_22 VDD VDD VSS VSS gf180mcu_as_sc_mcu7t3v3__fillcap_8
XFILLER_123_104 VDD VDD VSS VSS gf180mcu_as_sc_mcu7t3v3__fill_1
XFILLER_152_936 VDD VDD VSS VSS gf180mcu_as_sc_mcu7t3v3__fillcap_16
XFILLER_152_958 VDD VDD VSS VSS gf180mcu_as_sc_mcu7t3v3__fill_1
XFILLER_163_273 VDD VDD VSS VSS gf180mcu_as_sc_mcu7t3v3__fillcap_4
XFILLER_172_43 VDD VDD VSS VSS gf180mcu_as_sc_mcu7t3v3__fill_1
Xfanout760 VDD VDD VSS VSS _2189_/Y _3956_/A gf180mcu_as_sc_mcu7t3v3__buff_12
Xfanout782 VDD VDD VSS VSS _2424_/A _2461_/C gf180mcu_as_sc_mcu7t3v3__buff_12
Xfanout793 VDD VDD VSS VSS _2493_/B _4807_/D gf180mcu_as_sc_mcu7t3v3__buff_12
XPHY_EDGE_ROW_130_3_Right_171 VDD VSS gf180mcu_as_sc_mcu7t3v3__tap_2
XFILLER_111_1313 VDD VDD VSS VSS gf180mcu_as_sc_mcu7t3v3__fillcap_4
XTAP_TAPCELL_ROW_164_1363 VDD VSS gf180mcu_as_sc_mcu7t3v3__tap_2
XFILLER_2_1150 VDD VDD VSS VSS gf180mcu_as_sc_mcu7t3v3__fill_1
XPHY_EDGE_ROW_146_1_Right_655 VDD VSS gf180mcu_as_sc_mcu7t3v3__tap_2
XFILLER_109_1264 VDD VDD VSS VSS gf180mcu_as_sc_mcu7t3v3__fillcap_4
XFILLER_148_1291 VDD VDD VSS VSS gf180mcu_as_sc_mcu7t3v3__fillcap_4
XFILLER_81_62 VDD VDD VSS VSS gf180mcu_as_sc_mcu7t3v3__fill_1
XFILLER_159_557 VDD VDD VSS VSS gf180mcu_as_sc_mcu7t3v3__fill_2
XFILLER_174_538 VDD VDD VSS VSS gf180mcu_as_sc_mcu7t3v3__fillcap_4
XFILLER_186_387 VDD VDD VSS VSS gf180mcu_as_sc_mcu7t3v3__fillcap_16
X_2520_ VDD VDD VSS VSS _2521_/B _2566_/C _2566_/B gf180mcu_as_sc_mcu7t3v3__nand2_2
XFILLER_182_593 VDD VDD VSS VSS gf180mcu_as_sc_mcu7t3v3__fill_2
X_2451_ VDD VDD VSS VSS _2491_/S _4529_/Q _4521_/Q _2452_/C gf180mcu_as_sc_mcu7t3v3__mux2_2
XFILLER_155_1240 VDD VDD VSS VSS gf180mcu_as_sc_mcu7t3v3__fill_2
XFILLER_68_1281 VDD VDD VSS VSS gf180mcu_as_sc_mcu7t3v3__fillcap_8
XTAP_TAPCELL_ROW_188_1820 VDD VSS gf180mcu_as_sc_mcu7t3v3__tap_2
XFILLER_155_1262 VDD VDD VSS VSS gf180mcu_as_sc_mcu7t3v3__fillcap_8
XFILLER_190_1153 VDD VDD VSS VSS gf180mcu_as_sc_mcu7t3v3__fill_2
X_2382_ VDD VDD VSS VSS _2382_/B _4584_/Q _3468_/C gf180mcu_as_sc_mcu7t3v3__and2_2
XFILLER_155_1284 VDD VDD VSS VSS gf180mcu_as_sc_mcu7t3v3__fill_1
X_4121_ VDD VDD VSS VSS _4122_/C _4121_/C _4154_/S _4121_/A gf180mcu_as_sc_mcu7t3v3__aoi21_2
X_4052_ VDD VDD VSS VSS _4052_/A _4149_/B _4149_/C _4052_/D _4054_/B gf180mcu_as_sc_mcu7t3v3__ao22_2
XTAP_TAPCELL_ROW_184_1739 VDD VSS gf180mcu_as_sc_mcu7t3v3__tap_2
Xinput4 VDD VDD VSS VSS boot_addr[2] input4/Y gf180mcu_as_sc_mcu7t3v3__buff_12
X_3003_ VDD VDD VSS VSS _3003_/A _3006_/B _3006_/C _4415_/Q _4415_/D gf180mcu_as_sc_mcu7t3v3__ao22_2
XFILLER_188_1060 VDD VDD VSS VSS gf180mcu_as_sc_mcu7t3v3__fillcap_16
XTAP_TAPCELL_ROW_53_1_1006 VDD VSS gf180mcu_as_sc_mcu7t3v3__tap_2
XPHY_EDGE_ROW_36_1_Left_228 VDD VSS gf180mcu_as_sc_mcu7t3v3__tap_2
XFILLER_162_1200 VDD VDD VSS VSS gf180mcu_as_sc_mcu7t3v3__fillcap_16
X_3905_ VDD VDD VSS VSS _3933_/S _3905_/B _4238_/A _3906_/B gf180mcu_as_sc_mcu7t3v3__mux2_2
XFILLER_162_1244 VDD VDD VSS VSS gf180mcu_as_sc_mcu7t3v3__fill_1
XFILLER_177_343 VDD VDD VSS VSS gf180mcu_as_sc_mcu7t3v3__fillcap_4
X_3836_ VDD VDD VSS VSS _4179_/B _3872_/B _3836_/C _3836_/D _3837_/B gf180mcu_as_sc_mcu7t3v3__ao211_2
XTAP_TAPCELL_ROW_81_3_1992 VDD VSS gf180mcu_as_sc_mcu7t3v3__tap_2
XFILLER_192_346 VDD VDD VSS VSS gf180mcu_as_sc_mcu7t3v3__fill_2
X_3767_ VDD VDD VSS VSS _3798_/B _4120_/A _3773_/C gf180mcu_as_sc_mcu7t3v3__and2_2
X_2718_ VDD VDD VSS VSS _2818_/B _4055_/A _2722_/C gf180mcu_as_sc_mcu7t3v3__and2_2
XPHY_EDGE_ROW_150_1_Left_342 VDD VSS gf180mcu_as_sc_mcu7t3v3__tap_2
XFILLER_105_104 VDD VDD VSS VSS gf180mcu_as_sc_mcu7t3v3__fill_1
XFILLER_161_744 VDD VDD VSS VSS gf180mcu_as_sc_mcu7t3v3__fill_1
XFILLER_173_593 VDD VDD VSS VSS gf180mcu_as_sc_mcu7t3v3__fillcap_8
X_3698_ VDD VDD VSS VSS _4778_/Q _3806_/B _3808_/C _4053_/D _3699_/D gf180mcu_as_sc_mcu7t3v3__ao22_2
XFILLER_0_905 VDD VDD VSS VSS gf180mcu_as_sc_mcu7t3v3__fill_2
XFILLER_10_47 VDD VDD VSS VSS gf180mcu_as_sc_mcu7t3v3__fillcap_16
XFILLER_160_221 VDD VDD VSS VSS gf180mcu_as_sc_mcu7t3v3__fillcap_16
XFILLER_47_1321 VDD VDD VSS VSS gf180mcu_as_sc_mcu7t3v3__fill_2
Xoutput352 VDD VDD VSS VSS _4694_/Q east_out[1] gf180mcu_as_sc_mcu7t3v3__buff_12
Xoutput341 VDD VDD VSS VSS _4693_/Q east_out[0] gf180mcu_as_sc_mcu7t3v3__buff_12
X_2649_ VDD VDD VSS VSS _2660_/A _2668_/A _2654_/C _2649_/C _2649_/Y gf180mcu_as_sc_mcu7t3v3__ao31_2
XFILLER_134_1302 VDD VDD VSS VSS gf180mcu_as_sc_mcu7t3v3__fillcap_8
XFILLER_160_287 VDD VDD VSS VSS gf180mcu_as_sc_mcu7t3v3__fillcap_8
Xoutput396 VDD VDD VSS VSS _4684_/Q south_out[27] gf180mcu_as_sc_mcu7t3v3__buff_12
Xoutput385 VDD VDD VSS VSS _4674_/Q south_out[17] gf180mcu_as_sc_mcu7t3v3__buff_12
Xoutput374 VDD VDD VSS VSS _4700_/Q east_out[7] gf180mcu_as_sc_mcu7t3v3__buff_12
Xoutput363 VDD VDD VSS VSS _4695_/Q east_out[2] gf180mcu_as_sc_mcu7t3v3__buff_12
XFILLER_82_1256 VDD VDD VSS VSS gf180mcu_as_sc_mcu7t3v3__fillcap_16
X_4319_ VDD VDD VSS VSS _4804_/D _4511_/Q _4796_/D gf180mcu_as_sc_mcu7t3v3__and2_2
XFILLER_19_56 VDD VDD VSS VSS gf180mcu_as_sc_mcu7t3v3__fill_2
Xclkbuf_leaf_25_clk_regs VDD VDD VSS VSS clkload1/A _4809_/CLK gf180mcu_as_sc_mcu7t3v3__clkbuff_12
XTAP_TAPCELL_ROW_3_754 VDD VSS gf180mcu_as_sc_mcu7t3v3__tap_2
XTAP_TAPCELL_ROW_3_743 VDD VSS gf180mcu_as_sc_mcu7t3v3__tap_2
XPHY_EDGE_ROW_155_Right_17 VDD VSS gf180mcu_as_sc_mcu7t3v3__tap_2
XFILLER_167_1100 VDD VDD VSS VSS gf180mcu_as_sc_mcu7t3v3__fillcap_16
XFILLER_167_1122 VDD VDD VSS VSS gf180mcu_as_sc_mcu7t3v3__fillcap_16
XFILLER_187_107 VDD VDD VSS VSS gf180mcu_as_sc_mcu7t3v3__fill_1
XPHY_EDGE_ROW_48_3_Right_89 VDD VSS gf180mcu_as_sc_mcu7t3v3__tap_2
XFILLER_168_321 VDD VDD VSS VSS gf180mcu_as_sc_mcu7t3v3__fill_2
XFILLER_54_1303 VDD VDD VSS VSS gf180mcu_as_sc_mcu7t3v3__fill_2
XFILLER_169_866 VDD VDD VSS VSS gf180mcu_as_sc_mcu7t3v3__fill_2
XFILLER_184_803 VDD VDD VSS VSS gf180mcu_as_sc_mcu7t3v3__fill_2
XPHY_EDGE_ROW_21_3_Left_393 VDD VSS gf180mcu_as_sc_mcu7t3v3__tap_2
XFILLER_156_505 VDD VDD VSS VSS gf180mcu_as_sc_mcu7t3v3__fillcap_4
XFILLER_156_527 VDD VDD VSS VSS gf180mcu_as_sc_mcu7t3v3__fill_2
XPHY_EDGE_ROW_164_Right_26 VDD VSS gf180mcu_as_sc_mcu7t3v3__tap_2
XFILLER_13_1022 VDD VDD VSS VSS gf180mcu_as_sc_mcu7t3v3__fill_1
XFILLER_184_869 VDD VDD VSS VSS gf180mcu_as_sc_mcu7t3v3__fillcap_4
XPHY_EDGE_ROW_82_1_Left_274 VDD VSS gf180mcu_as_sc_mcu7t3v3__tap_2
XFILLER_152_744 VDD VDD VSS VSS gf180mcu_as_sc_mcu7t3v3__fillcap_4
XTAP_TAPCELL_ROW_166_1403 VDD VSS gf180mcu_as_sc_mcu7t3v3__tap_2
XPHY_EDGE_ROW_173_Right_35 VDD VSS gf180mcu_as_sc_mcu7t3v3__tap_2
Xfanout590 VDD VDD VSS VSS _2295_/Y _3124_/S gf180mcu_as_sc_mcu7t3v3__buff_12
XFILLER_185_1200 VDD VDD VSS VSS gf180mcu_as_sc_mcu7t3v3__fill_1
XPHY_EDGE_ROW_131_3_Right_172 VDD VSS gf180mcu_as_sc_mcu7t3v3__tap_2
XPHY_EDGE_ROW_147_1_Right_656 VDD VSS gf180mcu_as_sc_mcu7t3v3__tap_2
XFILLER_178_107 VDD VDD VSS VSS gf180mcu_as_sc_mcu7t3v3__fillcap_8
XFILLER_181_1119 VDD VDD VSS VSS gf180mcu_as_sc_mcu7t3v3__fill_1
XTAP_TAPCELL_ROW_114_1_1067 VDD VSS gf180mcu_as_sc_mcu7t3v3__tap_2
XPHY_EDGE_ROW_182_Right_44 VDD VSS gf180mcu_as_sc_mcu7t3v3__tap_2
XFILLER_159_376 VDD VDD VSS VSS gf180mcu_as_sc_mcu7t3v3__fill_2
XFILLER_186_173 VDD VDD VSS VSS gf180mcu_as_sc_mcu7t3v3__fill_2
XFILLER_187_696 VDD VDD VSS VSS gf180mcu_as_sc_mcu7t3v3__fillcap_4
X_4670_ VDD VDD VSS VSS clkload5/A _4670_/D _4670_/Q gf180mcu_as_sc_mcu7t3v3__dfxtp_2
XFILLER_175_869 VDD VDD VSS VSS gf180mcu_as_sc_mcu7t3v3__fillcap_8
XFILLER_179_1004 VDD VDD VSS VSS gf180mcu_as_sc_mcu7t3v3__fill_1
XFILLER_186_195 VDD VDD VSS VSS gf180mcu_as_sc_mcu7t3v3__fill_1
X_3621_ VDD VDD VSS VSS _3644_/C _3937_/A _3621_/A gf180mcu_as_sc_mcu7t3v3__nand2b_2
XFILLER_122_1272 VDD VDD VSS VSS gf180mcu_as_sc_mcu7t3v3__fillcap_8
Xmax_cap702 VDD VDD VSS VSS _3636_/A _3916_/B gf180mcu_as_sc_mcu7t3v3__clkbuff_12
X_3552_ VDD VDD VSS VSS _4619_/D _4464_/Q _3553_/B _3552_/C gf180mcu_as_sc_mcu7t3v3__ao21_2
XFILLER_155_593 VDD VDD VSS VSS gf180mcu_as_sc_mcu7t3v3__fill_1
X_2503_ VDD VDD VSS VSS _3446_/B _2503_/B _3082_/B gf180mcu_as_sc_mcu7t3v3__nor2_2
XFILLER_192_1215 VDD VDD VSS VSS gf180mcu_as_sc_mcu7t3v3__fillcap_4
XFILLER_192_1226 VDD VDD VSS VSS gf180mcu_as_sc_mcu7t3v3__fill_1
X_3483_ VDD VDD VSS VSS _3483_/S _3526_/A _3580_/A _3484_/B gf180mcu_as_sc_mcu7t3v3__mux2_2
XFILLER_170_585 VDD VDD VSS VSS gf180mcu_as_sc_mcu7t3v3__fillcap_8
X_2434_ VDD VDD VSS VSS _2436_/D _2434_/C _2490_/B _2434_/A gf180mcu_as_sc_mcu7t3v3__aoi21b_2
XFILLER_155_1070 VDD VDD VSS VSS gf180mcu_as_sc_mcu7t3v3__fill_2
X_2365_ VDD VDD VSS VSS _3478_/A _2369_/B _2522_/A _3530_/C _3611_/B gf180mcu_as_sc_mcu7t3v3__ao211_2
XPHY_EDGE_ROW_97_3_Left_469 VDD VSS gf180mcu_as_sc_mcu7t3v3__tap_2
XPHY_EDGE_ROW_191_Right_53 VDD VSS gf180mcu_as_sc_mcu7t3v3__tap_2
X_4104_ VDD VDD VSS VSS _4104_/A _4218_/B _4136_/B _4104_/D _4105_/C gf180mcu_as_sc_mcu7t3v3__ao22_2
XFILLER_9_1189 VDD VDD VSS VSS gf180mcu_as_sc_mcu7t3v3__fill_1
X_2296_ VDD VDD VSS VSS _3128_/A _2296_/B _3124_/S _2502_/B _2296_/D gf180mcu_as_sc_mcu7t3v3__aoi31_2
X_4035_ VDD VDD VSS VSS _4035_/B _4271_/A _4696_/D gf180mcu_as_sc_mcu7t3v3__and2_2
XFILLER_164_1317 VDD VDD VSS VSS gf180mcu_as_sc_mcu7t3v3__fill_1
XANTENNA_20 VDD VDD VSS VSS _4019_/B gf180mcu_as_sc_mcu7t3v3__diode_2
XANTENNA_31 VDD VDD VSS VSS _4059_/B gf180mcu_as_sc_mcu7t3v3__diode_2
XFILLER_166_803 VDD VDD VSS VSS gf180mcu_as_sc_mcu7t3v3__fill_2
XFILLER_166_836 VDD VDD VSS VSS gf180mcu_as_sc_mcu7t3v3__fill_2
XFILLER_178_663 VDD VDD VSS VSS gf180mcu_as_sc_mcu7t3v3__fill_2
XANTENNA_42 VDD VDD VSS VSS _4227_/A gf180mcu_as_sc_mcu7t3v3__diode_2
XANTENNA_53 VDD VDD VSS VSS _2895_/B gf180mcu_as_sc_mcu7t3v3__diode_2
XANTENNA_64 VDD VDD VSS VSS _4163_/A gf180mcu_as_sc_mcu7t3v3__diode_2
XFILLER_14_1331 VDD VDD VSS VSS gf180mcu_as_sc_mcu7t3v3__fillcap_8
XFILLER_192_110 VDD VDD VSS VSS gf180mcu_as_sc_mcu7t3v3__fill_1
X_3819_ VDD VDD VSS VSS _3883_/S _3819_/B _4163_/A _3820_/B gf180mcu_as_sc_mcu7t3v3__mux2_2
XFILLER_101_1323 VDD VDD VSS VSS gf180mcu_as_sc_mcu7t3v3__fill_1
XFILLER_165_368 VDD VDD VSS VSS gf180mcu_as_sc_mcu7t3v3__fill_2
X_4799_ VDD VDD VSS VSS _4804_/CLK _4799_/D _4799_/Q gf180mcu_as_sc_mcu7t3v3__dfxtp_2
XFILLER_137_46 VDD VDD VSS VSS gf180mcu_as_sc_mcu7t3v3__fillcap_16
XFILLER_192_176 VDD VDD VSS VSS gf180mcu_as_sc_mcu7t3v3__fill_2
XFILLER_108_6 VDD VDD VSS VSS gf180mcu_as_sc_mcu7t3v3__fill_2
XTAP_TAPCELL_ROW_8_846 VDD VSS gf180mcu_as_sc_mcu7t3v3__tap_2
XTAP_TAPCELL_ROW_8_835 VDD VSS gf180mcu_as_sc_mcu7t3v3__tap_2
XFILLER_173_1170 VDD VDD VSS VSS gf180mcu_as_sc_mcu7t3v3__fillcap_16
XFILLER_0_779 VDD VDD VSS VSS gf180mcu_as_sc_mcu7t3v3__fill_2
XFILLER_173_1192 VDD VDD VSS VSS gf180mcu_as_sc_mcu7t3v3__fillcap_16
XTAP_TAPCELL_ROW_161_1311 VDD VSS gf180mcu_as_sc_mcu7t3v3__tap_2
XTAP_TAPCELL_ROW_161_1300 VDD VSS gf180mcu_as_sc_mcu7t3v3__tap_2
XFILLER_189_906 VDD VDD VSS VSS gf180mcu_as_sc_mcu7t3v3__fillcap_4
XFILLER_102_60 VDD VDD VSS VSS gf180mcu_as_sc_mcu7t3v3__fill_1
XFILLER_12_831 VDD VDD VSS VSS gf180mcu_as_sc_mcu7t3v3__fillcap_4
XFILLER_58_1291 VDD VDD VSS VSS gf180mcu_as_sc_mcu7t3v3__fill_2
XFILLER_62_53 VDD VDD VSS VSS gf180mcu_as_sc_mcu7t3v3__fillcap_8
XFILLER_12_864 VDD VDD VSS VSS gf180mcu_as_sc_mcu7t3v3__fillcap_8
XTAP_TAPCELL_ROW_159_1262 VDD VSS gf180mcu_as_sc_mcu7t3v3__tap_2
XPHY_EDGE_ROW_71_1_Right_580 VDD VSS gf180mcu_as_sc_mcu7t3v3__tap_2
XFILLER_106_1256 VDD VDD VSS VSS gf180mcu_as_sc_mcu7t3v3__fillcap_16
XFILLER_11_352 VDD VDD VSS VSS gf180mcu_as_sc_mcu7t3v3__fillcap_4
XFILLER_156_324 VDD VDD VSS VSS gf180mcu_as_sc_mcu7t3v3__fillcap_4
XTAP_TAPCELL_ROW_159_1273 VDD VSS gf180mcu_as_sc_mcu7t3v3__tap_2
XFILLER_156_357 VDD VDD VSS VSS gf180mcu_as_sc_mcu7t3v3__fillcap_16
XFILLER_8_868 VDD VDD VSS VSS gf180mcu_as_sc_mcu7t3v3__fillcap_4
XFILLER_171_349 VDD VDD VSS VSS gf180mcu_as_sc_mcu7t3v3__fill_1
XFILLER_178_1081 VDD VDD VSS VSS gf180mcu_as_sc_mcu7t3v3__fillcap_4
XFILLER_87_72 VDD VDD VSS VSS gf180mcu_as_sc_mcu7t3v3__fill_1
XTAP_TAPCELL_ROW_133_3_2044 VDD VSS gf180mcu_as_sc_mcu7t3v3__tap_2
XFILLER_152_1276 VDD VDD VSS VSS gf180mcu_as_sc_mcu7t3v3__fillcap_4
XPHY_EDGE_ROW_132_3_Right_173 VDD VSS gf180mcu_as_sc_mcu7t3v3__tap_2
XFILLER_185_1052 VDD VDD VSS VSS gf180mcu_as_sc_mcu7t3v3__fillcap_4
XPHY_EDGE_ROW_148_1_Right_657 VDD VSS gf180mcu_as_sc_mcu7t3v3__tap_2
XFILLER_124_1301 VDD VDD VSS VSS gf180mcu_as_sc_mcu7t3v3__fillcap_4
XFILLER_163_1350 VDD VDD VSS VSS gf180mcu_as_sc_mcu7t3v3__fill_1
X_2983_ VDD VDD VSS VSS _2983_/A _2989_/B _2989_/C _4395_/Q _4395_/D gf180mcu_as_sc_mcu7t3v3__ao22_2
XTAP_TAPCELL_ROW_179_1649 VDD VSS gf180mcu_as_sc_mcu7t3v3__tap_2
XTAP_TAPCELL_ROW_179_1638 VDD VSS gf180mcu_as_sc_mcu7t3v3__tap_2
X_4722_ VDD VDD VSS VSS _4728_/CLK _4722_/D _4722_/Q gf180mcu_as_sc_mcu7t3v3__dfxtp_2
XTAP_TAPCELL_ROW_48_1_1001 VDD VSS gf180mcu_as_sc_mcu7t3v3__tap_2
XFILLER_187_482 VDD VDD VSS VSS gf180mcu_as_sc_mcu7t3v3__fillcap_8
XFILLER_72_1299 VDD VDD VSS VSS gf180mcu_as_sc_mcu7t3v3__fill_2
XFILLER_175_666 VDD VDD VSS VSS gf180mcu_as_sc_mcu7t3v3__fillcap_16
X_4653_ VDD VDD VSS VSS _4809_/CLK _4653_/D _4653_/Q gf180mcu_as_sc_mcu7t3v3__dfxtp_2
Xinput40 VDD VDD VSS VSS dft_wdata[5] _2478_/B gf180mcu_as_sc_mcu7t3v3__buff_12
XFILLER_163_839 VDD VDD VSS VSS gf180mcu_as_sc_mcu7t3v3__fill_1
XFILLER_190_625 VDD VDD VSS VSS gf180mcu_as_sc_mcu7t3v3__fill_1
X_4584_ VDD VDD VSS VSS _4828_/CLK _4584_/D _4584_/Q gf180mcu_as_sc_mcu7t3v3__dfxtp_2
Xinput51 VDD VDD VSS VSS east_in[16] _4132_/D gf180mcu_as_sc_mcu7t3v3__buff_12
Xinput62 VDD VDD VSS VSS east_in[26] _4214_/D gf180mcu_as_sc_mcu7t3v3__buff_12
Xinput73 VDD VDD VSS VSS east_in[3] _4028_/D gf180mcu_as_sc_mcu7t3v3__buff_12
Xmax_cap521 VDD VDD VSS VSS fanout520/Y _4228_/B gf180mcu_as_sc_mcu7t3v3__clkbuff_12
X_3604_ VDD VDD VSS VSS _3604_/B _3604_/A _4654_/D gf180mcu_as_sc_mcu7t3v3__and2_2
XFILLER_155_390 VDD VDD VSS VSS gf180mcu_as_sc_mcu7t3v3__fillcap_16
XFILLER_190_669 VDD VDD VSS VSS gf180mcu_as_sc_mcu7t3v3__fill_1
Xinput84 VDD VDD VSS VSS ne_in[13] _4112_/A gf180mcu_as_sc_mcu7t3v3__buff_12
Xinput95 VDD VDD VSS VSS ne_in[23] _4193_/A gf180mcu_as_sc_mcu7t3v3__buff_12
Xmax_cap554 VDD VDD VSS VSS _2426_/C _2441_/A gf180mcu_as_sc_mcu7t3v3__clkbuff_12
X_3535_ VDD VDD VSS VSS _3539_/S _4613_/Q _4614_/Q _3536_/B gf180mcu_as_sc_mcu7t3v3__mux2_2
XFILLER_107_27 VDD VDD VSS VSS gf180mcu_as_sc_mcu7t3v3__fill_2
X_3466_ VDD VDD VSS VSS _3468_/C _3469_/A _3471_/D _3467_/B gf180mcu_as_sc_mcu7t3v3__nor3_2
XFILLER_170_382 VDD VDD VSS VSS gf180mcu_as_sc_mcu7t3v3__fill_2
XFILLER_44_1302 VDD VDD VSS VSS gf180mcu_as_sc_mcu7t3v3__fill_2
X_2417_ VDD VDD VSS VSS _2418_/C _3602_/B _4550_/Q gf180mcu_as_sc_mcu7t3v3__nand2_2
X_3397_ VDD VDD VSS VSS _3397_/B _4460_/Q _3404_/D gf180mcu_as_sc_mcu7t3v3__and2_2
X_2348_ VDD VDD VSS VSS _4651_/Q _2393_/C _2348_/C _2348_/D _2349_/B gf180mcu_as_sc_mcu7t3v3__ao22_2
XFILLER_123_37 VDD VDD VSS VSS gf180mcu_as_sc_mcu7t3v3__fillcap_16
X_2279_ VDD VDD VSS VSS _3611_/A _3478_/B _4622_/Q gf180mcu_as_sc_mcu7t3v3__nor2_2
X_4018_ VDD VDD VSS VSS _4221_/S _4018_/B _4018_/A _4019_/B gf180mcu_as_sc_mcu7t3v3__mux2_2
XFILLER_129_1256 VDD VDD VSS VSS gf180mcu_as_sc_mcu7t3v3__fillcap_16
XTAP_TAPCELL_ROW_68_3_1979 VDD VSS gf180mcu_as_sc_mcu7t3v3__tap_2
XFILLER_13_639 VDD VDD VSS VSS gf180mcu_as_sc_mcu7t3v3__fill_2
XFILLER_164_1147 VDD VDD VSS VSS gf180mcu_as_sc_mcu7t3v3__fillcap_8
Xsram2048.u_bank1_826 VDD VDD VSS VSS sram2048.u_bank1/WEN[5] gf180mcu_as_sc_mcu7t3v3__tiel_4
XFILLER_185_408 VDD VDD VSS VSS gf180mcu_as_sc_mcu7t3v3__fill_1
XFILLER_8_109 VDD VDD VSS VSS gf180mcu_as_sc_mcu7t3v3__fill_1
XFILLER_32_34 VDD VDD VSS VSS gf180mcu_as_sc_mcu7t3v3__fill_1
XFILLER_180_102 VDD VDD VSS VSS gf180mcu_as_sc_mcu7t3v3__fill_2
XFILLER_181_614 VDD VDD VSS VSS gf180mcu_as_sc_mcu7t3v3__fillcap_16
XFILLER_181_636 VDD VDD VSS VSS gf180mcu_as_sc_mcu7t3v3__fill_1
XFILLER_5_816 VDD VDD VSS VSS gf180mcu_as_sc_mcu7t3v3__fill_1
XTAP_TAPCELL_ROW_154_1181 VDD VSS gf180mcu_as_sc_mcu7t3v3__tap_2
XTAP_TAPCELL_ROW_154_1170 VDD VSS gf180mcu_as_sc_mcu7t3v3__tap_2
XFILLER_175_1287 VDD VDD VSS VSS gf180mcu_as_sc_mcu7t3v3__fill_1
XPHY_EDGE_ROW_113_1_Left_305 VDD VSS gf180mcu_as_sc_mcu7t3v3__tap_2
XFILLER_169_1014 VDD VDD VSS VSS gf180mcu_as_sc_mcu7t3v3__fillcap_16
XFILLER_112_1271 VDD VDD VSS VSS gf180mcu_as_sc_mcu7t3v3__fillcap_4
XFILLER_180_65 VDD VDD VSS VSS gf180mcu_as_sc_mcu7t3v3__fillcap_8
XFILLER_73_52 VDD VDD VSS VSS gf180mcu_as_sc_mcu7t3v3__fillcap_16
XFILLER_189_74 VDD VDD VSS VSS gf180mcu_as_sc_mcu7t3v3__fill_1
XFILLER_185_920 VDD VDD VSS VSS gf180mcu_as_sc_mcu7t3v3__fill_2
XPHY_EDGE_ROW_72_1_Right_581 VDD VSS gf180mcu_as_sc_mcu7t3v3__tap_2
XFILLER_156_154 VDD VDD VSS VSS gf180mcu_as_sc_mcu7t3v3__fill_1
XFILLER_185_975 VDD VDD VSS VSS gf180mcu_as_sc_mcu7t3v3__fillcap_4
XTAP_TAPCELL_ROW_174_1557 VDD VSS gf180mcu_as_sc_mcu7t3v3__tap_2
XTAP_TAPCELL_ROW_174_1546 VDD VSS gf180mcu_as_sc_mcu7t3v3__tap_2
XFILLER_7_142 VDD VDD VSS VSS gf180mcu_as_sc_mcu7t3v3__fillcap_4
XTAP_TAPCELL_ROW_191_1871 VDD VSS gf180mcu_as_sc_mcu7t3v3__tap_2
XTAP_TAPCELL_ROW_109_1_1062 VDD VSS gf180mcu_as_sc_mcu7t3v3__tap_2
XFILLER_153_850 VDD VDD VSS VSS gf180mcu_as_sc_mcu7t3v3__fillcap_4
XFILLER_171_135 VDD VDD VSS VSS gf180mcu_as_sc_mcu7t3v3__fillcap_4
XFILLER_172_658 VDD VDD VSS VSS gf180mcu_as_sc_mcu7t3v3__fillcap_4
XFILLER_176_1029 VDD VDD VSS VSS gf180mcu_as_sc_mcu7t3v3__fill_1
XFILLER_7_186 VDD VDD VSS VSS gf180mcu_as_sc_mcu7t3v3__fillcap_16
XTAP_TAPCELL_ROW_191_1882 VDD VSS gf180mcu_as_sc_mcu7t3v3__tap_2
XTAP_TAPCELL_ROW_10_884 VDD VSS gf180mcu_as_sc_mcu7t3v3__tap_2
XTAP_TAPCELL_ROW_10_873 VDD VSS gf180mcu_as_sc_mcu7t3v3__tap_2
XFILLER_153_872 VDD VDD VSS VSS gf180mcu_as_sc_mcu7t3v3__fill_1
X_3320_ VDD VDD VSS VSS _3336_/S _4373_/Q _4402_/Q _3321_/B gf180mcu_as_sc_mcu7t3v3__mux2_2
XPHY_EDGE_ROW_45_1_Left_237 VDD VSS gf180mcu_as_sc_mcu7t3v3__tap_2
XPHY_EDGE_ROW_109_3_Left_481 VDD VSS gf180mcu_as_sc_mcu7t3v3__tap_2
XFILLER_6_1104 VDD VDD VSS VSS gf180mcu_as_sc_mcu7t3v3__fill_2
X_3251_ VDD VDD VSS VSS _4522_/Q _3315_/B _3315_/C _4523_/Q _3252_/C gf180mcu_as_sc_mcu7t3v3__ao22_2
X_3182_ VDD VDD VSS VSS _3185_/D _3182_/B _3369_/A gf180mcu_as_sc_mcu7t3v3__nor2_2
X_2202_ VDD VDD VSS VSS _3580_/A _4575_/Q gf180mcu_as_sc_mcu7t3v3__inv_2
XFILLER_6_1159 VDD VDD VSS VSS gf180mcu_as_sc_mcu7t3v3__fill_1
XFILLER_179_202 VDD VDD VSS VSS gf180mcu_as_sc_mcu7t3v3__fillcap_8
XPHY_EDGE_ROW_133_3_Right_174 VDD VSS gf180mcu_as_sc_mcu7t3v3__tap_2
XFILLER_168_909 VDD VDD VSS VSS gf180mcu_as_sc_mcu7t3v3__fillcap_16
XFILLER_167_419 VDD VDD VSS VSS gf180mcu_as_sc_mcu7t3v3__fill_1
XPHY_EDGE_ROW_149_1_Right_658 VDD VSS gf180mcu_as_sc_mcu7t3v3__tap_2
X_2966_ VDD VDD VSS VSS _3002_/A _2966_/A _3033_/A gf180mcu_as_sc_mcu7t3v3__and2_2
X_4705_ VDD VDD VSS VSS _4728_/CLK _4705_/D _4705_/Q gf180mcu_as_sc_mcu7t3v3__dfxtp_2
X_2897_ VDD VDD VSS VSS _2897_/B _4210_/D _2898_/D gf180mcu_as_sc_mcu7t3v3__or2_2
X_4636_ VDD VDD VSS VSS _4808_/CLK _4636_/D _4636_/Q gf180mcu_as_sc_mcu7t3v3__dfxtp_2
XFILLER_118_48 VDD VDD VSS VSS gf180mcu_as_sc_mcu7t3v3__fillcap_16
XFILLER_163_647 VDD VDD VSS VSS gf180mcu_as_sc_mcu7t3v3__fillcap_4
X_4567_ VDD VDD VSS VSS _4807_/CLK _4567_/D _4567_/Q gf180mcu_as_sc_mcu7t3v3__dfxtp_2
X_4498_ VDD VDD VSS VSS _4708_/CLK _4498_/D _4498_/Q gf180mcu_as_sc_mcu7t3v3__dfxtp_2
X_3518_ VDD VDD VSS VSS _3520_/S _3518_/B _4608_/Q _3519_/A gf180mcu_as_sc_mcu7t3v3__mux2_2
X_3449_ VDD VDD VSS VSS _4574_/Q _3449_/B _3449_/C _3449_/D _4574_/D gf180mcu_as_sc_mcu7t3v3__ao22_2
XPHY_EDGE_ROW_57_3_Right_98 VDD VSS gf180mcu_as_sc_mcu7t3v3__tap_2
XPHY_EDGE_ROW_91_1_Left_283 VDD VSS gf180mcu_as_sc_mcu7t3v3__tap_2
XFILLER_175_6 VDD VDD VSS VSS gf180mcu_as_sc_mcu7t3v3__fillcap_16
XFILLER_13_414 VDD VDD VSS VSS gf180mcu_as_sc_mcu7t3v3__fill_2
XFILLER_159_909 VDD VDD VSS VSS gf180mcu_as_sc_mcu7t3v3__fill_1
XFILLER_13_436 VDD VDD VSS VSS gf180mcu_as_sc_mcu7t3v3__fillcap_4
XTAP_TAPCELL_ROW_16_3_1927 VDD VSS gf180mcu_as_sc_mcu7t3v3__tap_2
XFILLER_55_1294 VDD VDD VSS VSS gf180mcu_as_sc_mcu7t3v3__fillcap_4
XTAP_TAPCELL_ROW_156_1210 VDD VSS gf180mcu_as_sc_mcu7t3v3__tap_2
XFILLER_9_418 VDD VDD VSS VSS gf180mcu_as_sc_mcu7t3v3__fill_2
XFILLER_159_88 VDD VDD VSS VSS gf180mcu_as_sc_mcu7t3v3__fillcap_16
XFILLER_16_1256 VDD VDD VSS VSS gf180mcu_as_sc_mcu7t3v3__fillcap_4
XFILLER_166_485 VDD VDD VSS VSS gf180mcu_as_sc_mcu7t3v3__fillcap_16
XFILLER_181_400 VDD VDD VSS VSS gf180mcu_as_sc_mcu7t3v3__fill_2
XFILLER_182_923 VDD VDD VSS VSS gf180mcu_as_sc_mcu7t3v3__fillcap_16
XTAP_TAPCELL_ROW_152_1107 VDD VSS gf180mcu_as_sc_mcu7t3v3__tap_2
XFILLER_177_1338 VDD VDD VSS VSS gf180mcu_as_sc_mcu7t3v3__fill_1
XFILLER_181_422 VDD VDD VSS VSS gf180mcu_as_sc_mcu7t3v3__fillcap_8
XTAP_TAPCELL_ROW_152_1129 VDD VSS gf180mcu_as_sc_mcu7t3v3__tap_2
XTAP_TAPCELL_ROW_152_1118 VDD VSS gf180mcu_as_sc_mcu7t3v3__tap_2
XFILLER_153_168 VDD VDD VSS VSS gf180mcu_as_sc_mcu7t3v3__fill_1
XFILLER_175_54 VDD VDD VSS VSS gf180mcu_as_sc_mcu7t3v3__fillcap_16
XFILLER_4_16 VDD VDD VSS VSS gf180mcu_as_sc_mcu7t3v3__fill_1
XFILLER_1_874 VDD VDD VSS VSS gf180mcu_as_sc_mcu7t3v3__fillcap_4
Xinput230 VDD VDD VSS VSS south_in[14] _4116_/A gf180mcu_as_sc_mcu7t3v3__buff_12
Xinput241 VDD VDD VSS VSS south_in[24] _4198_/A gf180mcu_as_sc_mcu7t3v3__buff_12
Xinput252 VDD VDD VSS VSS south_in[34] _3964_/A gf180mcu_as_sc_mcu7t3v3__buff_12
Xinput263 VDD VDD VSS VSS sw_in[11] _4098_/A gf180mcu_as_sc_mcu7t3v3__buff_12
Xinput274 VDD VDD VSS VSS sw_in[21] _4180_/A gf180mcu_as_sc_mcu7t3v3__buff_12
Xinput285 VDD VDD VSS VSS sw_in[31] _4269_/A gf180mcu_as_sc_mcu7t3v3__buff_12
Xinput296 VDD VDD VSS VSS sw_in[9] _2745_/A gf180mcu_as_sc_mcu7t3v3__buff_12
XFILLER_97_1317 VDD VDD VSS VSS gf180mcu_as_sc_mcu7t3v3__fillcap_4
XFILLER_97_1306 VDD VDD VSS VSS gf180mcu_as_sc_mcu7t3v3__fillcap_4
XFILLER_90_100 VDD VDD VSS VSS gf180mcu_as_sc_mcu7t3v3__fillcap_4
XFILLER_189_511 VDD VDD VSS VSS gf180mcu_as_sc_mcu7t3v3__fillcap_4
XFILLER_186_1180 VDD VDD VSS VSS gf180mcu_as_sc_mcu7t3v3__fill_2
X_2820_ VDD VDD VSS VSS _2829_/B _4141_/D _2821_/D gf180mcu_as_sc_mcu7t3v3__and2_2
XFILLER_13_992 VDD VDD VSS VSS gf180mcu_as_sc_mcu7t3v3__fill_2
X_2751_ VDD VDD VSS VSS _2752_/D _4080_/A _2823_/B _2751_/C gf180mcu_as_sc_mcu7t3v3__ao21_2
XFILLER_121_1326 VDD VDD VSS VSS gf180mcu_as_sc_mcu7t3v3__fill_2
XFILLER_144_102 VDD VDD VSS VSS gf180mcu_as_sc_mcu7t3v3__fill_2
XFILLER_158_997 VDD VDD VSS VSS gf180mcu_as_sc_mcu7t3v3__fillcap_4
XFILLER_172_400 VDD VDD VSS VSS gf180mcu_as_sc_mcu7t3v3__fill_2
XFILLER_173_912 VDD VDD VSS VSS gf180mcu_as_sc_mcu7t3v3__fill_1
XFILLER_184_271 VDD VDD VSS VSS gf180mcu_as_sc_mcu7t3v3__fillcap_4
XFILLER_185_772 VDD VDD VSS VSS gf180mcu_as_sc_mcu7t3v3__fill_2
XFILLER_185_794 VDD VDD VSS VSS gf180mcu_as_sc_mcu7t3v3__fill_2
XFILLER_191_219 VDD VDD VSS VSS gf180mcu_as_sc_mcu7t3v3__fillcap_8
X_2682_ VDD VDD VSS VSS _2903_/B _4023_/A _2686_/C gf180mcu_as_sc_mcu7t3v3__and2_2
XPHY_EDGE_ROW_73_1_Right_582 VDD VSS gf180mcu_as_sc_mcu7t3v3__tap_2
X_4421_ VDD VDD VSS VSS _4429_/CLK _4421_/D _4421_/Q gf180mcu_as_sc_mcu7t3v3__dfxtp_2
X_4352_ VDD VDD VSS VSS _4445_/CLK _4352_/D _4352_/Q gf180mcu_as_sc_mcu7t3v3__dfxtp_2
XFILLER_154_1157 VDD VDD VSS VSS gf180mcu_as_sc_mcu7t3v3__fill_1
X_4283_ VDD VDD VSS VSS _4287_/B _4768_/Q _4769_/Q gf180mcu_as_sc_mcu7t3v3__nand2_2
X_3303_ VDD VDD VSS VSS _3306_/C _4429_/Q _3304_/S gf180mcu_as_sc_mcu7t3v3__nand2_2
X_3234_ VDD VDD VSS VSS _3306_/A _3234_/B _3234_/C _3236_/B _3234_/D gf180mcu_as_sc_mcu7t3v3__aoi31_2
Xmesh_tile_845 VDD VDD VSS VSS ne_out[17] gf180mcu_as_sc_mcu7t3v3__tiel_4
Xmesh_tile_834 VDD VDD VSS VSS ne_out[6] gf180mcu_as_sc_mcu7t3v3__tiel_4
Xmesh_tile_878 VDD VDD VSS VSS north_out[14] gf180mcu_as_sc_mcu7t3v3__tiel_4
Xmesh_tile_867 VDD VDD VSS VSS north_out[3] gf180mcu_as_sc_mcu7t3v3__tiel_4
Xmesh_tile_856 VDD VDD VSS VSS ne_out[28] gf180mcu_as_sc_mcu7t3v3__tiel_4
X_3165_ VDD VDD VSS VSS _3166_/D _3165_/B _3210_/B gf180mcu_as_sc_mcu7t3v3__nor2_2
Xmesh_tile_889 VDD VDD VSS VSS north_out[25] gf180mcu_as_sc_mcu7t3v3__tiel_4
X_3096_ VDD VDD VSS VSS _3116_/S _4484_/Q _4483_/Q _4483_/D gf180mcu_as_sc_mcu7t3v3__mux2_2
XFILLER_120_27 VDD VDD VSS VSS gf180mcu_as_sc_mcu7t3v3__fillcap_8
XFILLER_78_1283 VDD VDD VSS VSS gf180mcu_as_sc_mcu7t3v3__fillcap_4
XPHY_EDGE_ROW_134_3_Right_175 VDD VSS gf180mcu_as_sc_mcu7t3v3__tap_2
XFILLER_39_1256 VDD VDD VSS VSS gf180mcu_as_sc_mcu7t3v3__fillcap_16
XFILLER_11_918 VDD VDD VSS VSS gf180mcu_as_sc_mcu7t3v3__fill_1
XFILLER_167_216 VDD VDD VSS VSS gf180mcu_as_sc_mcu7t3v3__fill_2
X_3998_ VDD VDD VSS VSS _4261_/A _3998_/A _3998_/Y gf180mcu_as_sc_mcu7t3v3__and2_2
XFILLER_164_901 VDD VDD VSS VSS gf180mcu_as_sc_mcu7t3v3__fill_1
Xwire809 VDD VDD VSS VSS wire809/A _3920_/A gf180mcu_as_sc_mcu7t3v3__clkbuff_12
X_2949_ VDD VDD VSS VSS _3023_/A _2951_/D _2951_/B _4375_/Q _4375_/D gf180mcu_as_sc_mcu7t3v3__ao22_2
XFILLER_129_58 VDD VDD VSS VSS gf180mcu_as_sc_mcu7t3v3__fill_1
XFILLER_13_58 VDD VDD VSS VSS gf180mcu_as_sc_mcu7t3v3__fillcap_8
XFILLER_182_219 VDD VDD VSS VSS gf180mcu_as_sc_mcu7t3v3__fillcap_8
XFILLER_163_422 VDD VDD VSS VSS gf180mcu_as_sc_mcu7t3v3__fillcap_16
XFILLER_175_282 VDD VDD VSS VSS gf180mcu_as_sc_mcu7t3v3__fillcap_8
XFILLER_163_466 VDD VDD VSS VSS gf180mcu_as_sc_mcu7t3v3__fillcap_16
X_4619_ VDD VDD VSS VSS _4830_/CLK _4619_/D _4619_/Q gf180mcu_as_sc_mcu7t3v3__dfxtp_2
XFILLER_145_24 VDD VDD VSS VSS gf180mcu_as_sc_mcu7t3v3__fill_1
XFILLER_190_285 VDD VDD VSS VSS gf180mcu_as_sc_mcu7t3v3__fill_1
XFILLER_172_1224 VDD VDD VSS VSS gf180mcu_as_sc_mcu7t3v3__fill_1
XFILLER_38_66 VDD VDD VSS VSS gf180mcu_as_sc_mcu7t3v3__fillcap_4
XTAP_TAPCELL_ROW_71_1_1024 VDD VSS gf180mcu_as_sc_mcu7t3v3__tap_2
XFILLER_22_1260 VDD VDD VSS VSS gf180mcu_as_sc_mcu7t3v3__fill_2
XFILLER_2_1310 VDD VDD VSS VSS gf180mcu_as_sc_mcu7t3v3__fill_1
XFILLER_166_1017 VDD VDD VSS VSS gf180mcu_as_sc_mcu7t3v3__fill_1
XFILLER_54_76 VDD VDD VSS VSS gf180mcu_as_sc_mcu7t3v3__fillcap_8
XTAP_TAPCELL_ROW_12_913 VDD VSS gf180mcu_as_sc_mcu7t3v3__tap_2
XTAP_TAPCELL_ROW_12_924 VDD VSS gf180mcu_as_sc_mcu7t3v3__tap_2
XFILLER_173_219 VDD VDD VSS VSS gf180mcu_as_sc_mcu7t3v3__fillcap_16
XFILLER_182_720 VDD VDD VSS VSS gf180mcu_as_sc_mcu7t3v3__fillcap_4
XFILLER_186_53 VDD VDD VSS VSS gf180mcu_as_sc_mcu7t3v3__fillcap_16
XFILLER_166_282 VDD VDD VSS VSS gf180mcu_as_sc_mcu7t3v3__fillcap_8
Xclkload18 VDD VDD VSS VSS _4807_/CLK clkload18/Y gf180mcu_as_sc_mcu7t3v3__clkbuff_12
XFILLER_177_1157 VDD VDD VSS VSS gf180mcu_as_sc_mcu7t3v3__fillcap_16
XFILLER_190_1313 VDD VDD VSS VSS gf180mcu_as_sc_mcu7t3v3__fillcap_16
XTAP_TAPCELL_ROW_169_1456 VDD VSS gf180mcu_as_sc_mcu7t3v3__tap_2
XTAP_TAPCELL_ROW_186_1781 VDD VSS gf180mcu_as_sc_mcu7t3v3__tap_2
XFILLER_188_1286 VDD VDD VSS VSS gf180mcu_as_sc_mcu7t3v3__fillcap_8
XFILLER_188_1297 VDD VDD VSS VSS gf180mcu_as_sc_mcu7t3v3__fillcap_16
XFILLER_177_503 VDD VDD VSS VSS gf180mcu_as_sc_mcu7t3v3__fillcap_8
XFILLER_189_352 VDD VDD VSS VSS gf180mcu_as_sc_mcu7t3v3__fillcap_4
X_3921_ VDD VDD VSS VSS _3921_/A _3921_/B _3921_/C _3921_/D _3922_/B gf180mcu_as_sc_mcu7t3v3__ao211_2
X_3852_ VDD VDD VSS VSS _4795_/Q _3852_/B _3926_/B _4189_/D _3853_/D gf180mcu_as_sc_mcu7t3v3__ao22_2
X_2803_ VDD VDD VSS VSS _4124_/A _2902_/C _2803_/C _2803_/D _2804_/D gf180mcu_as_sc_mcu7t3v3__ao211_2
XFILLER_125_1270 VDD VDD VSS VSS gf180mcu_as_sc_mcu7t3v3__fill_1
XFILLER_157_260 VDD VDD VSS VSS gf180mcu_as_sc_mcu7t3v3__fillcap_16
X_3783_ VDD VDD VSS VSS _3810_/S _3783_/B _4130_/A _3784_/B gf180mcu_as_sc_mcu7t3v3__mux2_2
XFILLER_9_760 VDD VDD VSS VSS gf180mcu_as_sc_mcu7t3v3__fillcap_8
XFILLER_157_282 VDD VDD VSS VSS gf180mcu_as_sc_mcu7t3v3__fillcap_16
XFILLER_158_794 VDD VDD VSS VSS gf180mcu_as_sc_mcu7t3v3__fill_2
X_2734_ VDD VDD VSS VSS _4067_/A _2919_/B _2734_/C _3016_/A _2871_/D gf180mcu_as_sc_mcu7t3v3__aoi211_2
XPHY_EDGE_ROW_74_1_Right_583 VDD VSS gf180mcu_as_sc_mcu7t3v3__tap_2
XFILLER_172_230 VDD VDD VSS VSS gf180mcu_as_sc_mcu7t3v3__fillcap_8
XFILLER_173_786 VDD VDD VSS VSS gf180mcu_as_sc_mcu7t3v3__fill_2
X_2665_ VDD VDD VSS VSS _2665_/B _2665_/A _2665_/Y gf180mcu_as_sc_mcu7t3v3__and2_2
XFILLER_156_1219 VDD VDD VSS VSS gf180mcu_as_sc_mcu7t3v3__fillcap_4
XFILLER_172_285 VDD VDD VSS VSS gf180mcu_as_sc_mcu7t3v3__fillcap_8
X_4404_ VDD VDD VSS VSS _4533_/CLK _4404_/D _4404_/Q gf180mcu_as_sc_mcu7t3v3__dfxtp_2
X_2596_ VDD VDD VSS VSS _3949_/C _3939_/A _3961_/C _3621_/A gf180mcu_as_sc_mcu7t3v3__nor3_2
X_4335_ VDD VDD VSS VSS _4429_/CLK _4335_/D _4335_/Q gf180mcu_as_sc_mcu7t3v3__dfxtp_2
XFILLER_115_38 VDD VDD VSS VSS gf180mcu_as_sc_mcu7t3v3__fill_2
X_4266_ VDD VDD VSS VSS _4266_/A _4266_/B _4266_/C _4266_/D _4270_/A gf180mcu_as_sc_mcu7t3v3__ao211_2
XFILLER_45_1293 VDD VDD VSS VSS gf180mcu_as_sc_mcu7t3v3__fillcap_4
X_4197_ VDD VDD VSS VSS _4197_/B _4271_/A _4716_/D gf180mcu_as_sc_mcu7t3v3__and2_2
X_3217_ VDD VDD VSS VSS _3219_/S _4517_/Q _3217_/A _4517_/D gf180mcu_as_sc_mcu7t3v3__mux2_2
XFILLER_54_100 VDD VDD VSS VSS gf180mcu_as_sc_mcu7t3v3__fillcap_4
X_3148_ VDD VDD VSS VSS _3148_/A _3148_/B _3148_/C _3148_/D _3159_/A gf180mcu_as_sc_mcu7t3v3__nand4_2
XFILLER_167_1348 VDD VDD VSS VSS gf180mcu_as_sc_mcu7t3v3__fill_2
X_3079_ VDD VDD VSS VSS _3079_/S _3585_/B _4477_/Q _4477_/D gf180mcu_as_sc_mcu7t3v3__mux2_2
XTAP_TAPCELL_ROW_132_1_1085 VDD VSS gf180mcu_as_sc_mcu7t3v3__tap_2
XFILLER_24_57 VDD VDD VSS VSS gf180mcu_as_sc_mcu7t3v3__fillcap_16
XPHY_EDGE_ROW_135_3_Right_176 VDD VSS gf180mcu_as_sc_mcu7t3v3__tap_2
XPHY_EDGE_ROW_122_1_Left_314 VDD VSS gf180mcu_as_sc_mcu7t3v3__tap_2
XFILLER_10_214 VDD VDD VSS VSS gf180mcu_as_sc_mcu7t3v3__fillcap_4
XFILLER_138_6 VDD VDD VSS VSS gf180mcu_as_sc_mcu7t3v3__fillcap_8
XFILLER_10_247 VDD VDD VSS VSS gf180mcu_as_sc_mcu7t3v3__fill_2
XFILLER_13_1226 VDD VDD VSS VSS gf180mcu_as_sc_mcu7t3v3__fillcap_4
XFILLER_183_539 VDD VDD VSS VSS gf180mcu_as_sc_mcu7t3v3__fillcap_4
XFILLER_104_1354 VDD VDD VSS VSS gf180mcu_as_sc_mcu7t3v3__fill_1
XFILLER_164_731 VDD VDD VSS VSS gf180mcu_as_sc_mcu7t3v3__fillcap_4
XFILLER_156_34 VDD VDD VSS VSS gf180mcu_as_sc_mcu7t3v3__fill_1
XFILLER_164_753 VDD VDD VSS VSS gf180mcu_as_sc_mcu7t3v3__fillcap_8
XTAP_TAPCELL_ROW_90_3_2001 VDD VSS gf180mcu_as_sc_mcu7t3v3__tap_2
XFILLER_191_594 VDD VDD VSS VSS gf180mcu_as_sc_mcu7t3v3__fillcap_16
XFILLER_2_457 VDD VDD VSS VSS gf180mcu_as_sc_mcu7t3v3__fill_1
Xfanout750 VDD VDD VSS VSS _4448_/Q fanout750/Y gf180mcu_as_sc_mcu7t3v3__buff_12
Xfanout783 VDD VDD VSS VSS _2424_/A _2493_/C gf180mcu_as_sc_mcu7t3v3__buff_12
Xfanout794 VDD VDD VSS VSS _2388_/A _2493_/B gf180mcu_as_sc_mcu7t3v3__buff_12
XTAP_TAPCELL_ROW_6_796 VDD VSS gf180mcu_as_sc_mcu7t3v3__tap_2
XTAP_TAPCELL_ROW_164_1353 VDD VSS gf180mcu_as_sc_mcu7t3v3__tap_2
XTAP_TAPCELL_ROW_164_1364 VDD VSS gf180mcu_as_sc_mcu7t3v3__tap_2
XPHY_EDGE_ROW_54_1_Left_246 VDD VSS gf180mcu_as_sc_mcu7t3v3__tap_2
XPHY_EDGE_ROW_118_3_Left_490 VDD VSS gf180mcu_as_sc_mcu7t3v3__tap_2
XFILLER_183_1183 VDD VDD VSS VSS gf180mcu_as_sc_mcu7t3v3__fillcap_4
XFILLER_186_311 VDD VDD VSS VSS gf180mcu_as_sc_mcu7t3v3__fillcap_4
XFILLER_187_834 VDD VDD VSS VSS gf180mcu_as_sc_mcu7t3v3__fillcap_4
XFILLER_174_506 VDD VDD VSS VSS gf180mcu_as_sc_mcu7t3v3__fillcap_16
XFILLER_179_1219 VDD VDD VSS VSS gf180mcu_as_sc_mcu7t3v3__fillcap_4
XFILLER_154_263 VDD VDD VSS VSS gf180mcu_as_sc_mcu7t3v3__fill_2
XFILLER_154_285 VDD VDD VSS VSS gf180mcu_as_sc_mcu7t3v3__fillcap_4
XFILLER_170_734 VDD VDD VSS VSS gf180mcu_as_sc_mcu7t3v3__fill_1
XFILLER_182_572 VDD VDD VSS VSS gf180mcu_as_sc_mcu7t3v3__fillcap_8
XFILLER_6_785 VDD VDD VSS VSS gf180mcu_as_sc_mcu7t3v3__fill_1
X_2450_ VDD VDD VSS VSS _2452_/D _2450_/C _2490_/B _2450_/A gf180mcu_as_sc_mcu7t3v3__aoi21b_2
XPHY_EDGE_ROW_137_3_Left_509 VDD VSS gf180mcu_as_sc_mcu7t3v3__tap_2
XFILLER_5_284 VDD VDD VSS VSS gf180mcu_as_sc_mcu7t3v3__fill_1
XTAP_TAPCELL_ROW_188_1821 VDD VSS gf180mcu_as_sc_mcu7t3v3__tap_2
XTAP_TAPCELL_ROW_188_1810 VDD VSS gf180mcu_as_sc_mcu7t3v3__tap_2
X_2381_ VDD VDD VSS VSS _2381_/B _2535_/A _2383_/C gf180mcu_as_sc_mcu7t3v3__and2_2
XFILLER_9_1327 VDD VDD VSS VSS gf180mcu_as_sc_mcu7t3v3__fill_2
X_4120_ VDD VDD VSS VSS _4120_/A _4143_/B _4153_/B _4120_/D _4121_/C gf180mcu_as_sc_mcu7t3v3__ao22_2
X_4051_ VDD VDD VSS VSS _4051_/B _4051_/A _4698_/D gf180mcu_as_sc_mcu7t3v3__and2_2
XFILLER_36_100 VDD VDD VSS VSS gf180mcu_as_sc_mcu7t3v3__fillcap_4
XFILLER_7_1073 VDD VDD VSS VSS gf180mcu_as_sc_mcu7t3v3__fillcap_4
Xinput5 VDD VDD VSS VSS boot_addr[3] input5/Y gf180mcu_as_sc_mcu7t3v3__buff_12
X_3002_ VDD VDD VSS VSS _3002_/A _3006_/B _3006_/C _4414_/Q _4414_/D gf180mcu_as_sc_mcu7t3v3__ao22_2
XFILLER_101_29 VDD VDD VSS VSS gf180mcu_as_sc_mcu7t3v3__fill_1
XFILLER_178_823 VDD VDD VSS VSS gf180mcu_as_sc_mcu7t3v3__fillcap_4
X_3904_ VDD VDD VSS VSS _4237_/A _3921_/B _3904_/C _3904_/D _3905_/B gf180mcu_as_sc_mcu7t3v3__ao211_2
XFILLER_162_1267 VDD VDD VSS VSS gf180mcu_as_sc_mcu7t3v3__fillcap_8
XFILLER_192_314 VDD VDD VSS VSS gf180mcu_as_sc_mcu7t3v3__fill_1
X_3835_ VDD VDD VSS VSS _4178_/A _3871_/B _3869_/C _4173_/D _3836_/D gf180mcu_as_sc_mcu7t3v3__ao22_2
X_3766_ VDD VDD VSS VSS _4115_/A _3855_/B _3766_/C _4670_/D _4138_/C gf180mcu_as_sc_mcu7t3v3__aoi211_2
X_2717_ VDD VDD VSS VSS _4337_/Q _2772_/B _2983_/A _2772_/D _4337_/D gf180mcu_as_sc_mcu7t3v3__ao22_2
XFILLER_161_734 VDD VDD VSS VSS gf180mcu_as_sc_mcu7t3v3__fillcap_8
X_3697_ VDD VDD VSS VSS _3859_/B _4052_/A _3699_/C gf180mcu_as_sc_mcu7t3v3__or2_2
XPHY_EDGE_ROW_75_1_Right_584 VDD VSS gf180mcu_as_sc_mcu7t3v3__tap_2
Xoutput353 VDD VDD VSS VSS _4713_/Q east_out[20] gf180mcu_as_sc_mcu7t3v3__buff_12
Xoutput342 VDD VDD VSS VSS _4703_/Q east_out[10] gf180mcu_as_sc_mcu7t3v3__buff_12
X_2648_ VDD VDD VSS VSS _2658_/C _2656_/A _2649_/C gf180mcu_as_sc_mcu7t3v3__and2_2
XFILLER_0_917 VDD VDD VSS VSS gf180mcu_as_sc_mcu7t3v3__fill_1
XFILLER_126_48 VDD VDD VSS VSS gf180mcu_as_sc_mcu7t3v3__fillcap_16
Xoutput386 VDD VDD VSS VSS _4675_/Q south_out[18] gf180mcu_as_sc_mcu7t3v3__buff_12
Xoutput375 VDD VDD VSS VSS _4701_/Q east_out[8] gf180mcu_as_sc_mcu7t3v3__buff_12
Xoutput364 VDD VDD VSS VSS _4723_/Q east_out[30] gf180mcu_as_sc_mcu7t3v3__buff_12
X_2579_ VDD VDD VSS VSS _3587_/A _2586_/B _4646_/Q _4645_/D gf180mcu_as_sc_mcu7t3v3__mux2_2
XTAP_TAPCELL_ROW_151_3_2062 VDD VSS gf180mcu_as_sc_mcu7t3v3__tap_2
Xoutput397 VDD VDD VSS VSS _4685_/Q south_out[28] gf180mcu_as_sc_mcu7t3v3__buff_12
X_4318_ VDD VDD VSS VSS _4318_/B _4542_/Q _4795_/D gf180mcu_as_sc_mcu7t3v3__and2_2
X_4249_ VDD VDD VSS VSS _4249_/A _4268_/B _4251_/B _4259_/D _4250_/C gf180mcu_as_sc_mcu7t3v3__ao22_2
XTAP_TAPCELL_ROW_3_755 VDD VSS gf180mcu_as_sc_mcu7t3v3__tap_2
XTAP_TAPCELL_ROW_3_744 VDD VSS gf180mcu_as_sc_mcu7t3v3__tap_2
XFILLER_163_1009 VDD VDD VSS VSS gf180mcu_as_sc_mcu7t3v3__fillcap_16
XFILLER_167_1189 VDD VDD VSS VSS gf180mcu_as_sc_mcu7t3v3__fill_1
XFILLER_180_1301 VDD VDD VSS VSS gf180mcu_as_sc_mcu7t3v3__fill_2
XFILLER_168_333 VDD VDD VSS VSS gf180mcu_as_sc_mcu7t3v3__fillcap_16
XPHY_EDGE_ROW_136_3_Right_177 VDD VSS gf180mcu_as_sc_mcu7t3v3__tap_2
XFILLER_167_22 VDD VDD VSS VSS gf180mcu_as_sc_mcu7t3v3__fill_1
XFILLER_183_314 VDD VDD VSS VSS gf180mcu_as_sc_mcu7t3v3__fillcap_16
XFILLER_51_88 VDD VDD VSS VSS gf180mcu_as_sc_mcu7t3v3__fillcap_16
XFILLER_164_550 VDD VDD VSS VSS gf180mcu_as_sc_mcu7t3v3__fill_1
XFILLER_192_881 VDD VDD VSS VSS gf180mcu_as_sc_mcu7t3v3__fill_2
XFILLER_3_722 VDD VDD VSS VSS gf180mcu_as_sc_mcu7t3v3__fill_2
XFILLER_139_1258 VDD VDD VSS VSS gf180mcu_as_sc_mcu7t3v3__fill_1
XFILLER_2_232 VDD VDD VSS VSS gf180mcu_as_sc_mcu7t3v3__fill_2
XFILLER_183_76 VDD VDD VSS VSS gf180mcu_as_sc_mcu7t3v3__fill_1
XFILLER_2_276 VDD VDD VSS VSS gf180mcu_as_sc_mcu7t3v3__fill_1
XTAP_TAPCELL_ROW_166_1404 VDD VSS gf180mcu_as_sc_mcu7t3v3__tap_2
XFILLER_4_1224 VDD VDD VSS VSS gf180mcu_as_sc_mcu7t3v3__fill_1
Xfanout580 VDD VDD VSS VSS _2891_/B _2818_/B gf180mcu_as_sc_mcu7t3v3__buff_12
Xfanout591 VDD VDD VSS VSS fanout592/Y _4225_/B gf180mcu_as_sc_mcu7t3v3__buff_12
XTAP_TAPCELL_ROW_86_3_1997 VDD VSS gf180mcu_as_sc_mcu7t3v3__tap_2
XFILLER_185_1245 VDD VDD VSS VSS gf180mcu_as_sc_mcu7t3v3__fill_1
XFILLER_185_1278 VDD VDD VSS VSS gf180mcu_as_sc_mcu7t3v3__fillcap_16
XFILLER_174_303 VDD VDD VSS VSS gf180mcu_as_sc_mcu7t3v3__fillcap_8
XFILLER_175_826 VDD VDD VSS VSS gf180mcu_as_sc_mcu7t3v3__fillcap_8
XFILLER_186_152 VDD VDD VSS VSS gf180mcu_as_sc_mcu7t3v3__fillcap_4
XFILLER_179_1016 VDD VDD VSS VSS gf180mcu_as_sc_mcu7t3v3__fillcap_16
X_3620_ VDD VDD VSS VSS _3966_/A _3636_/A _3953_/C gf180mcu_as_sc_mcu7t3v3__nor2b_2
XFILLER_155_550 VDD VDD VSS VSS gf180mcu_as_sc_mcu7t3v3__fillcap_8
XFILLER_190_807 VDD VDD VSS VSS gf180mcu_as_sc_mcu7t3v3__fillcap_8
X_3551_ VDD VDD VSS VSS _4620_/Q _3554_/B _3553_/C _4619_/Q _3552_/C gf180mcu_as_sc_mcu7t3v3__ao22_2
XFILLER_122_1295 VDD VDD VSS VSS gf180mcu_as_sc_mcu7t3v3__fill_1
XFILLER_183_892 VDD VDD VSS VSS gf180mcu_as_sc_mcu7t3v3__fillcap_16
X_2502_ VDD VDD VSS VSS _2502_/B _2502_/A _2503_/B gf180mcu_as_sc_mcu7t3v3__xnor2_2
XFILLER_182_391 VDD VDD VSS VSS gf180mcu_as_sc_mcu7t3v3__fill_2
X_3482_ VDD VDD VSS VSS _3600_/A _3585_/B _4594_/Q _4594_/D gf180mcu_as_sc_mcu7t3v3__mux2_2
X_2433_ VDD VDD VSS VSS _2434_/C _2433_/B _2441_/A gf180mcu_as_sc_mcu7t3v3__nor2_2
XFILLER_155_1082 VDD VDD VSS VSS gf180mcu_as_sc_mcu7t3v3__fillcap_8
X_2364_ VDD VDD VSS VSS _2535_/A _2522_/A _3530_/C gf180mcu_as_sc_mcu7t3v3__nor2_2
X_4103_ VDD VDD VSS VSS _4106_/B _4103_/B _4103_/A gf180mcu_as_sc_mcu7t3v3__nor2_2
X_2295_ VDD VDD VSS VSS _3609_/B _2295_/B _2295_/C _4631_/Q _2295_/Y gf180mcu_as_sc_mcu7t3v3__ao22_2
X_4034_ VDD VDD VSS VSS _4221_/S _4034_/B _4034_/A _4035_/B gf180mcu_as_sc_mcu7t3v3__mux2_2
XFILLER_77_1326 VDD VDD VSS VSS gf180mcu_as_sc_mcu7t3v3__fill_2
XANTENNA_10 VDD VDD VSS VSS _4709_/D gf180mcu_as_sc_mcu7t3v3__diode_2
XANTENNA_21 VDD VDD VSS VSS _4019_/B gf180mcu_as_sc_mcu7t3v3__diode_2
XANTENNA_32 VDD VDD VSS VSS _4075_/B gf180mcu_as_sc_mcu7t3v3__diode_2
XANTENNA_43 VDD VDD VSS VSS _4246_/A gf180mcu_as_sc_mcu7t3v3__diode_2
XANTENNA_54 VDD VDD VSS VSS _4184_/B gf180mcu_as_sc_mcu7t3v3__diode_2
XANTENNA_65 VDD VDD VSS VSS _4163_/A gf180mcu_as_sc_mcu7t3v3__diode_2
X_3818_ VDD VDD VSS VSS _4162_/A _3872_/B _3818_/C _3818_/D _3819_/B gf180mcu_as_sc_mcu7t3v3__ao211_2
XFILLER_14_1354 VDD VDD VSS VSS gf180mcu_as_sc_mcu7t3v3__fill_1
XFILLER_192_144 VDD VDD VSS VSS gf180mcu_as_sc_mcu7t3v3__fill_1
XFILLER_21_25 VDD VDD VSS VSS gf180mcu_as_sc_mcu7t3v3__fill_1
X_4798_ VDD VDD VSS VSS _4803_/CLK _4798_/D _4798_/Q gf180mcu_as_sc_mcu7t3v3__dfxtp_2
XTAP_TAPCELL_ROW_127_1_1080 VDD VSS gf180mcu_as_sc_mcu7t3v3__tap_2
XFILLER_180_306 VDD VDD VSS VSS gf180mcu_as_sc_mcu7t3v3__fillcap_8
XFILLER_180_317 VDD VDD VSS VSS gf180mcu_as_sc_mcu7t3v3__fillcap_16
XFILLER_21_69 VDD VDD VSS VSS gf180mcu_as_sc_mcu7t3v3__fill_1
XFILLER_4_508 VDD VDD VSS VSS gf180mcu_as_sc_mcu7t3v3__fill_2
X_3749_ VDD VDD VSS VSS _3881_/C _4104_/A _3755_/C gf180mcu_as_sc_mcu7t3v3__and2_2
XPHY_EDGE_ROW_76_1_Right_585 VDD VSS gf180mcu_as_sc_mcu7t3v3__tap_2
XTAP_TAPCELL_ROW_8_847 VDD VSS gf180mcu_as_sc_mcu7t3v3__tap_2
XTAP_TAPCELL_ROW_8_836 VDD VSS gf180mcu_as_sc_mcu7t3v3__tap_2
XFILLER_0_747 VDD VDD VSS VSS gf180mcu_as_sc_mcu7t3v3__fill_1
XFILLER_153_46 VDD VDD VSS VSS gf180mcu_as_sc_mcu7t3v3__fillcap_16
XTAP_TAPCELL_ROW_161_1301 VDD VSS gf180mcu_as_sc_mcu7t3v3__tap_2
XTAP_TAPCELL_ROW_161_1312 VDD VSS gf180mcu_as_sc_mcu7t3v3__tap_2
XFILLER_102_72 VDD VDD VSS VSS gf180mcu_as_sc_mcu7t3v3__fillcap_8
XFILLER_169_664 VDD VDD VSS VSS gf180mcu_as_sc_mcu7t3v3__fillcap_4
XFILLER_184_601 VDD VDD VSS VSS gf180mcu_as_sc_mcu7t3v3__fill_2
XFILLER_62_65 VDD VDD VSS VSS gf180mcu_as_sc_mcu7t3v3__fill_2
XFILLER_8_814 VDD VDD VSS VSS gf180mcu_as_sc_mcu7t3v3__fill_1
XFILLER_169_697 VDD VDD VSS VSS gf180mcu_as_sc_mcu7t3v3__fill_2
XFILLER_178_98 VDD VDD VSS VSS gf180mcu_as_sc_mcu7t3v3__fillcap_4
XFILLER_19_1298 VDD VDD VSS VSS gf180mcu_as_sc_mcu7t3v3__fill_1
XTAP_TAPCELL_ROW_159_1274 VDD VSS gf180mcu_as_sc_mcu7t3v3__tap_2
XTAP_TAPCELL_ROW_159_1263 VDD VSS gf180mcu_as_sc_mcu7t3v3__tap_2
XPHY_EDGE_ROW_137_3_Right_178 VDD VSS gf180mcu_as_sc_mcu7t3v3__tap_2
XFILLER_172_807 VDD VDD VSS VSS gf180mcu_as_sc_mcu7t3v3__fillcap_8
XFILLER_152_586 VDD VDD VSS VSS gf180mcu_as_sc_mcu7t3v3__fill_1
XFILLER_187_1329 VDD VDD VSS VSS gf180mcu_as_sc_mcu7t3v3__fill_1
XTAP_TAPCELL_ROW_19_1_972 VDD VSS gf180mcu_as_sc_mcu7t3v3__tap_2
XPHY_EDGE_ROW_99_3_Right_140 VDD VSS gf180mcu_as_sc_mcu7t3v3__tap_2
X_2982_ VDD VDD VSS VSS _2982_/A _2993_/B _2993_/C _4394_/Q _4394_/D gf180mcu_as_sc_mcu7t3v3__ao22_2
XTAP_TAPCELL_ROW_34_3_1945 VDD VSS gf180mcu_as_sc_mcu7t3v3__tap_2
XTAP_TAPCELL_ROW_179_1639 VDD VSS gf180mcu_as_sc_mcu7t3v3__tap_2
XFILLER_72_1256 VDD VDD VSS VSS gf180mcu_as_sc_mcu7t3v3__fillcap_8
X_4721_ VDD VDD VSS VSS _4728_/CLK _4721_/D _4721_/Q gf180mcu_as_sc_mcu7t3v3__dfxtp_2
XFILLER_159_174 VDD VDD VSS VSS gf180mcu_as_sc_mcu7t3v3__fillcap_16
X_4652_ VDD VDD VSS VSS _4726_/CLK _4652_/D _4652_/Q gf180mcu_as_sc_mcu7t3v3__dfxtp_2
X_4738__1034 VDD VDD VSS VSS _4738_/D gf180mcu_as_sc_mcu7t3v3__tiel_4
XPHY_EDGE_ROW_17_1_Left_209 VDD VSS gf180mcu_as_sc_mcu7t3v3__tap_2
Xinput30 VDD VDD VSS VSS dft_addr[7] _2229_/A gf180mcu_as_sc_mcu7t3v3__buff_12
X_3603_ VDD VDD VSS VSS _4653_/D _3603_/C _3603_/B _3603_/A gf180mcu_as_sc_mcu7t3v3__aoi21b_2
XFILLER_162_317 VDD VDD VSS VSS gf180mcu_as_sc_mcu7t3v3__fillcap_4
XFILLER_174_177 VDD VDD VSS VSS gf180mcu_as_sc_mcu7t3v3__fillcap_4
X_4583_ VDD VDD VSS VSS _4828_/CLK _4583_/D _4583_/Q gf180mcu_as_sc_mcu7t3v3__dfxtp_2
Xinput41 VDD VDD VSS VSS dft_wdata[6] _2479_/B gf180mcu_as_sc_mcu7t3v3__buff_12
Xinput52 VDD VDD VSS VSS east_in[17] wire776/A gf180mcu_as_sc_mcu7t3v3__buff_12
Xinput63 VDD VDD VSS VSS east_in[27] _4224_/D gf180mcu_as_sc_mcu7t3v3__buff_12
XFILLER_7_880 VDD VDD VSS VSS gf180mcu_as_sc_mcu7t3v3__fill_1
Xinput74 VDD VDD VSS VSS east_in[4] wire773/A gf180mcu_as_sc_mcu7t3v3__buff_12
Xinput85 VDD VDD VSS VSS ne_in[14] _4120_/A gf180mcu_as_sc_mcu7t3v3__buff_12
Xinput96 VDD VDD VSS VSS ne_in[24] _4202_/A gf180mcu_as_sc_mcu7t3v3__buff_12
X_3534_ VDD VDD VSS VSS _3583_/A _3534_/B _4459_/Q _4612_/D gf180mcu_as_sc_mcu7t3v3__mux2_2
X_3465_ VDD VDD VSS VSS _3608_/D _3465_/A _3471_/D gf180mcu_as_sc_mcu7t3v3__and2_2
XFILLER_157_1188 VDD VDD VSS VSS gf180mcu_as_sc_mcu7t3v3__fill_2
XFILLER_192_1079 VDD VDD VSS VSS gf180mcu_as_sc_mcu7t3v3__fillcap_4
X_2416_ VDD VDD VSS VSS _2418_/B _2425_/B _4486_/Q gf180mcu_as_sc_mcu7t3v3__nand2_2
X_3396_ VDD VDD VSS VSS _3396_/A _3396_/B _3396_/C _3396_/D _4540_/D gf180mcu_as_sc_mcu7t3v3__ao211_2
X_2347_ VDD VDD VSS VSS _4651_/Q _4650_/Q _2348_/C gf180mcu_as_sc_mcu7t3v3__xnor2_2
XPHY_EDGE_ROW_131_1_Left_323 VDD VSS gf180mcu_as_sc_mcu7t3v3__tap_2
X_2278_ VDD VDD VSS VSS _3478_/B _4584_/Q _2382_/B gf180mcu_as_sc_mcu7t3v3__nor2b_2
X_4017_ VDD VDD VSS VSS _4018_/B _4017_/A _4136_/C _4017_/C gf180mcu_as_sc_mcu7t3v3__ao21_2
XFILLER_164_1159 VDD VDD VSS VSS gf180mcu_as_sc_mcu7t3v3__fill_1
Xsram2048.u_bank1_827 VDD VDD VSS VSS sram2048.u_bank1/WEN[6] gf180mcu_as_sc_mcu7t3v3__tiel_4
XFILLER_12_139 VDD VDD VSS VSS gf180mcu_as_sc_mcu7t3v3__fill_2
XFILLER_51_1307 VDD VDD VSS VSS gf180mcu_as_sc_mcu7t3v3__fillcap_4
XFILLER_165_111 VDD VDD VSS VSS gf180mcu_as_sc_mcu7t3v3__fillcap_16
XFILLER_154_807 VDD VDD VSS VSS gf180mcu_as_sc_mcu7t3v3__fillcap_4
XFILLER_166_667 VDD VDD VSS VSS gf180mcu_as_sc_mcu7t3v3__fillcap_16
XFILLER_32_68 VDD VDD VSS VSS gf180mcu_as_sc_mcu7t3v3__fillcap_4
XFILLER_32_79 VDD VDD VSS VSS gf180mcu_as_sc_mcu7t3v3__fillcap_16
XFILLER_5_839 VDD VDD VSS VSS gf180mcu_as_sc_mcu7t3v3__fill_1
XTAP_TAPCELL_ROW_138_3_2049 VDD VSS gf180mcu_as_sc_mcu7t3v3__tap_2
XFILLER_10_1037 VDD VDD VSS VSS gf180mcu_as_sc_mcu7t3v3__fill_1
XFILLER_181_659 VDD VDD VSS VSS gf180mcu_as_sc_mcu7t3v3__fill_2
XTAP_TAPCELL_ROW_154_1171 VDD VSS gf180mcu_as_sc_mcu7t3v3__tap_2
XFILLER_164_34 VDD VDD VSS VSS gf180mcu_as_sc_mcu7t3v3__fill_1
XFILLER_175_1255 VDD VDD VSS VSS gf180mcu_as_sc_mcu7t3v3__fillcap_4
XFILLER_180_169 VDD VDD VSS VSS gf180mcu_as_sc_mcu7t3v3__fillcap_4
XFILLER_164_45 VDD VDD VSS VSS gf180mcu_as_sc_mcu7t3v3__fillcap_4
XFILLER_171_1119 VDD VDD VSS VSS gf180mcu_as_sc_mcu7t3v3__fill_1
XPHY_EDGE_ROW_77_1_Right_586 VDD VSS gf180mcu_as_sc_mcu7t3v3__tap_2
XPHY_EDGE_ROW_63_1_Left_255 VDD VSS gf180mcu_as_sc_mcu7t3v3__tap_2
XFILLER_25_1291 VDD VDD VSS VSS gf180mcu_as_sc_mcu7t3v3__fillcap_4
XFILLER_5_1352 VDD VDD VSS VSS gf180mcu_as_sc_mcu7t3v3__fill_2
XPHY_EDGE_ROW_11_Left_204 VDD VSS gf180mcu_as_sc_mcu7t3v3__tap_2
XFILLER_108_1319 VDD VDD VSS VSS gf180mcu_as_sc_mcu7t3v3__fill_2
XFILLER_147_1346 VDD VDD VSS VSS gf180mcu_as_sc_mcu7t3v3__fill_1
XFILLER_188_247 VDD VDD VSS VSS gf180mcu_as_sc_mcu7t3v3__fillcap_16
XPHY_EDGE_ROW_146_3_Left_518 VDD VSS gf180mcu_as_sc_mcu7t3v3__tap_2
XPHY_EDGE_ROW_159_Left_351 VDD VSS gf180mcu_as_sc_mcu7t3v3__tap_2
XFILLER_11_183 VDD VDD VSS VSS gf180mcu_as_sc_mcu7t3v3__fill_2
XTAP_TAPCELL_ROW_174_1558 VDD VSS gf180mcu_as_sc_mcu7t3v3__tap_2
XTAP_TAPCELL_ROW_174_1547 VDD VSS gf180mcu_as_sc_mcu7t3v3__tap_2
XPHY_EDGE_ROW_138_3_Right_179 VDD VSS gf180mcu_as_sc_mcu7t3v3__tap_2
XFILLER_156_177 VDD VDD VSS VSS gf180mcu_as_sc_mcu7t3v3__fillcap_16
XTAP_TAPCELL_ROW_191_1883 VDD VSS gf180mcu_as_sc_mcu7t3v3__tap_2
XTAP_TAPCELL_ROW_191_1872 VDD VSS gf180mcu_as_sc_mcu7t3v3__tap_2
XTAP_TAPCELL_ROW_10_885 VDD VSS gf180mcu_as_sc_mcu7t3v3__tap_2
XTAP_TAPCELL_ROW_10_874 VDD VSS gf180mcu_as_sc_mcu7t3v3__tap_2
XFILLER_138_90 VDD VDD VSS VSS gf180mcu_as_sc_mcu7t3v3__fillcap_8
XFILLER_154_1339 VDD VDD VSS VSS gf180mcu_as_sc_mcu7t3v3__fillcap_8
XFILLER_98_72 VDD VDD VSS VSS gf180mcu_as_sc_mcu7t3v3__fill_2
X_3250_ VDD VDD VSS VSS _3306_/A _3250_/B _3250_/C _3252_/B _3250_/D gf180mcu_as_sc_mcu7t3v3__aoi31_2
XPHY_EDGE_ROW_168_Left_360 VDD VSS gf180mcu_as_sc_mcu7t3v3__tap_2
X_3181_ VDD VDD VSS VSS _3368_/S _4387_/Q _4416_/Q _3182_/B gf180mcu_as_sc_mcu7t3v3__mux2_2
X_2201_ VDD VDD VSS VSS _3513_/A _4292_/C gf180mcu_as_sc_mcu7t3v3__inv_2
XFILLER_152_1085 VDD VDD VSS VSS gf180mcu_as_sc_mcu7t3v3__fill_2
XFILLER_6_1149 VDD VDD VSS VSS gf180mcu_as_sc_mcu7t3v3__fill_2
XFILLER_179_247 VDD VDD VSS VSS gf180mcu_as_sc_mcu7t3v3__fillcap_16
XFILLER_167_409 VDD VDD VSS VSS gf180mcu_as_sc_mcu7t3v3__fillcap_8
XFILLER_163_1170 VDD VDD VSS VSS gf180mcu_as_sc_mcu7t3v3__fill_2
X_4704_ VDD VDD VSS VSS _4726_/CLK _4704_/D _4704_/Q gf180mcu_as_sc_mcu7t3v3__dfxtp_2
X_2965_ VDD VDD VSS VSS _4384_/Q _2965_/B _3032_/A _2965_/D _4384_/D gf180mcu_as_sc_mcu7t3v3__ao22_2
X_2896_ VDD VDD VSS VSS _4211_/A _2896_/B _2896_/C _2896_/D _2898_/C gf180mcu_as_sc_mcu7t3v3__ao211_2
XFILLER_50_1351 VDD VDD VSS VSS gf180mcu_as_sc_mcu7t3v3__fillcap_4
X_4635_ VDD VDD VSS VSS _4808_/CLK _4635_/D _4635_/Q gf180mcu_as_sc_mcu7t3v3__dfxtp_2
XFILLER_118_27 VDD VDD VSS VSS gf180mcu_as_sc_mcu7t3v3__fillcap_8
XFILLER_190_445 VDD VDD VSS VSS gf180mcu_as_sc_mcu7t3v3__fillcap_8
X_4566_ VDD VDD VSS VSS _4807_/CLK _4566_/D _4566_/Q gf180mcu_as_sc_mcu7t3v3__dfxtp_2
X_3517_ VDD VDD VSS VSS _3529_/S _4606_/Q _3517_/A _4606_/D gf180mcu_as_sc_mcu7t3v3__mux2_2
X_4497_ VDD VDD VSS VSS _4708_/CLK _4497_/D _4497_/Q gf180mcu_as_sc_mcu7t3v3__dfxtp_2
XFILLER_48_1291 VDD VDD VSS VSS gf180mcu_as_sc_mcu7t3v3__fillcap_8
X_3448_ VDD VDD VSS VSS _3448_/S _3448_/B _3448_/A _3449_/C gf180mcu_as_sc_mcu7t3v3__mux2_2
XFILLER_134_37 VDD VDD VSS VSS gf180mcu_as_sc_mcu7t3v3__fill_2
XFILLER_135_1272 VDD VDD VSS VSS gf180mcu_as_sc_mcu7t3v3__fillcap_16
XFILLER_170_1141 VDD VDD VSS VSS gf180mcu_as_sc_mcu7t3v3__fillcap_4
X_3379_ VDD VDD VSS VSS _4538_/Q _3395_/B _3403_/C _4539_/Q _3380_/C gf180mcu_as_sc_mcu7t3v3__ao22_2
XFILLER_150_69 VDD VDD VSS VSS gf180mcu_as_sc_mcu7t3v3__fillcap_16
XFILLER_168_6 VDD VDD VSS VSS gf180mcu_as_sc_mcu7t3v3__fillcap_16
XFILLER_13_448 VDD VDD VSS VSS gf180mcu_as_sc_mcu7t3v3__fill_2
XFILLER_185_206 VDD VDD VSS VSS gf180mcu_as_sc_mcu7t3v3__fillcap_4
XFILLER_185_228 VDD VDD VSS VSS gf180mcu_as_sc_mcu7t3v3__fillcap_8
XFILLER_166_453 VDD VDD VSS VSS gf180mcu_as_sc_mcu7t3v3__fill_2
XTAP_TAPCELL_ROW_156_1211 VDD VSS gf180mcu_as_sc_mcu7t3v3__tap_2
XFILLER_142_1276 VDD VDD VSS VSS gf180mcu_as_sc_mcu7t3v3__fill_1
XTAP_TAPCELL_ROW_152_1108 VDD VSS gf180mcu_as_sc_mcu7t3v3__tap_2
XFILLER_175_22 VDD VDD VSS VSS gf180mcu_as_sc_mcu7t3v3__fillcap_16
XFILLER_181_434 VDD VDD VSS VSS gf180mcu_as_sc_mcu7t3v3__fill_1
XFILLER_182_957 VDD VDD VSS VSS gf180mcu_as_sc_mcu7t3v3__fillcap_8
Xclkbuf_2_0_0_clk_regs VDD VDD VSS VSS clkbuf_0_clk_regs/Y clkbuf_2_0_0_clk_regs/Y
+ gf180mcu_as_sc_mcu7t3v3__clkbuff_12
XTAP_TAPCELL_ROW_152_1119 VDD VSS gf180mcu_as_sc_mcu7t3v3__tap_2
XFILLER_153_158 VDD VDD VSS VSS gf180mcu_as_sc_mcu7t3v3__fillcap_8
XFILLER_181_478 VDD VDD VSS VSS gf180mcu_as_sc_mcu7t3v3__fillcap_8
XFILLER_5_669 VDD VDD VSS VSS gf180mcu_as_sc_mcu7t3v3__fill_1
XTAP_TAPCELL_ROW_18_1_971 VDD VSS gf180mcu_as_sc_mcu7t3v3__tap_2
XFILLER_175_1052 VDD VDD VSS VSS gf180mcu_as_sc_mcu7t3v3__fillcap_8
XFILLER_1_842 VDD VDD VSS VSS gf180mcu_as_sc_mcu7t3v3__fillcap_16
XPHY_EDGE_ROW_78_1_Right_587 VDD VSS gf180mcu_as_sc_mcu7t3v3__tap_2
XFILLER_153_1350 VDD VDD VSS VSS gf180mcu_as_sc_mcu7t3v3__fill_1
Xinput220 VDD VDD VSS VSS se_in[5] _4049_/A gf180mcu_as_sc_mcu7t3v3__buff_12
Xinput231 VDD VDD VSS VSS south_in[15] _4124_/A gf180mcu_as_sc_mcu7t3v3__buff_12
Xinput242 VDD VDD VSS VSS south_in[25] _4207_/A gf180mcu_as_sc_mcu7t3v3__buff_12
Xinput253 VDD VDD VSS VSS south_in[35] _3964_/B gf180mcu_as_sc_mcu7t3v3__buff_12
Xinput264 VDD VDD VSS VSS sw_in[12] _2773_/A gf180mcu_as_sc_mcu7t3v3__buff_12
Xinput275 VDD VDD VSS VSS sw_in[22] _2222_/A gf180mcu_as_sc_mcu7t3v3__buff_12
Xinput286 VDD VDD VSS VSS sw_in[32] _3944_/A gf180mcu_as_sc_mcu7t3v3__buff_12
Xinput297 VDD VDD VSS VSS west_in[0] _3993_/B gf180mcu_as_sc_mcu7t3v3__buff_12
XFILLER_189_556 VDD VDD VSS VSS gf180mcu_as_sc_mcu7t3v3__fillcap_4
XFILLER_189_578 VDD VDD VSS VSS gf180mcu_as_sc_mcu7t3v3__fillcap_8
XFILLER_13_960 VDD VDD VSS VSS gf180mcu_as_sc_mcu7t3v3__fill_1
XFILLER_176_217 VDD VDD VSS VSS gf180mcu_as_sc_mcu7t3v3__fill_1
XFILLER_160_1354 VDD VDD VSS VSS gf180mcu_as_sc_mcu7t3v3__fill_1
XFILLER_185_740 VDD VDD VSS VSS gf180mcu_as_sc_mcu7t3v3__fill_1
X_2750_ VDD VDD VSS VSS _4078_/A _2822_/B _2750_/C _2750_/D _2751_/C gf180mcu_as_sc_mcu7t3v3__ao211_2
XFILLER_9_942 VDD VDD VSS VSS gf180mcu_as_sc_mcu7t3v3__fill_2
X_2681_ VDD VDD VSS VSS _4333_/Q _2772_/B _2979_/A _2772_/D _4333_/D gf180mcu_as_sc_mcu7t3v3__ao22_2
XFILLER_173_946 VDD VDD VSS VSS gf180mcu_as_sc_mcu7t3v3__fill_1
X_4420_ VDD VDD VSS VSS clkload9/A _4420_/D _4420_/Q gf180mcu_as_sc_mcu7t3v3__dfxtp_2
XTAP_TAPCELL_ROW_29_3_1940 VDD VSS gf180mcu_as_sc_mcu7t3v3__tap_2
XFILLER_173_979 VDD VDD VSS VSS gf180mcu_as_sc_mcu7t3v3__fill_1
XFILLER_158_1272 VDD VDD VSS VSS gf180mcu_as_sc_mcu7t3v3__fillcap_16
X_4351_ VDD VDD VSS VSS _4440_/CLK _4351_/D _4351_/Q gf180mcu_as_sc_mcu7t3v3__dfxtp_2
XFILLER_119_1256 VDD VDD VSS VSS gf180mcu_as_sc_mcu7t3v3__fillcap_8
XFILLER_152_180 VDD VDD VSS VSS gf180mcu_as_sc_mcu7t3v3__fill_2
XFILLER_158_1294 VDD VDD VSS VSS gf180mcu_as_sc_mcu7t3v3__fill_1
X_4282_ VDD VDD VSS VSS _4769_/Q _4287_/A _4285_/B _4286_/A gf180mcu_as_sc_mcu7t3v3__nand3_2
X_3302_ VDD VDD VSS VSS _3306_/B _4342_/Q _3304_/S gf180mcu_as_sc_mcu7t3v3__nand2b_2
X_3233_ VDD VDD VSS VSS _3234_/D _3233_/B _3306_/A gf180mcu_as_sc_mcu7t3v3__nor2_2
Xmesh_tile_835 VDD VDD VSS VSS ne_out[7] gf180mcu_as_sc_mcu7t3v3__tiel_4
Xmesh_tile_868 VDD VDD VSS VSS north_out[4] gf180mcu_as_sc_mcu7t3v3__tiel_4
Xmesh_tile_857 VDD VDD VSS VSS ne_out[29] gf180mcu_as_sc_mcu7t3v3__tiel_4
Xmesh_tile_846 VDD VDD VSS VSS ne_out[18] gf180mcu_as_sc_mcu7t3v3__tiel_4
X_3164_ VDD VDD VSS VSS _3540_/A _3373_/B _3164_/C _3412_/A _3165_/B gf180mcu_as_sc_mcu7t3v3__ao22_2
Xmesh_tile_879 VDD VDD VSS VSS north_out[15] gf180mcu_as_sc_mcu7t3v3__tiel_4
X_3095_ VDD VDD VSS VSS _3116_/S _4483_/Q _4482_/Q _4482_/D gf180mcu_as_sc_mcu7t3v3__mux2_2
XFILLER_165_1254 VDD VDD VSS VSS gf180mcu_as_sc_mcu7t3v3__fillcap_4
XFILLER_11_908 VDD VDD VSS VSS gf180mcu_as_sc_mcu7t3v3__fill_2
X_3997_ VDD VDD VSS VSS _3997_/B _4265_/D _4261_/A gf180mcu_as_sc_mcu7t3v3__and2_2
X_2948_ VDD VDD VSS VSS _3022_/A _2951_/D _2951_/B _4374_/Q _4374_/D gf180mcu_as_sc_mcu7t3v3__ao22_2
XFILLER_176_784 VDD VDD VSS VSS gf180mcu_as_sc_mcu7t3v3__fillcap_16
XFILLER_175_294 VDD VDD VSS VSS gf180mcu_as_sc_mcu7t3v3__fill_2
X_4618_ VDD VDD VSS VSS _4830_/CLK _4618_/D _4618_/Q gf180mcu_as_sc_mcu7t3v3__dfxtp_2
X_2879_ VDD VDD VSS VSS _2879_/B _4195_/A _2880_/D gf180mcu_as_sc_mcu7t3v3__or2_2
XFILLER_190_231 VDD VDD VSS VSS gf180mcu_as_sc_mcu7t3v3__fill_2
XFILLER_191_765 VDD VDD VSS VSS gf180mcu_as_sc_mcu7t3v3__fillcap_4
XFILLER_191_776 VDD VDD VSS VSS gf180mcu_as_sc_mcu7t3v3__fill_2
Xclkbuf_leaf_19_clk_regs VDD VDD VSS VSS clkbuf_3_6__f_clk_regs/Y _4830_/CLK gf180mcu_as_sc_mcu7t3v3__clkbuff_12
XFILLER_137_1323 VDD VDD VSS VSS gf180mcu_as_sc_mcu7t3v3__fill_1
XFILLER_145_36 VDD VDD VSS VSS gf180mcu_as_sc_mcu7t3v3__fillcap_16
X_4549_ VDD VDD VSS VSS _4720_/CLK _4549_/D _4549_/Q gf180mcu_as_sc_mcu7t3v3__dfxtp_2
XFILLER_145_58 VDD VDD VSS VSS gf180mcu_as_sc_mcu7t3v3__fill_1
XFILLER_172_1214 VDD VDD VSS VSS gf180mcu_as_sc_mcu7t3v3__fillcap_8
XFILLER_38_34 VDD VDD VSS VSS gf180mcu_as_sc_mcu7t3v3__fill_1
XFILLER_166_1029 VDD VDD VSS VSS gf180mcu_as_sc_mcu7t3v3__fillcap_16
XFILLER_183_1332 VDD VDD VSS VSS gf180mcu_as_sc_mcu7t3v3__fillcap_16
XFILLER_0_1090 VDD VDD VSS VSS gf180mcu_as_sc_mcu7t3v3__fill_2
XFILLER_13_212 VDD VDD VSS VSS gf180mcu_as_sc_mcu7t3v3__fillcap_16
XFILLER_183_1354 VDD VDD VSS VSS gf180mcu_as_sc_mcu7t3v3__fill_1
XFILLER_186_537 VDD VDD VSS VSS gf180mcu_as_sc_mcu7t3v3__fillcap_8
XFILLER_9_205 VDD VDD VSS VSS gf180mcu_as_sc_mcu7t3v3__fillcap_4
XTAP_TAPCELL_ROW_12_925 VDD VSS gf180mcu_as_sc_mcu7t3v3__tap_2
XTAP_TAPCELL_ROW_12_914 VDD VSS gf180mcu_as_sc_mcu7t3v3__tap_2
XFILLER_167_762 VDD VDD VSS VSS gf180mcu_as_sc_mcu7t3v3__fill_1
XFILLER_6_901 VDD VDD VSS VSS gf180mcu_as_sc_mcu7t3v3__fillcap_4
XFILLER_181_220 VDD VDD VSS VSS gf180mcu_as_sc_mcu7t3v3__fill_2
XFILLER_5_422 VDD VDD VSS VSS gf180mcu_as_sc_mcu7t3v3__fill_1
XFILLER_70_98 VDD VDD VSS VSS gf180mcu_as_sc_mcu7t3v3__fillcap_4
Xclkload19 VDD VDD VSS VSS clkload19/Y _4692_/CLK gf180mcu_as_sc_mcu7t3v3__inv_6
XFILLER_155_979 VDD VDD VSS VSS gf180mcu_as_sc_mcu7t3v3__fill_1
XFILLER_170_905 VDD VDD VSS VSS gf180mcu_as_sc_mcu7t3v3__fillcap_16
XFILLER_170_927 VDD VDD VSS VSS gf180mcu_as_sc_mcu7t3v3__fill_1
XFILLER_181_264 VDD VDD VSS VSS gf180mcu_as_sc_mcu7t3v3__fill_1
XFILLER_182_798 VDD VDD VSS VSS gf180mcu_as_sc_mcu7t3v3__fillcap_4
XTAP_TAPCELL_ROW_169_1457 VDD VSS gf180mcu_as_sc_mcu7t3v3__tap_2
XPHY_EDGE_ROW_79_1_Right_588 VDD VSS gf180mcu_as_sc_mcu7t3v3__tap_2
XFILLER_3_1119 VDD VDD VSS VSS gf180mcu_as_sc_mcu7t3v3__fill_1
XFILLER_7_1266 VDD VDD VSS VSS gf180mcu_as_sc_mcu7t3v3__fill_2
XTAP_TAPCELL_ROW_186_1782 VDD VSS gf180mcu_as_sc_mcu7t3v3__tap_2
XTAP_TAPCELL_ROW_186_1771 VDD VSS gf180mcu_as_sc_mcu7t3v3__tap_2
XPHY_EDGE_ROW_26_1_Left_218 VDD VSS gf180mcu_as_sc_mcu7t3v3__tap_2
X_3920_ VDD VDD VSS VSS _3920_/A _3930_/B _3920_/C _4254_/D _3921_/D gf180mcu_as_sc_mcu7t3v3__ao22_2
X_3851_ VDD VDD VSS VSS _3890_/S _4192_/A _3853_/C gf180mcu_as_sc_mcu7t3v3__or2_2
XFILLER_160_1140 VDD VDD VSS VSS gf180mcu_as_sc_mcu7t3v3__fill_2
X_3782_ VDD VDD VSS VSS _4127_/D _3921_/B _3782_/C _3782_/D _3783_/B gf180mcu_as_sc_mcu7t3v3__ao211_2
X_2802_ VDD VDD VSS VSS _2901_/B _4124_/D _2803_/D gf180mcu_as_sc_mcu7t3v3__and2_2
XFILLER_13_790 VDD VDD VSS VSS gf180mcu_as_sc_mcu7t3v3__fill_1
X_2733_ VDD VDD VSS VSS _2734_/C _2733_/C _2900_/B _4065_/A gf180mcu_as_sc_mcu7t3v3__aoi21_2
XPHY_EDGE_ROW_4_Left_197 VDD VSS gf180mcu_as_sc_mcu7t3v3__tap_2
XPHY_EDGE_ROW_140_1_Left_332 VDD VSS gf180mcu_as_sc_mcu7t3v3__tap_2
XFILLER_9_772 VDD VDD VSS VSS gf180mcu_as_sc_mcu7t3v3__fillcap_8
XFILLER_185_592 VDD VDD VSS VSS gf180mcu_as_sc_mcu7t3v3__fillcap_16
XFILLER_172_242 VDD VDD VSS VSS gf180mcu_as_sc_mcu7t3v3__fill_2
X_2664_ VDD VDD VSS VSS _4772_/Q _2810_/B _2901_/C _3992_/A _2667_/C gf180mcu_as_sc_mcu7t3v3__ao22_2
X_4403_ VDD VDD VSS VSS _4429_/CLK _4403_/D _4403_/Q gf180mcu_as_sc_mcu7t3v3__dfxtp_2
X_2595_ VDD VDD VSS VSS _2668_/A _2638_/D _2654_/A gf180mcu_as_sc_mcu7t3v3__nand2_2
XTAP_TAPCELL_ROW_76_1_1029 VDD VSS gf180mcu_as_sc_mcu7t3v3__tap_2
X_4334_ VDD VDD VSS VSS _4429_/CLK _4334_/D _4334_/Q gf180mcu_as_sc_mcu7t3v3__dfxtp_2
X_4265_ VDD VDD VSS VSS _4265_/A _4265_/B _4265_/C _4265_/D _4266_/D gf180mcu_as_sc_mcu7t3v3__ao22_2
XFILLER_189_1007 VDD VDD VSS VSS gf180mcu_as_sc_mcu7t3v3__fill_2
X_4196_ VDD VDD VSS VSS _4221_/S _4196_/B _4196_/A _4197_/B gf180mcu_as_sc_mcu7t3v3__mux2_2
X_3216_ VDD VDD VSS VSS _4518_/Q _3218_/B _3405_/B _3528_/A _3217_/A gf180mcu_as_sc_mcu7t3v3__ao22_2
X_3147_ VDD VDD VSS VSS _3148_/D _4502_/Q _4499_/Q gf180mcu_as_sc_mcu7t3v3__nor2_2
XFILLER_131_38 VDD VDD VSS VSS gf180mcu_as_sc_mcu7t3v3__fill_2
X_3078_ VDD VDD VSS VSS _3079_/S _3528_/A _4476_/Q _4476_/D gf180mcu_as_sc_mcu7t3v3__mux2_2
XPHY_EDGE_ROW_38_3_Right_79 VDD VSS gf180mcu_as_sc_mcu7t3v3__tap_2
XTAP_TAPCELL_ROW_17_1_970 VDD VSS gf180mcu_as_sc_mcu7t3v3__tap_2
XFILLER_11_727 VDD VDD VSS VSS gf180mcu_as_sc_mcu7t3v3__fillcap_8
XPHY_EDGE_ROW_72_1_Left_264 VDD VSS gf180mcu_as_sc_mcu7t3v3__tap_2
XFILLER_91_1281 VDD VDD VSS VSS gf180mcu_as_sc_mcu7t3v3__fill_2
XFILLER_155_209 VDD VDD VSS VSS gf180mcu_as_sc_mcu7t3v3__fill_1
XFILLER_152_905 VDD VDD VSS VSS gf180mcu_as_sc_mcu7t3v3__fillcap_8
XFILLER_191_540 VDD VDD VSS VSS gf180mcu_as_sc_mcu7t3v3__fillcap_16
XFILLER_191_562 VDD VDD VSS VSS gf180mcu_as_sc_mcu7t3v3__fillcap_16
XFILLER_160_982 VDD VDD VSS VSS gf180mcu_as_sc_mcu7t3v3__fillcap_16
XFILLER_49_88 VDD VDD VSS VSS gf180mcu_as_sc_mcu7t3v3__fillcap_16
Xfanout740 VDD VDD VSS VSS _3409_/A _3408_/A gf180mcu_as_sc_mcu7t3v3__buff_12
Xfanout751 VDD VDD VSS VSS _3351_/A _3368_/S gf180mcu_as_sc_mcu7t3v3__buff_12
XFILLER_150_1320 VDD VDD VSS VSS gf180mcu_as_sc_mcu7t3v3__fill_2
XFILLER_172_1099 VDD VDD VSS VSS gf180mcu_as_sc_mcu7t3v3__fillcap_16
Xfanout762 VDD VDD VSS VSS _4051_/A _4271_/A gf180mcu_as_sc_mcu7t3v3__buff_12
Xfanout784 VDD VDD VSS VSS _2397_/D _2424_/A gf180mcu_as_sc_mcu7t3v3__buff_12
XTAP_TAPCELL_ROW_6_797 VDD VSS gf180mcu_as_sc_mcu7t3v3__tap_2
XFILLER_105_83 VDD VDD VSS VSS gf180mcu_as_sc_mcu7t3v3__fillcap_4
XFILLER_111_1326 VDD VDD VSS VSS gf180mcu_as_sc_mcu7t3v3__fillcap_4
Xfanout795 VDD VDD VSS VSS _2408_/A _2388_/A gf180mcu_as_sc_mcu7t3v3__buff_12
XTAP_TAPCELL_ROW_164_1354 VDD VSS gf180mcu_as_sc_mcu7t3v3__tap_2
XFILLER_65_54 VDD VDD VSS VSS gf180mcu_as_sc_mcu7t3v3__fillcap_16
XFILLER_65_76 VDD VDD VSS VSS gf180mcu_as_sc_mcu7t3v3__fill_2
XTAP_TAPCELL_ROW_164_1365 VDD VSS gf180mcu_as_sc_mcu7t3v3__tap_2
XTAP_TAPCELL_ROW_181_1690 VDD VSS gf180mcu_as_sc_mcu7t3v3__tap_2
XFILLER_148_1260 VDD VDD VSS VSS gf180mcu_as_sc_mcu7t3v3__fill_2
XFILLER_159_559 VDD VDD VSS VSS gf180mcu_as_sc_mcu7t3v3__fill_1
XFILLER_186_334 VDD VDD VSS VSS gf180mcu_as_sc_mcu7t3v3__fillcap_4
XFILLER_10_782 VDD VDD VSS VSS gf180mcu_as_sc_mcu7t3v3__fill_1
XFILLER_6_753 VDD VDD VSS VSS gf180mcu_as_sc_mcu7t3v3__fillcap_16
XFILLER_155_1220 VDD VDD VSS VSS gf180mcu_as_sc_mcu7t3v3__fillcap_16
XTAP_TAPCELL_ROW_188_1811 VDD VSS gf180mcu_as_sc_mcu7t3v3__tap_2
XPHY_EDGE_ROW_87_3_Left_459 VDD VSS gf180mcu_as_sc_mcu7t3v3__tap_2
XFILLER_155_1242 VDD VDD VSS VSS gf180mcu_as_sc_mcu7t3v3__fill_1
XFILLER_29_1267 VDD VDD VSS VSS gf180mcu_as_sc_mcu7t3v3__fillcap_8
X_2380_ VDD VDD VSS VSS _2380_/B _3608_/D _2385_/A gf180mcu_as_sc_mcu7t3v3__or2_2
XTAP_TAPCELL_ROW_188_1822 VDD VSS gf180mcu_as_sc_mcu7t3v3__tap_2
X_4050_ VDD VDD VSS VSS _4221_/S _4050_/B _4050_/A _4051_/B gf180mcu_as_sc_mcu7t3v3__mux2_2
Xinput6 VDD VDD VSS VSS boot_addr[4] input6/Y gf180mcu_as_sc_mcu7t3v3__buff_12
X_3001_ VDD VDD VSS VSS _3001_/A _3006_/B _3006_/C _4413_/Q _4413_/D gf180mcu_as_sc_mcu7t3v3__ao22_2
XFILLER_188_1084 VDD VDD VSS VSS gf180mcu_as_sc_mcu7t3v3__fill_1
XFILLER_178_802 VDD VDD VSS VSS gf180mcu_as_sc_mcu7t3v3__fill_2
XFILLER_51_104 VDD VDD VSS VSS gf180mcu_as_sc_mcu7t3v3__fill_1
XFILLER_162_1224 VDD VDD VSS VSS gf180mcu_as_sc_mcu7t3v3__fill_1
XFILLER_178_835 VDD VDD VSS VSS gf180mcu_as_sc_mcu7t3v3__fill_1
X_3903_ VDD VDD VSS VSS _4236_/A _3929_/B _3903_/C _3903_/D _3904_/D gf180mcu_as_sc_mcu7t3v3__ao22_2
XTAP_TAPCELL_ROW_95_3_2006 VDD VSS gf180mcu_as_sc_mcu7t3v3__tap_2
XFILLER_75_1298 VDD VDD VSS VSS gf180mcu_as_sc_mcu7t3v3__fillcap_8
X_3834_ VDD VDD VSS VSS _3836_/C _4177_/A _3871_/C _3834_/C gf180mcu_as_sc_mcu7t3v3__ao21_2
XFILLER_162_1279 VDD VDD VSS VSS gf180mcu_as_sc_mcu7t3v3__fillcap_16
X_3765_ VDD VDD VSS VSS _4113_/A _3800_/B _3765_/C _3766_/C _3846_/D gf180mcu_as_sc_mcu7t3v3__aoi211_2
XFILLER_192_348 VDD VDD VSS VSS gf180mcu_as_sc_mcu7t3v3__fill_1
X_3696_ VDD VDD VSS VSS _4055_/D _3795_/B _3696_/C _3795_/D _3699_/B gf180mcu_as_sc_mcu7t3v3__ao211_2
X_2716_ VDD VDD VSS VSS _4050_/A _2905_/B _2716_/C _2716_/D _2983_/A gf180mcu_as_sc_mcu7t3v3__ao22_2
XFILLER_161_702 VDD VDD VSS VSS gf180mcu_as_sc_mcu7t3v3__fillcap_16
XFILLER_173_562 VDD VDD VSS VSS gf180mcu_as_sc_mcu7t3v3__fillcap_4
X_2647_ VDD VDD VSS VSS _2658_/C _4003_/A _4269_/B gf180mcu_as_sc_mcu7t3v3__nand2_2
XFILLER_156_1017 VDD VDD VSS VSS gf180mcu_as_sc_mcu7t3v3__fill_2
XFILLER_47_1323 VDD VDD VSS VSS gf180mcu_as_sc_mcu7t3v3__fill_1
Xoutput343 VDD VDD VSS VSS _4704_/Q east_out[11] gf180mcu_as_sc_mcu7t3v3__buff_12
XFILLER_0_929 VDD VDD VSS VSS gf180mcu_as_sc_mcu7t3v3__fill_2
XFILLER_173_1342 VDD VDD VSS VSS gf180mcu_as_sc_mcu7t3v3__fillcap_8
Xoutput387 VDD VDD VSS VSS _4676_/Q south_out[19] gf180mcu_as_sc_mcu7t3v3__buff_12
Xoutput376 VDD VDD VSS VSS _4702_/Q east_out[9] gf180mcu_as_sc_mcu7t3v3__buff_12
Xoutput365 VDD VDD VSS VSS _4724_/Q east_out[31] gf180mcu_as_sc_mcu7t3v3__buff_12
Xoutput354 VDD VDD VSS VSS _4714_/Q east_out[21] gf180mcu_as_sc_mcu7t3v3__buff_12
X_2578_ VDD VDD VSS VSS _5074_/A _3585_/A _2586_/B gf180mcu_as_sc_mcu7t3v3__and2_2
Xoutput398 VDD VDD VSS VSS _4686_/Q south_out[29] gf180mcu_as_sc_mcu7t3v3__buff_12
X_4317_ VDD VDD VSS VSS _4804_/D _4541_/Q _4794_/D gf180mcu_as_sc_mcu7t3v3__and2_2
X_4248_ VDD VDD VSS VSS _4248_/A _4265_/B _4248_/C _4251_/B _4248_/D gf180mcu_as_sc_mcu7t3v3__aoi211_2
XFILLER_142_26 VDD VDD VSS VSS gf180mcu_as_sc_mcu7t3v3__fill_2
XFILLER_142_48 VDD VDD VSS VSS gf180mcu_as_sc_mcu7t3v3__fillcap_16
XFILLER_19_58 VDD VDD VSS VSS gf180mcu_as_sc_mcu7t3v3__fill_1
XTAP_TAPCELL_ROW_3_745 VDD VSS gf180mcu_as_sc_mcu7t3v3__tap_2
X_4179_ VDD VDD VSS VSS _4187_/B _4179_/B _4179_/A _4180_/C gf180mcu_as_sc_mcu7t3v3__mux2_2
XTAP_TAPCELL_ROW_3_756 VDD VSS gf180mcu_as_sc_mcu7t3v3__tap_2
XFILLER_167_1146 VDD VDD VSS VSS gf180mcu_as_sc_mcu7t3v3__fillcap_4
XFILLER_167_1179 VDD VDD VSS VSS gf180mcu_as_sc_mcu7t3v3__fillcap_8
XFILLER_42_104 VDD VDD VSS VSS gf180mcu_as_sc_mcu7t3v3__fill_1
XTAP_TAPCELL_ROW_52_3_1963 VDD VSS gf180mcu_as_sc_mcu7t3v3__tap_2
XFILLER_150_6 VDD VDD VSS VSS gf180mcu_as_sc_mcu7t3v3__fillcap_16
XFILLER_169_879 VDD VDD VSS VSS gf180mcu_as_sc_mcu7t3v3__fillcap_16
Xclkbuf_leaf_34_clk_regs VDD VDD VSS VSS clkbuf_leaf_1_clk_regs/A clkload4/A gf180mcu_as_sc_mcu7t3v3__clkbuff_12
XFILLER_11_579 VDD VDD VSS VSS gf180mcu_as_sc_mcu7t3v3__fill_1
XFILLER_13_1035 VDD VDD VSS VSS gf180mcu_as_sc_mcu7t3v3__fillcap_4
Xwire448 VDD VDD VSS VSS _4188_/Y _4715_/D gf180mcu_as_sc_mcu7t3v3__clkbuff_12
XFILLER_183_348 VDD VDD VSS VSS gf180mcu_as_sc_mcu7t3v3__fill_2
XFILLER_178_1275 VDD VDD VSS VSS gf180mcu_as_sc_mcu7t3v3__fillcap_8
XFILLER_152_757 VDD VDD VSS VSS gf180mcu_as_sc_mcu7t3v3__fillcap_4
XFILLER_178_1297 VDD VDD VSS VSS gf180mcu_as_sc_mcu7t3v3__fillcap_16
XFILLER_183_66 VDD VDD VSS VSS gf180mcu_as_sc_mcu7t3v3__fillcap_4
XFILLER_4_2 VDD VDD VSS VSS gf180mcu_as_sc_mcu7t3v3__fillcap_8
XFILLER_183_88 VDD VDD VSS VSS gf180mcu_as_sc_mcu7t3v3__fillcap_8
XTAP_TAPCELL_ROW_166_1405 VDD VSS gf180mcu_as_sc_mcu7t3v3__tap_2
Xfanout570 VDD VDD VSS VSS _3347_/B _3315_/B gf180mcu_as_sc_mcu7t3v3__buff_12
Xfanout581 VDD VDD VSS VSS _2659_/Y _2891_/B gf180mcu_as_sc_mcu7t3v3__buff_12
Xfanout592 VDD VDD VSS VSS _4118_/B fanout592/Y gf180mcu_as_sc_mcu7t3v3__buff_12
XTAP_TAPCELL_ROW_183_1730 VDD VSS gf180mcu_as_sc_mcu7t3v3__tap_2
XFILLER_33_104 VDD VDD VSS VSS gf180mcu_as_sc_mcu7t3v3__fill_1
XFILLER_187_621 VDD VDD VSS VSS gf180mcu_as_sc_mcu7t3v3__fill_2
XFILLER_187_632 VDD VDD VSS VSS gf180mcu_as_sc_mcu7t3v3__fillcap_16
XFILLER_159_378 VDD VDD VSS VSS gf180mcu_as_sc_mcu7t3v3__fill_1
XFILLER_187_687 VDD VDD VSS VSS gf180mcu_as_sc_mcu7t3v3__fill_2
XFILLER_175_838 VDD VDD VSS VSS gf180mcu_as_sc_mcu7t3v3__fill_2
X_3550_ VDD VDD VSS VSS _4618_/D _4463_/Q _3553_/B _3550_/C gf180mcu_as_sc_mcu7t3v3__ao21_2
XFILLER_170_510 VDD VDD VSS VSS gf180mcu_as_sc_mcu7t3v3__fillcap_8
X_2501_ VDD VDD VSS VSS _4806_/Q _2501_/B _2501_/A _5076_/A gf180mcu_as_sc_mcu7t3v3__mux2_2
XFILLER_157_1348 VDD VDD VSS VSS gf180mcu_as_sc_mcu7t3v3__fill_2
XFILLER_170_543 VDD VDD VSS VSS gf180mcu_as_sc_mcu7t3v3__fillcap_8
X_3481_ VDD VDD VSS VSS _4593_/D _3481_/C _3481_/B _3481_/A gf180mcu_as_sc_mcu7t3v3__aoi21b_2
XFILLER_192_1239 VDD VDD VSS VSS gf180mcu_as_sc_mcu7t3v3__fillcap_4
X_2432_ VDD VDD VSS VSS _4535_/Q _3070_/S _3049_/B _4511_/Q _2433_/B gf180mcu_as_sc_mcu7t3v3__ao22_2
XFILLER_155_1072 VDD VDD VSS VSS gf180mcu_as_sc_mcu7t3v3__fill_1
X_2363_ VDD VDD VSS VSS _2363_/D _2363_/A _2481_/A _3611_/A _2372_/B gf180mcu_as_sc_mcu7t3v3__ao31_2
XFILLER_9_1114 VDD VDD VSS VSS gf180mcu_as_sc_mcu7t3v3__fillcap_4
XFILLER_155_1094 VDD VDD VSS VSS gf180mcu_as_sc_mcu7t3v3__fill_1
X_4102_ VDD VDD VSS VSS _4102_/A _4225_/B _4217_/C _4102_/D _4103_/B gf180mcu_as_sc_mcu7t3v3__ao22_2
X_4033_ VDD VDD VSS VSS _4034_/B _4033_/A _4136_/C _4033_/C gf180mcu_as_sc_mcu7t3v3__ao21_2
X_2294_ VDD VDD VSS VSS _2295_/C _3573_/D _3573_/B _2552_/A gf180mcu_as_sc_mcu7t3v3__aoi21_2
XANTENNA_11 VDD VDD VSS VSS _4713_/D gf180mcu_as_sc_mcu7t3v3__diode_2
XANTENNA_22 VDD VDD VSS VSS _4027_/B gf180mcu_as_sc_mcu7t3v3__diode_2
XFILLER_162_1065 VDD VDD VSS VSS gf180mcu_as_sc_mcu7t3v3__fillcap_8
XFILLER_177_142 VDD VDD VSS VSS gf180mcu_as_sc_mcu7t3v3__fillcap_4
XANTENNA_33 VDD VDD VSS VSS _4075_/B gf180mcu_as_sc_mcu7t3v3__diode_2
XANTENNA_44 VDD VDD VSS VSS _4246_/A gf180mcu_as_sc_mcu7t3v3__diode_2
XANTENNA_55 VDD VDD VSS VSS _4137_/A gf180mcu_as_sc_mcu7t3v3__diode_2
XANTENNA_66 VDD VDD VSS VSS _3965_/C gf180mcu_as_sc_mcu7t3v3__diode_2
XFILLER_162_1098 VDD VDD VSS VSS gf180mcu_as_sc_mcu7t3v3__fillcap_16
XFILLER_166_838 VDD VDD VSS VSS gf180mcu_as_sc_mcu7t3v3__fill_1
X_4797_ VDD VDD VSS VSS _4804_/CLK _4797_/D _4797_/Q gf180mcu_as_sc_mcu7t3v3__dfxtp_2
X_3817_ VDD VDD VSS VSS _4791_/Q _3869_/B _3871_/B _4161_/A _3818_/D gf180mcu_as_sc_mcu7t3v3__ao22_2
XFILLER_101_1303 VDD VDD VSS VSS gf180mcu_as_sc_mcu7t3v3__fillcap_16
X_3748_ VDD VDD VSS VSS _3748_/B _3748_/A _4668_/D gf180mcu_as_sc_mcu7t3v3__and2_2
XFILLER_174_893 VDD VDD VSS VSS gf180mcu_as_sc_mcu7t3v3__fillcap_16
XFILLER_192_178 VDD VDD VSS VSS gf180mcu_as_sc_mcu7t3v3__fill_1
XFILLER_108_8 VDD VDD VSS VSS gf180mcu_as_sc_mcu7t3v3__fill_1
X_3679_ VDD VDD VSS VSS _3859_/B _4036_/A _3681_/C gf180mcu_as_sc_mcu7t3v3__or2_2
XTAP_TAPCELL_ROW_8_837 VDD VSS gf180mcu_as_sc_mcu7t3v3__tap_2
XTAP_TAPCELL_ROW_8_848 VDD VSS gf180mcu_as_sc_mcu7t3v3__tap_2
XFILLER_169_1208 VDD VDD VSS VSS gf180mcu_as_sc_mcu7t3v3__fillcap_4
XTAP_TAPCELL_ROW_161_1302 VDD VSS gf180mcu_as_sc_mcu7t3v3__tap_2
XTAP_TAPCELL_ROW_161_1313 VDD VSS gf180mcu_as_sc_mcu7t3v3__tap_2
XFILLER_15_104 VDD VDD VSS VSS gf180mcu_as_sc_mcu7t3v3__fill_1
XFILLER_102_84 VDD VDD VSS VSS gf180mcu_as_sc_mcu7t3v3__fill_1
XFILLER_178_22 VDD VDD VSS VSS gf180mcu_as_sc_mcu7t3v3__fillcap_8
XFILLER_62_33 VDD VDD VSS VSS gf180mcu_as_sc_mcu7t3v3__fill_2
XFILLER_145_1274 VDD VDD VSS VSS gf180mcu_as_sc_mcu7t3v3__fillcap_16
XFILLER_168_142 VDD VDD VSS VSS gf180mcu_as_sc_mcu7t3v3__fillcap_4
XFILLER_180_1143 VDD VDD VSS VSS gf180mcu_as_sc_mcu7t3v3__fill_2
XFILLER_8_804 VDD VDD VSS VSS gf180mcu_as_sc_mcu7t3v3__fill_1
XFILLER_12_877 VDD VDD VSS VSS gf180mcu_as_sc_mcu7t3v3__fillcap_16
XTAP_TAPCELL_ROW_159_1275 VDD VSS gf180mcu_as_sc_mcu7t3v3__tap_2
XTAP_TAPCELL_ROW_159_1264 VDD VSS gf180mcu_as_sc_mcu7t3v3__tap_2
XFILLER_8_826 VDD VDD VSS VSS gf180mcu_as_sc_mcu7t3v3__fillcap_4
XFILLER_8_848 VDD VDD VSS VSS gf180mcu_as_sc_mcu7t3v3__fill_1
XFILLER_165_893 VDD VDD VSS VSS gf180mcu_as_sc_mcu7t3v3__fillcap_4
XPHY_EDGE_ROW_35_1_Left_227 VDD VSS gf180mcu_as_sc_mcu7t3v3__tap_2
XFILLER_152_1201 VDD VDD VSS VSS gf180mcu_as_sc_mcu7t3v3__fillcap_8
XFILLER_65_1264 VDD VDD VSS VSS gf180mcu_as_sc_mcu7t3v3__fillcap_4
XFILLER_152_1223 VDD VDD VSS VSS gf180mcu_as_sc_mcu7t3v3__fill_1
XFILLER_152_1234 VDD VDD VSS VSS gf180mcu_as_sc_mcu7t3v3__fill_1
XFILLER_191_1294 VDD VDD VSS VSS gf180mcu_as_sc_mcu7t3v3__fillcap_16
XFILLER_152_1256 VDD VDD VSS VSS gf180mcu_as_sc_mcu7t3v3__fill_2
XFILLER_143_80 VDD VDD VSS VSS gf180mcu_as_sc_mcu7t3v3__fill_2
XFILLER_4_1033 VDD VDD VSS VSS gf180mcu_as_sc_mcu7t3v3__fill_2
XFILLER_185_1021 VDD VDD VSS VSS gf180mcu_as_sc_mcu7t3v3__fillcap_16
XFILLER_179_418 VDD VDD VSS VSS gf180mcu_as_sc_mcu7t3v3__fill_2
XFILLER_185_1087 VDD VDD VSS VSS gf180mcu_as_sc_mcu7t3v3__fillcap_16
X_2981_ VDD VDD VSS VSS _2981_/A _2993_/B _2989_/C _4393_/Q _4393_/D gf180mcu_as_sc_mcu7t3v3__ao22_2
XFILLER_159_120 VDD VDD VSS VSS gf180mcu_as_sc_mcu7t3v3__fillcap_16
XFILLER_159_142 VDD VDD VSS VSS gf180mcu_as_sc_mcu7t3v3__fillcap_16
X_4720_ VDD VDD VSS VSS _4720_/CLK _4720_/D _4720_/Q gf180mcu_as_sc_mcu7t3v3__dfxtp_2
X_4651_ VDD VDD VSS VSS _4726_/CLK _4651_/D _4651_/Q gf180mcu_as_sc_mcu7t3v3__dfxtp_2
XFILLER_174_145 VDD VDD VSS VSS gf180mcu_as_sc_mcu7t3v3__fillcap_16
Xinput20 VDD VDD VSS VSS boot_mode input20/Y gf180mcu_as_sc_mcu7t3v3__buff_12
Xinput31 VDD VDD VSS VSS dft_addr[8] _2424_/B gf180mcu_as_sc_mcu7t3v3__buff_12
X_3602_ VDD VDD VSS VSS _4451_/Q _3602_/B _3602_/C _3602_/D _3603_/B gf180mcu_as_sc_mcu7t3v3__ao211_2
X_4582_ VDD VDD VSS VSS _4831_/CLK _4582_/D _4582_/Q gf180mcu_as_sc_mcu7t3v3__dfxtp_2
Xinput42 VDD VDD VSS VSS dft_wdata[7] _2494_/B gf180mcu_as_sc_mcu7t3v3__buff_12
Xinput53 VDD VDD VSS VSS east_in[18] wire775/A gf180mcu_as_sc_mcu7t3v3__buff_12
Xinput64 VDD VDD VSS VSS east_in[28] _4234_/A gf180mcu_as_sc_mcu7t3v3__buff_12
XFILLER_156_893 VDD VDD VSS VSS gf180mcu_as_sc_mcu7t3v3__fill_2
Xinput75 VDD VDD VSS VSS east_in[5] _4044_/D gf180mcu_as_sc_mcu7t3v3__buff_12
Xinput86 VDD VDD VSS VSS ne_in[15] wire768/A gf180mcu_as_sc_mcu7t3v3__buff_12
Xinput97 VDD VDD VSS VSS ne_in[25] _4210_/A gf180mcu_as_sc_mcu7t3v3__buff_12
Xwire790 VDD VDD VSS VSS wire790/A _4220_/A gf180mcu_as_sc_mcu7t3v3__clkbuff_12
X_3533_ VDD VDD VSS VSS _3539_/S _4612_/Q _4613_/Q _3534_/B gf180mcu_as_sc_mcu7t3v3__mux2_2
XTAP_TAPCELL_ROW_104_3_2015 VDD VSS gf180mcu_as_sc_mcu7t3v3__tap_2
X_3464_ VDD VDD VSS VSS _3600_/A _3528_/A _4587_/Q _4587_/D gf180mcu_as_sc_mcu7t3v3__mux2_2
XPHY_EDGE_ROW_47_3_Right_88 VDD VSS gf180mcu_as_sc_mcu7t3v3__tap_2
XFILLER_153_1009 VDD VDD VSS VSS gf180mcu_as_sc_mcu7t3v3__fillcap_8
XFILLER_170_384 VDD VDD VSS VSS gf180mcu_as_sc_mcu7t3v3__fill_1
XFILLER_44_1304 VDD VDD VSS VSS gf180mcu_as_sc_mcu7t3v3__fill_1
X_2415_ VDD VDD VSS VSS _2494_/A _2415_/B _2415_/C _2415_/D _2415_/Y gf180mcu_as_sc_mcu7t3v3__ao22_2
X_3395_ VDD VDD VSS VSS _4540_/Q _3395_/B _3403_/C _4541_/Q _3396_/C gf180mcu_as_sc_mcu7t3v3__ao22_2
XPHY_EDGE_ROW_20_3_Left_392 VDD VSS gf180mcu_as_sc_mcu7t3v3__tap_2
X_2346_ VDD VDD VSS VSS _2353_/B _4651_/Q _4650_/Q gf180mcu_as_sc_mcu7t3v3__nor2_2
X_2277_ VDD VDD VSS VSS _3572_/B _2563_/D _3530_/C _2382_/B gf180mcu_as_sc_mcu7t3v3__nor3_2
XPHY_EDGE_ROW_81_1_Left_273 VDD VSS gf180mcu_as_sc_mcu7t3v3__tap_2
X_4016_ VDD VDD VSS VSS _4016_/A _4136_/B _4016_/C _4016_/D _4017_/C gf180mcu_as_sc_mcu7t3v3__ao211_2
XFILLER_12_107 VDD VDD VSS VSS gf180mcu_as_sc_mcu7t3v3__fillcap_16
Xsram2048.u_bank1_828 VDD VDD VSS VSS sram2048.u_bank1/WEN[7] gf180mcu_as_sc_mcu7t3v3__tiel_4
XFILLER_166_613 VDD VDD VSS VSS gf180mcu_as_sc_mcu7t3v3__fillcap_8
XFILLER_166_657 VDD VDD VSS VSS gf180mcu_as_sc_mcu7t3v3__fill_1
XFILLER_180_104 VDD VDD VSS VSS gf180mcu_as_sc_mcu7t3v3__fill_1
XFILLER_162_830 VDD VDD VSS VSS gf180mcu_as_sc_mcu7t3v3__fillcap_16
XFILLER_180_137 VDD VDD VSS VSS gf180mcu_as_sc_mcu7t3v3__fillcap_16
XTAP_TAPCELL_ROW_154_1172 VDD VSS gf180mcu_as_sc_mcu7t3v3__tap_2
XFILLER_180_34 VDD VDD VSS VSS gf180mcu_as_sc_mcu7t3v3__fill_1
XFILLER_189_2 VDD VDD VSS VSS gf180mcu_as_sc_mcu7t3v3__fillcap_16
XFILLER_57_88 VDD VDD VSS VSS gf180mcu_as_sc_mcu7t3v3__fillcap_16
XFILLER_113_72 VDD VDD VSS VSS gf180mcu_as_sc_mcu7t3v3__fillcap_8
XFILLER_182_1227 VDD VDD VSS VSS gf180mcu_as_sc_mcu7t3v3__fillcap_16
XFILLER_12_630 VDD VDD VSS VSS gf180mcu_as_sc_mcu7t3v3__fill_2
XPHY_EDGE_ROW_96_3_Left_468 VDD VSS gf180mcu_as_sc_mcu7t3v3__tap_2
XFILLER_169_462 VDD VDD VSS VSS gf180mcu_as_sc_mcu7t3v3__fillcap_8
XFILLER_185_922 VDD VDD VSS VSS gf180mcu_as_sc_mcu7t3v3__fill_1
XFILLER_156_123 VDD VDD VSS VSS gf180mcu_as_sc_mcu7t3v3__fillcap_4
XTAP_TAPCELL_ROW_174_1548 VDD VSS gf180mcu_as_sc_mcu7t3v3__tap_2
XFILLER_8_667 VDD VDD VSS VSS gf180mcu_as_sc_mcu7t3v3__fill_1
XTAP_TAPCELL_ROW_174_1559 VDD VSS gf180mcu_as_sc_mcu7t3v3__tap_2
XTAP_TAPCELL_ROW_191_1884 VDD VSS gf180mcu_as_sc_mcu7t3v3__tap_2
XTAP_TAPCELL_ROW_191_1873 VDD VSS gf180mcu_as_sc_mcu7t3v3__tap_2
XTAP_TAPCELL_ROW_10_886 VDD VSS gf180mcu_as_sc_mcu7t3v3__tap_2
XTAP_TAPCELL_ROW_10_875 VDD VSS gf180mcu_as_sc_mcu7t3v3__tap_2
XFILLER_67_1326 VDD VDD VSS VSS gf180mcu_as_sc_mcu7t3v3__fillcap_4
XFILLER_152_384 VDD VDD VSS VSS gf180mcu_as_sc_mcu7t3v3__fillcap_4
X_2200_ VDD VDD VSS VSS _3585_/A _4831_/Q gf180mcu_as_sc_mcu7t3v3__inv_2
XFILLER_152_1053 VDD VDD VSS VSS gf180mcu_as_sc_mcu7t3v3__fill_1
XFILLER_191_1080 VDD VDD VSS VSS gf180mcu_as_sc_mcu7t3v3__fill_2
XFILLER_6_1106 VDD VDD VSS VSS gf180mcu_as_sc_mcu7t3v3__fill_1
X_3180_ VDD VDD VSS VSS _3191_/A _3180_/B _3180_/C _3574_/D _3188_/C gf180mcu_as_sc_mcu7t3v3__ao211_2
XPHY_EDGE_ROW_179_Right_41 VDD VSS gf180mcu_as_sc_mcu7t3v3__tap_2
X_2964_ VDD VDD VSS VSS _3001_/A _2966_/A _3032_/A gf180mcu_as_sc_mcu7t3v3__and2_2
XFILLER_128_1291 VDD VDD VSS VSS gf180mcu_as_sc_mcu7t3v3__fill_2
X_4703_ VDD VDD VSS VSS _4726_/CLK _4703_/D _4703_/Q gf180mcu_as_sc_mcu7t3v3__dfxtp_2
X_2895_ VDD VDD VSS VSS _4206_/A _2895_/B _2895_/C _2895_/D _2896_/C gf180mcu_as_sc_mcu7t3v3__ao211_2
XFILLER_175_454 VDD VDD VSS VSS gf180mcu_as_sc_mcu7t3v3__fillcap_8
XFILLER_175_476 VDD VDD VSS VSS gf180mcu_as_sc_mcu7t3v3__fillcap_4
XFILLER_8_71 VDD VDD VSS VSS gf180mcu_as_sc_mcu7t3v3__fillcap_8
X_4634_ VDD VDD VSS VSS _4808_/CLK _4634_/D _4634_/Q gf180mcu_as_sc_mcu7t3v3__dfxtp_2
X_4565_ VDD VDD VSS VSS _4807_/CLK _4565_/D _4565_/Q gf180mcu_as_sc_mcu7t3v3__dfxtp_2
XPHY_EDGE_ROW_188_Right_50 VDD VSS gf180mcu_as_sc_mcu7t3v3__tap_2
XFILLER_190_457 VDD VDD VSS VSS gf180mcu_as_sc_mcu7t3v3__fillcap_16
X_3516_ VDD VDD VSS VSS _3520_/S _3516_/B _4607_/Q _3517_/A gf180mcu_as_sc_mcu7t3v3__mux2_2
X_4496_ VDD VDD VSS VSS _4727_/CLK _4496_/D _4496_/Q gf180mcu_as_sc_mcu7t3v3__dfxtp_2
XPHY_EDGE_ROW_4_Right_4 VDD VSS gf180mcu_as_sc_mcu7t3v3__tap_2
XFILLER_170_181 VDD VDD VSS VSS gf180mcu_as_sc_mcu7t3v3__fill_2
X_3447_ VDD VDD VSS VSS _3448_/A _3447_/B _3447_/A gf180mcu_as_sc_mcu7t3v3__nor2_2
XFILLER_134_27 VDD VDD VSS VSS gf180mcu_as_sc_mcu7t3v3__fillcap_8
XFILLER_134_49 VDD VDD VSS VSS gf180mcu_as_sc_mcu7t3v3__fillcap_16
X_3378_ VDD VDD VSS VSS _3408_/A _3378_/B _3378_/C _3380_/B _3378_/D gf180mcu_as_sc_mcu7t3v3__aoi31_2
X_2329_ VDD VDD VSS VSS _2461_/C _2329_/B _2329_/C _2329_/D _4329_/B gf180mcu_as_sc_mcu7t3v3__ao22_2
XFILLER_150_37 VDD VDD VSS VSS gf180mcu_as_sc_mcu7t3v3__fillcap_16
XFILLER_27_69 VDD VDD VSS VSS gf180mcu_as_sc_mcu7t3v3__fill_1
XFILLER_13_416 VDD VDD VSS VSS gf180mcu_as_sc_mcu7t3v3__fill_1
XFILLER_168_1082 VDD VDD VSS VSS gf180mcu_as_sc_mcu7t3v3__fill_2
XFILLER_159_46 VDD VDD VSS VSS gf180mcu_as_sc_mcu7t3v3__fill_1
XFILLER_166_410 VDD VDD VSS VSS gf180mcu_as_sc_mcu7t3v3__fillcap_4
XTAP_TAPCELL_ROW_156_1201 VDD VSS gf180mcu_as_sc_mcu7t3v3__tap_2
XTAP_TAPCELL_ROW_156_1212 VDD VSS gf180mcu_as_sc_mcu7t3v3__tap_2
XFILLER_154_605 VDD VDD VSS VSS gf180mcu_as_sc_mcu7t3v3__fillcap_4
XFILLER_153_137 VDD VDD VSS VSS gf180mcu_as_sc_mcu7t3v3__fill_2
XFILLER_177_1329 VDD VDD VSS VSS gf180mcu_as_sc_mcu7t3v3__fill_1
XTAP_TAPCELL_ROW_94_1_1047 VDD VSS gf180mcu_as_sc_mcu7t3v3__tap_2
XTAP_TAPCELL_ROW_152_1109 VDD VSS gf180mcu_as_sc_mcu7t3v3__tap_2
XFILLER_175_1064 VDD VDD VSS VSS gf180mcu_as_sc_mcu7t3v3__fill_2
XFILLER_108_83 VDD VDD VSS VSS gf180mcu_as_sc_mcu7t3v3__fill_2
Xinput210 VDD VDD VSS VSS se_in[29] _3912_/A gf180mcu_as_sc_mcu7t3v3__buff_12
XFILLER_191_66 VDD VDD VSS VSS gf180mcu_as_sc_mcu7t3v3__fillcap_4
XFILLER_191_88 VDD VDD VSS VSS gf180mcu_as_sc_mcu7t3v3__fill_2
XFILLER_62_1256 VDD VDD VSS VSS gf180mcu_as_sc_mcu7t3v3__fillcap_16
Xinput221 VDD VDD VSS VSS se_in[6] _4057_/A gf180mcu_as_sc_mcu7t3v3__buff_12
Xinput232 VDD VDD VSS VSS south_in[16] _4132_/A gf180mcu_as_sc_mcu7t3v3__buff_12
Xinput243 VDD VDD VSS VSS south_in[26] _4214_/A gf180mcu_as_sc_mcu7t3v3__buff_12
Xinput254 VDD VDD VSS VSS south_in[3] _4028_/A gf180mcu_as_sc_mcu7t3v3__buff_12
Xinput265 VDD VDD VSS VSS sw_in[13] _2220_/A gf180mcu_as_sc_mcu7t3v3__buff_12
Xinput276 VDD VDD VSS VSS sw_in[23] _4196_/A gf180mcu_as_sc_mcu7t3v3__buff_12
Xinput287 VDD VDD VSS VSS sw_in[33] _3955_/A gf180mcu_as_sc_mcu7t3v3__buff_12
Xinput298 VDD VDD VSS VSS west_in[10] _4087_/D gf180mcu_as_sc_mcu7t3v3__buff_12
XFILLER_84_97 VDD VDD VSS VSS gf180mcu_as_sc_mcu7t3v3__fillcap_8
XFILLER_182_1013 VDD VDD VSS VSS gf180mcu_as_sc_mcu7t3v3__fill_2
XFILLER_186_1182 VDD VDD VSS VSS gf180mcu_as_sc_mcu7t3v3__fill_1
XFILLER_158_911 VDD VDD VSS VSS gf180mcu_as_sc_mcu7t3v3__fillcap_8
XFILLER_160_1322 VDD VDD VSS VSS gf180mcu_as_sc_mcu7t3v3__fillcap_4
XFILLER_13_994 VDD VDD VSS VSS gf180mcu_as_sc_mcu7t3v3__fill_1
XFILLER_158_944 VDD VDD VSS VSS gf180mcu_as_sc_mcu7t3v3__fill_1
XFILLER_157_454 VDD VDD VSS VSS gf180mcu_as_sc_mcu7t3v3__fillcap_8
XFILLER_157_476 VDD VDD VSS VSS gf180mcu_as_sc_mcu7t3v3__fillcap_8
XFILLER_172_402 VDD VDD VSS VSS gf180mcu_as_sc_mcu7t3v3__fill_1
XFILLER_185_785 VDD VDD VSS VSS gf180mcu_as_sc_mcu7t3v3__fill_2
X_2680_ VDD VDD VSS VSS _4017_/A _2900_/B _2680_/C _2680_/D _2979_/A gf180mcu_as_sc_mcu7t3v3__ao211_2
XFILLER_144_104 VDD VDD VSS VSS gf180mcu_as_sc_mcu7t3v3__fill_1
XFILLER_149_90 VDD VDD VSS VSS gf180mcu_as_sc_mcu7t3v3__fillcap_8
XFILLER_173_958 VDD VDD VSS VSS gf180mcu_as_sc_mcu7t3v3__fillcap_8
XFILLER_185_796 VDD VDD VSS VSS gf180mcu_as_sc_mcu7t3v3__fill_1
XFILLER_172_457 VDD VDD VSS VSS gf180mcu_as_sc_mcu7t3v3__fill_2
X_4350_ VDD VDD VSS VSS _4440_/CLK _4350_/D _4350_/Q gf180mcu_as_sc_mcu7t3v3__dfxtp_2
XFILLER_158_1262 VDD VDD VSS VSS gf180mcu_as_sc_mcu7t3v3__fill_1
X_3301_ VDD VDD VSS VSS _3333_/B _4464_/Q _3308_/D gf180mcu_as_sc_mcu7t3v3__and2_2
XFILLER_4_692 VDD VDD VSS VSS gf180mcu_as_sc_mcu7t3v3__fillcap_4
X_4281_ VDD VDD VSS VSS _4768_/D _4281_/B _4281_/A gf180mcu_as_sc_mcu7t3v3__nor2_2
XFILLER_119_1268 VDD VDD VSS VSS gf180mcu_as_sc_mcu7t3v3__fill_2
X_3232_ VDD VDD VSS VSS _3304_/S _4362_/Q _4391_/Q _3233_/B gf180mcu_as_sc_mcu7t3v3__mux2_2
XFILLER_80_1345 VDD VDD VSS VSS gf180mcu_as_sc_mcu7t3v3__fillcap_8
Xmesh_tile_836 VDD VDD VSS VSS ne_out[8] gf180mcu_as_sc_mcu7t3v3__tiel_4
X_3163_ VDD VDD VSS VSS _3163_/Y _4291_/B _3218_/B gf180mcu_as_sc_mcu7t3v3__nor2_2
Xmesh_tile_869 VDD VDD VSS VSS north_out[5] gf180mcu_as_sc_mcu7t3v3__tiel_4
Xmesh_tile_858 VDD VDD VSS VSS ne_out[30] gf180mcu_as_sc_mcu7t3v3__tiel_4
Xmesh_tile_847 VDD VDD VSS VSS ne_out[19] gf180mcu_as_sc_mcu7t3v3__tiel_4
XFILLER_81_102 VDD VDD VSS VSS gf180mcu_as_sc_mcu7t3v3__fill_2
X_3094_ VDD VDD VSS VSS _3122_/S _4482_/Q _4481_/Q _4481_/D gf180mcu_as_sc_mcu7t3v3__mux2_2
XPHY_EDGE_ROW_112_1_Left_304 VDD VSS gf180mcu_as_sc_mcu7t3v3__tap_2
XFILLER_167_218 VDD VDD VSS VSS gf180mcu_as_sc_mcu7t3v3__fill_1
X_3996_ VDD VDD VSS VSS _3997_/B _3996_/B _4241_/B gf180mcu_as_sc_mcu7t3v3__nor2_2
XFILLER_13_27 VDD VDD VSS VSS gf180mcu_as_sc_mcu7t3v3__fillcap_4
XFILLER_176_752 VDD VDD VSS VSS gf180mcu_as_sc_mcu7t3v3__fillcap_4
X_2947_ VDD VDD VSS VSS _4373_/Q _2951_/B _3021_/A _2951_/D _4373_/D gf180mcu_as_sc_mcu7t3v3__ao22_2
XFILLER_129_27 VDD VDD VSS VSS gf180mcu_as_sc_mcu7t3v3__fillcap_8
XFILLER_164_925 VDD VDD VSS VSS gf180mcu_as_sc_mcu7t3v3__fillcap_16
XFILLER_175_251 VDD VDD VSS VSS gf180mcu_as_sc_mcu7t3v3__fill_1
XFILLER_11_1111 VDD VDD VSS VSS gf180mcu_as_sc_mcu7t3v3__fill_1
XFILLER_11_1122 VDD VDD VSS VSS gf180mcu_as_sc_mcu7t3v3__fillcap_8
XFILLER_135_104 VDD VDD VSS VSS gf180mcu_as_sc_mcu7t3v3__fill_1
XFILLER_164_947 VDD VDD VSS VSS gf180mcu_as_sc_mcu7t3v3__fillcap_16
X_4617_ VDD VDD VSS VSS _4830_/CLK _4617_/D _4617_/Q gf180mcu_as_sc_mcu7t3v3__dfxtp_2
X_2878_ VDD VDD VSS VSS _4194_/A _2917_/C _2878_/C _2914_/B _2880_/C gf180mcu_as_sc_mcu7t3v3__ao211_2
XFILLER_85_1256 VDD VDD VSS VSS gf180mcu_as_sc_mcu7t3v3__fillcap_16
X_4548_ VDD VDD VSS VSS _4720_/CLK _4548_/D _4548_/Q gf180mcu_as_sc_mcu7t3v3__dfxtp_2
XFILLER_1_128 VDD VDD VSS VSS gf180mcu_as_sc_mcu7t3v3__fill_2
X_4479_ VDD VDD VSS VSS _4826_/CLK _4479_/D _4479_/Q gf180mcu_as_sc_mcu7t3v3__dfxtp_2
XPHY_EDGE_ROW_107_1_Left_299 VDD VSS gf180mcu_as_sc_mcu7t3v3__tap_2
XPHY_EDGE_ROW_187_Left_379 VDD VSS gf180mcu_as_sc_mcu7t3v3__tap_2
XFILLER_54_45 VDD VDD VSS VSS gf180mcu_as_sc_mcu7t3v3__fillcap_4
XPHY_EDGE_ROW_44_1_Left_236 VDD VSS gf180mcu_as_sc_mcu7t3v3__tap_2
XPHY_EDGE_ROW_108_3_Left_480 VDD VSS gf180mcu_as_sc_mcu7t3v3__tap_2
XFILLER_186_516 VDD VDD VSS VSS gf180mcu_as_sc_mcu7t3v3__fillcap_8
XFILLER_10_920 VDD VDD VSS VSS gf180mcu_as_sc_mcu7t3v3__fill_2
XFILLER_110_84 VDD VDD VSS VSS gf180mcu_as_sc_mcu7t3v3__fill_2
XTAP_TAPCELL_ROW_12_926 VDD VSS gf180mcu_as_sc_mcu7t3v3__tap_2
XTAP_TAPCELL_ROW_12_915 VDD VSS gf180mcu_as_sc_mcu7t3v3__tap_2
XFILLER_70_66 VDD VDD VSS VSS gf180mcu_as_sc_mcu7t3v3__fill_1
XFILLER_126_104 VDD VDD VSS VSS gf180mcu_as_sc_mcu7t3v3__fill_1
XFILLER_154_457 VDD VDD VSS VSS gf180mcu_as_sc_mcu7t3v3__fillcap_4
XFILLER_182_766 VDD VDD VSS VSS gf180mcu_as_sc_mcu7t3v3__fillcap_16
XFILLER_6_979 VDD VDD VSS VSS gf180mcu_as_sc_mcu7t3v3__fillcap_8
XFILLER_181_276 VDD VDD VSS VSS gf180mcu_as_sc_mcu7t3v3__fillcap_4
XFILLER_181_298 VDD VDD VSS VSS gf180mcu_as_sc_mcu7t3v3__fillcap_4
XFILLER_79_64 VDD VDD VSS VSS gf180mcu_as_sc_mcu7t3v3__fillcap_4
XFILLER_0_172 VDD VDD VSS VSS gf180mcu_as_sc_mcu7t3v3__fillcap_4
XTAP_TAPCELL_ROW_169_1458 VDD VSS gf180mcu_as_sc_mcu7t3v3__tap_2
XFILLER_153_1192 VDD VDD VSS VSS gf180mcu_as_sc_mcu7t3v3__fill_2
XTAP_TAPCELL_ROW_186_1783 VDD VSS gf180mcu_as_sc_mcu7t3v3__tap_2
XTAP_TAPCELL_ROW_186_1772 VDD VSS gf180mcu_as_sc_mcu7t3v3__tap_2
XFILLER_28_90 VDD VDD VSS VSS gf180mcu_as_sc_mcu7t3v3__fillcap_4
XTAP_TAPCELL_ROW_70_3_1981 VDD VSS gf180mcu_as_sc_mcu7t3v3__tap_2
X_3850_ VDD VDD VSS VSS _4191_/A _3876_/B _3850_/C _3850_/D _3853_/B gf180mcu_as_sc_mcu7t3v3__ao211_2
XPHY_EDGE_ROW_56_3_Right_97 VDD VSS gf180mcu_as_sc_mcu7t3v3__tap_2
XFILLER_38_1291 VDD VDD VSS VSS gf180mcu_as_sc_mcu7t3v3__fillcap_8
X_3781_ VDD VDD VSS VSS _4128_/A _3930_/B _3926_/B _4127_/A _3782_/D gf180mcu_as_sc_mcu7t3v3__ao22_2
X_2801_ VDD VDD VSS VSS _4787_/Q _2810_/B _2901_/C _4127_/A _2803_/C gf180mcu_as_sc_mcu7t3v3__ao22_2
XFILLER_125_1283 VDD VDD VSS VSS gf180mcu_as_sc_mcu7t3v3__fill_2
XFILLER_158_774 VDD VDD VSS VSS gf180mcu_as_sc_mcu7t3v3__fillcap_16
XFILLER_192_519 VDD VDD VSS VSS gf180mcu_as_sc_mcu7t3v3__fillcap_4
X_2732_ VDD VDD VSS VSS _4064_/D _2904_/B _2732_/C _2905_/B _2733_/C gf180mcu_as_sc_mcu7t3v3__ao211_2
XFILLER_160_1196 VDD VDD VSS VSS gf180mcu_as_sc_mcu7t3v3__fillcap_16
XFILLER_173_722 VDD VDD VSS VSS gf180mcu_as_sc_mcu7t3v3__fill_2
XFILLER_185_582 VDD VDD VSS VSS gf180mcu_as_sc_mcu7t3v3__fill_2
XPHY_EDGE_ROW_90_1_Left_282 VDD VSS gf180mcu_as_sc_mcu7t3v3__tap_2
XFILLER_9_795 VDD VDD VSS VSS gf180mcu_as_sc_mcu7t3v3__fill_2
X_2663_ VDD VDD VSS VSS _2663_/Y _2663_/B _2892_/B gf180mcu_as_sc_mcu7t3v3__nor2_2
XFILLER_161_928 VDD VDD VSS VSS gf180mcu_as_sc_mcu7t3v3__fillcap_4
XFILLER_173_788 VDD VDD VSS VSS gf180mcu_as_sc_mcu7t3v3__fill_1
XFILLER_173_799 VDD VDD VSS VSS gf180mcu_as_sc_mcu7t3v3__fillcap_16
X_4402_ VDD VDD VSS VSS _4533_/CLK _4402_/D _4402_/Q gf180mcu_as_sc_mcu7t3v3__dfxtp_2
X_2594_ VDD VDD VSS VSS _3994_/A _3994_/B _2638_/D gf180mcu_as_sc_mcu7t3v3__and2_2
XFILLER_158_1081 VDD VDD VSS VSS gf180mcu_as_sc_mcu7t3v3__fillcap_4
XFILLER_5_72 VDD VDD VSS VSS gf180mcu_as_sc_mcu7t3v3__fillcap_4
XFILLER_5_990 VDD VDD VSS VSS gf180mcu_as_sc_mcu7t3v3__fill_1
X_4333_ VDD VDD VSS VSS clkload8/A _4333_/D _4333_/Q gf180mcu_as_sc_mcu7t3v3__dfxtp_2
X_4264_ VDD VDD VSS VSS _4800_/Q _4264_/B _4264_/C _4264_/D _4266_/C gf180mcu_as_sc_mcu7t3v3__ao22_2
X_3215_ VDD VDD VSS VSS _3219_/S _4516_/Q _3215_/A _4516_/D gf180mcu_as_sc_mcu7t3v3__mux2_2
XFILLER_171_1292 VDD VDD VSS VSS gf180mcu_as_sc_mcu7t3v3__fillcap_16
X_4195_ VDD VDD VSS VSS _4196_/B _4195_/A _4228_/B _4195_/C gf180mcu_as_sc_mcu7t3v3__ao21_2
X_3146_ VDD VDD VSS VSS _3148_/C _4500_/Q _4497_/Q gf180mcu_as_sc_mcu7t3v3__nor2_2
X_3077_ VDD VDD VSS VSS _3079_/S _5074_/A _4475_/Q _4475_/D gf180mcu_as_sc_mcu7t3v3__mux2_2
XFILLER_165_1052 VDD VDD VSS VSS gf180mcu_as_sc_mcu7t3v3__fillcap_8
XFILLER_24_37 VDD VDD VSS VSS gf180mcu_as_sc_mcu7t3v3__fillcap_8
XFILLER_165_1096 VDD VDD VSS VSS gf180mcu_as_sc_mcu7t3v3__fillcap_4
XFILLER_104_1334 VDD VDD VSS VSS gf180mcu_as_sc_mcu7t3v3__fillcap_16
XFILLER_10_249 VDD VDD VSS VSS gf180mcu_as_sc_mcu7t3v3__fill_1
X_3979_ VDD VDD VSS VSS _3989_/B _4247_/B _4265_/D gf180mcu_as_sc_mcu7t3v3__and2_2
XFILLER_152_917 VDD VDD VSS VSS gf180mcu_as_sc_mcu7t3v3__fill_1
XFILLER_156_69 VDD VDD VSS VSS gf180mcu_as_sc_mcu7t3v3__fill_2
XFILLER_176_1181 VDD VDD VSS VSS gf180mcu_as_sc_mcu7t3v3__fill_2
XFILLER_160_972 VDD VDD VSS VSS gf180mcu_as_sc_mcu7t3v3__fill_2
XFILLER_172_1056 VDD VDD VSS VSS gf180mcu_as_sc_mcu7t3v3__fillcap_16
Xfanout730 VDD VDD VSS VSS _4479_/Q _3128_/A gf180mcu_as_sc_mcu7t3v3__buff_12
Xfanout741 VDD VDD VSS VSS _3409_/A _3206_/A gf180mcu_as_sc_mcu7t3v3__buff_12
XFILLER_24_1324 VDD VDD VSS VSS gf180mcu_as_sc_mcu7t3v3__fillcap_4
Xfanout752 VDD VDD VSS VSS _3351_/A _3394_/A gf180mcu_as_sc_mcu7t3v3__buff_12
Xfanout763 VDD VDD VSS VSS _4213_/A _4051_/A gf180mcu_as_sc_mcu7t3v3__buff_12
Xfanout785 VDD VDD VSS VSS _2478_/A _2397_/D gf180mcu_as_sc_mcu7t3v3__buff_12
XTAP_TAPCELL_ROW_89_1_1042 VDD VSS gf180mcu_as_sc_mcu7t3v3__tap_2
XTAP_TAPCELL_ROW_103_1_1056 VDD VSS gf180mcu_as_sc_mcu7t3v3__tap_2
XFILLER_45_102 VDD VDD VSS VSS gf180mcu_as_sc_mcu7t3v3__fill_2
Xfanout796 VDD VDD VSS VSS input20/Y _2408_/A gf180mcu_as_sc_mcu7t3v3__buff_12
XTAP_TAPCELL_ROW_6_798 VDD VSS gf180mcu_as_sc_mcu7t3v3__tap_2
XTAP_TAPCELL_ROW_164_1366 VDD VSS gf180mcu_as_sc_mcu7t3v3__tap_2
XTAP_TAPCELL_ROW_164_1355 VDD VSS gf180mcu_as_sc_mcu7t3v3__tap_2
XTAP_TAPCELL_ROW_181_1691 VDD VSS gf180mcu_as_sc_mcu7t3v3__tap_2
XTAP_TAPCELL_ROW_181_1680 VDD VSS gf180mcu_as_sc_mcu7t3v3__tap_2
XFILLER_183_1130 VDD VDD VSS VSS gf180mcu_as_sc_mcu7t3v3__fillcap_4
XFILLER_121_72 VDD VDD VSS VSS gf180mcu_as_sc_mcu7t3v3__fillcap_4
XFILLER_109_1256 VDD VDD VSS VSS gf180mcu_as_sc_mcu7t3v3__fillcap_8
XFILLER_109_1278 VDD VDD VSS VSS gf180mcu_as_sc_mcu7t3v3__fillcap_16
XFILLER_186_379 VDD VDD VSS VSS gf180mcu_as_sc_mcu7t3v3__fillcap_4
XFILLER_81_98 VDD VDD VSS VSS gf180mcu_as_sc_mcu7t3v3__fillcap_4
XFILLER_14_92 VDD VDD VSS VSS gf180mcu_as_sc_mcu7t3v3__fillcap_8
XFILLER_155_766 VDD VDD VSS VSS gf180mcu_as_sc_mcu7t3v3__fillcap_4
XFILLER_182_541 VDD VDD VSS VSS gf180mcu_as_sc_mcu7t3v3__fillcap_4
XFILLER_6_732 VDD VDD VSS VSS gf180mcu_as_sc_mcu7t3v3__fill_2
XFILLER_170_747 VDD VDD VSS VSS gf180mcu_as_sc_mcu7t3v3__fillcap_8
XTAP_TAPCELL_ROW_188_1812 VDD VSS gf180mcu_as_sc_mcu7t3v3__tap_2
XFILLER_146_80 VDD VDD VSS VSS gf180mcu_as_sc_mcu7t3v3__fillcap_16
XTAP_TAPCELL_ROW_188_1823 VDD VSS gf180mcu_as_sc_mcu7t3v3__tap_2
XFILLER_9_1329 VDD VDD VSS VSS gf180mcu_as_sc_mcu7t3v3__fill_1
XFILLER_29_1279 VDD VDD VSS VSS gf180mcu_as_sc_mcu7t3v3__fill_2
XFILLER_1_492 VDD VDD VSS VSS gf180mcu_as_sc_mcu7t3v3__fill_2
Xclkbuf_leaf_4_clk_regs VDD VDD VSS VSS clkbuf_leaf_8_clk_regs/A clkload8/A gf180mcu_as_sc_mcu7t3v3__clkbuff_12
Xinput7 VDD VDD VSS VSS boot_addr[5] input7/Y gf180mcu_as_sc_mcu7t3v3__buff_12
X_3000_ VDD VDD VSS VSS _3031_/A _3004_/B _3004_/C _4412_/Q _4412_/D gf180mcu_as_sc_mcu7t3v3__ao22_2
XFILLER_7_1097 VDD VDD VSS VSS gf180mcu_as_sc_mcu7t3v3__fillcap_4
XFILLER_166_1350 VDD VDD VSS VSS gf180mcu_as_sc_mcu7t3v3__fill_1
XFILLER_177_302 VDD VDD VSS VSS gf180mcu_as_sc_mcu7t3v3__fill_2
X_3902_ VDD VDD VSS VSS _4800_/Q _3927_/B _3927_/C _3902_/D _3903_/D gf180mcu_as_sc_mcu7t3v3__ao211_2
XFILLER_189_184 VDD VDD VSS VSS gf180mcu_as_sc_mcu7t3v3__fill_1
X_3833_ VDD VDD VSS VSS _4793_/Q _3869_/B _3833_/C _3833_/D _3834_/C gf180mcu_as_sc_mcu7t3v3__ao22_2
XFILLER_165_508 VDD VDD VSS VSS gf180mcu_as_sc_mcu7t3v3__fillcap_16
XFILLER_177_368 VDD VDD VSS VSS gf180mcu_as_sc_mcu7t3v3__fill_1
XFILLER_158_571 VDD VDD VSS VSS gf180mcu_as_sc_mcu7t3v3__fill_1
X_3764_ VDD VDD VSS VSS _4112_/D _3799_/B _3764_/C _3764_/D _3765_/C gf180mcu_as_sc_mcu7t3v3__ao211_2
X_3695_ VDD VDD VSS VSS _3794_/B _4052_/D _3696_/C gf180mcu_as_sc_mcu7t3v3__and2_2
X_2715_ VDD VDD VSS VSS _2879_/B _4049_/A _2716_/D gf180mcu_as_sc_mcu7t3v3__or2_2
X_2646_ VDD VDD VSS VSS _4253_/A _4240_/A _4269_/A _4003_/A gf180mcu_as_sc_mcu7t3v3__nor3_2
XFILLER_156_1029 VDD VDD VSS VSS gf180mcu_as_sc_mcu7t3v3__fillcap_16
XFILLER_160_213 VDD VDD VSS VSS gf180mcu_as_sc_mcu7t3v3__fill_1
XFILLER_173_1310 VDD VDD VSS VSS gf180mcu_as_sc_mcu7t3v3__fillcap_16
Xoutput344 VDD VDD VSS VSS _4705_/Q east_out[12] gf180mcu_as_sc_mcu7t3v3__buff_12
Xoutput333 VDD VDD VSS VSS _5069_/Y dft_rdata[0] gf180mcu_as_sc_mcu7t3v3__buff_12
Xoutput377 VDD VDD VSS VSS _4657_/Q south_out[0] gf180mcu_as_sc_mcu7t3v3__buff_12
Xoutput366 VDD VDD VSS VSS _4725_/Q east_out[32] gf180mcu_as_sc_mcu7t3v3__buff_12
Xoutput355 VDD VDD VSS VSS _4715_/Q east_out[22] gf180mcu_as_sc_mcu7t3v3__buff_12
X_2577_ VDD VDD VSS VSS _3587_/A _2585_/B _4645_/Q _4644_/D gf180mcu_as_sc_mcu7t3v3__mux2_2
Xoutput399 VDD VDD VSS VSS _4659_/Q south_out[2] gf180mcu_as_sc_mcu7t3v3__buff_12
Xoutput388 VDD VDD VSS VSS _4658_/Q south_out[1] gf180mcu_as_sc_mcu7t3v3__buff_12
X_4316_ VDD VDD VSS VSS _4318_/B _4540_/Q _4793_/D gf180mcu_as_sc_mcu7t3v3__and2_2
X_4247_ VDD VDD VSS VSS _4247_/B _4247_/A _4265_/B gf180mcu_as_sc_mcu7t3v3__and2_2
XFILLER_19_48 VDD VDD VSS VSS gf180mcu_as_sc_mcu7t3v3__fillcap_8
X_4178_ VDD VDD VSS VSS _4179_/A _4178_/A _4186_/B _4178_/C gf180mcu_as_sc_mcu7t3v3__ao21_2
XTAP_TAPCELL_ROW_3_746 VDD VSS gf180mcu_as_sc_mcu7t3v3__tap_2
XTAP_TAPCELL_ROW_3_757 VDD VSS gf180mcu_as_sc_mcu7t3v3__tap_2
X_3129_ VDD VDD VSS VSS _3130_/B _4480_/Q _4625_/Q _3129_/C gf180mcu_as_sc_mcu7t3v3__maj3_2
XFILLER_180_1303 VDD VDD VSS VSS gf180mcu_as_sc_mcu7t3v3__fill_1
XFILLER_35_69 VDD VDD VSS VSS gf180mcu_as_sc_mcu7t3v3__fill_1
XFILLER_143_6 VDD VDD VSS VSS gf180mcu_as_sc_mcu7t3v3__fill_2
XFILLER_169_858 VDD VDD VSS VSS gf180mcu_as_sc_mcu7t3v3__fillcap_8
XFILLER_51_68 VDD VDD VSS VSS gf180mcu_as_sc_mcu7t3v3__fill_2
XTAP_TAPCELL_ROW_122_3_2033 VDD VSS gf180mcu_as_sc_mcu7t3v3__tap_2
XFILLER_164_574 VDD VDD VSS VSS gf180mcu_as_sc_mcu7t3v3__fillcap_4
XFILLER_178_1243 VDD VDD VSS VSS gf180mcu_as_sc_mcu7t3v3__fillcap_16
XFILLER_192_883 VDD VDD VSS VSS gf180mcu_as_sc_mcu7t3v3__fill_1
X_4831__1047 VDD VDD VSS VSS _4831_/D gf180mcu_as_sc_mcu7t3v3__tiel_4
XFILLER_174_1107 VDD VDD VSS VSS gf180mcu_as_sc_mcu7t3v3__fill_2
XFILLER_3_724 VDD VDD VSS VSS gf180mcu_as_sc_mcu7t3v3__fill_1
XFILLER_183_34 VDD VDD VSS VSS gf180mcu_as_sc_mcu7t3v3__fillcap_16
XFILLER_3_768 VDD VDD VSS VSS gf180mcu_as_sc_mcu7t3v3__fill_2
Xfanout560 VDD VDD VSS VSS _4326_/B _4804_/D gf180mcu_as_sc_mcu7t3v3__buff_12
XTAP_TAPCELL_ROW_166_1406 VDD VSS gf180mcu_as_sc_mcu7t3v3__tap_2
Xfanout571 VDD VDD VSS VSS _3395_/B _3347_/B gf180mcu_as_sc_mcu7t3v3__buff_12
Xfanout582 VDD VDD VSS VSS _2418_/A _3053_/B gf180mcu_as_sc_mcu7t3v3__buff_12
XTAP_TAPCELL_ROW_183_1731 VDD VSS gf180mcu_as_sc_mcu7t3v3__tap_2
XTAP_TAPCELL_ROW_183_1720 VDD VSS gf180mcu_as_sc_mcu7t3v3__tap_2
XFILLER_18_102 VDD VDD VSS VSS gf180mcu_as_sc_mcu7t3v3__fill_2
XFILLER_132_60 VDD VDD VSS VSS gf180mcu_as_sc_mcu7t3v3__fillcap_8
XFILLER_132_82 VDD VDD VSS VSS gf180mcu_as_sc_mcu7t3v3__fillcap_4
XFILLER_98_1288 VDD VDD VSS VSS gf180mcu_as_sc_mcu7t3v3__fill_1
XFILLER_170_500 VDD VDD VSS VSS gf180mcu_as_sc_mcu7t3v3__fill_2
Xmax_cap705 VDD VDD VSS VSS _4288_/C _4284_/A gf180mcu_as_sc_mcu7t3v3__clkbuff_12
X_3480_ VDD VDD VSS VSS _3481_/C _3480_/B _3480_/A gf180mcu_as_sc_mcu7t3v3__nor2_2
X_2500_ VDD VDD VSS VSS _4806_/Q _2500_/B _2500_/A _5075_/A gf180mcu_as_sc_mcu7t3v3__mux2_2
XFILLER_170_522 VDD VDD VSS VSS gf180mcu_as_sc_mcu7t3v3__fill_2
XFILLER_192_1207 VDD VDD VSS VSS gf180mcu_as_sc_mcu7t3v3__fillcap_4
X_2431_ VDD VDD VSS VSS _3071_/B _4453_/Q _2431_/Y gf180mcu_as_sc_mcu7t3v3__and2_2
XFILLER_170_555 VDD VDD VSS VSS gf180mcu_as_sc_mcu7t3v3__fill_2
X_2362_ VDD VDD VSS VSS _2363_/D _2481_/A _2369_/B _3611_/A gf180mcu_as_sc_mcu7t3v3__aoi21_2
XPHY_EDGE_ROW_121_1_Left_313 VDD VSS gf180mcu_as_sc_mcu7t3v3__tap_2
X_4101_ VDD VDD VSS VSS _4784_/Q _4134_/B _4216_/A _4101_/D _4103_/A gf180mcu_as_sc_mcu7t3v3__ao22_2
X_2293_ VDD VDD VSS VSS _3201_/S _2293_/B _2293_/A _3573_/B gf180mcu_as_sc_mcu7t3v3__mux2_2
XTAP_TAPCELL_ROW_57_3_1968 VDD VSS gf180mcu_as_sc_mcu7t3v3__tap_2
X_4032_ VDD VDD VSS VSS _4032_/A _4136_/B _4032_/C _4032_/D _4033_/C gf180mcu_as_sc_mcu7t3v3__ao211_2
XPHY_EDGE_ROW_160_Right_22 VDD VSS gf180mcu_as_sc_mcu7t3v3__tap_2
XFILLER_77_1328 VDD VDD VSS VSS gf180mcu_as_sc_mcu7t3v3__fill_1
XFILLER_162_1033 VDD VDD VSS VSS gf180mcu_as_sc_mcu7t3v3__fillcap_16
XANTENNA_12 VDD VDD VSS VSS _2397_/B gf180mcu_as_sc_mcu7t3v3__diode_2
XANTENNA_23 VDD VDD VSS VSS _4027_/B gf180mcu_as_sc_mcu7t3v3__diode_2
XANTENNA_34 VDD VDD VSS VSS _4091_/B gf180mcu_as_sc_mcu7t3v3__diode_2
XANTENNA_45 VDD VDD VSS VSS _4228_/A gf180mcu_as_sc_mcu7t3v3__diode_2
XANTENNA_56 VDD VDD VSS VSS _4137_/A gf180mcu_as_sc_mcu7t3v3__diode_2
XFILLER_166_828 VDD VDD VSS VSS gf180mcu_as_sc_mcu7t3v3__fillcap_8
XFILLER_177_176 VDD VDD VSS VSS gf180mcu_as_sc_mcu7t3v3__fillcap_16
X_4796_ VDD VDD VSS VSS _4804_/CLK _4796_/D _4796_/Q gf180mcu_as_sc_mcu7t3v3__dfxtp_2
X_3816_ VDD VDD VSS VSS _3818_/C _4160_/A _3871_/C _3816_/C gf180mcu_as_sc_mcu7t3v3__ao21_2
XANTENNA_67 VDD VDD VSS VSS _4149_/D gf180mcu_as_sc_mcu7t3v3__diode_2
X_3747_ VDD VDD VSS VSS _3747_/S _3747_/B _4098_/A _3748_/B gf180mcu_as_sc_mcu7t3v3__mux2_2
XFILLER_101_1326 VDD VDD VSS VSS gf180mcu_as_sc_mcu7t3v3__fill_2
XFILLER_137_27 VDD VDD VSS VSS gf180mcu_as_sc_mcu7t3v3__fillcap_8
X_3678_ VDD VDD VSS VSS _4039_/D _3795_/B _3678_/C _3795_/D _3681_/B gf180mcu_as_sc_mcu7t3v3__ao211_2
XFILLER_161_555 VDD VDD VSS VSS gf180mcu_as_sc_mcu7t3v3__fillcap_4
X_2629_ VDD VDD VSS VSS _2665_/B _4264_/B _2629_/B _3987_/A _2629_/D gf180mcu_as_sc_mcu7t3v3__aoi22_2
XTAP_TAPCELL_ROW_8_838 VDD VSS gf180mcu_as_sc_mcu7t3v3__tap_2
XPHY_EDGE_ROW_53_1_Left_245 VDD VSS gf180mcu_as_sc_mcu7t3v3__tap_2
XTAP_TAPCELL_ROW_8_849 VDD VSS gf180mcu_as_sc_mcu7t3v3__tap_2
XFILLER_46_68 VDD VDD VSS VSS gf180mcu_as_sc_mcu7t3v3__fill_2
XTAP_TAPCELL_ROW_161_1314 VDD VSS gf180mcu_as_sc_mcu7t3v3__tap_2
XTAP_TAPCELL_ROW_161_1303 VDD VSS gf180mcu_as_sc_mcu7t3v3__tap_2
XPHY_EDGE_ROW_136_3_Left_508 VDD VSS gf180mcu_as_sc_mcu7t3v3__tap_2
XFILLER_102_41 VDD VDD VSS VSS gf180mcu_as_sc_mcu7t3v3__fill_2
XFILLER_188_419 VDD VDD VSS VSS gf180mcu_as_sc_mcu7t3v3__fill_2
XFILLER_102_96 VDD VDD VSS VSS gf180mcu_as_sc_mcu7t3v3__fillcap_8
XFILLER_12_823 VDD VDD VSS VSS gf180mcu_as_sc_mcu7t3v3__fillcap_8
XFILLER_169_677 VDD VDD VSS VSS gf180mcu_as_sc_mcu7t3v3__fillcap_16
XFILLER_178_34 VDD VDD VSS VSS gf180mcu_as_sc_mcu7t3v3__fill_1
XFILLER_62_78 VDD VDD VSS VSS gf180mcu_as_sc_mcu7t3v3__fillcap_16
XFILLER_156_305 VDD VDD VSS VSS gf180mcu_as_sc_mcu7t3v3__fill_2
XFILLER_169_699 VDD VDD VSS VSS gf180mcu_as_sc_mcu7t3v3__fill_1
XFILLER_7_18 VDD VDD VSS VSS gf180mcu_as_sc_mcu7t3v3__fillcap_16
XTAP_TAPCELL_ROW_159_1276 VDD VSS gf180mcu_as_sc_mcu7t3v3__tap_2
XTAP_TAPCELL_ROW_159_1265 VDD VSS gf180mcu_as_sc_mcu7t3v3__tap_2
XFILLER_183_135 VDD VDD VSS VSS gf180mcu_as_sc_mcu7t3v3__fillcap_4
XTAP_TAPCELL_ROW_176_1590 VDD VSS gf180mcu_as_sc_mcu7t3v3__tap_2
XFILLER_165_861 VDD VDD VSS VSS gf180mcu_as_sc_mcu7t3v3__fillcap_4
XFILLER_164_382 VDD VDD VSS VSS gf180mcu_as_sc_mcu7t3v3__fill_2
XFILLER_191_1240 VDD VDD VSS VSS gf180mcu_as_sc_mcu7t3v3__fillcap_8
XFILLER_152_1213 VDD VDD VSS VSS gf180mcu_as_sc_mcu7t3v3__fill_2
XFILLER_191_1262 VDD VDD VSS VSS gf180mcu_as_sc_mcu7t3v3__fillcap_16
XFILLER_152_1268 VDD VDD VSS VSS gf180mcu_as_sc_mcu7t3v3__fillcap_4
XFILLER_65_1298 VDD VDD VSS VSS gf180mcu_as_sc_mcu7t3v3__fill_1
XPHY_EDGE_ROW_91_1_Right_600 VDD VSS gf180mcu_as_sc_mcu7t3v3__tap_2
X_2980_ VDD VDD VSS VSS _2980_/A _2989_/B _2989_/C _4392_/Q _4392_/D gf180mcu_as_sc_mcu7t3v3__ao22_2
XFILLER_187_452 VDD VDD VSS VSS gf180mcu_as_sc_mcu7t3v3__fill_2
XFILLER_175_625 VDD VDD VSS VSS gf180mcu_as_sc_mcu7t3v3__fillcap_4
XFILLER_188_997 VDD VDD VSS VSS gf180mcu_as_sc_mcu7t3v3__fillcap_16
X_4650_ VDD VDD VSS VSS _4726_/CLK _4650_/D _4650_/Q gf180mcu_as_sc_mcu7t3v3__dfxtp_2
Xinput10 VDD VDD VSS VSS boot_addr[8] _2423_/A gf180mcu_as_sc_mcu7t3v3__buff_12
Xinput21 VDD VDD VSS VSS boot_wen _2344_/B gf180mcu_as_sc_mcu7t3v3__buff_12
X_3601_ VDD VDD VSS VSS _4653_/Q _4649_/Q _3602_/D gf180mcu_as_sc_mcu7t3v3__xnor2_2
X_4581_ VDD VDD VSS VSS _4606_/CLK _4581_/D _4581_/Q gf180mcu_as_sc_mcu7t3v3__dfxtp_2
Xinput32 VDD VDD VSS VSS dft_addr[9] _2428_/B gf180mcu_as_sc_mcu7t3v3__buff_12
Xinput43 VDD VDD VSS VSS dft_we _2226_/A gf180mcu_as_sc_mcu7t3v3__buff_12
Xinput54 VDD VDD VSS VSS east_in[19] _4158_/D gf180mcu_as_sc_mcu7t3v3__buff_12
XFILLER_171_842 VDD VDD VSS VSS gf180mcu_as_sc_mcu7t3v3__fill_2
Xinput65 VDD VDD VSS VSS east_in[29] _4248_/A gf180mcu_as_sc_mcu7t3v3__buff_12
Xinput76 VDD VDD VSS VSS east_in[6] wire772/A gf180mcu_as_sc_mcu7t3v3__buff_12
Xinput87 VDD VDD VSS VSS ne_in[16] wire767/A gf180mcu_as_sc_mcu7t3v3__buff_12
Xinput98 VDD VDD VSS VSS ne_in[26] wire766/A gf180mcu_as_sc_mcu7t3v3__buff_12
Xwire791 VDD VDD VSS VSS wire791/A _4195_/A gf180mcu_as_sc_mcu7t3v3__clkbuff_12
Xmax_cap513 VDD VDD VSS VSS _2896_/D _2912_/B gf180mcu_as_sc_mcu7t3v3__clkbuff_12
X_3532_ VDD VDD VSS VSS _3583_/A _3532_/B _4458_/Q _4611_/D gf180mcu_as_sc_mcu7t3v3__mux2_2
X_3463_ VDD VDD VSS VSS _3600_/A _3516_/B _4586_/Q _4586_/D gf180mcu_as_sc_mcu7t3v3__mux2_2
XFILLER_157_1168 VDD VDD VSS VSS gf180mcu_as_sc_mcu7t3v3__fillcap_16
XFILLER_170_374 VDD VDD VSS VSS gf180mcu_as_sc_mcu7t3v3__fillcap_8
X_2414_ VDD VDD VSS VSS _2415_/D _2494_/A _2437_/B input8/Y gf180mcu_as_sc_mcu7t3v3__aoi21b_2
X_3394_ VDD VDD VSS VSS _3396_/B _3394_/C _3394_/B _3394_/A gf180mcu_as_sc_mcu7t3v3__aoi21_2
X_2345_ VDD VDD VSS VSS _2397_/D _2345_/B _2345_/A _2345_/Y gf180mcu_as_sc_mcu7t3v3__mux2_2
X_2276_ VDD VDD VSS VSS _2522_/A _2563_/D _3572_/B gf180mcu_as_sc_mcu7t3v3__nor2_2
X_4015_ VDD VDD VSS VSS _4015_/A _4218_/B _4225_/B _4015_/D _4016_/D gf180mcu_as_sc_mcu7t3v3__ao22_2
XFILLER_168_1231 VDD VDD VSS VSS gf180mcu_as_sc_mcu7t3v3__fill_1
XFILLER_16_27 VDD VDD VSS VSS gf180mcu_as_sc_mcu7t3v3__fillcap_8
XFILLER_168_1297 VDD VDD VSS VSS gf180mcu_as_sc_mcu7t3v3__fillcap_4
XFILLER_179_920 VDD VDD VSS VSS gf180mcu_as_sc_mcu7t3v3__fillcap_4
XFILLER_90_1303 VDD VDD VSS VSS gf180mcu_as_sc_mcu7t3v3__fill_2
XFILLER_178_452 VDD VDD VSS VSS gf180mcu_as_sc_mcu7t3v3__fill_2
XFILLER_179_975 VDD VDD VSS VSS gf180mcu_as_sc_mcu7t3v3__fillcap_4
XFILLER_166_625 VDD VDD VSS VSS gf180mcu_as_sc_mcu7t3v3__fill_1
XFILLER_148_37 VDD VDD VSS VSS gf180mcu_as_sc_mcu7t3v3__fill_2
X_4779_ VDD VDD VSS VSS _4783_/CLK _4779_/D _4779_/Q gf180mcu_as_sc_mcu7t3v3__dfxtp_2
XTAP_TAPCELL_ROW_154_1173 VDD VSS gf180mcu_as_sc_mcu7t3v3__tap_2
XFILLER_173_190 VDD VDD VSS VSS gf180mcu_as_sc_mcu7t3v3__fill_1
XFILLER_175_1235 VDD VDD VSS VSS gf180mcu_as_sc_mcu7t3v3__fillcap_8
XFILLER_161_363 VDD VDD VSS VSS gf180mcu_as_sc_mcu7t3v3__fillcap_16
XFILLER_164_69 VDD VDD VSS VSS gf180mcu_as_sc_mcu7t3v3__fill_2
XFILLER_57_45 VDD VDD VSS VSS gf180mcu_as_sc_mcu7t3v3__fillcap_16
XFILLER_5_1332 VDD VDD VSS VSS gf180mcu_as_sc_mcu7t3v3__fillcap_16
XFILLER_5_1354 VDD VDD VSS VSS gf180mcu_as_sc_mcu7t3v3__fill_1
XFILLER_112_1263 VDD VDD VSS VSS gf180mcu_as_sc_mcu7t3v3__fillcap_8
XFILLER_113_84 VDD VDD VSS VSS gf180mcu_as_sc_mcu7t3v3__fill_1
XFILLER_147_1326 VDD VDD VSS VSS gf180mcu_as_sc_mcu7t3v3__fillcap_16
XFILLER_182_1217 VDD VDD VSS VSS gf180mcu_as_sc_mcu7t3v3__fillcap_8
XFILLER_186_1353 VDD VDD VSS VSS gf180mcu_as_sc_mcu7t3v3__fill_2
XFILLER_189_55 VDD VDD VSS VSS gf180mcu_as_sc_mcu7t3v3__fill_2
XTAP_TAPCELL_ROW_178_1630 VDD VSS gf180mcu_as_sc_mcu7t3v3__tap_2
XPHY_EDGE_ROW_130_1_Right_639 VDD VSS gf180mcu_as_sc_mcu7t3v3__tap_2
XFILLER_169_474 VDD VDD VSS VSS gf180mcu_as_sc_mcu7t3v3__fill_2
XFILLER_185_912 VDD VDD VSS VSS gf180mcu_as_sc_mcu7t3v3__fillcap_8
XFILLER_11_163 VDD VDD VSS VSS gf180mcu_as_sc_mcu7t3v3__fillcap_4
XFILLER_157_636 VDD VDD VSS VSS gf180mcu_as_sc_mcu7t3v3__fill_2
XTAP_TAPCELL_ROW_174_1549 VDD VSS gf180mcu_as_sc_mcu7t3v3__tap_2
XFILLER_185_989 VDD VDD VSS VSS gf180mcu_as_sc_mcu7t3v3__fillcap_16
XFILLER_153_820 VDD VDD VSS VSS gf180mcu_as_sc_mcu7t3v3__fill_1
XFILLER_171_127 VDD VDD VSS VSS gf180mcu_as_sc_mcu7t3v3__fillcap_8
XFILLER_32_1275 VDD VDD VSS VSS gf180mcu_as_sc_mcu7t3v3__fillcap_4
XTAP_TAPCELL_ROW_191_1874 VDD VSS gf180mcu_as_sc_mcu7t3v3__tap_2
XTAP_TAPCELL_ROW_10_887 VDD VSS gf180mcu_as_sc_mcu7t3v3__tap_2
XTAP_TAPCELL_ROW_10_876 VDD VSS gf180mcu_as_sc_mcu7t3v3__tap_2
XFILLER_153_842 VDD VDD VSS VSS gf180mcu_as_sc_mcu7t3v3__fillcap_8
XFILLER_180_683 VDD VDD VSS VSS gf180mcu_as_sc_mcu7t3v3__fillcap_16
XFILLER_4_874 VDD VDD VSS VSS gf180mcu_as_sc_mcu7t3v3__fill_1
XFILLER_98_85 VDD VDD VSS VSS gf180mcu_as_sc_mcu7t3v3__fill_2
XFILLER_98_74 VDD VDD VSS VSS gf180mcu_as_sc_mcu7t3v3__fill_1
XFILLER_152_1065 VDD VDD VSS VSS gf180mcu_as_sc_mcu7t3v3__fillcap_16
XFILLER_152_1087 VDD VDD VSS VSS gf180mcu_as_sc_mcu7t3v3__fill_1
XPHY_EDGE_ROW_92_1_Right_601 VDD VSS gf180mcu_as_sc_mcu7t3v3__tap_2
X_2963_ VDD VDD VSS VSS _3031_/A _2965_/D _2965_/B _4383_/Q _4383_/D gf180mcu_as_sc_mcu7t3v3__ao22_2
X_4702_ VDD VDD VSS VSS _4727_/CLK _4702_/D _4702_/Q gf180mcu_as_sc_mcu7t3v3__dfxtp_2
XFILLER_175_422 VDD VDD VSS VSS gf180mcu_as_sc_mcu7t3v3__fillcap_16
XFILLER_187_282 VDD VDD VSS VSS gf180mcu_as_sc_mcu7t3v3__fill_2
X_2894_ VDD VDD VSS VSS _4207_/A _2894_/B _2894_/C _2894_/D _2895_/D gf180mcu_as_sc_mcu7t3v3__ao211_2
XFILLER_159_1208 VDD VDD VSS VSS gf180mcu_as_sc_mcu7t3v3__fillcap_16
X_4633_ VDD VDD VSS VSS _4808_/CLK _4633_/D _4633_/Q gf180mcu_as_sc_mcu7t3v3__dfxtp_2
XFILLER_11_1326 VDD VDD VSS VSS gf180mcu_as_sc_mcu7t3v3__fillcap_4
XFILLER_11_1348 VDD VDD VSS VSS gf180mcu_as_sc_mcu7t3v3__fillcap_4
XFILLER_156_691 VDD VDD VSS VSS gf180mcu_as_sc_mcu7t3v3__fill_2
X_4564_ VDD VDD VSS VSS _4807_/CLK _4564_/D _4564_/Q gf180mcu_as_sc_mcu7t3v3__dfxtp_2
X_3515_ VDD VDD VSS VSS _3529_/S _4605_/Q _3515_/A _4605_/D gf180mcu_as_sc_mcu7t3v3__mux2_2
XTAP_TAPCELL_ROW_60_1_1013 VDD VSS gf180mcu_as_sc_mcu7t3v3__tap_2
X_4495_ VDD VDD VSS VSS _4727_/CLK _4495_/D _4495_/Q gf180mcu_as_sc_mcu7t3v3__dfxtp_2
XFILLER_48_1260 VDD VDD VSS VSS gf180mcu_as_sc_mcu7t3v3__fill_2
X_3446_ VDD VDD VSS VSS _4630_/Q _3446_/B _3446_/A _3448_/B gf180mcu_as_sc_mcu7t3v3__mux2_2
X_3377_ VDD VDD VSS VSS _3378_/D _3377_/B _3408_/A gf180mcu_as_sc_mcu7t3v3__nor2_2
XFILLER_170_1165 VDD VDD VSS VSS gf180mcu_as_sc_mcu7t3v3__fill_2
X_2328_ VDD VDD VSS VSS _2329_/D _2461_/C _4807_/D input2/Y gf180mcu_as_sc_mcu7t3v3__aoi21b_2
X_2259_ VDD VDD VSS VSS _4623_/Q _4624_/Q _4625_/Q _3575_/B gf180mcu_as_sc_mcu7t3v3__nand3_2
XFILLER_107_1310 VDD VDD VSS VSS gf180mcu_as_sc_mcu7t3v3__fill_1
XFILLER_13_428 VDD VDD VSS VSS gf180mcu_as_sc_mcu7t3v3__fillcap_8
XFILLER_159_14 VDD VDD VSS VSS gf180mcu_as_sc_mcu7t3v3__fill_1
XFILLER_167_912 VDD VDD VSS VSS gf180mcu_as_sc_mcu7t3v3__fillcap_16
XFILLER_179_772 VDD VDD VSS VSS gf180mcu_as_sc_mcu7t3v3__fillcap_16
XFILLER_138_102 VDD VDD VSS VSS gf180mcu_as_sc_mcu7t3v3__fill_2
XFILLER_142_1256 VDD VDD VSS VSS gf180mcu_as_sc_mcu7t3v3__fillcap_16
XFILLER_181_1294 VDD VDD VSS VSS gf180mcu_as_sc_mcu7t3v3__fillcap_8
XTAP_TAPCELL_ROW_156_1213 VDD VSS gf180mcu_as_sc_mcu7t3v3__tap_2
XTAP_TAPCELL_ROW_156_1202 VDD VSS gf180mcu_as_sc_mcu7t3v3__tap_2
XFILLER_167_978 VDD VDD VSS VSS gf180mcu_as_sc_mcu7t3v3__fill_2
XFILLER_162_661 VDD VDD VSS VSS gf180mcu_as_sc_mcu7t3v3__fillcap_4
XFILLER_162_694 VDD VDD VSS VSS gf180mcu_as_sc_mcu7t3v3__fillcap_16
XFILLER_1_822 VDD VDD VSS VSS gf180mcu_as_sc_mcu7t3v3__fillcap_16
XFILLER_191_34 VDD VDD VSS VSS gf180mcu_as_sc_mcu7t3v3__fillcap_16
XFILLER_1_888 VDD VDD VSS VSS gf180mcu_as_sc_mcu7t3v3__fillcap_16
XFILLER_68_77 VDD VDD VSS VSS gf180mcu_as_sc_mcu7t3v3__fill_1
Xinput200 VDD VDD VSS VSS se_in[1] _4017_/A gf180mcu_as_sc_mcu7t3v3__buff_12
Xinput211 VDD VDD VSS VSS se_in[2] wire789/A gf180mcu_as_sc_mcu7t3v3__buff_12
Xinput222 VDD VDD VSS VSS se_in[7] wire787/A gf180mcu_as_sc_mcu7t3v3__buff_12
Xinput233 VDD VDD VSS VSS south_in[17] _4141_/A gf180mcu_as_sc_mcu7t3v3__buff_12
Xinput244 VDD VDD VSS VSS south_in[27] _4224_/A gf180mcu_as_sc_mcu7t3v3__buff_12
XPHY_EDGE_ROW_16_1_Left_208 VDD VSS gf180mcu_as_sc_mcu7t3v3__tap_2
XFILLER_124_61 VDD VDD VSS VSS gf180mcu_as_sc_mcu7t3v3__fill_1
X_4737__1035 VDD VDD VSS VSS _4737_/D gf180mcu_as_sc_mcu7t3v3__tiel_4
Xinput255 VDD VDD VSS VSS south_in[4] _4036_/A gf180mcu_as_sc_mcu7t3v3__buff_12
Xinput266 VDD VDD VSS VSS sw_in[14] _2221_/A gf180mcu_as_sc_mcu7t3v3__buff_12
Xinput277 VDD VDD VSS VSS sw_in[24] _4204_/A gf180mcu_as_sc_mcu7t3v3__buff_12
Xinput288 VDD VDD VSS VSS sw_in[34] _3957_/A gf180mcu_as_sc_mcu7t3v3__buff_12
Xinput299 VDD VDD VSS VSS west_in[11] _4094_/A gf180mcu_as_sc_mcu7t3v3__buff_12
XFILLER_189_503 VDD VDD VSS VSS gf180mcu_as_sc_mcu7t3v3__fillcap_8
XFILLER_17_92 VDD VDD VSS VSS gf180mcu_as_sc_mcu7t3v3__fillcap_4
XFILLER_186_1172 VDD VDD VSS VSS gf180mcu_as_sc_mcu7t3v3__fillcap_8
XFILLER_157_400 VDD VDD VSS VSS gf180mcu_as_sc_mcu7t3v3__fillcap_16
XFILLER_158_923 VDD VDD VSS VSS gf180mcu_as_sc_mcu7t3v3__fill_2
XFILLER_9_900 VDD VDD VSS VSS gf180mcu_as_sc_mcu7t3v3__fill_2
XFILLER_157_422 VDD VDD VSS VSS gf180mcu_as_sc_mcu7t3v3__fillcap_16
XPHY_EDGE_ROW_130_1_Left_322 VDD VSS gf180mcu_as_sc_mcu7t3v3__tap_2
XFILLER_157_466 VDD VDD VSS VSS gf180mcu_as_sc_mcu7t3v3__fill_2
XFILLER_9_977 VDD VDD VSS VSS gf180mcu_as_sc_mcu7t3v3__fill_2
XFILLER_157_499 VDD VDD VSS VSS gf180mcu_as_sc_mcu7t3v3__fillcap_16
XFILLER_184_263 VDD VDD VSS VSS gf180mcu_as_sc_mcu7t3v3__fillcap_8
X_3300_ VDD VDD VSS VSS _3348_/A _3300_/B _3300_/C _3300_/D _4528_/D gf180mcu_as_sc_mcu7t3v3__ao211_2
X_4280_ VDD VDD VSS VSS _4327_/A _4280_/A _4287_/A _4285_/B _4281_/B gf180mcu_as_sc_mcu7t3v3__ao31_2
X_3231_ VDD VDD VSS VSS _3234_/C _4420_/Q _3328_/S gf180mcu_as_sc_mcu7t3v3__nand2_2
XTAP_TAPCELL_ROW_121_1_1074 VDD VSS gf180mcu_as_sc_mcu7t3v3__tap_2
X_3162_ VDD VDD VSS VSS _3162_/A _4328_/A _4294_/A _3162_/D _4291_/B gf180mcu_as_sc_mcu7t3v3__nand4_2
Xmesh_tile_859 VDD VDD VSS VSS ne_out[31] gf180mcu_as_sc_mcu7t3v3__tiel_4
Xmesh_tile_848 VDD VDD VSS VSS ne_out[20] gf180mcu_as_sc_mcu7t3v3__tiel_4
Xmesh_tile_837 VDD VDD VSS VSS ne_out[9] gf180mcu_as_sc_mcu7t3v3__tiel_4
X_3093_ VDD VDD VSS VSS _3093_/S _3093_/B _4480_/Q _4480_/D gf180mcu_as_sc_mcu7t3v3__mux2_2
XPHY_EDGE_ROW_28_3_Right_69 VDD VSS gf180mcu_as_sc_mcu7t3v3__tap_2
XFILLER_165_1212 VDD VDD VSS VSS gf180mcu_as_sc_mcu7t3v3__fill_1
XFILLER_78_1264 VDD VDD VSS VSS gf180mcu_as_sc_mcu7t3v3__fillcap_4
XPHY_EDGE_ROW_93_1_Right_602 VDD VSS gf180mcu_as_sc_mcu7t3v3__tap_2
XFILLER_165_1278 VDD VDD VSS VSS gf180mcu_as_sc_mcu7t3v3__fill_1
XFILLER_165_1289 VDD VDD VSS VSS gf180mcu_as_sc_mcu7t3v3__fillcap_16
X_3995_ VDD VDD VSS VSS _3998_/A _4259_/D gf180mcu_as_sc_mcu7t3v3__inv_2
XPHY_EDGE_ROW_62_1_Left_254 VDD VSS gf180mcu_as_sc_mcu7t3v3__tap_2
X_2946_ VDD VDD VSS VSS _2990_/A _2974_/A _3021_/A gf180mcu_as_sc_mcu7t3v3__and2_2
X_2877_ VDD VDD VSS VSS _4191_/A _2916_/B _2877_/C _2877_/D _2878_/C gf180mcu_as_sc_mcu7t3v3__ao211_2
XFILLER_175_263 VDD VDD VSS VSS gf180mcu_as_sc_mcu7t3v3__fill_1
XFILLER_175_274 VDD VDD VSS VSS gf180mcu_as_sc_mcu7t3v3__fillcap_4
X_4616_ VDD VDD VSS VSS _4828_/CLK _4616_/D _4616_/Q gf180mcu_as_sc_mcu7t3v3__dfxtp_2
XFILLER_102_1273 VDD VDD VSS VSS gf180mcu_as_sc_mcu7t3v3__fillcap_16
XFILLER_11_1134 VDD VDD VSS VSS gf180mcu_as_sc_mcu7t3v3__fillcap_8
XFILLER_159_1049 VDD VDD VSS VSS gf180mcu_as_sc_mcu7t3v3__fill_1
XFILLER_175_296 VDD VDD VSS VSS gf180mcu_as_sc_mcu7t3v3__fill_1
XFILLER_190_233 VDD VDD VSS VSS gf180mcu_as_sc_mcu7t3v3__fill_1
XFILLER_191_778 VDD VDD VSS VSS gf180mcu_as_sc_mcu7t3v3__fill_1
XFILLER_102_1295 VDD VDD VSS VSS gf180mcu_as_sc_mcu7t3v3__fill_2
XFILLER_11_1178 VDD VDD VSS VSS gf180mcu_as_sc_mcu7t3v3__fill_2
XFILLER_176_1352 VDD VDD VSS VSS gf180mcu_as_sc_mcu7t3v3__fill_2
X_4547_ VDD VDD VSS VSS _4720_/CLK _4547_/D _4547_/Q gf180mcu_as_sc_mcu7t3v3__dfxtp_2
XFILLER_171_480 VDD VDD VSS VSS gf180mcu_as_sc_mcu7t3v3__fill_2
X_4478_ VDD VDD VSS VSS _4829_/CLK _4478_/D _4478_/Q gf180mcu_as_sc_mcu7t3v3__dfxtp_2
XPHY_EDGE_ROW_145_3_Left_517 VDD VSS gf180mcu_as_sc_mcu7t3v3__tap_2
X_3429_ VDD VDD VSS VSS _4558_/Q _3443_/B _3444_/C _4557_/Q _4557_/D gf180mcu_as_sc_mcu7t3v3__ao22_2
XFILLER_38_58 VDD VDD VSS VSS gf180mcu_as_sc_mcu7t3v3__fillcap_8
Xclkbuf_leaf_28_clk_regs VDD VDD VSS VSS clkload1/A _4708_/CLK gf180mcu_as_sc_mcu7t3v3__clkbuff_12
XFILLER_173_6 VDD VDD VSS VSS gf180mcu_as_sc_mcu7t3v3__fillcap_16
XFILLER_96_1353 VDD VDD VSS VSS gf180mcu_as_sc_mcu7t3v3__fill_2
XFILLER_0_1092 VDD VDD VSS VSS gf180mcu_as_sc_mcu7t3v3__fill_1
XTAP_TAPCELL_ROW_12_927 VDD VSS gf180mcu_as_sc_mcu7t3v3__tap_2
XTAP_TAPCELL_ROW_12_916 VDD VSS gf180mcu_as_sc_mcu7t3v3__tap_2
XFILLER_186_34 VDD VDD VSS VSS gf180mcu_as_sc_mcu7t3v3__fill_1
XFILLER_167_786 VDD VDD VSS VSS gf180mcu_as_sc_mcu7t3v3__fill_2
XFILLER_182_712 VDD VDD VSS VSS gf180mcu_as_sc_mcu7t3v3__fillcap_8
XFILLER_119_72 VDD VDD VSS VSS gf180mcu_as_sc_mcu7t3v3__fillcap_4
XFILLER_181_222 VDD VDD VSS VSS gf180mcu_as_sc_mcu7t3v3__fill_1
XFILLER_5_435 VDD VDD VSS VSS gf180mcu_as_sc_mcu7t3v3__fillcap_4
XFILLER_6_947 VDD VDD VSS VSS gf180mcu_as_sc_mcu7t3v3__fillcap_4
XFILLER_119_83 VDD VDD VSS VSS gf180mcu_as_sc_mcu7t3v3__fillcap_4
XFILLER_119_94 VDD VDD VSS VSS gf180mcu_as_sc_mcu7t3v3__fillcap_8
XPHY_EDGE_ROW_77_3_Left_449 VDD VSS gf180mcu_as_sc_mcu7t3v3__tap_2
XTAP_TAPCELL_ROW_169_1448 VDD VSS gf180mcu_as_sc_mcu7t3v3__tap_2
XFILLER_48_100 VDD VDD VSS VSS gf180mcu_as_sc_mcu7t3v3__fillcap_4
XTAP_TAPCELL_ROW_169_1459 VDD VSS gf180mcu_as_sc_mcu7t3v3__tap_2
XFILLER_118_1291 VDD VDD VSS VSS gf180mcu_as_sc_mcu7t3v3__fillcap_4
XFILLER_7_1268 VDD VDD VSS VSS gf180mcu_as_sc_mcu7t3v3__fill_1
XTAP_TAPCELL_ROW_186_1784 VDD VSS gf180mcu_as_sc_mcu7t3v3__tap_2
XTAP_TAPCELL_ROW_186_1773 VDD VSS gf180mcu_as_sc_mcu7t3v3__tap_2
XFILLER_188_1223 VDD VDD VSS VSS gf180mcu_as_sc_mcu7t3v3__fill_2
XFILLER_189_399 VDD VDD VSS VSS gf180mcu_as_sc_mcu7t3v3__fill_2
X_3780_ VDD VDD VSS VSS _3782_/C _4126_/A _3881_/C _3780_/C gf180mcu_as_sc_mcu7t3v3__ao21_2
X_2800_ VDD VDD VSS VSS _2903_/B _4126_/A _2804_/C gf180mcu_as_sc_mcu7t3v3__and2_2
XFILLER_160_1153 VDD VDD VSS VSS gf180mcu_as_sc_mcu7t3v3__fill_2
X_2731_ VDD VDD VSS VSS _4064_/A _2917_/B _2731_/C _2731_/D _2732_/C gf180mcu_as_sc_mcu7t3v3__ao211_2
XTAP_TAPCELL_ROW_140_3_2051 VDD VSS gf180mcu_as_sc_mcu7t3v3__tap_2
XFILLER_172_244 VDD VDD VSS VSS gf180mcu_as_sc_mcu7t3v3__fill_1
X_4401_ VDD VDD VSS VSS clkload8/A _4401_/D _4401_/Q gf180mcu_as_sc_mcu7t3v3__dfxtp_2
X_2662_ VDD VDD VSS VSS _2662_/A _2665_/A _2662_/C _2662_/Y gf180mcu_as_sc_mcu7t3v3__nor3_2
XFILLER_172_255 VDD VDD VSS VSS gf180mcu_as_sc_mcu7t3v3__fill_2
X_2593_ VDD VDD VSS VSS _3920_/A _3911_/A _4268_/A _3994_/A gf180mcu_as_sc_mcu7t3v3__nor3_2
XFILLER_5_51 VDD VDD VSS VSS gf180mcu_as_sc_mcu7t3v3__fill_1
X_4332_ VDD VDD VSS VSS _4795_/CLK _4332_/D _4332_/Q gf180mcu_as_sc_mcu7t3v3__dfxtp_2
X_4263_ VDD VDD VSS VSS _4263_/A _4263_/B _4263_/C _4263_/D _4265_/C gf180mcu_as_sc_mcu7t3v3__ao22_2
XFILLER_39_100 VDD VDD VSS VSS gf180mcu_as_sc_mcu7t3v3__fillcap_4
X_3214_ VDD VDD VSS VSS _3215_/A _5074_/A _3405_/B _3214_/C gf180mcu_as_sc_mcu7t3v3__ao21_2
XFILLER_45_1274 VDD VDD VSS VSS gf180mcu_as_sc_mcu7t3v3__fillcap_4
XFILLER_45_1285 VDD VDD VSS VSS gf180mcu_as_sc_mcu7t3v3__fillcap_8
X_4194_ VDD VDD VSS VSS _4194_/A _4227_/C _4194_/C _4194_/D _4195_/C gf180mcu_as_sc_mcu7t3v3__ao211_2
X_3145_ VDD VDD VSS VSS _4503_/Q _4506_/Q _3145_/C _3148_/B gf180mcu_as_sc_mcu7t3v3__nor3_2
XFILLER_132_1288 VDD VDD VSS VSS gf180mcu_as_sc_mcu7t3v3__fill_1
X_3076_ VDD VDD VSS VSS _3079_/S _3520_/B _4474_/Q _4474_/D gf180mcu_as_sc_mcu7t3v3__mux2_2
XFILLER_167_1329 VDD VDD VSS VSS gf180mcu_as_sc_mcu7t3v3__fill_1
XPHY_EDGE_ROW_94_1_Right_603 VDD VSS gf180mcu_as_sc_mcu7t3v3__tap_2
XFILLER_24_27 VDD VDD VSS VSS gf180mcu_as_sc_mcu7t3v3__fillcap_8
XFILLER_24_49 VDD VDD VSS VSS gf180mcu_as_sc_mcu7t3v3__fill_1
X_3978_ VDD VDD VSS VSS _3978_/B _3978_/A _3989_/B gf180mcu_as_sc_mcu7t3v3__or2_2
X_2929_ VDD VDD VSS VSS _4363_/Q _2945_/C _3011_/A _2945_/B _4363_/D gf180mcu_as_sc_mcu7t3v3__ao22_2
XFILLER_91_1294 VDD VDD VSS VSS gf180mcu_as_sc_mcu7t3v3__fillcap_4
XFILLER_163_244 VDD VDD VSS VSS gf180mcu_as_sc_mcu7t3v3__fillcap_4
XFILLER_40_37 VDD VDD VSS VSS gf180mcu_as_sc_mcu7t3v3__fillcap_16
XFILLER_156_37 VDD VDD VSS VSS gf180mcu_as_sc_mcu7t3v3__fillcap_16
XFILLER_163_277 VDD VDD VSS VSS gf180mcu_as_sc_mcu7t3v3__fill_2
XFILLER_3_928 VDD VDD VSS VSS gf180mcu_as_sc_mcu7t3v3__fillcap_16
XTAP_TAPCELL_ROW_75_3_1986 VDD VSS gf180mcu_as_sc_mcu7t3v3__tap_2
XFILLER_49_68 VDD VDD VSS VSS gf180mcu_as_sc_mcu7t3v3__fill_2
Xfanout731 VDD VDD VSS VSS _4452_/Q _2339_/C gf180mcu_as_sc_mcu7t3v3__buff_12
Xfanout742 VDD VDD VSS VSS fanout743/Y _3409_/A gf180mcu_as_sc_mcu7t3v3__buff_12
XFILLER_150_1311 VDD VDD VSS VSS gf180mcu_as_sc_mcu7t3v3__fill_2
XFILLER_150_1322 VDD VDD VSS VSS gf180mcu_as_sc_mcu7t3v3__fill_1
Xfanout753 VDD VDD VSS VSS _4448_/Q _3351_/A gf180mcu_as_sc_mcu7t3v3__buff_12
Xfanout764 VDD VDD VSS VSS _4292_/A _4213_/A gf180mcu_as_sc_mcu7t3v3__buff_12
Xfanout786 VDD VDD VSS VSS input33/Y _2478_/A gf180mcu_as_sc_mcu7t3v3__buff_12
XTAP_TAPCELL_ROW_6_799 VDD VSS gf180mcu_as_sc_mcu7t3v3__tap_2
XTAP_TAPCELL_ROW_164_1367 VDD VSS gf180mcu_as_sc_mcu7t3v3__tap_2
XTAP_TAPCELL_ROW_164_1356 VDD VSS gf180mcu_as_sc_mcu7t3v3__tap_2
XFILLER_65_78 VDD VDD VSS VSS gf180mcu_as_sc_mcu7t3v3__fill_1
XFILLER_65_89 VDD VDD VSS VSS gf180mcu_as_sc_mcu7t3v3__fillcap_16
XTAP_TAPCELL_ROW_181_1681 VDD VSS gf180mcu_as_sc_mcu7t3v3__tap_2
XFILLER_164_2 VDD VDD VSS VSS gf180mcu_as_sc_mcu7t3v3__fillcap_16
XTAP_TAPCELL_ROW_181_1692 VDD VSS gf180mcu_as_sc_mcu7t3v3__tap_2
XFILLER_148_1284 VDD VDD VSS VSS gf180mcu_as_sc_mcu7t3v3__fillcap_4
XFILLER_183_1175 VDD VDD VSS VSS gf180mcu_as_sc_mcu7t3v3__fillcap_8
XFILLER_186_303 VDD VDD VSS VSS gf180mcu_as_sc_mcu7t3v3__fillcap_8
XFILLER_109_1268 VDD VDD VSS VSS gf180mcu_as_sc_mcu7t3v3__fill_2
XFILLER_167_550 VDD VDD VSS VSS gf180mcu_as_sc_mcu7t3v3__fillcap_8
XFILLER_186_347 VDD VDD VSS VSS gf180mcu_as_sc_mcu7t3v3__fillcap_16
XFILLER_10_795 VDD VDD VSS VSS gf180mcu_as_sc_mcu7t3v3__fill_2
XFILLER_154_233 VDD VDD VSS VSS gf180mcu_as_sc_mcu7t3v3__fill_2
XFILLER_182_531 VDD VDD VSS VSS gf180mcu_as_sc_mcu7t3v3__fill_2
XFILLER_154_277 VDD VDD VSS VSS gf180mcu_as_sc_mcu7t3v3__fillcap_8
XFILLER_154_299 VDD VDD VSS VSS gf180mcu_as_sc_mcu7t3v3__fillcap_4
XFILLER_170_737 VDD VDD VSS VSS gf180mcu_as_sc_mcu7t3v3__fill_2
XFILLER_182_597 VDD VDD VSS VSS gf180mcu_as_sc_mcu7t3v3__fillcap_16
XTAP_TAPCELL_ROW_188_1824 VDD VSS gf180mcu_as_sc_mcu7t3v3__tap_2
XTAP_TAPCELL_ROW_188_1813 VDD VSS gf180mcu_as_sc_mcu7t3v3__tap_2
XFILLER_190_1157 VDD VDD VSS VSS gf180mcu_as_sc_mcu7t3v3__fillcap_4
XFILLER_7_1043 VDD VDD VSS VSS gf180mcu_as_sc_mcu7t3v3__fill_1
Xinput8 VDD VDD VSS VSS boot_addr[6] input8/Y gf180mcu_as_sc_mcu7t3v3__buff_12
XFILLER_178_804 VDD VDD VSS VSS gf180mcu_as_sc_mcu7t3v3__fill_1
XFILLER_75_1256 VDD VDD VSS VSS gf180mcu_as_sc_mcu7t3v3__fillcap_16
X_3901_ VDD VDD VSS VSS _3901_/A _3926_/B _3901_/C _3926_/D _3902_/D gf180mcu_as_sc_mcu7t3v3__ao22_2
X_3832_ VDD VDD VSS VSS _3833_/D _4174_/A _3870_/A _3832_/C gf180mcu_as_sc_mcu7t3v3__ao21_2
XFILLER_177_347 VDD VDD VSS VSS gf180mcu_as_sc_mcu7t3v3__fill_2
X_3763_ VDD VDD VSS VSS _3763_/D _3796_/B _3763_/B _3763_/C _3764_/D gf180mcu_as_sc_mcu7t3v3__ao31_2
X_3694_ VDD VDD VSS VSS _3694_/B _3748_/A _4662_/D gf180mcu_as_sc_mcu7t3v3__and2_2
X_2714_ VDD VDD VSS VSS _4048_/A _2904_/B _2714_/C _2900_/B _2716_/C gf180mcu_as_sc_mcu7t3v3__ao211_2
X_2645_ VDD VDD VSS VSS _3633_/A _3957_/B _4269_/B gf180mcu_as_sc_mcu7t3v3__and2_2
XFILLER_156_1019 VDD VDD VSS VSS gf180mcu_as_sc_mcu7t3v3__fill_1
X_4732__1040 VDD VDD VSS VSS _4732_/D gf180mcu_as_sc_mcu7t3v3__tiel_4
Xoutput334 VDD VDD VSS VSS _5070_/Y dft_rdata[1] gf180mcu_as_sc_mcu7t3v3__buff_12
XFILLER_160_247 VDD VDD VSS VSS gf180mcu_as_sc_mcu7t3v3__fill_1
Xoutput378 VDD VDD VSS VSS _4667_/Q south_out[10] gf180mcu_as_sc_mcu7t3v3__buff_12
Xoutput367 VDD VDD VSS VSS _4726_/Q east_out[33] gf180mcu_as_sc_mcu7t3v3__buff_12
Xoutput356 VDD VDD VSS VSS _4716_/Q east_out[23] gf180mcu_as_sc_mcu7t3v3__buff_12
Xoutput345 VDD VDD VSS VSS _4706_/Q east_out[13] gf180mcu_as_sc_mcu7t3v3__buff_12
X_4315_ VDD VDD VSS VSS _4804_/D _4539_/Q _4792_/D gf180mcu_as_sc_mcu7t3v3__and2_2
X_2576_ VDD VDD VSS VSS _3520_/B _3585_/A _2585_/B gf180mcu_as_sc_mcu7t3v3__and2_2
Xoutput389 VDD VDD VSS VSS _4677_/Q south_out[20] gf180mcu_as_sc_mcu7t3v3__buff_12
X_4246_ VDD VDD VSS VSS _4246_/A _4264_/C _4246_/C _4246_/D _4248_/C gf180mcu_as_sc_mcu7t3v3__ao211_2
X_4177_ VDD VDD VSS VSS _4177_/A _4210_/B _4177_/C _4177_/D _4178_/C gf180mcu_as_sc_mcu7t3v3__ao211_2
X_3128_ VDD VDD VSS VSS _4624_/Q _3128_/A _3129_/C gf180mcu_as_sc_mcu7t3v3__and2_2
XTAP_TAPCELL_ROW_3_747 VDD VSS gf180mcu_as_sc_mcu7t3v3__tap_2
X_3059_ VDD VDD VSS VSS _3062_/S _3520_/B _4458_/Q _4458_/D gf180mcu_as_sc_mcu7t3v3__mux2_2
XFILLER_169_804 VDD VDD VSS VSS gf180mcu_as_sc_mcu7t3v3__fillcap_4
XFILLER_168_314 VDD VDD VSS VSS gf180mcu_as_sc_mcu7t3v3__fill_1
XFILLER_169_837 VDD VDD VSS VSS gf180mcu_as_sc_mcu7t3v3__fill_2
XFILLER_180_1315 VDD VDD VSS VSS gf180mcu_as_sc_mcu7t3v3__fill_1
XPHY_EDGE_ROW_95_1_Right_604 VDD VSS gf180mcu_as_sc_mcu7t3v3__tap_2
XFILLER_156_509 VDD VDD VSS VSS gf180mcu_as_sc_mcu7t3v3__fill_2
XFILLER_184_807 VDD VDD VSS VSS gf180mcu_as_sc_mcu7t3v3__fill_1
XFILLER_177_881 VDD VDD VSS VSS gf180mcu_as_sc_mcu7t3v3__fill_2
XPHY_EDGE_ROW_25_1_Left_217 VDD VSS gf180mcu_as_sc_mcu7t3v3__tap_2
XFILLER_116_73 VDD VDD VSS VSS gf180mcu_as_sc_mcu7t3v3__fillcap_4
XFILLER_76_33 VDD VDD VSS VSS gf180mcu_as_sc_mcu7t3v3__fill_2
XTAP_TAPCELL_ROW_166_1407 VDD VSS gf180mcu_as_sc_mcu7t3v3__tap_2
XFILLER_28_1291 VDD VDD VSS VSS gf180mcu_as_sc_mcu7t3v3__fillcap_4
Xfanout561 VDD VDD VSS VSS _4294_/Y _4326_/B gf180mcu_as_sc_mcu7t3v3__buff_12
Xfanout572 VDD VDD VSS VSS _3411_/B _3395_/B gf180mcu_as_sc_mcu7t3v3__buff_12
Xfanout583 VDD VDD VSS VSS _2418_/A _2492_/B gf180mcu_as_sc_mcu7t3v3__buff_12
XTAP_TAPCELL_ROW_23_3_1934 VDD VSS gf180mcu_as_sc_mcu7t3v3__tap_2
XTAP_TAPCELL_ROW_183_1732 VDD VSS gf180mcu_as_sc_mcu7t3v3__tap_2
XTAP_TAPCELL_ROW_183_1721 VDD VSS gf180mcu_as_sc_mcu7t3v3__tap_2
XFILLER_115_1272 VDD VDD VSS VSS gf180mcu_as_sc_mcu7t3v3__fill_2
XFILLER_76_99 VDD VDD VSS VSS gf180mcu_as_sc_mcu7t3v3__fillcap_4
Xfanout594 VDD VDD VSS VSS _3444_/C _3439_/C gf180mcu_as_sc_mcu7t3v3__buff_12
XFILLER_132_72 VDD VDD VSS VSS gf180mcu_as_sc_mcu7t3v3__fill_2
XFILLER_185_1215 VDD VDD VSS VSS gf180mcu_as_sc_mcu7t3v3__fill_2
XFILLER_98_1256 VDD VDD VSS VSS gf180mcu_as_sc_mcu7t3v3__fillcap_16
XFILLER_186_111 VDD VDD VSS VSS gf180mcu_as_sc_mcu7t3v3__fill_2
XFILLER_187_623 VDD VDD VSS VSS gf180mcu_as_sc_mcu7t3v3__fill_1
XFILLER_174_317 VDD VDD VSS VSS gf180mcu_as_sc_mcu7t3v3__fillcap_16
XFILLER_186_177 VDD VDD VSS VSS gf180mcu_as_sc_mcu7t3v3__fillcap_16
XFILLER_167_380 VDD VDD VSS VSS gf180mcu_as_sc_mcu7t3v3__fill_2
XFILLER_35_1295 VDD VDD VSS VSS gf180mcu_as_sc_mcu7t3v3__fill_1
Xmax_cap706 VDD VDD VSS VSS _5076_/A _3585_/B gf180mcu_as_sc_mcu7t3v3__clkbuff_12
X_2430_ VDD VDD VSS VSS _3051_/A _4453_/Q _2430_/Y gf180mcu_as_sc_mcu7t3v3__and2_2
XPHY_EDGE_ROW_37_3_Right_78 VDD VSS gf180mcu_as_sc_mcu7t3v3__tap_2
X_2361_ VDD VDD VSS VSS _2369_/B _4586_/Q _4584_/Q gf180mcu_as_sc_mcu7t3v3__nand2b_2
X_4100_ VDD VDD VSS VSS _4100_/A _4214_/B _4214_/C _4100_/D _4101_/D gf180mcu_as_sc_mcu7t3v3__ao22_2
X_2292_ VDD VDD VSS VSS _2292_/B _2292_/A _2293_/A gf180mcu_as_sc_mcu7t3v3__xnor2_2
XPHY_EDGE_ROW_71_1_Left_263 VDD VSS gf180mcu_as_sc_mcu7t3v3__tap_2
X_4031_ VDD VDD VSS VSS _4031_/A _4218_/B _4225_/B _4031_/D _4032_/D gf180mcu_as_sc_mcu7t3v3__ao22_2
XFILLER_42_1299 VDD VDD VSS VSS gf180mcu_as_sc_mcu7t3v3__fill_2
XTAP_TAPCELL_ROW_127_3_2038 VDD VSS gf180mcu_as_sc_mcu7t3v3__tap_2
XFILLER_166_1192 VDD VDD VSS VSS gf180mcu_as_sc_mcu7t3v3__fillcap_16
XANTENNA_13 VDD VDD VSS VSS _2413_/C gf180mcu_as_sc_mcu7t3v3__diode_2
XFILLER_166_807 VDD VDD VSS VSS gf180mcu_as_sc_mcu7t3v3__fill_1
XFILLER_177_133 VDD VDD VSS VSS gf180mcu_as_sc_mcu7t3v3__fillcap_4
XFILLER_178_667 VDD VDD VSS VSS gf180mcu_as_sc_mcu7t3v3__fillcap_8
XANTENNA_24 VDD VDD VSS VSS _4035_/B gf180mcu_as_sc_mcu7t3v3__diode_2
XANTENNA_35 VDD VDD VSS VSS _4091_/B gf180mcu_as_sc_mcu7t3v3__diode_2
XANTENNA_46 VDD VDD VSS VSS _4228_/A gf180mcu_as_sc_mcu7t3v3__diode_2
XANTENNA_57 VDD VDD VSS VSS _4136_/D gf180mcu_as_sc_mcu7t3v3__diode_2
XFILLER_14_1302 VDD VDD VSS VSS gf180mcu_as_sc_mcu7t3v3__fill_2
X_4795_ VDD VDD VSS VSS _4795_/CLK _4795_/D _4795_/Q gf180mcu_as_sc_mcu7t3v3__dfxtp_2
X_3815_ VDD VDD VSS VSS _4157_/D _3869_/C _3815_/C _3815_/D _3816_/C gf180mcu_as_sc_mcu7t3v3__ao22_2
XANTENNA_68 VDD VDD VSS VSS _4033_/A gf180mcu_as_sc_mcu7t3v3__diode_2
X_3746_ VDD VDD VSS VSS _4097_/A _3800_/B _3746_/C _3746_/D _3747_/B gf180mcu_as_sc_mcu7t3v3__ao211_2
XFILLER_174_873 VDD VDD VSS VSS gf180mcu_as_sc_mcu7t3v3__fill_2
XFILLER_173_394 VDD VDD VSS VSS gf180mcu_as_sc_mcu7t3v3__fillcap_4
X_3677_ VDD VDD VSS VSS _3794_/B _4036_/D _3678_/C gf180mcu_as_sc_mcu7t3v3__and2_2
X_2628_ VDD VDD VSS VSS _2663_/B _2629_/D _3987_/A gf180mcu_as_sc_mcu7t3v3__nand2_2
XFILLER_138_1272 VDD VDD VSS VSS gf180mcu_as_sc_mcu7t3v3__fillcap_16
X_2559_ VDD VDD VSS VSS _2562_/A _3131_/B _2560_/B gf180mcu_as_sc_mcu7t3v3__or2_2
XTAP_TAPCELL_ROW_8_839 VDD VSS gf180mcu_as_sc_mcu7t3v3__tap_2
XFILLER_101_100 VDD VDD VSS VSS gf180mcu_as_sc_mcu7t3v3__fillcap_4
X_4229_ VDD VDD VSS VSS _4229_/D _4238_/S _4229_/B _4229_/C _4230_/C gf180mcu_as_sc_mcu7t3v3__ao31_2
XTAP_TAPCELL_ROW_161_1304 VDD VSS gf180mcu_as_sc_mcu7t3v3__tap_2
XPHY_EDGE_ROW_86_3_Left_458 VDD VSS gf180mcu_as_sc_mcu7t3v3__tap_2
XPHY_EDGE_ROW_80_3_Right_121 VDD VSS gf180mcu_as_sc_mcu7t3v3__tap_2
XFILLER_58_1262 VDD VDD VSS VSS gf180mcu_as_sc_mcu7t3v3__fill_2
XFILLER_184_1292 VDD VDD VSS VSS gf180mcu_as_sc_mcu7t3v3__fill_2
XPHY_EDGE_ROW_96_1_Right_605 VDD VSS gf180mcu_as_sc_mcu7t3v3__tap_2
XFILLER_11_345 VDD VDD VSS VSS gf180mcu_as_sc_mcu7t3v3__fillcap_4
XTAP_TAPCELL_ROW_159_1266 VDD VSS gf180mcu_as_sc_mcu7t3v3__tap_2
XFILLER_156_328 VDD VDD VSS VSS gf180mcu_as_sc_mcu7t3v3__fill_2
XTAP_TAPCELL_ROW_176_1591 VDD VSS gf180mcu_as_sc_mcu7t3v3__tap_2
XFILLER_11_50 VDD VDD VSS VSS gf180mcu_as_sc_mcu7t3v3__fill_1
XFILLER_152_512 VDD VDD VSS VSS gf180mcu_as_sc_mcu7t3v3__fillcap_16
XFILLER_11_72 VDD VDD VSS VSS gf180mcu_as_sc_mcu7t3v3__fillcap_16
XFILLER_127_72 VDD VDD VSS VSS gf180mcu_as_sc_mcu7t3v3__fillcap_16
XFILLER_87_54 VDD VDD VSS VSS gf180mcu_as_sc_mcu7t3v3__fillcap_4
XFILLER_143_82 VDD VDD VSS VSS gf180mcu_as_sc_mcu7t3v3__fill_1
XFILLER_189_1192 VDD VDD VSS VSS gf180mcu_as_sc_mcu7t3v3__fillcap_8
XFILLER_185_1045 VDD VDD VSS VSS gf180mcu_as_sc_mcu7t3v3__fillcap_4
XFILLER_185_1056 VDD VDD VSS VSS gf180mcu_as_sc_mcu7t3v3__fill_2
XFILLER_163_1310 VDD VDD VSS VSS gf180mcu_as_sc_mcu7t3v3__fillcap_16
XFILLER_163_1332 VDD VDD VSS VSS gf180mcu_as_sc_mcu7t3v3__fillcap_16
XFILLER_188_932 VDD VDD VSS VSS gf180mcu_as_sc_mcu7t3v3__fillcap_4
X_4580_ VDD VDD VSS VSS _4831_/CLK _4580_/D _4580_/Q gf180mcu_as_sc_mcu7t3v3__dfxtp_2
Xinput11 VDD VDD VSS VSS boot_addr[9] _2427_/A gf180mcu_as_sc_mcu7t3v3__buff_12
Xinput22 VDD VDD VSS VSS dft_addr[0] _2352_/B gf180mcu_as_sc_mcu7t3v3__buff_12
X_3600_ VDD VDD VSS VSS _3602_/C _3600_/A _3604_/B gf180mcu_as_sc_mcu7t3v3__or2_2
XFILLER_162_309 VDD VDD VSS VSS gf180mcu_as_sc_mcu7t3v3__fillcap_4
XFILLER_174_169 VDD VDD VSS VSS gf180mcu_as_sc_mcu7t3v3__fillcap_4
Xinput33 VDD VDD VSS VSS dft_ce input33/Y gf180mcu_as_sc_mcu7t3v3__buff_12
Xinput44 VDD VDD VSS VSS east_in[0] _3990_/D gf180mcu_as_sc_mcu7t3v3__buff_12
Xinput55 VDD VDD VSS VSS east_in[1] _4012_/D gf180mcu_as_sc_mcu7t3v3__buff_12
Xwire770 VDD VDD VSS VSS wire770/A _4077_/D gf180mcu_as_sc_mcu7t3v3__clkbuff_12
X_3531_ VDD VDD VSS VSS _3539_/S _4611_/Q _4612_/Q _3532_/B gf180mcu_as_sc_mcu7t3v3__mux2_2
XFILLER_156_895 VDD VDD VSS VSS gf180mcu_as_sc_mcu7t3v3__fill_1
XFILLER_183_670 VDD VDD VSS VSS gf180mcu_as_sc_mcu7t3v3__fillcap_16
Xinput66 VDD VDD VSS VSS east_in[2] _4020_/D gf180mcu_as_sc_mcu7t3v3__buff_12
Xinput77 VDD VDD VSS VSS east_in[7] _4060_/D gf180mcu_as_sc_mcu7t3v3__buff_12
Xinput88 VDD VDD VSS VSS ne_in[17] _4143_/A gf180mcu_as_sc_mcu7t3v3__buff_12
XFILLER_170_342 VDD VDD VSS VSS gf180mcu_as_sc_mcu7t3v3__fillcap_16
Xinput99 VDD VDD VSS VSS ne_in[27] _4227_/A gf180mcu_as_sc_mcu7t3v3__buff_12
X_3462_ VDD VDD VSS VSS _3600_/A _4460_/Q _4585_/Q _4585_/D gf180mcu_as_sc_mcu7t3v3__mux2_2
XFILLER_83_1322 VDD VDD VSS VSS gf180mcu_as_sc_mcu7t3v3__fill_2
X_3393_ VDD VDD VSS VSS _3394_/C _3393_/C _4411_/Q _3393_/A gf180mcu_as_sc_mcu7t3v3__aoi21b_2
X_2413_ VDD VDD VSS VSS _2418_/A _2413_/B _2413_/C _2418_/D _2415_/C gf180mcu_as_sc_mcu7t3v3__ao211_2
Xclkbuf_1_0__f_clk VDD VDD VSS VSS clkbuf_0_clk/Y clkbuf_1_0__f_clk/Y gf180mcu_as_sc_mcu7t3v3__clkbuff_12
X_2344_ VDD VDD VSS VSS _2493_/B _2344_/B _2393_/C _2345_/A gf180mcu_as_sc_mcu7t3v3__mux2_2
X_2275_ VDD VDD VSS VSS _3572_/B _3458_/A _3084_/A gf180mcu_as_sc_mcu7t3v3__or2_2
XFILLER_168_1210 VDD VDD VSS VSS gf180mcu_as_sc_mcu7t3v3__fill_1
X_4014_ VDD VDD VSS VSS _4016_/C _4216_/A _4014_/B _4014_/C gf180mcu_as_sc_mcu7t3v3__ao21_2
XFILLER_168_1221 VDD VDD VSS VSS gf180mcu_as_sc_mcu7t3v3__fillcap_4
XPHY_EDGE_ROW_9_Left_202 VDD VSS gf180mcu_as_sc_mcu7t3v3__tap_2
XFILLER_164_1129 VDD VDD VSS VSS gf180mcu_as_sc_mcu7t3v3__fillcap_4
XFILLER_178_486 VDD VDD VSS VSS gf180mcu_as_sc_mcu7t3v3__fillcap_4
XFILLER_179_998 VDD VDD VSS VSS gf180mcu_as_sc_mcu7t3v3__fillcap_4
XFILLER_166_637 VDD VDD VSS VSS gf180mcu_as_sc_mcu7t3v3__fillcap_16
XFILLER_105_1260 VDD VDD VSS VSS gf180mcu_as_sc_mcu7t3v3__fill_2
XFILLER_165_158 VDD VDD VSS VSS gf180mcu_as_sc_mcu7t3v3__fillcap_16
X_4778_ VDD VDD VSS VSS _4783_/CLK _4778_/D _4778_/Q gf180mcu_as_sc_mcu7t3v3__dfxtp_2
X_3729_ VDD VDD VSS VSS _4079_/A _3800_/B _3729_/C _3730_/C _3855_/B gf180mcu_as_sc_mcu7t3v3__aoi211_2
XTAP_TAPCELL_ROW_154_1174 VDD VSS gf180mcu_as_sc_mcu7t3v3__tap_2
XTAP_TAPCELL_ROW_154_1163 VDD VSS gf180mcu_as_sc_mcu7t3v3__tap_2
XFILLER_162_854 VDD VDD VSS VSS gf180mcu_as_sc_mcu7t3v3__fillcap_4
XFILLER_175_1247 VDD VDD VSS VSS gf180mcu_as_sc_mcu7t3v3__fillcap_8
XFILLER_164_37 VDD VDD VSS VSS gf180mcu_as_sc_mcu7t3v3__fillcap_8
XFILLER_112_1286 VDD VDD VSS VSS gf180mcu_as_sc_mcu7t3v3__fill_2
XFILLER_113_96 VDD VDD VSS VSS gf180mcu_as_sc_mcu7t3v3__fillcap_8
XPHY_EDGE_ROW_81_3_Right_122 VDD VSS gf180mcu_as_sc_mcu7t3v3__tap_2
XTAP_TAPCELL_ROW_178_1631 VDD VSS gf180mcu_as_sc_mcu7t3v3__tap_2
XTAP_TAPCELL_ROW_178_1620 VDD VSS gf180mcu_as_sc_mcu7t3v3__tap_2
XFILLER_12_632 VDD VDD VSS VSS gf180mcu_as_sc_mcu7t3v3__fill_1
XFILLER_157_626 VDD VDD VSS VSS gf180mcu_as_sc_mcu7t3v3__fillcap_4
XFILLER_185_902 VDD VDD VSS VSS gf180mcu_as_sc_mcu7t3v3__fillcap_8
XPHY_EDGE_ROW_97_1_Right_606 VDD VSS gf180mcu_as_sc_mcu7t3v3__tap_2
XFILLER_8_636 VDD VDD VSS VSS gf180mcu_as_sc_mcu7t3v3__fill_2
XFILLER_11_175 VDD VDD VSS VSS gf180mcu_as_sc_mcu7t3v3__fillcap_8
XFILLER_185_979 VDD VDD VSS VSS gf180mcu_as_sc_mcu7t3v3__fill_1
XFILLER_7_146 VDD VDD VSS VSS gf180mcu_as_sc_mcu7t3v3__fill_2
XFILLER_172_629 VDD VDD VSS VSS gf180mcu_as_sc_mcu7t3v3__fillcap_16
XFILLER_184_489 VDD VDD VSS VSS gf180mcu_as_sc_mcu7t3v3__fillcap_16
XTAP_TAPCELL_ROW_191_1875 VDD VSS gf180mcu_as_sc_mcu7t3v3__tap_2
XTAP_TAPCELL_ROW_10_877 VDD VSS gf180mcu_as_sc_mcu7t3v3__tap_2
XFILLER_152_342 VDD VDD VSS VSS gf180mcu_as_sc_mcu7t3v3__fillcap_16
XFILLER_153_854 VDD VDD VSS VSS gf180mcu_as_sc_mcu7t3v3__fill_1
XFILLER_171_139 VDD VDD VSS VSS gf180mcu_as_sc_mcu7t3v3__fill_1
XTAP_TAPCELL_ROW_10_888 VDD VSS gf180mcu_as_sc_mcu7t3v3__tap_2
XFILLER_98_64 VDD VDD VSS VSS gf180mcu_as_sc_mcu7t3v3__fillcap_8
XFILLER_3_385 VDD VDD VSS VSS gf180mcu_as_sc_mcu7t3v3__fill_2
XFILLER_152_1022 VDD VDD VSS VSS gf180mcu_as_sc_mcu7t3v3__fill_2
XFILLER_154_81 VDD VDD VSS VSS gf180mcu_as_sc_mcu7t3v3__fillcap_16
XFILLER_6_1119 VDD VDD VSS VSS gf180mcu_as_sc_mcu7t3v3__fill_2
X_2962_ VDD VDD VSS VSS _4382_/Q _2965_/B _3030_/A _2965_/D _4382_/D gf180mcu_as_sc_mcu7t3v3__ao22_2
X_4701_ VDD VDD VSS VSS _4727_/CLK _4701_/D _4701_/Q gf180mcu_as_sc_mcu7t3v3__dfxtp_2
X_4632_ VDD VDD VSS VSS _4809_/CLK _4632_/D _4632_/Q gf180mcu_as_sc_mcu7t3v3__dfxtp_2
X_2893_ VDD VDD VSS VSS _2893_/B _4207_/D _2894_/D gf180mcu_as_sc_mcu7t3v3__and2_2
XFILLER_163_629 VDD VDD VSS VSS gf180mcu_as_sc_mcu7t3v3__fill_1
XFILLER_190_415 VDD VDD VSS VSS gf180mcu_as_sc_mcu7t3v3__fill_2
X_4563_ VDD VDD VSS VSS _4807_/CLK _4563_/D _4563_/Q gf180mcu_as_sc_mcu7t3v3__dfxtp_2
X_4494_ VDD VDD VSS VSS _4727_/CLK _4494_/D _4494_/Q gf180mcu_as_sc_mcu7t3v3__dfxtp_2
X_3514_ VDD VDD VSS VSS _3520_/S _3514_/B _4606_/Q _3515_/A gf180mcu_as_sc_mcu7t3v3__mux2_2
XFILLER_170_161 VDD VDD VSS VSS gf180mcu_as_sc_mcu7t3v3__fillcap_8
X_3445_ VDD VDD VSS VSS _4574_/Q _3445_/B _3449_/B _4573_/Q _4573_/D gf180mcu_as_sc_mcu7t3v3__ao22_2
XFILLER_170_183 VDD VDD VSS VSS gf180mcu_as_sc_mcu7t3v3__fill_1
X_3376_ VDD VDD VSS VSS _3394_/A _4380_/Q _4409_/Q _3377_/B gf180mcu_as_sc_mcu7t3v3__mux2_2
X_2327_ VDD VDD VSS VSS _2327_/A _3602_/B _2426_/C _2327_/D _2327_/Y gf180mcu_as_sc_mcu7t3v3__ao211_2
XFILLER_170_1199 VDD VDD VSS VSS gf180mcu_as_sc_mcu7t3v3__fillcap_16
X_2258_ VDD VDD VSS VSS _3566_/B _4624_/Q _3569_/B gf180mcu_as_sc_mcu7t3v3__and2_2
XFILLER_27_49 VDD VDD VSS VSS gf180mcu_as_sc_mcu7t3v3__fillcap_16
XPHY_EDGE_ROW_34_1_Left_226 VDD VSS gf180mcu_as_sc_mcu7t3v3__tap_2
X_2189_ VDD VDD VSS VSS _2189_/Y _4272_/C gf180mcu_as_sc_mcu7t3v3__inv_2
XFILLER_13_407 VDD VDD VSS VSS gf180mcu_as_sc_mcu7t3v3__fill_1
XFILLER_168_1084 VDD VDD VSS VSS gf180mcu_as_sc_mcu7t3v3__fill_1
XFILLER_0_1285 VDD VDD VSS VSS gf180mcu_as_sc_mcu7t3v3__fillcap_4
XFILLER_107_1300 VDD VDD VSS VSS gf180mcu_as_sc_mcu7t3v3__fillcap_8
XFILLER_94_1281 VDD VDD VSS VSS gf180mcu_as_sc_mcu7t3v3__fillcap_8
XFILLER_107_1322 VDD VDD VSS VSS gf180mcu_as_sc_mcu7t3v3__fill_2
XFILLER_181_1262 VDD VDD VSS VSS gf180mcu_as_sc_mcu7t3v3__fillcap_16
XFILLER_43_59 VDD VDD VSS VSS gf180mcu_as_sc_mcu7t3v3__fillcap_4
XFILLER_179_795 VDD VDD VSS VSS gf180mcu_as_sc_mcu7t3v3__fillcap_16
XFILLER_55_1298 VDD VDD VSS VSS gf180mcu_as_sc_mcu7t3v3__fill_1
XTAP_TAPCELL_ROW_156_1214 VDD VSS gf180mcu_as_sc_mcu7t3v3__tap_2
XTAP_TAPCELL_ROW_156_1203 VDD VSS gf180mcu_as_sc_mcu7t3v3__tap_2
XFILLER_153_139 VDD VDD VSS VSS gf180mcu_as_sc_mcu7t3v3__fill_1
XFILLER_175_1000 VDD VDD VSS VSS gf180mcu_as_sc_mcu7t3v3__fillcap_16
XFILLER_108_63 VDD VDD VSS VSS gf180mcu_as_sc_mcu7t3v3__fillcap_16
XFILLER_108_85 VDD VDD VSS VSS gf180mcu_as_sc_mcu7t3v3__fill_1
XFILLER_68_45 VDD VDD VSS VSS gf180mcu_as_sc_mcu7t3v3__fillcap_16
XFILLER_1_878 VDD VDD VSS VSS gf180mcu_as_sc_mcu7t3v3__fill_2
Xinput201 VDD VDD VSS VSS se_in[20] _4170_/A gf180mcu_as_sc_mcu7t3v3__buff_12
Xinput212 VDD VDD VSS VSS se_in[30] _3921_/A gf180mcu_as_sc_mcu7t3v3__buff_12
Xinput223 VDD VDD VSS VSS se_in[8] _4073_/A gf180mcu_as_sc_mcu7t3v3__buff_12
Xinput234 VDD VDD VSS VSS south_in[18] _4149_/A gf180mcu_as_sc_mcu7t3v3__buff_12
Xinput245 VDD VDD VSS VSS south_in[28] _4231_/A gf180mcu_as_sc_mcu7t3v3__buff_12
Xinput256 VDD VDD VSS VSS south_in[5] _4044_/A gf180mcu_as_sc_mcu7t3v3__buff_12
Xinput267 VDD VDD VSS VSS sw_in[15] _4130_/A gf180mcu_as_sc_mcu7t3v3__buff_12
Xinput278 VDD VDD VSS VSS sw_in[25] _4212_/A gf180mcu_as_sc_mcu7t3v3__buff_12
Xinput289 VDD VDD VSS VSS sw_in[35] _3957_/B gf180mcu_as_sc_mcu7t3v3__buff_12
XFILLER_90_104 VDD VDD VSS VSS gf180mcu_as_sc_mcu7t3v3__fill_1
XFILLER_5_1185 VDD VDD VSS VSS gf180mcu_as_sc_mcu7t3v3__fillcap_4
XPHY_EDGE_ROW_21_1_Right_530 VDD VSS gf180mcu_as_sc_mcu7t3v3__tap_2
XFILLER_140_61 VDD VDD VSS VSS gf180mcu_as_sc_mcu7t3v3__fill_1
XFILLER_189_515 VDD VDD VSS VSS gf180mcu_as_sc_mcu7t3v3__fill_1
XPHY_EDGE_ROW_46_3_Right_87 VDD VSS gf180mcu_as_sc_mcu7t3v3__tap_2
XFILLER_140_94 VDD VDD VSS VSS gf180mcu_as_sc_mcu7t3v3__fillcap_8
XTAP_TAPCELL_ROW_65_1_1018 VDD VSS gf180mcu_as_sc_mcu7t3v3__tap_2
XPHY_EDGE_ROW_82_3_Right_123 VDD VSS gf180mcu_as_sc_mcu7t3v3__tap_2
XFILLER_9_912 VDD VDD VSS VSS gf180mcu_as_sc_mcu7t3v3__fillcap_4
XFILLER_129_103 VDD VDD VSS VSS gf180mcu_as_sc_mcu7t3v3__fill_2
XFILLER_34_1327 VDD VDD VSS VSS gf180mcu_as_sc_mcu7t3v3__fill_2
XFILLER_184_231 VDD VDD VSS VSS gf180mcu_as_sc_mcu7t3v3__fill_2
XPHY_EDGE_ROW_98_1_Right_607 VDD VSS gf180mcu_as_sc_mcu7t3v3__tap_2
XPHY_EDGE_ROW_80_1_Left_272 VDD VSS gf180mcu_as_sc_mcu7t3v3__tap_2
XFILLER_172_437 VDD VDD VSS VSS gf180mcu_as_sc_mcu7t3v3__fillcap_4
XFILLER_172_459 VDD VDD VSS VSS gf180mcu_as_sc_mcu7t3v3__fill_1
XFILLER_181_982 VDD VDD VSS VSS gf180mcu_as_sc_mcu7t3v3__fillcap_16
XFILLER_152_172 VDD VDD VSS VSS gf180mcu_as_sc_mcu7t3v3__fillcap_8
XFILLER_180_481 VDD VDD VSS VSS gf180mcu_as_sc_mcu7t3v3__fill_2
X_3230_ VDD VDD VSS VSS _3234_/B _4333_/Q _3312_/S gf180mcu_as_sc_mcu7t3v3__nand2b_2
X_3161_ VDD VDD VSS VSS _4292_/C _3161_/B _4293_/B _3162_/D gf180mcu_as_sc_mcu7t3v3__nor3_2
Xmesh_tile_849 VDD VDD VSS VSS ne_out[21] gf180mcu_as_sc_mcu7t3v3__tiel_4
Xmesh_tile_838 VDD VDD VSS VSS ne_out[10] gf180mcu_as_sc_mcu7t3v3__tiel_4
XFILLER_81_104 VDD VDD VSS VSS gf180mcu_as_sc_mcu7t3v3__fill_1
X_3092_ VDD VDD VSS VSS _3093_/B _4481_/Q _3608_/A _3123_/D gf180mcu_as_sc_mcu7t3v3__ao21_2
XFILLER_165_1246 VDD VDD VSS VSS gf180mcu_as_sc_mcu7t3v3__fillcap_8
XFILLER_78_1287 VDD VDD VSS VSS gf180mcu_as_sc_mcu7t3v3__fill_2
XFILLER_167_209 VDD VDD VSS VSS gf180mcu_as_sc_mcu7t3v3__fill_1
X_3994_ VDD VDD VSS VSS _4259_/D _3994_/B _3994_/A gf180mcu_as_sc_mcu7t3v3__nand2b_2
X_2945_ VDD VDD VSS VSS _3020_/A _2945_/B _2945_/C _4372_/Q _4372_/D gf180mcu_as_sc_mcu7t3v3__ao22_2
XFILLER_175_231 VDD VDD VSS VSS gf180mcu_as_sc_mcu7t3v3__fillcap_16
X_2876_ VDD VDD VSS VSS _4192_/A _2915_/C _2876_/C _2876_/D _2877_/D gf180mcu_as_sc_mcu7t3v3__ao211_2
X_4615_ VDD VDD VSS VSS _4828_/CLK _4615_/D _4615_/Q gf180mcu_as_sc_mcu7t3v3__dfxtp_2
XFILLER_11_1146 VDD VDD VSS VSS gf180mcu_as_sc_mcu7t3v3__fillcap_16
X_4546_ VDD VDD VSS VSS _4720_/CLK _4546_/D _4546_/Q gf180mcu_as_sc_mcu7t3v3__dfxtp_2
XFILLER_137_1326 VDD VDD VSS VSS gf180mcu_as_sc_mcu7t3v3__fillcap_4
X_4477_ VDD VDD VSS VSS _4602_/CLK _4477_/D _4477_/Q gf180mcu_as_sc_mcu7t3v3__dfxtp_2
X_3428_ VDD VDD VSS VSS _4557_/Q _3443_/B _3444_/C _4556_/Q _4556_/D gf180mcu_as_sc_mcu7t3v3__ao22_2
XPHY_EDGE_ROW_95_3_Left_467 VDD VSS gf180mcu_as_sc_mcu7t3v3__tap_2
XPHY_EDGE_ROW_60_1_Right_569 VDD VSS gf180mcu_as_sc_mcu7t3v3__tap_2
Xhold1100 VDD VDD VSS VSS _4817_/Q hold1100/Y gf180mcu_as_sc_mcu7t3v3__clkbuff_4
X_3359_ VDD VDD VSS VSS _3362_/C _4436_/Q _3368_/S gf180mcu_as_sc_mcu7t3v3__nand2_2
XFILLER_161_38 VDD VDD VSS VSS gf180mcu_as_sc_mcu7t3v3__fillcap_4
XFILLER_72_104 VDD VDD VSS VSS gf180mcu_as_sc_mcu7t3v3__fill_1
XFILLER_166_6 VDD VDD VSS VSS gf180mcu_as_sc_mcu7t3v3__fill_2
XFILLER_183_1324 VDD VDD VSS VSS gf180mcu_as_sc_mcu7t3v3__fillcap_4
XFILLER_158_209 VDD VDD VSS VSS gf180mcu_as_sc_mcu7t3v3__fillcap_4
XFILLER_110_64 VDD VDD VSS VSS gf180mcu_as_sc_mcu7t3v3__fillcap_16
XFILLER_13_259 VDD VDD VSS VSS gf180mcu_as_sc_mcu7t3v3__fill_2
XTAP_TAPCELL_ROW_12_928 VDD VSS gf180mcu_as_sc_mcu7t3v3__tap_2
XTAP_TAPCELL_ROW_12_917 VDD VSS gf180mcu_as_sc_mcu7t3v3__tap_2
XFILLER_10_922 VDD VDD VSS VSS gf180mcu_as_sc_mcu7t3v3__fill_1
XFILLER_167_743 VDD VDD VSS VSS gf180mcu_as_sc_mcu7t3v3__fillcap_4
XFILLER_167_754 VDD VDD VSS VSS gf180mcu_as_sc_mcu7t3v3__fillcap_8
XFILLER_154_415 VDD VDD VSS VSS gf180mcu_as_sc_mcu7t3v3__fillcap_4
XTAP_TAPCELL_ROW_126_1_1079 VDD VSS gf180mcu_as_sc_mcu7t3v3__tap_2
XFILLER_181_212 VDD VDD VSS VSS gf180mcu_as_sc_mcu7t3v3__fillcap_8
XFILLER_79_99 VDD VDD VSS VSS gf180mcu_as_sc_mcu7t3v3__fillcap_4
XFILLER_135_72 VDD VDD VSS VSS gf180mcu_as_sc_mcu7t3v3__fillcap_16
XTAP_TAPCELL_ROW_169_1449 VDD VSS gf180mcu_as_sc_mcu7t3v3__tap_2
XTAP_TAPCELL_ROW_186_1785 VDD VSS gf180mcu_as_sc_mcu7t3v3__tap_2
XTAP_TAPCELL_ROW_186_1774 VDD VSS gf180mcu_as_sc_mcu7t3v3__tap_2
XFILLER_188_1235 VDD VDD VSS VSS gf180mcu_as_sc_mcu7t3v3__fillcap_4
XFILLER_28_70 VDD VDD VSS VSS gf180mcu_as_sc_mcu7t3v3__fill_1
XPHY_EDGE_ROW_22_1_Right_531 VDD VSS gf180mcu_as_sc_mcu7t3v3__tap_2
XFILLER_189_356 VDD VDD VSS VSS gf180mcu_as_sc_mcu7t3v3__fill_1
XPHY_EDGE_ROW_83_3_Right_124 VDD VSS gf180mcu_as_sc_mcu7t3v3__tap_2
X_2730_ VDD VDD VSS VSS _2916_/B _4062_/A _2731_/D gf180mcu_as_sc_mcu7t3v3__and2_2
XFILLER_173_702 VDD VDD VSS VSS gf180mcu_as_sc_mcu7t3v3__fillcap_16
XFILLER_173_724 VDD VDD VSS VSS gf180mcu_as_sc_mcu7t3v3__fill_1
XFILLER_185_562 VDD VDD VSS VSS gf180mcu_as_sc_mcu7t3v3__fillcap_16
XFILLER_185_584 VDD VDD VSS VSS gf180mcu_as_sc_mcu7t3v3__fill_1
X_2661_ VDD VDD VSS VSS _2902_/B _3993_/B _2669_/D gf180mcu_as_sc_mcu7t3v3__and2_2
XPHY_EDGE_ROW_99_1_Right_608 VDD VSS gf180mcu_as_sc_mcu7t3v3__tap_2
XFILLER_173_768 VDD VDD VSS VSS gf180mcu_as_sc_mcu7t3v3__fill_2
X_4400_ VDD VDD VSS VSS _4429_/CLK _4400_/D _4400_/Q gf180mcu_as_sc_mcu7t3v3__dfxtp_2
XFILLER_5_30 VDD VDD VSS VSS gf180mcu_as_sc_mcu7t3v3__fill_2
X_2592_ VDD VDD VSS VSS _3625_/A _3960_/B _3994_/B gf180mcu_as_sc_mcu7t3v3__and2_2
XFILLER_160_429 VDD VDD VSS VSS gf180mcu_as_sc_mcu7t3v3__fillcap_16
X_4331_ VDD VDD VSS VSS _4767_/D _4331_/B _4331_/A gf180mcu_as_sc_mcu7t3v3__nor2_2
X_4262_ VDD VDD VSS VSS _4723_/D _4272_/C _4262_/B _4262_/A gf180mcu_as_sc_mcu7t3v3__aoi21_2
XFILLER_84_1291 VDD VDD VSS VSS gf180mcu_as_sc_mcu7t3v3__fillcap_8
X_3213_ VDD VDD VSS VSS _3214_/C _3213_/B _3573_/B gf180mcu_as_sc_mcu7t3v3__nor2_2
XTAP_TAPCELL_ROW_41_3_1952 VDD VSS gf180mcu_as_sc_mcu7t3v3__tap_2
XFILLER_45_1297 VDD VDD VSS VSS gf180mcu_as_sc_mcu7t3v3__fill_2
X_4193_ VDD VDD VSS VSS _4193_/A _4236_/B _4193_/C _4193_/D _4194_/D gf180mcu_as_sc_mcu7t3v3__ao22_2
XFILLER_132_1256 VDD VDD VSS VSS gf180mcu_as_sc_mcu7t3v3__fill_2
X_3144_ VDD VDD VSS VSS _4504_/Q _4501_/Q _3145_/C gf180mcu_as_sc_mcu7t3v3__or2_2
XFILLER_54_104 VDD VDD VSS VSS gf180mcu_as_sc_mcu7t3v3__fill_1
X_3075_ VDD VDD VSS VSS _3079_/S _3518_/B _4473_/Q _4473_/D gf180mcu_as_sc_mcu7t3v3__mux2_2
XFILLER_168_507 VDD VDD VSS VSS gf180mcu_as_sc_mcu7t3v3__fillcap_4
X_3977_ VDD VDD VSS VSS _4234_/C _3978_/B _3978_/A gf180mcu_as_sc_mcu7t3v3__nor2_2
XFILLER_10_218 VDD VDD VSS VSS gf180mcu_as_sc_mcu7t3v3__fill_2
X_2928_ VDD VDD VSS VSS _2980_/A _2943_/A _3011_/A gf180mcu_as_sc_mcu7t3v3__and2_2
XFILLER_40_27 VDD VDD VSS VSS gf180mcu_as_sc_mcu7t3v3__fillcap_8
XFILLER_163_212 VDD VDD VSS VSS gf180mcu_as_sc_mcu7t3v3__fillcap_4
X_2859_ VDD VDD VSS VSS _2891_/B _4177_/A _2860_/D gf180mcu_as_sc_mcu7t3v3__and2_2
XFILLER_160_941 VDD VDD VSS VSS gf180mcu_as_sc_mcu7t3v3__fillcap_4
X_4529_ VDD VDD VSS VSS _4789_/CLK _4529_/D _4529_/Q gf180mcu_as_sc_mcu7t3v3__dfxtp_2
XFILLER_160_974 VDD VDD VSS VSS gf180mcu_as_sc_mcu7t3v3__fill_1
XFILLER_172_37 VDD VDD VSS VSS gf180mcu_as_sc_mcu7t3v3__fillcap_4
Xfanout721 VDD VDD VSS VSS _4582_/Q _3572_/B gf180mcu_as_sc_mcu7t3v3__buff_12
Xfanout743 VDD VDD VSS VSS _4449_/Q fanout743/Y gf180mcu_as_sc_mcu7t3v3__buff_12
Xfanout754 VDD VDD VSS VSS _3408_/C _3205_/A gf180mcu_as_sc_mcu7t3v3__buff_12
XFILLER_105_53 VDD VDD VSS VSS gf180mcu_as_sc_mcu7t3v3__fillcap_16
XFILLER_150_1345 VDD VDD VSS VSS gf180mcu_as_sc_mcu7t3v3__fillcap_4
XFILLER_45_104 VDD VDD VSS VSS gf180mcu_as_sc_mcu7t3v3__fill_1
XTAP_TAPCELL_ROW_164_1368 VDD VSS gf180mcu_as_sc_mcu7t3v3__tap_2
XTAP_TAPCELL_ROW_164_1357 VDD VSS gf180mcu_as_sc_mcu7t3v3__tap_2
XPHY_EDGE_ROW_0_Left_193 VDD VSS gf180mcu_as_sc_mcu7t3v3__tap_2
XTAP_TAPCELL_ROW_181_1682 VDD VSS gf180mcu_as_sc_mcu7t3v3__tap_2
XTAP_TAPCELL_ROW_145_3_2056 VDD VSS gf180mcu_as_sc_mcu7t3v3__tap_2
XTAP_TAPCELL_ROW_181_1693 VDD VSS gf180mcu_as_sc_mcu7t3v3__tap_2
XFILLER_157_2 VDD VDD VSS VSS gf180mcu_as_sc_mcu7t3v3__fill_2
XFILLER_183_1187 VDD VDD VSS VSS gf180mcu_as_sc_mcu7t3v3__fill_2
XFILLER_186_326 VDD VDD VSS VSS gf180mcu_as_sc_mcu7t3v3__fillcap_8
XFILLER_187_838 VDD VDD VSS VSS gf180mcu_as_sc_mcu7t3v3__fill_2
XFILLER_81_56 VDD VDD VSS VSS gf180mcu_as_sc_mcu7t3v3__fillcap_4
XFILLER_154_201 VDD VDD VSS VSS gf180mcu_as_sc_mcu7t3v3__fill_2
XFILLER_155_702 VDD VDD VSS VSS gf180mcu_as_sc_mcu7t3v3__fill_2
XFILLER_167_573 VDD VDD VSS VSS gf180mcu_as_sc_mcu7t3v3__fillcap_16
XFILLER_6_734 VDD VDD VSS VSS gf180mcu_as_sc_mcu7t3v3__fill_1
XFILLER_154_289 VDD VDD VSS VSS gf180mcu_as_sc_mcu7t3v3__fill_2
XFILLER_155_1212 VDD VDD VSS VSS gf180mcu_as_sc_mcu7t3v3__fill_1
XFILLER_68_1264 VDD VDD VSS VSS gf180mcu_as_sc_mcu7t3v3__fillcap_4
XFILLER_2_951 VDD VDD VSS VSS gf180mcu_as_sc_mcu7t3v3__fill_2
XTAP_TAPCELL_ROW_188_1825 VDD VSS gf180mcu_as_sc_mcu7t3v3__tap_2
XTAP_TAPCELL_ROW_188_1814 VDD VSS gf180mcu_as_sc_mcu7t3v3__tap_2
XPHY_EDGE_ROW_111_1_Left_303 VDD VSS gf180mcu_as_sc_mcu7t3v3__tap_2
XFILLER_1_472 VDD VDD VSS VSS gf180mcu_as_sc_mcu7t3v3__fillcap_4
XFILLER_1_494 VDD VDD VSS VSS gf180mcu_as_sc_mcu7t3v3__fill_1
XFILLER_7_1077 VDD VDD VSS VSS gf180mcu_as_sc_mcu7t3v3__fill_2
XFILLER_36_104 VDD VDD VSS VSS gf180mcu_as_sc_mcu7t3v3__fill_1
Xinput9 VDD VDD VSS VSS boot_addr[7] input9/Y gf180mcu_as_sc_mcu7t3v3__buff_12
XFILLER_188_1076 VDD VDD VSS VSS gf180mcu_as_sc_mcu7t3v3__fill_1
XFILLER_188_1087 VDD VDD VSS VSS gf180mcu_as_sc_mcu7t3v3__fillcap_4
XFILLER_162_1216 VDD VDD VSS VSS gf180mcu_as_sc_mcu7t3v3__fillcap_8
XFILLER_178_827 VDD VDD VSS VSS gf180mcu_as_sc_mcu7t3v3__fill_1
XFILLER_189_142 VDD VDD VSS VSS gf180mcu_as_sc_mcu7t3v3__fillcap_4
X_3900_ VDD VDD VSS VSS _3925_/S _3900_/B _4231_/A _3901_/C gf180mcu_as_sc_mcu7t3v3__mux2_2
XPHY_EDGE_ROW_23_1_Right_532 VDD VSS gf180mcu_as_sc_mcu7t3v3__tap_2
XFILLER_162_1227 VDD VDD VSS VSS gf180mcu_as_sc_mcu7t3v3__fill_1
XFILLER_162_1238 VDD VDD VSS VSS gf180mcu_as_sc_mcu7t3v3__fillcap_4
XFILLER_177_304 VDD VDD VSS VSS gf180mcu_as_sc_mcu7t3v3__fill_1
X_3831_ VDD VDD VSS VSS _4175_/A _3867_/B _3831_/C _3867_/D _3833_/C gf180mcu_as_sc_mcu7t3v3__ao211_2
X_3762_ VDD VDD VSS VSS _4785_/Q _3927_/B _3926_/B _4110_/D _3763_/D gf180mcu_as_sc_mcu7t3v3__ao22_2
XPHY_EDGE_ROW_84_3_Right_125 VDD VSS gf180mcu_as_sc_mcu7t3v3__tap_2
XPHY_EDGE_ROW_106_1_Left_298 VDD VSS gf180mcu_as_sc_mcu7t3v3__tap_2
X_3693_ VDD VDD VSS VSS _3747_/S _3693_/B _4050_/A _3694_/B gf180mcu_as_sc_mcu7t3v3__mux2_2
X_2713_ VDD VDD VSS VSS _4047_/D _2902_/B _2713_/C _2713_/D _2714_/C gf180mcu_as_sc_mcu7t3v3__ao211_2
X_2644_ VDD VDD VSS VSS _3955_/A _3944_/A _3957_/A _3633_/A gf180mcu_as_sc_mcu7t3v3__nor3_2
XFILLER_156_1009 VDD VDD VSS VSS gf180mcu_as_sc_mcu7t3v3__fillcap_4
Xoutput335 VDD VDD VSS VSS _5071_/Y dft_rdata[2] gf180mcu_as_sc_mcu7t3v3__buff_12
X_2575_ VDD VDD VSS VSS _3587_/A _2584_/B _4644_/Q _4643_/D gf180mcu_as_sc_mcu7t3v3__mux2_2
XPHY_EDGE_ROW_43_1_Left_235 VDD VSS gf180mcu_as_sc_mcu7t3v3__tap_2
XFILLER_160_237 VDD VDD VSS VSS gf180mcu_as_sc_mcu7t3v3__fill_1
Xoutput368 VDD VDD VSS VSS _4727_/Q east_out[34] gf180mcu_as_sc_mcu7t3v3__buff_12
Xoutput357 VDD VDD VSS VSS _4717_/Q east_out[24] gf180mcu_as_sc_mcu7t3v3__buff_12
Xoutput346 VDD VDD VSS VSS _4707_/Q east_out[14] gf180mcu_as_sc_mcu7t3v3__buff_12
X_4314_ VDD VDD VSS VSS _4318_/B _4538_/Q _4791_/D gf180mcu_as_sc_mcu7t3v3__and2_2
Xoutput379 VDD VDD VSS VSS _4668_/Q south_out[11] gf180mcu_as_sc_mcu7t3v3__buff_12
X_4245_ VDD VDD VSS VSS _4266_/B _4245_/A _4246_/D gf180mcu_as_sc_mcu7t3v3__and2_2
XFILLER_142_18 VDD VDD VSS VSS gf180mcu_as_sc_mcu7t3v3__fillcap_8
X_4176_ VDD VDD VSS VSS _4176_/B _4209_/A _4177_/D gf180mcu_as_sc_mcu7t3v3__and2_2
XFILLER_27_104 VDD VDD VSS VSS gf180mcu_as_sc_mcu7t3v3__fill_1
X_3127_ VDD VDD VSS VSS _3211_/A _3608_/A _3131_/C gf180mcu_as_sc_mcu7t3v3__or2_2
XTAP_TAPCELL_ROW_3_748 VDD VSS gf180mcu_as_sc_mcu7t3v3__tap_2
XFILLER_167_1116 VDD VDD VSS VSS gf180mcu_as_sc_mcu7t3v3__fillcap_4
XFILLER_167_1138 VDD VDD VSS VSS gf180mcu_as_sc_mcu7t3v3__fillcap_8
XFILLER_35_27 VDD VDD VSS VSS gf180mcu_as_sc_mcu7t3v3__fillcap_4
X_3058_ VDD VDD VSS VSS _3062_/S _3518_/B _4457_/Q _4457_/D gf180mcu_as_sc_mcu7t3v3__mux2_2
XFILLER_11_527 VDD VDD VSS VSS gf180mcu_as_sc_mcu7t3v3__fillcap_4
XFILLER_108_1291 VDD VDD VSS VSS gf180mcu_as_sc_mcu7t3v3__fillcap_8
XFILLER_178_1201 VDD VDD VSS VSS gf180mcu_as_sc_mcu7t3v3__fillcap_16
XFILLER_152_716 VDD VDD VSS VSS gf180mcu_as_sc_mcu7t3v3__fill_2
XPHY_EDGE_ROW_55_3_Right_96 VDD VSS gf180mcu_as_sc_mcu7t3v3__tap_2
XFILLER_160_793 VDD VDD VSS VSS gf180mcu_as_sc_mcu7t3v3__fillcap_8
Xfanout540 VDD VDD VSS VSS _3364_/A _3340_/A gf180mcu_as_sc_mcu7t3v3__buff_12
XTAP_TAPCELL_ROW_166_1408 VDD VSS gf180mcu_as_sc_mcu7t3v3__tap_2
XFILLER_76_45 VDD VDD VSS VSS gf180mcu_as_sc_mcu7t3v3__fillcap_16
Xfanout562 VDD VDD VSS VSS _3929_/B _3881_/C gf180mcu_as_sc_mcu7t3v3__buff_12
Xfanout573 VDD VDD VSS VSS _2916_/B _2902_/B gf180mcu_as_sc_mcu7t3v3__buff_12
Xfanout584 VDD VDD VSS VSS _2324_/Y _2418_/A gf180mcu_as_sc_mcu7t3v3__buff_12
XTAP_TAPCELL_ROW_183_1722 VDD VSS gf180mcu_as_sc_mcu7t3v3__tap_2
XFILLER_189_1352 VDD VDD VSS VSS gf180mcu_as_sc_mcu7t3v3__fill_2
XFILLER_18_104 VDD VDD VSS VSS gf180mcu_as_sc_mcu7t3v3__fill_1
Xfanout595 VDD VDD VSS VSS _3444_/C _3442_/C gf180mcu_as_sc_mcu7t3v3__buff_12
Xclkbuf_leaf_12_clk_regs VDD VDD VSS VSS clkload0/A _4447_/CLK gf180mcu_as_sc_mcu7t3v3__clkbuff_12
XFILLER_92_77 VDD VDD VSS VSS gf180mcu_as_sc_mcu7t3v3__fill_2
XFILLER_186_101 VDD VDD VSS VSS gf180mcu_as_sc_mcu7t3v3__fillcap_4
XFILLER_159_337 VDD VDD VSS VSS gf180mcu_as_sc_mcu7t3v3__fill_2
XFILLER_186_156 VDD VDD VSS VSS gf180mcu_as_sc_mcu7t3v3__fill_2
XFILLER_161_1282 VDD VDD VSS VSS gf180mcu_as_sc_mcu7t3v3__fill_1
XFILLER_168_893 VDD VDD VSS VSS gf180mcu_as_sc_mcu7t3v3__fillcap_16
XFILLER_155_576 VDD VDD VSS VSS gf180mcu_as_sc_mcu7t3v3__fillcap_4
XFILLER_170_502 VDD VDD VSS VSS gf180mcu_as_sc_mcu7t3v3__fill_1
XFILLER_170_524 VDD VDD VSS VSS gf180mcu_as_sc_mcu7t3v3__fill_1
XFILLER_182_384 VDD VDD VSS VSS gf180mcu_as_sc_mcu7t3v3__fill_1
XFILLER_170_557 VDD VDD VSS VSS gf180mcu_as_sc_mcu7t3v3__fill_1
X_2360_ VDD VDD VSS VSS _2360_/Y _2455_/A _2360_/B _2360_/C gf180mcu_as_sc_mcu7t3v3__ao21_2
X_2291_ VDD VDD VSS VSS _3199_/A _3210_/A _3189_/B _2292_/B gf180mcu_as_sc_mcu7t3v3__nand3_2
X_4030_ VDD VDD VSS VSS _4032_/C _4216_/A _4030_/B _4030_/C gf180mcu_as_sc_mcu7t3v3__ao21_2
XPHY_EDGE_ROW_10_Right_10 VDD VSS gf180mcu_as_sc_mcu7t3v3__tap_2
XFILLER_81_1294 VDD VDD VSS VSS gf180mcu_as_sc_mcu7t3v3__fill_2
XANTENNA_14 VDD VDD VSS VSS _2486_/B gf180mcu_as_sc_mcu7t3v3__diode_2
XPHY_EDGE_ROW_24_1_Right_533 VDD VSS gf180mcu_as_sc_mcu7t3v3__tap_2
XANTENNA_25 VDD VDD VSS VSS _4035_/B gf180mcu_as_sc_mcu7t3v3__diode_2
XANTENNA_36 VDD VDD VSS VSS _4099_/B gf180mcu_as_sc_mcu7t3v3__diode_2
XANTENNA_47 VDD VDD VSS VSS _4198_/A gf180mcu_as_sc_mcu7t3v3__diode_2
XFILLER_192_104 VDD VDD VSS VSS gf180mcu_as_sc_mcu7t3v3__fillcap_4
X_4794_ VDD VDD VSS VSS _4803_/CLK _4794_/D _4794_/Q gf180mcu_as_sc_mcu7t3v3__dfxtp_2
X_3814_ VDD VDD VSS VSS _3815_/D _4158_/A _3870_/A _3823_/C gf180mcu_as_sc_mcu7t3v3__ao21_2
XANTENNA_58 VDD VDD VSS VSS _3911_/A gf180mcu_as_sc_mcu7t3v3__diode_2
XANTENNA_69 VDD VDD VSS VSS _4033_/A gf180mcu_as_sc_mcu7t3v3__diode_2
XFILLER_140_1322 VDD VDD VSS VSS gf180mcu_as_sc_mcu7t3v3__fill_1
XFILLER_159_893 VDD VDD VSS VSS gf180mcu_as_sc_mcu7t3v3__fillcap_16
X_3745_ VDD VDD VSS VSS _4096_/A _3799_/B _3808_/C _4092_/D _3746_/D gf180mcu_as_sc_mcu7t3v3__ao22_2
XPHY_EDGE_ROW_85_3_Right_126 VDD VSS gf180mcu_as_sc_mcu7t3v3__tap_2
X_3676_ VDD VDD VSS VSS _3676_/B _3748_/A _4660_/D gf180mcu_as_sc_mcu7t3v3__and2_2
XTAP_TAPCELL_ROW_28_3_1939 VDD VSS gf180mcu_as_sc_mcu7t3v3__tap_2
X_2627_ VDD VDD VSS VSS _3039_/A _4284_/A _2627_/C _2629_/D _4246_/A gf180mcu_as_sc_mcu7t3v3__aoi211_2
X_2558_ VDD VDD VSS VSS _3572_/B _4599_/Q _4640_/Q _2562_/A gf180mcu_as_sc_mcu7t3v3__mux2_2
XFILLER_173_1186 VDD VDD VSS VSS gf180mcu_as_sc_mcu7t3v3__fillcap_4
X_2489_ VDD VDD VSS VSS _2490_/C _2489_/B _2489_/A gf180mcu_as_sc_mcu7t3v3__nor2_2
X_4228_ VDD VDD VSS VSS _4229_/C _4228_/C _4228_/B _4228_/A gf180mcu_as_sc_mcu7t3v3__aoi21_2
XFILLER_46_48 VDD VDD VSS VSS gf180mcu_as_sc_mcu7t3v3__fillcap_16
X_4159_ VDD VDD VSS VSS _4160_/C _4159_/A _4184_/B _4159_/C gf180mcu_as_sc_mcu7t3v3__ao21_2
XTAP_TAPCELL_ROW_161_1305 VDD VSS gf180mcu_as_sc_mcu7t3v3__tap_2
XFILLER_102_54 VDD VDD VSS VSS gf180mcu_as_sc_mcu7t3v3__fillcap_4
XFILLER_168_101 VDD VDD VSS VSS gf180mcu_as_sc_mcu7t3v3__fillcap_4
XFILLER_58_1274 VDD VDD VSS VSS gf180mcu_as_sc_mcu7t3v3__fill_2
XFILLER_157_808 VDD VDD VSS VSS gf180mcu_as_sc_mcu7t3v3__fillcap_16
XFILLER_168_134 VDD VDD VSS VSS gf180mcu_as_sc_mcu7t3v3__fillcap_8
XFILLER_169_668 VDD VDD VSS VSS gf180mcu_as_sc_mcu7t3v3__fill_2
XFILLER_180_1135 VDD VDD VSS VSS gf180mcu_as_sc_mcu7t3v3__fillcap_8
XFILLER_156_307 VDD VDD VSS VSS gf180mcu_as_sc_mcu7t3v3__fill_1
XFILLER_180_1157 VDD VDD VSS VSS gf180mcu_as_sc_mcu7t3v3__fillcap_16
XTAP_TAPCELL_ROW_159_1267 VDD VSS gf180mcu_as_sc_mcu7t3v3__tap_2
XTAP_TAPCELL_ROW_176_1581 VDD VSS gf180mcu_as_sc_mcu7t3v3__tap_2
XTAP_TAPCELL_ROW_176_1592 VDD VSS gf180mcu_as_sc_mcu7t3v3__tap_2
XFILLER_164_362 VDD VDD VSS VSS gf180mcu_as_sc_mcu7t3v3__fillcap_16
XFILLER_164_384 VDD VDD VSS VSS gf180mcu_as_sc_mcu7t3v3__fill_1
XFILLER_192_671 VDD VDD VSS VSS gf180mcu_as_sc_mcu7t3v3__fillcap_4
XFILLER_192_682 VDD VDD VSS VSS gf180mcu_as_sc_mcu7t3v3__fillcap_4
XFILLER_152_546 VDD VDD VSS VSS gf180mcu_as_sc_mcu7t3v3__fillcap_16
XFILLER_156_1351 VDD VDD VSS VSS gf180mcu_as_sc_mcu7t3v3__fillcap_4
XFILLER_180_877 VDD VDD VSS VSS gf180mcu_as_sc_mcu7t3v3__fillcap_16
XFILLER_2_2 VDD VDD VSS VSS gf180mcu_as_sc_mcu7t3v3__fillcap_4
XFILLER_152_1215 VDD VDD VSS VSS gf180mcu_as_sc_mcu7t3v3__fill_1
XFILLER_152_1226 VDD VDD VSS VSS gf180mcu_as_sc_mcu7t3v3__fillcap_8
XFILLER_3_589 VDD VDD VSS VSS gf180mcu_as_sc_mcu7t3v3__fill_1
XFILLER_65_1256 VDD VDD VSS VSS gf180mcu_as_sc_mcu7t3v3__fillcap_8
XFILLER_143_72 VDD VDD VSS VSS gf180mcu_as_sc_mcu7t3v3__fillcap_8
XFILLER_8_1194 VDD VDD VSS VSS gf180mcu_as_sc_mcu7t3v3__fillcap_4
XFILLER_143_94 VDD VDD VSS VSS gf180mcu_as_sc_mcu7t3v3__fillcap_8
XPHY_EDGE_ROW_151_1_Right_660 VDD VSS gf180mcu_as_sc_mcu7t3v3__tap_2
XFILLER_187_454 VDD VDD VSS VSS gf180mcu_as_sc_mcu7t3v3__fill_1
XFILLER_174_115 VDD VDD VSS VSS gf180mcu_as_sc_mcu7t3v3__fill_2
Xinput12 VDD VDD VSS VSS boot_data[0] _2437_/A gf180mcu_as_sc_mcu7t3v3__buff_12
Xinput23 VDD VDD VSS VSS dft_addr[10] _2329_/B gf180mcu_as_sc_mcu7t3v3__buff_12
Xinput34 VDD VDD VSS VSS dft_mode _2311_/B gf180mcu_as_sc_mcu7t3v3__buff_12
Xinput45 VDD VDD VSS VSS east_in[10] wire779/A gf180mcu_as_sc_mcu7t3v3__buff_12
X_3530_ VDD VDD VSS VSS _3530_/D _3541_/A _3580_/A _3530_/C _3539_/S gf180mcu_as_sc_mcu7t3v3__ao31_2
XFILLER_157_1104 VDD VDD VSS VSS gf180mcu_as_sc_mcu7t3v3__fillcap_16
Xinput56 VDD VDD VSS VSS east_in[20] _4165_/D gf180mcu_as_sc_mcu7t3v3__buff_12
Xinput67 VDD VDD VSS VSS east_in[30] _4258_/A gf180mcu_as_sc_mcu7t3v3__buff_12
Xinput78 VDD VDD VSS VSS east_in[8] wire771/A gf180mcu_as_sc_mcu7t3v3__buff_12
Xinput89 VDD VDD VSS VSS ne_in[18] _4152_/A gf180mcu_as_sc_mcu7t3v3__buff_12
Xwire771 VDD VDD VSS VSS wire771/A _4068_/D gf180mcu_as_sc_mcu7t3v3__clkbuff_12
XFILLER_182_181 VDD VDD VSS VSS gf180mcu_as_sc_mcu7t3v3__fill_2
XFILLER_192_1017 VDD VDD VSS VSS gf180mcu_as_sc_mcu7t3v3__fill_2
X_3461_ VDD VDD VSS VSS _3600_/A _4459_/Q _4584_/Q _4584_/D gf180mcu_as_sc_mcu7t3v3__mux2_2
X_3392_ VDD VDD VSS VSS _3393_/C _3393_/A _4353_/Q _3394_/A gf180mcu_as_sc_mcu7t3v3__ao21_2
X_2412_ VDD VDD VSS VSS _2413_/C _2412_/B _3053_/B gf180mcu_as_sc_mcu7t3v3__nor2_2
XFILLER_170_387 VDD VDD VSS VSS gf180mcu_as_sc_mcu7t3v3__fillcap_4
X_2343_ VDD VDD VSS VSS _2393_/C _2411_/S gf180mcu_as_sc_mcu7t3v3__inv_2
X_4013_ VDD VDD VSS VSS _4773_/Q _4134_/B _4217_/C _4013_/D _4014_/C gf180mcu_as_sc_mcu7t3v3__ao22_2
X_2274_ VDD VDD VSS VSS _2523_/B _2296_/B _2274_/C _2296_/D gf180mcu_as_sc_mcu7t3v3__nor3_2
XFILLER_168_1200 VDD VDD VSS VSS gf180mcu_as_sc_mcu7t3v3__fillcap_8
XTAP_TAPCELL_ROW_83_1_1036 VDD VSS gf180mcu_as_sc_mcu7t3v3__tap_2
XFILLER_178_454 VDD VDD VSS VSS gf180mcu_as_sc_mcu7t3v3__fill_1
XFILLER_178_465 VDD VDD VSS VSS gf180mcu_as_sc_mcu7t3v3__fill_2
XPHY_EDGE_ROW_25_1_Right_534 VDD VSS gf180mcu_as_sc_mcu7t3v3__tap_2
XFILLER_148_39 VDD VDD VSS VSS gf180mcu_as_sc_mcu7t3v3__fill_1
X_4777_ VDD VDD VSS VSS clkload7/A _4777_/D _4777_/Q gf180mcu_as_sc_mcu7t3v3__dfxtp_2
XFILLER_162_822 VDD VDD VSS VSS gf180mcu_as_sc_mcu7t3v3__fill_1
XFILLER_175_1204 VDD VDD VSS VSS gf180mcu_as_sc_mcu7t3v3__fillcap_16
XFILLER_180_107 VDD VDD VSS VSS gf180mcu_as_sc_mcu7t3v3__fill_2
XFILLER_88_1256 VDD VDD VSS VSS gf180mcu_as_sc_mcu7t3v3__fillcap_4
X_3728_ VDD VDD VSS VSS _4080_/A _3799_/B _3728_/C _3728_/D _3729_/C gf180mcu_as_sc_mcu7t3v3__ao211_2
XTAP_TAPCELL_ROW_154_1164 VDD VSS gf180mcu_as_sc_mcu7t3v3__tap_2
XPHY_EDGE_ROW_86_3_Right_127 VDD VSS gf180mcu_as_sc_mcu7t3v3__tap_2
XFILLER_161_310 VDD VDD VSS VSS gf180mcu_as_sc_mcu7t3v3__fill_2
X_3659_ VDD VDD VSS VSS _3875_/B _4020_/D _3660_/C gf180mcu_as_sc_mcu7t3v3__and2_2
XTAP_TAPCELL_ROW_154_1175 VDD VSS gf180mcu_as_sc_mcu7t3v3__tap_2
XFILLER_162_877 VDD VDD VSS VSS gf180mcu_as_sc_mcu7t3v3__fillcap_4
XFILLER_175_1259 VDD VDD VSS VSS gf180mcu_as_sc_mcu7t3v3__fill_1
XFILLER_57_14 VDD VDD VSS VSS gf180mcu_as_sc_mcu7t3v3__fillcap_4
XFILLER_180_37 VDD VDD VSS VSS gf180mcu_as_sc_mcu7t3v3__fill_1
XFILLER_57_69 VDD VDD VSS VSS gf180mcu_as_sc_mcu7t3v3__fill_1
XFILLER_25_1295 VDD VDD VSS VSS gf180mcu_as_sc_mcu7t3v3__fill_2
XFILLER_113_53 VDD VDD VSS VSS gf180mcu_as_sc_mcu7t3v3__fillcap_4
XFILLER_73_68 VDD VDD VSS VSS gf180mcu_as_sc_mcu7t3v3__fill_2
XFILLER_189_68 VDD VDD VSS VSS gf180mcu_as_sc_mcu7t3v3__fill_2
XTAP_TAPCELL_ROW_178_1632 VDD VSS gf180mcu_as_sc_mcu7t3v3__tap_2
XTAP_TAPCELL_ROW_178_1621 VDD VSS gf180mcu_as_sc_mcu7t3v3__tap_2
XPHY_EDGE_ROW_120_1_Left_312 VDD VSS gf180mcu_as_sc_mcu7t3v3__tap_2
Xsram2048.u_bank0_820 VDD VDD VSS VSS sram2048.u_bank0/WEN[7] gf180mcu_as_sc_mcu7t3v3__tiel_4
XFILLER_184_435 VDD VDD VSS VSS gf180mcu_as_sc_mcu7t3v3__fillcap_16
XFILLER_184_457 VDD VDD VSS VSS gf180mcu_as_sc_mcu7t3v3__fillcap_16
XTAP_TAPCELL_ROW_191_1876 VDD VSS gf180mcu_as_sc_mcu7t3v3__tap_2
XTAP_TAPCELL_ROW_10_878 VDD VSS gf180mcu_as_sc_mcu7t3v3__tap_2
XTAP_TAPCELL_ROW_10_889 VDD VSS gf180mcu_as_sc_mcu7t3v3__tap_2
XFILLER_152_376 VDD VDD VSS VSS gf180mcu_as_sc_mcu7t3v3__fillcap_8
XFILLER_98_87 VDD VDD VSS VSS gf180mcu_as_sc_mcu7t3v3__fill_1
XFILLER_191_1094 VDD VDD VSS VSS gf180mcu_as_sc_mcu7t3v3__fillcap_16
XPHY_EDGE_ROW_18_3_Right_59 VDD VSS gf180mcu_as_sc_mcu7t3v3__tap_2
XPHY_EDGE_ROW_52_1_Left_244 VDD VSS gf180mcu_as_sc_mcu7t3v3__tap_2
X_2961_ VDD VDD VSS VSS _2999_/A _2966_/A _3030_/A gf180mcu_as_sc_mcu7t3v3__and2_2
XFILLER_176_925 VDD VDD VSS VSS gf180mcu_as_sc_mcu7t3v3__fillcap_16
X_4700_ VDD VDD VSS VSS _4720_/CLK _4700_/D _4700_/Q gf180mcu_as_sc_mcu7t3v3__dfxtp_2
XFILLER_176_958 VDD VDD VSS VSS gf180mcu_as_sc_mcu7t3v3__fillcap_16
XFILLER_187_284 VDD VDD VSS VSS gf180mcu_as_sc_mcu7t3v3__fill_1
XFILLER_50_1311 VDD VDD VSS VSS gf180mcu_as_sc_mcu7t3v3__fill_2
XFILLER_8_30 VDD VDD VSS VSS gf180mcu_as_sc_mcu7t3v3__fillcap_4
X_4631_ VDD VDD VSS VSS _4820_/CLK _4631_/D _4631_/Q gf180mcu_as_sc_mcu7t3v3__dfxtp_2
X_2892_ VDD VDD VSS VSS _4797_/Q _2892_/B _2892_/C _3869_/D _2894_/C gf180mcu_as_sc_mcu7t3v3__ao22_2
XTAP_TAPCELL_ROW_144_1_1097 VDD VSS gf180mcu_as_sc_mcu7t3v3__tap_2
XFILLER_162_107 VDD VDD VSS VSS gf180mcu_as_sc_mcu7t3v3__fillcap_16
X_4562_ VDD VDD VSS VSS _4807_/CLK _4562_/D _4562_/Q gf180mcu_as_sc_mcu7t3v3__dfxtp_2
X_4493_ VDD VDD VSS VSS _4727_/CLK _4493_/D _4493_/Q gf180mcu_as_sc_mcu7t3v3__dfxtp_2
X_3513_ VDD VDD VSS VSS _3513_/D _3513_/A _3583_/A _3541_/C _3529_/S gf180mcu_as_sc_mcu7t3v3__ao31_2
XPHY_EDGE_ROW_135_3_Left_507 VDD VSS gf180mcu_as_sc_mcu7t3v3__tap_2
X_3444_ VDD VDD VSS VSS _4573_/Q _3445_/B _3444_/C _4572_/Q _4572_/D gf180mcu_as_sc_mcu7t3v3__ao22_2
XFILLER_170_173 VDD VDD VSS VSS gf180mcu_as_sc_mcu7t3v3__fill_2
X_3375_ VDD VDD VSS VSS _3378_/C _4438_/Q _3408_/C gf180mcu_as_sc_mcu7t3v3__nand2_2
XFILLER_170_1145 VDD VDD VSS VSS gf180mcu_as_sc_mcu7t3v3__fill_2
XFILLER_170_1167 VDD VDD VSS VSS gf180mcu_as_sc_mcu7t3v3__fill_1
X_2326_ VDD VDD VSS VSS _2425_/B _4489_/Q _2327_/D gf180mcu_as_sc_mcu7t3v3__and2_2
X_2257_ VDD VDD VSS VSS _4623_/Q _4629_/Q _3566_/B gf180mcu_as_sc_mcu7t3v3__and2_2
X_2188_ VDD VDD VSS VSS _4267_/A _3932_/B gf180mcu_as_sc_mcu7t3v3__inv_2
XFILLER_43_27 VDD VDD VSS VSS gf180mcu_as_sc_mcu7t3v3__fill_2
XFILLER_179_763 VDD VDD VSS VSS gf180mcu_as_sc_mcu7t3v3__fillcap_4
XFILLER_138_104 VDD VDD VSS VSS gf180mcu_as_sc_mcu7t3v3__fill_1
XFILLER_166_402 VDD VDD VSS VSS gf180mcu_as_sc_mcu7t3v3__fillcap_8
XFILLER_167_936 VDD VDD VSS VSS gf180mcu_as_sc_mcu7t3v3__fill_1
XTAP_TAPCELL_ROW_156_1215 VDD VSS gf180mcu_as_sc_mcu7t3v3__tap_2
XTAP_TAPCELL_ROW_156_1204 VDD VSS gf180mcu_as_sc_mcu7t3v3__tap_2
XFILLER_166_457 VDD VDD VSS VSS gf180mcu_as_sc_mcu7t3v3__fill_1
XFILLER_178_295 VDD VDD VSS VSS gf180mcu_as_sc_mcu7t3v3__fillcap_16
X_4829_ VDD VDD VSS VSS _4829_/CLK _4829_/D _4829_/Q gf180mcu_as_sc_mcu7t3v3__dfxtp_2
XPHY_EDGE_ROW_26_1_Right_535 VDD VSS gf180mcu_as_sc_mcu7t3v3__tap_2
XFILLER_182_939 VDD VDD VSS VSS gf180mcu_as_sc_mcu7t3v3__fillcap_4
XFILLER_5_607 VDD VDD VSS VSS gf180mcu_as_sc_mcu7t3v3__fill_1
XTAP_TAPCELL_ROW_173_1540 VDD VSS gf180mcu_as_sc_mcu7t3v3__tap_2
XPHY_EDGE_ROW_67_3_Left_439 VDD VSS gf180mcu_as_sc_mcu7t3v3__tap_2
XPHY_EDGE_ROW_87_3_Right_128 VDD VSS gf180mcu_as_sc_mcu7t3v3__tap_2
XFILLER_108_31 VDD VDD VSS VSS gf180mcu_as_sc_mcu7t3v3__fillcap_4
XFILLER_161_173 VDD VDD VSS VSS gf180mcu_as_sc_mcu7t3v3__fillcap_16
XFILLER_175_1078 VDD VDD VSS VSS gf180mcu_as_sc_mcu7t3v3__fillcap_16
XFILLER_108_97 VDD VDD VSS VSS gf180mcu_as_sc_mcu7t3v3__fillcap_8
XFILLER_153_1332 VDD VDD VSS VSS gf180mcu_as_sc_mcu7t3v3__fillcap_16
Xinput202 VDD VDD VSS VSS se_in[21] _4179_/B gf180mcu_as_sc_mcu7t3v3__buff_12
XFILLER_114_1316 VDD VDD VSS VSS gf180mcu_as_sc_mcu7t3v3__fill_1
XFILLER_124_30 VDD VDD VSS VSS gf180mcu_as_sc_mcu7t3v3__fillcap_4
Xinput213 VDD VDD VSS VSS se_in[31] _3932_/B gf180mcu_as_sc_mcu7t3v3__buff_12
Xinput224 VDD VDD VSS VSS se_in[9] _4079_/A gf180mcu_as_sc_mcu7t3v3__buff_12
Xinput235 VDD VDD VSS VSS south_in[19] _4158_/A gf180mcu_as_sc_mcu7t3v3__buff_12
XFILLER_124_52 VDD VDD VSS VSS gf180mcu_as_sc_mcu7t3v3__fill_2
XFILLER_187_2 VDD VDD VSS VSS gf180mcu_as_sc_mcu7t3v3__fillcap_16
Xinput246 VDD VDD VSS VSS south_in[29] _4245_/A gf180mcu_as_sc_mcu7t3v3__buff_12
Xinput257 VDD VDD VSS VSS south_in[6] _4052_/A gf180mcu_as_sc_mcu7t3v3__buff_12
Xinput268 VDD VDD VSS VSS sw_in[16] _4138_/A gf180mcu_as_sc_mcu7t3v3__buff_12
Xinput279 VDD VDD VSS VSS sw_in[26] _4221_/A gf180mcu_as_sc_mcu7t3v3__buff_12
XFILLER_124_85 VDD VDD VSS VSS gf180mcu_as_sc_mcu7t3v3__fillcap_16
XFILLER_17_72 VDD VDD VSS VSS gf180mcu_as_sc_mcu7t3v3__fillcap_4
XFILLER_186_1152 VDD VDD VSS VSS gf180mcu_as_sc_mcu7t3v3__fill_2
XFILLER_13_920 VDD VDD VSS VSS gf180mcu_as_sc_mcu7t3v3__fillcap_16
XFILLER_9_902 VDD VDD VSS VSS gf180mcu_as_sc_mcu7t3v3__fill_1
XFILLER_158_925 VDD VDD VSS VSS gf180mcu_as_sc_mcu7t3v3__fill_1
XFILLER_158_947 VDD VDD VSS VSS gf180mcu_as_sc_mcu7t3v3__fillcap_16
XFILLER_157_468 VDD VDD VSS VSS gf180mcu_as_sc_mcu7t3v3__fill_1
XFILLER_9_979 VDD VDD VSS VSS gf180mcu_as_sc_mcu7t3v3__fill_1
XFILLER_153_652 VDD VDD VSS VSS gf180mcu_as_sc_mcu7t3v3__fill_2
XFILLER_158_1243 VDD VDD VSS VSS gf180mcu_as_sc_mcu7t3v3__fillcap_8
XFILLER_152_184 VDD VDD VSS VSS gf180mcu_as_sc_mcu7t3v3__fillcap_16
X_3160_ VDD VDD VSS VSS _4483_/Q _4484_/Q _4293_/B gf180mcu_as_sc_mcu7t3v3__or2_2
Xmesh_tile_839 VDD VDD VSS VSS ne_out[11] gf180mcu_as_sc_mcu7t3v3__tiel_4
X_3091_ VDD VDD VSS VSS _3123_/D _3091_/B _3091_/A gf180mcu_as_sc_mcu7t3v3__nor2_2
XFILLER_169_1350 VDD VDD VSS VSS gf180mcu_as_sc_mcu7t3v3__fill_1
XFILLER_165_1258 VDD VDD VSS VSS gf180mcu_as_sc_mcu7t3v3__fill_2
XFILLER_78_1299 VDD VDD VSS VSS gf180mcu_as_sc_mcu7t3v3__fillcap_4
XPHY_EDGE_ROW_8_Right_8 VDD VSS gf180mcu_as_sc_mcu7t3v3__tap_2
X_3993_ VDD VDD VSS VSS _4225_/B _3993_/B _3993_/A _4009_/B gf180mcu_as_sc_mcu7t3v3__mux2_2
XFILLER_176_733 VDD VDD VSS VSS gf180mcu_as_sc_mcu7t3v3__fill_2
XFILLER_188_582 VDD VDD VSS VSS gf180mcu_as_sc_mcu7t3v3__fill_2
X_2944_ VDD VDD VSS VSS _4371_/Q _2951_/B _3019_/A _2951_/D _4371_/D gf180mcu_as_sc_mcu7t3v3__ao22_2
XFILLER_176_744 VDD VDD VSS VSS gf180mcu_as_sc_mcu7t3v3__fillcap_8
X_2875_ VDD VDD VSS VSS _2918_/B _4190_/A _2876_/D gf180mcu_as_sc_mcu7t3v3__and2_2
XFILLER_191_725 VDD VDD VSS VSS gf180mcu_as_sc_mcu7t3v3__fill_1
X_4614_ VDD VDD VSS VSS _4828_/CLK _4614_/D _4614_/Q gf180mcu_as_sc_mcu7t3v3__dfxtp_2
XFILLER_102_1264 VDD VDD VSS VSS gf180mcu_as_sc_mcu7t3v3__fill_2
XFILLER_163_438 VDD VDD VSS VSS gf180mcu_as_sc_mcu7t3v3__fillcap_16
XFILLER_191_769 VDD VDD VSS VSS gf180mcu_as_sc_mcu7t3v3__fill_1
X_4545_ VDD VDD VSS VSS _4726_/CLK _4545_/D _4545_/Q gf180mcu_as_sc_mcu7t3v3__dfxtp_2
XTAP_TAPCELL_ROW_78_1_1031 VDD VSS gf180mcu_as_sc_mcu7t3v3__tap_2
XFILLER_176_1354 VDD VDD VSS VSS gf180mcu_as_sc_mcu7t3v3__fill_1
XFILLER_171_482 VDD VDD VSS VSS gf180mcu_as_sc_mcu7t3v3__fill_1
X_4476_ VDD VDD VSS VSS _4602_/CLK _4476_/D _4476_/Q gf180mcu_as_sc_mcu7t3v3__dfxtp_2
X_3427_ VDD VDD VSS VSS _4556_/Q _3443_/B _3444_/C _4555_/Q _4555_/D gf180mcu_as_sc_mcu7t3v3__ao22_2
X_3358_ VDD VDD VSS VSS _3362_/B _4349_/Q _3368_/S gf180mcu_as_sc_mcu7t3v3__nand2b_2
Xhold1101 VDD VDD VSS VSS _4824_/Q hold1101/Y gf180mcu_as_sc_mcu7t3v3__clkbuff_4
X_2309_ VDD VDD VSS VSS _2309_/D _3483_/S _3090_/B _2309_/C _2310_/B gf180mcu_as_sc_mcu7t3v3__ao31_2
X_3289_ VDD VDD VSS VSS _3290_/D _3289_/B _3346_/A gf180mcu_as_sc_mcu7t3v3__nor2_2
XFILLER_54_37 VDD VDD VSS VSS gf180mcu_as_sc_mcu7t3v3__fill_1
XFILLER_159_6 VDD VDD VSS VSS gf180mcu_as_sc_mcu7t3v3__fillcap_8
XPHY_EDGE_ROW_156_Left_348 VDD VSS gf180mcu_as_sc_mcu7t3v3__tap_2
XFILLER_10_912 VDD VDD VSS VSS gf180mcu_as_sc_mcu7t3v3__fillcap_8
XTAP_TAPCELL_ROW_12_918 VDD VSS gf180mcu_as_sc_mcu7t3v3__tap_2
XFILLER_9_209 VDD VDD VSS VSS gf180mcu_as_sc_mcu7t3v3__fill_1
XFILLER_10_934 VDD VDD VSS VSS gf180mcu_as_sc_mcu7t3v3__fill_1
XFILLER_110_98 VDD VDD VSS VSS gf180mcu_as_sc_mcu7t3v3__fillcap_4
XFILLER_186_69 VDD VDD VSS VSS gf180mcu_as_sc_mcu7t3v3__fillcap_16
XPHY_EDGE_ROW_27_1_Right_536 VDD VSS gf180mcu_as_sc_mcu7t3v3__tap_2
XFILLER_163_961 VDD VDD VSS VSS gf180mcu_as_sc_mcu7t3v3__fillcap_16
XFILLER_79_56 VDD VDD VSS VSS gf180mcu_as_sc_mcu7t3v3__fillcap_8
XPHY_EDGE_ROW_88_3_Right_129 VDD VSS gf180mcu_as_sc_mcu7t3v3__tap_2
XPHY_EDGE_ROW_165_Left_357 VDD VSS gf180mcu_as_sc_mcu7t3v3__tap_2
XFILLER_190_1329 VDD VDD VSS VSS gf180mcu_as_sc_mcu7t3v3__fillcap_16
XFILLER_0_142 VDD VDD VSS VSS gf180mcu_as_sc_mcu7t3v3__fill_2
XTAP_TAPCELL_ROW_186_1786 VDD VSS gf180mcu_as_sc_mcu7t3v3__tap_2
XTAP_TAPCELL_ROW_186_1775 VDD VSS gf180mcu_as_sc_mcu7t3v3__tap_2
XFILLER_95_33 VDD VDD VSS VSS gf180mcu_as_sc_mcu7t3v3__fill_1
XFILLER_188_1203 VDD VDD VSS VSS gf180mcu_as_sc_mcu7t3v3__fillcap_16
XFILLER_188_1258 VDD VDD VSS VSS gf180mcu_as_sc_mcu7t3v3__fill_2
XFILLER_28_82 VDD VDD VSS VSS gf180mcu_as_sc_mcu7t3v3__fillcap_8
XFILLER_151_72 VDD VDD VSS VSS gf180mcu_as_sc_mcu7t3v3__fillcap_16
XPHY_EDGE_ROW_174_Left_366 VDD VSS gf180mcu_as_sc_mcu7t3v3__tap_2
XFILLER_44_70 VDD VDD VSS VSS gf180mcu_as_sc_mcu7t3v3__fill_1
XFILLER_13_750 VDD VDD VSS VSS gf180mcu_as_sc_mcu7t3v3__fillcap_8
XFILLER_158_733 VDD VDD VSS VSS gf180mcu_as_sc_mcu7t3v3__fill_2
XFILLER_38_1272 VDD VDD VSS VSS gf180mcu_as_sc_mcu7t3v3__fillcap_16
XFILLER_125_1264 VDD VDD VSS VSS gf180mcu_as_sc_mcu7t3v3__fillcap_4
XFILLER_158_744 VDD VDD VSS VSS gf180mcu_as_sc_mcu7t3v3__fill_2
XFILLER_157_276 VDD VDD VSS VSS gf180mcu_as_sc_mcu7t3v3__fillcap_4
X_2660_ VDD VDD VSS VSS _2660_/A _2660_/B _2660_/C _2660_/Y gf180mcu_as_sc_mcu7t3v3__nor3_2
XFILLER_157_298 VDD VDD VSS VSS gf180mcu_as_sc_mcu7t3v3__fillcap_4
XFILLER_161_909 VDD VDD VSS VSS gf180mcu_as_sc_mcu7t3v3__fill_1
X_2591_ VDD VDD VSS VSS _3947_/A _3935_/A _3960_/A _3625_/A gf180mcu_as_sc_mcu7t3v3__nor3_2
XPHY_EDGE_ROW_183_Left_375 VDD VSS gf180mcu_as_sc_mcu7t3v3__tap_2
XFILLER_5_64 VDD VDD VSS VSS gf180mcu_as_sc_mcu7t3v3__fillcap_4
XFILLER_5_982 VDD VDD VSS VSS gf180mcu_as_sc_mcu7t3v3__fillcap_8
X_4330_ VDD VDD VSS VSS _4331_/A _4330_/B _4330_/C _4766_/D gf180mcu_as_sc_mcu7t3v3__nor3_2
X_4261_ VDD VDD VSS VSS _4262_/B _4261_/C _4261_/B _4261_/A gf180mcu_as_sc_mcu7t3v3__ao21b_2
XTAP_TAPCELL_ROW_139_1_1092 VDD VSS gf180mcu_as_sc_mcu7t3v3__tap_2
X_3212_ VDD VDD VSS VSS _3574_/D _3566_/B _3212_/B _3212_/C _3213_/B gf180mcu_as_sc_mcu7t3v3__ao31_2
XFILLER_171_1273 VDD VDD VSS VSS gf180mcu_as_sc_mcu7t3v3__fillcap_4
X_4192_ VDD VDD VSS VSS _4193_/D _4192_/A _4225_/D _4247_/B gf180mcu_as_sc_mcu7t3v3__ao21_2
X_3143_ VDD VDD VSS VSS _4505_/Q _4508_/Q _4507_/Q _3148_/A gf180mcu_as_sc_mcu7t3v3__nor3_2
X_3074_ VDD VDD VSS VSS _3079_/S _3516_/B _4472_/Q _4472_/D gf180mcu_as_sc_mcu7t3v3__mux2_2
XPHY_EDGE_ROW_192_Left_384 VDD VSS gf180mcu_as_sc_mcu7t3v3__tap_2
XTAP_TAPCELL_ROW_111_3_2022 VDD VSS gf180mcu_as_sc_mcu7t3v3__tap_2
XFILLER_165_1044 VDD VDD VSS VSS gf180mcu_as_sc_mcu7t3v3__fillcap_4
XFILLER_165_1088 VDD VDD VSS VSS gf180mcu_as_sc_mcu7t3v3__fillcap_8
X_3976_ VDD VDD VSS VSS _4247_/B _4231_/B _4225_/D gf180mcu_as_sc_mcu7t3v3__nor2b_2
X_2927_ VDD VDD VSS VSS _4362_/Q _2945_/C _3010_/A _2945_/B _4362_/D gf180mcu_as_sc_mcu7t3v3__ao22_2
XPHY_EDGE_ROW_15_1_Left_207 VDD VSS gf180mcu_as_sc_mcu7t3v3__tap_2
X_4736__1036 VDD VDD VSS VSS _4736_/D gf180mcu_as_sc_mcu7t3v3__tiel_4
X_2858_ VDD VDD VSS VSS _4173_/D _2892_/C _2858_/C _2858_/D _2860_/C gf180mcu_as_sc_mcu7t3v3__ao211_2
XFILLER_3_908 VDD VDD VSS VSS gf180mcu_as_sc_mcu7t3v3__fill_2
X_2789_ VDD VDD VSS VSS _4115_/A _2796_/D _2789_/C _3022_/A _2871_/D gf180mcu_as_sc_mcu7t3v3__aoi211_2
XFILLER_163_279 VDD VDD VSS VSS gf180mcu_as_sc_mcu7t3v3__fill_1
X_4528_ VDD VDD VSS VSS _4789_/CLK _4528_/D _4528_/Q gf180mcu_as_sc_mcu7t3v3__dfxtp_2
XFILLER_171_290 VDD VDD VSS VSS gf180mcu_as_sc_mcu7t3v3__fill_1
XFILLER_176_1173 VDD VDD VSS VSS gf180mcu_as_sc_mcu7t3v3__fillcap_8
Xfanout700 VDD VDD VSS VSS _3916_/B _3875_/B gf180mcu_as_sc_mcu7t3v3__buff_12
X_4459_ VDD VDD VSS VSS _4606_/CLK _4459_/D _4459_/Q gf180mcu_as_sc_mcu7t3v3__dfxtp_2
Xfanout722 VDD VDD VSS VSS _4581_/Q _3458_/A gf180mcu_as_sc_mcu7t3v3__buff_12
Xfanout733 VDD VDD VSS VSS _4452_/Q _3071_/B gf180mcu_as_sc_mcu7t3v3__buff_12
Xfanout744 VDD VDD VSS VSS fanout750/Y _3312_/S gf180mcu_as_sc_mcu7t3v3__buff_12
Xfanout755 VDD VDD VSS VSS _3410_/A _3408_/C gf180mcu_as_sc_mcu7t3v3__buff_12
Xfanout799 VDD VDD VSS VSS _4229_/D _4138_/C gf180mcu_as_sc_mcu7t3v3__buff_12
XFILLER_105_87 VDD VDD VSS VSS gf180mcu_as_sc_mcu7t3v3__fill_1
XFILLER_6_1292 VDD VDD VSS VSS gf180mcu_as_sc_mcu7t3v3__fill_2
XTAP_TAPCELL_ROW_164_1369 VDD VSS gf180mcu_as_sc_mcu7t3v3__tap_2
XTAP_TAPCELL_ROW_164_1358 VDD VSS gf180mcu_as_sc_mcu7t3v3__tap_2
XFILLER_121_42 VDD VDD VSS VSS gf180mcu_as_sc_mcu7t3v3__fill_2
XFILLER_183_1122 VDD VDD VSS VSS gf180mcu_as_sc_mcu7t3v3__fillcap_8
XTAP_TAPCELL_ROW_181_1694 VDD VSS gf180mcu_as_sc_mcu7t3v3__tap_2
XTAP_TAPCELL_ROW_181_1683 VDD VSS gf180mcu_as_sc_mcu7t3v3__tap_2
XFILLER_159_508 VDD VDD VSS VSS gf180mcu_as_sc_mcu7t3v3__fill_2
XFILLER_183_1199 VDD VDD VSS VSS gf180mcu_as_sc_mcu7t3v3__fillcap_16
XFILLER_186_338 VDD VDD VSS VSS gf180mcu_as_sc_mcu7t3v3__fill_2
XFILLER_10_797 VDD VDD VSS VSS gf180mcu_as_sc_mcu7t3v3__fill_1
XFILLER_182_533 VDD VDD VSS VSS gf180mcu_as_sc_mcu7t3v3__fill_1
XTAP_TAPCELL_ROW_46_3_1957 VDD VSS gf180mcu_as_sc_mcu7t3v3__tap_2
XPHY_EDGE_ROW_27_3_Right_68 VDD VSS gf180mcu_as_sc_mcu7t3v3__tap_2
XPHY_EDGE_ROW_28_1_Right_537 VDD VSS gf180mcu_as_sc_mcu7t3v3__tap_2
XFILLER_163_780 VDD VDD VSS VSS gf180mcu_as_sc_mcu7t3v3__fill_2
XFILLER_170_739 VDD VDD VSS VSS gf180mcu_as_sc_mcu7t3v3__fill_1
XTAP_TAPCELL_ROW_188_1826 VDD VSS gf180mcu_as_sc_mcu7t3v3__tap_2
XTAP_TAPCELL_ROW_188_1815 VDD VSS gf180mcu_as_sc_mcu7t3v3__tap_2
XFILLER_190_1137 VDD VDD VSS VSS gf180mcu_as_sc_mcu7t3v3__fillcap_16
XPHY_EDGE_ROW_61_1_Left_253 VDD VSS gf180mcu_as_sc_mcu7t3v3__tap_2
XFILLER_188_1033 VDD VDD VSS VSS gf180mcu_as_sc_mcu7t3v3__fillcap_4
XFILLER_188_1044 VDD VDD VSS VSS gf180mcu_as_sc_mcu7t3v3__fillcap_16
XFILLER_7_1089 VDD VDD VSS VSS gf180mcu_as_sc_mcu7t3v3__fillcap_8
XTAP_TAPCELL_ROW_5_790 VDD VSS gf180mcu_as_sc_mcu7t3v3__tap_2
XFILLER_127_1326 VDD VDD VSS VSS gf180mcu_as_sc_mcu7t3v3__fillcap_4
XPHY_EDGE_ROW_144_3_Left_516 VDD VSS gf180mcu_as_sc_mcu7t3v3__tap_2
X_3830_ VDD VDD VSS VSS _3866_/B _4174_/D _3831_/C gf180mcu_as_sc_mcu7t3v3__and2_2
XFILLER_177_349 VDD VDD VSS VSS gf180mcu_as_sc_mcu7t3v3__fill_1
X_3761_ VDD VDD VSS VSS _3859_/B _4108_/A _3763_/C gf180mcu_as_sc_mcu7t3v3__or2_2
XFILLER_186_861 VDD VDD VSS VSS gf180mcu_as_sc_mcu7t3v3__fill_2
XFILLER_192_308 VDD VDD VSS VSS gf180mcu_as_sc_mcu7t3v3__fillcap_4
X_2712_ VDD VDD VSS VSS _4044_/A _2915_/C _2712_/C _2712_/D _2713_/D gf180mcu_as_sc_mcu7t3v3__ao211_2
XFILLER_185_382 VDD VDD VSS VSS gf180mcu_as_sc_mcu7t3v3__fillcap_16
X_3692_ VDD VDD VSS VSS _4049_/A _3882_/B _3692_/C _3692_/D _3693_/B gf180mcu_as_sc_mcu7t3v3__ao211_2
XFILLER_173_577 VDD VDD VSS VSS gf180mcu_as_sc_mcu7t3v3__fillcap_16
X_2643_ VDD VDD VSS VSS _2656_/A _3999_/A _3999_/B gf180mcu_as_sc_mcu7t3v3__nand2_2
XFILLER_12_1297 VDD VDD VSS VSS gf180mcu_as_sc_mcu7t3v3__fillcap_4
X_2574_ VDD VDD VSS VSS _3518_/B _3585_/A _2584_/B gf180mcu_as_sc_mcu7t3v3__and2_2
Xoutput369 VDD VDD VSS VSS _4728_/Q east_out[35] gf180mcu_as_sc_mcu7t3v3__buff_12
Xoutput358 VDD VDD VSS VSS _4718_/Q east_out[25] gf180mcu_as_sc_mcu7t3v3__buff_12
Xoutput347 VDD VDD VSS VSS _4708_/Q east_out[15] gf180mcu_as_sc_mcu7t3v3__buff_12
Xoutput336 VDD VDD VSS VSS _5072_/Y dft_rdata[3] gf180mcu_as_sc_mcu7t3v3__buff_12
X_4313_ VDD VDD VSS VSS _4313_/B _4537_/Q _4790_/D gf180mcu_as_sc_mcu7t3v3__and2_2
X_4244_ VDD VDD VSS VSS _4244_/A _4244_/B _4244_/C _4266_/B gf180mcu_as_sc_mcu7t3v3__nor3_2
X_4175_ VDD VDD VSS VSS _4176_/B _4175_/A _4184_/B _4175_/C gf180mcu_as_sc_mcu7t3v3__ao21_2
X_3126_ VDD VDD VSS VSS _3574_/D _4451_/Q _3126_/B _4805_/Q gf180mcu_as_sc_mcu7t3v3__ao21_2
XTAP_TAPCELL_ROW_3_749 VDD VSS gf180mcu_as_sc_mcu7t3v3__tap_2
XFILLER_110_1352 VDD VDD VSS VSS gf180mcu_as_sc_mcu7t3v3__fill_2
X_3057_ VDD VDD VSS VSS _3062_/S _3516_/B _4456_/Q _4456_/D gf180mcu_as_sc_mcu7t3v3__mux2_2
XPHY_EDGE_ROW_76_3_Left_448 VDD VSS gf180mcu_as_sc_mcu7t3v3__tap_2
XFILLER_93_1314 VDD VDD VSS VSS gf180mcu_as_sc_mcu7t3v3__fill_2
XFILLER_169_839 VDD VDD VSS VSS gf180mcu_as_sc_mcu7t3v3__fill_1
XFILLER_168_349 VDD VDD VSS VSS gf180mcu_as_sc_mcu7t3v3__fill_1
XFILLER_177_850 VDD VDD VSS VSS gf180mcu_as_sc_mcu7t3v3__fill_2
X_3959_ VDD VDD VSS VSS _3959_/A _3959_/B _3959_/C _3959_/D _3960_/D gf180mcu_as_sc_mcu7t3v3__ao22_2
XFILLER_13_1039 VDD VDD VSS VSS gf180mcu_as_sc_mcu7t3v3__fill_2
XFILLER_164_522 VDD VDD VSS VSS gf180mcu_as_sc_mcu7t3v3__fill_2
XFILLER_176_382 VDD VDD VSS VSS gf180mcu_as_sc_mcu7t3v3__fill_2
XFILLER_191_352 VDD VDD VSS VSS gf180mcu_as_sc_mcu7t3v3__fill_2
XFILLER_116_53 VDD VDD VSS VSS gf180mcu_as_sc_mcu7t3v3__fill_1
Xfanout541 VDD VDD VSS VSS _3163_/Y _3364_/A gf180mcu_as_sc_mcu7t3v3__buff_12
XTAP_TAPCELL_ROW_166_1409 VDD VSS gf180mcu_as_sc_mcu7t3v3__tap_2
Xfanout563 VDD VDD VSS VSS _3645_/Y _3920_/C gf180mcu_as_sc_mcu7t3v3__buff_12
Xfanout574 VDD VDD VSS VSS _2660_/Y _2916_/B gf180mcu_as_sc_mcu7t3v3__buff_12
XTAP_TAPCELL_ROW_183_1723 VDD VSS gf180mcu_as_sc_mcu7t3v3__tap_2
Xfanout585 VDD VDD VSS VSS _3117_/S _3116_/S gf180mcu_as_sc_mcu7t3v3__buff_12
Xfanout596 VDD VDD VSS VSS _3449_/B _3444_/C gf180mcu_as_sc_mcu7t3v3__buff_12
XFILLER_132_74 VDD VDD VSS VSS gf180mcu_as_sc_mcu7t3v3__fill_1
XFILLER_132_96 VDD VDD VSS VSS gf180mcu_as_sc_mcu7t3v3__fillcap_8
XFILLER_185_1239 VDD VDD VSS VSS gf180mcu_as_sc_mcu7t3v3__fillcap_4
XFILLER_25_72 VDD VDD VSS VSS gf180mcu_as_sc_mcu7t3v3__fillcap_16
XFILLER_186_113 VDD VDD VSS VSS gf180mcu_as_sc_mcu7t3v3__fill_1
XFILLER_74_1291 VDD VDD VSS VSS gf180mcu_as_sc_mcu7t3v3__fillcap_16
XFILLER_122_1256 VDD VDD VSS VSS gf180mcu_as_sc_mcu7t3v3__fill_2
XFILLER_167_393 VDD VDD VSS VSS gf180mcu_as_sc_mcu7t3v3__fillcap_16
XFILLER_41_93 VDD VDD VSS VSS gf180mcu_as_sc_mcu7t3v3__fillcap_8
Xmax_cap708 VDD VDD VSS VSS _5073_/A _3520_/B gf180mcu_as_sc_mcu7t3v3__clkbuff_12
XFILLER_182_363 VDD VDD VSS VSS gf180mcu_as_sc_mcu7t3v3__fill_2
XPHY_EDGE_ROW_29_1_Right_538 VDD VSS gf180mcu_as_sc_mcu7t3v3__tap_2
XFILLER_9_1118 VDD VDD VSS VSS gf180mcu_as_sc_mcu7t3v3__fill_2
XFILLER_110_102 VDD VDD VSS VSS gf180mcu_as_sc_mcu7t3v3__fill_2
X_2290_ VDD VDD VSS VSS _3200_/B _3189_/B _3199_/A gf180mcu_as_sc_mcu7t3v3__nand2_2
XFILLER_162_1014 VDD VDD VSS VSS gf180mcu_as_sc_mcu7t3v3__fill_1
XFILLER_178_647 VDD VDD VSS VSS gf180mcu_as_sc_mcu7t3v3__fillcap_16
X_3813_ VDD VDD VSS VSS _4159_/A _3867_/B _3813_/C _3867_/D _3815_/C gf180mcu_as_sc_mcu7t3v3__ao211_2
XANTENNA_15 VDD VDD VSS VSS _2494_/C gf180mcu_as_sc_mcu7t3v3__diode_2
XANTENNA_26 VDD VDD VSS VSS _4043_/B gf180mcu_as_sc_mcu7t3v3__diode_2
XANTENNA_37 VDD VDD VSS VSS _4099_/B gf180mcu_as_sc_mcu7t3v3__diode_2
XANTENNA_48 VDD VDD VSS VSS _4198_/A gf180mcu_as_sc_mcu7t3v3__diode_2
XFILLER_159_861 VDD VDD VSS VSS gf180mcu_as_sc_mcu7t3v3__fillcap_16
X_4793_ VDD VDD VSS VSS _4795_/CLK _4793_/D _4793_/Q gf180mcu_as_sc_mcu7t3v3__dfxtp_2
XANTENNA_59 VDD VDD VSS VSS _2462_/A gf180mcu_as_sc_mcu7t3v3__diode_2
XFILLER_14_1348 VDD VDD VSS VSS gf180mcu_as_sc_mcu7t3v3__fillcap_4
XFILLER_192_138 VDD VDD VSS VSS gf180mcu_as_sc_mcu7t3v3__fillcap_4
X_3744_ VDD VDD VSS VSS _3746_/C _4095_/A _3798_/B _3744_/C gf180mcu_as_sc_mcu7t3v3__ao21_2
XFILLER_173_330 VDD VDD VSS VSS gf180mcu_as_sc_mcu7t3v3__fillcap_8
XFILLER_185_190 VDD VDD VSS VSS gf180mcu_as_sc_mcu7t3v3__fillcap_16
X_3675_ VDD VDD VSS VSS _3747_/S _3675_/B _4034_/A _3676_/B gf180mcu_as_sc_mcu7t3v3__mux2_2
XFILLER_173_352 VDD VDD VSS VSS gf180mcu_as_sc_mcu7t3v3__fillcap_16
X_2626_ VDD VDD VSS VSS _2627_/C _4246_/A _3974_/D gf180mcu_as_sc_mcu7t3v3__or2_2
XFILLER_12_1083 VDD VDD VSS VSS gf180mcu_as_sc_mcu7t3v3__fill_2
X_2557_ VDD VDD VSS VSS _2557_/B _2557_/A _4828_/D gf180mcu_as_sc_mcu7t3v3__and2_2
XFILLER_153_18 VDD VDD VSS VSS gf180mcu_as_sc_mcu7t3v3__fill_1
XFILLER_173_1154 VDD VDD VSS VSS gf180mcu_as_sc_mcu7t3v3__fillcap_16
X_2488_ VDD VDD VSS VSS _4542_/Q _3068_/S _3061_/S _4518_/Q _2489_/B gf180mcu_as_sc_mcu7t3v3__ao22_2
X_4227_ VDD VDD VSS VSS _4227_/A _4236_/B _4227_/C _4227_/D _4228_/C gf180mcu_as_sc_mcu7t3v3__ao22_2
XFILLER_46_27 VDD VDD VSS VSS gf180mcu_as_sc_mcu7t3v3__fillcap_8
X_4158_ VDD VDD VSS VSS _4158_/A _4207_/B _4207_/C _4158_/D _4159_/C gf180mcu_as_sc_mcu7t3v3__ao22_2
XTAP_TAPCELL_ROW_161_1306 VDD VSS gf180mcu_as_sc_mcu7t3v3__tap_2
X_4089_ VDD VDD VSS VSS _4090_/B _4089_/A _4154_/S _4089_/C gf180mcu_as_sc_mcu7t3v3__ao21_2
X_3109_ VDD VDD VSS VSS _3121_/S _4497_/Q _4496_/Q _4496_/D gf180mcu_as_sc_mcu7t3v3__mux2_2
XFILLER_12_804 VDD VDD VSS VSS gf180mcu_as_sc_mcu7t3v3__fill_1
XFILLER_180_1103 VDD VDD VSS VSS gf180mcu_as_sc_mcu7t3v3__fillcap_16
XFILLER_184_1272 VDD VDD VSS VSS gf180mcu_as_sc_mcu7t3v3__fillcap_16
XFILLER_62_37 VDD VDD VSS VSS gf180mcu_as_sc_mcu7t3v3__fillcap_16
XFILLER_141_6 VDD VDD VSS VSS gf180mcu_as_sc_mcu7t3v3__fillcap_16
XFILLER_145_1256 VDD VDD VSS VSS gf180mcu_as_sc_mcu7t3v3__fillcap_8
XFILLER_184_1294 VDD VDD VSS VSS gf180mcu_as_sc_mcu7t3v3__fill_1
XFILLER_168_146 VDD VDD VSS VSS gf180mcu_as_sc_mcu7t3v3__fill_2
XTAP_TAPCELL_ROW_159_1268 VDD VSS gf180mcu_as_sc_mcu7t3v3__tap_2
XPHY_EDGE_ROW_140_3_Right_181 VDD VSS gf180mcu_as_sc_mcu7t3v3__tap_2
XFILLER_183_127 VDD VDD VSS VSS gf180mcu_as_sc_mcu7t3v3__fillcap_8
XFILLER_165_853 VDD VDD VSS VSS gf180mcu_as_sc_mcu7t3v3__fillcap_8
XFILLER_192_650 VDD VDD VSS VSS gf180mcu_as_sc_mcu7t3v3__fill_1
XTAP_TAPCELL_ROW_176_1593 VDD VSS gf180mcu_as_sc_mcu7t3v3__tap_2
XTAP_TAPCELL_ROW_176_1582 VDD VSS gf180mcu_as_sc_mcu7t3v3__tap_2
XFILLER_165_897 VDD VDD VSS VSS gf180mcu_as_sc_mcu7t3v3__fill_1
XFILLER_178_1065 VDD VDD VSS VSS gf180mcu_as_sc_mcu7t3v3__fillcap_16
XFILLER_180_834 VDD VDD VSS VSS gf180mcu_as_sc_mcu7t3v3__fillcap_16
XFILLER_178_1087 VDD VDD VSS VSS gf180mcu_as_sc_mcu7t3v3__fillcap_16
XFILLER_191_1254 VDD VDD VSS VSS gf180mcu_as_sc_mcu7t3v3__fillcap_4
XFILLER_65_1268 VDD VDD VSS VSS gf180mcu_as_sc_mcu7t3v3__fill_2
XTAP_TAPCELL_ROW_7_830 VDD VSS gf180mcu_as_sc_mcu7t3v3__tap_2
XFILLER_8_1140 VDD VDD VSS VSS gf180mcu_as_sc_mcu7t3v3__fill_1
XFILLER_185_1058 VDD VDD VSS VSS gf180mcu_as_sc_mcu7t3v3__fill_1
XFILLER_36_71 VDD VDD VSS VSS gf180mcu_as_sc_mcu7t3v3__fill_1
XFILLER_36_82 VDD VDD VSS VSS gf180mcu_as_sc_mcu7t3v3__fillcap_4
XFILLER_37_1326 VDD VDD VSS VSS gf180mcu_as_sc_mcu7t3v3__fillcap_4
X_4731__1041 VDD VDD VSS VSS _4731_/D gf180mcu_as_sc_mcu7t3v3__tiel_4
Xinput13 VDD VDD VSS VSS boot_data[1] _2445_/A gf180mcu_as_sc_mcu7t3v3__buff_12
XFILLER_155_330 VDD VDD VSS VSS gf180mcu_as_sc_mcu7t3v3__fillcap_4
Xinput24 VDD VDD VSS VSS dft_addr[1] _2360_/B gf180mcu_as_sc_mcu7t3v3__buff_12
Xinput35 VDD VDD VSS VSS dft_wdata[0] _2438_/B gf180mcu_as_sc_mcu7t3v3__buff_12
Xinput46 VDD VDD VSS VSS east_in[11] wire778/A gf180mcu_as_sc_mcu7t3v3__buff_12
XFILLER_155_374 VDD VDD VSS VSS gf180mcu_as_sc_mcu7t3v3__fillcap_16
XFILLER_171_812 VDD VDD VSS VSS gf180mcu_as_sc_mcu7t3v3__fill_1
XFILLER_171_823 VDD VDD VSS VSS gf180mcu_as_sc_mcu7t3v3__fill_1
XFILLER_7_874 VDD VDD VSS VSS gf180mcu_as_sc_mcu7t3v3__fillcap_4
Xinput57 VDD VDD VSS VSS east_in[21] wire774/A gf180mcu_as_sc_mcu7t3v3__buff_12
Xinput68 VDD VDD VSS VSS east_in[31] _4265_/A gf180mcu_as_sc_mcu7t3v3__buff_12
Xinput79 VDD VDD VSS VSS east_in[9] wire770/A gf180mcu_as_sc_mcu7t3v3__buff_12
Xwire772 VDD VDD VSS VSS wire772/A _4052_/D gf180mcu_as_sc_mcu7t3v3__clkbuff_12
XFILLER_171_834 VDD VDD VSS VSS gf180mcu_as_sc_mcu7t3v3__fillcap_4
XFILLER_7_896 VDD VDD VSS VSS gf180mcu_as_sc_mcu7t3v3__fillcap_4
X_3460_ VDD VDD VSS VSS _3600_/A _4458_/Q _4583_/Q _4583_/D gf180mcu_as_sc_mcu7t3v3__mux2_2
X_3391_ VDD VDD VSS VSS _3394_/B _3391_/A gf180mcu_as_sc_mcu7t3v3__inv_2
X_2411_ VDD VDD VSS VSS _2411_/S _4620_/Q _2411_/A _2412_/B gf180mcu_as_sc_mcu7t3v3__mux2_2
X_2342_ VDD VDD VSS VSS _2348_/D _2342_/A _2342_/B _2342_/C _2411_/S gf180mcu_as_sc_mcu7t3v3__ao31_2
X_4012_ VDD VDD VSS VSS _4012_/A _4214_/B _4214_/C _4012_/D _4014_/B gf180mcu_as_sc_mcu7t3v3__ao22_2
X_2273_ VDD VDD VSS VSS _2274_/C _4625_/Q _4624_/Q _4623_/Q gf180mcu_as_sc_mcu7t3v3__aoi21_2
XPHY_EDGE_ROW_24_1_Left_216 VDD VSS gf180mcu_as_sc_mcu7t3v3__tap_2
XPHY_EDGE_ROW_149_1_Left_341 VDD VSS gf180mcu_as_sc_mcu7t3v3__tap_2
XFILLER_168_1289 VDD VDD VSS VSS gf180mcu_as_sc_mcu7t3v3__fillcap_4
XFILLER_179_912 VDD VDD VSS VSS gf180mcu_as_sc_mcu7t3v3__fillcap_8
XFILLER_178_444 VDD VDD VSS VSS gf180mcu_as_sc_mcu7t3v3__fillcap_8
XFILLER_148_29 VDD VDD VSS VSS gf180mcu_as_sc_mcu7t3v3__fillcap_4
XFILLER_165_127 VDD VDD VSS VSS gf180mcu_as_sc_mcu7t3v3__fillcap_4
X_4776_ VDD VDD VSS VSS _4783_/CLK _4776_/D _4776_/Q gf180mcu_as_sc_mcu7t3v3__dfxtp_2
XFILLER_105_1262 VDD VDD VSS VSS gf180mcu_as_sc_mcu7t3v3__fill_1
X_3727_ VDD VDD VSS VSS _3727_/D _3796_/B _3727_/B _3727_/C _3728_/D gf180mcu_as_sc_mcu7t3v3__ao31_2
XFILLER_174_683 VDD VDD VSS VSS gf180mcu_as_sc_mcu7t3v3__fillcap_16
XFILLER_179_1352 VDD VDD VSS VSS gf180mcu_as_sc_mcu7t3v3__fill_2
XTAP_TAPCELL_ROW_154_1165 VDD VSS gf180mcu_as_sc_mcu7t3v3__tap_2
XFILLER_88_1279 VDD VDD VSS VSS gf180mcu_as_sc_mcu7t3v3__fill_2
X_3658_ VDD VDD VSS VSS _3658_/B _3748_/A _4658_/D gf180mcu_as_sc_mcu7t3v3__and2_2
XTAP_TAPCELL_ROW_154_1176 VDD VSS gf180mcu_as_sc_mcu7t3v3__tap_2
XFILLER_162_867 VDD VDD VSS VSS gf180mcu_as_sc_mcu7t3v3__fill_1
X_3589_ VDD VDD VSS VSS _4632_/Q _4451_/Q _3603_/C _3602_/C _3599_/B gf180mcu_as_sc_mcu7t3v3__ao211_2
X_2609_ VDD VDD VSS VSS _4258_/A _4248_/A _4265_/A _3978_/B gf180mcu_as_sc_mcu7t3v3__nor3_2
XTAP_TAPCELL_ROW_171_1490 VDD VSS gf180mcu_as_sc_mcu7t3v3__tap_2
XFILLER_180_49 VDD VDD VSS VSS gf180mcu_as_sc_mcu7t3v3__fillcap_16
XFILLER_112_1288 VDD VDD VSS VSS gf180mcu_as_sc_mcu7t3v3__fill_1
XFILLER_112_1299 VDD VDD VSS VSS gf180mcu_as_sc_mcu7t3v3__fillcap_4
XFILLER_147_1318 VDD VDD VSS VSS gf180mcu_as_sc_mcu7t3v3__fillcap_4
XFILLER_186_1345 VDD VDD VSS VSS gf180mcu_as_sc_mcu7t3v3__fillcap_8
XPHY_EDGE_ROW_36_3_Right_77 VDD VSS gf180mcu_as_sc_mcu7t3v3__tap_2
XFILLER_169_433 VDD VDD VSS VSS gf180mcu_as_sc_mcu7t3v3__fill_2
XTAP_TAPCELL_ROW_178_1633 VDD VSS gf180mcu_as_sc_mcu7t3v3__tap_2
XTAP_TAPCELL_ROW_178_1622 VDD VSS gf180mcu_as_sc_mcu7t3v3__tap_2
XFILLER_11_100 VDD VDD VSS VSS gf180mcu_as_sc_mcu7t3v3__fillcap_16
XPHY_EDGE_ROW_70_1_Left_262 VDD VSS gf180mcu_as_sc_mcu7t3v3__tap_2
XFILLER_12_667 VDD VDD VSS VSS gf180mcu_as_sc_mcu7t3v3__fillcap_4
XFILLER_132_2 VDD VDD VSS VSS gf180mcu_as_sc_mcu7t3v3__fillcap_4
XFILLER_184_403 VDD VDD VSS VSS gf180mcu_as_sc_mcu7t3v3__fillcap_16
XFILLER_185_948 VDD VDD VSS VSS gf180mcu_as_sc_mcu7t3v3__fill_2
XFILLER_8_638 VDD VDD VSS VSS gf180mcu_as_sc_mcu7t3v3__fill_1
XFILLER_71_1272 VDD VDD VSS VSS gf180mcu_as_sc_mcu7t3v3__fill_1
XPHY_EDGE_ROW_141_3_Right_182 VDD VSS gf180mcu_as_sc_mcu7t3v3__tap_2
XFILLER_165_683 VDD VDD VSS VSS gf180mcu_as_sc_mcu7t3v3__fillcap_4
XFILLER_32_1267 VDD VDD VSS VSS gf180mcu_as_sc_mcu7t3v3__fillcap_8
XTAP_TAPCELL_ROW_191_1877 VDD VSS gf180mcu_as_sc_mcu7t3v3__tap_2
XTAP_TAPCELL_ROW_191_1866 VDD VSS gf180mcu_as_sc_mcu7t3v3__tap_2
XTAP_TAPCELL_ROW_110_1_1063 VDD VSS gf180mcu_as_sc_mcu7t3v3__tap_2
XFILLER_164_193 VDD VDD VSS VSS gf180mcu_as_sc_mcu7t3v3__fill_1
XFILLER_180_631 VDD VDD VSS VSS gf180mcu_as_sc_mcu7t3v3__fill_1
XTAP_TAPCELL_ROW_10_879 VDD VSS gf180mcu_as_sc_mcu7t3v3__tap_2
XFILLER_98_33 VDD VDD VSS VSS gf180mcu_as_sc_mcu7t3v3__fill_2
XFILLER_4_877 VDD VDD VSS VSS gf180mcu_as_sc_mcu7t3v3__fill_1
XFILLER_4_888 VDD VDD VSS VSS gf180mcu_as_sc_mcu7t3v3__fillcap_16
X_4749__1023 VDD VDD VSS VSS _4749_/D gf180mcu_as_sc_mcu7t3v3__tiel_4
X_2960_ VDD VDD VSS VSS _4381_/Q _2965_/B _3029_/A _2965_/D _4381_/D gf180mcu_as_sc_mcu7t3v3__ao22_2
XFILLER_188_764 VDD VDD VSS VSS gf180mcu_as_sc_mcu7t3v3__fillcap_4
X_2891_ VDD VDD VSS VSS _2891_/B _4210_/A _2895_/C gf180mcu_as_sc_mcu7t3v3__and2_2
X_4630_ VDD VDD VSS VSS _4820_/CLK _4630_/D _4630_/Q gf180mcu_as_sc_mcu7t3v3__dfxtp_2
XFILLER_191_907 VDD VDD VSS VSS gf180mcu_as_sc_mcu7t3v3__fill_2
XFILLER_8_53 VDD VDD VSS VSS gf180mcu_as_sc_mcu7t3v3__fillcap_4
XFILLER_190_417 VDD VDD VSS VSS gf180mcu_as_sc_mcu7t3v3__fill_1
X_4561_ VDD VDD VSS VSS _4807_/CLK _4561_/D _4561_/Q gf180mcu_as_sc_mcu7t3v3__dfxtp_2
XFILLER_156_683 VDD VDD VSS VSS gf180mcu_as_sc_mcu7t3v3__fillcap_8
X_4492_ VDD VDD VSS VSS _4727_/CLK _4492_/D _4492_/Q gf180mcu_as_sc_mcu7t3v3__dfxtp_2
X_3512_ VDD VDD VSS VSS _3558_/B _4575_/Q _3541_/C gf180mcu_as_sc_mcu7t3v3__and2_2
XFILLER_6_181 VDD VDD VSS VSS gf180mcu_as_sc_mcu7t3v3__fill_1
X_3443_ VDD VDD VSS VSS _4572_/Q _3443_/B _3444_/C _4571_/Q _4571_/D gf180mcu_as_sc_mcu7t3v3__ao22_2
XPHY_EDGE_ROW_85_3_Left_457 VDD VSS gf180mcu_as_sc_mcu7t3v3__tap_2
X_3374_ VDD VDD VSS VSS _3378_/B _4351_/Q _3394_/A gf180mcu_as_sc_mcu7t3v3__nand2b_2
XFILLER_135_1288 VDD VDD VSS VSS gf180mcu_as_sc_mcu7t3v3__fillcap_4
XFILLER_170_1157 VDD VDD VSS VSS gf180mcu_as_sc_mcu7t3v3__fillcap_8
X_2325_ VDD VDD VSS VSS _2325_/Y _2418_/A _2408_/A gf180mcu_as_sc_mcu7t3v3__nand2b_2
XFILLER_170_1179 VDD VDD VSS VSS gf180mcu_as_sc_mcu7t3v3__fill_2
X_2256_ VDD VDD VSS VSS _2298_/B _4810_/Q _2502_/A gf180mcu_as_sc_mcu7t3v3__xnor2_2
XFILLER_0_1221 VDD VDD VSS VSS gf180mcu_as_sc_mcu7t3v3__fill_2
X_2187_ VDD VDD VSS VSS _4250_/A _3912_/A gf180mcu_as_sc_mcu7t3v3__inv_2
XFILLER_179_742 VDD VDD VSS VSS gf180mcu_as_sc_mcu7t3v3__fill_2
XFILLER_55_1256 VDD VDD VSS VSS gf180mcu_as_sc_mcu7t3v3__fillcap_4
XFILLER_166_414 VDD VDD VSS VSS gf180mcu_as_sc_mcu7t3v3__fill_1
XFILLER_178_263 VDD VDD VSS VSS gf180mcu_as_sc_mcu7t3v3__fillcap_16
X_4828_ VDD VDD VSS VSS _4828_/CLK _4828_/D _4828_/Q gf180mcu_as_sc_mcu7t3v3__dfxtp_2
XTAP_TAPCELL_ROW_156_1216 VDD VSS gf180mcu_as_sc_mcu7t3v3__tap_2
XTAP_TAPCELL_ROW_156_1205 VDD VSS gf180mcu_as_sc_mcu7t3v3__tap_2
XFILLER_154_609 VDD VDD VSS VSS gf180mcu_as_sc_mcu7t3v3__fill_2
XFILLER_181_417 VDD VDD VSS VSS gf180mcu_as_sc_mcu7t3v3__fill_2
X_4759_ VDD VDD VSS VSS clkload3/A _4759_/D _4759_/Q gf180mcu_as_sc_mcu7t3v3__dfxtp_2
XTAP_TAPCELL_ROW_173_1541 VDD VSS gf180mcu_as_sc_mcu7t3v3__tap_2
XTAP_TAPCELL_ROW_173_1530 VDD VSS gf180mcu_as_sc_mcu7t3v3__tap_2
XFILLER_175_38 VDD VDD VSS VSS gf180mcu_as_sc_mcu7t3v3__fillcap_16
XFILLER_161_130 VDD VDD VSS VSS gf180mcu_as_sc_mcu7t3v3__fillcap_8
XFILLER_175_1024 VDD VDD VSS VSS gf180mcu_as_sc_mcu7t3v3__fill_2
XFILLER_1_858 VDD VDD VSS VSS gf180mcu_as_sc_mcu7t3v3__fillcap_16
XPHY_EDGE_ROW_81_1_Right_590 VDD VSS gf180mcu_as_sc_mcu7t3v3__tap_2
Xinput203 VDD VDD VSS VSS se_in[22] _4187_/A gf180mcu_as_sc_mcu7t3v3__buff_12
Xinput214 VDD VDD VSS VSS se_in[32] _3958_/A gf180mcu_as_sc_mcu7t3v3__buff_12
Xinput225 VDD VDD VSS VSS south_in[0] _3990_/A gf180mcu_as_sc_mcu7t3v3__buff_12
Xinput236 VDD VDD VSS VSS south_in[1] _4012_/A gf180mcu_as_sc_mcu7t3v3__buff_12
Xinput247 VDD VDD VSS VSS south_in[2] _4020_/A gf180mcu_as_sc_mcu7t3v3__buff_12
Xinput258 VDD VDD VSS VSS south_in[7] _4060_/A gf180mcu_as_sc_mcu7t3v3__buff_12
Xinput269 VDD VDD VSS VSS sw_in[17] _4146_/A gf180mcu_as_sc_mcu7t3v3__buff_12
XFILLER_182_1017 VDD VDD VSS VSS gf180mcu_as_sc_mcu7t3v3__fill_2
XFILLER_73_1301 VDD VDD VSS VSS gf180mcu_as_sc_mcu7t3v3__fillcap_8
XFILLER_73_1323 VDD VDD VSS VSS gf180mcu_as_sc_mcu7t3v3__fill_1
XFILLER_13_954 VDD VDD VSS VSS gf180mcu_as_sc_mcu7t3v3__fillcap_4
XFILLER_169_230 VDD VDD VSS VSS gf180mcu_as_sc_mcu7t3v3__fill_1
XFILLER_160_1326 VDD VDD VSS VSS gf180mcu_as_sc_mcu7t3v3__fill_1
XFILLER_185_734 VDD VDD VSS VSS gf180mcu_as_sc_mcu7t3v3__fillcap_4
XFILLER_34_1329 VDD VDD VSS VSS gf180mcu_as_sc_mcu7t3v3__fill_1
XFILLER_184_233 VDD VDD VSS VSS gf180mcu_as_sc_mcu7t3v3__fill_1
XFILLER_33_72 VDD VDD VSS VSS gf180mcu_as_sc_mcu7t3v3__fillcap_16
XFILLER_8_457 VDD VDD VSS VSS gf180mcu_as_sc_mcu7t3v3__fill_2
XPHY_EDGE_ROW_142_3_Right_183 VDD VSS gf180mcu_as_sc_mcu7t3v3__tap_2
XFILLER_180_450 VDD VDD VSS VSS gf180mcu_as_sc_mcu7t3v3__fillcap_4
XFILLER_181_962 VDD VDD VSS VSS gf180mcu_as_sc_mcu7t3v3__fillcap_4
XFILLER_158_1288 VDD VDD VSS VSS gf180mcu_as_sc_mcu7t3v3__fillcap_4
XFILLER_4_663 VDD VDD VSS VSS gf180mcu_as_sc_mcu7t3v3__fill_2
XFILLER_3_195 VDD VDD VSS VSS gf180mcu_as_sc_mcu7t3v3__fill_2
XFILLER_4_696 VDD VDD VSS VSS gf180mcu_as_sc_mcu7t3v3__fill_2
XFILLER_66_103 VDD VDD VSS VSS gf180mcu_as_sc_mcu7t3v3__fill_2
Xmesh_tile_829 VDD VDD VSS VSS ne_out[1] gf180mcu_as_sc_mcu7t3v3__tiel_4
X_3090_ VDD VDD VSS VSS _3608_/A _3483_/S _3090_/B _3090_/C _3091_/B gf180mcu_as_sc_mcu7t3v3__ao31_2
XFILLER_181_81 VDD VDD VSS VSS gf180mcu_as_sc_mcu7t3v3__fillcap_16
Xclkbuf_leaf_7_clk_regs VDD VDD VSS VSS clkbuf_leaf_9_clk_regs/A _4533_/CLK gf180mcu_as_sc_mcu7t3v3__clkbuff_12
XFILLER_78_1256 VDD VDD VSS VSS gf180mcu_as_sc_mcu7t3v3__fillcap_8
X_3992_ VDD VDD VSS VSS _3992_/A _4217_/C _3992_/C _3992_/D _3993_/A gf180mcu_as_sc_mcu7t3v3__ao211_2
X_2943_ VDD VDD VSS VSS _2988_/A _2943_/A _3019_/A gf180mcu_as_sc_mcu7t3v3__and2_2
XFILLER_176_756 VDD VDD VSS VSS gf180mcu_as_sc_mcu7t3v3__fill_1
X_2874_ VDD VDD VSS VSS _4795_/Q _2874_/B _2915_/B _4189_/D _2876_/C gf180mcu_as_sc_mcu7t3v3__ao22_2
XTAP_TAPCELL_ROW_64_3_1975 VDD VSS gf180mcu_as_sc_mcu7t3v3__tap_2
X_4613_ VDD VDD VSS VSS _4828_/CLK _4613_/D _4613_/Q gf180mcu_as_sc_mcu7t3v3__dfxtp_2
X_4544_ VDD VDD VSS VSS _4726_/CLK _4544_/D _4544_/Q gf180mcu_as_sc_mcu7t3v3__dfxtp_2
XFILLER_171_472 VDD VDD VSS VSS gf180mcu_as_sc_mcu7t3v3__fillcap_8
X_4475_ VDD VDD VSS VSS _4602_/CLK _4475_/D _4475_/Q gf180mcu_as_sc_mcu7t3v3__dfxtp_2
X_3426_ VDD VDD VSS VSS _4555_/Q _3449_/D _3444_/C _4554_/Q _4554_/D gf180mcu_as_sc_mcu7t3v3__ao22_2
X_3357_ VDD VDD VSS VSS _3389_/B _4455_/Q _3364_/D gf180mcu_as_sc_mcu7t3v3__and2_2
Xhold1102 VDD VDD VSS VSS _4815_/Q hold1102/Y gf180mcu_as_sc_mcu7t3v3__clkbuff_4
X_2308_ VDD VDD VSS VSS _2309_/C _2308_/A _3090_/C gf180mcu_as_sc_mcu7t3v3__and2_2
X_3288_ VDD VDD VSS VSS _3344_/S _4369_/Q _4398_/Q _3289_/B gf180mcu_as_sc_mcu7t3v3__mux2_2
X_2239_ VDD VDD VSS VSS _3483_/S _2506_/B _2563_/D _3080_/A _2287_/B gf180mcu_as_sc_mcu7t3v3__ao31_2
XTAP_TAPCELL_ROW_29_1_982 VDD VSS gf180mcu_as_sc_mcu7t3v3__tap_2
XFILLER_22_1299 VDD VDD VSS VSS gf180mcu_as_sc_mcu7t3v3__fillcap_4
XFILLER_2_1349 VDD VDD VSS VSS gf180mcu_as_sc_mcu7t3v3__fillcap_4
XFILLER_13_206 VDD VDD VSS VSS gf180mcu_as_sc_mcu7t3v3__fill_2
XFILLER_183_1348 VDD VDD VSS VSS gf180mcu_as_sc_mcu7t3v3__fillcap_4
XTAP_TAPCELL_ROW_12_919 VDD VSS gf180mcu_as_sc_mcu7t3v3__tap_2
XFILLER_10_968 VDD VDD VSS VSS gf180mcu_as_sc_mcu7t3v3__fill_1
XFILLER_186_37 VDD VDD VSS VSS gf180mcu_as_sc_mcu7t3v3__fillcap_16
XFILLER_154_439 VDD VDD VSS VSS gf180mcu_as_sc_mcu7t3v3__fillcap_4
XFILLER_182_737 VDD VDD VSS VSS gf180mcu_as_sc_mcu7t3v3__fillcap_4
XFILLER_6_939 VDD VDD VSS VSS gf180mcu_as_sc_mcu7t3v3__fillcap_4
XPHY_EDGE_ROW_167_Right_29 VDD VSS gf180mcu_as_sc_mcu7t3v3__tap_2
XFILLER_181_258 VDD VDD VSS VSS gf180mcu_as_sc_mcu7t3v3__fillcap_4
XFILLER_79_68 VDD VDD VSS VSS gf180mcu_as_sc_mcu7t3v3__fill_2
XFILLER_153_1141 VDD VDD VSS VSS gf180mcu_as_sc_mcu7t3v3__fill_2
XPHY_EDGE_ROW_82_1_Right_591 VDD VSS gf180mcu_as_sc_mcu7t3v3__tap_2
XFILLER_0_176 VDD VDD VSS VSS gf180mcu_as_sc_mcu7t3v3__fill_2
XTAP_TAPCELL_ROW_186_1776 VDD VSS gf180mcu_as_sc_mcu7t3v3__tap_2
XTAP_TAPCELL_ROW_186_1787 VDD VSS gf180mcu_as_sc_mcu7t3v3__tap_2
XPHY_EDGE_ROW_176_Right_38 VDD VSS gf180mcu_as_sc_mcu7t3v3__tap_2
XFILLER_13_762 VDD VDD VSS VSS gf180mcu_as_sc_mcu7t3v3__fill_1
XFILLER_164_1270 VDD VDD VSS VSS gf180mcu_as_sc_mcu7t3v3__fillcap_16
XFILLER_44_82 VDD VDD VSS VSS gf180mcu_as_sc_mcu7t3v3__fillcap_16
XFILLER_157_244 VDD VDD VSS VSS gf180mcu_as_sc_mcu7t3v3__fillcap_16
XFILLER_185_553 VDD VDD VSS VSS gf180mcu_as_sc_mcu7t3v3__fillcap_4
XPHY_EDGE_ROW_185_Right_47 VDD VSS gf180mcu_as_sc_mcu7t3v3__tap_2
XPHY_EDGE_ROW_33_1_Left_225 VDD VSS gf180mcu_as_sc_mcu7t3v3__tap_2
XFILLER_172_247 VDD VDD VSS VSS gf180mcu_as_sc_mcu7t3v3__fillcap_8
XFILLER_172_269 VDD VDD VSS VSS gf180mcu_as_sc_mcu7t3v3__fillcap_16
XFILLER_5_950 VDD VDD VSS VSS gf180mcu_as_sc_mcu7t3v3__fill_2
X_2590_ VDD VDD VSS VSS _2654_/A _4284_/A _3039_/A gf180mcu_as_sc_mcu7t3v3__nand2_2
XPHY_EDGE_ROW_143_3_Right_184 VDD VSS gf180mcu_as_sc_mcu7t3v3__tap_2
XFILLER_5_32 VDD VDD VSS VSS gf180mcu_as_sc_mcu7t3v3__fill_1
XFILLER_84_1260 VDD VDD VSS VSS gf180mcu_as_sc_mcu7t3v3__fill_2
X_4260_ VDD VDD VSS VSS _4260_/A _4268_/C _4260_/C _4260_/D _4261_/C gf180mcu_as_sc_mcu7t3v3__ao22_2
X_4191_ VDD VDD VSS VSS _4191_/A _4191_/B _4191_/C _4231_/B _4193_/C gf180mcu_as_sc_mcu7t3v3__ao211_2
X_3211_ VDD VDD VSS VSS _3212_/C _3573_/D _3211_/A gf180mcu_as_sc_mcu7t3v3__nor2_2
X_3142_ VDD VDD VSS VSS _4328_/A _3142_/B _3142_/A gf180mcu_as_sc_mcu7t3v3__nor2b_2
XFILLER_10_2 VDD VDD VSS VSS gf180mcu_as_sc_mcu7t3v3__fillcap_4
XFILLER_132_1258 VDD VDD VSS VSS gf180mcu_as_sc_mcu7t3v3__fill_1
X_3073_ VDD VDD VSS VSS _3079_/S _3514_/B _4471_/Q _4471_/D gf180mcu_as_sc_mcu7t3v3__mux2_2
XFILLER_169_1170 VDD VDD VSS VSS gf180mcu_as_sc_mcu7t3v3__fillcap_16
XFILLER_169_1192 VDD VDD VSS VSS gf180mcu_as_sc_mcu7t3v3__fillcap_16
X_3975_ VDD VDD VSS VSS _3975_/Y _3975_/B _4244_/A gf180mcu_as_sc_mcu7t3v3__nor2_2
XFILLER_188_380 VDD VDD VSS VSS gf180mcu_as_sc_mcu7t3v3__fillcap_4
X_2926_ VDD VDD VSS VSS _2979_/A _2943_/A _3010_/A gf180mcu_as_sc_mcu7t3v3__and2_2
X_2857_ VDD VDD VSS VSS _2893_/B _4174_/D _2858_/D gf180mcu_as_sc_mcu7t3v3__and2_2
XFILLER_164_737 VDD VDD VSS VSS gf180mcu_as_sc_mcu7t3v3__fillcap_16
XFILLER_176_597 VDD VDD VSS VSS gf180mcu_as_sc_mcu7t3v3__fillcap_16
XFILLER_191_556 VDD VDD VSS VSS gf180mcu_as_sc_mcu7t3v3__fillcap_4
XFILLER_191_578 VDD VDD VSS VSS gf180mcu_as_sc_mcu7t3v3__fillcap_16
X_2788_ VDD VDD VSS VSS _2789_/C _2788_/C _2823_/D _4113_/A gf180mcu_as_sc_mcu7t3v3__aoi21_2
X_4527_ VDD VDD VSS VSS _4789_/CLK _4527_/D _4527_/Q gf180mcu_as_sc_mcu7t3v3__dfxtp_2
XPHY_EDGE_ROW_45_3_Right_86 VDD VSS gf180mcu_as_sc_mcu7t3v3__tap_2
X_4458_ VDD VDD VSS VSS _4606_/CLK _4458_/D _4458_/Q gf180mcu_as_sc_mcu7t3v3__dfxtp_2
XFILLER_160_998 VDD VDD VSS VSS gf180mcu_as_sc_mcu7t3v3__fillcap_8
XFILLER_63_1322 VDD VDD VSS VSS gf180mcu_as_sc_mcu7t3v3__fill_2
Xfanout701 VDD VDD VSS VSS _3924_/B _3636_/A gf180mcu_as_sc_mcu7t3v3__buff_12
Xfanout712 VDD VDD VSS VSS _3049_/B _3061_/S gf180mcu_as_sc_mcu7t3v3__buff_12
Xfanout723 VDD VDD VSS VSS _3571_/D _2510_/D gf180mcu_as_sc_mcu7t3v3__buff_12
X_3409_ VDD VDD VSS VSS _3410_/C _3409_/C _4413_/Q _3409_/A gf180mcu_as_sc_mcu7t3v3__aoi21b_2
XFILLER_24_1328 VDD VDD VSS VSS gf180mcu_as_sc_mcu7t3v3__fill_2
Xfanout734 VDD VDD VSS VSS _3330_/A _3314_/A gf180mcu_as_sc_mcu7t3v3__buff_12
Xfanout745 VDD VDD VSS VSS fanout750/Y _3296_/S gf180mcu_as_sc_mcu7t3v3__buff_12
Xfanout756 VDD VDD VSS VSS _4448_/Q _3410_/A gf180mcu_as_sc_mcu7t3v3__buff_12
X_4389_ VDD VDD VSS VSS _4447_/CLK _4389_/D _4389_/Q gf180mcu_as_sc_mcu7t3v3__dfxtp_2
XTAP_TAPCELL_ROW_168_1440 VDD VSS gf180mcu_as_sc_mcu7t3v3__tap_2
XTAP_TAPCELL_ROW_164_1359 VDD VSS gf180mcu_as_sc_mcu7t3v3__tap_2
XFILLER_171_6 VDD VDD VSS VSS gf180mcu_as_sc_mcu7t3v3__fillcap_16
XTAP_TAPCELL_ROW_181_1684 VDD VSS gf180mcu_as_sc_mcu7t3v3__tap_2
XFILLER_121_76 VDD VDD VSS VSS gf180mcu_as_sc_mcu7t3v3__fill_2
XFILLER_148_1276 VDD VDD VSS VSS gf180mcu_as_sc_mcu7t3v3__fillcap_8
XFILLER_183_1134 VDD VDD VSS VSS gf180mcu_as_sc_mcu7t3v3__fill_1
XFILLER_183_1145 VDD VDD VSS VSS gf180mcu_as_sc_mcu7t3v3__fillcap_4
XFILLER_183_1189 VDD VDD VSS VSS gf180mcu_as_sc_mcu7t3v3__fill_1
XFILLER_186_317 VDD VDD VSS VSS gf180mcu_as_sc_mcu7t3v3__fill_2
XFILLER_14_41 VDD VDD VSS VSS gf180mcu_as_sc_mcu7t3v3__fill_2
XFILLER_10_721 VDD VDD VSS VSS gf180mcu_as_sc_mcu7t3v3__fill_2
XFILLER_14_74 VDD VDD VSS VSS gf180mcu_as_sc_mcu7t3v3__fillcap_4
XFILLER_155_704 VDD VDD VSS VSS gf180mcu_as_sc_mcu7t3v3__fill_1
XTAP_TAPCELL_ROW_14_1_1924 VDD VSS gf180mcu_as_sc_mcu7t3v3__tap_2
XFILLER_154_247 VDD VDD VSS VSS gf180mcu_as_sc_mcu7t3v3__fillcap_16
XFILLER_6_769 VDD VDD VSS VSS gf180mcu_as_sc_mcu7t3v3__fillcap_16
XFILLER_159_1350 VDD VDD VSS VSS gf180mcu_as_sc_mcu7t3v3__fill_1
XFILLER_155_1236 VDD VDD VSS VSS gf180mcu_as_sc_mcu7t3v3__fillcap_4
XTAP_TAPCELL_ROW_188_1827 VDD VSS gf180mcu_as_sc_mcu7t3v3__tap_2
XTAP_TAPCELL_ROW_188_1816 VDD VSS gf180mcu_as_sc_mcu7t3v3__tap_2
XFILLER_155_1258 VDD VDD VSS VSS gf180mcu_as_sc_mcu7t3v3__fill_2
XFILLER_68_1299 VDD VDD VSS VSS gf180mcu_as_sc_mcu7t3v3__fill_1
XTAP_TAPCELL_ROW_116_3_2027 VDD VSS gf180mcu_as_sc_mcu7t3v3__tap_2
XPHY_EDGE_ROW_83_1_Right_592 VDD VSS gf180mcu_as_sc_mcu7t3v3__tap_2
XTAP_TAPCELL_ROW_5_791 VDD VSS gf180mcu_as_sc_mcu7t3v3__tap_2
XTAP_TAPCELL_ROW_5_780 VDD VSS gf180mcu_as_sc_mcu7t3v3__tap_2
XFILLER_178_807 VDD VDD VSS VSS gf180mcu_as_sc_mcu7t3v3__fillcap_16
XPHY_EDGE_ROW_94_3_Left_466 VDD VSS gf180mcu_as_sc_mcu7t3v3__tap_2
X_3760_ VDD VDD VSS VSS _4110_/A _3795_/B _3760_/C _3795_/D _3763_/B gf180mcu_as_sc_mcu7t3v3__ao211_2
X_2711_ VDD VDD VSS VSS _2918_/B _4044_/D _2712_/D gf180mcu_as_sc_mcu7t3v3__and2_2
XFILLER_158_597 VDD VDD VSS VSS gf180mcu_as_sc_mcu7t3v3__fillcap_16
XFILLER_187_91 VDD VDD VSS VSS gf180mcu_as_sc_mcu7t3v3__fillcap_16
X_3691_ VDD VDD VSS VSS _4048_/A _3881_/B _3879_/B _4045_/D _3692_/D gf180mcu_as_sc_mcu7t3v3__ao22_2
X_2642_ VDD VDD VSS VSS _4267_/C _3959_/B _3999_/A gf180mcu_as_sc_mcu7t3v3__and2_2
XFILLER_161_718 VDD VDD VSS VSS gf180mcu_as_sc_mcu7t3v3__fillcap_16
XFILLER_86_1322 VDD VDD VSS VSS gf180mcu_as_sc_mcu7t3v3__fillcap_4
X_2573_ VDD VDD VSS VSS _4829_/D _2583_/B _4643_/Q _4642_/D gf180mcu_as_sc_mcu7t3v3__mux2_2
XTAP_TAPCELL_ROW_28_1_981 VDD VSS gf180mcu_as_sc_mcu7t3v3__tap_2
XPHY_EDGE_ROW_144_3_Right_185 VDD VSS gf180mcu_as_sc_mcu7t3v3__tap_2
XFILLER_47_1306 VDD VDD VSS VSS gf180mcu_as_sc_mcu7t3v3__fill_2
XFILLER_5_780 VDD VDD VSS VSS gf180mcu_as_sc_mcu7t3v3__fillcap_4
Xoutput359 VDD VDD VSS VSS _4719_/Q east_out[26] gf180mcu_as_sc_mcu7t3v3__buff_12
Xoutput348 VDD VDD VSS VSS _4709_/Q east_out[16] gf180mcu_as_sc_mcu7t3v3__buff_12
Xoutput337 VDD VDD VSS VSS _5073_/Y dft_rdata[4] gf180mcu_as_sc_mcu7t3v3__buff_12
X_4312_ VDD VDD VSS VSS _4312_/B _4536_/Q _4789_/D gf180mcu_as_sc_mcu7t3v3__and2_2
X_4243_ VDD VDD VSS VSS _4243_/B _4265_/D _4248_/D gf180mcu_as_sc_mcu7t3v3__and2_2
XTAP_TAPCELL_ROW_59_3_1970 VDD VSS gf180mcu_as_sc_mcu7t3v3__tap_2
X_4174_ VDD VDD VSS VSS _4174_/A _4207_/B _4207_/C _4174_/D _4175_/C gf180mcu_as_sc_mcu7t3v3__ao22_2
X_3125_ VDD VDD VSS VSS _3218_/B _4805_/Q _3126_/B _4451_/Q gf180mcu_as_sc_mcu7t3v3__aoi21_2
XTAP_TAPCELL_ROW_3_739 VDD VSS gf180mcu_as_sc_mcu7t3v3__tap_2
X_3056_ VDD VDD VSS VSS _3062_/S _3514_/B _4455_/Q _4455_/D gf180mcu_as_sc_mcu7t3v3__mux2_2
XFILLER_93_1326 VDD VDD VSS VSS gf180mcu_as_sc_mcu7t3v3__fill_2
XFILLER_168_306 VDD VDD VSS VSS gf180mcu_as_sc_mcu7t3v3__fillcap_8
XFILLER_168_317 VDD VDD VSS VSS gf180mcu_as_sc_mcu7t3v3__fillcap_4
X_3958_ VDD VDD VSS VSS _3959_/D _3958_/C _3959_/B _3958_/A gf180mcu_as_sc_mcu7t3v3__aoi21_2
XFILLER_164_501 VDD VDD VSS VSS gf180mcu_as_sc_mcu7t3v3__fillcap_8
X_3889_ VDD VDD VSS VSS _3916_/B _4224_/D _3890_/B gf180mcu_as_sc_mcu7t3v3__and2_2
X_2909_ VDD VDD VSS VSS _4225_/A _2916_/B _2915_/C _4224_/A _2910_/D gf180mcu_as_sc_mcu7t3v3__ao22_2
XFILLER_192_843 VDD VDD VSS VSS gf180mcu_as_sc_mcu7t3v3__fillcap_4
XFILLER_152_718 VDD VDD VSS VSS gf180mcu_as_sc_mcu7t3v3__fill_1
XFILLER_164_578 VDD VDD VSS VSS gf180mcu_as_sc_mcu7t3v3__fill_2
XFILLER_116_65 VDD VDD VSS VSS gf180mcu_as_sc_mcu7t3v3__fillcap_8
Xfanout520 VDD VDD VSS VSS _4237_/B fanout520/Y gf180mcu_as_sc_mcu7t3v3__buff_12
Xfanout531 VDD VDD VSS VSS _4236_/B _4218_/B gf180mcu_as_sc_mcu7t3v3__buff_12
Xfanout542 VDD VDD VSS VSS _3396_/A _3412_/A gf180mcu_as_sc_mcu7t3v3__buff_12
Xfanout553 VDD VDD VSS VSS _2325_/Y _2426_/C gf180mcu_as_sc_mcu7t3v3__buff_12
Xfanout575 VDD VDD VSS VSS _2895_/B _2822_/B gf180mcu_as_sc_mcu7t3v3__buff_12
XTAP_TAPCELL_ROW_183_1724 VDD VSS gf180mcu_as_sc_mcu7t3v3__tap_2
XFILLER_189_1332 VDD VDD VSS VSS gf180mcu_as_sc_mcu7t3v3__fillcap_16
XFILLER_76_69 VDD VDD VSS VSS gf180mcu_as_sc_mcu7t3v3__fill_2
Xfanout586 VDD VDD VSS VSS _3117_/S _3120_/S gf180mcu_as_sc_mcu7t3v3__buff_12
Xfanout597 VDD VDD VSS VSS _3584_/D _3449_/B gf180mcu_as_sc_mcu7t3v3__buff_12
XFILLER_132_31 VDD VDD VSS VSS gf180mcu_as_sc_mcu7t3v3__fillcap_4
XFILLER_189_1354 VDD VDD VSS VSS gf180mcu_as_sc_mcu7t3v3__fill_1
Xmesh_tile_990 VDD VDD VSS VSS sw_out[18] gf180mcu_as_sc_mcu7t3v3__tiel_4
XFILLER_92_79 VDD VDD VSS VSS gf180mcu_as_sc_mcu7t3v3__fill_1
XFILLER_159_339 VDD VDD VSS VSS gf180mcu_as_sc_mcu7t3v3__fill_1
XFILLER_186_125 VDD VDD VSS VSS gf180mcu_as_sc_mcu7t3v3__fillcap_4
XFILLER_186_136 VDD VDD VSS VSS gf180mcu_as_sc_mcu7t3v3__fillcap_16
XFILLER_187_648 VDD VDD VSS VSS gf180mcu_as_sc_mcu7t3v3__fillcap_8
XFILLER_161_1262 VDD VDD VSS VSS gf180mcu_as_sc_mcu7t3v3__fillcap_16
XFILLER_186_169 VDD VDD VSS VSS gf180mcu_as_sc_mcu7t3v3__fillcap_4
XFILLER_10_562 VDD VDD VSS VSS gf180mcu_as_sc_mcu7t3v3__fillcap_8
XFILLER_41_50 VDD VDD VSS VSS gf180mcu_as_sc_mcu7t3v3__fillcap_16
Xclkbuf_leaf_21_clk_regs VDD VDD VSS VSS clkload2/A _4808_/CLK gf180mcu_as_sc_mcu7t3v3__clkbuff_12
XFILLER_157_72 VDD VDD VSS VSS gf180mcu_as_sc_mcu7t3v3__fillcap_16
XFILLER_133_1320 VDD VDD VSS VSS gf180mcu_as_sc_mcu7t3v3__fillcap_4
XFILLER_1_282 VDD VDD VSS VSS gf180mcu_as_sc_mcu7t3v3__fillcap_4
XFILLER_81_1296 VDD VDD VSS VSS gf180mcu_as_sc_mcu7t3v3__fill_1
XPHY_EDGE_ROW_84_1_Right_593 VDD VSS gf180mcu_as_sc_mcu7t3v3__tap_2
XTAP_TAPCELL_ROW_147_1_1100 VDD VSS gf180mcu_as_sc_mcu7t3v3__tap_2
XFILLER_177_125 VDD VDD VSS VSS gf180mcu_as_sc_mcu7t3v3__fillcap_8
X_3812_ VDD VDD VSS VSS _3866_/B _4158_/D _3813_/C gf180mcu_as_sc_mcu7t3v3__and2_2
XANTENNA_16 VDD VDD VSS VSS _2912_/C gf180mcu_as_sc_mcu7t3v3__diode_2
XANTENNA_27 VDD VDD VSS VSS _4043_/B gf180mcu_as_sc_mcu7t3v3__diode_2
XANTENNA_38 VDD VDD VSS VSS _4147_/B gf180mcu_as_sc_mcu7t3v3__diode_2
X_4792_ VDD VDD VSS VSS _4803_/CLK _4792_/D _4792_/Q gf180mcu_as_sc_mcu7t3v3__dfxtp_2
XANTENNA_49 VDD VDD VSS VSS _4180_/A gf180mcu_as_sc_mcu7t3v3__diode_2
XFILLER_158_372 VDD VDD VSS VSS gf180mcu_as_sc_mcu7t3v3__fillcap_4
X_3743_ VDD VDD VSS VSS _4783_/Q _3806_/B _3743_/C _3743_/D _3744_/C gf180mcu_as_sc_mcu7t3v3__ao22_2
XFILLER_101_1319 VDD VDD VSS VSS gf180mcu_as_sc_mcu7t3v3__fillcap_4
X_3674_ VDD VDD VSS VSS _4033_/A _3882_/B _3674_/C _3674_/D _3675_/B gf180mcu_as_sc_mcu7t3v3__ao211_2
X_2625_ VDD VDD VSS VSS _4264_/D _4257_/A _2627_/C gf180mcu_as_sc_mcu7t3v3__or2_2
XFILLER_161_537 VDD VDD VSS VSS gf180mcu_as_sc_mcu7t3v3__fillcap_4
XFILLER_161_559 VDD VDD VSS VSS gf180mcu_as_sc_mcu7t3v3__fill_1
XFILLER_173_386 VDD VDD VSS VSS gf180mcu_as_sc_mcu7t3v3__fillcap_8
XFILLER_173_1122 VDD VDD VSS VSS gf180mcu_as_sc_mcu7t3v3__fillcap_16
X_2556_ VDD VDD VSS VSS _2556_/A _3446_/B _2556_/C _2556_/D _2557_/B gf180mcu_as_sc_mcu7t3v3__ao211_2
XPHY_EDGE_ROW_145_3_Right_186 VDD VSS gf180mcu_as_sc_mcu7t3v3__tap_2
X_2487_ VDD VDD VSS VSS _2487_/S _4819_/Q _4828_/Q _2490_/A gf180mcu_as_sc_mcu7t3v3__mux2_2
X_4226_ VDD VDD VSS VSS _4226_/A _4226_/B _4257_/C _4229_/B _4226_/D gf180mcu_as_sc_mcu7t3v3__aoi211_2
X_4157_ VDD VDD VSS VSS _4791_/Q _4208_/B _4208_/C _4157_/D _4161_/C gf180mcu_as_sc_mcu7t3v3__ao22_2
X_3108_ VDD VDD VSS VSS _3121_/S _4496_/Q _4495_/Q _4495_/D gf180mcu_as_sc_mcu7t3v3__mux2_2
XTAP_TAPCELL_ROW_161_1307 VDD VSS gf180mcu_as_sc_mcu7t3v3__tap_2
X_4088_ VDD VDD VSS VSS _4088_/A _4153_/B _4088_/C _4088_/D _4089_/C gf180mcu_as_sc_mcu7t3v3__ao211_2
XFILLER_102_34 VDD VDD VSS VSS gf180mcu_as_sc_mcu7t3v3__fill_1
X_3039_ VDD VDD VSS VSS _3162_/A _4288_/C _3039_/A gf180mcu_as_sc_mcu7t3v3__nand2b_2
XFILLER_184_1251 VDD VDD VSS VSS gf180mcu_as_sc_mcu7t3v3__fillcap_4
XFILLER_58_1276 VDD VDD VSS VSS gf180mcu_as_sc_mcu7t3v3__fill_1
XPHY_EDGE_ROW_110_1_Left_302 VDD VSS gf180mcu_as_sc_mcu7t3v3__tap_2
XTAP_TAPCELL_ROW_159_1269 VDD VSS gf180mcu_as_sc_mcu7t3v3__tap_2
XTAP_TAPCELL_ROW_159_1258 VDD VSS gf180mcu_as_sc_mcu7t3v3__tap_2
XFILLER_165_865 VDD VDD VSS VSS gf180mcu_as_sc_mcu7t3v3__fill_1
XFILLER_183_139 VDD VDD VSS VSS gf180mcu_as_sc_mcu7t3v3__fill_1
XTAP_TAPCELL_ROW_176_1594 VDD VSS gf180mcu_as_sc_mcu7t3v3__tap_2
XTAP_TAPCELL_ROW_176_1583 VDD VSS gf180mcu_as_sc_mcu7t3v3__tap_2
XFILLER_178_1033 VDD VDD VSS VSS gf180mcu_as_sc_mcu7t3v3__fillcap_16
XFILLER_180_802 VDD VDD VSS VSS gf180mcu_as_sc_mcu7t3v3__fill_2
XFILLER_11_64 VDD VDD VSS VSS gf180mcu_as_sc_mcu7t3v3__fillcap_4
XFILLER_117_1326 VDD VDD VSS VSS gf180mcu_as_sc_mcu7t3v3__fillcap_4
XFILLER_160_570 VDD VDD VSS VSS gf180mcu_as_sc_mcu7t3v3__fillcap_4
XTAP_TAPCELL_ROW_7_831 VDD VSS gf180mcu_as_sc_mcu7t3v3__tap_2
XTAP_TAPCELL_ROW_7_820 VDD VSS gf180mcu_as_sc_mcu7t3v3__tap_2
XPHY_EDGE_ROW_105_1_Left_297 VDD VSS gf180mcu_as_sc_mcu7t3v3__tap_2
XFILLER_41_1291 VDD VDD VSS VSS gf180mcu_as_sc_mcu7t3v3__fill_2
XFILLER_185_1037 VDD VDD VSS VSS gf180mcu_as_sc_mcu7t3v3__fillcap_8
XTAP_TAPCELL_ROW_27_1_980 VDD VSS gf180mcu_as_sc_mcu7t3v3__tap_2
XPHY_EDGE_ROW_42_1_Left_234 VDD VSS gf180mcu_as_sc_mcu7t3v3__tap_2
XFILLER_188_924 VDD VDD VSS VSS gf180mcu_as_sc_mcu7t3v3__fillcap_8
XFILLER_159_136 VDD VDD VSS VSS gf180mcu_as_sc_mcu7t3v3__fillcap_4
XFILLER_159_158 VDD VDD VSS VSS gf180mcu_as_sc_mcu7t3v3__fillcap_16
XFILLER_174_117 VDD VDD VSS VSS gf180mcu_as_sc_mcu7t3v3__fill_1
XFILLER_175_629 VDD VDD VSS VSS gf180mcu_as_sc_mcu7t3v3__fill_1
XFILLER_156_832 VDD VDD VSS VSS gf180mcu_as_sc_mcu7t3v3__fillcap_16
XFILLER_183_640 VDD VDD VSS VSS gf180mcu_as_sc_mcu7t3v3__fillcap_4
XFILLER_7_842 VDD VDD VSS VSS gf180mcu_as_sc_mcu7t3v3__fillcap_16
Xinput14 VDD VDD VSS VSS boot_data[2] _2453_/A gf180mcu_as_sc_mcu7t3v3__buff_12
Xinput25 VDD VDD VSS VSS dft_addr[2] _2377_/A gf180mcu_as_sc_mcu7t3v3__buff_12
Xinput36 VDD VDD VSS VSS dft_wdata[1] _2446_/B gf180mcu_as_sc_mcu7t3v3__buff_12
Xinput47 VDD VDD VSS VSS east_in[12] _4100_/D gf180mcu_as_sc_mcu7t3v3__buff_12
Xinput58 VDD VDD VSS VSS east_in[22] _4183_/D gf180mcu_as_sc_mcu7t3v3__buff_12
Xinput69 VDD VDD VSS VSS east_in[32] _3943_/A gf180mcu_as_sc_mcu7t3v3__buff_12
Xwire773 VDD VDD VSS VSS wire773/A _4036_/D gf180mcu_as_sc_mcu7t3v3__clkbuff_12
XFILLER_100_1352 VDD VDD VSS VSS gf180mcu_as_sc_mcu7t3v3__fill_2
XFILLER_192_1019 VDD VDD VSS VSS gf180mcu_as_sc_mcu7t3v3__fill_1
Xmax_cap528 VDD VDD VSS VSS fanout527/Y _4227_/C gf180mcu_as_sc_mcu7t3v3__clkbuff_12
X_2410_ VDD VDD VSS VSS _2425_/B _4485_/Q _4549_/Q _2413_/B gf180mcu_as_sc_mcu7t3v3__mux2_2
XFILLER_184_70 VDD VDD VSS VSS gf180mcu_as_sc_mcu7t3v3__fill_1
X_3390_ VDD VDD VSS VSS _3393_/A _4440_/Q _4382_/Q _3391_/A gf180mcu_as_sc_mcu7t3v3__mux2_2
X_2341_ VDD VDD VSS VSS _2342_/C _2341_/B _3602_/B gf180mcu_as_sc_mcu7t3v3__nor2_2
X_2272_ VDD VDD VSS VSS _2296_/B _2556_/A gf180mcu_as_sc_mcu7t3v3__inv_2
X_4011_ VDD VDD VSS VSS _4011_/B _4011_/A _4693_/D gf180mcu_as_sc_mcu7t3v3__and2_2
XFILLER_20_1331 VDD VDD VSS VSS gf180mcu_as_sc_mcu7t3v3__fillcap_4
XPHY_EDGE_ROW_85_1_Right_594 VDD VSS gf180mcu_as_sc_mcu7t3v3__tap_2
XFILLER_20_1353 VDD VDD VSS VSS gf180mcu_as_sc_mcu7t3v3__fill_2
XFILLER_179_924 VDD VDD VSS VSS gf180mcu_as_sc_mcu7t3v3__fill_1
XPHY_EDGE_ROW_99_1_Left_291 VDD VSS gf180mcu_as_sc_mcu7t3v3__tap_2
XPHY_EDGE_ROW_54_3_Right_95 VDD VSS gf180mcu_as_sc_mcu7t3v3__tap_2
XFILLER_179_979 VDD VDD VSS VSS gf180mcu_as_sc_mcu7t3v3__fill_1
XFILLER_178_478 VDD VDD VSS VSS gf180mcu_as_sc_mcu7t3v3__fillcap_8
XFILLER_187_990 VDD VDD VSS VSS gf180mcu_as_sc_mcu7t3v3__fill_1
X_4775_ VDD VDD VSS VSS _4783_/CLK _4775_/D _4775_/Q gf180mcu_as_sc_mcu7t3v3__dfxtp_2
X_3726_ VDD VDD VSS VSS _4781_/Q _3806_/B _3808_/C _4076_/D _3727_/D gf180mcu_as_sc_mcu7t3v3__ao22_2
XPHY_EDGE_ROW_57_3_Left_429 VDD VSS gf180mcu_as_sc_mcu7t3v3__tap_2
XFILLER_105_1296 VDD VDD VSS VSS gf180mcu_as_sc_mcu7t3v3__fillcap_4
XFILLER_180_109 VDD VDD VSS VSS gf180mcu_as_sc_mcu7t3v3__fill_1
XFILLER_161_312 VDD VDD VSS VSS gf180mcu_as_sc_mcu7t3v3__fill_1
XFILLER_162_846 VDD VDD VSS VSS gf180mcu_as_sc_mcu7t3v3__fillcap_8
X_3657_ VDD VDD VSS VSS _3747_/S _3657_/B _4018_/A _3658_/B gf180mcu_as_sc_mcu7t3v3__mux2_2
XTAP_TAPCELL_ROW_154_1177 VDD VSS gf180mcu_as_sc_mcu7t3v3__tap_2
XTAP_TAPCELL_ROW_154_1166 VDD VSS gf180mcu_as_sc_mcu7t3v3__tap_2
XFILLER_164_18 VDD VDD VSS VSS gf180mcu_as_sc_mcu7t3v3__fillcap_16
X_3588_ VDD VDD VSS VSS _3604_/A _3588_/A _4648_/D gf180mcu_as_sc_mcu7t3v3__and2_2
X_2608_ VDD VDD VSS VSS _3978_/A _3613_/B _3965_/B gf180mcu_as_sc_mcu7t3v3__nand2_2
XTAP_TAPCELL_ROW_171_1491 VDD VSS gf180mcu_as_sc_mcu7t3v3__tap_2
XFILLER_161_389 VDD VDD VSS VSS gf180mcu_as_sc_mcu7t3v3__fillcap_16
X_2539_ VDD VDD VSS VSS _2543_/D _3447_/A _3611_/B gf180mcu_as_sc_mcu7t3v3__nor2_2
XPHY_EDGE_ROW_146_3_Right_187 VDD VSS gf180mcu_as_sc_mcu7t3v3__tap_2
XFILLER_64_1280 VDD VDD VSS VSS gf180mcu_as_sc_mcu7t3v3__fill_2
XFILLER_64_1291 VDD VDD VSS VSS gf180mcu_as_sc_mcu7t3v3__fill_2
X_4209_ VDD VDD VSS VSS _4209_/A _4209_/B _4209_/C _4211_/C _4209_/D gf180mcu_as_sc_mcu7t3v3__aoi31_2
XTAP_TAPCELL_ROW_54_1_1007 VDD VSS gf180mcu_as_sc_mcu7t3v3__tap_2
XFILLER_186_1313 VDD VDD VSS VSS gf180mcu_as_sc_mcu7t3v3__fillcap_16
XFILLER_189_26 VDD VDD VSS VSS gf180mcu_as_sc_mcu7t3v3__fill_2
XTAP_TAPCELL_ROW_178_1623 VDD VSS gf180mcu_as_sc_mcu7t3v3__tap_2
XTAP_TAPCELL_ROW_178_1634 VDD VSS gf180mcu_as_sc_mcu7t3v3__tap_2
XTAP_TAPCELL_ROW_82_3_1993 VDD VSS gf180mcu_as_sc_mcu7t3v3__tap_2
XFILLER_11_167 VDD VDD VSS VSS gf180mcu_as_sc_mcu7t3v3__fill_1
XFILLER_32_1279 VDD VDD VSS VSS gf180mcu_as_sc_mcu7t3v3__fill_1
XTAP_TAPCELL_ROW_191_1867 VDD VSS gf180mcu_as_sc_mcu7t3v3__tap_2
XFILLER_164_172 VDD VDD VSS VSS gf180mcu_as_sc_mcu7t3v3__fill_2
XTAP_TAPCELL_ROW_191_1878 VDD VSS gf180mcu_as_sc_mcu7t3v3__tap_2
XFILLER_78_101 VDD VDD VSS VSS gf180mcu_as_sc_mcu7t3v3__fillcap_4
XFILLER_161_890 VDD VDD VSS VSS gf180mcu_as_sc_mcu7t3v3__fillcap_4
XFILLER_191_1052 VDD VDD VSS VSS gf180mcu_as_sc_mcu7t3v3__fillcap_16
XFILLER_163_1110 VDD VDD VSS VSS gf180mcu_as_sc_mcu7t3v3__fill_1
X_2890_ VDD VDD VSS VSS _4356_/Q _2906_/B _3002_/A _2906_/D _4356_/D gf180mcu_as_sc_mcu7t3v3__ao22_2
XFILLER_175_415 VDD VDD VSS VSS gf180mcu_as_sc_mcu7t3v3__fillcap_4
XFILLER_8_10 VDD VDD VSS VSS gf180mcu_as_sc_mcu7t3v3__fill_2
X_4560_ VDD VDD VSS VSS _4807_/CLK _4560_/D _4560_/Q gf180mcu_as_sc_mcu7t3v3__dfxtp_2
XFILLER_155_150 VDD VDD VSS VSS gf180mcu_as_sc_mcu7t3v3__fill_2
XFILLER_156_662 VDD VDD VSS VSS gf180mcu_as_sc_mcu7t3v3__fill_2
XFILLER_184_971 VDD VDD VSS VSS gf180mcu_as_sc_mcu7t3v3__fillcap_16
XFILLER_183_492 VDD VDD VSS VSS gf180mcu_as_sc_mcu7t3v3__fillcap_8
X_4491_ VDD VDD VSS VSS _4708_/CLK _4491_/D _4491_/Q gf180mcu_as_sc_mcu7t3v3__dfxtp_2
X_3511_ VDD VDD VSS VSS _4604_/Q _3513_/D _3546_/D _3511_/D _4604_/D gf180mcu_as_sc_mcu7t3v3__ao211_2
XFILLER_171_643 VDD VDD VSS VSS gf180mcu_as_sc_mcu7t3v3__fill_2
XFILLER_6_193 VDD VDD VSS VSS gf180mcu_as_sc_mcu7t3v3__fill_2
X_3442_ VDD VDD VSS VSS _4571_/Q _3443_/B _3442_/C _4570_/Q _4570_/D gf180mcu_as_sc_mcu7t3v3__ao22_2
XFILLER_171_698 VDD VDD VSS VSS gf180mcu_as_sc_mcu7t3v3__fill_2
X_3373_ VDD VDD VSS VSS _3373_/B _4457_/Q _3380_/D gf180mcu_as_sc_mcu7t3v3__and2_2
XFILLER_170_1114 VDD VDD VSS VSS gf180mcu_as_sc_mcu7t3v3__fillcap_4
X_2324_ VDD VDD VSS VSS _2324_/B _2342_/A _2324_/Y gf180mcu_as_sc_mcu7t3v3__and2_2
XFILLER_135_1256 VDD VDD VSS VSS gf180mcu_as_sc_mcu7t3v3__fillcap_16
XFILLER_170_1147 VDD VDD VSS VSS gf180mcu_as_sc_mcu7t3v3__fill_1
X_2255_ VDD VDD VSS VSS _2255_/B _4543_/Q _2298_/B gf180mcu_as_sc_mcu7t3v3__and2_2
X_2186_ VDD VDD VSS VSS _4260_/A _3921_/A gf180mcu_as_sc_mcu7t3v3__inv_2
XFILLER_168_1021 VDD VDD VSS VSS gf180mcu_as_sc_mcu7t3v3__fill_2
XPHY_EDGE_ROW_86_1_Right_595 VDD VSS gf180mcu_as_sc_mcu7t3v3__tap_2
XFILLER_168_1065 VDD VDD VSS VSS gf180mcu_as_sc_mcu7t3v3__fill_1
XTAP_TAPCELL_ROW_115_1_1068 VDD VSS gf180mcu_as_sc_mcu7t3v3__tap_2
XFILLER_168_1087 VDD VDD VSS VSS gf180mcu_as_sc_mcu7t3v3__fillcap_16
XFILLER_181_1221 VDD VDD VSS VSS gf180mcu_as_sc_mcu7t3v3__fillcap_8
XFILLER_178_220 VDD VDD VSS VSS gf180mcu_as_sc_mcu7t3v3__fillcap_16
X_4827_ VDD VDD VSS VSS _4828_/CLK _4827_/D _4827_/Q gf180mcu_as_sc_mcu7t3v3__dfxtp_2
XTAP_TAPCELL_ROW_156_1206 VDD VSS gf180mcu_as_sc_mcu7t3v3__tap_2
XTAP_TAPCELL_ROW_156_1217 VDD VSS gf180mcu_as_sc_mcu7t3v3__tap_2
XFILLER_175_960 VDD VDD VSS VSS gf180mcu_as_sc_mcu7t3v3__fillcap_16
XFILLER_175_982 VDD VDD VSS VSS gf180mcu_as_sc_mcu7t3v3__fillcap_4
X_4758_ VDD VDD VSS VSS clkload3/A _4758_/D _4758_/Q gf180mcu_as_sc_mcu7t3v3__dfxtp_2
XTAP_TAPCELL_ROW_173_1542 VDD VSS gf180mcu_as_sc_mcu7t3v3__tap_2
XTAP_TAPCELL_ROW_173_1531 VDD VSS gf180mcu_as_sc_mcu7t3v3__tap_2
X_4689_ VDD VDD VSS VSS _4692_/CLK _4689_/D _4689_/Q gf180mcu_as_sc_mcu7t3v3__dfxtp_2
X_3709_ VDD VDD VSS VSS _3709_/D _3926_/D _3709_/B _3709_/C _3710_/D gf180mcu_as_sc_mcu7t3v3__ao31_2
XFILLER_161_142 VDD VDD VSS VSS gf180mcu_as_sc_mcu7t3v3__fillcap_4
XFILLER_175_1047 VDD VDD VSS VSS gf180mcu_as_sc_mcu7t3v3__fill_2
XFILLER_161_197 VDD VDD VSS VSS gf180mcu_as_sc_mcu7t3v3__fillcap_4
Xinput204 VDD VDD VSS VSS se_in[23] wire791/A gf180mcu_as_sc_mcu7t3v3__buff_12
Xinput215 VDD VDD VSS VSS se_in[33] _3948_/A gf180mcu_as_sc_mcu7t3v3__buff_12
Xinput226 VDD VDD VSS VSS south_in[10] _4084_/A gf180mcu_as_sc_mcu7t3v3__buff_12
XPHY_EDGE_ROW_147_3_Right_188 VDD VSS gf180mcu_as_sc_mcu7t3v3__tap_2
Xinput237 VDD VDD VSS VSS south_in[20] _4165_/A gf180mcu_as_sc_mcu7t3v3__buff_12
Xinput248 VDD VDD VSS VSS south_in[30] _4256_/A gf180mcu_as_sc_mcu7t3v3__buff_12
Xinput259 VDD VDD VSS VSS south_in[8] _4068_/A gf180mcu_as_sc_mcu7t3v3__buff_12
XFILLER_186_1110 VDD VDD VSS VSS gf180mcu_as_sc_mcu7t3v3__fillcap_8
XFILLER_186_1154 VDD VDD VSS VSS gf180mcu_as_sc_mcu7t3v3__fill_1
XFILLER_140_53 VDD VDD VSS VSS gf180mcu_as_sc_mcu7t3v3__fillcap_8
XFILLER_169_242 VDD VDD VSS VSS gf180mcu_as_sc_mcu7t3v3__fillcap_16
XFILLER_12_454 VDD VDD VSS VSS gf180mcu_as_sc_mcu7t3v3__fill_1
XFILLER_185_702 VDD VDD VSS VSS gf180mcu_as_sc_mcu7t3v3__fillcap_16
XFILLER_9_926 VDD VDD VSS VSS gf180mcu_as_sc_mcu7t3v3__fillcap_16
XFILLER_13_988 VDD VDD VSS VSS gf180mcu_as_sc_mcu7t3v3__fillcap_4
XFILLER_173_908 VDD VDD VSS VSS gf180mcu_as_sc_mcu7t3v3__fill_2
XFILLER_185_768 VDD VDD VSS VSS gf180mcu_as_sc_mcu7t3v3__fill_2
XTAP_TAPCELL_ROW_30_3_1941 VDD VSS gf180mcu_as_sc_mcu7t3v3__tap_2
XFILLER_153_610 VDD VDD VSS VSS gf180mcu_as_sc_mcu7t3v3__fill_2
XFILLER_153_632 VDD VDD VSS VSS gf180mcu_as_sc_mcu7t3v3__fillcap_4
XFILLER_152_120 VDD VDD VSS VSS gf180mcu_as_sc_mcu7t3v3__fillcap_16
XFILLER_153_654 VDD VDD VSS VSS gf180mcu_as_sc_mcu7t3v3__fill_1
XFILLER_165_492 VDD VDD VSS VSS gf180mcu_as_sc_mcu7t3v3__fillcap_16
XFILLER_153_687 VDD VDD VSS VSS gf180mcu_as_sc_mcu7t3v3__fill_2
XFILLER_180_473 VDD VDD VSS VSS gf180mcu_as_sc_mcu7t3v3__fillcap_8
XFILLER_165_83 VDD VDD VSS VSS gf180mcu_as_sc_mcu7t3v3__fill_2
XFILLER_0_881 VDD VDD VSS VSS gf180mcu_as_sc_mcu7t3v3__fill_2
XFILLER_78_1268 VDD VDD VSS VSS gf180mcu_as_sc_mcu7t3v3__fill_2
X_3991_ VDD VDD VSS VSS _4772_/Q _4134_/B _4216_/A _3991_/D _3992_/C gf180mcu_as_sc_mcu7t3v3__ao22_2
XPHY_EDGE_ROW_109_3_Right_150 VDD VSS gf180mcu_as_sc_mcu7t3v3__tap_2
X_2942_ VDD VDD VSS VSS _4370_/Q _2945_/C _3018_/A _2945_/B _4370_/D gf180mcu_as_sc_mcu7t3v3__ao22_2
XFILLER_175_212 VDD VDD VSS VSS gf180mcu_as_sc_mcu7t3v3__fillcap_8
X_2873_ VDD VDD VSS VSS _2917_/B _4193_/A _2877_/C gf180mcu_as_sc_mcu7t3v3__and2_2
XFILLER_163_407 VDD VDD VSS VSS gf180mcu_as_sc_mcu7t3v3__fill_1
X_4612_ VDD VDD VSS VSS _4828_/CLK _4612_/D _4612_/Q gf180mcu_as_sc_mcu7t3v3__dfxtp_2
XFILLER_175_278 VDD VDD VSS VSS gf180mcu_as_sc_mcu7t3v3__fill_2
XFILLER_176_1312 VDD VDD VSS VSS gf180mcu_as_sc_mcu7t3v3__fillcap_4
X_4543_ VDD VDD VSS VSS _4726_/CLK _4543_/D _4543_/Q gf180mcu_as_sc_mcu7t3v3__dfxtp_2
X_4474_ VDD VDD VSS VSS _4576_/CLK _4474_/D _4474_/Q gf180mcu_as_sc_mcu7t3v3__dfxtp_2
X_3425_ VDD VDD VSS VSS _4554_/Q _3449_/D _3444_/C _4553_/Q _4553_/D gf180mcu_as_sc_mcu7t3v3__ao22_2
Xsram2048.u_bank0 _2424_/Y _2420_/Y _2415_/Y _2406_/Y _2399_/Y _2390_/Y _2377_/Y _2360_/Y
+ _2352_/Y hold1056/Y clkbuf_1_0__f_clk/Y _2494_/Y _2486_/Y _2478_/Y _2470_/Y _2462_/Y
+ _2454_/Y _2446_/Y _2438_/Y _2345_/Y _2501_/A _2500_/A _2499_/A _2498_/A _2497_/A
+ _2496_/A _2495_/A _2230_/A VDD VSS sram2048.u_bank0/WEN[7] sram2048.u_bank0/WEN[6]
+ sram2048.u_bank0/WEN[5] sram2048.u_bank0/WEN[4] sram2048.u_bank0/WEN[3] sram2048.u_bank0/WEN[2]
+ sram2048.u_bank0/WEN[1] sram2048.u_bank0/WEN[0] _2428_/Y gf180mcu_ocd_ip_sram__sram1024x8m8wm1
X_3356_ VDD VDD VSS VSS _3412_/A _3356_/B _3356_/C _3356_/D _4535_/D gf180mcu_as_sc_mcu7t3v3__ao211_2
XTAP_TAPCELL_ROW_134_3_2045 VDD VSS gf180mcu_as_sc_mcu7t3v3__tap_2
XFILLER_57_104 VDD VDD VSS VSS gf180mcu_as_sc_mcu7t3v3__fill_1
Xhold1103 VDD VDD VSS VSS _4826_/Q hold1103/Y gf180mcu_as_sc_mcu7t3v3__clkbuff_4
X_3287_ VDD VDD VSS VSS _3290_/C _4427_/Q _3344_/S gf180mcu_as_sc_mcu7t3v3__nand2_2
X_2307_ VDD VDD VSS VSS _4811_/Q _4640_/Q _2307_/B _3527_/A _2309_/C gf180mcu_as_sc_mcu7t3v3__ao31_2
X_2238_ VDD VDD VSS VSS _3080_/A _3572_/B _3458_/A gf180mcu_as_sc_mcu7t3v3__nand2_2
XFILLER_22_1256 VDD VDD VSS VSS gf180mcu_as_sc_mcu7t3v3__fillcap_4
XPHY_EDGE_ROW_87_1_Right_596 VDD VSS gf180mcu_as_sc_mcu7t3v3__tap_2
XFILLER_167_702 VDD VDD VSS VSS gf180mcu_as_sc_mcu7t3v3__fillcap_4
XFILLER_179_562 VDD VDD VSS VSS gf180mcu_as_sc_mcu7t3v3__fill_2
XTAP_TAPCELL_ROW_49_1_1002 VDD VSS gf180mcu_as_sc_mcu7t3v3__tap_2
XFILLER_167_735 VDD VDD VSS VSS gf180mcu_as_sc_mcu7t3v3__fillcap_8
XFILLER_10_947 VDD VDD VSS VSS gf180mcu_as_sc_mcu7t3v3__fill_2
XFILLER_155_908 VDD VDD VSS VSS gf180mcu_as_sc_mcu7t3v3__fill_2
XFILLER_155_919 VDD VDD VSS VSS gf180mcu_as_sc_mcu7t3v3__fillcap_8
XPHY_EDGE_ROW_17_3_Right_58 VDD VSS gf180mcu_as_sc_mcu7t3v3__tap_2
XFILLER_119_54 VDD VDD VSS VSS gf180mcu_as_sc_mcu7t3v3__fillcap_16
XFILLER_119_87 VDD VDD VSS VSS gf180mcu_as_sc_mcu7t3v3__fill_2
XFILLER_5_439 VDD VDD VSS VSS gf180mcu_as_sc_mcu7t3v3__fill_1
XPHY_EDGE_ROW_51_1_Left_243 VDD VSS gf180mcu_as_sc_mcu7t3v3__tap_2
XFILLER_162_484 VDD VDD VSS VSS gf180mcu_as_sc_mcu7t3v3__fillcap_16
XFILLER_0_144 VDD VDD VSS VSS gf180mcu_as_sc_mcu7t3v3__fill_1
XFILLER_118_1295 VDD VDD VSS VSS gf180mcu_as_sc_mcu7t3v3__fill_2
XFILLER_192_2 VDD VDD VSS VSS gf180mcu_as_sc_mcu7t3v3__fillcap_16
XFILLER_48_104 VDD VDD VSS VSS gf180mcu_as_sc_mcu7t3v3__fill_1
XTAP_TAPCELL_ROW_186_1777 VDD VSS gf180mcu_as_sc_mcu7t3v3__tap_2
XPHY_EDGE_ROW_148_3_Right_189 VDD VSS gf180mcu_as_sc_mcu7t3v3__tap_2
XFILLER_188_1227 VDD VDD VSS VSS gf180mcu_as_sc_mcu7t3v3__fillcap_8
XTAP_TAPCELL_ROW_186_1788 VDD VSS gf180mcu_as_sc_mcu7t3v3__tap_2
XPHY_EDGE_ROW_134_3_Left_506 VDD VSS gf180mcu_as_sc_mcu7t3v3__tap_2
XFILLER_77_1290 VDD VDD VSS VSS gf180mcu_as_sc_mcu7t3v3__fill_1
XFILLER_158_713 VDD VDD VSS VSS gf180mcu_as_sc_mcu7t3v3__fillcap_4
XFILLER_157_212 VDD VDD VSS VSS gf180mcu_as_sc_mcu7t3v3__fillcap_16
XFILLER_158_746 VDD VDD VSS VSS gf180mcu_as_sc_mcu7t3v3__fill_1
XFILLER_185_521 VDD VDD VSS VSS gf180mcu_as_sc_mcu7t3v3__fillcap_16
XFILLER_160_1157 VDD VDD VSS VSS gf180mcu_as_sc_mcu7t3v3__fillcap_16
XFILLER_8_299 VDD VDD VSS VSS gf180mcu_as_sc_mcu7t3v3__fillcap_4
XFILLER_5_962 VDD VDD VSS VSS gf180mcu_as_sc_mcu7t3v3__fillcap_4
XFILLER_10_1193 VDD VDD VSS VSS gf180mcu_as_sc_mcu7t3v3__fillcap_4
XFILLER_171_1242 VDD VDD VSS VSS gf180mcu_as_sc_mcu7t3v3__fill_1
XFILLER_192_70 VDD VDD VSS VSS gf180mcu_as_sc_mcu7t3v3__fillcap_4
X_4190_ VDD VDD VSS VSS _4234_/C _4190_/A _4191_/C gf180mcu_as_sc_mcu7t3v3__and2_2
X_3210_ VDD VDD VSS VSS _4515_/D _3210_/C _3210_/B _3210_/A gf180mcu_as_sc_mcu7t3v3__aoi21_2
XFILLER_39_104 VDD VDD VSS VSS gf180mcu_as_sc_mcu7t3v3__fill_1
X_3141_ VDD VDD VSS VSS _3408_/A _3141_/B _3141_/C _3164_/C _3141_/D gf180mcu_as_sc_mcu7t3v3__aoi31_2
X_3072_ VDD VDD VSS VSS _3079_/S _3540_/A _4470_/Q _4470_/D gf180mcu_as_sc_mcu7t3v3__mux2_2
XPHY_EDGE_ROW_66_3_Left_438 VDD VSS gf180mcu_as_sc_mcu7t3v3__tap_2
X_3974_ VDD VDD VSS VSS _3974_/Y _4264_/B _3974_/B _3987_/A _3974_/D gf180mcu_as_sc_mcu7t3v3__aoi22_2
X_2925_ VDD VDD VSS VSS _2965_/D _3009_/A _2965_/B _4361_/Q _4361_/D gf180mcu_as_sc_mcu7t3v3__ao22_2
XFILLER_176_543 VDD VDD VSS VSS gf180mcu_as_sc_mcu7t3v3__fillcap_16
X_2856_ VDD VDD VSS VSS _4793_/Q _2892_/B _2894_/B _4174_/A _2858_/C gf180mcu_as_sc_mcu7t3v3__ao22_2
XFILLER_91_1298 VDD VDD VSS VSS gf180mcu_as_sc_mcu7t3v3__fill_1
XFILLER_163_204 VDD VDD VSS VSS gf180mcu_as_sc_mcu7t3v3__fillcap_4
XFILLER_191_524 VDD VDD VSS VSS gf180mcu_as_sc_mcu7t3v3__fillcap_16
XFILLER_163_248 VDD VDD VSS VSS gf180mcu_as_sc_mcu7t3v3__fill_2
X_2787_ VDD VDD VSS VSS _4112_/D _2823_/B _2787_/C _2796_/D _2788_/C gf180mcu_as_sc_mcu7t3v3__ao211_2
XFILLER_160_900 VDD VDD VSS VSS gf180mcu_as_sc_mcu7t3v3__fill_1
X_4526_ VDD VDD VSS VSS _4789_/CLK _4526_/D _4526_/Q gf180mcu_as_sc_mcu7t3v3__dfxtp_2
XFILLER_172_793 VDD VDD VSS VSS gf180mcu_as_sc_mcu7t3v3__fillcap_8
X_4457_ VDD VDD VSS VSS _4576_/CLK _4457_/D _4457_/Q gf180mcu_as_sc_mcu7t3v3__dfxtp_2
Xfanout713 VDD VDD VSS VSS _3049_/B _3062_/S gf180mcu_as_sc_mcu7t3v3__buff_12
Xfanout724 VDD VDD VSS VSS _3505_/A _3571_/D gf180mcu_as_sc_mcu7t3v3__buff_12
X_3408_ VDD VDD VSS VSS _3409_/C _3408_/A _4355_/Q _3408_/C gf180mcu_as_sc_mcu7t3v3__ao21_2
Xfanout735 VDD VDD VSS VSS _3330_/A _3306_/A gf180mcu_as_sc_mcu7t3v3__buff_12
Xfanout746 VDD VDD VSS VSS _3328_/S _3304_/S gf180mcu_as_sc_mcu7t3v3__buff_12
Xfanout757 VDD VDD VSS VSS _3884_/A _3748_/A gf180mcu_as_sc_mcu7t3v3__buff_12
X_4388_ VDD VDD VSS VSS _4447_/CLK _4388_/D _4388_/Q gf180mcu_as_sc_mcu7t3v3__dfxtp_2
XTAP_TAPCELL_ROW_168_1441 VDD VSS gf180mcu_as_sc_mcu7t3v3__tap_2
XTAP_TAPCELL_ROW_168_1430 VDD VSS gf180mcu_as_sc_mcu7t3v3__tap_2
X_3339_ VDD VDD VSS VSS _4533_/Q _3347_/B _3347_/C _4534_/Q _3340_/C gf180mcu_as_sc_mcu7t3v3__ao22_2
XFILLER_6_1294 VDD VDD VSS VSS gf180mcu_as_sc_mcu7t3v3__fill_1
XTAP_TAPCELL_ROW_181_1685 VDD VSS gf180mcu_as_sc_mcu7t3v3__tap_2
XFILLER_121_55 VDD VDD VSS VSS gf180mcu_as_sc_mcu7t3v3__fillcap_4
XPHY_EDGE_ROW_88_1_Right_597 VDD VSS gf180mcu_as_sc_mcu7t3v3__tap_2
XFILLER_121_99 VDD VDD VSS VSS gf180mcu_as_sc_mcu7t3v3__fillcap_4
XFILLER_148_1288 VDD VDD VSS VSS gf180mcu_as_sc_mcu7t3v3__fill_1
XFILLER_10_766 VDD VDD VSS VSS gf180mcu_as_sc_mcu7t3v3__fillcap_16
XFILLER_6_737 VDD VDD VSS VSS gf180mcu_as_sc_mcu7t3v3__fillcap_16
XFILLER_146_30 VDD VDD VSS VSS gf180mcu_as_sc_mcu7t3v3__fillcap_4
XFILLER_30_52 VDD VDD VSS VSS gf180mcu_as_sc_mcu7t3v3__fill_2
XFILLER_68_1256 VDD VDD VSS VSS gf180mcu_as_sc_mcu7t3v3__fillcap_8
XFILLER_2_943 VDD VDD VSS VSS gf180mcu_as_sc_mcu7t3v3__fill_2
XTAP_TAPCELL_ROW_188_1817 VDD VSS gf180mcu_as_sc_mcu7t3v3__tap_2
XFILLER_146_96 VDD VDD VSS VSS gf180mcu_as_sc_mcu7t3v3__fillcap_8
XFILLER_39_61 VDD VDD VSS VSS gf180mcu_as_sc_mcu7t3v3__fill_2
XFILLER_39_72 VDD VDD VSS VSS gf180mcu_as_sc_mcu7t3v3__fill_2
XFILLER_188_1013 VDD VDD VSS VSS gf180mcu_as_sc_mcu7t3v3__fill_2
XTAP_TAPCELL_ROW_5_792 VDD VSS gf180mcu_as_sc_mcu7t3v3__tap_2
XTAP_TAPCELL_ROW_5_781 VDD VSS gf180mcu_as_sc_mcu7t3v3__tap_2
XFILLER_166_1322 VDD VDD VSS VSS gf180mcu_as_sc_mcu7t3v3__fillcap_16
XTAP_TAPCELL_ROW_17_3_1928 VDD VSS gf180mcu_as_sc_mcu7t3v3__tap_2
XFILLER_158_565 VDD VDD VSS VSS gf180mcu_as_sc_mcu7t3v3__fillcap_4
X_2710_ VDD VDD VSS VSS _4777_/Q _2810_/B _2915_/B _4045_/D _2712_/C gf180mcu_as_sc_mcu7t3v3__ao22_2
XFILLER_158_587 VDD VDD VSS VSS gf180mcu_as_sc_mcu7t3v3__fill_1
X_3690_ VDD VDD VSS VSS _3692_/C _4047_/A _3929_/B _3690_/C gf180mcu_as_sc_mcu7t3v3__ao21_2
X_2641_ VDD VDD VSS VSS _3948_/A _3958_/A _3959_/A _4267_/C gf180mcu_as_sc_mcu7t3v3__nor3_2
X_2572_ VDD VDD VSS VSS _3516_/B _3585_/A _2583_/B gf180mcu_as_sc_mcu7t3v3__and2_2
XFILLER_173_1326 VDD VDD VSS VSS gf180mcu_as_sc_mcu7t3v3__fillcap_4
Xoutput349 VDD VDD VSS VSS _4710_/Q east_out[17] gf180mcu_as_sc_mcu7t3v3__buff_12
Xoutput338 VDD VDD VSS VSS _5074_/Y dft_rdata[5] gf180mcu_as_sc_mcu7t3v3__buff_12
X_4311_ VDD VDD VSS VSS _4312_/B _4535_/Q _4788_/D gf180mcu_as_sc_mcu7t3v3__and2_2
X_4242_ VDD VDD VSS VSS _4242_/A _4263_/B _4263_/C _4242_/D _4243_/B gf180mcu_as_sc_mcu7t3v3__ao22_2
XFILLER_171_1072 VDD VDD VSS VSS gf180mcu_as_sc_mcu7t3v3__fillcap_4
X_4173_ VDD VDD VSS VSS _4793_/Q _4208_/B _4208_/C _4173_/D _4177_/C gf180mcu_as_sc_mcu7t3v3__ao22_2
X_3124_ VDD VDD VSS VSS _3124_/S _3124_/B _4510_/Q _4510_/D gf180mcu_as_sc_mcu7t3v3__mux2_2
XFILLER_110_1332 VDD VDD VSS VSS gf180mcu_as_sc_mcu7t3v3__fillcap_16
X_3055_ VDD VDD VSS VSS _3061_/S _3540_/A _4454_/Q _4454_/D gf180mcu_as_sc_mcu7t3v3__mux2_2
XFILLER_110_1354 VDD VDD VSS VSS gf180mcu_as_sc_mcu7t3v3__fill_1
XTAP_TAPCELL_ROW_129_3_2040 VDD VSS gf180mcu_as_sc_mcu7t3v3__tap_2
XFILLER_169_808 VDD VDD VSS VSS gf180mcu_as_sc_mcu7t3v3__fill_2
XFILLER_177_830 VDD VDD VSS VSS gf180mcu_as_sc_mcu7t3v3__fillcap_8
X_3957_ VDD VDD VSS VSS _3958_/C _3957_/B _3957_/A gf180mcu_as_sc_mcu7t3v3__nand2_2
XFILLER_108_1272 VDD VDD VSS VSS gf180mcu_as_sc_mcu7t3v3__fillcap_16
Xclkbuf_0_clk_regs VDD VDD VSS VSS clkbuf_regs_0_clk/Y clkbuf_0_clk_regs/Y gf180mcu_as_sc_mcu7t3v3__clkbuff_12
X_2908_ VDD VDD VSS VSS _4224_/D _2918_/B _2915_/B _4226_/A _2910_/C gf180mcu_as_sc_mcu7t3v3__ao22_2
XFILLER_164_524 VDD VDD VSS VSS gf180mcu_as_sc_mcu7t3v3__fill_1
XFILLER_176_362 VDD VDD VSS VSS gf180mcu_as_sc_mcu7t3v3__fillcap_16
XFILLER_176_384 VDD VDD VSS VSS gf180mcu_as_sc_mcu7t3v3__fill_1
X_3888_ VDD VDD VSS VSS _3919_/A _3927_/C _3927_/B _4799_/Q gf180mcu_as_sc_mcu7t3v3__aoi21_2
XFILLER_164_546 VDD VDD VSS VSS gf180mcu_as_sc_mcu7t3v3__fillcap_4
X_2839_ VDD VDD VSS VSS _2893_/B _4158_/D _2840_/D gf180mcu_as_sc_mcu7t3v3__and2_2
XFILLER_178_1259 VDD VDD VSS VSS gf180mcu_as_sc_mcu7t3v3__fillcap_16
XFILLER_192_877 VDD VDD VSS VSS gf180mcu_as_sc_mcu7t3v3__fillcap_4
XFILLER_104_101 VDD VDD VSS VSS gf180mcu_as_sc_mcu7t3v3__fillcap_4
XFILLER_2_228 VDD VDD VSS VSS gf180mcu_as_sc_mcu7t3v3__fillcap_4
X_4509_ VDD VDD VSS VSS _4726_/CLK _4509_/D _4509_/Q gf180mcu_as_sc_mcu7t3v3__dfxtp_2
XFILLER_160_763 VDD VDD VSS VSS gf180mcu_as_sc_mcu7t3v3__fill_2
XFILLER_8_1301 VDD VDD VSS VSS gf180mcu_as_sc_mcu7t3v3__fill_2
Xfanout510 VDD VDD VSS VSS _2655_/Y _2914_/B gf180mcu_as_sc_mcu7t3v3__buff_12
Xfanout532 VDD VDD VSS VSS _3982_/Y _4236_/B gf180mcu_as_sc_mcu7t3v3__buff_12
XFILLER_116_77 VDD VDD VSS VSS gf180mcu_as_sc_mcu7t3v3__fill_2
XFILLER_154_1292 VDD VDD VSS VSS gf180mcu_as_sc_mcu7t3v3__fill_2
XFILLER_28_1273 VDD VDD VSS VSS gf180mcu_as_sc_mcu7t3v3__fill_2
XFILLER_28_1295 VDD VDD VSS VSS gf180mcu_as_sc_mcu7t3v3__fill_2
XFILLER_76_37 VDD VDD VSS VSS gf180mcu_as_sc_mcu7t3v3__fillcap_4
Xfanout543 VDD VDD VSS VSS _3163_/Y _3396_/A gf180mcu_as_sc_mcu7t3v3__buff_12
Xfanout565 VDD VDD VSS VSS _3871_/C _3798_/B gf180mcu_as_sc_mcu7t3v3__buff_12
XTAP_TAPCELL_ROW_183_1714 VDD VSS gf180mcu_as_sc_mcu7t3v3__tap_2
Xfanout576 VDD VDD VSS VSS fanout576/A _2895_/B gf180mcu_as_sc_mcu7t3v3__buff_12
Xfanout587 VDD VDD VSS VSS _3117_/S _3121_/S gf180mcu_as_sc_mcu7t3v3__buff_12
Xfanout598 VDD VDD VSS VSS _3414_/Y _3584_/D gf180mcu_as_sc_mcu7t3v3__buff_12
XTAP_TAPCELL_ROW_183_1725 VDD VSS gf180mcu_as_sc_mcu7t3v3__tap_2
XFILLER_6_1091 VDD VDD VSS VSS gf180mcu_as_sc_mcu7t3v3__fill_2
Xmesh_tile_980 VDD VDD VSS VSS sw_out[8] gf180mcu_as_sc_mcu7t3v3__tiel_4
Xmesh_tile_991 VDD VDD VSS VSS sw_out[19] gf180mcu_as_sc_mcu7t3v3__tiel_4
XFILLER_187_605 VDD VDD VSS VSS gf180mcu_as_sc_mcu7t3v3__fillcap_16
XFILLER_159_329 VDD VDD VSS VSS gf180mcu_as_sc_mcu7t3v3__fillcap_8
XFILLER_74_1260 VDD VDD VSS VSS gf180mcu_as_sc_mcu7t3v3__fill_2
XPHY_EDGE_ROW_89_1_Right_598 VDD VSS gf180mcu_as_sc_mcu7t3v3__tap_2
XFILLER_168_874 VDD VDD VSS VSS gf180mcu_as_sc_mcu7t3v3__fill_1
XFILLER_155_535 VDD VDD VSS VSS gf180mcu_as_sc_mcu7t3v3__fillcap_4
XFILLER_182_321 VDD VDD VSS VSS gf180mcu_as_sc_mcu7t3v3__fill_1
XFILLER_182_365 VDD VDD VSS VSS gf180mcu_as_sc_mcu7t3v3__fill_1
XFILLER_170_527 VDD VDD VSS VSS gf180mcu_as_sc_mcu7t3v3__fillcap_16
XFILLER_182_387 VDD VDD VSS VSS gf180mcu_as_sc_mcu7t3v3__fillcap_4
XFILLER_159_1192 VDD VDD VSS VSS gf180mcu_as_sc_mcu7t3v3__fillcap_16
XFILLER_110_104 VDD VDD VSS VSS gf180mcu_as_sc_mcu7t3v3__fill_1
XFILLER_173_72 VDD VDD VSS VSS gf180mcu_as_sc_mcu7t3v3__fill_2
XFILLER_2_34 VDD VDD VSS VSS gf180mcu_as_sc_mcu7t3v3__fill_1
XFILLER_81_1264 VDD VDD VSS VSS gf180mcu_as_sc_mcu7t3v3__fill_2
XFILLER_2_45 VDD VDD VSS VSS gf180mcu_as_sc_mcu7t3v3__fillcap_4
XTAP_TAPCELL_ROW_72_1_1025 VDD VSS gf180mcu_as_sc_mcu7t3v3__tap_2
X_4735__1037 VDD VDD VSS VSS _4735_/D gf180mcu_as_sc_mcu7t3v3__tiel_4
XPHY_EDGE_ROW_139_1_Left_331 VDD VSS gf180mcu_as_sc_mcu7t3v3__tap_2
XFILLER_162_1049 VDD VDD VSS VSS gf180mcu_as_sc_mcu7t3v3__fillcap_16
X_3811_ VDD VDD VSS VSS _3811_/B _3884_/A _4675_/D gf180mcu_as_sc_mcu7t3v3__and2_2
XANTENNA_17 VDD VDD VSS VSS _3868_/B gf180mcu_as_sc_mcu7t3v3__diode_2
XANTENNA_28 VDD VDD VSS VSS _4051_/B gf180mcu_as_sc_mcu7t3v3__diode_2
XANTENNA_39 VDD VDD VSS VSS _4193_/A gf180mcu_as_sc_mcu7t3v3__diode_2
XFILLER_177_137 VDD VDD VSS VSS gf180mcu_as_sc_mcu7t3v3__fill_2
X_4791_ VDD VDD VSS VSS _4795_/CLK _4791_/D _4791_/Q gf180mcu_as_sc_mcu7t3v3__dfxtp_2
XFILLER_14_1339 VDD VDD VSS VSS gf180mcu_as_sc_mcu7t3v3__fill_2
XFILLER_70_2 VDD VDD VSS VSS gf180mcu_as_sc_mcu7t3v3__fillcap_8
X_3742_ VDD VDD VSS VSS _3743_/D _4093_/A _3796_/B _3823_/C gf180mcu_as_sc_mcu7t3v3__ao21_2
XFILLER_158_395 VDD VDD VSS VSS gf180mcu_as_sc_mcu7t3v3__fill_2
X_3673_ VDD VDD VSS VSS _4032_/A _3881_/B _3881_/C _4031_/A _3674_/D gf180mcu_as_sc_mcu7t3v3__ao22_2
XFILLER_9_372 VDD VDD VSS VSS gf180mcu_as_sc_mcu7t3v3__fill_1
XFILLER_12_1041 VDD VDD VSS VSS gf180mcu_as_sc_mcu7t3v3__fill_2
XFILLER_12_1063 VDD VDD VSS VSS gf180mcu_as_sc_mcu7t3v3__fillcap_4
XFILLER_174_877 VDD VDD VSS VSS gf180mcu_as_sc_mcu7t3v3__fillcap_16
X_2624_ VDD VDD VSS VSS _3615_/B _3640_/A _3987_/A gf180mcu_as_sc_mcu7t3v3__and2_2
XFILLER_173_398 VDD VDD VSS VSS gf180mcu_as_sc_mcu7t3v3__fill_1
X_2555_ VDD VDD VSS VSS _3541_/B _2555_/B _2555_/C _2563_/A _2556_/D gf180mcu_as_sc_mcu7t3v3__ao211_2
XFILLER_101_104 VDD VDD VSS VSS gf180mcu_as_sc_mcu7t3v3__fill_1
X_2486_ VDD VDD VSS VSS _2486_/D _2486_/A _2486_/B _2486_/C _2486_/Y gf180mcu_as_sc_mcu7t3v3__ao31_2
XPHY_EDGE_ROW_189_Left_381 VDD VSS gf180mcu_as_sc_mcu7t3v3__tap_2
X_4225_ VDD VDD VSS VSS _4225_/A _4225_/B _4225_/C _4225_/D _4226_/D gf180mcu_as_sc_mcu7t3v3__ao22_2
X_4156_ VDD VDD VSS VSS _4711_/D _4156_/B _4204_/C gf180mcu_as_sc_mcu7t3v3__nor2_2
X_3107_ VDD VDD VSS VSS _3120_/S _4495_/Q _4494_/Q _4494_/D gf180mcu_as_sc_mcu7t3v3__mux2_2
XTAP_TAPCELL_ROW_161_1308 VDD VSS gf180mcu_as_sc_mcu7t3v3__tap_2
XPHY_EDGE_ROW_26_3_Right_67 VDD VSS gf180mcu_as_sc_mcu7t3v3__tap_2
X_4087_ VDD VDD VSS VSS _4087_/A _4143_/B _4235_/B _4087_/D _4088_/D gf180mcu_as_sc_mcu7t3v3__ao22_2
XFILLER_149_1350 VDD VDD VSS VSS gf180mcu_as_sc_mcu7t3v3__fill_1
X_3038_ VDD VDD VSS VSS _3038_/A _3038_/B _3038_/C _4447_/Q _4447_/D gf180mcu_as_sc_mcu7t3v3__ao22_2
XPHY_EDGE_ROW_60_1_Left_252 VDD VSS gf180mcu_as_sc_mcu7t3v3__tap_2
XTAP_TAPCELL_ROW_159_1259 VDD VSS gf180mcu_as_sc_mcu7t3v3__tap_2
XFILLER_11_349 VDD VDD VSS VSS gf180mcu_as_sc_mcu7t3v3__fill_1
XFILLER_176_181 VDD VDD VSS VSS gf180mcu_as_sc_mcu7t3v3__fill_1
XFILLER_192_641 VDD VDD VSS VSS gf180mcu_as_sc_mcu7t3v3__fill_1
XTAP_TAPCELL_ROW_176_1595 VDD VSS gf180mcu_as_sc_mcu7t3v3__tap_2
XTAP_TAPCELL_ROW_176_1584 VDD VSS gf180mcu_as_sc_mcu7t3v3__tap_2
XFILLER_192_663 VDD VDD VSS VSS gf180mcu_as_sc_mcu7t3v3__fillcap_4
XFILLER_164_387 VDD VDD VSS VSS gf180mcu_as_sc_mcu7t3v3__fillcap_16
XFILLER_127_54 VDD VDD VSS VSS gf180mcu_as_sc_mcu7t3v3__fillcap_4
XFILLER_156_1343 VDD VDD VSS VSS gf180mcu_as_sc_mcu7t3v3__fillcap_8
XPHY_EDGE_ROW_143_3_Left_515 VDD VSS gf180mcu_as_sc_mcu7t3v3__tap_2
XFILLER_87_58 VDD VDD VSS VSS gf180mcu_as_sc_mcu7t3v3__fill_1
Xdelaybuf_1_clk VDD VDD VSS VSS delaybuf_1_clk/A delaybuf_2_clk/A gf180mcu_as_sc_mcu7t3v3__clkbuff_12
XTAP_TAPCELL_ROW_7_832 VDD VSS gf180mcu_as_sc_mcu7t3v3__tap_2
XTAP_TAPCELL_ROW_7_821 VDD VSS gf180mcu_as_sc_mcu7t3v3__tap_2
XFILLER_191_1278 VDD VDD VSS VSS gf180mcu_as_sc_mcu7t3v3__fillcap_16
XFILLER_143_64 VDD VDD VSS VSS gf180mcu_as_sc_mcu7t3v3__fillcap_4
XFILLER_4_1017 VDD VDD VSS VSS gf180mcu_as_sc_mcu7t3v3__fillcap_4
XFILLER_185_1005 VDD VDD VSS VSS gf180mcu_as_sc_mcu7t3v3__fillcap_16
XFILLER_189_1174 VDD VDD VSS VSS gf180mcu_as_sc_mcu7t3v3__fillcap_16
XFILLER_185_1049 VDD VDD VSS VSS gf180mcu_as_sc_mcu7t3v3__fill_1
XTAP_TAPCELL_ROW_133_1_1086 VDD VSS gf180mcu_as_sc_mcu7t3v3__tap_2
XFILLER_159_104 VDD VDD VSS VSS gf180mcu_as_sc_mcu7t3v3__fillcap_16
XFILLER_188_936 VDD VDD VSS VSS gf180mcu_as_sc_mcu7t3v3__fill_2
XFILLER_174_107 VDD VDD VSS VSS gf180mcu_as_sc_mcu7t3v3__fillcap_8
XFILLER_52_83 VDD VDD VSS VSS gf180mcu_as_sc_mcu7t3v3__fill_1
XFILLER_7_832 VDD VDD VSS VSS gf180mcu_as_sc_mcu7t3v3__fill_1
Xinput15 VDD VDD VSS VSS boot_data[3] _2461_/A gf180mcu_as_sc_mcu7t3v3__buff_12
Xinput26 VDD VDD VSS VSS dft_addr[3] _2390_/A gf180mcu_as_sc_mcu7t3v3__buff_12
Xinput37 VDD VDD VSS VSS dft_wdata[2] _2454_/B gf180mcu_as_sc_mcu7t3v3__buff_12
XFILLER_156_877 VDD VDD VSS VSS gf180mcu_as_sc_mcu7t3v3__fillcap_16
Xinput48 VDD VDD VSS VSS east_in[13] _4108_/D gf180mcu_as_sc_mcu7t3v3__buff_12
Xinput59 VDD VDD VSS VSS east_in[23] _4190_/A gf180mcu_as_sc_mcu7t3v3__buff_12
Xwire774 VDD VDD VSS VSS wire774/A _4174_/D gf180mcu_as_sc_mcu7t3v3__clkbuff_12
XTAP_TAPCELL_ROW_91_3_2002 VDD VSS gf180mcu_as_sc_mcu7t3v3__tap_2
XPHY_EDGE_ROW_75_3_Left_447 VDD VSS gf180mcu_as_sc_mcu7t3v3__tap_2
XFILLER_83_1326 VDD VDD VSS VSS gf180mcu_as_sc_mcu7t3v3__fill_2
X_2340_ VDD VDD VSS VSS _2340_/A _2340_/B _3513_/A _4451_/Q _2341_/B gf180mcu_as_sc_mcu7t3v3__ao211_2
XFILLER_96_102 VDD VDD VSS VSS gf180mcu_as_sc_mcu7t3v3__fill_2
X_2271_ VDD VDD VSS VSS _2556_/A _3526_/B _2510_/D gf180mcu_as_sc_mcu7t3v3__nor2_2
X_4010_ VDD VDD VSS VSS _4011_/B _4138_/C _4138_/B _4010_/A gf180mcu_as_sc_mcu7t3v3__aoi21b_2
XFILLER_178_457 VDD VDD VSS VSS gf180mcu_as_sc_mcu7t3v3__fillcap_8
XFILLER_20_102 VDD VDD VSS VSS gf180mcu_as_sc_mcu7t3v3__fill_2
X_4774_ VDD VDD VSS VSS _4783_/CLK _4774_/D _4774_/Q gf180mcu_as_sc_mcu7t3v3__dfxtp_2
XFILLER_144_1291 VDD VDD VSS VSS gf180mcu_as_sc_mcu7t3v3__fillcap_8
X_3725_ VDD VDD VSS VSS _3859_/B _4077_/A _3727_/C gf180mcu_as_sc_mcu7t3v3__or2_2
XFILLER_179_1332 VDD VDD VSS VSS gf180mcu_as_sc_mcu7t3v3__fillcap_16
XFILLER_179_1354 VDD VDD VSS VSS gf180mcu_as_sc_mcu7t3v3__fill_1
XFILLER_173_162 VDD VDD VSS VSS gf180mcu_as_sc_mcu7t3v3__fill_1
X_3656_ VDD VDD VSS VSS _4017_/A _3882_/B _3656_/C _3656_/D _3657_/B gf180mcu_as_sc_mcu7t3v3__ao211_2
XTAP_TAPCELL_ROW_154_1178 VDD VSS gf180mcu_as_sc_mcu7t3v3__tap_2
XTAP_TAPCELL_ROW_154_1167 VDD VSS gf180mcu_as_sc_mcu7t3v3__tap_2
XFILLER_162_858 VDD VDD VSS VSS gf180mcu_as_sc_mcu7t3v3__fill_2
X_3587_ VDD VDD VSS VSS _3587_/B _3587_/A _4647_/D gf180mcu_as_sc_mcu7t3v3__and2_2
X_2607_ VDD VDD VSS VSS _3613_/B _3965_/B _4247_/A gf180mcu_as_sc_mcu7t3v3__and2_2
XTAP_TAPCELL_ROW_171_1492 VDD VSS gf180mcu_as_sc_mcu7t3v3__tap_2
X_2538_ VDD VDD VSS VSS _4623_/Q _4629_/Q _3564_/B gf180mcu_as_sc_mcu7t3v3__or2_2
XFILLER_180_18 VDD VDD VSS VSS gf180mcu_as_sc_mcu7t3v3__fillcap_16
X_4208_ VDD VDD VSS VSS _4208_/A _4208_/B _4208_/C _4208_/D _4209_/D gf180mcu_as_sc_mcu7t3v3__ao22_2
X_2469_ VDD VDD VSS VSS _2470_/D _2493_/C _4807_/D _2469_/A gf180mcu_as_sc_mcu7t3v3__aoi21b_2
XFILLER_5_1326 VDD VDD VSS VSS gf180mcu_as_sc_mcu7t3v3__fillcap_4
XFILLER_5_1348 VDD VDD VSS VSS gf180mcu_as_sc_mcu7t3v3__fillcap_4
X_4139_ VDD VDD VSS VSS _4139_/B _4139_/A _4709_/D gf180mcu_as_sc_mcu7t3v3__and2_2
XTAP_TAPCELL_ROW_178_1624 VDD VSS gf180mcu_as_sc_mcu7t3v3__tap_2
XTAP_TAPCELL_ROW_178_1635 VDD VSS gf180mcu_as_sc_mcu7t3v3__tap_2
XFILLER_11_124 VDD VDD VSS VSS gf180mcu_as_sc_mcu7t3v3__fillcap_4
XFILLER_156_107 VDD VDD VSS VSS gf180mcu_as_sc_mcu7t3v3__fillcap_16
XFILLER_22_64 VDD VDD VSS VSS gf180mcu_as_sc_mcu7t3v3__fillcap_8
XTAP_TAPCELL_ROW_191_1868 VDD VSS gf180mcu_as_sc_mcu7t3v3__tap_2
XFILLER_138_53 VDD VDD VSS VSS gf180mcu_as_sc_mcu7t3v3__fillcap_16
XFILLER_152_324 VDD VDD VSS VSS gf180mcu_as_sc_mcu7t3v3__fillcap_16
XFILLER_153_836 VDD VDD VSS VSS gf180mcu_as_sc_mcu7t3v3__fillcap_4
XFILLER_192_471 VDD VDD VSS VSS gf180mcu_as_sc_mcu7t3v3__fill_1
XFILLER_192_482 VDD VDD VSS VSS gf180mcu_as_sc_mcu7t3v3__fill_1
XFILLER_22_97 VDD VDD VSS VSS gf180mcu_as_sc_mcu7t3v3__fillcap_8
XTAP_TAPCELL_ROW_191_1879 VDD VSS gf180mcu_as_sc_mcu7t3v3__tap_2
XFILLER_0_2 VDD VDD VSS VSS gf180mcu_as_sc_mcu7t3v3__fillcap_4
XFILLER_154_30 VDD VDD VSS VSS gf180mcu_as_sc_mcu7t3v3__fillcap_4
XFILLER_156_1140 VDD VDD VSS VSS gf180mcu_as_sc_mcu7t3v3__fill_2
XFILLER_156_1151 VDD VDD VSS VSS gf180mcu_as_sc_mcu7t3v3__fillcap_4
XFILLER_180_699 VDD VDD VSS VSS gf180mcu_as_sc_mcu7t3v3__fillcap_16
XFILLER_152_1004 VDD VDD VSS VSS gf180mcu_as_sc_mcu7t3v3__fillcap_16
XFILLER_47_72 VDD VDD VSS VSS gf180mcu_as_sc_mcu7t3v3__fill_2
XFILLER_163_1122 VDD VDD VSS VSS gf180mcu_as_sc_mcu7t3v3__fillcap_4
XTAP_TAPCELL_ROW_67_1_1020 VDD VSS gf180mcu_as_sc_mcu7t3v3__tap_2
XFILLER_128_1264 VDD VDD VSS VSS gf180mcu_as_sc_mcu7t3v3__fill_2
XFILLER_163_1166 VDD VDD VSS VSS gf180mcu_as_sc_mcu7t3v3__fillcap_4
XFILLER_187_276 VDD VDD VSS VSS gf180mcu_as_sc_mcu7t3v3__fillcap_4
XFILLER_50_1303 VDD VDD VSS VSS gf180mcu_as_sc_mcu7t3v3__fillcap_8
XFILLER_175_438 VDD VDD VSS VSS gf180mcu_as_sc_mcu7t3v3__fillcap_16
XFILLER_191_909 VDD VDD VSS VSS gf180mcu_as_sc_mcu7t3v3__fill_1
X_3510_ VDD VDD VSS VSS _3583_/A _3611_/C _3513_/D gf180mcu_as_sc_mcu7t3v3__and2_2
XFILLER_7_662 VDD VDD VSS VSS gf180mcu_as_sc_mcu7t3v3__fill_2
X_4490_ VDD VDD VSS VSS _4708_/CLK _4490_/D _4490_/Q gf180mcu_as_sc_mcu7t3v3__dfxtp_2
XFILLER_87_1270 VDD VDD VSS VSS gf180mcu_as_sc_mcu7t3v3__fill_1
X_3441_ VDD VDD VSS VSS _4570_/Q _3443_/B _3442_/C _4569_/Q _4569_/D gf180mcu_as_sc_mcu7t3v3__ao22_2
X_3372_ VDD VDD VSS VSS _3412_/A _3372_/B _3372_/C _3372_/D _4537_/D gf180mcu_as_sc_mcu7t3v3__ao211_2
XFILLER_174_1273 VDD VDD VSS VSS gf180mcu_as_sc_mcu7t3v3__fillcap_4
X_2323_ VDD VDD VSS VSS _2324_/B _2348_/D _4451_/Q gf180mcu_as_sc_mcu7t3v3__nor2_2
X_2254_ VDD VDD VSS VSS _3580_/D _3513_/A _2254_/C _2254_/D _2255_/B gf180mcu_as_sc_mcu7t3v3__ao211_2
X_2185_ VDD VDD VSS VSS _4249_/A _3911_/A gf180mcu_as_sc_mcu7t3v3__inv_2
XFILLER_168_1011 VDD VDD VSS VSS gf180mcu_as_sc_mcu7t3v3__fillcap_4
XFILLER_168_1033 VDD VDD VSS VSS gf180mcu_as_sc_mcu7t3v3__fillcap_16
XTAP_TAPCELL_ROW_87_3_1998 VDD VSS gf180mcu_as_sc_mcu7t3v3__tap_2
XFILLER_0_1223 VDD VDD VSS VSS gf180mcu_as_sc_mcu7t3v3__fill_1
XFILLER_0_1256 VDD VDD VSS VSS gf180mcu_as_sc_mcu7t3v3__fill_2
XFILLER_181_1200 VDD VDD VSS VSS gf180mcu_as_sc_mcu7t3v3__fillcap_4
XFILLER_0_1289 VDD VDD VSS VSS gf180mcu_as_sc_mcu7t3v3__fill_2
XFILLER_179_755 VDD VDD VSS VSS gf180mcu_as_sc_mcu7t3v3__fillcap_8
XFILLER_181_1233 VDD VDD VSS VSS gf180mcu_as_sc_mcu7t3v3__fill_1
XFILLER_107_1326 VDD VDD VSS VSS gf180mcu_as_sc_mcu7t3v3__fill_2
XFILLER_167_928 VDD VDD VSS VSS gf180mcu_as_sc_mcu7t3v3__fillcap_8
X_4826_ VDD VDD VSS VSS _4826_/CLK _4826_/D _4826_/Q gf180mcu_as_sc_mcu7t3v3__dfxtp_2
XTAP_TAPCELL_ROW_156_1207 VDD VSS gf180mcu_as_sc_mcu7t3v3__tap_2
XFILLER_166_449 VDD VDD VSS VSS gf180mcu_as_sc_mcu7t3v3__fillcap_4
XTAP_TAPCELL_ROW_156_1218 VDD VSS gf180mcu_as_sc_mcu7t3v3__tap_2
XFILLER_181_419 VDD VDD VSS VSS gf180mcu_as_sc_mcu7t3v3__fill_1
X_4757_ VDD VDD VSS VSS clkload3/A _4757_/D _4757_/Q gf180mcu_as_sc_mcu7t3v3__dfxtp_2
XTAP_TAPCELL_ROW_173_1532 VDD VSS gf180mcu_as_sc_mcu7t3v3__tap_2
XFILLER_174_482 VDD VDD VSS VSS gf180mcu_as_sc_mcu7t3v3__fill_2
X_4688_ VDD VDD VSS VSS _4692_/CLK _4688_/D _4688_/Q gf180mcu_as_sc_mcu7t3v3__dfxtp_2
X_3708_ VDD VDD VSS VSS _4779_/Q _3852_/B _3879_/B _4062_/D _3709_/D gf180mcu_as_sc_mcu7t3v3__ao22_2
XFILLER_175_1026 VDD VDD VSS VSS gf180mcu_as_sc_mcu7t3v3__fill_1
X_3639_ VDD VDD VSS VSS _3890_/S _3990_/A _3643_/C gf180mcu_as_sc_mcu7t3v3__or2_2
XFILLER_190_986 VDD VDD VSS VSS gf180mcu_as_sc_mcu7t3v3__fill_2
XFILLER_1_838 VDD VDD VSS VSS gf180mcu_as_sc_mcu7t3v3__fill_2
X_4730__1042 VDD VDD VSS VSS _4730_/D gf180mcu_as_sc_mcu7t3v3__tiel_4
Xinput205 VDD VDD VSS VSS se_in[24] _4202_/D gf180mcu_as_sc_mcu7t3v3__buff_12
Xinput216 VDD VDD VSS VSS se_in[34] _3959_/A gf180mcu_as_sc_mcu7t3v3__buff_12
Xinput227 VDD VDD VSS VSS south_in[11] _4093_/A gf180mcu_as_sc_mcu7t3v3__buff_12
XFILLER_5_1112 VDD VDD VSS VSS gf180mcu_as_sc_mcu7t3v3__fill_1
Xinput238 VDD VDD VSS VSS south_in[21] _4174_/A gf180mcu_as_sc_mcu7t3v3__buff_12
Xinput249 VDD VDD VSS VSS south_in[31] _4266_/A gf180mcu_as_sc_mcu7t3v3__buff_12
XFILLER_186_1122 VDD VDD VSS VSS gf180mcu_as_sc_mcu7t3v3__fill_2
XFILLER_5_1189 VDD VDD VSS VSS gf180mcu_as_sc_mcu7t3v3__fill_1
XFILLER_17_42 VDD VDD VSS VSS gf180mcu_as_sc_mcu7t3v3__fill_2
XFILLER_157_416 VDD VDD VSS VSS gf180mcu_as_sc_mcu7t3v3__fillcap_4
XFILLER_160_1306 VDD VDD VSS VSS gf180mcu_as_sc_mcu7t3v3__fillcap_16
XFILLER_9_916 VDD VDD VSS VSS gf180mcu_as_sc_mcu7t3v3__fill_2
XFILLER_149_30 VDD VDD VSS VSS gf180mcu_as_sc_mcu7t3v3__fill_2
XFILLER_157_438 VDD VDD VSS VSS gf180mcu_as_sc_mcu7t3v3__fillcap_16
XTAP_TAPCELL_ROW_128_1_1081 VDD VSS gf180mcu_as_sc_mcu7t3v3__tap_2
XFILLER_149_63 VDD VDD VSS VSS gf180mcu_as_sc_mcu7t3v3__fillcap_4
XFILLER_8_459 VDD VDD VSS VSS gf180mcu_as_sc_mcu7t3v3__fill_1
XPHY_EDGE_ROW_23_1_Left_215 VDD VSS gf180mcu_as_sc_mcu7t3v3__tap_2
XPHY_EDGE_ROW_148_1_Left_340 VDD VSS gf180mcu_as_sc_mcu7t3v3__tap_2
XFILLER_152_154 VDD VDD VSS VSS gf180mcu_as_sc_mcu7t3v3__fillcap_16
XFILLER_3_142 VDD VDD VSS VSS gf180mcu_as_sc_mcu7t3v3__fill_1
XFILLER_3_197 VDD VDD VSS VSS gf180mcu_as_sc_mcu7t3v3__fill_1
XTAP_TAPCELL_ROW_100_3_2011 VDD VSS gf180mcu_as_sc_mcu7t3v3__tap_2
XFILLER_181_50 VDD VDD VSS VSS gf180mcu_as_sc_mcu7t3v3__fillcap_4
XFILLER_181_72 VDD VDD VSS VSS gf180mcu_as_sc_mcu7t3v3__fill_2
X_3990_ VDD VDD VSS VSS _3990_/A _4214_/B _4214_/C _3990_/D _3991_/D gf180mcu_as_sc_mcu7t3v3__ao22_2
X_2941_ VDD VDD VSS VSS _2987_/A _2943_/A _3018_/A gf180mcu_as_sc_mcu7t3v3__and2_2
XFILLER_176_703 VDD VDD VSS VSS gf180mcu_as_sc_mcu7t3v3__fillcap_4
XFILLER_188_574 VDD VDD VSS VSS gf180mcu_as_sc_mcu7t3v3__fillcap_8
X_4611_ VDD VDD VSS VSS _4828_/CLK _4611_/D _4611_/Q gf180mcu_as_sc_mcu7t3v3__dfxtp_2
X_2872_ VDD VDD VSS VSS _4354_/Q _2906_/B _3031_/A _2906_/D _4354_/D gf180mcu_as_sc_mcu7t3v3__ao22_2
XPHY_EDGE_ROW_19_3_Left_391 VDD VSS gf180mcu_as_sc_mcu7t3v3__tap_2
XFILLER_164_909 VDD VDD VSS VSS gf180mcu_as_sc_mcu7t3v3__fillcap_16
XFILLER_54_1291 VDD VDD VSS VSS gf180mcu_as_sc_mcu7t3v3__fillcap_8
XFILLER_89_1321 VDD VDD VSS VSS gf180mcu_as_sc_mcu7t3v3__fill_2
XFILLER_15_1297 VDD VDD VSS VSS gf180mcu_as_sc_mcu7t3v3__fill_2
XFILLER_163_419 VDD VDD VSS VSS gf180mcu_as_sc_mcu7t3v3__fill_1
XFILLER_190_227 VDD VDD VSS VSS gf180mcu_as_sc_mcu7t3v3__fillcap_4
X_4542_ VDD VDD VSS VSS _4804_/CLK _4542_/D _4542_/Q gf180mcu_as_sc_mcu7t3v3__dfxtp_2
XFILLER_102_1256 VDD VDD VSS VSS gf180mcu_as_sc_mcu7t3v3__fillcap_8
XFILLER_171_441 VDD VDD VSS VSS gf180mcu_as_sc_mcu7t3v3__fillcap_4
XFILLER_7_492 VDD VDD VSS VSS gf180mcu_as_sc_mcu7t3v3__fillcap_4
X_4473_ VDD VDD VSS VSS _4576_/CLK _4473_/D _4473_/Q gf180mcu_as_sc_mcu7t3v3__dfxtp_2
XPHY_EDGE_ROW_35_3_Right_76 VDD VSS gf180mcu_as_sc_mcu7t3v3__tap_2
XFILLER_172_986 VDD VDD VSS VSS gf180mcu_as_sc_mcu7t3v3__fill_2
X_3424_ VDD VDD VSS VSS _4553_/Q _3445_/B _3584_/D _4552_/Q _4552_/D gf180mcu_as_sc_mcu7t3v3__ao22_2
Xsram2048.u_bank1 _2424_/Y _2420_/Y _2415_/Y _2406_/Y _2399_/Y _2390_/Y _2377_/Y _2360_/Y
+ _2352_/Y hold1084/Y clkbuf_1_1__f_clk/Y _2494_/Y _2486_/Y _2478_/Y _2470_/Y _2462_/Y
+ _2454_/Y _2446_/Y _2438_/Y _2345_/Y _2501_/B _2500_/B _2499_/B _2498_/B _2497_/B
+ _2496_/B _2495_/B _2230_/B VDD VSS sram2048.u_bank1/WEN[7] sram2048.u_bank1/WEN[6]
+ sram2048.u_bank1/WEN[5] sram2048.u_bank1/WEN[4] sram2048.u_bank1/WEN[3] sram2048.u_bank1/WEN[2]
+ sram2048.u_bank1/WEN[1] sram2048.u_bank1/WEN[0] _2428_/Y gf180mcu_ocd_ip_sram__sram1024x8m8wm1
X_3355_ VDD VDD VSS VSS _4535_/Q _3395_/B _3403_/C _4536_/Q _3356_/C gf180mcu_as_sc_mcu7t3v3__ao22_2
X_3286_ VDD VDD VSS VSS _3290_/B _4340_/Q _3344_/S gf180mcu_as_sc_mcu7t3v3__nand2b_2
X_2306_ VDD VDD VSS VSS _2510_/D _3082_/B _2306_/C _3090_/B _2523_/B gf180mcu_as_sc_mcu7t3v3__aoi31_2
X_2237_ VDD VDD VSS VSS _2549_/C _2563_/D gf180mcu_as_sc_mcu7t3v3__inv_2
XTAP_TAPCELL_ROW_166_1391 VDD VSS gf180mcu_as_sc_mcu7t3v3__tap_2
XFILLER_0_1053 VDD VDD VSS VSS gf180mcu_as_sc_mcu7t3v3__fill_1
XFILLER_183_1328 VDD VDD VSS VSS gf180mcu_as_sc_mcu7t3v3__fill_2
XTAP_TAPCELL_ROW_35_3_1946 VDD VSS gf180mcu_as_sc_mcu7t3v3__tap_2
XFILLER_181_1052 VDD VDD VSS VSS gf180mcu_as_sc_mcu7t3v3__fillcap_4
X_4748__1024 VDD VDD VSS VSS _4748_/D gf180mcu_as_sc_mcu7t3v3__tiel_4
X_4809_ VDD VDD VSS VSS _4809_/CLK _4809_/D _4809_/Q gf180mcu_as_sc_mcu7t3v3__dfxtp_2
XFILLER_154_419 VDD VDD VSS VSS gf180mcu_as_sc_mcu7t3v3__fill_1
XFILLER_1_602 VDD VDD VSS VSS gf180mcu_as_sc_mcu7t3v3__fill_2
XFILLER_190_794 VDD VDD VSS VSS gf180mcu_as_sc_mcu7t3v3__fillcap_8
XFILLER_135_65 VDD VDD VSS VSS gf180mcu_as_sc_mcu7t3v3__fillcap_4
XFILLER_153_1143 VDD VDD VSS VSS gf180mcu_as_sc_mcu7t3v3__fill_1
XFILLER_192_1192 VDD VDD VSS VSS gf180mcu_as_sc_mcu7t3v3__fill_2
XFILLER_0_178 VDD VDD VSS VSS gf180mcu_as_sc_mcu7t3v3__fill_1
XTAP_TAPCELL_ROW_186_1789 VDD VSS gf180mcu_as_sc_mcu7t3v3__tap_2
XTAP_TAPCELL_ROW_186_1778 VDD VSS gf180mcu_as_sc_mcu7t3v3__tap_2
XFILLER_185_2 VDD VDD VSS VSS gf180mcu_as_sc_mcu7t3v3__fillcap_16
XFILLER_188_1239 VDD VDD VSS VSS gf180mcu_as_sc_mcu7t3v3__fill_1
XFILLER_28_52 VDD VDD VSS VSS gf180mcu_as_sc_mcu7t3v3__fillcap_16
Xclkbuf_leaf_15_clk_regs VDD VDD VSS VSS clkload0/A _4576_/CLK gf180mcu_as_sc_mcu7t3v3__clkbuff_12
XPHY_EDGE_ROW_84_3_Left_456 VDD VSS gf180mcu_as_sc_mcu7t3v3__tap_2
XTAP_TAPCELL_ROW_0_690 VDD VSS gf180mcu_as_sc_mcu7t3v3__tap_2
XFILLER_125_1256 VDD VDD VSS VSS gf180mcu_as_sc_mcu7t3v3__fillcap_8
XFILLER_12_241 VDD VDD VSS VSS gf180mcu_as_sc_mcu7t3v3__fillcap_4
XFILLER_13_775 VDD VDD VSS VSS gf180mcu_as_sc_mcu7t3v3__fill_2
XFILLER_160_1136 VDD VDD VSS VSS gf180mcu_as_sc_mcu7t3v3__fillcap_4
XFILLER_164_1294 VDD VDD VSS VSS gf180mcu_as_sc_mcu7t3v3__fill_1
XFILLER_9_724 VDD VDD VSS VSS gf180mcu_as_sc_mcu7t3v3__fill_2
XFILLER_100_90 VDD VDD VSS VSS gf180mcu_as_sc_mcu7t3v3__fillcap_8
XFILLER_158_758 VDD VDD VSS VSS gf180mcu_as_sc_mcu7t3v3__fillcap_16
XFILLER_9_768 VDD VDD VSS VSS gf180mcu_as_sc_mcu7t3v3__fill_2
XFILLER_166_780 VDD VDD VSS VSS gf180mcu_as_sc_mcu7t3v3__fill_2
XFILLER_172_238 VDD VDD VSS VSS gf180mcu_as_sc_mcu7t3v3__fillcap_4
XFILLER_5_930 VDD VDD VSS VSS gf180mcu_as_sc_mcu7t3v3__fill_1
XFILLER_154_997 VDD VDD VSS VSS gf180mcu_as_sc_mcu7t3v3__fillcap_16
XFILLER_181_750 VDD VDD VSS VSS gf180mcu_as_sc_mcu7t3v3__fillcap_16
XFILLER_181_772 VDD VDD VSS VSS gf180mcu_as_sc_mcu7t3v3__fillcap_4
XFILLER_140_102 VDD VDD VSS VSS gf180mcu_as_sc_mcu7t3v3__fill_2
XFILLER_153_485 VDD VDD VSS VSS gf180mcu_as_sc_mcu7t3v3__fillcap_4
XFILLER_158_1087 VDD VDD VSS VSS gf180mcu_as_sc_mcu7t3v3__fill_2
XPHY_EDGE_ROW_152_Left_344 VDD VSS gf180mcu_as_sc_mcu7t3v3__tap_2
XFILLER_171_1254 VDD VDD VSS VSS gf180mcu_as_sc_mcu7t3v3__fillcap_4
X_3140_ VDD VDD VSS VSS _3141_/D _3140_/B _3408_/A gf180mcu_as_sc_mcu7t3v3__nor2_2
X_3071_ VDD VDD VSS VSS _3071_/B _3071_/A _3079_/S gf180mcu_as_sc_mcu7t3v3__and2_2
XPHY_EDGE_ROW_161_Left_353 VDD VSS gf180mcu_as_sc_mcu7t3v3__tap_2
X_3973_ VDD VDD VSS VSS _3988_/B _3974_/B _4264_/B gf180mcu_as_sc_mcu7t3v3__nand2_2
XFILLER_143_1323 VDD VDD VSS VSS gf180mcu_as_sc_mcu7t3v3__fill_1
XFILLER_17_1326 VDD VDD VSS VSS gf180mcu_as_sc_mcu7t3v3__fill_2
X_2924_ VDD VDD VSS VSS _2924_/Y _2945_/B _4122_/D gf180mcu_as_sc_mcu7t3v3__nor2_2
X_2855_ VDD VDD VSS VSS _2871_/B _4180_/A _2862_/C gf180mcu_as_sc_mcu7t3v3__and2_2
XFILLER_163_216 VDD VDD VSS VSS gf180mcu_as_sc_mcu7t3v3__fill_1
X_4525_ VDD VDD VSS VSS _4789_/CLK _4525_/D _4525_/Q gf180mcu_as_sc_mcu7t3v3__dfxtp_2
X_2786_ VDD VDD VSS VSS _4112_/A _2818_/B _2786_/C _2786_/D _2787_/C gf180mcu_as_sc_mcu7t3v3__ao211_2
XFILLER_176_1154 VDD VDD VSS VSS gf180mcu_as_sc_mcu7t3v3__fill_1
XFILLER_131_102 VDD VDD VSS VSS gf180mcu_as_sc_mcu7t3v3__fill_2
XFILLER_171_260 VDD VDD VSS VSS gf180mcu_as_sc_mcu7t3v3__fillcap_16
XFILLER_171_282 VDD VDD VSS VSS gf180mcu_as_sc_mcu7t3v3__fillcap_8
X_4456_ VDD VDD VSS VSS _4576_/CLK _4456_/D _4456_/Q gf180mcu_as_sc_mcu7t3v3__dfxtp_2
XPHY_EDGE_ROW_170_Left_362 VDD VSS gf180mcu_as_sc_mcu7t3v3__tap_2
Xfanout703 VDD VDD VSS VSS _3866_/B _3794_/B gf180mcu_as_sc_mcu7t3v3__buff_12
Xfanout714 VDD VDD VSS VSS _2431_/Y _3049_/B gf180mcu_as_sc_mcu7t3v3__buff_12
X_4387_ VDD VDD VSS VSS _4440_/CLK _4387_/D _4387_/Q gf180mcu_as_sc_mcu7t3v3__dfxtp_2
X_3407_ VDD VDD VSS VSS _3410_/B _3407_/A gf180mcu_as_sc_mcu7t3v3__inv_2
Xfanout725 VDD VDD VSS VSS _4579_/Q _3505_/A gf180mcu_as_sc_mcu7t3v3__buff_12
Xfanout736 VDD VDD VSS VSS _3346_/A _3330_/A gf180mcu_as_sc_mcu7t3v3__buff_12
Xfanout747 VDD VDD VSS VSS fanout750/Y _3328_/S gf180mcu_as_sc_mcu7t3v3__buff_12
Xfanout758 VDD VDD VSS VSS _3956_/A _3884_/A gf180mcu_as_sc_mcu7t3v3__buff_12
X_3338_ VDD VDD VSS VSS _3346_/A _3338_/B _3338_/C _3340_/B _3338_/D gf180mcu_as_sc_mcu7t3v3__aoi31_2
XTAP_TAPCELL_ROW_90_1_1043 VDD VSS gf180mcu_as_sc_mcu7t3v3__tap_2
XTAP_TAPCELL_ROW_168_1442 VDD VSS gf180mcu_as_sc_mcu7t3v3__tap_2
XTAP_TAPCELL_ROW_168_1431 VDD VSS gf180mcu_as_sc_mcu7t3v3__tap_2
XFILLER_150_1349 VDD VDD VSS VSS gf180mcu_as_sc_mcu7t3v3__fill_2
X_3269_ VDD VDD VSS VSS _3405_/B _4476_/Q _3276_/D gf180mcu_as_sc_mcu7t3v3__and2_2
XFILLER_2_1148 VDD VDD VSS VSS gf180mcu_as_sc_mcu7t3v3__fill_2
XFILLER_183_1114 VDD VDD VSS VSS gf180mcu_as_sc_mcu7t3v3__fillcap_4
XTAP_TAPCELL_ROW_181_1686 VDD VSS gf180mcu_as_sc_mcu7t3v3__tap_2
XFILLER_148_1256 VDD VDD VSS VSS gf180mcu_as_sc_mcu7t3v3__fillcap_4
XFILLER_14_54 VDD VDD VSS VSS gf180mcu_as_sc_mcu7t3v3__fillcap_8
XFILLER_167_500 VDD VDD VSS VSS gf180mcu_as_sc_mcu7t3v3__fill_1
XFILLER_10_723 VDD VDD VSS VSS gf180mcu_as_sc_mcu7t3v3__fill_1
XFILLER_10_756 VDD VDD VSS VSS gf180mcu_as_sc_mcu7t3v3__fill_2
XFILLER_6_716 VDD VDD VSS VSS gf180mcu_as_sc_mcu7t3v3__fillcap_16
XFILLER_163_772 VDD VDD VSS VSS gf180mcu_as_sc_mcu7t3v3__fillcap_8
XFILLER_30_64 VDD VDD VSS VSS gf180mcu_as_sc_mcu7t3v3__fillcap_4
XFILLER_100_2 VDD VDD VSS VSS gf180mcu_as_sc_mcu7t3v3__fill_2
XFILLER_146_64 VDD VDD VSS VSS gf180mcu_as_sc_mcu7t3v3__fillcap_16
XFILLER_68_1268 VDD VDD VSS VSS gf180mcu_as_sc_mcu7t3v3__fill_1
XTAP_TAPCELL_ROW_188_1818 VDD VSS gf180mcu_as_sc_mcu7t3v3__tap_2
XFILLER_162_293 VDD VDD VSS VSS gf180mcu_as_sc_mcu7t3v3__fillcap_16
XFILLER_1_432 VDD VDD VSS VSS gf180mcu_as_sc_mcu7t3v3__fillcap_4
XFILLER_162_30 VDD VDD VSS VSS gf180mcu_as_sc_mcu7t3v3__fillcap_4
XFILLER_39_84 VDD VDD VSS VSS gf180mcu_as_sc_mcu7t3v3__fillcap_16
XFILLER_7_1059 VDD VDD VSS VSS gf180mcu_as_sc_mcu7t3v3__fillcap_8
XTAP_TAPCELL_ROW_5_793 VDD VSS gf180mcu_as_sc_mcu7t3v3__tap_2
XTAP_TAPCELL_ROW_5_782 VDD VSS gf180mcu_as_sc_mcu7t3v3__tap_2
XFILLER_55_72 VDD VDD VSS VSS gf180mcu_as_sc_mcu7t3v3__fillcap_16
XFILLER_158_522 VDD VDD VSS VSS gf180mcu_as_sc_mcu7t3v3__fill_2
XFILLER_186_853 VDD VDD VSS VSS gf180mcu_as_sc_mcu7t3v3__fillcap_8
X_2640_ VDD VDD VSS VSS _3999_/B _4267_/B _3932_/B gf180mcu_as_sc_mcu7t3v3__nor2_2
X_2571_ VDD VDD VSS VSS _4829_/D _2582_/B _4642_/Q _4641_/D gf180mcu_as_sc_mcu7t3v3__mux2_2
XFILLER_47_1308 VDD VDD VSS VSS gf180mcu_as_sc_mcu7t3v3__fill_1
XFILLER_5_760 VDD VDD VSS VSS gf180mcu_as_sc_mcu7t3v3__fillcap_8
Xoutput339 VDD VDD VSS VSS _5075_/Y dft_rdata[6] gf180mcu_as_sc_mcu7t3v3__buff_12
X_4310_ VDD VDD VSS VSS _4310_/B _4534_/Q _4787_/D gf180mcu_as_sc_mcu7t3v3__and2_2
X_4241_ VDD VDD VSS VSS _4263_/C _4241_/B _4241_/A gf180mcu_as_sc_mcu7t3v3__nor2_2
X_4172_ VDD VDD VSS VSS _4172_/B _4172_/A _4713_/D gf180mcu_as_sc_mcu7t3v3__and2_2
X_3123_ VDD VDD VSS VSS _3123_/D _4510_/Q _4587_/Q _3608_/A _3124_/B gf180mcu_as_sc_mcu7t3v3__ao31_2
XFILLER_96_90 VDD VDD VSS VSS gf180mcu_as_sc_mcu7t3v3__fillcap_8
X_3054_ VDD VDD VSS VSS _3603_/C _3054_/B _3054_/C _4453_/D gf180mcu_as_sc_mcu7t3v3__nor3_2
XTAP_TAPCELL_ROW_163_1350 VDD VSS gf180mcu_as_sc_mcu7t3v3__tap_2
XFILLER_93_1306 VDD VDD VSS VSS gf180mcu_as_sc_mcu7t3v3__fillcap_8
XFILLER_50_100 VDD VDD VSS VSS gf180mcu_as_sc_mcu7t3v3__fillcap_4
X_3956_ VDD VDD VSS VSS _3956_/B _3956_/A _4690_/D gf180mcu_as_sc_mcu7t3v3__and2_2
XFILLER_177_842 VDD VDD VSS VSS gf180mcu_as_sc_mcu7t3v3__fillcap_8
X_2907_ VDD VDD VSS VSS _2917_/C _4227_/D _2911_/C gf180mcu_as_sc_mcu7t3v3__and2_2
X_3887_ VDD VDD VSS VSS _3892_/C _3928_/B _4225_/A gf180mcu_as_sc_mcu7t3v3__nor2_2
XFILLER_164_558 VDD VDD VSS VSS gf180mcu_as_sc_mcu7t3v3__fillcap_16
XFILLER_178_1227 VDD VDD VSS VSS gf180mcu_as_sc_mcu7t3v3__fillcap_16
X_2838_ VDD VDD VSS VSS _4791_/Q _2892_/B _2892_/C _4157_/D _2840_/C gf180mcu_as_sc_mcu7t3v3__ao22_2
X_2769_ VDD VDD VSS VSS _2796_/D _4098_/A _2770_/D gf180mcu_as_sc_mcu7t3v3__and2_2
XFILLER_183_18 VDD VDD VSS VSS gf180mcu_as_sc_mcu7t3v3__fillcap_16
X_4508_ VDD VDD VSS VSS _4708_/CLK _4508_/D _4508_/Q gf180mcu_as_sc_mcu7t3v3__dfxtp_2
X_4439_ VDD VDD VSS VSS _4445_/CLK _4439_/D _4439_/Q gf180mcu_as_sc_mcu7t3v3__dfxtp_2
XFILLER_116_34 VDD VDD VSS VSS gf180mcu_as_sc_mcu7t3v3__fill_1
Xfanout500 VDD VDD VSS VSS _3634_/Y _3872_/B gf180mcu_as_sc_mcu7t3v3__buff_12
Xfanout511 VDD VDD VSS VSS _2912_/B _2823_/D gf180mcu_as_sc_mcu7t3v3__buff_12
Xfanout522 VDD VDD VSS VSS _4007_/Y _4268_/C gf180mcu_as_sc_mcu7t3v3__buff_12
Xfanout533 VDD VDD VSS VSS _4210_/B _4143_/B gf180mcu_as_sc_mcu7t3v3__buff_12
XFILLER_154_1271 VDD VDD VSS VSS gf180mcu_as_sc_mcu7t3v3__fill_2
Xfanout544 VDD VDD VSS VSS _3133_/Y _3210_/B gf180mcu_as_sc_mcu7t3v3__buff_12
Xfanout555 VDD VDD VSS VSS _2325_/Y _2489_/A gf180mcu_as_sc_mcu7t3v3__buff_12
Xfanout566 VDD VDD VSS VSS _3645_/Y _3871_/C gf180mcu_as_sc_mcu7t3v3__buff_12
XTAP_TAPCELL_ROW_183_1715 VDD VSS gf180mcu_as_sc_mcu7t3v3__tap_2
Xfanout588 VDD VDD VSS VSS _3122_/S _3117_/S gf180mcu_as_sc_mcu7t3v3__buff_12
Xfanout599 VDD VDD VSS VSS _3443_/B _3439_/B gf180mcu_as_sc_mcu7t3v3__buff_12
XTAP_TAPCELL_ROW_183_1726 VDD VSS gf180mcu_as_sc_mcu7t3v3__tap_2
XFILLER_132_44 VDD VDD VSS VSS gf180mcu_as_sc_mcu7t3v3__fillcap_16
Xmesh_tile_981 VDD VDD VSS VSS sw_out[9] gf180mcu_as_sc_mcu7t3v3__tiel_4
Xmesh_tile_970 VDD VDD VSS VSS se_out[34] gf180mcu_as_sc_mcu7t3v3__tiel_4
XTAP_TAPCELL_ROW_2_730 VDD VSS gf180mcu_as_sc_mcu7t3v3__tap_2
XPHY_EDGE_ROW_32_1_Left_224 VDD VSS gf180mcu_as_sc_mcu7t3v3__tap_2
Xmesh_tile_992 VDD VDD VSS VSS sw_out[20] gf180mcu_as_sc_mcu7t3v3__tiel_4
XFILLER_187_1091 VDD VDD VSS VSS gf180mcu_as_sc_mcu7t3v3__fillcap_4
XFILLER_92_37 VDD VDD VSS VSS gf180mcu_as_sc_mcu7t3v3__fillcap_8
XFILLER_25_53 VDD VDD VSS VSS gf180mcu_as_sc_mcu7t3v3__fillcap_4
XFILLER_187_628 VDD VDD VSS VSS gf180mcu_as_sc_mcu7t3v3__fill_2
XFILLER_126_1351 VDD VDD VSS VSS gf180mcu_as_sc_mcu7t3v3__fillcap_4
XFILLER_168_853 VDD VDD VSS VSS gf180mcu_as_sc_mcu7t3v3__fill_1
XFILLER_35_1256 VDD VDD VSS VSS gf180mcu_as_sc_mcu7t3v3__fill_1
XFILLER_167_352 VDD VDD VSS VSS gf180mcu_as_sc_mcu7t3v3__fill_1
XFILLER_155_558 VDD VDD VSS VSS gf180mcu_as_sc_mcu7t3v3__fill_2
XFILLER_157_63 VDD VDD VSS VSS gf180mcu_as_sc_mcu7t3v3__fillcap_4
XFILLER_182_355 VDD VDD VSS VSS gf180mcu_as_sc_mcu7t3v3__fillcap_8
XFILLER_157_96 VDD VDD VSS VSS gf180mcu_as_sc_mcu7t3v3__fill_2
XFILLER_2_730 VDD VDD VSS VSS gf180mcu_as_sc_mcu7t3v3__fillcap_4
XFILLER_133_1311 VDD VDD VSS VSS gf180mcu_as_sc_mcu7t3v3__fill_2
Xclkbuf_leaf_30_clk_regs VDD VDD VSS VSS clkbuf_3_4__f_clk_regs/Y _4719_/CLK gf180mcu_as_sc_mcu7t3v3__clkbuff_12
XFILLER_66_82 VDD VDD VSS VSS gf180mcu_as_sc_mcu7t3v3__fill_2
XPHY_EDGE_ROW_89_1_Left_281 VDD VSS gf180mcu_as_sc_mcu7t3v3__tap_2
XFILLER_166_1131 VDD VDD VSS VSS gf180mcu_as_sc_mcu7t3v3__fillcap_8
XPHY_EDGE_ROW_44_3_Right_85 VDD VSS gf180mcu_as_sc_mcu7t3v3__tap_2
XFILLER_162_1006 VDD VDD VSS VSS gf180mcu_as_sc_mcu7t3v3__fillcap_8
XFILLER_178_617 VDD VDD VSS VSS gf180mcu_as_sc_mcu7t3v3__fill_2
XFILLER_162_1017 VDD VDD VSS VSS gf180mcu_as_sc_mcu7t3v3__fillcap_16
XFILLER_53_1301 VDD VDD VSS VSS gf180mcu_as_sc_mcu7t3v3__fillcap_8
X_4790_ VDD VDD VSS VSS clkload7/A _4790_/D _4790_/Q gf180mcu_as_sc_mcu7t3v3__dfxtp_2
X_3810_ VDD VDD VSS VSS _3810_/S _3810_/B _4155_/A _3811_/B gf180mcu_as_sc_mcu7t3v3__mux2_2
XANTENNA_18 VDD VDD VSS VSS _3868_/B gf180mcu_as_sc_mcu7t3v3__diode_2
XANTENNA_29 VDD VDD VSS VSS _4051_/B gf180mcu_as_sc_mcu7t3v3__diode_2
XFILLER_159_842 VDD VDD VSS VSS gf180mcu_as_sc_mcu7t3v3__fillcap_8
X_3741_ VDD VDD VSS VSS _4094_/A _3795_/B _3741_/C _3795_/D _3743_/C gf180mcu_as_sc_mcu7t3v3__ao211_2
XPHY_EDGE_ROW_47_3_Left_419 VDD VSS gf180mcu_as_sc_mcu7t3v3__tap_2
XFILLER_13_391 VDD VDD VSS VSS gf180mcu_as_sc_mcu7t3v3__fillcap_16
XFILLER_174_823 VDD VDD VSS VSS gf180mcu_as_sc_mcu7t3v3__fillcap_4
XFILLER_186_661 VDD VDD VSS VSS gf180mcu_as_sc_mcu7t3v3__fillcap_4
XFILLER_186_683 VDD VDD VSS VSS gf180mcu_as_sc_mcu7t3v3__fillcap_16
XFILLER_192_108 VDD VDD VSS VSS gf180mcu_as_sc_mcu7t3v3__fill_2
X_3672_ VDD VDD VSS VSS _3672_/D _3880_/A _3672_/B _3672_/C _3674_/C gf180mcu_as_sc_mcu7t3v3__ao31_2
X_2623_ VDD VDD VSS VSS _3952_/C _3941_/C _3963_/C _3615_/B gf180mcu_as_sc_mcu7t3v3__nor3_2
X_2554_ VDD VDD VSS VSS _3608_/D _3571_/D _4575_/Q _3446_/A _2555_/C gf180mcu_as_sc_mcu7t3v3__ao31_2
XFILLER_138_1288 VDD VDD VSS VSS gf180mcu_as_sc_mcu7t3v3__fill_1
X_2485_ VDD VDD VSS VSS _2486_/C _2493_/C _4807_/D _2485_/A gf180mcu_as_sc_mcu7t3v3__aoi21b_2
X_4224_ VDD VDD VSS VSS _4224_/A _4231_/B _4224_/C _4224_/D _4225_/C gf180mcu_as_sc_mcu7t3v3__ao22_2
X_4155_ VDD VDD VSS VSS _4156_/B _4155_/C _4187_/D _4155_/A gf180mcu_as_sc_mcu7t3v3__aoi21_2
X_3106_ VDD VDD VSS VSS _3122_/S _4494_/Q _4493_/Q _4493_/D gf180mcu_as_sc_mcu7t3v3__mux2_2
XFILLER_3_1232 VDD VDD VSS VSS gf180mcu_as_sc_mcu7t3v3__fill_1
X_4086_ VDD VDD VSS VSS _4088_/C _4151_/A _4086_/B _4086_/C gf180mcu_as_sc_mcu7t3v3__ao21_2
XTAP_TAPCELL_ROW_161_1309 VDD VSS gf180mcu_as_sc_mcu7t3v3__tap_2
XFILLER_3_1287 VDD VDD VSS VSS gf180mcu_as_sc_mcu7t3v3__fillcap_16
X_3037_ VDD VDD VSS VSS _3037_/D _4274_/A _3037_/B _3038_/B _4446_/D gf180mcu_as_sc_mcu7t3v3__ao31_2
XFILLER_102_58 VDD VDD VSS VSS gf180mcu_as_sc_mcu7t3v3__fill_2
XFILLER_12_807 VDD VDD VSS VSS gf180mcu_as_sc_mcu7t3v3__fillcap_16
XFILLER_184_1297 VDD VDD VSS VSS gf180mcu_as_sc_mcu7t3v3__fillcap_16
XFILLER_62_29 VDD VDD VSS VSS gf180mcu_as_sc_mcu7t3v3__fillcap_4
X_3939_ VDD VDD VSS VSS _3940_/B _3939_/A _3961_/D _3939_/C gf180mcu_as_sc_mcu7t3v3__ao21_2
XFILLER_164_333 VDD VDD VSS VSS gf180mcu_as_sc_mcu7t3v3__fill_2
XFILLER_176_160 VDD VDD VSS VSS gf180mcu_as_sc_mcu7t3v3__fillcap_8
XFILLER_178_1002 VDD VDD VSS VSS gf180mcu_as_sc_mcu7t3v3__fill_2
XFILLER_192_631 VDD VDD VSS VSS gf180mcu_as_sc_mcu7t3v3__fillcap_4
XTAP_TAPCELL_ROW_176_1596 VDD VSS gf180mcu_as_sc_mcu7t3v3__tap_2
XTAP_TAPCELL_ROW_176_1585 VDD VSS gf180mcu_as_sc_mcu7t3v3__tap_2
XFILLER_180_804 VDD VDD VSS VSS gf180mcu_as_sc_mcu7t3v3__fill_1
XFILLER_152_528 VDD VDD VSS VSS gf180mcu_as_sc_mcu7t3v3__fillcap_16
XFILLER_192_686 VDD VDD VSS VSS gf180mcu_as_sc_mcu7t3v3__fill_2
XFILLER_191_1224 VDD VDD VSS VSS gf180mcu_as_sc_mcu7t3v3__fillcap_16
XFILLER_2_6 VDD VDD VSS VSS gf180mcu_as_sc_mcu7t3v3__fill_2
XFILLER_127_88 VDD VDD VSS VSS gf180mcu_as_sc_mcu7t3v3__fillcap_16
XTAP_TAPCELL_ROW_7_833 VDD VSS gf180mcu_as_sc_mcu7t3v3__tap_2
XTAP_TAPCELL_ROW_7_822 VDD VSS gf180mcu_as_sc_mcu7t3v3__tap_2
XPHY_EDGE_ROW_93_3_Left_465 VDD VSS gf180mcu_as_sc_mcu7t3v3__tap_2
XFILLER_160_594 VDD VDD VSS VSS gf180mcu_as_sc_mcu7t3v3__fill_1
XFILLER_8_1110 VDD VDD VSS VSS gf180mcu_as_sc_mcu7t3v3__fill_2
XFILLER_8_1198 VDD VDD VSS VSS gf180mcu_as_sc_mcu7t3v3__fill_2
XPHY_EDGE_ROW_14_1_Right_661 VDD VSS gf180mcu_as_sc_mcu7t3v3__tap_2
XFILLER_36_41 VDD VDD VSS VSS gf180mcu_as_sc_mcu7t3v3__fill_1
XFILLER_41_1293 VDD VDD VSS VSS gf180mcu_as_sc_mcu7t3v3__fill_1
XFILLER_14_100 VDD VDD VSS VSS gf180mcu_as_sc_mcu7t3v3__fillcap_4
XFILLER_163_1326 VDD VDD VSS VSS gf180mcu_as_sc_mcu7t3v3__fillcap_4
XFILLER_163_1348 VDD VDD VSS VSS gf180mcu_as_sc_mcu7t3v3__fill_2
XFILLER_175_609 VDD VDD VSS VSS gf180mcu_as_sc_mcu7t3v3__fillcap_16
XFILLER_187_436 VDD VDD VSS VSS gf180mcu_as_sc_mcu7t3v3__fillcap_16
XFILLER_168_661 VDD VDD VSS VSS gf180mcu_as_sc_mcu7t3v3__fillcap_4
XFILLER_168_683 VDD VDD VSS VSS gf180mcu_as_sc_mcu7t3v3__fillcap_16
XFILLER_52_95 VDD VDD VSS VSS gf180mcu_as_sc_mcu7t3v3__fillcap_8
Xinput16 VDD VDD VSS VSS boot_data[4] _2469_/A gf180mcu_as_sc_mcu7t3v3__buff_12
Xinput27 VDD VDD VSS VSS dft_addr[4] _2399_/B gf180mcu_as_sc_mcu7t3v3__buff_12
XFILLER_155_344 VDD VDD VSS VSS gf180mcu_as_sc_mcu7t3v3__fillcap_4
XFILLER_167_193 VDD VDD VSS VSS gf180mcu_as_sc_mcu7t3v3__fillcap_16
XFILLER_6_332 VDD VDD VSS VSS gf180mcu_as_sc_mcu7t3v3__fill_2
Xinput38 VDD VDD VSS VSS dft_wdata[3] _2455_/B gf180mcu_as_sc_mcu7t3v3__buff_12
Xinput49 VDD VDD VSS VSS east_in[14] wire777/A gf180mcu_as_sc_mcu7t3v3__buff_12
Xwire775 VDD VDD VSS VSS wire775/A _4149_/D gf180mcu_as_sc_mcu7t3v3__clkbuff_12
XFILLER_182_163 VDD VDD VSS VSS gf180mcu_as_sc_mcu7t3v3__fillcap_4
XFILLER_182_174 VDD VDD VSS VSS gf180mcu_as_sc_mcu7t3v3__fill_1
XFILLER_183_686 VDD VDD VSS VSS gf180mcu_as_sc_mcu7t3v3__fillcap_4
XFILLER_7_888 VDD VDD VSS VSS gf180mcu_as_sc_mcu7t3v3__fillcap_8
Xwire797 VDD VDD VSS VSS wire797/A _4136_/D gf180mcu_as_sc_mcu7t3v3__clkbuff_12
XFILLER_100_1354 VDD VDD VSS VSS gf180mcu_as_sc_mcu7t3v3__fill_1
XFILLER_170_358 VDD VDD VSS VSS gf180mcu_as_sc_mcu7t3v3__fillcap_16
XFILLER_2_582 VDD VDD VSS VSS gf180mcu_as_sc_mcu7t3v3__fill_2
X_2270_ VDD VDD VSS VSS _3526_/B _4575_/Q _3454_/A gf180mcu_as_sc_mcu7t3v3__nand2_2
XFILLER_144_1270 VDD VDD VSS VSS gf180mcu_as_sc_mcu7t3v3__fillcap_16
XFILLER_159_672 VDD VDD VSS VSS gf180mcu_as_sc_mcu7t3v3__fill_2
X_4773_ VDD VDD VSS VSS _4783_/CLK _4773_/D _4773_/Q gf180mcu_as_sc_mcu7t3v3__dfxtp_2
X_3724_ VDD VDD VSS VSS _4078_/A _3795_/B _3724_/C _3795_/D _3727_/B gf180mcu_as_sc_mcu7t3v3__ao211_2
XFILLER_158_193 VDD VDD VSS VSS gf180mcu_as_sc_mcu7t3v3__fillcap_16
XFILLER_173_130 VDD VDD VSS VSS gf180mcu_as_sc_mcu7t3v3__fillcap_8
XFILLER_174_664 VDD VDD VSS VSS gf180mcu_as_sc_mcu7t3v3__fill_1
X_3655_ VDD VDD VSS VSS _4016_/A _3881_/B _3881_/C _4015_/A _3656_/D gf180mcu_as_sc_mcu7t3v3__ao22_2
X_2606_ VDD VDD VSS VSS _3953_/A _3943_/A _3965_/A _3613_/B gf180mcu_as_sc_mcu7t3v3__nor3_2
XTAP_TAPCELL_ROW_154_1179 VDD VSS gf180mcu_as_sc_mcu7t3v3__tap_2
XTAP_TAPCELL_ROW_154_1168 VDD VSS gf180mcu_as_sc_mcu7t3v3__tap_2
X_3586_ VDD VDD VSS VSS _3587_/B _4830_/D _4639_/D gf180mcu_as_sc_mcu7t3v3__and2_2
XTAP_TAPCELL_ROW_171_1493 VDD VSS gf180mcu_as_sc_mcu7t3v3__tap_2
X_2537_ VDD VDD VSS VSS _2537_/B _4624_/Q _2544_/B gf180mcu_as_sc_mcu7t3v3__and2_2
X_2468_ VDD VDD VSS VSS _2468_/D _3071_/A _2492_/B _2468_/C _2470_/C gf180mcu_as_sc_mcu7t3v3__ao31_2
XFILLER_64_1293 VDD VDD VSS VSS gf180mcu_as_sc_mcu7t3v3__fill_1
X_4207_ VDD VDD VSS VSS _4209_/C _4207_/A _4207_/B _4207_/C _4207_/D gf180mcu_as_sc_mcu7t3v3__aoi22_2
X_2399_ VDD VDD VSS VSS _2399_/Y _2455_/A _2399_/B _2399_/C gf180mcu_as_sc_mcu7t3v3__ao21_2
XFILLER_151_1296 VDD VDD VSS VSS gf180mcu_as_sc_mcu7t3v3__fillcap_16
X_4138_ VDD VDD VSS VSS _4139_/B _4138_/C _4138_/B _4138_/A gf180mcu_as_sc_mcu7t3v3__aoi21b_2
XFILLER_113_57 VDD VDD VSS VSS gf180mcu_as_sc_mcu7t3v3__fill_1
X_4069_ VDD VDD VSS VSS _4780_/Q _4148_/B _4148_/C _4069_/D _4070_/C gf180mcu_as_sc_mcu7t3v3__ao22_2
XTAP_TAPCELL_ROW_96_3_2007 VDD VSS gf180mcu_as_sc_mcu7t3v3__tap_2
Xsram2048.u_bank0_813 VDD VDD VSS VSS sram2048.u_bank0/WEN[0] gf180mcu_as_sc_mcu7t3v3__tiel_4
XTAP_TAPCELL_ROW_178_1636 VDD VSS gf180mcu_as_sc_mcu7t3v3__tap_2
XTAP_TAPCELL_ROW_178_1625 VDD VSS gf180mcu_as_sc_mcu7t3v3__tap_2
XFILLER_11_136 VDD VDD VSS VSS gf180mcu_as_sc_mcu7t3v3__fillcap_4
XFILLER_138_32 VDD VDD VSS VSS gf180mcu_as_sc_mcu7t3v3__fill_2
XFILLER_153_804 VDD VDD VSS VSS gf180mcu_as_sc_mcu7t3v3__fillcap_16
XFILLER_165_653 VDD VDD VSS VSS gf180mcu_as_sc_mcu7t3v3__fill_2
XFILLER_192_450 VDD VDD VSS VSS gf180mcu_as_sc_mcu7t3v3__fill_1
XFILLER_164_174 VDD VDD VSS VSS gf180mcu_as_sc_mcu7t3v3__fill_1
XFILLER_4_803 VDD VDD VSS VSS gf180mcu_as_sc_mcu7t3v3__fill_2
XTAP_TAPCELL_ROW_191_1869 VDD VSS gf180mcu_as_sc_mcu7t3v3__tap_2
XFILLER_138_98 VDD VDD VSS VSS gf180mcu_as_sc_mcu7t3v3__fillcap_4
XFILLER_152_358 VDD VDD VSS VSS gf180mcu_as_sc_mcu7t3v3__fillcap_16
XFILLER_180_667 VDD VDD VSS VSS gf180mcu_as_sc_mcu7t3v3__fillcap_16
XFILLER_4_858 VDD VDD VSS VSS gf180mcu_as_sc_mcu7t3v3__fill_2
XFILLER_154_53 VDD VDD VSS VSS gf180mcu_as_sc_mcu7t3v3__fill_1
XFILLER_191_1076 VDD VDD VSS VSS gf180mcu_as_sc_mcu7t3v3__fillcap_4
XFILLER_154_97 VDD VDD VSS VSS gf180mcu_as_sc_mcu7t3v3__fillcap_8
XFILLER_170_30 VDD VDD VSS VSS gf180mcu_as_sc_mcu7t3v3__fillcap_4
XFILLER_170_41 VDD VDD VSS VSS gf180mcu_as_sc_mcu7t3v3__fill_1
XTAP_TAPCELL_ROW_53_3_1964 VDD VSS gf180mcu_as_sc_mcu7t3v3__tap_2
XFILLER_167_1270 VDD VDD VSS VSS gf180mcu_as_sc_mcu7t3v3__fill_1
XFILLER_128_1276 VDD VDD VSS VSS gf180mcu_as_sc_mcu7t3v3__fill_2
XFILLER_187_222 VDD VDD VSS VSS gf180mcu_as_sc_mcu7t3v3__fillcap_4
XFILLER_63_72 VDD VDD VSS VSS gf180mcu_as_sc_mcu7t3v3__fillcap_8
XFILLER_163_1189 VDD VDD VSS VSS gf180mcu_as_sc_mcu7t3v3__fill_1
XFILLER_8_34 VDD VDD VSS VSS gf180mcu_as_sc_mcu7t3v3__fill_1
XFILLER_156_664 VDD VDD VSS VSS gf180mcu_as_sc_mcu7t3v3__fill_1
XFILLER_183_450 VDD VDD VSS VSS gf180mcu_as_sc_mcu7t3v3__fillcap_16
Xwire550 VDD VDD VSS VSS _2668_/Y wire550/Y gf180mcu_as_sc_mcu7t3v3__clkbuff_12
XFILLER_13_1170 VDD VDD VSS VSS gf180mcu_as_sc_mcu7t3v3__fillcap_4
XFILLER_155_152 VDD VDD VSS VSS gf180mcu_as_sc_mcu7t3v3__fill_1
XFILLER_13_1192 VDD VDD VSS VSS gf180mcu_as_sc_mcu7t3v3__fill_1
XFILLER_171_645 VDD VDD VSS VSS gf180mcu_as_sc_mcu7t3v3__fill_1
X_3440_ VDD VDD VSS VSS _4569_/Q _3443_/B _3442_/C _4568_/Q _4568_/D gf180mcu_as_sc_mcu7t3v3__ao22_2
XFILLER_174_1241 VDD VDD VSS VSS gf180mcu_as_sc_mcu7t3v3__fillcap_8
X_3371_ VDD VDD VSS VSS _4537_/Q _3395_/B _3403_/C _4538_/Q _3372_/C gf180mcu_as_sc_mcu7t3v3__ao22_2
XFILLER_152_881 VDD VDD VSS VSS gf180mcu_as_sc_mcu7t3v3__fill_2
XFILLER_170_177 VDD VDD VSS VSS gf180mcu_as_sc_mcu7t3v3__fillcap_4
XFILLER_69_103 VDD VDD VSS VSS gf180mcu_as_sc_mcu7t3v3__fill_2
X_2322_ VDD VDD VSS VSS _4830_/D _4655_/Q _4656_/Q _4830_/Q _2348_/D gf180mcu_as_sc_mcu7t3v3__ao22_2
XFILLER_48_1299 VDD VDD VSS VSS gf180mcu_as_sc_mcu7t3v3__fillcap_4
Xload_slew577 VDD VDD VSS VSS _2660_/Y fanout576/A gf180mcu_as_sc_mcu7t3v3__clkbuff_12
X_2253_ VDD VDD VSS VSS _3580_/A _2267_/C _2253_/C _4583_/Q _2254_/D gf180mcu_as_sc_mcu7t3v3__ao22_2
X_2184_ VDD VDD VSS VSS _4259_/A _3920_/A gf180mcu_as_sc_mcu7t3v3__inv_2
XFILLER_146_1321 VDD VDD VSS VSS gf180mcu_as_sc_mcu7t3v3__fillcap_16
XFILLER_168_1078 VDD VDD VSS VSS gf180mcu_as_sc_mcu7t3v3__fillcap_4
XFILLER_179_734 VDD VDD VSS VSS gf180mcu_as_sc_mcu7t3v3__fillcap_8
XFILLER_178_244 VDD VDD VSS VSS gf180mcu_as_sc_mcu7t3v3__fill_1
XFILLER_179_767 VDD VDD VSS VSS gf180mcu_as_sc_mcu7t3v3__fill_2
XFILLER_181_1256 VDD VDD VSS VSS gf180mcu_as_sc_mcu7t3v3__fillcap_4
XFILLER_181_1278 VDD VDD VSS VSS gf180mcu_as_sc_mcu7t3v3__fillcap_16
X_4825_ VDD VDD VSS VSS _4830_/CLK _4825_/D _4825_/Q gf180mcu_as_sc_mcu7t3v3__dfxtp_2
XTAP_TAPCELL_ROW_156_1219 VDD VSS gf180mcu_as_sc_mcu7t3v3__tap_2
XTAP_TAPCELL_ROW_156_1208 VDD VSS gf180mcu_as_sc_mcu7t3v3__tap_2
XPHY_EDGE_ROW_104_1_Left_296 VDD VSS gf180mcu_as_sc_mcu7t3v3__tap_2
XFILLER_181_409 VDD VDD VSS VSS gf180mcu_as_sc_mcu7t3v3__fillcap_8
X_4756_ VDD VDD VSS VSS clkload3/A _4756_/D _4756_/Q gf180mcu_as_sc_mcu7t3v3__dfxtp_2
XTAP_TAPCELL_ROW_173_1533 VDD VSS gf180mcu_as_sc_mcu7t3v3__tap_2
XFILLER_190_921 VDD VDD VSS VSS gf180mcu_as_sc_mcu7t3v3__fillcap_16
X_4687_ VDD VDD VSS VSS _4692_/CLK _4687_/D _4687_/Q gf180mcu_as_sc_mcu7t3v3__dfxtp_2
X_3707_ VDD VDD VSS VSS _3890_/S _4060_/A _3709_/C gf180mcu_as_sc_mcu7t3v3__or2_2
XFILLER_162_645 VDD VDD VSS VSS gf180mcu_as_sc_mcu7t3v3__fillcap_16
XFILLER_175_1016 VDD VDD VSS VSS gf180mcu_as_sc_mcu7t3v3__fillcap_8
XFILLER_179_1185 VDD VDD VSS VSS gf180mcu_as_sc_mcu7t3v3__fillcap_4
X_3638_ VDD VDD VSS VSS _3993_/B _3876_/B _3638_/C _3876_/D _3643_/B gf180mcu_as_sc_mcu7t3v3__ao211_2
XPHY_EDGE_ROW_41_1_Left_233 VDD VSS gf180mcu_as_sc_mcu7t3v3__tap_2
XFILLER_162_678 VDD VDD VSS VSS gf180mcu_as_sc_mcu7t3v3__fillcap_16
XFILLER_175_1049 VDD VDD VSS VSS gf180mcu_as_sc_mcu7t3v3__fill_1
XFILLER_1_806 VDD VDD VSS VSS gf180mcu_as_sc_mcu7t3v3__fillcap_16
X_3569_ VDD VDD VSS VSS _3569_/B _4625_/Q _3570_/B gf180mcu_as_sc_mcu7t3v3__or2_2
XFILLER_108_79 VDD VDD VSS VSS gf180mcu_as_sc_mcu7t3v3__fillcap_4
XFILLER_191_18 VDD VDD VSS VSS gf180mcu_as_sc_mcu7t3v3__fillcap_16
XFILLER_192_1352 VDD VDD VSS VSS gf180mcu_as_sc_mcu7t3v3__fill_2
Xinput206 VDD VDD VSS VSS se_in[25] _4210_/D gf180mcu_as_sc_mcu7t3v3__buff_12
Xinput217 VDD VDD VSS VSS se_in[35] _3959_/B gf180mcu_as_sc_mcu7t3v3__buff_12
XFILLER_124_34 VDD VDD VSS VSS gf180mcu_as_sc_mcu7t3v3__fill_1
Xinput228 VDD VDD VSS VSS south_in[12] _4100_/A gf180mcu_as_sc_mcu7t3v3__buff_12
Xinput239 VDD VDD VSS VSS south_in[22] _4183_/A gf180mcu_as_sc_mcu7t3v3__buff_12
XFILLER_13_902 VDD VDD VSS VSS gf180mcu_as_sc_mcu7t3v3__fillcap_16
XFILLER_17_76 VDD VDD VSS VSS gf180mcu_as_sc_mcu7t3v3__fill_2
XFILLER_169_222 VDD VDD VSS VSS gf180mcu_as_sc_mcu7t3v3__fillcap_8
XFILLER_73_1326 VDD VDD VSS VSS gf180mcu_as_sc_mcu7t3v3__fillcap_4
XFILLER_169_266 VDD VDD VSS VSS gf180mcu_as_sc_mcu7t3v3__fill_2
XFILLER_12_467 VDD VDD VSS VSS gf180mcu_as_sc_mcu7t3v3__fillcap_4
XFILLER_184_203 VDD VDD VSS VSS gf180mcu_as_sc_mcu7t3v3__fillcap_16
XFILLER_33_64 VDD VDD VSS VSS gf180mcu_as_sc_mcu7t3v3__fillcap_4
XFILLER_184_247 VDD VDD VSS VSS gf180mcu_as_sc_mcu7t3v3__fillcap_16
XFILLER_158_1203 VDD VDD VSS VSS gf180mcu_as_sc_mcu7t3v3__fill_1
XFILLER_181_932 VDD VDD VSS VSS gf180mcu_as_sc_mcu7t3v3__fill_2
XFILLER_165_30 VDD VDD VSS VSS gf180mcu_as_sc_mcu7t3v3__fill_2
XFILLER_180_420 VDD VDD VSS VSS gf180mcu_as_sc_mcu7t3v3__fillcap_16
XFILLER_192_280 VDD VDD VSS VSS gf180mcu_as_sc_mcu7t3v3__fill_1
XFILLER_4_611 VDD VDD VSS VSS gf180mcu_as_sc_mcu7t3v3__fill_2
XFILLER_158_1258 VDD VDD VSS VSS gf180mcu_as_sc_mcu7t3v3__fillcap_4
XFILLER_181_998 VDD VDD VSS VSS gf180mcu_as_sc_mcu7t3v3__fillcap_16
XFILLER_3_132 VDD VDD VSS VSS gf180mcu_as_sc_mcu7t3v3__fillcap_8
XPHY_EDGE_ROW_98_1_Left_290 VDD VSS gf180mcu_as_sc_mcu7t3v3__tap_2
XFILLER_165_85 VDD VDD VSS VSS gf180mcu_as_sc_mcu7t3v3__fill_1
XPHY_EDGE_ROW_53_3_Right_94 VDD VSS gf180mcu_as_sc_mcu7t3v3__tap_2
XFILLER_0_883 VDD VDD VSS VSS gf180mcu_as_sc_mcu7t3v3__fill_1
XFILLER_0_894 VDD VDD VSS VSS gf180mcu_as_sc_mcu7t3v3__fill_1
XPHY_EDGE_ROW_56_3_Left_428 VDD VSS gf180mcu_as_sc_mcu7t3v3__tap_2
XFILLER_169_1332 VDD VDD VSS VSS gf180mcu_as_sc_mcu7t3v3__fillcap_16
XPHY_EDGE_ROW_101_1_Right_610 VDD VSS gf180mcu_as_sc_mcu7t3v3__tap_2
X_2940_ VDD VDD VSS VSS _4369_/Q _2951_/B _3017_/A _2951_/D _4369_/D gf180mcu_as_sc_mcu7t3v3__ao22_2
X_2871_ VDD VDD VSS VSS _4188_/A _2871_/B _2871_/C _3031_/A _2871_/D gf180mcu_as_sc_mcu7t3v3__aoi211_2
XFILLER_188_597 VDD VDD VSS VSS gf180mcu_as_sc_mcu7t3v3__fill_2
X_4610_ VDD VDD VSS VSS _4808_/CLK _4610_/D _4610_/Q gf180mcu_as_sc_mcu7t3v3__dfxtp_2
XFILLER_175_247 VDD VDD VSS VSS gf180mcu_as_sc_mcu7t3v3__fillcap_4
X_4541_ VDD VDD VSS VSS _4804_/CLK _4541_/D _4541_/Q gf180mcu_as_sc_mcu7t3v3__dfxtp_2
XFILLER_172_943 VDD VDD VSS VSS gf180mcu_as_sc_mcu7t3v3__fill_2
X_4472_ VDD VDD VSS VSS _4576_/CLK _4472_/D _4472_/Q gf180mcu_as_sc_mcu7t3v3__dfxtp_2
X_3423_ VDD VDD VSS VSS _4552_/Q _3445_/B _3449_/B _4551_/Q _4551_/D gf180mcu_as_sc_mcu7t3v3__ao22_2
X_3354_ VDD VDD VSS VSS _3369_/A _3354_/B _3354_/C _3356_/B _3354_/D gf180mcu_as_sc_mcu7t3v3__aoi31_2
X_3285_ VDD VDD VSS VSS _3405_/B _4462_/Q _3292_/D gf180mcu_as_sc_mcu7t3v3__and2_2
X_2305_ VDD VDD VSS VSS _4576_/Q _4575_/Q _2306_/C gf180mcu_as_sc_mcu7t3v3__xnor2_2
X_2236_ VDD VDD VSS VSS _3458_/A _4580_/Q _2563_/D gf180mcu_as_sc_mcu7t3v3__or2_2
XFILLER_61_1296 VDD VDD VSS VSS gf180mcu_as_sc_mcu7t3v3__fill_2
XTAP_TAPCELL_ROW_166_1392 VDD VSS gf180mcu_as_sc_mcu7t3v3__tap_2
XFILLER_181_1075 VDD VDD VSS VSS gf180mcu_as_sc_mcu7t3v3__fillcap_4
XFILLER_33_1321 VDD VDD VSS VSS gf180mcu_as_sc_mcu7t3v3__fill_2
XFILLER_166_247 VDD VDD VSS VSS gf180mcu_as_sc_mcu7t3v3__fillcap_8
XFILLER_186_18 VDD VDD VSS VSS gf180mcu_as_sc_mcu7t3v3__fillcap_16
X_4808_ VDD VDD VSS VSS _4808_/CLK _4808_/D _4808_/Q gf180mcu_as_sc_mcu7t3v3__dfxtp_2
XTAP_TAPCELL_ROW_192_1920 VDD VSS gf180mcu_as_sc_mcu7t3v3__tap_2
X_4739_ VDD VDD VSS VSS _4751_/CLK _4739_/D _4739_/Q gf180mcu_as_sc_mcu7t3v3__dfxtp_2
XTAP_TAPCELL_ROW_105_3_2016 VDD VSS gf180mcu_as_sc_mcu7t3v3__tap_2
XFILLER_174_291 VDD VDD VSS VSS gf180mcu_as_sc_mcu7t3v3__fill_1
XFILLER_79_27 VDD VDD VSS VSS gf180mcu_as_sc_mcu7t3v3__fill_2
XFILLER_119_89 VDD VDD VSS VSS gf180mcu_as_sc_mcu7t3v3__fill_1
XFILLER_162_442 VDD VDD VSS VSS gf180mcu_as_sc_mcu7t3v3__fill_2
Xmax_cap680 VDD VDD VSS VSS _3975_/Y fanout678/A gf180mcu_as_sc_mcu7t3v3__clkbuff_12
XPHY_EDGE_ROW_140_1_Right_649 VDD VSS gf180mcu_as_sc_mcu7t3v3__tap_2
XFILLER_153_1122 VDD VDD VSS VSS gf180mcu_as_sc_mcu7t3v3__fillcap_4
XFILLER_1_636 VDD VDD VSS VSS gf180mcu_as_sc_mcu7t3v3__fill_2
XFILLER_118_1297 VDD VDD VSS VSS gf180mcu_as_sc_mcu7t3v3__fill_1
XFILLER_135_88 VDD VDD VSS VSS gf180mcu_as_sc_mcu7t3v3__fillcap_16
XFILLER_40_1303 VDD VDD VSS VSS gf180mcu_as_sc_mcu7t3v3__fill_2
XTAP_TAPCELL_ROW_186_1779 VDD VSS gf180mcu_as_sc_mcu7t3v3__tap_2
XFILLER_151_54 VDD VDD VSS VSS gf180mcu_as_sc_mcu7t3v3__fillcap_16
XTAP_TAPCELL_ROW_0_691 VDD VSS gf180mcu_as_sc_mcu7t3v3__tap_2
XTAP_TAPCELL_ROW_0_680 VDD VSS gf180mcu_as_sc_mcu7t3v3__tap_2
XFILLER_157_203 VDD VDD VSS VSS gf180mcu_as_sc_mcu7t3v3__fillcap_4
XTAP_TAPCELL_ROW_11_900 VDD VSS gf180mcu_as_sc_mcu7t3v3__tap_2
XFILLER_125_1268 VDD VDD VSS VSS gf180mcu_as_sc_mcu7t3v3__fill_2
XFILLER_12_264 VDD VDD VSS VSS gf180mcu_as_sc_mcu7t3v3__fill_1
XFILLER_173_718 VDD VDD VSS VSS gf180mcu_as_sc_mcu7t3v3__fillcap_4
XFILLER_185_578 VDD VDD VSS VSS gf180mcu_as_sc_mcu7t3v3__fillcap_4
XFILLER_60_62 VDD VDD VSS VSS gf180mcu_as_sc_mcu7t3v3__fill_1
XFILLER_154_943 VDD VDD VSS VSS gf180mcu_as_sc_mcu7t3v3__fill_2
XFILLER_176_73 VDD VDD VSS VSS gf180mcu_as_sc_mcu7t3v3__fill_2
XFILLER_153_442 VDD VDD VSS VSS gf180mcu_as_sc_mcu7t3v3__fillcap_16
XFILLER_4_452 VDD VDD VSS VSS gf180mcu_as_sc_mcu7t3v3__fill_2
XPHY_EDGE_ROW_154_Right_16 VDD VSS gf180mcu_as_sc_mcu7t3v3__tap_2
XFILLER_5_68 VDD VDD VSS VSS gf180mcu_as_sc_mcu7t3v3__fill_2
XFILLER_45_1258 VDD VDD VSS VSS gf180mcu_as_sc_mcu7t3v3__fillcap_16
XFILLER_171_1277 VDD VDD VSS VSS gf180mcu_as_sc_mcu7t3v3__fill_1
X_3070_ VDD VDD VSS VSS _3070_/S _3585_/B _4469_/Q _4469_/D gf180mcu_as_sc_mcu7t3v3__mux2_2
XPHY_EDGE_ROW_163_Right_25 VDD VSS gf180mcu_as_sc_mcu7t3v3__tap_2
XPHY_EDGE_ROW_102_1_Right_611 VDD VSS gf180mcu_as_sc_mcu7t3v3__tap_2
XFILLER_165_1048 VDD VDD VSS VSS gf180mcu_as_sc_mcu7t3v3__fill_2
X_3972_ VDD VDD VSS VSS _3974_/B _4264_/B _3972_/Y gf180mcu_as_sc_mcu7t3v3__and2_2
X_2923_ VDD VDD VSS VSS _2978_/A _2966_/A _3009_/A gf180mcu_as_sc_mcu7t3v3__and2_2
X_2854_ VDD VDD VSS VSS _4352_/Q _2906_/B _2998_/A _2906_/D _4352_/D gf180mcu_as_sc_mcu7t3v3__ao22_2
X_2785_ VDD VDD VSS VSS _2822_/B _4110_/A _2786_/D gf180mcu_as_sc_mcu7t3v3__and2_2
XFILLER_157_792 VDD VDD VSS VSS gf180mcu_as_sc_mcu7t3v3__fillcap_16
XFILLER_163_228 VDD VDD VSS VSS gf180mcu_as_sc_mcu7t3v3__fillcap_16
X_4524_ VDD VDD VSS VSS _4789_/CLK _4524_/D _4524_/Q gf180mcu_as_sc_mcu7t3v3__dfxtp_2
XPHY_EDGE_ROW_172_Right_34 VDD VSS gf180mcu_as_sc_mcu7t3v3__tap_2
XFILLER_172_751 VDD VDD VSS VSS gf180mcu_as_sc_mcu7t3v3__fill_1
X_4455_ VDD VDD VSS VSS _4606_/CLK _4455_/D _4455_/Q gf180mcu_as_sc_mcu7t3v3__dfxtp_2
XFILLER_63_1314 VDD VDD VSS VSS gf180mcu_as_sc_mcu7t3v3__fillcap_8
Xfanout704 VDD VDD VSS VSS _3924_/B _3866_/B gf180mcu_as_sc_mcu7t3v3__buff_12
Xfanout715 VDD VDD VSS VSS _3582_/A _3604_/A gf180mcu_as_sc_mcu7t3v3__buff_12
X_4386_ VDD VDD VSS VSS _4447_/CLK _4386_/D _4386_/Q gf180mcu_as_sc_mcu7t3v3__dfxtp_2
X_3406_ VDD VDD VSS VSS _3408_/A _4442_/Q _4384_/Q _3407_/A gf180mcu_as_sc_mcu7t3v3__mux2_2
Xfanout726 VDD VDD VSS VSS _3541_/A _4292_/C gf180mcu_as_sc_mcu7t3v3__buff_12
Xfanout737 VDD VDD VSS VSS fanout743/Y _3346_/A gf180mcu_as_sc_mcu7t3v3__buff_12
Xfanout748 VDD VDD VSS VSS fanout750/Y _3344_/S gf180mcu_as_sc_mcu7t3v3__buff_12
X_3337_ VDD VDD VSS VSS _3338_/D _3337_/B _3346_/A gf180mcu_as_sc_mcu7t3v3__nor2_2
XTAP_TAPCELL_ROW_168_1443 VDD VSS gf180mcu_as_sc_mcu7t3v3__tap_2
XTAP_TAPCELL_ROW_168_1432 VDD VSS gf180mcu_as_sc_mcu7t3v3__tap_2
Xfanout759 VDD VDD VSS VSS _3956_/A _3945_/A gf180mcu_as_sc_mcu7t3v3__buff_12
XFILLER_105_69 VDD VDD VSS VSS gf180mcu_as_sc_mcu7t3v3__fill_1
XFILLER_6_1252 VDD VDD VSS VSS gf180mcu_as_sc_mcu7t3v3__fill_2
X_3268_ VDD VDD VSS VSS _3348_/A _3268_/B _3268_/C _3268_/D _4524_/D gf180mcu_as_sc_mcu7t3v3__ao211_2
XPHY_EDGE_ROW_181_Right_43 VDD VSS gf180mcu_as_sc_mcu7t3v3__tap_2
X_3199_ VDD VDD VSS VSS _4514_/D _3199_/A _3210_/B _3199_/C _3199_/D gf180mcu_as_sc_mcu7t3v3__aoi22_2
X_2219_ VDD VDD VSS VSS _4107_/A _2773_/A gf180mcu_as_sc_mcu7t3v3__inv_2
XFILLER_187_1262 VDD VDD VSS VSS gf180mcu_as_sc_mcu7t3v3__fillcap_4
XTAP_TAPCELL_ROW_181_1687 VDD VSS gf180mcu_as_sc_mcu7t3v3__tap_2
XTAP_TAPCELL_ROW_181_1676 VDD VSS gf180mcu_as_sc_mcu7t3v3__tap_2
XFILLER_187_1295 VDD VDD VSS VSS gf180mcu_as_sc_mcu7t3v3__fillcap_16
XFILLER_10_713 VDD VDD VSS VSS gf180mcu_as_sc_mcu7t3v3__fillcap_8
XFILLER_167_589 VDD VDD VSS VSS gf180mcu_as_sc_mcu7t3v3__fillcap_16
XPHY_EDGE_ROW_190_Right_52 VDD VSS gf180mcu_as_sc_mcu7t3v3__tap_2
XFILLER_154_217 VDD VDD VSS VSS gf180mcu_as_sc_mcu7t3v3__fillcap_16
XFILLER_163_795 VDD VDD VSS VSS gf180mcu_as_sc_mcu7t3v3__fillcap_16
XFILLER_190_570 VDD VDD VSS VSS gf180mcu_as_sc_mcu7t3v3__fillcap_8
XFILLER_30_87 VDD VDD VSS VSS gf180mcu_as_sc_mcu7t3v3__fillcap_4
XTAP_TAPCELL_ROW_188_1819 VDD VSS gf180mcu_as_sc_mcu7t3v3__tap_2
XFILLER_162_53 VDD VDD VSS VSS gf180mcu_as_sc_mcu7t3v3__fillcap_16
XTAP_TAPCELL_ROW_5_783 VDD VSS gf180mcu_as_sc_mcu7t3v3__tap_2
XPHY_EDGE_ROW_129_1_Left_321 VDD VSS gf180mcu_as_sc_mcu7t3v3__tap_2
XFILLER_131_1272 VDD VDD VSS VSS gf180mcu_as_sc_mcu7t3v3__fill_1
XTAP_TAPCELL_ROW_5_794 VDD VSS gf180mcu_as_sc_mcu7t3v3__tap_2
XFILLER_166_1346 VDD VDD VSS VSS gf180mcu_as_sc_mcu7t3v3__fillcap_4
XFILLER_111_90 VDD VDD VSS VSS gf180mcu_as_sc_mcu7t3v3__fill_1
XFILLER_13_584 VDD VDD VSS VSS gf180mcu_as_sc_mcu7t3v3__fill_2
XFILLER_71_83 VDD VDD VSS VSS gf180mcu_as_sc_mcu7t3v3__fillcap_16
XFILLER_187_72 VDD VDD VSS VSS gf180mcu_as_sc_mcu7t3v3__fillcap_4
XFILLER_173_559 VDD VDD VSS VSS gf180mcu_as_sc_mcu7t3v3__fill_1
XTAP_TAPCELL_ROW_95_1_1048 VDD VSS gf180mcu_as_sc_mcu7t3v3__tap_2
X_2570_ VDD VDD VSS VSS _3514_/B _3585_/A _2582_/B gf180mcu_as_sc_mcu7t3v3__and2_2
XFILLER_154_773 VDD VDD VSS VSS gf180mcu_as_sc_mcu7t3v3__fill_2
XFILLER_181_570 VDD VDD VSS VSS gf180mcu_as_sc_mcu7t3v3__fill_2
XFILLER_5_772 VDD VDD VSS VSS gf180mcu_as_sc_mcu7t3v3__fillcap_8
XFILLER_153_294 VDD VDD VSS VSS gf180mcu_as_sc_mcu7t3v3__fillcap_16
XFILLER_5_794 VDD VDD VSS VSS gf180mcu_as_sc_mcu7t3v3__fillcap_16
X_4240_ VDD VDD VSS VSS _4252_/A _4253_/B _4240_/A gf180mcu_as_sc_mcu7t3v3__nand2_2
X_4171_ VDD VDD VSS VSS _4172_/B _4331_/A _4187_/D _4171_/A gf180mcu_as_sc_mcu7t3v3__aoi21b_2
XFILLER_171_1052 VDD VDD VSS VSS gf180mcu_as_sc_mcu7t3v3__fillcap_8
X_3122_ VDD VDD VSS VSS _3122_/S _4510_/Q _4509_/Q _4509_/D gf180mcu_as_sc_mcu7t3v3__mux2_2
XPHY_EDGE_ROW_16_3_Right_57 VDD VSS gf180mcu_as_sc_mcu7t3v3__tap_2
X_3053_ VDD VDD VSS VSS _3054_/C _4453_/Q _3053_/B _3071_/B gf180mcu_as_sc_mcu7t3v3__aoi21_2
XTAP_TAPCELL_ROW_163_1340 VDD VSS gf180mcu_as_sc_mcu7t3v3__tap_2
XTAP_TAPCELL_ROW_163_1351 VDD VSS gf180mcu_as_sc_mcu7t3v3__tap_2
XPHY_EDGE_ROW_50_1_Left_242 VDD VSS gf180mcu_as_sc_mcu7t3v3__tap_2
XPHY_EDGE_ROW_103_1_Right_612 VDD VSS gf180mcu_as_sc_mcu7t3v3__tap_2
X_3955_ VDD VDD VSS VSS _3955_/A _3955_/B _3955_/C _3955_/D _3956_/B gf180mcu_as_sc_mcu7t3v3__ao211_2
X_2906_ VDD VDD VSS VSS _4358_/Q _2906_/B _3004_/A _2906_/D _4358_/D gf180mcu_as_sc_mcu7t3v3__ao22_2
XFILLER_192_813 VDD VDD VSS VSS gf180mcu_as_sc_mcu7t3v3__fill_2
X_3886_ VDD VDD VSS VSS _3928_/B _3886_/B _3953_/C gf180mcu_as_sc_mcu7t3v3__nand2_2
XFILLER_178_1217 VDD VDD VSS VSS gf180mcu_as_sc_mcu7t3v3__fillcap_8
Xclkbuf_leaf_0_clk_regs VDD VDD VSS VSS clkbuf_leaf_1_clk_regs/A _4751_/CLK gf180mcu_as_sc_mcu7t3v3__clkbuff_12
X_2837_ VDD VDD VSS VSS _2891_/B _4160_/A _2841_/C gf180mcu_as_sc_mcu7t3v3__and2_2
X_2768_ VDD VDD VSS VSS _4096_/A _2823_/B _2768_/C _2768_/D _2770_/C gf180mcu_as_sc_mcu7t3v3__ao211_2
XPHY_EDGE_ROW_133_3_Left_505 VDD VSS gf180mcu_as_sc_mcu7t3v3__tap_2
X_4507_ VDD VDD VSS VSS _4708_/CLK _4507_/D _4507_/Q gf180mcu_as_sc_mcu7t3v3__dfxtp_2
X_2699_ VDD VDD VSS VSS _4335_/Q _2772_/B _2981_/A _2772_/D _4335_/D gf180mcu_as_sc_mcu7t3v3__ao22_2
XFILLER_172_592 VDD VDD VSS VSS gf180mcu_as_sc_mcu7t3v3__fill_2
X_4438_ VDD VDD VSS VSS _4445_/CLK _4438_/D _4438_/Q gf180mcu_as_sc_mcu7t3v3__dfxtp_2
XFILLER_160_765 VDD VDD VSS VSS gf180mcu_as_sc_mcu7t3v3__fill_1
Xfanout501 VDD VDD VSS VSS _2919_/B _2905_/B gf180mcu_as_sc_mcu7t3v3__buff_12
Xfanout512 VDD VDD VSS VSS _2655_/Y _2896_/D gf180mcu_as_sc_mcu7t3v3__buff_12
XFILLER_116_79 VDD VDD VSS VSS gf180mcu_as_sc_mcu7t3v3__fill_1
XFILLER_28_1286 VDD VDD VSS VSS gf180mcu_as_sc_mcu7t3v3__fill_2
Xfanout534 VDD VDD VSS VSS _3982_/Y _4210_/B gf180mcu_as_sc_mcu7t3v3__buff_12
Xfanout545 VDD VDD VSS VSS _3133_/Y _3219_/S gf180mcu_as_sc_mcu7t3v3__buff_12
Xfanout556 VDD VDD VSS VSS _4312_/B _4310_/B gf180mcu_as_sc_mcu7t3v3__buff_12
X_4369_ VDD VDD VSS VSS clkload9/A _4369_/D _4369_/Q gf180mcu_as_sc_mcu7t3v3__dfxtp_2
XFILLER_115_1256 VDD VDD VSS VSS gf180mcu_as_sc_mcu7t3v3__fillcap_16
XFILLER_154_1294 VDD VDD VSS VSS gf180mcu_as_sc_mcu7t3v3__fill_1
XFILLER_189_1302 VDD VDD VSS VSS gf180mcu_as_sc_mcu7t3v3__fillcap_16
XFILLER_28_1297 VDD VDD VSS VSS gf180mcu_as_sc_mcu7t3v3__fill_1
Xfanout567 VDD VDD VSS VSS _3347_/C _3315_/C gf180mcu_as_sc_mcu7t3v3__buff_12
Xfanout578 VDD VDD VSS VSS _2917_/B _2903_/B gf180mcu_as_sc_mcu7t3v3__buff_12
Xfanout589 VDD VDD VSS VSS _3124_/S _3122_/S gf180mcu_as_sc_mcu7t3v3__buff_12
XTAP_TAPCELL_ROW_183_1727 VDD VSS gf180mcu_as_sc_mcu7t3v3__tap_2
XTAP_TAPCELL_ROW_183_1716 VDD VSS gf180mcu_as_sc_mcu7t3v3__tap_2
Xmesh_tile_971 VDD VDD VSS VSS se_out[35] gf180mcu_as_sc_mcu7t3v3__tiel_4
Xmesh_tile_960 VDD VDD VSS VSS se_out[24] gf180mcu_as_sc_mcu7t3v3__tiel_4
XTAP_TAPCELL_ROW_2_731 VDD VSS gf180mcu_as_sc_mcu7t3v3__tap_2
XTAP_TAPCELL_ROW_2_720 VDD VSS gf180mcu_as_sc_mcu7t3v3__tap_2
Xmesh_tile_993 VDD VDD VSS VSS sw_out[21] gf180mcu_as_sc_mcu7t3v3__tiel_4
Xmesh_tile_982 VDD VDD VSS VSS sw_out[10] gf180mcu_as_sc_mcu7t3v3__tiel_4
XFILLER_92_27 VDD VDD VSS VSS gf180mcu_as_sc_mcu7t3v3__fillcap_8
XFILLER_41_101 VDD VDD VSS VSS gf180mcu_as_sc_mcu7t3v3__fillcap_4
XFILLER_161_1243 VDD VDD VSS VSS gf180mcu_as_sc_mcu7t3v3__fillcap_4
XFILLER_157_31 VDD VDD VSS VSS gf180mcu_as_sc_mcu7t3v3__fillcap_4
XFILLER_183_835 VDD VDD VSS VSS gf180mcu_as_sc_mcu7t3v3__fillcap_4
XPHY_EDGE_ROW_65_3_Left_437 VDD VSS gf180mcu_as_sc_mcu7t3v3__tap_2
XFILLER_159_1161 VDD VDD VSS VSS gf180mcu_as_sc_mcu7t3v3__fillcap_8
XFILLER_170_518 VDD VDD VSS VSS gf180mcu_as_sc_mcu7t3v3__fillcap_4
XFILLER_81_1266 VDD VDD VSS VSS gf180mcu_as_sc_mcu7t3v3__fill_1
XFILLER_166_1165 VDD VDD VSS VSS gf180mcu_as_sc_mcu7t3v3__fillcap_4
XFILLER_166_1176 VDD VDD VSS VSS gf180mcu_as_sc_mcu7t3v3__fillcap_16
XANTENNA_19 VDD VDD VSS VSS _3958_/C gf180mcu_as_sc_mcu7t3v3__diode_2
XFILLER_177_139 VDD VDD VSS VSS gf180mcu_as_sc_mcu7t3v3__fill_1
X_3740_ VDD VDD VSS VSS _3794_/B _4093_/D _3741_/C gf180mcu_as_sc_mcu7t3v3__and2_2
XFILLER_158_364 VDD VDD VSS VSS gf180mcu_as_sc_mcu7t3v3__fillcap_8
XFILLER_174_802 VDD VDD VSS VSS gf180mcu_as_sc_mcu7t3v3__fill_2
XFILLER_9_352 VDD VDD VSS VSS gf180mcu_as_sc_mcu7t3v3__fillcap_4
XFILLER_158_397 VDD VDD VSS VSS gf180mcu_as_sc_mcu7t3v3__fill_1
X_3671_ VDD VDD VSS VSS _4775_/Q _3852_/B _3879_/B _4029_/D _3672_/D gf180mcu_as_sc_mcu7t3v3__ao22_2
X_2622_ VDD VDD VSS VSS _2629_/B _4264_/B _2622_/Y gf180mcu_as_sc_mcu7t3v3__and2_2
XFILLER_12_1087 VDD VDD VSS VSS gf180mcu_as_sc_mcu7t3v3__fillcap_4
XFILLER_161_529 VDD VDD VSS VSS gf180mcu_as_sc_mcu7t3v3__fillcap_8
X_2553_ VDD VDD VSS VSS _2553_/B _2553_/A _3446_/A gf180mcu_as_sc_mcu7t3v3__xnor2_2
XFILLER_154_592 VDD VDD VSS VSS gf180mcu_as_sc_mcu7t3v3__fill_2
XFILLER_138_1256 VDD VDD VSS VSS gf180mcu_as_sc_mcu7t3v3__fillcap_16
X_2484_ VDD VDD VSS VSS _3071_/A _2484_/B _2484_/C _2489_/A _2486_/B gf180mcu_as_sc_mcu7t3v3__ao211_2
X_4223_ VDD VDD VSS VSS _4264_/B _4799_/Q _4257_/C gf180mcu_as_sc_mcu7t3v3__and2_2
X_4154_ VDD VDD VSS VSS _4154_/S _4154_/B _4154_/A _4155_/C gf180mcu_as_sc_mcu7t3v3__mux2_2
X_4085_ VDD VDD VSS VSS _4782_/Q _4148_/B _4148_/C _4085_/D _4086_/C gf180mcu_as_sc_mcu7t3v3__ao22_2
X_3105_ VDD VDD VSS VSS _3122_/S _4493_/Q _4492_/Q _4492_/D gf180mcu_as_sc_mcu7t3v3__mux2_2
X_3036_ VDD VDD VSS VSS _3038_/C _4446_/Q _3037_/D gf180mcu_as_sc_mcu7t3v3__and2_2
XTAP_TAPCELL_ROW_71_3_1982 VDD VSS gf180mcu_as_sc_mcu7t3v3__tap_2
XFILLER_102_37 VDD VDD VSS VSS gf180mcu_as_sc_mcu7t3v3__fillcap_4
XFILLER_184_1243 VDD VDD VSS VSS gf180mcu_as_sc_mcu7t3v3__fillcap_8
XPHY_EDGE_ROW_104_1_Right_613 VDD VSS gf180mcu_as_sc_mcu7t3v3__tap_2
XFILLER_165_813 VDD VDD VSS VSS gf180mcu_as_sc_mcu7t3v3__fillcap_16
X_3938_ VDD VDD VSS VSS _3938_/A _3961_/B _3962_/A _3938_/D _3939_/C gf180mcu_as_sc_mcu7t3v3__ao22_2
XFILLER_176_172 VDD VDD VSS VSS gf180mcu_as_sc_mcu7t3v3__fill_2
X_3869_ VDD VDD VSS VSS _4797_/Q _3869_/B _3869_/C _3869_/D _3870_/D gf180mcu_as_sc_mcu7t3v3__ao22_2
XTAP_TAPCELL_ROW_176_1597 VDD VSS gf180mcu_as_sc_mcu7t3v3__tap_2
XTAP_TAPCELL_ROW_176_1586 VDD VSS gf180mcu_as_sc_mcu7t3v3__tap_2
XFILLER_191_142 VDD VDD VSS VSS gf180mcu_as_sc_mcu7t3v3__fillcap_16
XFILLER_11_34 VDD VDD VSS VSS gf180mcu_as_sc_mcu7t3v3__fillcap_16
XFILLER_164_378 VDD VDD VSS VSS gf180mcu_as_sc_mcu7t3v3__fillcap_4
XFILLER_152_1209 VDD VDD VSS VSS gf180mcu_as_sc_mcu7t3v3__fillcap_4
XFILLER_191_1258 VDD VDD VSS VSS gf180mcu_as_sc_mcu7t3v3__fill_2
XTAP_TAPCELL_ROW_7_823 VDD VSS gf180mcu_as_sc_mcu7t3v3__tap_2
XFILLER_36_53 VDD VDD VSS VSS gf180mcu_as_sc_mcu7t3v3__fillcap_16
XFILLER_36_86 VDD VDD VSS VSS gf180mcu_as_sc_mcu7t3v3__fill_2
XFILLER_168_30 VDD VDD VSS VSS gf180mcu_as_sc_mcu7t3v3__fillcap_4
XFILLER_11_874 VDD VDD VSS VSS gf180mcu_as_sc_mcu7t3v3__fillcap_8
XFILLER_161_1084 VDD VDD VSS VSS gf180mcu_as_sc_mcu7t3v3__fillcap_16
XFILLER_168_74 VDD VDD VSS VSS gf180mcu_as_sc_mcu7t3v3__fill_2
XFILLER_183_632 VDD VDD VSS VSS gf180mcu_as_sc_mcu7t3v3__fillcap_8
XFILLER_7_812 VDD VDD VSS VSS gf180mcu_as_sc_mcu7t3v3__fillcap_16
Xinput17 VDD VDD VSS VSS boot_data[5] _2477_/A gf180mcu_as_sc_mcu7t3v3__buff_12
Xinput28 VDD VDD VSS VSS dft_addr[5] _2406_/B gf180mcu_as_sc_mcu7t3v3__buff_12
Xwire710 VDD VDD VSS VSS _5071_/A _3516_/B gf180mcu_as_sc_mcu7t3v3__clkbuff_12
Xwire732 VDD VDD VSS VSS _2339_/C _2491_/S gf180mcu_as_sc_mcu7t3v3__clkbuff_12
XFILLER_155_334 VDD VDD VSS VSS gf180mcu_as_sc_mcu7t3v3__fill_2
Xinput39 VDD VDD VSS VSS dft_wdata[4] _2470_/B gf180mcu_as_sc_mcu7t3v3__buff_12
Xwire776 VDD VDD VSS VSS wire776/A _4141_/D gf180mcu_as_sc_mcu7t3v3__clkbuff_12
XFILLER_100_1344 VDD VDD VSS VSS gf180mcu_as_sc_mcu7t3v3__fillcap_8
XFILLER_171_838 VDD VDD VSS VSS gf180mcu_as_sc_mcu7t3v3__fill_2
XFILLER_7_878 VDD VDD VSS VSS gf180mcu_as_sc_mcu7t3v3__fill_2
Xwire787 VDD VDD VSS VSS wire787/A _4065_/A gf180mcu_as_sc_mcu7t3v3__clkbuff_12
Xwire798 VDD VDD VSS VSS wire798/A _4105_/A gf180mcu_as_sc_mcu7t3v3__clkbuff_12
XFILLER_96_104 VDD VDD VSS VSS gf180mcu_as_sc_mcu7t3v3__fill_1
XFILLER_172_1180 VDD VDD VSS VSS gf180mcu_as_sc_mcu7t3v3__fillcap_4
XTAP_TAPCELL_ROW_104_1_1057 VDD VSS gf180mcu_as_sc_mcu7t3v3__tap_2
XFILLER_168_1227 VDD VDD VSS VSS gf180mcu_as_sc_mcu7t3v3__fillcap_4
XFILLER_20_104 VDD VDD VSS VSS gf180mcu_as_sc_mcu7t3v3__fill_1
XFILLER_187_982 VDD VDD VSS VSS gf180mcu_as_sc_mcu7t3v3__fillcap_8
X_4772_ VDD VDD VSS VSS _4789_/CLK _4772_/D _4772_/Q gf180mcu_as_sc_mcu7t3v3__dfxtp_2
XFILLER_179_1312 VDD VDD VSS VSS gf180mcu_as_sc_mcu7t3v3__fillcap_4
XFILLER_186_481 VDD VDD VSS VSS gf180mcu_as_sc_mcu7t3v3__fillcap_8
X_3723_ VDD VDD VSS VSS _3794_/B _4077_/D _3724_/C gf180mcu_as_sc_mcu7t3v3__and2_2
XTAP_TAPCELL_ROW_158_1250 VDD VSS gf180mcu_as_sc_mcu7t3v3__tap_2
XFILLER_105_1288 VDD VDD VSS VSS gf180mcu_as_sc_mcu7t3v3__fillcap_8
XFILLER_173_142 VDD VDD VSS VSS gf180mcu_as_sc_mcu7t3v3__fillcap_16
X_3654_ VDD VDD VSS VSS _3654_/D _3880_/A _3654_/B _3654_/C _3656_/C gf180mcu_as_sc_mcu7t3v3__ao31_2
XFILLER_9_171 VDD VDD VSS VSS gf180mcu_as_sc_mcu7t3v3__fill_2
X_2605_ VDD VDD VSS VSS _2660_/B _3969_/B _4263_/B gf180mcu_as_sc_mcu7t3v3__nand2_2
XTAP_TAPCELL_ROW_154_1169 VDD VSS gf180mcu_as_sc_mcu7t3v3__tap_2
XFILLER_155_890 VDD VDD VSS VSS gf180mcu_as_sc_mcu7t3v3__fill_1
X_3585_ VDD VDD VSS VSS _3585_/B _3585_/A _3587_/B gf180mcu_as_sc_mcu7t3v3__and2_2
X_2536_ VDD VDD VSS VSS _2537_/B _4625_/Q _4623_/Q _4626_/Q gf180mcu_as_sc_mcu7t3v3__aoi21b_2
XTAP_TAPCELL_ROW_171_1494 VDD VSS gf180mcu_as_sc_mcu7t3v3__tap_2
X_2467_ VDD VDD VSS VSS _2491_/S _4531_/Q _4523_/Q _2468_/C gf180mcu_as_sc_mcu7t3v3__mux2_2
XFILLER_64_1272 VDD VDD VSS VSS gf180mcu_as_sc_mcu7t3v3__fillcap_8
X_4206_ VDD VDD VSS VSS _4209_/B _4206_/B _4206_/A gf180mcu_as_sc_mcu7t3v3__nand2_2
XFILLER_25_1256 VDD VDD VSS VSS gf180mcu_as_sc_mcu7t3v3__fillcap_8
X_2398_ VDD VDD VSS VSS _2399_/C _2398_/C _2437_/B input6/Y gf180mcu_as_sc_mcu7t3v3__aoi21b_2
X_4137_ VDD VDD VSS VSS _4137_/A _4218_/B _4137_/C _4137_/D _4139_/A gf180mcu_as_sc_mcu7t3v3__ao211_2
XFILLER_113_69 VDD VDD VSS VSS gf180mcu_as_sc_mcu7t3v3__fill_1
X_4068_ VDD VDD VSS VSS _4068_/A _4149_/B _4149_/C _4068_/D _4070_/B gf180mcu_as_sc_mcu7t3v3__ao22_2
XFILLER_189_18 VDD VDD VSS VSS gf180mcu_as_sc_mcu7t3v3__fillcap_8
X_3019_ VDD VDD VSS VSS _3019_/A _3019_/B _3024_/C _4429_/Q _4429_/D gf180mcu_as_sc_mcu7t3v3__ao22_2
XFILLER_184_1084 VDD VDD VSS VSS gf180mcu_as_sc_mcu7t3v3__fill_1
XFILLER_184_1095 VDD VDD VSS VSS gf180mcu_as_sc_mcu7t3v3__fillcap_4
Xsram2048.u_bank0_814 VDD VDD VSS VSS sram2048.u_bank0/WEN[1] gf180mcu_as_sc_mcu7t3v3__tiel_4
XTAP_TAPCELL_ROW_178_1637 VDD VSS gf180mcu_as_sc_mcu7t3v3__tap_2
XTAP_TAPCELL_ROW_178_1626 VDD VSS gf180mcu_as_sc_mcu7t3v3__tap_2
XPHY_EDGE_ROW_105_1_Right_614 VDD VSS gf180mcu_as_sc_mcu7t3v3__tap_2
XFILLER_132_6 VDD VDD VSS VSS gf180mcu_as_sc_mcu7t3v3__fill_2
XFILLER_165_610 VDD VDD VSS VSS gf180mcu_as_sc_mcu7t3v3__fillcap_8
XFILLER_165_643 VDD VDD VSS VSS gf180mcu_as_sc_mcu7t3v3__fill_2
XFILLER_71_1298 VDD VDD VSS VSS gf180mcu_as_sc_mcu7t3v3__fill_1
XPHY_EDGE_ROW_138_1_Left_330 VDD VSS gf180mcu_as_sc_mcu7t3v3__tap_2
XFILLER_138_77 VDD VDD VSS VSS gf180mcu_as_sc_mcu7t3v3__fill_2
XFILLER_152_304 VDD VDD VSS VSS gf180mcu_as_sc_mcu7t3v3__fill_2
XFILLER_164_164 VDD VDD VSS VSS gf180mcu_as_sc_mcu7t3v3__fillcap_8
XFILLER_165_687 VDD VDD VSS VSS gf180mcu_as_sc_mcu7t3v3__fill_2
XFILLER_180_613 VDD VDD VSS VSS gf180mcu_as_sc_mcu7t3v3__fillcap_16
X_4734__1038 VDD VDD VSS VSS _4734_/D gf180mcu_as_sc_mcu7t3v3__tiel_4
XFILLER_180_657 VDD VDD VSS VSS gf180mcu_as_sc_mcu7t3v3__fillcap_8
XFILLER_192_495 VDD VDD VSS VSS gf180mcu_as_sc_mcu7t3v3__fillcap_4
XFILLER_98_37 VDD VDD VSS VSS gf180mcu_as_sc_mcu7t3v3__fill_2
XFILLER_191_1044 VDD VDD VSS VSS gf180mcu_as_sc_mcu7t3v3__fillcap_4
XFILLER_47_52 VDD VDD VSS VSS gf180mcu_as_sc_mcu7t3v3__fillcap_4
XFILLER_47_85 VDD VDD VSS VSS gf180mcu_as_sc_mcu7t3v3__fillcap_16
XFILLER_170_97 VDD VDD VSS VSS gf180mcu_as_sc_mcu7t3v3__fillcap_8
XFILLER_163_1102 VDD VDD VSS VSS gf180mcu_as_sc_mcu7t3v3__fillcap_8
XFILLER_188_768 VDD VDD VSS VSS gf180mcu_as_sc_mcu7t3v3__fill_2
XFILLER_169_982 VDD VDD VSS VSS gf180mcu_as_sc_mcu7t3v3__fillcap_16
XFILLER_8_57 VDD VDD VSS VSS gf180mcu_as_sc_mcu7t3v3__fill_2
XFILLER_156_632 VDD VDD VSS VSS gf180mcu_as_sc_mcu7t3v3__fillcap_4
XFILLER_156_654 VDD VDD VSS VSS gf180mcu_as_sc_mcu7t3v3__fillcap_8
Xwire551 VDD VDD VSS VSS _2649_/Y _4278_/A gf180mcu_as_sc_mcu7t3v3__clkbuff_12
XTAP_TAPCELL_ROW_123_3_2034 VDD VSS gf180mcu_as_sc_mcu7t3v3__tap_2
XPHY_EDGE_ROW_25_3_Right_66 VDD VSS gf180mcu_as_sc_mcu7t3v3__tap_2
XFILLER_155_142 VDD VDD VSS VSS gf180mcu_as_sc_mcu7t3v3__fillcap_8
XFILLER_155_164 VDD VDD VSS VSS gf180mcu_as_sc_mcu7t3v3__fill_2
XFILLER_171_602 VDD VDD VSS VSS gf180mcu_as_sc_mcu7t3v3__fill_2
XFILLER_7_697 VDD VDD VSS VSS gf180mcu_as_sc_mcu7t3v3__fill_2
XFILLER_170_145 VDD VDD VSS VSS gf180mcu_as_sc_mcu7t3v3__fillcap_16
XFILLER_174_1220 VDD VDD VSS VSS gf180mcu_as_sc_mcu7t3v3__fillcap_4
X_3370_ VDD VDD VSS VSS _3393_/A _3370_/B _3370_/C _3372_/B _3370_/D gf180mcu_as_sc_mcu7t3v3__aoi31_2
XFILLER_3_892 VDD VDD VSS VSS gf180mcu_as_sc_mcu7t3v3__fillcap_16
XFILLER_48_1256 VDD VDD VSS VSS gf180mcu_as_sc_mcu7t3v3__fillcap_4
X_2321_ VDD VDD VSS VSS _2342_/A _3142_/A _3142_/B _3602_/B gf180mcu_as_sc_mcu7t3v3__ao21_2
XFILLER_174_1297 VDD VDD VSS VSS gf180mcu_as_sc_mcu7t3v3__fillcap_8
X_2252_ VDD VDD VSS VSS _3530_/C _3131_/A _3571_/D gf180mcu_as_sc_mcu7t3v3__nand2_2
XFILLER_19_2 VDD VDD VSS VSS gf180mcu_as_sc_mcu7t3v3__fill_2
X_2183_ VDD VDD VSS VSS _2603_/B _3961_/B gf180mcu_as_sc_mcu7t3v3__inv_2
XFILLER_179_702 VDD VDD VSS VSS gf180mcu_as_sc_mcu7t3v3__fillcap_16
XPHY_EDGE_ROW_142_3_Left_514 VDD VSS gf180mcu_as_sc_mcu7t3v3__tap_2
X_4824_ VDD VDD VSS VSS _4830_/CLK _4824_/D _4824_/Q gf180mcu_as_sc_mcu7t3v3__dfxtp_2
X_4755_ VDD VDD VSS VSS clkload3/A _4755_/D _4755_/Q gf180mcu_as_sc_mcu7t3v3__dfxtp_2
XTAP_TAPCELL_ROW_156_1209 VDD VSS gf180mcu_as_sc_mcu7t3v3__tap_2
XFILLER_159_492 VDD VDD VSS VSS gf180mcu_as_sc_mcu7t3v3__fillcap_16
X_3706_ VDD VDD VSS VSS _4062_/A _3886_/B _3706_/C _3850_/D _3709_/B gf180mcu_as_sc_mcu7t3v3__ao211_2
XTAP_TAPCELL_ROW_173_1534 VDD VSS gf180mcu_as_sc_mcu7t3v3__tap_2
XFILLER_162_613 VDD VDD VSS VSS gf180mcu_as_sc_mcu7t3v3__fillcap_16
X_4686_ VDD VDD VSS VSS _4692_/CLK _4686_/D _4686_/Q gf180mcu_as_sc_mcu7t3v3__dfxtp_2
XFILLER_174_484 VDD VDD VSS VSS gf180mcu_as_sc_mcu7t3v3__fill_1
X_3637_ VDD VDD VSS VSS _3875_/B _3990_/D _3638_/C gf180mcu_as_sc_mcu7t3v3__and2_2
XPHY_EDGE_ROW_90_3_Right_131 VDD VSS gf180mcu_as_sc_mcu7t3v3__tap_2
XFILLER_108_47 VDD VDD VSS VSS gf180mcu_as_sc_mcu7t3v3__fillcap_16
XFILLER_175_1039 VDD VDD VSS VSS gf180mcu_as_sc_mcu7t3v3__fillcap_8
X_3568_ VDD VDD VSS VSS _3582_/A _3568_/A _3584_/B gf180mcu_as_sc_mcu7t3v3__and2_2
XFILLER_161_189 VDD VDD VSS VSS gf180mcu_as_sc_mcu7t3v3__fillcap_8
X_2519_ VDD VDD VSS VSS _3513_/A _2524_/B _2519_/C _2524_/C _2566_/C gf180mcu_as_sc_mcu7t3v3__ao211_2
XTAP_TAPCELL_ROW_58_3_1969 VDD VSS gf180mcu_as_sc_mcu7t3v3__tap_2
XFILLER_153_1348 VDD VDD VSS VSS gf180mcu_as_sc_mcu7t3v3__fill_2
Xinput207 VDD VDD VSS VSS se_in[26] wire790/A gf180mcu_as_sc_mcu7t3v3__buff_12
Xinput218 VDD VDD VSS VSS se_in[3] wire788/A gf180mcu_as_sc_mcu7t3v3__buff_12
X_3499_ VDD VDD VSS VSS _4600_/D _4600_/Q _3503_/B _3499_/C gf180mcu_as_sc_mcu7t3v3__ao21_2
Xinput229 VDD VDD VSS VSS south_in[13] _4108_/A gf180mcu_as_sc_mcu7t3v3__buff_12
XFILLER_186_1124 VDD VDD VSS VSS gf180mcu_as_sc_mcu7t3v3__fill_1
XFILLER_140_34 VDD VDD VSS VSS gf180mcu_as_sc_mcu7t3v3__fill_1
XFILLER_17_44 VDD VDD VSS VSS gf180mcu_as_sc_mcu7t3v3__fill_1
XFILLER_186_1157 VDD VDD VSS VSS gf180mcu_as_sc_mcu7t3v3__fill_1
XPHY_EDGE_ROW_74_3_Left_446 VDD VSS gf180mcu_as_sc_mcu7t3v3__tap_2
XFILLER_13_936 VDD VDD VSS VSS gf180mcu_as_sc_mcu7t3v3__fillcap_16
XFILLER_12_435 VDD VDD VSS VSS gf180mcu_as_sc_mcu7t3v3__fill_1
XFILLER_13_958 VDD VDD VSS VSS gf180mcu_as_sc_mcu7t3v3__fill_2
XFILLER_158_919 VDD VDD VSS VSS gf180mcu_as_sc_mcu7t3v3__fillcap_4
XFILLER_9_918 VDD VDD VSS VSS gf180mcu_as_sc_mcu7t3v3__fill_1
XFILLER_149_32 VDD VDD VSS VSS gf180mcu_as_sc_mcu7t3v3__fill_1
XFILLER_185_738 VDD VDD VSS VSS gf180mcu_as_sc_mcu7t3v3__fill_2
XPHY_EDGE_ROW_106_1_Right_615 VDD VSS gf180mcu_as_sc_mcu7t3v3__tap_2
XFILLER_166_963 VDD VDD VSS VSS gf180mcu_as_sc_mcu7t3v3__fill_1
XFILLER_149_98 VDD VDD VSS VSS gf180mcu_as_sc_mcu7t3v3__fillcap_4
XFILLER_166_996 VDD VDD VSS VSS gf180mcu_as_sc_mcu7t3v3__fillcap_16
XFILLER_152_101 VDD VDD VSS VSS gf180mcu_as_sc_mcu7t3v3__fill_1
XFILLER_180_454 VDD VDD VSS VSS gf180mcu_as_sc_mcu7t3v3__fill_1
XFILLER_181_966 VDD VDD VSS VSS gf180mcu_as_sc_mcu7t3v3__fill_2
XFILLER_74_61 VDD VDD VSS VSS gf180mcu_as_sc_mcu7t3v3__fillcap_16
XFILLER_165_1208 VDD VDD VSS VSS gf180mcu_as_sc_mcu7t3v3__fillcap_4
XFILLER_188_521 VDD VDD VSS VSS gf180mcu_as_sc_mcu7t3v3__fillcap_4
X_2870_ VDD VDD VSS VSS _2871_/C _2870_/B _2871_/B gf180mcu_as_sc_mcu7t3v3__nor2_2
XFILLER_11_1119 VDD VDD VSS VSS gf180mcu_as_sc_mcu7t3v3__fill_1
XFILLER_156_451 VDD VDD VSS VSS gf180mcu_as_sc_mcu7t3v3__fillcap_4
XFILLER_156_473 VDD VDD VSS VSS gf180mcu_as_sc_mcu7t3v3__fillcap_16
XFILLER_157_974 VDD VDD VSS VSS gf180mcu_as_sc_mcu7t3v3__fillcap_4
XFILLER_15_1266 VDD VDD VSS VSS gf180mcu_as_sc_mcu7t3v3__fillcap_4
XFILLER_184_771 VDD VDD VSS VSS gf180mcu_as_sc_mcu7t3v3__fill_1
XFILLER_89_1323 VDD VDD VSS VSS gf180mcu_as_sc_mcu7t3v3__fill_1
X_4540_ VDD VDD VSS VSS _4576_/CLK _4540_/D _4540_/Q gf180mcu_as_sc_mcu7t3v3__dfxtp_2
XFILLER_176_1304 VDD VDD VSS VSS gf180mcu_as_sc_mcu7t3v3__fillcap_8
X_4471_ VDD VDD VSS VSS _4804_/CLK _4471_/D _4471_/Q gf180mcu_as_sc_mcu7t3v3__dfxtp_2
X_3422_ VDD VDD VSS VSS _4551_/Q _3445_/B _3449_/B _4550_/Q _4550_/D gf180mcu_as_sc_mcu7t3v3__ao22_2
XFILLER_99_91 VDD VDD VSS VSS gf180mcu_as_sc_mcu7t3v3__fillcap_8
X_3353_ VDD VDD VSS VSS _3354_/D _3353_/B _3369_/A gf180mcu_as_sc_mcu7t3v3__nor2_2
X_3284_ VDD VDD VSS VSS _3348_/A _3284_/B _3284_/C _3284_/D _4526_/D gf180mcu_as_sc_mcu7t3v3__ao211_2
X_2304_ VDD VDD VSS VSS _3471_/B _4626_/Q _3082_/B gf180mcu_as_sc_mcu7t3v3__and2_2
XFILLER_61_1264 VDD VDD VSS VSS gf180mcu_as_sc_mcu7t3v3__fillcap_4
X_2235_ VDD VDD VSS VSS _2506_/B _4575_/Q _2510_/D gf180mcu_as_sc_mcu7t3v3__nor2_2
XTAP_TAPCELL_ROW_166_1393 VDD VSS gf180mcu_as_sc_mcu7t3v3__tap_2
XFILLER_96_1349 VDD VDD VSS VSS gf180mcu_as_sc_mcu7t3v3__fillcap_4
XFILLER_110_48 VDD VDD VSS VSS gf180mcu_as_sc_mcu7t3v3__fillcap_16
XFILLER_179_543 VDD VDD VSS VSS gf180mcu_as_sc_mcu7t3v3__fill_2
X_4807_ VDD VDD VSS VSS _4807_/CLK _4807_/Q _4807_/RN _4271_/A _4807_/D gf180mcu_as_sc_mcu7t3v3__dfsrtp_2
XPHY_EDGE_ROW_3_Right_3 VDD VSS gf180mcu_as_sc_mcu7t3v3__tap_2
X_2999_ VDD VDD VSS VSS _2999_/A _3004_/B _3004_/C _4411_/Q _4411_/D gf180mcu_as_sc_mcu7t3v3__ao22_2
XTAP_TAPCELL_ROW_192_1921 VDD VSS gf180mcu_as_sc_mcu7t3v3__tap_2
XTAP_TAPCELL_ROW_192_1910 VDD VSS gf180mcu_as_sc_mcu7t3v3__tap_2
X_4738_ VDD VDD VSS VSS _4751_/CLK _4738_/D _4738_/Q gf180mcu_as_sc_mcu7t3v3__dfxtp_2
XFILLER_162_410 VDD VDD VSS VSS gf180mcu_as_sc_mcu7t3v3__fill_2
XFILLER_190_730 VDD VDD VSS VSS gf180mcu_as_sc_mcu7t3v3__fillcap_4
X_4669_ VDD VDD VSS VSS clkload5/A _4669_/D _4669_/Q gf180mcu_as_sc_mcu7t3v3__dfxtp_2
XFILLER_163_977 VDD VDD VSS VSS gf180mcu_as_sc_mcu7t3v3__fill_2
XPHY_EDGE_ROW_91_3_Right_132 VDD VSS gf180mcu_as_sc_mcu7t3v3__tap_2
XFILLER_1_604 VDD VDD VSS VSS gf180mcu_as_sc_mcu7t3v3__fill_1
XFILLER_157_1270 VDD VDD VSS VSS gf180mcu_as_sc_mcu7t3v3__fillcap_4
XFILLER_192_1183 VDD VDD VSS VSS gf180mcu_as_sc_mcu7t3v3__fill_2
Xclkbuf_1_1__f_clk VDD VDD VSS VSS clkbuf_0_clk/Y clkbuf_1_1__f_clk/Y gf180mcu_as_sc_mcu7t3v3__clkbuff_12
XFILLER_192_1194 VDD VDD VSS VSS gf180mcu_as_sc_mcu7t3v3__fill_1
XFILLER_151_22 VDD VDD VSS VSS gf180mcu_as_sc_mcu7t3v3__fillcap_4
XFILLER_188_1219 VDD VDD VSS VSS gf180mcu_as_sc_mcu7t3v3__fillcap_4
XFILLER_151_88 VDD VDD VSS VSS gf180mcu_as_sc_mcu7t3v3__fillcap_16
XTAP_TAPCELL_ROW_0_692 VDD VSS gf180mcu_as_sc_mcu7t3v3__tap_2
XTAP_TAPCELL_ROW_0_681 VDD VSS gf180mcu_as_sc_mcu7t3v3__tap_2
XTAP_TAPCELL_ROW_0_670 VDD VSS gf180mcu_as_sc_mcu7t3v3__tap_2
XFILLER_12_221 VDD VDD VSS VSS gf180mcu_as_sc_mcu7t3v3__fillcap_8
XFILLER_158_705 VDD VDD VSS VSS gf180mcu_as_sc_mcu7t3v3__fillcap_8
XFILLER_44_64 VDD VDD VSS VSS gf180mcu_as_sc_mcu7t3v3__fillcap_4
XFILLER_13_777 VDD VDD VSS VSS gf180mcu_as_sc_mcu7t3v3__fill_1
XFILLER_38_1288 VDD VDD VSS VSS gf180mcu_as_sc_mcu7t3v3__fill_1
XFILLER_38_1299 VDD VDD VSS VSS gf180mcu_as_sc_mcu7t3v3__fillcap_4
XFILLER_13_788 VDD VDD VSS VSS gf180mcu_as_sc_mcu7t3v3__fill_2
XFILLER_160_1149 VDD VDD VSS VSS gf180mcu_as_sc_mcu7t3v3__fillcap_4
XFILLER_185_557 VDD VDD VSS VSS gf180mcu_as_sc_mcu7t3v3__fill_2
XTAP_TAPCELL_ROW_11_901 VDD VSS gf180mcu_as_sc_mcu7t3v3__tap_2
XPHY_EDGE_ROW_107_1_Right_616 VDD VSS gf180mcu_as_sc_mcu7t3v3__tap_2
XFILLER_176_30 VDD VDD VSS VSS gf180mcu_as_sc_mcu7t3v3__fillcap_4
XFILLER_8_247 VDD VDD VSS VSS gf180mcu_as_sc_mcu7t3v3__fill_2
XFILLER_158_1001 VDD VDD VSS VSS gf180mcu_as_sc_mcu7t3v3__fill_2
XFILLER_60_85 VDD VDD VSS VSS gf180mcu_as_sc_mcu7t3v3__fillcap_16
Xclkbuf_leaf_24_clk_regs VDD VDD VSS VSS clkload2/A _4826_/CLK gf180mcu_as_sc_mcu7t3v3__clkbuff_12
XFILLER_180_240 VDD VDD VSS VSS gf180mcu_as_sc_mcu7t3v3__fillcap_4
XFILLER_10_1174 VDD VDD VSS VSS gf180mcu_as_sc_mcu7t3v3__fill_2
XFILLER_140_104 VDD VDD VSS VSS gf180mcu_as_sc_mcu7t3v3__fill_1
XFILLER_5_47 VDD VDD VSS VSS gf180mcu_as_sc_mcu7t3v3__fillcap_4
XFILLER_69_83 VDD VDD VSS VSS gf180mcu_as_sc_mcu7t3v3__fillcap_16
XFILLER_171_1234 VDD VDD VSS VSS gf180mcu_as_sc_mcu7t3v3__fillcap_8
X_3971_ VDD VDD VSS VSS _3974_/D _3987_/A _4244_/B gf180mcu_as_sc_mcu7t3v3__and2_2
XFILLER_143_1303 VDD VDD VSS VSS gf180mcu_as_sc_mcu7t3v3__fillcap_4
X_2922_ VDD VDD VSS VSS _2922_/Y _4765_/Q _4275_/B gf180mcu_as_sc_mcu7t3v3__nor2b_2
XFILLER_176_524 VDD VDD VSS VSS gf180mcu_as_sc_mcu7t3v3__fill_1
XFILLER_188_384 VDD VDD VSS VSS gf180mcu_as_sc_mcu7t3v3__fill_1
XFILLER_86_2 VDD VDD VSS VSS gf180mcu_as_sc_mcu7t3v3__fillcap_4
X_2853_ VDD VDD VSS VSS _4171_/A _2871_/B _2853_/C _2853_/D _2998_/A gf180mcu_as_sc_mcu7t3v3__ao22_2
X_2784_ VDD VDD VSS VSS _4108_/D _2918_/B _2784_/C _2784_/D _2786_/C gf180mcu_as_sc_mcu7t3v3__ao211_2
XFILLER_156_281 VDD VDD VSS VSS gf180mcu_as_sc_mcu7t3v3__fillcap_16
X_4523_ VDD VDD VSS VSS clkload9/A _4523_/D _4523_/Q gf180mcu_as_sc_mcu7t3v3__dfxtp_2
XFILLER_8_781 VDD VDD VSS VSS gf180mcu_as_sc_mcu7t3v3__fillcap_8
XFILLER_131_104 VDD VDD VSS VSS gf180mcu_as_sc_mcu7t3v3__fill_1
X_4454_ VDD VDD VSS VSS _4606_/CLK _4454_/D _4454_/Q gf180mcu_as_sc_mcu7t3v3__dfxtp_2
XFILLER_63_1326 VDD VDD VSS VSS gf180mcu_as_sc_mcu7t3v3__fillcap_4
X_4385_ VDD VDD VSS VSS _4447_/CLK _4385_/D _4385_/Q gf180mcu_as_sc_mcu7t3v3__dfxtp_2
X_3405_ VDD VDD VSS VSS _3405_/B _4461_/Q _3412_/D gf180mcu_as_sc_mcu7t3v3__and2_2
XFILLER_150_1307 VDD VDD VSS VSS gf180mcu_as_sc_mcu7t3v3__fillcap_4
Xfanout716 VDD VDD VSS VSS _2312_/Y _3582_/A gf180mcu_as_sc_mcu7t3v3__buff_12
Xfanout727 VDD VDD VSS VSS _4578_/Q _3541_/A gf180mcu_as_sc_mcu7t3v3__buff_12
Xfanout738 VDD VDD VSS VSS fanout743/Y _3369_/A gf180mcu_as_sc_mcu7t3v3__buff_12
Xfanout749 VDD VDD VSS VSS fanout750/Y _3336_/S gf180mcu_as_sc_mcu7t3v3__buff_12
X_3336_ VDD VDD VSS VSS _3336_/S _4375_/Q _4404_/Q _3337_/B gf180mcu_as_sc_mcu7t3v3__mux2_2
XTAP_TAPCELL_ROW_168_1444 VDD VSS gf180mcu_as_sc_mcu7t3v3__tap_2
XTAP_TAPCELL_ROW_168_1433 VDD VSS gf180mcu_as_sc_mcu7t3v3__tap_2
XFILLER_105_37 VDD VDD VSS VSS gf180mcu_as_sc_mcu7t3v3__fillcap_16
X_3267_ VDD VDD VSS VSS _4524_/Q _3315_/B _3315_/C _4525_/Q _3268_/C gf180mcu_as_sc_mcu7t3v3__ao22_2
XPHY_EDGE_ROW_22_1_Left_214 VDD VSS gf180mcu_as_sc_mcu7t3v3__tap_2
XFILLER_6_1297 VDD VDD VSS VSS gf180mcu_as_sc_mcu7t3v3__fillcap_4
X_3198_ VDD VDD VSS VSS _3199_/D _3198_/B _3210_/B gf180mcu_as_sc_mcu7t3v3__nor2_2
X_2218_ VDD VDD VSS VSS _4083_/A _2745_/A gf180mcu_as_sc_mcu7t3v3__inv_2
XTAP_TAPCELL_ROW_181_1688 VDD VSS gf180mcu_as_sc_mcu7t3v3__tap_2
XTAP_TAPCELL_ROW_181_1677 VDD VSS gf180mcu_as_sc_mcu7t3v3__tap_2
XFILLER_183_1149 VDD VDD VSS VSS gf180mcu_as_sc_mcu7t3v3__fill_1
XFILLER_14_34 VDD VDD VSS VSS gf180mcu_as_sc_mcu7t3v3__fill_1
XFILLER_14_78 VDD VDD VSS VSS gf180mcu_as_sc_mcu7t3v3__fill_2
XFILLER_179_384 VDD VDD VSS VSS gf180mcu_as_sc_mcu7t3v3__fill_1
XFILLER_10_758 VDD VDD VSS VSS gf180mcu_as_sc_mcu7t3v3__fill_1
XFILLER_124_1291 VDD VDD VSS VSS gf180mcu_as_sc_mcu7t3v3__fill_2
XFILLER_182_527 VDD VDD VSS VSS gf180mcu_as_sc_mcu7t3v3__fillcap_4
XFILLER_146_22 VDD VDD VSS VSS gf180mcu_as_sc_mcu7t3v3__fillcap_8
XFILLER_159_1332 VDD VDD VSS VSS gf180mcu_as_sc_mcu7t3v3__fillcap_16
XFILLER_162_240 VDD VDD VSS VSS gf180mcu_as_sc_mcu7t3v3__fillcap_4
XTAP_TAPCELL_ROW_61_1_1014 VDD VSS gf180mcu_as_sc_mcu7t3v3__tap_2
XPHY_EDGE_ROW_31_1_Right_540 VDD VSS gf180mcu_as_sc_mcu7t3v3__tap_2
XFILLER_122_104 VDD VDD VSS VSS gf180mcu_as_sc_mcu7t3v3__fill_1
XFILLER_190_582 VDD VDD VSS VSS gf180mcu_as_sc_mcu7t3v3__fill_2
XTAP_TAPCELL_ROW_188_1809 VDD VSS gf180mcu_as_sc_mcu7t3v3__tap_2
XPHY_EDGE_ROW_92_3_Right_133 VDD VSS gf180mcu_as_sc_mcu7t3v3__tap_2
XFILLER_7_1006 VDD VDD VSS VSS gf180mcu_as_sc_mcu7t3v3__fillcap_4
XFILLER_7_1017 VDD VDD VSS VSS gf180mcu_as_sc_mcu7t3v3__fill_1
XFILLER_190_2 VDD VDD VSS VSS gf180mcu_as_sc_mcu7t3v3__fillcap_16
XPHY_EDGE_ROW_18_3_Left_390 VDD VSS gf180mcu_as_sc_mcu7t3v3__tap_2
XTAP_TAPCELL_ROW_5_784 VDD VSS gf180mcu_as_sc_mcu7t3v3__tap_2
XTAP_TAPCELL_ROW_5_795 VDD VSS gf180mcu_as_sc_mcu7t3v3__tap_2
XPHY_EDGE_ROW_79_1_Left_271 VDD VSS gf180mcu_as_sc_mcu7t3v3__tap_2
XPHY_EDGE_ROW_34_3_Right_75 VDD VSS gf180mcu_as_sc_mcu7t3v3__tap_2
XFILLER_127_1309 VDD VDD VSS VSS gf180mcu_as_sc_mcu7t3v3__fill_1
XPHY_EDGE_ROW_37_3_Left_409 VDD VSS gf180mcu_as_sc_mcu7t3v3__tap_2
XFILLER_158_524 VDD VDD VSS VSS gf180mcu_as_sc_mcu7t3v3__fill_1
XFILLER_158_535 VDD VDD VSS VSS gf180mcu_as_sc_mcu7t3v3__fill_2
XFILLER_185_321 VDD VDD VSS VSS gf180mcu_as_sc_mcu7t3v3__fill_1
XFILLER_103_1320 VDD VDD VSS VSS gf180mcu_as_sc_mcu7t3v3__fillcap_4
XFILLER_158_579 VDD VDD VSS VSS gf180mcu_as_sc_mcu7t3v3__fillcap_8
XPHY_EDGE_ROW_108_1_Right_617 VDD VSS gf180mcu_as_sc_mcu7t3v3__tap_2
XFILLER_185_398 VDD VDD VSS VSS gf180mcu_as_sc_mcu7t3v3__fillcap_8
XFILLER_51_1263 VDD VDD VSS VSS gf180mcu_as_sc_mcu7t3v3__fillcap_4
XFILLER_154_741 VDD VDD VSS VSS gf180mcu_as_sc_mcu7t3v3__fill_2
XFILLER_113_104 VDD VDD VSS VSS gf180mcu_as_sc_mcu7t3v3__fill_1
XFILLER_153_262 VDD VDD VSS VSS gf180mcu_as_sc_mcu7t3v3__fillcap_16
XFILLER_5_784 VDD VDD VSS VSS gf180mcu_as_sc_mcu7t3v3__fill_2
XPHY_EDGE_ROW_151_3_Left_523 VDD VSS gf180mcu_as_sc_mcu7t3v3__tap_2
X_4170_ VDD VDD VSS VSS _4170_/A _4187_/B _4170_/C _4170_/D _4172_/A gf180mcu_as_sc_mcu7t3v3__ao211_2
X_4747__1025 VDD VDD VSS VSS _4747_/D gf180mcu_as_sc_mcu7t3v3__tiel_4
X_3121_ VDD VDD VSS VSS _3121_/S _4509_/Q _4508_/Q _4508_/D gf180mcu_as_sc_mcu7t3v3__mux2_2
X_3052_ VDD VDD VSS VSS _3052_/B _3604_/A _4452_/D gf180mcu_as_sc_mcu7t3v3__and2_2
XTAP_TAPCELL_ROW_163_1352 VDD VSS gf180mcu_as_sc_mcu7t3v3__tap_2
XTAP_TAPCELL_ROW_163_1341 VDD VSS gf180mcu_as_sc_mcu7t3v3__tap_2
X_3954_ VDD VDD VSS VSS _3954_/D _3954_/A _3964_/B _3964_/C _3955_/D gf180mcu_as_sc_mcu7t3v3__ao31_2
XPHY_EDGE_ROW_70_1_Right_579 VDD VSS gf180mcu_as_sc_mcu7t3v3__tap_2
XFILLER_176_310 VDD VDD VSS VSS gf180mcu_as_sc_mcu7t3v3__fillcap_4
X_3885_ VDD VDD VSS VSS _3886_/B _3953_/C _3927_/C gf180mcu_as_sc_mcu7t3v3__and2_2
X_2905_ VDD VDD VSS VSS _4221_/A _2905_/B _2905_/C _2905_/D _3004_/A gf180mcu_as_sc_mcu7t3v3__ao211_2
XFILLER_177_877 VDD VDD VSS VSS gf180mcu_as_sc_mcu7t3v3__fillcap_4
X_2836_ VDD VDD VSS VSS _4350_/Q _2906_/B _3027_/A _2906_/D _4350_/D gf180mcu_as_sc_mcu7t3v3__ao22_2
XFILLER_164_538 VDD VDD VSS VSS gf180mcu_as_sc_mcu7t3v3__fillcap_8
XFILLER_192_847 VDD VDD VSS VSS gf180mcu_as_sc_mcu7t3v3__fill_2
X_2767_ VDD VDD VSS VSS _2818_/B _4095_/A _2768_/D gf180mcu_as_sc_mcu7t3v3__and2_2
X_4506_ VDD VDD VSS VSS _4708_/CLK _4506_/D _4506_/Q gf180mcu_as_sc_mcu7t3v3__dfxtp_2
X_2698_ VDD VDD VSS VSS _4034_/A _2905_/B _2698_/C _2698_/D _2981_/A gf180mcu_as_sc_mcu7t3v3__ao22_2
XPHY_EDGE_ROW_83_3_Left_455 VDD VSS gf180mcu_as_sc_mcu7t3v3__tap_2
XFILLER_160_733 VDD VDD VSS VSS gf180mcu_as_sc_mcu7t3v3__fill_2
X_4437_ VDD VDD VSS VSS _4440_/CLK _4437_/D _4437_/Q gf180mcu_as_sc_mcu7t3v3__dfxtp_2
Xfanout502 VDD VDD VSS VSS _2898_/B _2919_/B gf180mcu_as_sc_mcu7t3v3__buff_12
Xfanout524 VDD VDD VSS VSS _4227_/C _4136_/B gf180mcu_as_sc_mcu7t3v3__buff_12
XTAP_TAPCELL_ROW_122_1_1075 VDD VSS gf180mcu_as_sc_mcu7t3v3__tap_2
XFILLER_28_1265 VDD VDD VSS VSS gf180mcu_as_sc_mcu7t3v3__fillcap_8
XFILLER_76_29 VDD VDD VSS VSS gf180mcu_as_sc_mcu7t3v3__fillcap_4
Xfanout535 VDD VDD VSS VSS _3930_/B _3881_/B gf180mcu_as_sc_mcu7t3v3__buff_12
Xfanout546 VDD VDD VSS VSS _2917_/C _2904_/B gf180mcu_as_sc_mcu7t3v3__buff_12
Xfanout557 VDD VDD VSS VSS _4312_/B _4313_/B gf180mcu_as_sc_mcu7t3v3__buff_12
X_4368_ VDD VDD VSS VSS clkload8/A _4368_/D _4368_/Q gf180mcu_as_sc_mcu7t3v3__dfxtp_2
Xfanout568 VDD VDD VSS VSS _3403_/C _3347_/C gf180mcu_as_sc_mcu7t3v3__buff_12
Xfanout579 VDD VDD VSS VSS _2659_/Y _2917_/B gf180mcu_as_sc_mcu7t3v3__buff_12
X_4299_ VDD VDD VSS VSS _4310_/B _4523_/Q _4776_/D gf180mcu_as_sc_mcu7t3v3__and2_2
X_3319_ VDD VDD VSS VSS _3322_/C _4431_/Q _3336_/S gf180mcu_as_sc_mcu7t3v3__nand2_2
XTAP_TAPCELL_ROW_183_1728 VDD VSS gf180mcu_as_sc_mcu7t3v3__tap_2
XTAP_TAPCELL_ROW_183_1717 VDD VSS gf180mcu_as_sc_mcu7t3v3__tap_2
Xmesh_tile_972 VDD VDD VSS VSS sw_out[0] gf180mcu_as_sc_mcu7t3v3__tiel_4
Xmesh_tile_961 VDD VDD VSS VSS se_out[25] gf180mcu_as_sc_mcu7t3v3__tiel_4
Xmesh_tile_950 VDD VDD VSS VSS se_out[14] gf180mcu_as_sc_mcu7t3v3__tiel_4
XTAP_TAPCELL_ROW_2_732 VDD VSS gf180mcu_as_sc_mcu7t3v3__tap_2
XTAP_TAPCELL_ROW_2_721 VDD VSS gf180mcu_as_sc_mcu7t3v3__tap_2
XFILLER_132_68 VDD VDD VSS VSS gf180mcu_as_sc_mcu7t3v3__fillcap_4
Xmesh_tile_994 VDD VDD VSS VSS sw_out[22] gf180mcu_as_sc_mcu7t3v3__tiel_4
Xmesh_tile_983 VDD VDD VSS VSS sw_out[11] gf180mcu_as_sc_mcu7t3v3__tiel_4
XFILLER_162_6 VDD VDD VSS VSS gf180mcu_as_sc_mcu7t3v3__fillcap_16
XFILLER_186_107 VDD VDD VSS VSS gf180mcu_as_sc_mcu7t3v3__fillcap_4
XFILLER_25_88 VDD VDD VSS VSS gf180mcu_as_sc_mcu7t3v3__fillcap_16
XFILLER_168_866 VDD VDD VSS VSS gf180mcu_as_sc_mcu7t3v3__fillcap_8
XFILLER_168_877 VDD VDD VSS VSS gf180mcu_as_sc_mcu7t3v3__fillcap_16
XFILLER_182_302 VDD VDD VSS VSS gf180mcu_as_sc_mcu7t3v3__fill_2
XPHY_EDGE_ROW_32_1_Right_541 VDD VSS gf180mcu_as_sc_mcu7t3v3__tap_2
XFILLER_155_1026 VDD VDD VSS VSS gf180mcu_as_sc_mcu7t3v3__fill_2
XPHY_EDGE_ROW_93_3_Right_134 VDD VSS gf180mcu_as_sc_mcu7t3v3__tap_2
XFILLER_2_787 VDD VDD VSS VSS gf180mcu_as_sc_mcu7t3v3__fillcap_8
XFILLER_81_1256 VDD VDD VSS VSS gf180mcu_as_sc_mcu7t3v3__fillcap_8
XFILLER_2_37 VDD VDD VSS VSS gf180mcu_as_sc_mcu7t3v3__fillcap_8
XFILLER_66_62 VDD VDD VSS VSS gf180mcu_as_sc_mcu7t3v3__fillcap_4
XFILLER_66_95 VDD VDD VSS VSS gf180mcu_as_sc_mcu7t3v3__fillcap_8
XFILLER_178_619 VDD VDD VSS VSS gf180mcu_as_sc_mcu7t3v3__fill_1
XFILLER_82_61 VDD VDD VSS VSS gf180mcu_as_sc_mcu7t3v3__fill_1
XFILLER_158_332 VDD VDD VSS VSS gf180mcu_as_sc_mcu7t3v3__fillcap_16
XFILLER_159_877 VDD VDD VSS VSS gf180mcu_as_sc_mcu7t3v3__fillcap_16
XFILLER_9_331 VDD VDD VSS VSS gf180mcu_as_sc_mcu7t3v3__fill_1
XFILLER_158_376 VDD VDD VSS VSS gf180mcu_as_sc_mcu7t3v3__fill_2
XFILLER_158_387 VDD VDD VSS VSS gf180mcu_as_sc_mcu7t3v3__fillcap_8
XFILLER_185_162 VDD VDD VSS VSS gf180mcu_as_sc_mcu7t3v3__fill_1
X_3670_ VDD VDD VSS VSS _3890_/S _4028_/A _3672_/C gf180mcu_as_sc_mcu7t3v3__or2_2
XFILLER_12_1055 VDD VDD VSS VSS gf180mcu_as_sc_mcu7t3v3__fillcap_8
X_2621_ VDD VDD VSS VSS _3039_/A _4284_/A _2621_/C _2629_/B _4799_/Q gf180mcu_as_sc_mcu7t3v3__aoi211_2
XPHY_EDGE_ROW_109_1_Right_618 VDD VSS gf180mcu_as_sc_mcu7t3v3__tap_2
XFILLER_154_560 VDD VDD VSS VSS gf180mcu_as_sc_mcu7t3v3__fill_2
XFILLER_161_508 VDD VDD VSS VSS gf180mcu_as_sc_mcu7t3v3__fill_1
X_2552_ VDD VDD VSS VSS _3555_/C _2552_/A _4621_/Q _3555_/B _2555_/B gf180mcu_as_sc_mcu7t3v3__ao31_2
XFILLER_173_1104 VDD VDD VSS VSS gf180mcu_as_sc_mcu7t3v3__fill_2
XFILLER_177_1262 VDD VDD VSS VSS gf180mcu_as_sc_mcu7t3v3__fill_2
XPHY_EDGE_ROW_10_Left_203 VDD VSS gf180mcu_as_sc_mcu7t3v3__tap_2
X_4222_ VDD VDD VSS VSS _4222_/B _4271_/A _4719_/D gf180mcu_as_sc_mcu7t3v3__and2_2
X_2483_ VDD VDD VSS VSS _4541_/Q _3068_/S _3061_/S _4517_/Q _2484_/C gf180mcu_as_sc_mcu7t3v3__ao22_2
X_4153_ VDD VDD VSS VSS _4154_/A _4153_/A _4153_/B _4153_/C gf180mcu_as_sc_mcu7t3v3__ao21_2
X_4084_ VDD VDD VSS VSS _4084_/A _4149_/B _4149_/C _4084_/D _4086_/B gf180mcu_as_sc_mcu7t3v3__ao22_2
X_3104_ VDD VDD VSS VSS _3122_/S _4492_/Q _4491_/Q _4491_/D gf180mcu_as_sc_mcu7t3v3__mux2_2
XPHY_EDGE_ROW_158_Left_350 VDD VSS gf180mcu_as_sc_mcu7t3v3__tap_2
X_3035_ VDD VDD VSS VSS _3035_/A _3038_/B _3038_/C _4445_/Q _4445_/D gf180mcu_as_sc_mcu7t3v3__ao22_2
XFILLER_149_1342 VDD VDD VSS VSS gf180mcu_as_sc_mcu7t3v3__fillcap_8
XFILLER_184_1255 VDD VDD VSS VSS gf180mcu_as_sc_mcu7t3v3__fill_2
XFILLER_58_1258 VDD VDD VSS VSS gf180mcu_as_sc_mcu7t3v3__fillcap_4
XFILLER_180_1119 VDD VDD VSS VSS gf180mcu_as_sc_mcu7t3v3__fillcap_16
XFILLER_184_1288 VDD VDD VSS VSS gf180mcu_as_sc_mcu7t3v3__fillcap_4
X_3937_ VDD VDD VSS VSS _3937_/B _3937_/A _3961_/D gf180mcu_as_sc_mcu7t3v3__and2_2
XTAP_TAPCELL_ROW_141_3_2052 VDD VSS gf180mcu_as_sc_mcu7t3v3__tap_2
XFILLER_176_151 VDD VDD VSS VSS gf180mcu_as_sc_mcu7t3v3__fill_2
XFILLER_177_685 VDD VDD VSS VSS gf180mcu_as_sc_mcu7t3v3__fillcap_4
XFILLER_178_1004 VDD VDD VSS VSS gf180mcu_as_sc_mcu7t3v3__fill_1
X_3868_ VDD VDD VSS VSS _3868_/B _4207_/A _3870_/C gf180mcu_as_sc_mcu7t3v3__or2_2
XTAP_TAPCELL_ROW_176_1587 VDD VSS gf180mcu_as_sc_mcu7t3v3__tap_2
XFILLER_192_655 VDD VDD VSS VSS gf180mcu_as_sc_mcu7t3v3__fillcap_4
X_3799_ VDD VDD VSS VSS _4144_/A _3799_/B _3808_/C _4140_/D _3800_/D gf180mcu_as_sc_mcu7t3v3__ao22_2
X_2819_ VDD VDD VSS VSS _4789_/Q _2828_/B _2828_/C _4140_/D _2821_/C gf180mcu_as_sc_mcu7t3v3__ao22_2
XTAP_TAPCELL_ROW_176_1598 VDD VSS gf180mcu_as_sc_mcu7t3v3__tap_2
XFILLER_121_1283 VDD VDD VSS VSS gf180mcu_as_sc_mcu7t3v3__fill_2
XFILLER_192_688 VDD VDD VSS VSS gf180mcu_as_sc_mcu7t3v3__fill_1
XFILLER_11_68 VDD VDD VSS VSS gf180mcu_as_sc_mcu7t3v3__fill_2
XFILLER_156_1313 VDD VDD VSS VSS gf180mcu_as_sc_mcu7t3v3__fill_2
XFILLER_173_891 VDD VDD VSS VSS gf180mcu_as_sc_mcu7t3v3__fillcap_4
XFILLER_191_1248 VDD VDD VSS VSS gf180mcu_as_sc_mcu7t3v3__fill_2
XFILLER_2_8 VDD VDD VSS VSS gf180mcu_as_sc_mcu7t3v3__fill_1
XTAP_TAPCELL_ROW_7_824 VDD VSS gf180mcu_as_sc_mcu7t3v3__tap_2
XFILLER_160_574 VDD VDD VSS VSS gf180mcu_as_sc_mcu7t3v3__fill_1
XFILLER_8_1112 VDD VDD VSS VSS gf180mcu_as_sc_mcu7t3v3__fill_1
XFILLER_143_23 VDD VDD VSS VSS gf180mcu_as_sc_mcu7t3v3__fill_2
XFILLER_154_1081 VDD VDD VSS VSS gf180mcu_as_sc_mcu7t3v3__fillcap_4
XFILLER_189_1122 VDD VDD VSS VSS gf180mcu_as_sc_mcu7t3v3__fillcap_16
XFILLER_11_831 VDD VDD VSS VSS gf180mcu_as_sc_mcu7t3v3__fillcap_8
XFILLER_161_1052 VDD VDD VSS VSS gf180mcu_as_sc_mcu7t3v3__fillcap_16
XFILLER_52_75 VDD VDD VSS VSS gf180mcu_as_sc_mcu7t3v3__fillcap_8
Xinput18 VDD VDD VSS VSS boot_data[6] _2485_/A gf180mcu_as_sc_mcu7t3v3__buff_12
Xwire711 VDD VDD VSS VSS _5070_/A _3514_/B gf180mcu_as_sc_mcu7t3v3__clkbuff_12
XFILLER_183_644 VDD VDD VSS VSS gf180mcu_as_sc_mcu7t3v3__fill_2
XFILLER_6_334 VDD VDD VSS VSS gf180mcu_as_sc_mcu7t3v3__fill_1
Xinput29 VDD VDD VSS VSS dft_addr[6] _2415_/B gf180mcu_as_sc_mcu7t3v3__buff_12
Xwire766 VDD VDD VSS VSS wire766/A _4218_/A gf180mcu_as_sc_mcu7t3v3__clkbuff_12
Xwire777 VDD VDD VSS VSS wire777/A _4116_/D gf180mcu_as_sc_mcu7t3v3__clkbuff_12
XFILLER_182_143 VDD VDD VSS VSS gf180mcu_as_sc_mcu7t3v3__fill_1
Xwire788 VDD VDD VSS VSS wire788/A _4033_/A gf180mcu_as_sc_mcu7t3v3__clkbuff_12
XFILLER_184_52 VDD VDD VSS VSS gf180mcu_as_sc_mcu7t3v3__fillcap_16
XFILLER_83_1307 VDD VDD VSS VSS gf180mcu_as_sc_mcu7t3v3__fill_2
XTAP_TAPCELL_ROW_76_3_1987 VDD VSS gf180mcu_as_sc_mcu7t3v3__tap_2
XPHY_EDGE_ROW_33_1_Right_542 VDD VSS gf180mcu_as_sc_mcu7t3v3__tap_2
XFILLER_77_72 VDD VDD VSS VSS gf180mcu_as_sc_mcu7t3v3__fill_2
XPHY_EDGE_ROW_94_3_Right_135 VDD VSS gf180mcu_as_sc_mcu7t3v3__tap_2
XFILLER_178_416 VDD VDD VSS VSS gf180mcu_as_sc_mcu7t3v3__fill_1
XFILLER_187_972 VDD VDD VSS VSS gf180mcu_as_sc_mcu7t3v3__fillcap_8
X_4771_ VDD VDD VSS VSS _4803_/CLK _4771_/D _4771_/Q gf180mcu_as_sc_mcu7t3v3__dfxtp_2
XFILLER_105_1256 VDD VDD VSS VSS gf180mcu_as_sc_mcu7t3v3__fillcap_4
XFILLER_158_173 VDD VDD VSS VSS gf180mcu_as_sc_mcu7t3v3__fill_2
XFILLER_159_674 VDD VDD VSS VSS gf180mcu_as_sc_mcu7t3v3__fill_1
XFILLER_159_696 VDD VDD VSS VSS gf180mcu_as_sc_mcu7t3v3__fillcap_4
X_3722_ VDD VDD VSS VSS _3798_/B _4081_/A _3728_/C gf180mcu_as_sc_mcu7t3v3__and2_2
XTAP_TAPCELL_ROW_158_1251 VDD VSS gf180mcu_as_sc_mcu7t3v3__tap_2
XTAP_TAPCELL_ROW_158_1240 VDD VSS gf180mcu_as_sc_mcu7t3v3__tap_2
X_3653_ VDD VDD VSS VSS _4773_/Q _3852_/B _3879_/B _4013_/D _3654_/D gf180mcu_as_sc_mcu7t3v3__ao22_2
XPHY_EDGE_ROW_31_1_Left_223 VDD VSS gf180mcu_as_sc_mcu7t3v3__tap_2
XFILLER_174_699 VDD VDD VSS VSS gf180mcu_as_sc_mcu7t3v3__fillcap_16
X_2604_ VDD VDD VSS VSS _4254_/A _4242_/A _4263_/A _3969_/B gf180mcu_as_sc_mcu7t3v3__nor3_2
XFILLER_161_349 VDD VDD VSS VSS gf180mcu_as_sc_mcu7t3v3__fill_1
X_3584_ VDD VDD VSS VSS _4632_/D _3584_/A _3584_/B _3584_/C _3584_/D gf180mcu_as_sc_mcu7t3v3__aoi22_2
X_2535_ VDD VDD VSS VSS _2535_/B _2535_/A _2544_/A gf180mcu_as_sc_mcu7t3v3__and2_2
XTAP_TAPCELL_ROW_171_1495 VDD VSS gf180mcu_as_sc_mcu7t3v3__tap_2
X_2466_ VDD VDD VSS VSS _2468_/D _2466_/C _2490_/B _2466_/A gf180mcu_as_sc_mcu7t3v3__aoi21b_2
XFILLER_190_1270 VDD VDD VSS VSS gf180mcu_as_sc_mcu7t3v3__fillcap_16
X_4205_ VDD VDD VSS VSS _4205_/B _4205_/A _4717_/D gf180mcu_as_sc_mcu7t3v3__and2_2
X_4136_ VDD VDD VSS VSS _4136_/A _4136_/B _4136_/C _4136_/D _4137_/D gf180mcu_as_sc_mcu7t3v3__ao22_2
X_2397_ VDD VDD VSS VSS _2405_/A _2397_/B _2397_/C _2397_/D _2398_/C gf180mcu_as_sc_mcu7t3v3__ao211_2
XFILLER_113_37 VDD VDD VSS VSS gf180mcu_as_sc_mcu7t3v3__fillcap_16
XFILLER_3_1020 VDD VDD VSS VSS gf180mcu_as_sc_mcu7t3v3__fillcap_4
X_4067_ VDD VDD VSS VSS _4700_/D _4067_/C _4138_/B _4067_/A gf180mcu_as_sc_mcu7t3v3__aoi21_2
XTAP_TAPCELL_ROW_117_1_1070 VDD VSS gf180mcu_as_sc_mcu7t3v3__tap_2
X_3018_ VDD VDD VSS VSS _3018_/A _3019_/B _3020_/S _4428_/Q _4428_/D gf180mcu_as_sc_mcu7t3v3__ao22_2
XFILLER_169_416 VDD VDD VSS VSS gf180mcu_as_sc_mcu7t3v3__fillcap_4
XTAP_TAPCELL_ROW_178_1627 VDD VSS gf180mcu_as_sc_mcu7t3v3__tap_2
XFILLER_11_116 VDD VDD VSS VSS gf180mcu_as_sc_mcu7t3v3__fillcap_8
XFILLER_162_1350 VDD VDD VSS VSS gf180mcu_as_sc_mcu7t3v3__fill_1
Xsram2048.u_bank0_815 VDD VDD VSS VSS sram2048.u_bank0/WEN[2] gf180mcu_as_sc_mcu7t3v3__tiel_4
XFILLER_184_419 VDD VDD VSS VSS gf180mcu_as_sc_mcu7t3v3__fillcap_16
XFILLER_138_34 VDD VDD VSS VSS gf180mcu_as_sc_mcu7t3v3__fill_1
XFILLER_165_655 VDD VDD VSS VSS gf180mcu_as_sc_mcu7t3v3__fill_1
XFILLER_192_441 VDD VDD VSS VSS gf180mcu_as_sc_mcu7t3v3__fill_1
XFILLER_153_828 VDD VDD VSS VSS gf180mcu_as_sc_mcu7t3v3__fillcap_8
XFILLER_192_463 VDD VDD VSS VSS gf180mcu_as_sc_mcu7t3v3__fillcap_4
XPHY_EDGE_ROW_88_1_Left_280 VDD VSS gf180mcu_as_sc_mcu7t3v3__tap_2
X_4742__1030 VDD VDD VSS VSS _4742_/D gf180mcu_as_sc_mcu7t3v3__tiel_4
XPHY_EDGE_ROW_43_3_Right_84 VDD VSS gf180mcu_as_sc_mcu7t3v3__tap_2
XFILLER_3_359 VDD VDD VSS VSS gf180mcu_as_sc_mcu7t3v3__fill_1
XFILLER_154_22 VDD VDD VSS VSS gf180mcu_as_sc_mcu7t3v3__fillcap_8
XFILLER_156_1165 VDD VDD VSS VSS gf180mcu_as_sc_mcu7t3v3__fillcap_4
XFILLER_161_894 VDD VDD VSS VSS gf180mcu_as_sc_mcu7t3v3__fill_2
XPHY_EDGE_ROW_46_3_Left_418 VDD VSS gf180mcu_as_sc_mcu7t3v3__tap_2
XFILLER_128_1256 VDD VDD VSS VSS gf180mcu_as_sc_mcu7t3v3__fillcap_8
XFILLER_176_909 VDD VDD VSS VSS gf180mcu_as_sc_mcu7t3v3__fillcap_16
XFILLER_168_471 VDD VDD VSS VSS gf180mcu_as_sc_mcu7t3v3__fill_1
XFILLER_175_419 VDD VDD VSS VSS gf180mcu_as_sc_mcu7t3v3__fill_1
XFILLER_155_121 VDD VDD VSS VSS gf180mcu_as_sc_mcu7t3v3__fillcap_16
XFILLER_7_632 VDD VDD VSS VSS gf180mcu_as_sc_mcu7t3v3__fillcap_4
Xwire530 VDD VDD VSS VSS _4268_/B _4236_/C gf180mcu_as_sc_mcu7t3v3__clkbuff_12
XFILLER_10_171 VDD VDD VSS VSS gf180mcu_as_sc_mcu7t3v3__fillcap_4
XFILLER_183_474 VDD VDD VSS VSS gf180mcu_as_sc_mcu7t3v3__fillcap_4
XFILLER_155_176 VDD VDD VSS VSS gf180mcu_as_sc_mcu7t3v3__fillcap_4
XFILLER_152_883 VDD VDD VSS VSS gf180mcu_as_sc_mcu7t3v3__fill_1
X_2320_ VDD VDD VSS VSS _3142_/B _4510_/Q _4509_/Q gf180mcu_as_sc_mcu7t3v3__nor2_2
XPHY_EDGE_ROW_34_1_Right_543 VDD VSS gf180mcu_as_sc_mcu7t3v3__tap_2
XFILLER_170_1118 VDD VDD VSS VSS gf180mcu_as_sc_mcu7t3v3__fill_1
XFILLER_174_1287 VDD VDD VSS VSS gf180mcu_as_sc_mcu7t3v3__fill_1
X_2251_ VDD VDD VSS VSS _3131_/A _2510_/D _2253_/C gf180mcu_as_sc_mcu7t3v3__and2_2
XTAP_TAPCELL_ROW_24_3_1935 VDD VSS gf180mcu_as_sc_mcu7t3v3__tap_2
XPHY_EDGE_ROW_95_3_Right_136 VDD VSS gf180mcu_as_sc_mcu7t3v3__tap_2
X_2182_ VDD VDD VSS VSS _3051_/A _2339_/C gf180mcu_as_sc_mcu7t3v3__inv_2
XFILLER_0_1226 VDD VDD VSS VSS gf180mcu_as_sc_mcu7t3v3__fill_1
XFILLER_146_1345 VDD VDD VSS VSS gf180mcu_as_sc_mcu7t3v3__fill_2
XPHY_EDGE_ROW_92_3_Left_464 VDD VSS gf180mcu_as_sc_mcu7t3v3__tap_2
XFILLER_107_1318 VDD VDD VSS VSS gf180mcu_as_sc_mcu7t3v3__fillcap_4
XFILLER_179_769 VDD VDD VSS VSS gf180mcu_as_sc_mcu7t3v3__fill_1
X_4823_ VDD VDD VSS VSS _4830_/CLK _4823_/D _4823_/Q gf180mcu_as_sc_mcu7t3v3__dfxtp_2
XFILLER_178_279 VDD VDD VSS VSS gf180mcu_as_sc_mcu7t3v3__fillcap_16
X_4754_ VDD VDD VSS VSS clkload3/A _4754_/D _4754_/Q gf180mcu_as_sc_mcu7t3v3__dfxtp_2
XFILLER_159_482 VDD VDD VSS VSS gf180mcu_as_sc_mcu7t3v3__fillcap_8
X_3705_ VDD VDD VSS VSS _3916_/B _4060_/D _3706_/C gf180mcu_as_sc_mcu7t3v3__and2_2
XTAP_TAPCELL_ROW_173_1535 VDD VSS gf180mcu_as_sc_mcu7t3v3__tap_2
XTAP_TAPCELL_ROW_173_1524 VDD VSS gf180mcu_as_sc_mcu7t3v3__tap_2
XFILLER_175_986 VDD VDD VSS VSS gf180mcu_as_sc_mcu7t3v3__fill_2
XFILLER_179_1154 VDD VDD VSS VSS gf180mcu_as_sc_mcu7t3v3__fill_1
X_4685_ VDD VDD VSS VSS _4692_/CLK _4685_/D _4685_/Q gf180mcu_as_sc_mcu7t3v3__dfxtp_2
XFILLER_31_1283 VDD VDD VSS VSS gf180mcu_as_sc_mcu7t3v3__fill_2
X_3636_ VDD VDD VSS VSS _3636_/Y _3937_/B _3636_/A gf180mcu_as_sc_mcu7t3v3__nor2_2
XTAP_TAPCELL_ROW_190_1860 VDD VSS gf180mcu_as_sc_mcu7t3v3__tap_2
XFILLER_161_146 VDD VDD VSS VSS gf180mcu_as_sc_mcu7t3v3__fill_2
XFILLER_192_1310 VDD VDD VSS VSS gf180mcu_as_sc_mcu7t3v3__fillcap_16
XFILLER_66_1324 VDD VDD VSS VSS gf180mcu_as_sc_mcu7t3v3__fillcap_4
X_3567_ VDD VDD VSS VSS _3569_/B _3603_/C _3567_/C _4624_/D gf180mcu_as_sc_mcu7t3v3__nor3_2
XFILLER_192_1354 VDD VDD VSS VSS gf180mcu_as_sc_mcu7t3v3__fill_1
X_2518_ VDD VDD VSS VSS _3513_/A _2523_/B _2567_/B _2523_/C _2566_/B gf180mcu_as_sc_mcu7t3v3__ao211_2
XFILLER_170_691 VDD VDD VSS VSS gf180mcu_as_sc_mcu7t3v3__fill_1
Xinput208 VDD VDD VSS VSS se_in[27] _4228_/A gf180mcu_as_sc_mcu7t3v3__buff_12
X_3498_ VDD VDD VSS VSS _4454_/Q _3553_/B _3502_/C _4601_/Q _3499_/C gf180mcu_as_sc_mcu7t3v3__ao22_2
Xinput219 VDD VDD VSS VSS se_in[4] _4041_/A gf180mcu_as_sc_mcu7t3v3__buff_12
X_2449_ VDD VDD VSS VSS _2450_/C _2449_/B _2489_/A gf180mcu_as_sc_mcu7t3v3__nor2_2
XFILLER_124_69 VDD VDD VSS VSS gf180mcu_as_sc_mcu7t3v3__fillcap_16
XFILLER_84_29 VDD VDD VSS VSS gf180mcu_as_sc_mcu7t3v3__fill_2
X_4119_ VDD VDD VSS VSS _4122_/B _4119_/B _4119_/A gf180mcu_as_sc_mcu7t3v3__nor2_2
XPHY_EDGE_ROW_3_Left_196 VDD VSS gf180mcu_as_sc_mcu7t3v3__tap_2
XTAP_TAPCELL_ROW_128_3_2039 VDD VSS gf180mcu_as_sc_mcu7t3v3__tap_2
XFILLER_149_22 VDD VDD VSS VSS gf180mcu_as_sc_mcu7t3v3__fillcap_8
XFILLER_149_44 VDD VDD VSS VSS gf180mcu_as_sc_mcu7t3v3__fillcap_8
XFILLER_169_268 VDD VDD VSS VSS gf180mcu_as_sc_mcu7t3v3__fill_1
XFILLER_165_430 VDD VDD VSS VSS gf180mcu_as_sc_mcu7t3v3__fillcap_4
XFILLER_177_290 VDD VDD VSS VSS gf180mcu_as_sc_mcu7t3v3__fillcap_8
XFILLER_184_227 VDD VDD VSS VSS gf180mcu_as_sc_mcu7t3v3__fillcap_4
XFILLER_33_88 VDD VDD VSS VSS gf180mcu_as_sc_mcu7t3v3__fillcap_16
XFILLER_10_1301 VDD VDD VSS VSS gf180mcu_as_sc_mcu7t3v3__fill_2
XFILLER_181_912 VDD VDD VSS VSS gf180mcu_as_sc_mcu7t3v3__fillcap_16
XFILLER_116_2 VDD VDD VSS VSS gf180mcu_as_sc_mcu7t3v3__fillcap_4
XFILLER_153_625 VDD VDD VSS VSS gf180mcu_as_sc_mcu7t3v3__fillcap_4
XFILLER_153_636 VDD VDD VSS VSS gf180mcu_as_sc_mcu7t3v3__fill_2
XFILLER_158_1227 VDD VDD VSS VSS gf180mcu_as_sc_mcu7t3v3__fillcap_16
XFILLER_165_485 VDD VDD VSS VSS gf180mcu_as_sc_mcu7t3v3__fillcap_4
XFILLER_181_934 VDD VDD VSS VSS gf180mcu_as_sc_mcu7t3v3__fill_1
XFILLER_181_978 VDD VDD VSS VSS gf180mcu_as_sc_mcu7t3v3__fill_2
XFILLER_0_852 VDD VDD VSS VSS gf180mcu_as_sc_mcu7t3v3__fill_1
XFILLER_0_863 VDD VDD VSS VSS gf180mcu_as_sc_mcu7t3v3__fill_2
XFILLER_58_85 VDD VDD VSS VSS gf180mcu_as_sc_mcu7t3v3__fillcap_16
XFILLER_181_97 VDD VDD VSS VSS gf180mcu_as_sc_mcu7t3v3__fillcap_16
XFILLER_188_500 VDD VDD VSS VSS gf180mcu_as_sc_mcu7t3v3__fillcap_4
XFILLER_188_599 VDD VDD VSS VSS gf180mcu_as_sc_mcu7t3v3__fill_1
XFILLER_12_992 VDD VDD VSS VSS gf180mcu_as_sc_mcu7t3v3__fillcap_16
XFILLER_191_709 VDD VDD VSS VSS gf180mcu_as_sc_mcu7t3v3__fillcap_16
XFILLER_11_1109 VDD VDD VSS VSS gf180mcu_as_sc_mcu7t3v3__fill_2
XFILLER_141_1264 VDD VDD VSS VSS gf180mcu_as_sc_mcu7t3v3__fillcap_4
XFILLER_141_1275 VDD VDD VSS VSS gf180mcu_as_sc_mcu7t3v3__fillcap_16
XFILLER_8_974 VDD VDD VSS VSS gf180mcu_as_sc_mcu7t3v3__fill_2
XFILLER_143_102 VDD VDD VSS VSS gf180mcu_as_sc_mcu7t3v3__fill_2
XFILLER_176_1316 VDD VDD VSS VSS gf180mcu_as_sc_mcu7t3v3__fill_2
XFILLER_183_282 VDD VDD VSS VSS gf180mcu_as_sc_mcu7t3v3__fillcap_16
X_4470_ VDD VDD VSS VSS _4576_/CLK _4470_/D _4470_/Q gf180mcu_as_sc_mcu7t3v3__dfxtp_2
X_3421_ VDD VDD VSS VSS _4550_/Q _3445_/B _3449_/B _4549_/Q _4549_/D gf180mcu_as_sc_mcu7t3v3__ao22_2
X_3352_ VDD VDD VSS VSS _3368_/S _4377_/Q _4406_/Q _3353_/B gf180mcu_as_sc_mcu7t3v3__mux2_2
X_2303_ VDD VDD VSS VSS _2309_/D _2308_/A gf180mcu_as_sc_mcu7t3v3__inv_2
X_3283_ VDD VDD VSS VSS _4526_/Q _3315_/B _3315_/C _4527_/Q _3284_/C gf180mcu_as_sc_mcu7t3v3__ao22_2
XPHY_EDGE_ROW_35_1_Right_544 VDD VSS gf180mcu_as_sc_mcu7t3v3__tap_2
X_2234_ VDD VDD VSS VSS _2234_/B _3086_/A _3609_/B gf180mcu_as_sc_mcu7t3v3__or2_2
XFILLER_61_1298 VDD VDD VSS VSS gf180mcu_as_sc_mcu7t3v3__fill_1
XPHY_EDGE_ROW_96_3_Right_137 VDD VSS gf180mcu_as_sc_mcu7t3v3__tap_2
XTAP_TAPCELL_ROW_166_1394 VDD VSS gf180mcu_as_sc_mcu7t3v3__tap_2
XFILLER_0_70 VDD VDD VSS VSS gf180mcu_as_sc_mcu7t3v3__fillcap_4
XFILLER_110_27 VDD VDD VSS VSS gf180mcu_as_sc_mcu7t3v3__fillcap_8
XFILLER_167_706 VDD VDD VSS VSS gf180mcu_as_sc_mcu7t3v3__fill_2
XFILLER_179_555 VDD VDD VSS VSS gf180mcu_as_sc_mcu7t3v3__fillcap_4
XFILLER_166_205 VDD VDD VSS VSS gf180mcu_as_sc_mcu7t3v3__fill_2
XFILLER_33_1301 VDD VDD VSS VSS gf180mcu_as_sc_mcu7t3v3__fillcap_16
X_4806_ VDD VDD VSS VSS _4807_/CLK _4806_/D _4806_/Q gf180mcu_as_sc_mcu7t3v3__dfxtp_2
XTAP_TAPCELL_ROW_192_1900 VDD VSS gf180mcu_as_sc_mcu7t3v3__tap_2
XFILLER_33_1323 VDD VDD VSS VSS gf180mcu_as_sc_mcu7t3v3__fill_1
X_2998_ VDD VDD VSS VSS _2998_/A _3004_/B _3004_/C _4410_/Q _4410_/D gf180mcu_as_sc_mcu7t3v3__ao22_2
XTAP_TAPCELL_ROW_192_1922 VDD VSS gf180mcu_as_sc_mcu7t3v3__tap_2
XTAP_TAPCELL_ROW_192_1911 VDD VSS gf180mcu_as_sc_mcu7t3v3__tap_2
XFILLER_163_912 VDD VDD VSS VSS gf180mcu_as_sc_mcu7t3v3__fillcap_16
XFILLER_175_772 VDD VDD VSS VSS gf180mcu_as_sc_mcu7t3v3__fillcap_16
X_4737_ VDD VDD VSS VSS clkload6/A _4737_/D _4737_/Q gf180mcu_as_sc_mcu7t3v3__dfxtp_2
XFILLER_162_422 VDD VDD VSS VSS gf180mcu_as_sc_mcu7t3v3__fillcap_16
X_4668_ VDD VDD VSS VSS clkload5/A _4668_/D _4668_/Q gf180mcu_as_sc_mcu7t3v3__dfxtp_2
XFILLER_162_444 VDD VDD VSS VSS gf180mcu_as_sc_mcu7t3v3__fill_1
XFILLER_190_753 VDD VDD VSS VSS gf180mcu_as_sc_mcu7t3v3__fill_2
X_3619_ VDD VDD VSS VSS _3890_/S _3880_/A _3832_/C gf180mcu_as_sc_mcu7t3v3__and2_2
X_4599_ VDD VDD VSS VSS _4602_/CLK _4599_/D _4599_/Q gf180mcu_as_sc_mcu7t3v3__dfxtp_2
XFILLER_0_104 VDD VDD VSS VSS gf180mcu_as_sc_mcu7t3v3__fill_2
XFILLER_153_1113 VDD VDD VSS VSS gf180mcu_as_sc_mcu7t3v3__fillcap_4
XFILLER_157_1293 VDD VDD VSS VSS gf180mcu_as_sc_mcu7t3v3__fill_2
XFILLER_192_1151 VDD VDD VSS VSS gf180mcu_as_sc_mcu7t3v3__fill_1
XFILLER_192_1162 VDD VDD VSS VSS gf180mcu_as_sc_mcu7t3v3__fill_1
XPHY_EDGE_ROW_119_1_Left_311 VDD VSS gf180mcu_as_sc_mcu7t3v3__tap_2
XFILLER_77_1272 VDD VDD VSS VSS gf180mcu_as_sc_mcu7t3v3__fillcap_16
XTAP_TAPCELL_ROW_0_682 VDD VSS gf180mcu_as_sc_mcu7t3v3__tap_2
XTAP_TAPCELL_ROW_0_671 VDD VSS gf180mcu_as_sc_mcu7t3v3__tap_2
XFILLER_38_1256 VDD VDD VSS VSS gf180mcu_as_sc_mcu7t3v3__fillcap_16
XTAP_TAPCELL_ROW_0_693 VDD VSS gf180mcu_as_sc_mcu7t3v3__tap_2
XFILLER_13_745 VDD VDD VSS VSS gf180mcu_as_sc_mcu7t3v3__fill_2
XFILLER_158_717 VDD VDD VSS VSS gf180mcu_as_sc_mcu7t3v3__fill_1
XFILLER_164_1286 VDD VDD VSS VSS gf180mcu_as_sc_mcu7t3v3__fillcap_8
XFILLER_164_1297 VDD VDD VSS VSS gf180mcu_as_sc_mcu7t3v3__fillcap_16
XFILLER_44_98 VDD VDD VSS VSS gf180mcu_as_sc_mcu7t3v3__fillcap_4
XTAP_TAPCELL_ROW_11_902 VDD VSS gf180mcu_as_sc_mcu7t3v3__tap_2
XFILLER_125_102 VDD VDD VSS VSS gf180mcu_as_sc_mcu7t3v3__fill_2
XFILLER_153_422 VDD VDD VSS VSS gf180mcu_as_sc_mcu7t3v3__fillcap_8
XFILLER_154_923 VDD VDD VSS VSS gf180mcu_as_sc_mcu7t3v3__fillcap_16
XFILLER_176_53 VDD VDD VSS VSS gf180mcu_as_sc_mcu7t3v3__fillcap_16
XFILLER_154_967 VDD VDD VSS VSS gf180mcu_as_sc_mcu7t3v3__fill_2
XFILLER_5_26 VDD VDD VSS VSS gf180mcu_as_sc_mcu7t3v3__fillcap_4
XFILLER_5_966 VDD VDD VSS VSS gf180mcu_as_sc_mcu7t3v3__fill_1
XFILLER_109_80 VDD VDD VSS VSS gf180mcu_as_sc_mcu7t3v3__fillcap_4
XFILLER_10_1153 VDD VDD VSS VSS gf180mcu_as_sc_mcu7t3v3__fill_2
XFILLER_180_263 VDD VDD VSS VSS gf180mcu_as_sc_mcu7t3v3__fillcap_4
XFILLER_4_454 VDD VDD VSS VSS gf180mcu_as_sc_mcu7t3v3__fill_1
XFILLER_5_977 VDD VDD VSS VSS gf180mcu_as_sc_mcu7t3v3__fill_2
XTAP_TAPCELL_ROW_140_1_1093 VDD VSS gf180mcu_as_sc_mcu7t3v3__tap_2
XFILLER_10_1197 VDD VDD VSS VSS gf180mcu_as_sc_mcu7t3v3__fill_1
XFILLER_171_1202 VDD VDD VSS VSS gf180mcu_as_sc_mcu7t3v3__fillcap_16
XFILLER_180_296 VDD VDD VSS VSS gf180mcu_as_sc_mcu7t3v3__fill_1
XFILLER_192_52 VDD VDD VSS VSS gf180mcu_as_sc_mcu7t3v3__fillcap_16
XFILLER_192_74 VDD VDD VSS VSS gf180mcu_as_sc_mcu7t3v3__fill_2
XPHY_EDGE_ROW_103_1_Left_295 VDD VSS gf180mcu_as_sc_mcu7t3v3__tap_2
XPHY_EDGE_ROW_13_Right_13 VDD VSS gf180mcu_as_sc_mcu7t3v3__tap_2
XFILLER_85_72 VDD VDD VSS VSS gf180mcu_as_sc_mcu7t3v3__fillcap_4
XFILLER_165_1006 VDD VDD VSS VSS gf180mcu_as_sc_mcu7t3v3__fill_1
XPHY_EDGE_ROW_40_1_Left_232 VDD VSS gf180mcu_as_sc_mcu7t3v3__tap_2
XFILLER_169_1186 VDD VDD VSS VSS gf180mcu_as_sc_mcu7t3v3__fillcap_4
XFILLER_1_1354 VDD VDD VSS VSS gf180mcu_as_sc_mcu7t3v3__fill_1
X_3970_ VDD VDD VSS VSS _3996_/B _3970_/B _4241_/A gf180mcu_as_sc_mcu7t3v3__nor2_2
XTAP_TAPCELL_ROW_19_3_1930 VDD VSS gf180mcu_as_sc_mcu7t3v3__tap_2
X_2921_ VDD VDD VSS VSS _4275_/B _4278_/A _4764_/Q gf180mcu_as_sc_mcu7t3v3__nor2b_2
XFILLER_143_1326 VDD VDD VSS VSS gf180mcu_as_sc_mcu7t3v3__fill_2
X_2852_ VDD VDD VSS VSS _2897_/B _4170_/A _2853_/D gf180mcu_as_sc_mcu7t3v3__or2_2
XFILLER_163_208 VDD VDD VSS VSS gf180mcu_as_sc_mcu7t3v3__fill_2
X_2783_ VDD VDD VSS VSS _4785_/Q _2874_/B _2915_/B _4110_/D _2784_/D gf180mcu_as_sc_mcu7t3v3__ao22_2
X_4522_ VDD VDD VSS VSS clkload9/A _4522_/D _4522_/Q gf180mcu_as_sc_mcu7t3v3__dfxtp_2
XFILLER_171_230 VDD VDD VSS VSS gf180mcu_as_sc_mcu7t3v3__fill_2
XFILLER_176_1135 VDD VDD VSS VSS gf180mcu_as_sc_mcu7t3v3__fillcap_4
X_4453_ VDD VDD VSS VSS _4726_/CLK _4453_/D _4453_/Q gf180mcu_as_sc_mcu7t3v3__dfxtp_2
XFILLER_176_1157 VDD VDD VSS VSS gf180mcu_as_sc_mcu7t3v3__fillcap_16
X_3404_ VDD VDD VSS VSS _3412_/A _3404_/B _3404_/C _3404_/D _4541_/D gf180mcu_as_sc_mcu7t3v3__ao211_2
X_4384_ VDD VDD VSS VSS _4447_/CLK _4384_/D _4384_/Q gf180mcu_as_sc_mcu7t3v3__dfxtp_2
Xfanout728 VDD VDD VSS VSS _3454_/A _3131_/A gf180mcu_as_sc_mcu7t3v3__buff_12
Xfanout739 VDD VDD VSS VSS fanout743/Y _3393_/A gf180mcu_as_sc_mcu7t3v3__buff_12
X_3335_ VDD VDD VSS VSS _3338_/C _4433_/Q _3344_/S gf180mcu_as_sc_mcu7t3v3__nand2_2
XTAP_TAPCELL_ROW_168_1434 VDD VSS gf180mcu_as_sc_mcu7t3v3__tap_2
X_3266_ VDD VDD VSS VSS _3314_/A _3266_/B _3266_/C _3268_/B _3266_/D gf180mcu_as_sc_mcu7t3v3__aoi31_2
XTAP_TAPCELL_ROW_168_1445 VDD VSS gf180mcu_as_sc_mcu7t3v3__tap_2
XPHY_EDGE_ROW_36_1_Right_545 VDD VSS gf180mcu_as_sc_mcu7t3v3__tap_2
X_2217_ VDD VDD VSS VSS _4067_/A _2217_/A gf180mcu_as_sc_mcu7t3v3__inv_2
XTAP_TAPCELL_ROW_185_1770 VDD VSS gf180mcu_as_sc_mcu7t3v3__tap_2
X_3197_ VDD VDD VSS VSS _3518_/B _3397_/B _3412_/A _3197_/D _3198_/B gf180mcu_as_sc_mcu7t3v3__ao22_2
XPHY_EDGE_ROW_97_3_Right_138 VDD VSS gf180mcu_as_sc_mcu7t3v3__tap_2
XFILLER_187_1253 VDD VDD VSS VSS gf180mcu_as_sc_mcu7t3v3__fillcap_4
XFILLER_53_100 VDD VDD VSS VSS gf180mcu_as_sc_mcu7t3v3__fillcap_4
XTAP_TAPCELL_ROW_181_1689 VDD VSS gf180mcu_as_sc_mcu7t3v3__tap_2
XTAP_TAPCELL_ROW_181_1678 VDD VSS gf180mcu_as_sc_mcu7t3v3__tap_2
XFILLER_121_59 VDD VDD VSS VSS gf180mcu_as_sc_mcu7t3v3__fill_1
XPHY_EDGE_ROW_52_3_Right_93 VDD VSS gf180mcu_as_sc_mcu7t3v3__tap_2
XFILLER_179_352 VDD VDD VSS VSS gf180mcu_as_sc_mcu7t3v3__fillcap_16
XFILLER_10_748 VDD VDD VSS VSS gf180mcu_as_sc_mcu7t3v3__fillcap_8
XFILLER_167_558 VDD VDD VSS VSS gf180mcu_as_sc_mcu7t3v3__fill_2
XPHY_EDGE_ROW_55_3_Left_427 VDD VSS gf180mcu_as_sc_mcu7t3v3__tap_2
XFILLER_124_1281 VDD VDD VSS VSS gf180mcu_as_sc_mcu7t3v3__fill_1
XFILLER_159_1311 VDD VDD VSS VSS gf180mcu_as_sc_mcu7t3v3__fill_2
XFILLER_146_34 VDD VDD VSS VSS gf180mcu_as_sc_mcu7t3v3__fill_1
XFILLER_155_1208 VDD VDD VSS VSS gf180mcu_as_sc_mcu7t3v3__fillcap_4
XFILLER_162_263 VDD VDD VSS VSS gf180mcu_as_sc_mcu7t3v3__fill_2
XFILLER_2_947 VDD VDD VSS VSS gf180mcu_as_sc_mcu7t3v3__fillcap_4
Xmax_cap490 VDD VDD VSS VSS _4238_/S _4212_/S gf180mcu_as_sc_mcu7t3v3__clkbuff_12
XFILLER_162_22 VDD VDD VSS VSS gf180mcu_as_sc_mcu7t3v3__fillcap_8
XFILLER_188_1017 VDD VDD VSS VSS gf180mcu_as_sc_mcu7t3v3__fillcap_16
XFILLER_183_2 VDD VDD VSS VSS gf180mcu_as_sc_mcu7t3v3__fillcap_16
XTAP_TAPCELL_ROW_5_785 VDD VSS gf180mcu_as_sc_mcu7t3v3__tap_2
XFILLER_131_1296 VDD VDD VSS VSS gf180mcu_as_sc_mcu7t3v3__fill_2
XFILLER_186_823 VDD VDD VSS VSS gf180mcu_as_sc_mcu7t3v3__fill_2
XFILLER_13_586 VDD VDD VSS VSS gf180mcu_as_sc_mcu7t3v3__fill_1
XFILLER_185_333 VDD VDD VSS VSS gf180mcu_as_sc_mcu7t3v3__fillcap_16
XFILLER_158_569 VDD VDD VSS VSS gf180mcu_as_sc_mcu7t3v3__fill_2
XFILLER_187_63 VDD VDD VSS VSS gf180mcu_as_sc_mcu7t3v3__fillcap_4
XPHY_EDGE_ROW_59_3_Right_100 VDD VSS gf180mcu_as_sc_mcu7t3v3__tap_2
XFILLER_90_1291 VDD VDD VSS VSS gf180mcu_as_sc_mcu7t3v3__fillcap_8
XFILLER_153_230 VDD VDD VSS VSS gf180mcu_as_sc_mcu7t3v3__fillcap_16
XFILLER_166_591 VDD VDD VSS VSS gf180mcu_as_sc_mcu7t3v3__fillcap_4
XFILLER_154_775 VDD VDD VSS VSS gf180mcu_as_sc_mcu7t3v3__fill_1
XFILLER_181_572 VDD VDD VSS VSS gf180mcu_as_sc_mcu7t3v3__fill_1
X_3120_ VDD VDD VSS VSS _3120_/S _4508_/Q _4507_/Q _4507_/D gf180mcu_as_sc_mcu7t3v3__mux2_2
XFILLER_110_1303 VDD VDD VSS VSS gf180mcu_as_sc_mcu7t3v3__fill_1
X_3051_ VDD VDD VSS VSS _3053_/B _3051_/A _3052_/B gf180mcu_as_sc_mcu7t3v3__xnor2_2
XTAP_TAPCELL_ROW_163_1342 VDD VSS gf180mcu_as_sc_mcu7t3v3__tap_2
XFILLER_147_1281 VDD VDD VSS VSS gf180mcu_as_sc_mcu7t3v3__fillcap_8
XFILLER_189_672 VDD VDD VSS VSS gf180mcu_as_sc_mcu7t3v3__fill_2
X_3953_ VDD VDD VSS VSS _3953_/D _3953_/A _3965_/B _3953_/C _3954_/D gf180mcu_as_sc_mcu7t3v3__ao31_2
XTAP_TAPCELL_ROW_66_1_1019 VDD VSS gf180mcu_as_sc_mcu7t3v3__tap_2
X_3884_ VDD VDD VSS VSS _3884_/B _3884_/A _4683_/D gf180mcu_as_sc_mcu7t3v3__and2_2
X_2904_ VDD VDD VSS VSS _2905_/D _4219_/A _2904_/B _2904_/C gf180mcu_as_sc_mcu7t3v3__ao21_2
XFILLER_176_333 VDD VDD VSS VSS gf180mcu_as_sc_mcu7t3v3__fill_2
XFILLER_188_193 VDD VDD VSS VSS gf180mcu_as_sc_mcu7t3v3__fill_2
XFILLER_192_815 VDD VDD VSS VSS gf180mcu_as_sc_mcu7t3v3__fill_1
X_2835_ VDD VDD VSS VSS _2835_/B _2966_/A _3027_/A gf180mcu_as_sc_mcu7t3v3__and2_2
X_2766_ VDD VDD VSS VSS _2768_/C _4094_/A _2822_/B _2766_/C gf180mcu_as_sc_mcu7t3v3__ao21_2
X_4505_ VDD VDD VSS VSS _4720_/CLK _4505_/D _4505_/Q gf180mcu_as_sc_mcu7t3v3__dfxtp_2
X_2697_ VDD VDD VSS VSS _2879_/B _4033_/A _2698_/D gf180mcu_as_sc_mcu7t3v3__or2_2
XFILLER_172_594 VDD VDD VSS VSS gf180mcu_as_sc_mcu7t3v3__fill_1
X_4436_ VDD VDD VSS VSS _4440_/CLK _4436_/D _4436_/Q gf180mcu_as_sc_mcu7t3v3__dfxtp_2
XFILLER_116_37 VDD VDD VSS VSS gf180mcu_as_sc_mcu7t3v3__fillcap_16
Xfanout503 VDD VDD VSS VSS _2871_/B _2796_/D gf180mcu_as_sc_mcu7t3v3__buff_12
Xfanout514 VDD VDD VSS VSS _2974_/A _2943_/A gf180mcu_as_sc_mcu7t3v3__buff_12
X_4367_ VDD VDD VSS VSS clkload8/A _4367_/D _4367_/Q gf180mcu_as_sc_mcu7t3v3__dfxtp_2
XFILLER_154_1263 VDD VDD VSS VSS gf180mcu_as_sc_mcu7t3v3__fillcap_8
Xfanout525 VDD VDD VSS VSS _4227_/C _4153_/B gf180mcu_as_sc_mcu7t3v3__buff_12
Xfanout536 VDD VDD VSS VSS _3635_/Y _3930_/B gf180mcu_as_sc_mcu7t3v3__buff_12
Xfanout547 VDD VDD VSS VSS wire550/Y _2917_/C gf180mcu_as_sc_mcu7t3v3__buff_12
X_3318_ VDD VDD VSS VSS _3322_/B _4344_/Q _3344_/S gf180mcu_as_sc_mcu7t3v3__nand2b_2
XFILLER_28_1288 VDD VDD VSS VSS gf180mcu_as_sc_mcu7t3v3__fill_1
Xfanout558 VDD VDD VSS VSS _4318_/B _4312_/B gf180mcu_as_sc_mcu7t3v3__buff_12
Xfanout569 VDD VDD VSS VSS _3411_/C _3403_/C gf180mcu_as_sc_mcu7t3v3__buff_12
X_4298_ VDD VDD VSS VSS _4313_/B _4522_/Q _4775_/D gf180mcu_as_sc_mcu7t3v3__and2_2
XTAP_TAPCELL_ROW_183_1729 VDD VSS gf180mcu_as_sc_mcu7t3v3__tap_2
XTAP_TAPCELL_ROW_183_1718 VDD VSS gf180mcu_as_sc_mcu7t3v3__tap_2
XFILLER_189_1326 VDD VDD VSS VSS gf180mcu_as_sc_mcu7t3v3__fillcap_4
XFILLER_189_1348 VDD VDD VSS VSS gf180mcu_as_sc_mcu7t3v3__fillcap_4
Xmesh_tile_962 VDD VDD VSS VSS se_out[26] gf180mcu_as_sc_mcu7t3v3__tiel_4
Xmesh_tile_951 VDD VDD VSS VSS se_out[15] gf180mcu_as_sc_mcu7t3v3__tiel_4
Xmesh_tile_940 VDD VDD VSS VSS se_out[4] gf180mcu_as_sc_mcu7t3v3__tiel_4
X_3249_ VDD VDD VSS VSS _3250_/D _3249_/B _3306_/A gf180mcu_as_sc_mcu7t3v3__nor2_2
XTAP_TAPCELL_ROW_2_733 VDD VSS gf180mcu_as_sc_mcu7t3v3__tap_2
XTAP_TAPCELL_ROW_2_722 VDD VSS gf180mcu_as_sc_mcu7t3v3__tap_2
XPHY_EDGE_ROW_37_1_Right_546 VDD VSS gf180mcu_as_sc_mcu7t3v3__tap_2
XFILLER_6_1084 VDD VDD VSS VSS gf180mcu_as_sc_mcu7t3v3__fill_1
Xmesh_tile_995 VDD VDD VSS VSS sw_out[23] gf180mcu_as_sc_mcu7t3v3__tiel_4
Xmesh_tile_984 VDD VDD VSS VSS sw_out[12] gf180mcu_as_sc_mcu7t3v3__tiel_4
Xmesh_tile_973 VDD VDD VSS VSS sw_out[1] gf180mcu_as_sc_mcu7t3v3__tiel_4
XPHY_EDGE_ROW_98_3_Right_139 VDD VSS gf180mcu_as_sc_mcu7t3v3__tap_2
XFILLER_187_1083 VDD VDD VSS VSS gf180mcu_as_sc_mcu7t3v3__fillcap_8
XFILLER_155_6 VDD VDD VSS VSS gf180mcu_as_sc_mcu7t3v3__fillcap_8
XFILLER_168_845 VDD VDD VSS VSS gf180mcu_as_sc_mcu7t3v3__fillcap_8
XFILLER_161_1278 VDD VDD VSS VSS gf180mcu_as_sc_mcu7t3v3__fillcap_4
XFILLER_41_66 VDD VDD VSS VSS gf180mcu_as_sc_mcu7t3v3__fillcap_4
XFILLER_157_88 VDD VDD VSS VSS gf180mcu_as_sc_mcu7t3v3__fillcap_8
XFILLER_9_2 VDD VDD VSS VSS gf180mcu_as_sc_mcu7t3v3__fillcap_4
XFILLER_133_1303 VDD VDD VSS VSS gf180mcu_as_sc_mcu7t3v3__fillcap_8
XFILLER_173_54 VDD VDD VSS VSS gf180mcu_as_sc_mcu7t3v3__fillcap_4
XFILLER_2_49 VDD VDD VSS VSS gf180mcu_as_sc_mcu7t3v3__fill_2
XFILLER_17_100 VDD VDD VSS VSS gf180mcu_as_sc_mcu7t3v3__fillcap_4
XTAP_TAPCELL_ROW_39_1_992 VDD VSS gf180mcu_as_sc_mcu7t3v3__tap_2
XFILLER_32_103 VDD VDD VSS VSS gf180mcu_as_sc_mcu7t3v3__fill_2
XFILLER_178_609 VDD VDD VSS VSS gf180mcu_as_sc_mcu7t3v3__fillcap_8
XFILLER_82_73 VDD VDD VSS VSS gf180mcu_as_sc_mcu7t3v3__fillcap_4
XFILLER_53_1326 VDD VDD VSS VSS gf180mcu_as_sc_mcu7t3v3__fill_2
XFILLER_140_1318 VDD VDD VSS VSS gf180mcu_as_sc_mcu7t3v3__fillcap_4
XFILLER_174_804 VDD VDD VSS VSS gf180mcu_as_sc_mcu7t3v3__fill_1
XFILLER_12_1012 VDD VDD VSS VSS gf180mcu_as_sc_mcu7t3v3__fill_2
XFILLER_173_314 VDD VDD VSS VSS gf180mcu_as_sc_mcu7t3v3__fillcap_16
XFILLER_185_174 VDD VDD VSS VSS gf180mcu_as_sc_mcu7t3v3__fillcap_16
X_2620_ VDD VDD VSS VSS _2621_/C _4799_/Q _3974_/B gf180mcu_as_sc_mcu7t3v3__or2_2
XFILLER_12_1067 VDD VDD VSS VSS gf180mcu_as_sc_mcu7t3v3__fill_2
XFILLER_182_870 VDD VDD VSS VSS gf180mcu_as_sc_mcu7t3v3__fillcap_4
X_2551_ VDD VDD VSS VSS _3555_/C _2551_/C _2551_/B _2551_/A gf180mcu_as_sc_mcu7t3v3__aoi21_2
XFILLER_154_594 VDD VDD VSS VSS gf180mcu_as_sc_mcu7t3v3__fill_1
X_2482_ VDD VDD VSS VSS _2491_/S _4533_/Q _4525_/Q _2484_/B gf180mcu_as_sc_mcu7t3v3__mux2_2
XFILLER_99_103 VDD VDD VSS VSS gf180mcu_as_sc_mcu7t3v3__fill_2
XFILLER_173_1138 VDD VDD VSS VSS gf180mcu_as_sc_mcu7t3v3__fillcap_16
X_4221_ VDD VDD VSS VSS _4221_/S _4221_/B _4221_/A _4222_/B gf180mcu_as_sc_mcu7t3v3__mux2_2
X_4152_ VDD VDD VSS VSS _4152_/A _4210_/B _4152_/C _4152_/D _4153_/C gf180mcu_as_sc_mcu7t3v3__ao211_2
X_4083_ VDD VDD VSS VSS _4702_/D _4083_/C _4187_/D _4083_/A gf180mcu_as_sc_mcu7t3v3__aoi21_2
X_3103_ VDD VDD VSS VSS _3122_/S _4491_/Q _4490_/Q _4490_/D gf180mcu_as_sc_mcu7t3v3__mux2_2
X_3034_ VDD VDD VSS VSS _3034_/A _3034_/B _3038_/C _4444_/Q _4444_/D gf180mcu_as_sc_mcu7t3v3__ao22_2
XFILLER_149_1310 VDD VDD VSS VSS gf180mcu_as_sc_mcu7t3v3__fill_1
XFILLER_97_1264 VDD VDD VSS VSS gf180mcu_as_sc_mcu7t3v3__fillcap_4
XFILLER_184_1223 VDD VDD VSS VSS gf180mcu_as_sc_mcu7t3v3__fill_2
XFILLER_177_620 VDD VDD VSS VSS gf180mcu_as_sc_mcu7t3v3__fillcap_8
X_3936_ VDD VDD VSS VSS _3936_/D _3958_/A _3959_/B _3960_/C _3938_/D gf180mcu_as_sc_mcu7t3v3__ao31_2
XPHY_EDGE_ROW_169_Right_31 VDD VSS gf180mcu_as_sc_mcu7t3v3__tap_2
XFILLER_176_174 VDD VDD VSS VSS gf180mcu_as_sc_mcu7t3v3__fill_1
XFILLER_192_623 VDD VDD VSS VSS gf180mcu_as_sc_mcu7t3v3__fillcap_4
X_3867_ VDD VDD VSS VSS _4206_/A _3867_/B _3867_/C _3867_/D _3870_/B gf180mcu_as_sc_mcu7t3v3__ao211_2
XTAP_TAPCELL_ROW_176_1588 VDD VSS gf180mcu_as_sc_mcu7t3v3__tap_2
XPHY_EDGE_ROW_128_1_Left_320 VDD VSS gf180mcu_as_sc_mcu7t3v3__tap_2
XFILLER_34_1281 VDD VDD VSS VSS gf180mcu_as_sc_mcu7t3v3__fillcap_8
X_3798_ VDD VDD VSS VSS _3800_/C _4143_/A _3798_/B _3798_/C gf180mcu_as_sc_mcu7t3v3__ao21_2
X_2818_ VDD VDD VSS VSS _2818_/B _4143_/A _2822_/C gf180mcu_as_sc_mcu7t3v3__and2_2
XTAP_TAPCELL_ROW_176_1599 VDD VSS gf180mcu_as_sc_mcu7t3v3__tap_2
XFILLER_178_1049 VDD VDD VSS VSS gf180mcu_as_sc_mcu7t3v3__fillcap_16
XFILLER_180_818 VDD VDD VSS VSS gf180mcu_as_sc_mcu7t3v3__fillcap_16
X_2749_ VDD VDD VSS VSS _2818_/B _4081_/A _2750_/D gf180mcu_as_sc_mcu7t3v3__and2_2
XFILLER_127_58 VDD VDD VSS VSS gf180mcu_as_sc_mcu7t3v3__fill_2
XFILLER_160_520 VDD VDD VSS VSS gf180mcu_as_sc_mcu7t3v3__fillcap_4
XTAP_TAPCELL_ROW_7_825 VDD VSS gf180mcu_as_sc_mcu7t3v3__tap_2
XPHY_EDGE_ROW_178_Right_40 VDD VSS gf180mcu_as_sc_mcu7t3v3__tap_2
XFILLER_160_586 VDD VDD VSS VSS gf180mcu_as_sc_mcu7t3v3__fillcap_8
XFILLER_160_597 VDD VDD VSS VSS gf180mcu_as_sc_mcu7t3v3__fillcap_4
X_4419_ VDD VDD VSS VSS _4795_/CLK _4419_/D _4419_/Q gf180mcu_as_sc_mcu7t3v3__dfxtp_2
XTAP_TAPCELL_ROW_42_3_1953 VDD VSS gf180mcu_as_sc_mcu7t3v3__tap_2
XFILLER_8_1157 VDD VDD VSS VSS gf180mcu_as_sc_mcu7t3v3__fill_2
XFILLER_143_68 VDD VDD VSS VSS gf180mcu_as_sc_mcu7t3v3__fill_2
XPHY_EDGE_ROW_38_1_Right_547 VDD VSS gf180mcu_as_sc_mcu7t3v3__tap_2
XFILLER_161_1031 VDD VDD VSS VSS gf180mcu_as_sc_mcu7t3v3__fillcap_16
XFILLER_168_653 VDD VDD VSS VSS gf180mcu_as_sc_mcu7t3v3__fillcap_8
XFILLER_10_342 VDD VDD VSS VSS gf180mcu_as_sc_mcu7t3v3__fillcap_4
XFILLER_155_303 VDD VDD VSS VSS gf180mcu_as_sc_mcu7t3v3__fill_2
Xinput19 VDD VDD VSS VSS boot_data[7] _2493_/A gf180mcu_as_sc_mcu7t3v3__buff_12
XPHY_EDGE_ROW_15_3_Right_56 VDD VSS gf180mcu_as_sc_mcu7t3v3__tap_2
XFILLER_155_336 VDD VDD VSS VSS gf180mcu_as_sc_mcu7t3v3__fill_1
XFILLER_7_858 VDD VDD VSS VSS gf180mcu_as_sc_mcu7t3v3__fillcap_16
Xwire767 VDD VDD VSS VSS wire767/A _4137_/A gf180mcu_as_sc_mcu7t3v3__clkbuff_12
XFILLER_182_155 VDD VDD VSS VSS gf180mcu_as_sc_mcu7t3v3__fillcap_8
Xwire778 VDD VDD VSS VSS wire778/A _4093_/D gf180mcu_as_sc_mcu7t3v3__clkbuff_12
Xwire789 VDD VDD VSS VSS wire789/A _4025_/A gf180mcu_as_sc_mcu7t3v3__clkbuff_12
XFILLER_182_177 VDD VDD VSS VSS gf180mcu_as_sc_mcu7t3v3__fillcap_4
XFILLER_163_391 VDD VDD VSS VSS gf180mcu_as_sc_mcu7t3v3__fillcap_16
XFILLER_172_1171 VDD VDD VSS VSS gf180mcu_as_sc_mcu7t3v3__fill_2
XFILLER_77_62 VDD VDD VSS VSS gf180mcu_as_sc_mcu7t3v3__fillcap_8
XFILLER_133_90 VDD VDD VSS VSS gf180mcu_as_sc_mcu7t3v3__fill_1
XTAP_TAPCELL_ROW_146_3_2057 VDD VSS gf180mcu_as_sc_mcu7t3v3__tap_2
XPHY_EDGE_ROW_132_3_Left_504 VDD VSS gf180mcu_as_sc_mcu7t3v3__tap_2
XFILLER_93_72 VDD VDD VSS VSS gf180mcu_as_sc_mcu7t3v3__fillcap_8
XFILLER_93_61 VDD VDD VSS VSS gf180mcu_as_sc_mcu7t3v3__fillcap_8
XFILLER_179_907 VDD VDD VSS VSS gf180mcu_as_sc_mcu7t3v3__fill_2
X_4770_ VDD VDD VSS VSS _4803_/CLK _4770_/D _4770_/Q gf180mcu_as_sc_mcu7t3v3__dfxtp_2
XFILLER_186_450 VDD VDD VSS VSS gf180mcu_as_sc_mcu7t3v3__fillcap_4
X_3721_ VDD VDD VSS VSS _3721_/B _3748_/A _4665_/D gf180mcu_as_sc_mcu7t3v3__and2_2
XTAP_TAPCELL_ROW_158_1252 VDD VSS gf180mcu_as_sc_mcu7t3v3__tap_2
XTAP_TAPCELL_ROW_158_1241 VDD VSS gf180mcu_as_sc_mcu7t3v3__tap_2
X_3652_ VDD VDD VSS VSS _3890_/S _4012_/A _3654_/C gf180mcu_as_sc_mcu7t3v3__or2_2
XFILLER_9_173 VDD VDD VSS VSS gf180mcu_as_sc_mcu7t3v3__fill_1
XFILLER_161_306 VDD VDD VSS VSS gf180mcu_as_sc_mcu7t3v3__fillcap_4
XFILLER_162_807 VDD VDD VSS VSS gf180mcu_as_sc_mcu7t3v3__fillcap_8
XFILLER_174_667 VDD VDD VSS VSS gf180mcu_as_sc_mcu7t3v3__fillcap_16
X_3583_ VDD VDD VSS VSS _3584_/C _3584_/B _3583_/A gf180mcu_as_sc_mcu7t3v3__nand2_2
X_2603_ VDD VDD VSS VSS _3961_/A _2603_/B _2603_/C _4263_/B gf180mcu_as_sc_mcu7t3v3__nor3_2
X_2534_ VDD VDD VSS VSS _4586_/Q _4585_/Q _4583_/Q _2535_/B gf180mcu_as_sc_mcu7t3v3__nor3_2
XTAP_TAPCELL_ROW_171_1496 VDD VSS gf180mcu_as_sc_mcu7t3v3__tap_2
X_2465_ VDD VDD VSS VSS _2466_/C _2465_/B _2489_/A gf180mcu_as_sc_mcu7t3v3__nor2_2
XPHY_EDGE_ROW_127_3_Left_499 VDD VSS gf180mcu_as_sc_mcu7t3v3__tap_2
X_4204_ VDD VDD VSS VSS _4205_/B _4204_/C _4204_/B _4204_/A gf180mcu_as_sc_mcu7t3v3__aoi21b_2
X_2396_ VDD VDD VSS VSS _2397_/C _2396_/B _2426_/C gf180mcu_as_sc_mcu7t3v3__nor2_2
X_4135_ VDD VDD VSS VSS _4216_/A _4135_/B _4135_/C _4138_/B _4137_/C gf180mcu_as_sc_mcu7t3v3__ao211_2
XFILLER_151_1266 VDD VDD VSS VSS gf180mcu_as_sc_mcu7t3v3__fillcap_16
XPHY_EDGE_ROW_64_3_Left_436 VDD VSS gf180mcu_as_sc_mcu7t3v3__tap_2
XFILLER_99_1326 VDD VDD VSS VSS gf180mcu_as_sc_mcu7t3v3__fill_2
XFILLER_186_1329 VDD VDD VSS VSS gf180mcu_as_sc_mcu7t3v3__fillcap_16
X_4066_ VDD VDD VSS VSS _4138_/C _4221_/S _4066_/B _4066_/C _4067_/C gf180mcu_as_sc_mcu7t3v3__ao31_2
X_3017_ VDD VDD VSS VSS _3017_/A _3038_/B _3024_/C _4427_/Q _4427_/D gf180mcu_as_sc_mcu7t3v3__ao22_2
XTAP_TAPCELL_ROW_178_1628 VDD VSS gf180mcu_as_sc_mcu7t3v3__tap_2
XFILLER_11_128 VDD VDD VSS VSS gf180mcu_as_sc_mcu7t3v3__fill_1
Xsram2048.u_bank0_816 VDD VDD VSS VSS sram2048.u_bank0/WEN[3] gf180mcu_as_sc_mcu7t3v3__tiel_4
XFILLER_71_1256 VDD VDD VSS VSS gf180mcu_as_sc_mcu7t3v3__fillcap_16
X_3919_ VDD VDD VSS VSS _3921_/C _3919_/C _3919_/B _3919_/A gf180mcu_as_sc_mcu7t3v3__aoi21_2
XFILLER_192_431 VDD VDD VSS VSS gf180mcu_as_sc_mcu7t3v3__fillcap_4
XTAP_TAPCELL_ROW_38_1_991 VDD VSS gf180mcu_as_sc_mcu7t3v3__tap_2
XFILLER_164_177 VDD VDD VSS VSS gf180mcu_as_sc_mcu7t3v3__fillcap_16
XFILLER_0_6 VDD VDD VSS VSS gf180mcu_as_sc_mcu7t3v3__fill_2
XFILLER_154_34 VDD VDD VSS VSS gf180mcu_as_sc_mcu7t3v3__fill_1
XFILLER_160_350 VDD VDD VSS VSS gf180mcu_as_sc_mcu7t3v3__fill_1
XFILLER_191_1068 VDD VDD VSS VSS gf180mcu_as_sc_mcu7t3v3__fillcap_8
XFILLER_170_22 VDD VDD VSS VSS gf180mcu_as_sc_mcu7t3v3__fillcap_8
XPHY_EDGE_ROW_39_1_Right_548 VDD VSS gf180mcu_as_sc_mcu7t3v3__tap_2
XFILLER_167_1262 VDD VDD VSS VSS gf180mcu_as_sc_mcu7t3v3__fillcap_8
XPHY_EDGE_ROW_177_Left_369 VDD VSS gf180mcu_as_sc_mcu7t3v3__tap_2
XFILLER_163_1126 VDD VDD VSS VSS gf180mcu_as_sc_mcu7t3v3__fill_2
XFILLER_179_20 VDD VDD VSS VSS gf180mcu_as_sc_mcu7t3v3__fill_1
XFILLER_188_737 VDD VDD VSS VSS gf180mcu_as_sc_mcu7t3v3__fill_2
Xclkbuf_leaf_18_clk_regs VDD VDD VSS VSS clkbuf_3_6__f_clk_regs/Y _4602_/CLK gf180mcu_as_sc_mcu7t3v3__clkbuff_12
XFILLER_8_37 VDD VDD VSS VSS gf180mcu_as_sc_mcu7t3v3__fillcap_16
XFILLER_156_667 VDD VDD VSS VSS gf180mcu_as_sc_mcu7t3v3__fill_2
XFILLER_171_604 VDD VDD VSS VSS gf180mcu_as_sc_mcu7t3v3__fill_1
XFILLER_184_987 VDD VDD VSS VSS gf180mcu_as_sc_mcu7t3v3__fillcap_16
XFILLER_12_90 VDD VDD VSS VSS gf180mcu_as_sc_mcu7t3v3__fill_1
XFILLER_7_699 VDD VDD VSS VSS gf180mcu_as_sc_mcu7t3v3__fill_1
XTAP_TAPCELL_ROW_153_1160 VDD VSS gf180mcu_as_sc_mcu7t3v3__tap_2
XFILLER_174_1211 VDD VDD VSS VSS gf180mcu_as_sc_mcu7t3v3__fill_2
XPHY_EDGE_ROW_186_Left_378 VDD VSS gf180mcu_as_sc_mcu7t3v3__tap_2
XFILLER_170_169 VDD VDD VSS VSS gf180mcu_as_sc_mcu7t3v3__fillcap_4
XFILLER_3_850 VDD VDD VSS VSS gf180mcu_as_sc_mcu7t3v3__fillcap_4
XFILLER_87_1296 VDD VDD VSS VSS gf180mcu_as_sc_mcu7t3v3__fill_1
XFILLER_174_1277 VDD VDD VSS VSS gf180mcu_as_sc_mcu7t3v3__fill_2
X_2250_ VDD VDD VSS VSS _4576_/Q _4575_/Q _2254_/C gf180mcu_as_sc_mcu7t3v3__and2_2
XFILLER_19_4 VDD VDD VSS VSS gf180mcu_as_sc_mcu7t3v3__fill_1
X_2181_ VDD VDD VSS VSS _3071_/A _4453_/Q gf180mcu_as_sc_mcu7t3v3__inv_2
XFILLER_24_1291 VDD VDD VSS VSS gf180mcu_as_sc_mcu7t3v3__fillcap_8
XFILLER_181_1204 VDD VDD VSS VSS gf180mcu_as_sc_mcu7t3v3__fill_2
XFILLER_107_1308 VDD VDD VSS VSS gf180mcu_as_sc_mcu7t3v3__fill_2
XFILLER_178_236 VDD VDD VSS VSS gf180mcu_as_sc_mcu7t3v3__fillcap_8
XFILLER_178_247 VDD VDD VSS VSS gf180mcu_as_sc_mcu7t3v3__fillcap_16
XFILLER_181_1248 VDD VDD VSS VSS gf180mcu_as_sc_mcu7t3v3__fillcap_8
X_4822_ VDD VDD VSS VSS _4830_/CLK _4822_/D _4822_/Q gf180mcu_as_sc_mcu7t3v3__dfxtp_2
X_4753_ VDD VDD VSS VSS clkload3/A _4753_/D _4753_/Q gf180mcu_as_sc_mcu7t3v3__dfxtp_2
X_3704_ VDD VDD VSS VSS _3929_/B _4064_/A _3710_/C gf180mcu_as_sc_mcu7t3v3__and2_2
XTAP_TAPCELL_ROW_173_1536 VDD VSS gf180mcu_as_sc_mcu7t3v3__tap_2
XTAP_TAPCELL_ROW_173_1525 VDD VSS gf180mcu_as_sc_mcu7t3v3__tap_2
XFILLER_174_453 VDD VDD VSS VSS gf180mcu_as_sc_mcu7t3v3__fill_2
XFILLER_175_976 VDD VDD VSS VSS gf180mcu_as_sc_mcu7t3v3__fillcap_4
XFILLER_179_1122 VDD VDD VSS VSS gf180mcu_as_sc_mcu7t3v3__fillcap_16
X_4684_ VDD VDD VSS VSS clkload4/A _4684_/D _4684_/Q gf180mcu_as_sc_mcu7t3v3__dfxtp_2
XFILLER_161_103 VDD VDD VSS VSS gf180mcu_as_sc_mcu7t3v3__fillcap_4
X_3635_ VDD VDD VSS VSS _3635_/Y _3960_/C _3635_/A gf180mcu_as_sc_mcu7t3v3__nor2b_2
XTAP_TAPCELL_ROW_190_1861 VDD VSS gf180mcu_as_sc_mcu7t3v3__tap_2
XTAP_TAPCELL_ROW_190_1850 VDD VSS gf180mcu_as_sc_mcu7t3v3__tap_2
X_3566_ VDD VDD VSS VSS _3567_/C _3566_/B _4624_/Q gf180mcu_as_sc_mcu7t3v3__nor2_2
XFILLER_192_1344 VDD VDD VSS VSS gf180mcu_as_sc_mcu7t3v3__fillcap_8
X_3497_ VDD VDD VSS VSS _4599_/D _4599_/Q _3503_/B _3497_/C gf180mcu_as_sc_mcu7t3v3__ao21_2
X_2517_ VDD VDD VSS VSS _3218_/A _2523_/C _2523_/B _3513_/A gf180mcu_as_sc_mcu7t3v3__aoi21_2
Xinput209 VDD VDD VSS VSS se_in[28] _4237_/A gf180mcu_as_sc_mcu7t3v3__buff_12
X_2448_ VDD VDD VSS VSS _4537_/Q _3068_/S _3061_/S _4513_/Q _2449_/B gf180mcu_as_sc_mcu7t3v3__ao22_2
XFILLER_124_37 VDD VDD VSS VSS gf180mcu_as_sc_mcu7t3v3__fillcap_4
XPHY_EDGE_ROW_150_3_Right_191 VDD VSS gf180mcu_as_sc_mcu7t3v3__tap_2
X_2379_ VDD VDD VSS VSS _2487_/S _2381_/B _4617_/Q _2380_/B gf180mcu_as_sc_mcu7t3v3__mux2_2
X_4118_ VDD VDD VSS VSS _4118_/A _4118_/B _4118_/C _4151_/A _4119_/B gf180mcu_as_sc_mcu7t3v3__ao22_2
X_4049_ VDD VDD VSS VSS _4050_/B _4049_/A _4136_/C _4049_/C gf180mcu_as_sc_mcu7t3v3__ao21_2
XFILLER_169_258 VDD VDD VSS VSS gf180mcu_as_sc_mcu7t3v3__fillcap_8
XFILLER_185_718 VDD VDD VSS VSS gf180mcu_as_sc_mcu7t3v3__fillcap_16
XFILLER_8_419 VDD VDD VSS VSS gf180mcu_as_sc_mcu7t3v3__fill_1
XFILLER_149_67 VDD VDD VSS VSS gf180mcu_as_sc_mcu7t3v3__fill_2
XFILLER_162_1181 VDD VDD VSS VSS gf180mcu_as_sc_mcu7t3v3__fill_2
XFILLER_165_22 VDD VDD VSS VSS gf180mcu_as_sc_mcu7t3v3__fillcap_8
XFILLER_165_66 VDD VDD VSS VSS gf180mcu_as_sc_mcu7t3v3__fillcap_4
XFILLER_58_31 VDD VDD VSS VSS gf180mcu_as_sc_mcu7t3v3__fillcap_4
XFILLER_0_875 VDD VDD VSS VSS gf180mcu_as_sc_mcu7t3v3__fill_2
XFILLER_58_53 VDD VDD VSS VSS gf180mcu_as_sc_mcu7t3v3__fillcap_8
XFILLER_134_1272 VDD VDD VSS VSS gf180mcu_as_sc_mcu7t3v3__fillcap_16
XFILLER_181_54 VDD VDD VSS VSS gf180mcu_as_sc_mcu7t3v3__fill_2
XFILLER_169_1302 VDD VDD VSS VSS gf180mcu_as_sc_mcu7t3v3__fillcap_4
XFILLER_169_1324 VDD VDD VSS VSS gf180mcu_as_sc_mcu7t3v3__fillcap_4
XFILLER_130_80 VDD VDD VSS VSS gf180mcu_as_sc_mcu7t3v3__fill_2
XFILLER_176_707 VDD VDD VSS VSS gf180mcu_as_sc_mcu7t3v3__fill_1
XFILLER_157_932 VDD VDD VSS VSS gf180mcu_as_sc_mcu7t3v3__fill_1
XTAP_TAPCELL_ROW_155_1200 VDD VSS gf180mcu_as_sc_mcu7t3v3__tap_2
XFILLER_8_942 VDD VDD VSS VSS gf180mcu_as_sc_mcu7t3v3__fill_2
XFILLER_172_935 VDD VDD VSS VSS gf180mcu_as_sc_mcu7t3v3__fillcap_8
XFILLER_7_496 VDD VDD VSS VSS gf180mcu_as_sc_mcu7t3v3__fill_2
X_3420_ VDD VDD VSS VSS _4549_/Q _3445_/B _3449_/B _4548_/Q _4548_/D gf180mcu_as_sc_mcu7t3v3__ao22_2
X_3351_ VDD VDD VSS VSS _3354_/C _4435_/Q _3351_/A gf180mcu_as_sc_mcu7t3v3__nand2_2
X_2302_ VDD VDD VSS VSS _4640_/Q _4811_/Q _2307_/B _3527_/A _2308_/A gf180mcu_as_sc_mcu7t3v3__nand4_2
X_3282_ VDD VDD VSS VSS _3314_/A _3282_/B _3282_/C _3284_/B _3282_/D gf180mcu_as_sc_mcu7t3v3__aoi31_2
X_2233_ VDD VDD VSS VSS _3530_/D _2234_/B _3086_/A gf180mcu_as_sc_mcu7t3v3__nor2_2
XTAP_TAPCELL_ROW_166_1395 VDD VSS gf180mcu_as_sc_mcu7t3v3__tap_2
XFILLER_0_1013 VDD VDD VSS VSS gf180mcu_as_sc_mcu7t3v3__fillcap_4
X_4733__1039 VDD VDD VSS VSS _4733_/D gf180mcu_as_sc_mcu7t3v3__tiel_4
XTAP_TAPCELL_ROW_37_1_990 VDD VSS gf180mcu_as_sc_mcu7t3v3__tap_2
XFILLER_179_545 VDD VDD VSS VSS gf180mcu_as_sc_mcu7t3v3__fill_1
XFILLER_181_1034 VDD VDD VSS VSS gf180mcu_as_sc_mcu7t3v3__fillcap_16
XFILLER_185_1192 VDD VDD VSS VSS gf180mcu_as_sc_mcu7t3v3__fillcap_8
XFILLER_181_1056 VDD VDD VSS VSS gf180mcu_as_sc_mcu7t3v3__fill_1
XFILLER_181_1067 VDD VDD VSS VSS gf180mcu_as_sc_mcu7t3v3__fillcap_8
X_4805_ VDD VDD VSS VSS _4809_/CLK _4805_/D _4805_/Q gf180mcu_as_sc_mcu7t3v3__dfxtp_2
X_2997_ VDD VDD VSS VSS _2997_/A _3004_/B _3004_/C _4409_/Q _4409_/D gf180mcu_as_sc_mcu7t3v3__ao22_2
XTAP_TAPCELL_ROW_192_1923 VDD VSS gf180mcu_as_sc_mcu7t3v3__tap_2
XTAP_TAPCELL_ROW_192_1912 VDD VSS gf180mcu_as_sc_mcu7t3v3__tap_2
XTAP_TAPCELL_ROW_192_1901 VDD VSS gf180mcu_as_sc_mcu7t3v3__tap_2
XFILLER_181_209 VDD VDD VSS VSS gf180mcu_as_sc_mcu7t3v3__fill_1
X_4736_ VDD VDD VSS VSS _4751_/CLK _4736_/D _4736_/Q gf180mcu_as_sc_mcu7t3v3__dfxtp_2
X_4667_ VDD VDD VSS VSS clkload5/A _4667_/D _4667_/Q gf180mcu_as_sc_mcu7t3v3__dfxtp_2
XFILLER_163_979 VDD VDD VSS VSS gf180mcu_as_sc_mcu7t3v3__fill_1
X_3618_ VDD VDD VSS VSS _3868_/B _3964_/B _3618_/A gf180mcu_as_sc_mcu7t3v3__nand2b_2
XFILLER_192_1130 VDD VDD VSS VSS gf180mcu_as_sc_mcu7t3v3__fill_1
X_4598_ VDD VDD VSS VSS _4602_/CLK _4598_/D _4598_/Q gf180mcu_as_sc_mcu7t3v3__dfxtp_2
X_3549_ VDD VDD VSS VSS _4619_/Q _3554_/B _3553_/C _4618_/Q _3550_/C gf180mcu_as_sc_mcu7t3v3__ao22_2
XFILLER_0_138 VDD VDD VSS VSS gf180mcu_as_sc_mcu7t3v3__fillcap_4
XFILLER_118_1256 VDD VDD VSS VSS gf180mcu_as_sc_mcu7t3v3__fillcap_8
XFILLER_135_69 VDD VDD VSS VSS gf180mcu_as_sc_mcu7t3v3__fill_1
XFILLER_192_1185 VDD VDD VSS VSS gf180mcu_as_sc_mcu7t3v3__fill_1
XFILLER_95_29 VDD VDD VSS VSS gf180mcu_as_sc_mcu7t3v3__fillcap_4
XPHY_EDGE_ROW_69_1_Left_261 VDD VSS gf180mcu_as_sc_mcu7t3v3__tap_2
XPHY_EDGE_ROW_151_3_Right_192 VDD VSS gf180mcu_as_sc_mcu7t3v3__tap_2
XFILLER_28_34 VDD VDD VSS VSS gf180mcu_as_sc_mcu7t3v3__fill_1
XPHY_EDGE_ROW_24_3_Right_65 VDD VSS gf180mcu_as_sc_mcu7t3v3__tap_2
XFILLER_164_1221 VDD VDD VSS VSS gf180mcu_as_sc_mcu7t3v3__fillcap_4
XTAP_TAPCELL_ROW_84_1_1037 VDD VSS gf180mcu_as_sc_mcu7t3v3__tap_2
XTAP_TAPCELL_ROW_0_683 VDD VSS gf180mcu_as_sc_mcu7t3v3__tap_2
XTAP_TAPCELL_ROW_0_672 VDD VSS gf180mcu_as_sc_mcu7t3v3__tap_2
XFILLER_164_1243 VDD VDD VSS VSS gf180mcu_as_sc_mcu7t3v3__fillcap_16
XTAP_TAPCELL_ROW_0_694 VDD VSS gf180mcu_as_sc_mcu7t3v3__tap_2
XFILLER_158_729 VDD VDD VSS VSS gf180mcu_as_sc_mcu7t3v3__fillcap_4
XFILLER_157_228 VDD VDD VSS VSS gf180mcu_as_sc_mcu7t3v3__fillcap_16
XFILLER_185_537 VDD VDD VSS VSS gf180mcu_as_sc_mcu7t3v3__fillcap_16
XTAP_TAPCELL_ROW_11_903 VDD VSS gf180mcu_as_sc_mcu7t3v3__tap_2
XFILLER_185_559 VDD VDD VSS VSS gf180mcu_as_sc_mcu7t3v3__fill_1
XFILLER_153_412 VDD VDD VSS VSS gf180mcu_as_sc_mcu7t3v3__fillcap_8
XFILLER_5_912 VDD VDD VSS VSS gf180mcu_as_sc_mcu7t3v3__fillcap_16
XFILLER_153_489 VDD VDD VSS VSS gf180mcu_as_sc_mcu7t3v3__fill_1
XFILLER_181_776 VDD VDD VSS VSS gf180mcu_as_sc_mcu7t3v3__fill_2
XPHY_EDGE_ROW_141_3_Left_513 VDD VSS gf180mcu_as_sc_mcu7t3v3__tap_2
XFILLER_162_990 VDD VDD VSS VSS gf180mcu_as_sc_mcu7t3v3__fillcap_16
XFILLER_69_63 VDD VDD VSS VSS gf180mcu_as_sc_mcu7t3v3__fillcap_4
XFILLER_84_1299 VDD VDD VSS VSS gf180mcu_as_sc_mcu7t3v3__fillcap_4
XFILLER_171_1258 VDD VDD VSS VSS gf180mcu_as_sc_mcu7t3v3__fill_2
XFILLER_125_91 VDD VDD VSS VSS gf180mcu_as_sc_mcu7t3v3__fill_1
Xclkbuf_leaf_33_clk_regs VDD VDD VSS VSS clkbuf_3_4__f_clk_regs/Y _4692_/CLK gf180mcu_as_sc_mcu7t3v3__clkbuff_12
XFILLER_169_1154 VDD VDD VSS VSS gf180mcu_as_sc_mcu7t3v3__fillcap_16
XFILLER_56_1324 VDD VDD VSS VSS gf180mcu_as_sc_mcu7t3v3__fillcap_4
X_2920_ VDD VDD VSS VSS _4360_/Q _2920_/B _3006_/A _2920_/D _4360_/D gf180mcu_as_sc_mcu7t3v3__ao22_2
XFILLER_182_1354 VDD VDD VSS VSS gf180mcu_as_sc_mcu7t3v3__fill_1
X_2851_ VDD VDD VSS VSS _4169_/D _2896_/B _2851_/C _2896_/D _2853_/C gf180mcu_as_sc_mcu7t3v3__ao211_2
XFILLER_176_559 VDD VDD VSS VSS gf180mcu_as_sc_mcu7t3v3__fill_1
X_2782_ VDD VDD VSS VSS _2915_/C _4108_/A _2784_/C gf180mcu_as_sc_mcu7t3v3__and2_2
X_4521_ VDD VDD VSS VSS clkload9/A _4521_/D _4521_/Q gf180mcu_as_sc_mcu7t3v3__dfxtp_2
XFILLER_172_732 VDD VDD VSS VSS gf180mcu_as_sc_mcu7t3v3__fill_2
X_4452_ VDD VDD VSS VSS _4809_/CLK _4452_/D _4452_/Q gf180mcu_as_sc_mcu7t3v3__dfxtp_2
XPHY_EDGE_ROW_73_3_Left_445 VDD VSS gf180mcu_as_sc_mcu7t3v3__tap_2
X_3403_ VDD VDD VSS VSS _4541_/Q _3411_/B _3403_/C _4542_/Q _3404_/C gf180mcu_as_sc_mcu7t3v3__ao22_2
X_4383_ VDD VDD VSS VSS _4445_/CLK _4383_/D _4383_/Q gf180mcu_as_sc_mcu7t3v3__dfxtp_2
Xfanout718 VDD VDD VSS VSS _4830_/Q _2487_/S gf180mcu_as_sc_mcu7t3v3__buff_12
Xfanout729 VDD VDD VSS VSS _4577_/Q _3454_/A gf180mcu_as_sc_mcu7t3v3__buff_12
X_3334_ VDD VDD VSS VSS _3338_/B _4346_/Q _3336_/S gf180mcu_as_sc_mcu7t3v3__nand2b_2
XTAP_TAPCELL_ROW_168_1435 VDD VSS gf180mcu_as_sc_mcu7t3v3__tap_2
X_3265_ VDD VDD VSS VSS _3266_/D _3265_/B _3314_/A gf180mcu_as_sc_mcu7t3v3__nor2_2
XTAP_TAPCELL_ROW_168_1446 VDD VSS gf180mcu_as_sc_mcu7t3v3__tap_2
X_2216_ VDD VDD VSS VSS _3161_/B _4481_/Q gf180mcu_as_sc_mcu7t3v3__inv_2
XTAP_TAPCELL_ROW_185_1760 VDD VSS gf180mcu_as_sc_mcu7t3v3__tap_2
X_3196_ VDD VDD VSS VSS _3409_/A _3196_/B _3196_/C _3197_/D _3196_/D gf180mcu_as_sc_mcu7t3v3__aoi31_2
XTAP_TAPCELL_ROW_181_1679 VDD VSS gf180mcu_as_sc_mcu7t3v3__tap_2
XFILLER_121_38 VDD VDD VSS VSS gf180mcu_as_sc_mcu7t3v3__fillcap_4
XFILLER_183_1118 VDD VDD VSS VSS gf180mcu_as_sc_mcu7t3v3__fill_2
XTAP_TAPCELL_ROW_145_1_1098 VDD VSS gf180mcu_as_sc_mcu7t3v3__tap_2
XFILLER_124_1293 VDD VDD VSS VSS gf180mcu_as_sc_mcu7t3v3__fill_1
X_4719_ VDD VDD VSS VSS _4719_/CLK _4719_/D _4719_/Q gf180mcu_as_sc_mcu7t3v3__dfxtp_2
XFILLER_2_904 VDD VDD VSS VSS gf180mcu_as_sc_mcu7t3v3__fillcap_8
XFILLER_30_79 VDD VDD VSS VSS gf180mcu_as_sc_mcu7t3v3__fillcap_8
XFILLER_1_436 VDD VDD VSS VSS gf180mcu_as_sc_mcu7t3v3__fill_2
XFILLER_162_34 VDD VDD VSS VSS gf180mcu_as_sc_mcu7t3v3__fill_1
XFILLER_170_1291 VDD VDD VSS VSS gf180mcu_as_sc_mcu7t3v3__fillcap_4
XTAP_TAPCELL_ROW_5_786 VDD VSS gf180mcu_as_sc_mcu7t3v3__tap_2
XFILLER_166_1338 VDD VDD VSS VSS gf180mcu_as_sc_mcu7t3v3__fillcap_8
XFILLER_55_54 VDD VDD VSS VSS gf180mcu_as_sc_mcu7t3v3__fillcap_4
XFILLER_158_537 VDD VDD VSS VSS gf180mcu_as_sc_mcu7t3v3__fill_1
XFILLER_185_367 VDD VDD VSS VSS gf180mcu_as_sc_mcu7t3v3__fillcap_4
XFILLER_187_42 VDD VDD VSS VSS gf180mcu_as_sc_mcu7t3v3__fillcap_4
XFILLER_154_743 VDD VDD VSS VSS gf180mcu_as_sc_mcu7t3v3__fill_1
XFILLER_5_720 VDD VDD VSS VSS gf180mcu_as_sc_mcu7t3v3__fill_1
XFILLER_181_562 VDD VDD VSS VSS gf180mcu_as_sc_mcu7t3v3__fillcap_8
XFILLER_5_786 VDD VDD VSS VSS gf180mcu_as_sc_mcu7t3v3__fill_1
XTAP_TAPCELL_ROW_60_3_1971 VDD VSS gf180mcu_as_sc_mcu7t3v3__tap_2
X_3050_ VDD VDD VSS VSS _3054_/B _3604_/A _4451_/D gf180mcu_as_sc_mcu7t3v3__and2_2
XFILLER_110_1315 VDD VDD VSS VSS gf180mcu_as_sc_mcu7t3v3__fillcap_4
XFILLER_110_1348 VDD VDD VSS VSS gf180mcu_as_sc_mcu7t3v3__fillcap_4
XTAP_TAPCELL_ROW_163_1343 VDD VSS gf180mcu_as_sc_mcu7t3v3__tap_2
XFILLER_50_104 VDD VDD VSS VSS gf180mcu_as_sc_mcu7t3v3__fill_1
X_3952_ VDD VDD VSS VSS _4802_/Q _4804_/Q _3952_/C _3963_/D _3953_/D gf180mcu_as_sc_mcu7t3v3__ao22_2
XFILLER_147_1293 VDD VDD VSS VSS gf180mcu_as_sc_mcu7t3v3__fill_2
X_3883_ VDD VDD VSS VSS _3883_/S _3883_/B _4221_/A _3884_/B gf180mcu_as_sc_mcu7t3v3__mux2_2
X_2903_ VDD VDD VSS VSS _4218_/A _2903_/B _2903_/C _2903_/D _2904_/C gf180mcu_as_sc_mcu7t3v3__ao211_2
XFILLER_91_2 VDD VDD VSS VSS gf180mcu_as_sc_mcu7t3v3__fill_2
XFILLER_108_1288 VDD VDD VSS VSS gf180mcu_as_sc_mcu7t3v3__fill_1
XFILLER_108_1299 VDD VDD VSS VSS gf180mcu_as_sc_mcu7t3v3__fillcap_4
X_2834_ VDD VDD VSS VSS _4154_/B _2896_/D _2834_/C _2834_/D _2835_/B gf180mcu_as_sc_mcu7t3v3__ao211_2
XFILLER_176_378 VDD VDD VSS VSS gf180mcu_as_sc_mcu7t3v3__fillcap_4
XFILLER_192_849 VDD VDD VSS VSS gf180mcu_as_sc_mcu7t3v3__fill_1
X_4504_ VDD VDD VSS VSS _4720_/CLK _4504_/D _4504_/Q gf180mcu_as_sc_mcu7t3v3__dfxtp_2
X_2765_ VDD VDD VSS VSS _4093_/D _2829_/B _2765_/C _2765_/D _2766_/C gf180mcu_as_sc_mcu7t3v3__ao211_2
XFILLER_160_702 VDD VDD VSS VSS gf180mcu_as_sc_mcu7t3v3__fillcap_16
X_2696_ VDD VDD VSS VSS _4032_/A _2904_/B _2696_/C _2900_/B _2698_/C gf180mcu_as_sc_mcu7t3v3__ao211_2
XFILLER_172_584 VDD VDD VSS VSS gf180mcu_as_sc_mcu7t3v3__fillcap_8
X_4435_ VDD VDD VSS VSS _4445_/CLK _4435_/D _4435_/Q gf180mcu_as_sc_mcu7t3v3__dfxtp_2
XFILLER_154_1231 VDD VDD VSS VSS gf180mcu_as_sc_mcu7t3v3__fillcap_16
XFILLER_67_1272 VDD VDD VSS VSS gf180mcu_as_sc_mcu7t3v3__fillcap_16
Xfanout504 VDD VDD VSS VSS _2898_/B _2871_/B gf180mcu_as_sc_mcu7t3v3__buff_12
Xfanout515 VDD VDD VSS VSS _2974_/A _2966_/A gf180mcu_as_sc_mcu7t3v3__buff_12
X_4366_ VDD VDD VSS VSS _4783_/CLK _4366_/D _4366_/Q gf180mcu_as_sc_mcu7t3v3__dfxtp_2
XTAP_TAPCELL_ROW_187_1800 VDD VSS gf180mcu_as_sc_mcu7t3v3__tap_2
Xfanout526 VDD VDD VSS VSS fanout527/Y _4186_/B gf180mcu_as_sc_mcu7t3v3__buff_12
Xfanout537 VDD VDD VSS VSS _3871_/B _3799_/B gf180mcu_as_sc_mcu7t3v3__buff_12
Xfanout548 VDD VDD VSS VSS _2896_/B _2823_/B gf180mcu_as_sc_mcu7t3v3__buff_12
X_3317_ VDD VDD VSS VSS _3389_/B _4466_/Q _3324_/D gf180mcu_as_sc_mcu7t3v3__and2_2
XFILLER_154_1297 VDD VDD VSS VSS gf180mcu_as_sc_mcu7t3v3__fillcap_16
Xfanout559 VDD VDD VSS VSS _4326_/B _4318_/B gf180mcu_as_sc_mcu7t3v3__buff_12
X_4297_ VDD VDD VSS VSS _4310_/B _4521_/Q _4774_/D gf180mcu_as_sc_mcu7t3v3__and2_2
XTAP_TAPCELL_ROW_183_1719 VDD VSS gf180mcu_as_sc_mcu7t3v3__tap_2
Xmesh_tile_963 VDD VDD VSS VSS se_out[27] gf180mcu_as_sc_mcu7t3v3__tiel_4
Xmesh_tile_952 VDD VDD VSS VSS se_out[16] gf180mcu_as_sc_mcu7t3v3__tiel_4
Xmesh_tile_941 VDD VDD VSS VSS se_out[5] gf180mcu_as_sc_mcu7t3v3__tiel_4
Xmesh_tile_930 VDD VDD VSS VSS nw_out[30] gf180mcu_as_sc_mcu7t3v3__tiel_4
X_3248_ VDD VDD VSS VSS _3328_/S _4364_/Q _4393_/Q _3249_/B gf180mcu_as_sc_mcu7t3v3__mux2_2
XTAP_TAPCELL_ROW_2_723 VDD VSS gf180mcu_as_sc_mcu7t3v3__tap_2
Xmesh_tile_996 VDD VDD VSS VSS sw_out[24] gf180mcu_as_sc_mcu7t3v3__tiel_4
Xmesh_tile_985 VDD VDD VSS VSS sw_out[13] gf180mcu_as_sc_mcu7t3v3__tiel_4
Xmesh_tile_974 VDD VDD VSS VSS sw_out[2] gf180mcu_as_sc_mcu7t3v3__tiel_4
X_3179_ VDD VDD VSS VSS _3201_/S _3199_/A _3180_/C gf180mcu_as_sc_mcu7t3v3__and2_2
XTAP_TAPCELL_ROW_2_734 VDD VSS gf180mcu_as_sc_mcu7t3v3__tap_2
XFILLER_168_802 VDD VDD VSS VSS gf180mcu_as_sc_mcu7t3v3__fill_2
XFILLER_25_57 VDD VDD VSS VSS gf180mcu_as_sc_mcu7t3v3__fill_2
XFILLER_41_34 VDD VDD VSS VSS gf180mcu_as_sc_mcu7t3v3__fillcap_16
XTAP_TAPCELL_ROW_79_1_1032 VDD VSS gf180mcu_as_sc_mcu7t3v3__tap_2
XFILLER_183_849 VDD VDD VSS VSS gf180mcu_as_sc_mcu7t3v3__fillcap_4
X_4807__1048 VDD VDD VSS VSS _4807_/RN gf180mcu_as_sc_mcu7t3v3__tieh_4
XFILLER_157_67 VDD VDD VSS VSS gf180mcu_as_sc_mcu7t3v3__fill_2
XFILLER_159_1131 VDD VDD VSS VSS gf180mcu_as_sc_mcu7t3v3__fill_2
XFILLER_163_551 VDD VDD VSS VSS gf180mcu_as_sc_mcu7t3v3__fillcap_8
XFILLER_163_562 VDD VDD VSS VSS gf180mcu_as_sc_mcu7t3v3__fillcap_4
XFILLER_155_1006 VDD VDD VSS VSS gf180mcu_as_sc_mcu7t3v3__fillcap_8
XTAP_TAPCELL_ROW_16_1_969 VDD VSS gf180mcu_as_sc_mcu7t3v3__tap_2
XFILLER_155_1028 VDD VDD VSS VSS gf180mcu_as_sc_mcu7t3v3__fill_1
XFILLER_173_22 VDD VDD VSS VSS gf180mcu_as_sc_mcu7t3v3__fillcap_4
XFILLER_2_734 VDD VDD VSS VSS gf180mcu_as_sc_mcu7t3v3__fill_1
XFILLER_172_1353 VDD VDD VSS VSS gf180mcu_as_sc_mcu7t3v3__fill_2
XFILLER_1_266 VDD VDD VSS VSS gf180mcu_as_sc_mcu7t3v3__fill_2
XFILLER_133_1326 VDD VDD VSS VSS gf180mcu_as_sc_mcu7t3v3__fill_2
XFILLER_166_1157 VDD VDD VSS VSS gf180mcu_as_sc_mcu7t3v3__fillcap_8
XFILLER_159_824 VDD VDD VSS VSS gf180mcu_as_sc_mcu7t3v3__fillcap_16
XFILLER_13_373 VDD VDD VSS VSS gf180mcu_as_sc_mcu7t3v3__fill_1
XFILLER_185_142 VDD VDD VSS VSS gf180mcu_as_sc_mcu7t3v3__fillcap_16
XPHY_EDGE_ROW_21_1_Left_213 VDD VSS gf180mcu_as_sc_mcu7t3v3__tap_2
XFILLER_12_1079 VDD VDD VSS VSS gf180mcu_as_sc_mcu7t3v3__fillcap_4
XFILLER_154_562 VDD VDD VSS VSS gf180mcu_as_sc_mcu7t3v3__fill_1
X_2550_ VDD VDD VSS VSS _3555_/B _2550_/A _4480_/Q _2550_/C _2551_/C gf180mcu_as_sc_mcu7t3v3__ao31_2
XFILLER_182_893 VDD VDD VSS VSS gf180mcu_as_sc_mcu7t3v3__fill_2
X_2481_ VDD VDD VSS VSS _2481_/A _4827_/Q _2481_/C _2481_/D _2486_/A gf180mcu_as_sc_mcu7t3v3__ao211_2
XFILLER_181_392 VDD VDD VSS VSS gf180mcu_as_sc_mcu7t3v3__fillcap_8
X_4220_ VDD VDD VSS VSS _4220_/A _4228_/B _4220_/C _4220_/D _4221_/B gf180mcu_as_sc_mcu7t3v3__ao211_2
X_4151_ VDD VDD VSS VSS _4151_/B _4151_/A _4152_/D gf180mcu_as_sc_mcu7t3v3__and2_2
X_4082_ VDD VDD VSS VSS _4122_/D _4163_/S _4082_/B _4082_/C _4083_/C gf180mcu_as_sc_mcu7t3v3__ao31_2
X_3102_ VDD VDD VSS VSS _3120_/S _4490_/Q _4489_/Q _4489_/D gf180mcu_as_sc_mcu7t3v3__mux2_2
X_3033_ VDD VDD VSS VSS _3033_/A _3034_/B _3038_/C _4443_/Q _4443_/D gf180mcu_as_sc_mcu7t3v3__ao22_2
XFILLER_149_1322 VDD VDD VSS VSS gf180mcu_as_sc_mcu7t3v3__fill_2
XFILLER_3_1258 VDD VDD VSS VSS gf180mcu_as_sc_mcu7t3v3__fill_2
XFILLER_184_1257 VDD VDD VSS VSS gf180mcu_as_sc_mcu7t3v3__fill_1
X_3935_ VDD VDD VSS VSS _3960_/B _3935_/A _3936_/D gf180mcu_as_sc_mcu7t3v3__and2_2
XFILLER_177_632 VDD VDD VSS VSS gf180mcu_as_sc_mcu7t3v3__fill_2
XFILLER_176_142 VDD VDD VSS VSS gf180mcu_as_sc_mcu7t3v3__fill_2
X_3866_ VDD VDD VSS VSS _3866_/B _4207_/D _3867_/C gf180mcu_as_sc_mcu7t3v3__and2_2
XFILLER_178_1017 VDD VDD VSS VSS gf180mcu_as_sc_mcu7t3v3__fillcap_16
X_3797_ VDD VDD VSS VSS _4789_/Q _3806_/B _3797_/C _3797_/D _3798_/C gf180mcu_as_sc_mcu7t3v3__ao22_2
X_2817_ VDD VDD VSS VSS _4348_/Q _2906_/B _2994_/A _2906_/D _4348_/D gf180mcu_as_sc_mcu7t3v3__ao22_2
XTAP_TAPCELL_ROW_176_1589 VDD VSS gf180mcu_as_sc_mcu7t3v3__tap_2
XPHY_EDGE_ROW_78_1_Left_270 VDD VSS gf180mcu_as_sc_mcu7t3v3__tap_2
XFILLER_192_679 VDD VDD VSS VSS gf180mcu_as_sc_mcu7t3v3__fill_1
X_2748_ VDD VDD VSS VSS _4076_/D _2828_/C _2748_/C _2748_/D _2750_/C gf180mcu_as_sc_mcu7t3v3__ao211_2
XPHY_EDGE_ROW_33_3_Right_74 VDD VSS gf180mcu_as_sc_mcu7t3v3__tap_2
XFILLER_156_1315 VDD VDD VSS VSS gf180mcu_as_sc_mcu7t3v3__fill_1
XFILLER_160_543 VDD VDD VSS VSS gf180mcu_as_sc_mcu7t3v3__fillcap_4
XFILLER_160_554 VDD VDD VSS VSS gf180mcu_as_sc_mcu7t3v3__fillcap_16
X_4418_ VDD VDD VSS VSS _4447_/CLK _4418_/D _4418_/Q gf180mcu_as_sc_mcu7t3v3__dfxtp_2
X_2679_ VDD VDD VSS VSS _2680_/D _4016_/A _2904_/B _2679_/C gf180mcu_as_sc_mcu7t3v3__ao21_2
XTAP_TAPCELL_ROW_7_815 VDD VSS gf180mcu_as_sc_mcu7t3v3__tap_2
XTAP_TAPCELL_ROW_7_826 VDD VSS gf180mcu_as_sc_mcu7t3v3__tap_2
XPHY_EDGE_ROW_36_3_Left_408 VDD VSS gf180mcu_as_sc_mcu7t3v3__tap_2
XFILLER_143_25 VDD VDD VSS VSS gf180mcu_as_sc_mcu7t3v3__fill_1
XFILLER_143_36 VDD VDD VSS VSS gf180mcu_as_sc_mcu7t3v3__fill_2
X_4349_ VDD VDD VSS VSS _4795_/CLK _4349_/D _4349_/Q gf180mcu_as_sc_mcu7t3v3__dfxtp_2
XFILLER_80_1291 VDD VDD VSS VSS gf180mcu_as_sc_mcu7t3v3__fill_2
XFILLER_14_104 VDD VDD VSS VSS gf180mcu_as_sc_mcu7t3v3__fill_1
XTAP_TAPCELL_ROW_112_3_2023 VDD VSS gf180mcu_as_sc_mcu7t3v3__tap_2
XFILLER_187_407 VDD VDD VSS VSS gf180mcu_as_sc_mcu7t3v3__fill_2
XPHY_EDGE_ROW_150_3_Left_522 VDD VSS gf180mcu_as_sc_mcu7t3v3__tap_2
XFILLER_161_1010 VDD VDD VSS VSS gf180mcu_as_sc_mcu7t3v3__fill_2
XFILLER_52_33 VDD VDD VSS VSS gf180mcu_as_sc_mcu7t3v3__fill_2
XFILLER_11_822 VDD VDD VSS VSS gf180mcu_as_sc_mcu7t3v3__fill_2
XFILLER_168_22 VDD VDD VSS VSS gf180mcu_as_sc_mcu7t3v3__fillcap_8
XFILLER_167_142 VDD VDD VSS VSS gf180mcu_as_sc_mcu7t3v3__fillcap_16
XFILLER_168_66 VDD VDD VSS VSS gf180mcu_as_sc_mcu7t3v3__fillcap_8
X_4746__1026 VDD VDD VSS VSS _4746_/D gf180mcu_as_sc_mcu7t3v3__tiel_4
XFILLER_155_348 VDD VDD VSS VSS gf180mcu_as_sc_mcu7t3v3__fill_2
XFILLER_182_101 VDD VDD VSS VSS gf180mcu_as_sc_mcu7t3v3__fillcap_4
XFILLER_182_123 VDD VDD VSS VSS gf180mcu_as_sc_mcu7t3v3__fillcap_16
XFILLER_183_646 VDD VDD VSS VSS gf180mcu_as_sc_mcu7t3v3__fill_1
Xwire768 VDD VDD VSS VSS wire768/A _4126_/A gf180mcu_as_sc_mcu7t3v3__clkbuff_12
XFILLER_170_307 VDD VDD VSS VSS gf180mcu_as_sc_mcu7t3v3__fillcap_8
Xwire779 VDD VDD VSS VSS wire779/A _4084_/D gf180mcu_as_sc_mcu7t3v3__clkbuff_12
XFILLER_164_893 VDD VDD VSS VSS gf180mcu_as_sc_mcu7t3v3__fillcap_8
XFILLER_83_1309 VDD VDD VSS VSS gf180mcu_as_sc_mcu7t3v3__fill_1
XFILLER_184_98 VDD VDD VSS VSS gf180mcu_as_sc_mcu7t3v3__fillcap_4
XFILLER_2_597 VDD VDD VSS VSS gf180mcu_as_sc_mcu7t3v3__fill_2
XFILLER_77_74 VDD VDD VSS VSS gf180mcu_as_sc_mcu7t3v3__fill_1
XFILLER_77_96 VDD VDD VSS VSS gf180mcu_as_sc_mcu7t3v3__fillcap_8
XFILLER_168_1208 VDD VDD VSS VSS gf180mcu_as_sc_mcu7t3v3__fill_2
XPHY_EDGE_ROW_82_3_Left_454 VDD VSS gf180mcu_as_sc_mcu7t3v3__tap_2
XFILLER_159_632 VDD VDD VSS VSS gf180mcu_as_sc_mcu7t3v3__fillcap_4
X_3720_ VDD VDD VSS VSS _3747_/S _3720_/B _4074_/A _3721_/B gf180mcu_as_sc_mcu7t3v3__mux2_2
XFILLER_174_613 VDD VDD VSS VSS gf180mcu_as_sc_mcu7t3v3__fillcap_16
XTAP_TAPCELL_ROW_158_1253 VDD VSS gf180mcu_as_sc_mcu7t3v3__tap_2
XTAP_TAPCELL_ROW_158_1242 VDD VSS gf180mcu_as_sc_mcu7t3v3__tap_2
XFILLER_179_1326 VDD VDD VSS VSS gf180mcu_as_sc_mcu7t3v3__fillcap_4
X_3651_ VDD VDD VSS VSS _4015_/D _3876_/B _3651_/C _3876_/D _3654_/B gf180mcu_as_sc_mcu7t3v3__ao211_2
XTAP_TAPCELL_ROW_47_3_1958 VDD VSS gf180mcu_as_sc_mcu7t3v3__tap_2
XFILLER_179_1348 VDD VDD VSS VSS gf180mcu_as_sc_mcu7t3v3__fillcap_4
X_3582_ VDD VDD VSS VSS _3582_/A _3582_/B _3584_/B _4631_/Q _4631_/D gf180mcu_as_sc_mcu7t3v3__ao22_2
X_2602_ VDD VDD VSS VSS _2603_/C _3961_/A _3644_/B gf180mcu_as_sc_mcu7t3v3__or2_2
X_2533_ VDD VDD VSS VSS _2533_/B _3478_/A _3471_/C gf180mcu_as_sc_mcu7t3v3__and2_2
XFILLER_154_381 VDD VDD VSS VSS gf180mcu_as_sc_mcu7t3v3__fillcap_4
XFILLER_170_841 VDD VDD VSS VSS gf180mcu_as_sc_mcu7t3v3__fillcap_8
XTAP_TAPCELL_ROW_171_1497 VDD VSS gf180mcu_as_sc_mcu7t3v3__tap_2
XTAP_TAPCELL_ROW_171_1486 VDD VSS gf180mcu_as_sc_mcu7t3v3__tap_2
XFILLER_170_874 VDD VDD VSS VSS gf180mcu_as_sc_mcu7t3v3__fill_1
X_2464_ VDD VDD VSS VSS _4539_/Q _3068_/S _3061_/S _4515_/Q _2465_/B gf180mcu_as_sc_mcu7t3v3__ao22_2
X_4203_ VDD VDD VSS VSS _4203_/A _4236_/C _4203_/C _4203_/D _4205_/A gf180mcu_as_sc_mcu7t3v3__ao211_2
X_2395_ VDD VDD VSS VSS _2425_/B _4483_/Q _4547_/Q _2396_/B gf180mcu_as_sc_mcu7t3v3__mux2_2
XFILLER_190_1294 VDD VDD VSS VSS gf180mcu_as_sc_mcu7t3v3__fill_1
X_4134_ VDD VDD VSS VSS _4788_/Q _4134_/B _4217_/C _4134_/D _4135_/C gf180mcu_as_sc_mcu7t3v3__ao22_2
X_4065_ VDD VDD VSS VSS _4066_/C _4065_/C _4136_/C _4065_/A gf180mcu_as_sc_mcu7t3v3__aoi21_2
X_3016_ VDD VDD VSS VSS _3020_/S _4426_/Q _3016_/A _4426_/D gf180mcu_as_sc_mcu7t3v3__mux2_2
XFILLER_184_1076 VDD VDD VSS VSS gf180mcu_as_sc_mcu7t3v3__fillcap_8
XFILLER_184_1087 VDD VDD VSS VSS gf180mcu_as_sc_mcu7t3v3__fillcap_8
XTAP_TAPCELL_ROW_178_1629 VDD VSS gf180mcu_as_sc_mcu7t3v3__tap_2
XTAP_TAPCELL_ROW_15_1_968 VDD VSS gf180mcu_as_sc_mcu7t3v3__tap_2
Xsram2048.u_bank0_817 VDD VDD VSS VSS sram2048.u_bank0/WEN[4] gf180mcu_as_sc_mcu7t3v3__tiel_4
X_3918_ VDD VDD VSS VSS _3919_/B _4257_/A _3926_/B _3918_/C _3926_/D gf180mcu_as_sc_mcu7t3v3__aoi22_2
XFILLER_138_14 VDD VDD VSS VSS gf180mcu_as_sc_mcu7t3v3__fill_2
XFILLER_192_410 VDD VDD VSS VSS gf180mcu_as_sc_mcu7t3v3__fill_1
X_3849_ VDD VDD VSS VSS _3875_/B _4190_/A _3850_/C gf180mcu_as_sc_mcu7t3v3__and2_2
XFILLER_4_807 VDD VDD VSS VSS gf180mcu_as_sc_mcu7t3v3__fillcap_16
XFILLER_138_69 VDD VDD VSS VSS gf180mcu_as_sc_mcu7t3v3__fill_1
XFILLER_192_487 VDD VDD VSS VSS gf180mcu_as_sc_mcu7t3v3__fillcap_4
XFILLER_98_29 VDD VDD VSS VSS gf180mcu_as_sc_mcu7t3v3__fillcap_4
XFILLER_161_874 VDD VDD VSS VSS gf180mcu_as_sc_mcu7t3v3__fillcap_16
XFILLER_161_896 VDD VDD VSS VSS gf180mcu_as_sc_mcu7t3v3__fill_1
XFILLER_160_384 VDD VDD VSS VSS gf180mcu_as_sc_mcu7t3v3__fill_1
XFILLER_43_1326 VDD VDD VSS VSS gf180mcu_as_sc_mcu7t3v3__fill_2
XFILLER_170_34 VDD VDD VSS VSS gf180mcu_as_sc_mcu7t3v3__fill_1
XFILLER_170_56 VDD VDD VSS VSS gf180mcu_as_sc_mcu7t3v3__fillcap_16
XFILLER_103_72 VDD VDD VSS VSS gf180mcu_as_sc_mcu7t3v3__fillcap_16
XFILLER_63_54 VDD VDD VSS VSS gf180mcu_as_sc_mcu7t3v3__fillcap_16
XFILLER_179_65 VDD VDD VSS VSS gf180mcu_as_sc_mcu7t3v3__fillcap_4
XFILLER_169_974 VDD VDD VSS VSS gf180mcu_as_sc_mcu7t3v3__fillcap_4
XFILLER_184_955 VDD VDD VSS VSS gf180mcu_as_sc_mcu7t3v3__fillcap_16
XFILLER_104_1280 VDD VDD VSS VSS gf180mcu_as_sc_mcu7t3v3__fillcap_8
XFILLER_104_1291 VDD VDD VSS VSS gf180mcu_as_sc_mcu7t3v3__fillcap_4
XFILLER_12_80 VDD VDD VSS VSS gf180mcu_as_sc_mcu7t3v3__fillcap_8
XFILLER_13_1174 VDD VDD VSS VSS gf180mcu_as_sc_mcu7t3v3__fill_2
XFILLER_13_1185 VDD VDD VSS VSS gf180mcu_as_sc_mcu7t3v3__fillcap_4
XFILLER_6_177 VDD VDD VSS VSS gf180mcu_as_sc_mcu7t3v3__fillcap_4
XFILLER_7_689 VDD VDD VSS VSS gf180mcu_as_sc_mcu7t3v3__fillcap_8
XTAP_TAPCELL_ROW_153_1150 VDD VSS gf180mcu_as_sc_mcu7t3v3__tap_2
XFILLER_152_852 VDD VDD VSS VSS gf180mcu_as_sc_mcu7t3v3__fillcap_16
XFILLER_87_1264 VDD VDD VSS VSS gf180mcu_as_sc_mcu7t3v3__fillcap_4
XTAP_TAPCELL_ROW_153_1161 VDD VSS gf180mcu_as_sc_mcu7t3v3__tap_2
X_2180_ VDD VDD VSS VSS _2287_/A _4631_/Q gf180mcu_as_sc_mcu7t3v3__inv_2
XFILLER_0_1217 VDD VDD VSS VSS gf180mcu_as_sc_mcu7t3v3__fillcap_4
XFILLER_168_1049 VDD VDD VSS VSS gf180mcu_as_sc_mcu7t3v3__fillcap_16
XFILLER_185_1352 VDD VDD VSS VSS gf180mcu_as_sc_mcu7t3v3__fill_2
XFILLER_178_204 VDD VDD VSS VSS gf180mcu_as_sc_mcu7t3v3__fillcap_16
X_4821_ VDD VDD VSS VSS _4830_/CLK _4821_/D _4821_/Q gf180mcu_as_sc_mcu7t3v3__dfxtp_2
X_4752_ VDD VDD VSS VSS clkload3/A _4752_/D _4752_/Q gf180mcu_as_sc_mcu7t3v3__dfxtp_2
XFILLER_175_944 VDD VDD VSS VSS gf180mcu_as_sc_mcu7t3v3__fillcap_16
XFILLER_186_281 VDD VDD VSS VSS gf180mcu_as_sc_mcu7t3v3__fillcap_4
X_4683_ VDD VDD VSS VSS clkload4/A _4683_/D _4683_/Q gf180mcu_as_sc_mcu7t3v3__dfxtp_2
X_3703_ VDD VDD VSS VSS _3703_/B _3748_/A _4663_/D gf180mcu_as_sc_mcu7t3v3__and2_2
XTAP_TAPCELL_ROW_173_1526 VDD VSS gf180mcu_as_sc_mcu7t3v3__tap_2
XFILLER_175_988 VDD VDD VSS VSS gf180mcu_as_sc_mcu7t3v3__fill_1
X_3634_ VDD VDD VSS VSS _3634_/Y _3634_/B _3634_/A gf180mcu_as_sc_mcu7t3v3__nor2b_2
XTAP_TAPCELL_ROW_173_1537 VDD VSS gf180mcu_as_sc_mcu7t3v3__tap_2
XFILLER_31_1285 VDD VDD VSS VSS gf180mcu_as_sc_mcu7t3v3__fill_1
XTAP_TAPCELL_ROW_190_1862 VDD VSS gf180mcu_as_sc_mcu7t3v3__tap_2
XTAP_TAPCELL_ROW_190_1851 VDD VSS gf180mcu_as_sc_mcu7t3v3__tap_2
XFILLER_179_1189 VDD VDD VSS VSS gf180mcu_as_sc_mcu7t3v3__fill_1
X_3565_ VDD VDD VSS VSS _4623_/D _3565_/B _3566_/B gf180mcu_as_sc_mcu7t3v3__nor2_2
XFILLER_153_1307 VDD VDD VSS VSS gf180mcu_as_sc_mcu7t3v3__fillcap_16
XFILLER_161_159 VDD VDD VSS VSS gf180mcu_as_sc_mcu7t3v3__fillcap_4
X_3496_ VDD VDD VSS VSS _4469_/Q _3553_/B _3502_/C _4600_/Q _3497_/C gf180mcu_as_sc_mcu7t3v3__ao22_2
X_2516_ VDD VDD VSS VSS _2524_/C _3447_/A _3513_/A gf180mcu_as_sc_mcu7t3v3__nor2_2
X_2447_ VDD VDD VSS VSS _2487_/S _4814_/Q _4823_/Q _2450_/A gf180mcu_as_sc_mcu7t3v3__mux2_2
XPHY_EDGE_ROW_109_1_Left_301 VDD VSS gf180mcu_as_sc_mcu7t3v3__tap_2
X_2378_ VDD VDD VSS VSS _4583_/Q _4586_/Q _2381_/B gf180mcu_as_sc_mcu7t3v3__and2_2
X_4117_ VDD VDD VSS VSS _4786_/Q _4148_/B _4148_/C _4117_/D _4119_/A gf180mcu_as_sc_mcu7t3v3__ao22_2
X_4048_ VDD VDD VSS VSS _4048_/A _4136_/B _4048_/C _4048_/D _4049_/C gf180mcu_as_sc_mcu7t3v3__ao211_2
XFILLER_140_37 VDD VDD VSS VSS gf180mcu_as_sc_mcu7t3v3__fillcap_16
XFILLER_33_68 VDD VDD VSS VSS gf180mcu_as_sc_mcu7t3v3__fill_2
XFILLER_166_944 VDD VDD VSS VSS gf180mcu_as_sc_mcu7t3v3__fill_1
XFILLER_165_443 VDD VDD VSS VSS gf180mcu_as_sc_mcu7t3v3__fillcap_16
XFILLER_192_240 VDD VDD VSS VSS gf180mcu_as_sc_mcu7t3v3__fillcap_4
XFILLER_152_104 VDD VDD VSS VSS gf180mcu_as_sc_mcu7t3v3__fillcap_16
XFILLER_180_402 VDD VDD VSS VSS gf180mcu_as_sc_mcu7t3v3__fillcap_4
XFILLER_180_457 VDD VDD VSS VSS gf180mcu_as_sc_mcu7t3v3__fillcap_16
XFILLER_160_170 VDD VDD VSS VSS gf180mcu_as_sc_mcu7t3v3__fillcap_4
XPHY_EDGE_ROW_30_1_Left_222 VDD VSS gf180mcu_as_sc_mcu7t3v3__tap_2
XFILLER_188_513 VDD VDD VSS VSS gf180mcu_as_sc_mcu7t3v3__fillcap_8
XFILLER_130_92 VDD VDD VSS VSS gf180mcu_as_sc_mcu7t3v3__fillcap_8
XFILLER_169_760 VDD VDD VSS VSS gf180mcu_as_sc_mcu7t3v3__fillcap_8
XFILLER_90_41 VDD VDD VSS VSS gf180mcu_as_sc_mcu7t3v3__fillcap_8
XFILLER_128_101 VDD VDD VSS VSS gf180mcu_as_sc_mcu7t3v3__fillcap_4
XFILLER_90_74 VDD VDD VSS VSS gf180mcu_as_sc_mcu7t3v3__fill_1
XFILLER_11_482 VDD VDD VSS VSS gf180mcu_as_sc_mcu7t3v3__fillcap_8
XFILLER_168_292 VDD VDD VSS VSS gf180mcu_as_sc_mcu7t3v3__fill_2
XFILLER_143_104 VDD VDD VSS VSS gf180mcu_as_sc_mcu7t3v3__fill_1
XFILLER_172_947 VDD VDD VSS VSS gf180mcu_as_sc_mcu7t3v3__fill_2
XFILLER_8_998 VDD VDD VSS VSS gf180mcu_as_sc_mcu7t3v3__fillcap_4
XFILLER_8_987 VDD VDD VSS VSS gf180mcu_as_sc_mcu7t3v3__fillcap_4
XFILLER_8_976 VDD VDD VSS VSS gf180mcu_as_sc_mcu7t3v3__fill_1
XFILLER_99_72 VDD VDD VSS VSS gf180mcu_as_sc_mcu7t3v3__fillcap_8
X_3350_ VDD VDD VSS VSS _3354_/B _4348_/Q _3351_/A gf180mcu_as_sc_mcu7t3v3__nand2b_2
X_2301_ VDD VDD VSS VSS _3527_/A _3580_/A _2510_/D gf180mcu_as_sc_mcu7t3v3__nand2_2
XFILLER_26_1321 VDD VDD VSS VSS gf180mcu_as_sc_mcu7t3v3__fillcap_4
X_3281_ VDD VDD VSS VSS _3282_/D _3281_/B _3314_/A gf180mcu_as_sc_mcu7t3v3__nor2_2
XFILLER_61_1256 VDD VDD VSS VSS gf180mcu_as_sc_mcu7t3v3__fillcap_8
X_2232_ VDD VDD VSS VSS _4629_/Q _4628_/Q _2234_/B gf180mcu_as_sc_mcu7t3v3__or2_2
XFILLER_4_1150 VDD VDD VSS VSS gf180mcu_as_sc_mcu7t3v3__fillcap_4
XTAP_TAPCELL_ROW_166_1396 VDD VSS gf180mcu_as_sc_mcu7t3v3__tap_2
X_4741__1031 VDD VDD VSS VSS _4741_/D gf180mcu_as_sc_mcu7t3v3__tiel_4
XPHY_EDGE_ROW_42_3_Right_83 VDD VSS gf180mcu_as_sc_mcu7t3v3__tap_2
XTAP_TAPCELL_ROW_50_1_1003 VDD VSS gf180mcu_as_sc_mcu7t3v3__tap_2
XFILLER_167_708 VDD VDD VSS VSS gf180mcu_as_sc_mcu7t3v3__fill_1
XFILLER_167_719 VDD VDD VSS VSS gf180mcu_as_sc_mcu7t3v3__fillcap_16
XFILLER_181_1079 VDD VDD VSS VSS gf180mcu_as_sc_mcu7t3v3__fill_1
X_4804_ VDD VDD VSS VSS _4804_/CLK _4804_/D _4804_/Q gf180mcu_as_sc_mcu7t3v3__dfxtp_2
XPHY_EDGE_ROW_45_3_Left_417 VDD VSS gf180mcu_as_sc_mcu7t3v3__tap_2
X_4735_ VDD VDD VSS VSS _4751_/CLK _4735_/D _4735_/Q gf180mcu_as_sc_mcu7t3v3__dfxtp_2
X_2996_ VDD VDD VSS VSS _3027_/A _3004_/B _3004_/C _4408_/Q _4408_/D gf180mcu_as_sc_mcu7t3v3__ao22_2
XTAP_TAPCELL_ROW_192_1913 VDD VSS gf180mcu_as_sc_mcu7t3v3__tap_2
XTAP_TAPCELL_ROW_192_1902 VDD VSS gf180mcu_as_sc_mcu7t3v3__tap_2
XFILLER_119_38 VDD VDD VSS VSS gf180mcu_as_sc_mcu7t3v3__fillcap_16
XFILLER_175_796 VDD VDD VSS VSS gf180mcu_as_sc_mcu7t3v3__fillcap_4
XFILLER_190_722 VDD VDD VSS VSS gf180mcu_as_sc_mcu7t3v3__fillcap_8
X_4666_ VDD VDD VSS VSS clkload5/A _4666_/D _4666_/Q gf180mcu_as_sc_mcu7t3v3__dfxtp_2
X_4597_ VDD VDD VSS VSS _4831_/CLK _4597_/D _4597_/Q gf180mcu_as_sc_mcu7t3v3__dfxtp_2
Xclkbuf_leaf_3_clk_regs VDD VDD VSS VSS clkbuf_leaf_8_clk_regs/A _4783_/CLK gf180mcu_as_sc_mcu7t3v3__clkbuff_12
X_3617_ VDD VDD VSS VSS _3617_/Y _3618_/A _3964_/B gf180mcu_as_sc_mcu7t3v3__nor2b_2
XFILLER_162_468 VDD VDD VSS VSS gf180mcu_as_sc_mcu7t3v3__fillcap_16
X_3548_ VDD VDD VSS VSS _4617_/D _4462_/Q _3553_/B _3548_/C gf180mcu_as_sc_mcu7t3v3__ao21_2
XFILLER_0_106 VDD VDD VSS VSS gf180mcu_as_sc_mcu7t3v3__fill_1
XFILLER_157_1262 VDD VDD VSS VSS gf180mcu_as_sc_mcu7t3v3__fillcap_8
XFILLER_153_1137 VDD VDD VSS VSS gf180mcu_as_sc_mcu7t3v3__fillcap_4
XFILLER_192_1175 VDD VDD VSS VSS gf180mcu_as_sc_mcu7t3v3__fillcap_4
X_3479_ VDD VDD VSS VSS _3479_/B _3480_/B _3481_/B gf180mcu_as_sc_mcu7t3v3__and2_2
XFILLER_28_68 VDD VDD VSS VSS gf180mcu_as_sc_mcu7t3v3__fill_2
XFILLER_178_6 VDD VDD VSS VSS gf180mcu_as_sc_mcu7t3v3__fillcap_16
XFILLER_44_34 VDD VDD VSS VSS gf180mcu_as_sc_mcu7t3v3__fill_1
XTAP_TAPCELL_ROW_0_673 VDD VSS gf180mcu_as_sc_mcu7t3v3__tap_2
XTAP_TAPCELL_ROW_0_662 VDD VSS gf180mcu_as_sc_mcu7t3v3__tap_2
XTAP_TAPCELL_ROW_0_695 VDD VSS gf180mcu_as_sc_mcu7t3v3__tap_2
XTAP_TAPCELL_ROW_0_684 VDD VSS gf180mcu_as_sc_mcu7t3v3__tap_2
XFILLER_13_747 VDD VDD VSS VSS gf180mcu_as_sc_mcu7t3v3__fill_1
XFILLER_13_758 VDD VDD VSS VSS gf180mcu_as_sc_mcu7t3v3__fillcap_4
XFILLER_157_207 VDD VDD VSS VSS gf180mcu_as_sc_mcu7t3v3__fill_2
XFILLER_185_505 VDD VDD VSS VSS gf180mcu_as_sc_mcu7t3v3__fillcap_16
XTAP_TAPCELL_ROW_11_904 VDD VSS gf180mcu_as_sc_mcu7t3v3__tap_2
XFILLER_176_22 VDD VDD VSS VSS gf180mcu_as_sc_mcu7t3v3__fillcap_8
XFILLER_125_104 VDD VDD VSS VSS gf180mcu_as_sc_mcu7t3v3__fill_1
XFILLER_165_251 VDD VDD VSS VSS gf180mcu_as_sc_mcu7t3v3__fill_1
XFILLER_154_947 VDD VDD VSS VSS gf180mcu_as_sc_mcu7t3v3__fill_2
XFILLER_154_969 VDD VDD VSS VSS gf180mcu_as_sc_mcu7t3v3__fill_1
XFILLER_180_232 VDD VDD VSS VSS gf180mcu_as_sc_mcu7t3v3__fillcap_8
XFILLER_5_946 VDD VDD VSS VSS gf180mcu_as_sc_mcu7t3v3__fillcap_4
XFILLER_101_1272 VDD VDD VSS VSS gf180mcu_as_sc_mcu7t3v3__fillcap_4
XFILLER_181_766 VDD VDD VSS VSS gf180mcu_as_sc_mcu7t3v3__fillcap_4
XFILLER_5_979 VDD VDD VSS VSS gf180mcu_as_sc_mcu7t3v3__fill_1
XFILLER_84_1256 VDD VDD VSS VSS gf180mcu_as_sc_mcu7t3v3__fillcap_4
XPHY_EDGE_ROW_91_3_Left_463 VDD VSS gf180mcu_as_sc_mcu7t3v3__tap_2
XFILLER_192_76 VDD VDD VSS VSS gf180mcu_as_sc_mcu7t3v3__fill_1
XFILLER_169_1122 VDD VDD VSS VSS gf180mcu_as_sc_mcu7t3v3__fillcap_4
XFILLER_62_102 VDD VDD VSS VSS gf180mcu_as_sc_mcu7t3v3__fill_2
XFILLER_21_1273 VDD VDD VSS VSS gf180mcu_as_sc_mcu7t3v3__fill_1
XFILLER_189_833 VDD VDD VSS VSS gf180mcu_as_sc_mcu7t3v3__fillcap_4
X_2850_ VDD VDD VSS VSS _4166_/A _2895_/B _2850_/C _2850_/D _2851_/C gf180mcu_as_sc_mcu7t3v3__ao211_2
XFILLER_176_516 VDD VDD VSS VSS gf180mcu_as_sc_mcu7t3v3__fillcap_8
XFILLER_176_527 VDD VDD VSS VSS gf180mcu_as_sc_mcu7t3v3__fillcap_16
XFILLER_191_508 VDD VDD VSS VSS gf180mcu_as_sc_mcu7t3v3__fillcap_16
X_2781_ VDD VDD VSS VSS _4344_/Q _2826_/B _2990_/A _2808_/D _4344_/D gf180mcu_as_sc_mcu7t3v3__ao22_2
XTAP_TAPCELL_ROW_97_1_1050 VDD VSS gf180mcu_as_sc_mcu7t3v3__tap_2
XTAP_TAPCELL_ROW_111_1_1064 VDD VSS gf180mcu_as_sc_mcu7t3v3__tap_2
X_4520_ VDD VDD VSS VSS clkload9/A _4520_/D _4520_/Q gf180mcu_as_sc_mcu7t3v3__dfxtp_2
X_4451_ VDD VDD VSS VSS _4809_/CLK _4451_/D _4451_/Q gf180mcu_as_sc_mcu7t3v3__dfxtp_2
XFILLER_160_928 VDD VDD VSS VSS gf180mcu_as_sc_mcu7t3v3__fill_1
XFILLER_171_232 VDD VDD VSS VSS gf180mcu_as_sc_mcu7t3v3__fill_1
X_3402_ VDD VDD VSS VSS _3409_/A _3402_/B _3402_/C _3404_/B _3402_/D gf180mcu_as_sc_mcu7t3v3__aoi31_2
XFILLER_171_276 VDD VDD VSS VSS gf180mcu_as_sc_mcu7t3v3__fillcap_4
X_4759__1013 VDD VDD VSS VSS _4759_/D gf180mcu_as_sc_mcu7t3v3__tiel_4
X_4382_ VDD VDD VSS VSS _4440_/CLK _4382_/D _4382_/Q gf180mcu_as_sc_mcu7t3v3__dfxtp_2
Xfanout719 VDD VDD VSS VSS _4829_/Q _4830_/D gf180mcu_as_sc_mcu7t3v3__buff_12
X_3333_ VDD VDD VSS VSS _3333_/B _4468_/Q _3340_/D gf180mcu_as_sc_mcu7t3v3__and2_2
X_3264_ VDD VDD VSS VSS _3312_/S _4366_/Q _4395_/Q _3265_/B gf180mcu_as_sc_mcu7t3v3__mux2_2
XTAP_TAPCELL_ROW_168_1447 VDD VSS gf180mcu_as_sc_mcu7t3v3__tap_2
XTAP_TAPCELL_ROW_168_1436 VDD VSS gf180mcu_as_sc_mcu7t3v3__tap_2
XPHY_EDGE_ROW_7_Right_7 VDD VSS gf180mcu_as_sc_mcu7t3v3__tap_2
X_2215_ VDD VDD VSS VSS _2481_/A _2487_/S gf180mcu_as_sc_mcu7t3v3__inv_2
XTAP_TAPCELL_ROW_185_1761 VDD VSS gf180mcu_as_sc_mcu7t3v3__tap_2
XFILLER_152_1192 VDD VDD VSS VSS gf180mcu_as_sc_mcu7t3v3__fillcap_4
XFILLER_187_1200 VDD VDD VSS VSS gf180mcu_as_sc_mcu7t3v3__fillcap_4
X_3195_ VDD VDD VSS VSS _3196_/C _4446_/Q _3410_/A gf180mcu_as_sc_mcu7t3v3__nand2_2
XFILLER_187_1266 VDD VDD VSS VSS gf180mcu_as_sc_mcu7t3v3__fill_2
XFILLER_14_37 VDD VDD VSS VSS gf180mcu_as_sc_mcu7t3v3__fillcap_4
X_2979_ VDD VDD VSS VSS _2979_/A _2989_/B _2989_/C _4391_/Q _4391_/D gf180mcu_as_sc_mcu7t3v3__ao22_2
X_4718_ VDD VDD VSS VSS _4726_/CLK _4718_/D _4718_/Q gf180mcu_as_sc_mcu7t3v3__dfxtp_2
XFILLER_159_1313 VDD VDD VSS VSS gf180mcu_as_sc_mcu7t3v3__fill_1
X_4649_ VDD VDD VSS VSS _4809_/CLK _4649_/D _4649_/Q gf180mcu_as_sc_mcu7t3v3__dfxtp_2
XFILLER_162_232 VDD VDD VSS VSS gf180mcu_as_sc_mcu7t3v3__fillcap_8
XFILLER_162_265 VDD VDD VSS VSS gf180mcu_as_sc_mcu7t3v3__fill_1
XFILLER_1_415 VDD VDD VSS VSS gf180mcu_as_sc_mcu7t3v3__fillcap_4
XTAP_TAPCELL_ROW_5_787 VDD VSS gf180mcu_as_sc_mcu7t3v3__tap_2
XFILLER_131_1298 VDD VDD VSS VSS gf180mcu_as_sc_mcu7t3v3__fill_1
XFILLER_44_102 VDD VDD VSS VSS gf180mcu_as_sc_mcu7t3v3__fill_2
XFILLER_55_88 VDD VDD VSS VSS gf180mcu_as_sc_mcu7t3v3__fillcap_16
XFILLER_111_50 VDD VDD VSS VSS gf180mcu_as_sc_mcu7t3v3__fill_2
XFILLER_111_72 VDD VDD VSS VSS gf180mcu_as_sc_mcu7t3v3__fill_2
XFILLER_164_1063 VDD VDD VSS VSS gf180mcu_as_sc_mcu7t3v3__fill_2
XFILLER_13_577 VDD VDD VSS VSS gf180mcu_as_sc_mcu7t3v3__fill_1
XFILLER_158_527 VDD VDD VSS VSS gf180mcu_as_sc_mcu7t3v3__fillcap_8
XFILLER_186_825 VDD VDD VSS VSS gf180mcu_as_sc_mcu7t3v3__fill_1
XFILLER_71_65 VDD VDD VSS VSS gf180mcu_as_sc_mcu7t3v3__fillcap_4
XFILLER_158_549 VDD VDD VSS VSS gf180mcu_as_sc_mcu7t3v3__fillcap_16
XFILLER_173_508 VDD VDD VSS VSS gf180mcu_as_sc_mcu7t3v3__fill_1
XFILLER_187_76 VDD VDD VSS VSS gf180mcu_as_sc_mcu7t3v3__fill_1
XFILLER_153_221 VDD VDD VSS VSS gf180mcu_as_sc_mcu7t3v3__fill_2
XPHY_EDGE_ROW_119_3_Right_160 VDD VSS gf180mcu_as_sc_mcu7t3v3__tap_2
XFILLER_35_102 VDD VDD VSS VSS gf180mcu_as_sc_mcu7t3v3__fill_2
XTAP_TAPCELL_ROW_163_1344 VDD VSS gf180mcu_as_sc_mcu7t3v3__tap_2
XTAP_TAPCELL_ROW_130_3_2041 VDD VSS gf180mcu_as_sc_mcu7t3v3__tap_2
X_3951_ VDD VDD VSS VSS _3951_/B _3966_/A _3955_/C gf180mcu_as_sc_mcu7t3v3__and2_2
X_2902_ VDD VDD VSS VSS _4217_/A _2902_/B _2902_/C _4214_/A _2903_/D gf180mcu_as_sc_mcu7t3v3__ao22_2
XFILLER_108_1256 VDD VDD VSS VSS gf180mcu_as_sc_mcu7t3v3__fillcap_16
XFILLER_189_674 VDD VDD VSS VSS gf180mcu_as_sc_mcu7t3v3__fill_1
X_3882_ VDD VDD VSS VSS _4220_/A _3882_/B _3882_/C _3882_/D _3883_/B gf180mcu_as_sc_mcu7t3v3__ao211_2
XPHY_EDGE_ROW_118_1_Left_310 VDD VSS gf180mcu_as_sc_mcu7t3v3__tap_2
XFILLER_176_346 VDD VDD VSS VSS gf180mcu_as_sc_mcu7t3v3__fillcap_16
X_2833_ VDD VDD VSS VSS _2871_/B _4155_/A _2834_/D gf180mcu_as_sc_mcu7t3v3__and2_2
X_2764_ VDD VDD VSS VSS _4783_/Q _2828_/B _2828_/C _4092_/D _2765_/D gf180mcu_as_sc_mcu7t3v3__ao22_2
X_4503_ VDD VDD VSS VSS _4708_/CLK _4503_/D _4503_/Q gf180mcu_as_sc_mcu7t3v3__dfxtp_2
X_2695_ VDD VDD VSS VSS _4031_/D _2902_/B _2695_/C _2695_/D _2696_/C gf180mcu_as_sc_mcu7t3v3__ao211_2
X_4434_ VDD VDD VSS VSS _4533_/CLK _4434_/D _4434_/Q gf180mcu_as_sc_mcu7t3v3__dfxtp_2
XFILLER_160_747 VDD VDD VSS VSS gf180mcu_as_sc_mcu7t3v3__fillcap_16
Xfanout505 VDD VDD VSS VSS _2658_/Y _2898_/B gf180mcu_as_sc_mcu7t3v3__buff_12
X_4365_ VDD VDD VSS VSS _4429_/CLK _4365_/D _4365_/Q gf180mcu_as_sc_mcu7t3v3__dfxtp_2
XTAP_TAPCELL_ROW_187_1801 VDD VSS gf180mcu_as_sc_mcu7t3v3__tap_2
Xfanout516 VDD VDD VSS VSS _2650_/Y _2974_/A gf180mcu_as_sc_mcu7t3v3__buff_12
Xfanout527 VDD VDD VSS VSS _4236_/C fanout527/Y gf180mcu_as_sc_mcu7t3v3__buff_12
Xfanout538 VDD VDD VSS VSS _3635_/Y _3871_/B gf180mcu_as_sc_mcu7t3v3__buff_12
X_3316_ VDD VDD VSS VSS _3348_/A _3316_/B _3316_/C _3316_/D _4530_/D gf180mcu_as_sc_mcu7t3v3__ao211_2
Xfanout549 VDD VDD VSS VSS wire550/Y _2896_/B gf180mcu_as_sc_mcu7t3v3__buff_12
Xmesh_tile_920 VDD VDD VSS VSS nw_out[20] gf180mcu_as_sc_mcu7t3v3__tiel_4
X_4296_ VDD VDD VSS VSS _4310_/B _4520_/Q _4773_/D gf180mcu_as_sc_mcu7t3v3__and2_2
Xmesh_tile_953 VDD VDD VSS VSS se_out[17] gf180mcu_as_sc_mcu7t3v3__tiel_4
Xmesh_tile_942 VDD VDD VSS VSS se_out[6] gf180mcu_as_sc_mcu7t3v3__tiel_4
Xmesh_tile_931 VDD VDD VSS VSS nw_out[31] gf180mcu_as_sc_mcu7t3v3__tiel_4
X_3247_ VDD VDD VSS VSS _3250_/C _4422_/Q _3304_/S gf180mcu_as_sc_mcu7t3v3__nand2_2
XTAP_TAPCELL_ROW_2_724 VDD VSS gf180mcu_as_sc_mcu7t3v3__tap_2
Xmesh_tile_986 VDD VDD VSS VSS sw_out[14] gf180mcu_as_sc_mcu7t3v3__tiel_4
Xmesh_tile_975 VDD VDD VSS VSS sw_out[3] gf180mcu_as_sc_mcu7t3v3__tiel_4
Xmesh_tile_964 VDD VDD VSS VSS se_out[28] gf180mcu_as_sc_mcu7t3v3__tiel_4
X_3178_ VDD VDD VSS VSS _3178_/B _3188_/A _3180_/B gf180mcu_as_sc_mcu7t3v3__xnor2_2
XTAP_TAPCELL_ROW_2_735 VDD VSS gf180mcu_as_sc_mcu7t3v3__tap_2
XFILLER_187_1052 VDD VDD VSS VSS gf180mcu_as_sc_mcu7t3v3__fillcap_4
Xmesh_tile_997 VDD VDD VSS VSS sw_out[25] gf180mcu_as_sc_mcu7t3v3__tiel_4
XFILLER_165_1350 VDD VDD VSS VSS gf180mcu_as_sc_mcu7t3v3__fill_1
XFILLER_179_173 VDD VDD VSS VSS gf180mcu_as_sc_mcu7t3v3__fill_2
XFILLER_161_1247 VDD VDD VSS VSS gf180mcu_as_sc_mcu7t3v3__fill_2
XFILLER_167_335 VDD VDD VSS VSS gf180mcu_as_sc_mcu7t3v3__fillcap_4
XTAP_TAPCELL_ROW_65_3_1976 VDD VSS gf180mcu_as_sc_mcu7t3v3__tap_2
XPHY_EDGE_ROW_102_1_Left_294 VDD VSS gf180mcu_as_sc_mcu7t3v3__tap_2
XFILLER_155_508 VDD VDD VSS VSS gf180mcu_as_sc_mcu7t3v3__fill_2
XFILLER_183_839 VDD VDD VSS VSS gf180mcu_as_sc_mcu7t3v3__fill_1
XFILLER_157_35 VDD VDD VSS VSS gf180mcu_as_sc_mcu7t3v3__fill_2
XFILLER_159_1187 VDD VDD VSS VSS gf180mcu_as_sc_mcu7t3v3__fill_2
XFILLER_1_212 VDD VDD VSS VSS gf180mcu_as_sc_mcu7t3v3__fill_2
XPHY_EDGE_ROW_8_Left_201 VDD VSS gf180mcu_as_sc_mcu7t3v3__tap_2
XFILLER_166_1103 VDD VDD VSS VSS gf180mcu_as_sc_mcu7t3v3__fillcap_4
XFILLER_186_699 VDD VDD VSS VSS gf180mcu_as_sc_mcu7t3v3__fillcap_16
XFILLER_12_1014 VDD VDD VSS VSS gf180mcu_as_sc_mcu7t3v3__fill_1
XFILLER_12_1025 VDD VDD VSS VSS gf180mcu_as_sc_mcu7t3v3__fill_2
XFILLER_167_891 VDD VDD VSS VSS gf180mcu_as_sc_mcu7t3v3__fillcap_8
XFILLER_173_338 VDD VDD VSS VSS gf180mcu_as_sc_mcu7t3v3__fill_1
XFILLER_12_1069 VDD VDD VSS VSS gf180mcu_as_sc_mcu7t3v3__fill_1
XFILLER_154_552 VDD VDD VSS VSS gf180mcu_as_sc_mcu7t3v3__fillcap_8
XFILLER_177_1276 VDD VDD VSS VSS gf180mcu_as_sc_mcu7t3v3__fill_1
XFILLER_5_573 VDD VDD VSS VSS gf180mcu_as_sc_mcu7t3v3__fill_2
X_2480_ VDD VDD VSS VSS _4818_/Q _4830_/Q _2481_/D gf180mcu_as_sc_mcu7t3v3__and2_2
XFILLER_173_1118 VDD VDD VSS VSS gf180mcu_as_sc_mcu7t3v3__fill_2
XPHY_EDGE_ROW_51_3_Right_92 VDD VSS gf180mcu_as_sc_mcu7t3v3__tap_2
XPHY_EDGE_ROW_117_3_Left_489 VDD VSS gf180mcu_as_sc_mcu7t3v3__tap_2
X_4150_ VDD VDD VSS VSS _4151_/B _4150_/A _4184_/B _4150_/C gf180mcu_as_sc_mcu7t3v3__ao21_2
X_3101_ VDD VDD VSS VSS _3116_/S _4489_/Q _4488_/Q _4488_/D gf180mcu_as_sc_mcu7t3v3__mux2_2
X_4081_ VDD VDD VSS VSS _4082_/C _4081_/C _4143_/B _4081_/A gf180mcu_as_sc_mcu7t3v3__aoi21_2
XPHY_EDGE_ROW_54_3_Left_426 VDD VSS gf180mcu_as_sc_mcu7t3v3__tap_2
Xinput190 VDD VDD VSS VSS se_in[10] _4089_/A gf180mcu_as_sc_mcu7t3v3__buff_12
X_3032_ VDD VDD VSS VSS _3032_/A _3034_/B _3038_/C _4442_/Q _4442_/D gf180mcu_as_sc_mcu7t3v3__ao22_2
XFILLER_189_482 VDD VDD VSS VSS gf180mcu_as_sc_mcu7t3v3__fillcap_8
X_3934_ VDD VDD VSS VSS _3934_/B _4271_/A _4688_/D gf180mcu_as_sc_mcu7t3v3__and2_2
X_3865_ VDD VDD VSS VSS _3865_/B _3945_/A _4681_/D gf180mcu_as_sc_mcu7t3v3__and2_2
XFILLER_192_614 VDD VDD VSS VSS gf180mcu_as_sc_mcu7t3v3__fillcap_4
X_2816_ VDD VDD VSS VSS _4138_/A _2905_/B _2816_/C _2816_/D _2994_/A gf180mcu_as_sc_mcu7t3v3__ao22_2
X_3796_ VDD VDD VSS VSS _3797_/D _4141_/A _3796_/B _3823_/C gf180mcu_as_sc_mcu7t3v3__ao21_2
XFILLER_121_1264 VDD VDD VSS VSS gf180mcu_as_sc_mcu7t3v3__fillcap_4
XFILLER_121_1275 VDD VDD VSS VSS gf180mcu_as_sc_mcu7t3v3__fillcap_8
X_2747_ VDD VDD VSS VSS _2829_/B _4077_/D _2748_/D gf180mcu_as_sc_mcu7t3v3__and2_2
XFILLER_127_38 VDD VDD VSS VSS gf180mcu_as_sc_mcu7t3v3__fillcap_16
XFILLER_173_883 VDD VDD VSS VSS gf180mcu_as_sc_mcu7t3v3__fill_1
X_2678_ VDD VDD VSS VSS _4015_/D _2902_/B _2678_/C _2678_/D _2679_/C gf180mcu_as_sc_mcu7t3v3__ao211_2
X_4417_ VDD VDD VSS VSS _4447_/CLK _4417_/D _4417_/Q gf180mcu_as_sc_mcu7t3v3__dfxtp_2
XTAP_TAPCELL_ROW_7_816 VDD VSS gf180mcu_as_sc_mcu7t3v3__tap_2
XTAP_TAPCELL_ROW_7_827 VDD VSS gf180mcu_as_sc_mcu7t3v3__tap_2
X_4348_ VDD VDD VSS VSS _4795_/CLK _4348_/D _4348_/Q gf180mcu_as_sc_mcu7t3v3__dfxtp_2
XFILLER_143_48 VDD VDD VSS VSS gf180mcu_as_sc_mcu7t3v3__fillcap_16
X_4279_ VDD VDD VSS VSS _4281_/A _4280_/A _4285_/B _4287_/A gf180mcu_as_sc_mcu7t3v3__aoi21_2
XFILLER_168_622 VDD VDD VSS VSS gf180mcu_as_sc_mcu7t3v3__fillcap_4
XFILLER_168_34 VDD VDD VSS VSS gf180mcu_as_sc_mcu7t3v3__fill_1
XFILLER_168_699 VDD VDD VSS VSS gf180mcu_as_sc_mcu7t3v3__fillcap_16
Xwire769 VDD VDD VSS VSS wire769/A _4104_/A gf180mcu_as_sc_mcu7t3v3__clkbuff_12
XFILLER_20_1349 VDD VDD VSS VSS gf180mcu_as_sc_mcu7t3v3__fillcap_4
XFILLER_179_909 VDD VDD VSS VSS gf180mcu_as_sc_mcu7t3v3__fill_1
XFILLER_178_408 VDD VDD VSS VSS gf180mcu_as_sc_mcu7t3v3__fillcap_8
XFILLER_158_121 VDD VDD VSS VSS gf180mcu_as_sc_mcu7t3v3__fill_1
XFILLER_18_1256 VDD VDD VSS VSS gf180mcu_as_sc_mcu7t3v3__fillcap_8
XFILLER_144_1286 VDD VDD VSS VSS gf180mcu_as_sc_mcu7t3v3__fill_2
XTAP_TAPCELL_ROW_158_1254 VDD VSS gf180mcu_as_sc_mcu7t3v3__tap_2
XTAP_TAPCELL_ROW_158_1243 VDD VSS gf180mcu_as_sc_mcu7t3v3__tap_2
XFILLER_9_142 VDD VDD VSS VSS gf180mcu_as_sc_mcu7t3v3__fillcap_4
XFILLER_158_165 VDD VDD VSS VSS gf180mcu_as_sc_mcu7t3v3__fillcap_8
X_3650_ VDD VDD VSS VSS _3875_/B _4012_/D _3651_/C gf180mcu_as_sc_mcu7t3v3__and2_2
X_3581_ VDD VDD VSS VSS _4630_/Q _3584_/B _3581_/C _3582_/A _4630_/D gf180mcu_as_sc_mcu7t3v3__ao22_2
X_2601_ VDD VDD VSS VSS _3938_/A _3949_/A _2603_/C gf180mcu_as_sc_mcu7t3v3__or2_2
XFILLER_9_197 VDD VDD VSS VSS gf180mcu_as_sc_mcu7t3v3__fillcap_8
X_2532_ VDD VDD VSS VSS _2535_/A _4584_/Q _2533_/B gf180mcu_as_sc_mcu7t3v3__and2_2
XFILLER_170_853 VDD VDD VSS VSS gf180mcu_as_sc_mcu7t3v3__fill_1
XFILLER_181_190 VDD VDD VSS VSS gf180mcu_as_sc_mcu7t3v3__fillcap_4
XFILLER_6_893 VDD VDD VSS VSS gf180mcu_as_sc_mcu7t3v3__fillcap_8
XTAP_TAPCELL_ROW_171_1498 VDD VSS gf180mcu_as_sc_mcu7t3v3__tap_2
XTAP_TAPCELL_ROW_171_1487 VDD VSS gf180mcu_as_sc_mcu7t3v3__tap_2
X_4202_ VDD VDD VSS VSS _4202_/A _4210_/B _4237_/B _4202_/D _4203_/D gf180mcu_as_sc_mcu7t3v3__ao22_2
X_2463_ VDD VDD VSS VSS _2487_/S _4816_/Q _4825_/Q _2466_/A gf180mcu_as_sc_mcu7t3v3__mux2_2
X_2394_ VDD VDD VSS VSS _2407_/B _2394_/B _2407_/C _4618_/Q _2397_/B gf180mcu_as_sc_mcu7t3v3__ao22_2
XTAP_TAPCELL_ROW_117_3_2028 VDD VSS gf180mcu_as_sc_mcu7t3v3__tap_2
X_4133_ VDD VDD VSS VSS _4135_/B _4133_/A _4133_/B _4133_/C gf180mcu_as_sc_mcu7t3v3__ao21_2
X_4064_ VDD VDD VSS VSS _4064_/A _4218_/B _4136_/B _4064_/D _4065_/C gf180mcu_as_sc_mcu7t3v3__ao22_2
XFILLER_7_1192 VDD VDD VSS VSS gf180mcu_as_sc_mcu7t3v3__fillcap_4
X_3015_ VDD VDD VSS VSS _3015_/A _3019_/B _3020_/S _4425_/Q _4425_/D gf180mcu_as_sc_mcu7t3v3__ao22_2
XFILLER_184_1011 VDD VDD VSS VSS gf180mcu_as_sc_mcu7t3v3__fillcap_4
XFILLER_184_1033 VDD VDD VSS VSS gf180mcu_as_sc_mcu7t3v3__fillcap_16
XFILLER_169_408 VDD VDD VSS VSS gf180mcu_as_sc_mcu7t3v3__fillcap_8
XTAP_TAPCELL_ROW_178_1619 VDD VSS gf180mcu_as_sc_mcu7t3v3__tap_2
XFILLER_177_430 VDD VDD VSS VSS gf180mcu_as_sc_mcu7t3v3__fill_2
XFILLER_184_1099 VDD VDD VSS VSS gf180mcu_as_sc_mcu7t3v3__fill_1
Xsram2048.u_bank0_818 VDD VDD VSS VSS sram2048.u_bank0/WEN[5] gf180mcu_as_sc_mcu7t3v3__tiel_4
XFILLER_123_1326 VDD VDD VSS VSS gf180mcu_as_sc_mcu7t3v3__fillcap_4
X_3917_ VDD VDD VSS VSS _3925_/S _3917_/B _4256_/A _3918_/C gf180mcu_as_sc_mcu7t3v3__mux2_2
XFILLER_22_48 VDD VDD VSS VSS gf180mcu_as_sc_mcu7t3v3__fillcap_16
X_3848_ VDD VDD VSS VSS _3856_/A _3882_/B _4195_/A gf180mcu_as_sc_mcu7t3v3__nand2_2
XFILLER_138_37 VDD VDD VSS VSS gf180mcu_as_sc_mcu7t3v3__fillcap_16
XFILLER_192_455 VDD VDD VSS VSS gf180mcu_as_sc_mcu7t3v3__fillcap_4
X_3779_ VDD VDD VSS VSS _4787_/Q _3852_/B _3779_/C _3779_/D _3780_/C gf180mcu_as_sc_mcu7t3v3__ao22_2
XFILLER_152_308 VDD VDD VSS VSS gf180mcu_as_sc_mcu7t3v3__fillcap_16
XFILLER_161_842 VDD VDD VSS VSS gf180mcu_as_sc_mcu7t3v3__fillcap_16
XFILLER_173_680 VDD VDD VSS VSS gf180mcu_as_sc_mcu7t3v3__fillcap_16
XFILLER_0_8 VDD VDD VSS VSS gf180mcu_as_sc_mcu7t3v3__fill_1
XFILLER_156_1157 VDD VDD VSS VSS gf180mcu_as_sc_mcu7t3v3__fillcap_8
XFILLER_191_1048 VDD VDD VSS VSS gf180mcu_as_sc_mcu7t3v3__fill_2
XFILLER_47_56 VDD VDD VSS VSS gf180mcu_as_sc_mcu7t3v3__fill_2
XFILLER_167_1242 VDD VDD VSS VSS gf180mcu_as_sc_mcu7t3v3__fill_2
XFILLER_167_1297 VDD VDD VSS VSS gf180mcu_as_sc_mcu7t3v3__fillcap_4
XFILLER_168_430 VDD VDD VSS VSS gf180mcu_as_sc_mcu7t3v3__fillcap_16
XFILLER_156_636 VDD VDD VSS VSS gf180mcu_as_sc_mcu7t3v3__fill_2
XFILLER_183_422 VDD VDD VSS VSS gf180mcu_as_sc_mcu7t3v3__fillcap_16
XFILLER_7_624 VDD VDD VSS VSS gf180mcu_as_sc_mcu7t3v3__fillcap_4
XFILLER_10_185 VDD VDD VSS VSS gf180mcu_as_sc_mcu7t3v3__fill_2
XFILLER_171_639 VDD VDD VSS VSS gf180mcu_as_sc_mcu7t3v3__fillcap_4
XFILLER_183_466 VDD VDD VSS VSS gf180mcu_as_sc_mcu7t3v3__fillcap_8
XTAP_TAPCELL_ROW_153_1151 VDD VSS gf180mcu_as_sc_mcu7t3v3__tap_2
XFILLER_174_1224 VDD VDD VSS VSS gf180mcu_as_sc_mcu7t3v3__fill_1
Xclkbuf_leaf_27_clk_regs VDD VDD VSS VSS clkload1/A _4727_/CLK gf180mcu_as_sc_mcu7t3v3__clkbuff_12
XTAP_TAPCELL_ROW_153_1162 VDD VSS gf180mcu_as_sc_mcu7t3v3__tap_2
XFILLER_152_886 VDD VDD VSS VSS gf180mcu_as_sc_mcu7t3v3__fill_2
XFILLER_174_1257 VDD VDD VSS VSS gf180mcu_as_sc_mcu7t3v3__fillcap_16
XFILLER_174_1279 VDD VDD VSS VSS gf180mcu_as_sc_mcu7t3v3__fill_1
XFILLER_111_1263 VDD VDD VSS VSS gf180mcu_as_sc_mcu7t3v3__fillcap_4
XFILLER_168_1017 VDD VDD VSS VSS gf180mcu_as_sc_mcu7t3v3__fillcap_4
XFILLER_146_1304 VDD VDD VSS VSS gf180mcu_as_sc_mcu7t3v3__fillcap_4
XFILLER_146_1337 VDD VDD VSS VSS gf180mcu_as_sc_mcu7t3v3__fillcap_8
X_4820_ VDD VDD VSS VSS _4820_/CLK _4820_/D _4820_/Q gf180mcu_as_sc_mcu7t3v3__dfxtp_2
XFILLER_159_441 VDD VDD VSS VSS gf180mcu_as_sc_mcu7t3v3__fillcap_4
XFILLER_175_901 VDD VDD VSS VSS gf180mcu_as_sc_mcu7t3v3__fillcap_8
XFILLER_175_912 VDD VDD VSS VSS gf180mcu_as_sc_mcu7t3v3__fillcap_16
XFILLER_187_750 VDD VDD VSS VSS gf180mcu_as_sc_mcu7t3v3__fillcap_4
X_4751_ VDD VDD VSS VSS _4751_/CLK _4751_/D _4751_/Q gf180mcu_as_sc_mcu7t3v3__dfxtp_2
XFILLER_186_271 VDD VDD VSS VSS gf180mcu_as_sc_mcu7t3v3__fill_2
X_4682_ VDD VDD VSS VSS clkload4/A _4682_/D _4682_/Q gf180mcu_as_sc_mcu7t3v3__dfxtp_2
X_3702_ VDD VDD VSS VSS _3747_/S _3702_/B _4058_/A _3703_/B gf180mcu_as_sc_mcu7t3v3__mux2_2
XTAP_TAPCELL_ROW_173_1527 VDD VSS gf180mcu_as_sc_mcu7t3v3__tap_2
XFILLER_70_1291 VDD VDD VSS VSS gf180mcu_as_sc_mcu7t3v3__fillcap_4
X_3633_ VDD VDD VSS VSS _3633_/B _3633_/A _3633_/Y gf180mcu_as_sc_mcu7t3v3__or2_2
XTAP_TAPCELL_ROW_173_1538 VDD VSS gf180mcu_as_sc_mcu7t3v3__tap_2
XFILLER_190_937 VDD VDD VSS VSS gf180mcu_as_sc_mcu7t3v3__fill_1
XTAP_TAPCELL_ROW_190_1863 VDD VSS gf180mcu_as_sc_mcu7t3v3__tap_2
XTAP_TAPCELL_ROW_190_1852 VDD VSS gf180mcu_as_sc_mcu7t3v3__tap_2
XFILLER_161_138 VDD VDD VSS VSS gf180mcu_as_sc_mcu7t3v3__fill_2
X_3564_ VDD VDD VSS VSS _3565_/B _3564_/B _3582_/A gf180mcu_as_sc_mcu7t3v3__nand2_2
XFILLER_154_190 VDD VDD VSS VSS gf180mcu_as_sc_mcu7t3v3__fill_1
X_3495_ VDD VDD VSS VSS _4598_/D _4598_/Q _3503_/B _3495_/C gf180mcu_as_sc_mcu7t3v3__ao21_2
X_2515_ VDD VDD VSS VSS _3447_/A _4292_/C _2523_/C gf180mcu_as_sc_mcu7t3v3__and2_2
X_2446_ VDD VDD VSS VSS _2455_/A _2446_/B _2446_/C _2446_/D _2446_/Y gf180mcu_as_sc_mcu7t3v3__ao22_2
XPHY_EDGE_ROW_59_1_Left_251 VDD VSS gf180mcu_as_sc_mcu7t3v3__tap_2
X_4116_ VDD VDD VSS VSS _4116_/A _4149_/B _4149_/C _4116_/D _4118_/C gf180mcu_as_sc_mcu7t3v3__ao22_2
X_2377_ VDD VDD VSS VSS _2377_/Y _2377_/C _2455_/A _2377_/A gf180mcu_as_sc_mcu7t3v3__aoi21b_2
XPHY_EDGE_ROW_14_3_Right_55 VDD VSS gf180mcu_as_sc_mcu7t3v3__tap_2
XTAP_TAPCELL_ROW_148_1_1101 VDD VSS gf180mcu_as_sc_mcu7t3v3__tap_2
X_4047_ VDD VDD VSS VSS _4047_/A _4218_/B _4225_/B _4047_/D _4048_/D gf180mcu_as_sc_mcu7t3v3__ao22_2
XFILLER_73_1309 VDD VDD VSS VSS gf180mcu_as_sc_mcu7t3v3__fill_2
XFILLER_178_761 VDD VDD VSS VSS gf180mcu_as_sc_mcu7t3v3__fill_2
XFILLER_137_102 VDD VDD VSS VSS gf180mcu_as_sc_mcu7t3v3__fill_2
XFILLER_165_422 VDD VDD VSS VSS gf180mcu_as_sc_mcu7t3v3__fillcap_8
XFILLER_184_219 VDD VDD VSS VSS gf180mcu_as_sc_mcu7t3v3__fillcap_8
XFILLER_149_69 VDD VDD VSS VSS gf180mcu_as_sc_mcu7t3v3__fill_1
XFILLER_177_282 VDD VDD VSS VSS gf180mcu_as_sc_mcu7t3v3__fill_1
XFILLER_153_606 VDD VDD VSS VSS gf180mcu_as_sc_mcu7t3v3__fillcap_4
XFILLER_165_477 VDD VDD VSS VSS gf180mcu_as_sc_mcu7t3v3__fillcap_8
XFILLER_192_274 VDD VDD VSS VSS gf180mcu_as_sc_mcu7t3v3__fillcap_4
XPHY_EDGE_ROW_131_3_Left_503 VDD VSS gf180mcu_as_sc_mcu7t3v3__tap_2
XFILLER_152_138 VDD VDD VSS VSS gf180mcu_as_sc_mcu7t3v3__fillcap_16
XFILLER_180_436 VDD VDD VSS VSS gf180mcu_as_sc_mcu7t3v3__fill_2
XFILLER_0_822 VDD VDD VSS VSS gf180mcu_as_sc_mcu7t3v3__fill_1
XFILLER_0_833 VDD VDD VSS VSS gf180mcu_as_sc_mcu7t3v3__fill_2
XFILLER_0_899 VDD VDD VSS VSS gf180mcu_as_sc_mcu7t3v3__fill_2
XFILLER_181_34 VDD VDD VSS VSS gf180mcu_as_sc_mcu7t3v3__fillcap_16
XFILLER_181_67 VDD VDD VSS VSS gf180mcu_as_sc_mcu7t3v3__fill_2
XFILLER_169_1348 VDD VDD VSS VSS gf180mcu_as_sc_mcu7t3v3__fill_2
XFILLER_130_60 VDD VDD VSS VSS gf180mcu_as_sc_mcu7t3v3__fillcap_16
XPHY_EDGE_ROW_126_3_Left_498 VDD VSS gf180mcu_as_sc_mcu7t3v3__tap_2
XFILLER_157_912 VDD VDD VSS VSS gf180mcu_as_sc_mcu7t3v3__fillcap_16
XFILLER_169_772 VDD VDD VSS VSS gf180mcu_as_sc_mcu7t3v3__fillcap_16
XFILLER_184_720 VDD VDD VSS VSS gf180mcu_as_sc_mcu7t3v3__fillcap_4
XFILLER_141_1256 VDD VDD VSS VSS gf180mcu_as_sc_mcu7t3v3__fillcap_8
XFILLER_157_978 VDD VDD VSS VSS gf180mcu_as_sc_mcu7t3v3__fill_2
XPHY_EDGE_ROW_63_3_Left_435 VDD VSS gf180mcu_as_sc_mcu7t3v3__tap_2
XFILLER_8_966 VDD VDD VSS VSS gf180mcu_as_sc_mcu7t3v3__fillcap_8
XFILLER_8_955 VDD VDD VSS VSS gf180mcu_as_sc_mcu7t3v3__fill_1
XFILLER_8_944 VDD VDD VSS VSS gf180mcu_as_sc_mcu7t3v3__fill_1
XFILLER_183_274 VDD VDD VSS VSS gf180mcu_as_sc_mcu7t3v3__fillcap_4
XFILLER_174_1065 VDD VDD VSS VSS gf180mcu_as_sc_mcu7t3v3__fillcap_8
X_3280_ VDD VDD VSS VSS _3296_/S _4368_/Q _4397_/Q _3281_/B gf180mcu_as_sc_mcu7t3v3__mux2_2
X_2300_ VDD VDD VSS VSS _2307_/B _4576_/Q _2510_/D gf180mcu_as_sc_mcu7t3v3__nand2_2
XFILLER_155_90 VDD VDD VSS VSS gf180mcu_as_sc_mcu7t3v3__fillcap_4
XFILLER_174_1087 VDD VDD VSS VSS gf180mcu_as_sc_mcu7t3v3__fillcap_16
X_2231_ VDD VDD VSS VSS _4626_/Q _4627_/Q _3086_/A gf180mcu_as_sc_mcu7t3v3__or2_2
XFILLER_61_1268 VDD VDD VSS VSS gf180mcu_as_sc_mcu7t3v3__fill_1
XTAP_TAPCELL_ROW_166_1397 VDD VSS gf180mcu_as_sc_mcu7t3v3__tap_2
XFILLER_0_40 VDD VDD VSS VSS gf180mcu_as_sc_mcu7t3v3__fill_2
XFILLER_181_1014 VDD VDD VSS VSS gf180mcu_as_sc_mcu7t3v3__fillcap_4
XFILLER_185_1183 VDD VDD VSS VSS gf180mcu_as_sc_mcu7t3v3__fillcap_4
X_4803_ VDD VDD VSS VSS _4803_/CLK _4803_/D _4803_/Q gf180mcu_as_sc_mcu7t3v3__dfxtp_2
XFILLER_119_102 VDD VDD VSS VSS gf180mcu_as_sc_mcu7t3v3__fill_2
XFILLER_175_720 VDD VDD VSS VSS gf180mcu_as_sc_mcu7t3v3__fill_1
XFILLER_33_1326 VDD VDD VSS VSS gf180mcu_as_sc_mcu7t3v3__fill_2
X_4734_ VDD VDD VSS VSS clkload6/A _4734_/D _4734_/Q gf180mcu_as_sc_mcu7t3v3__dfxtp_2
X_2995_ VDD VDD VSS VSS _2995_/A _3004_/B _3004_/C _4407_/Q _4407_/D gf180mcu_as_sc_mcu7t3v3__ao22_2
XTAP_TAPCELL_ROW_192_1914 VDD VSS gf180mcu_as_sc_mcu7t3v3__tap_2
XTAP_TAPCELL_ROW_192_1903 VDD VSS gf180mcu_as_sc_mcu7t3v3__tap_2
XFILLER_174_263 VDD VDD VSS VSS gf180mcu_as_sc_mcu7t3v3__fill_2
XFILLER_175_764 VDD VDD VSS VSS gf180mcu_as_sc_mcu7t3v3__fillcap_4
X_4665_ VDD VDD VSS VSS clkload5/A _4665_/D _4665_/Q gf180mcu_as_sc_mcu7t3v3__dfxtp_2
XFILLER_190_734 VDD VDD VSS VSS gf180mcu_as_sc_mcu7t3v3__fill_1
X_4596_ VDD VDD VSS VSS _4831_/CLK _4596_/D _4596_/Q gf180mcu_as_sc_mcu7t3v3__dfxtp_2
X_3616_ VDD VDD VSS VSS _3616_/Y _3641_/A _3869_/B gf180mcu_as_sc_mcu7t3v3__nor2_2
XFILLER_192_1121 VDD VDD VSS VSS gf180mcu_as_sc_mcu7t3v3__fill_1
X_3547_ VDD VDD VSS VSS _4618_/Q _3554_/B _3553_/C _4617_/Q _3548_/C gf180mcu_as_sc_mcu7t3v3__ao22_2
XFILLER_135_38 VDD VDD VSS VSS gf180mcu_as_sc_mcu7t3v3__fill_1
XFILLER_192_1143 VDD VDD VSS VSS gf180mcu_as_sc_mcu7t3v3__fillcap_4
Xmax_cap685 VDD VDD VSS VSS _3614_/Y fanout682/A gf180mcu_as_sc_mcu7t3v3__clkbuff_12
XFILLER_135_49 VDD VDD VSS VSS gf180mcu_as_sc_mcu7t3v3__fillcap_16
X_3478_ VDD VDD VSS VSS _3479_/B _3478_/B _3478_/A gf180mcu_as_sc_mcu7t3v3__nand2_2
X_2429_ VDD VDD VSS VSS _2487_/S _4812_/Q _4821_/Q _2434_/A gf180mcu_as_sc_mcu7t3v3__mux2_2
XFILLER_151_26 VDD VDD VSS VSS gf180mcu_as_sc_mcu7t3v3__fill_1
XFILLER_71_103 VDD VDD VSS VSS gf180mcu_as_sc_mcu7t3v3__fill_2
XTAP_TAPCELL_ROW_0_674 VDD VSS gf180mcu_as_sc_mcu7t3v3__tap_2
XTAP_TAPCELL_ROW_0_663 VDD VSS gf180mcu_as_sc_mcu7t3v3__tap_2
XFILLER_44_68 VDD VDD VSS VSS gf180mcu_as_sc_mcu7t3v3__fill_2
XTAP_TAPCELL_ROW_0_696 VDD VSS gf180mcu_as_sc_mcu7t3v3__tap_2
XTAP_TAPCELL_ROW_0_685 VDD VSS gf180mcu_as_sc_mcu7t3v3__tap_2
XFILLER_12_247 VDD VDD VSS VSS gf180mcu_as_sc_mcu7t3v3__fill_2
XTAP_TAPCELL_ROW_11_905 VDD VSS gf180mcu_as_sc_mcu7t3v3__tap_2
XFILLER_165_263 VDD VDD VSS VSS gf180mcu_as_sc_mcu7t3v3__fillcap_16
XFILLER_166_764 VDD VDD VSS VSS gf180mcu_as_sc_mcu7t3v3__fillcap_16
XFILLER_176_34 VDD VDD VSS VSS gf180mcu_as_sc_mcu7t3v3__fill_1
XFILLER_10_1123 VDD VDD VSS VSS gf180mcu_as_sc_mcu7t3v3__fill_2
XFILLER_154_959 VDD VDD VSS VSS gf180mcu_as_sc_mcu7t3v3__fillcap_8
XFILLER_176_89 VDD VDD VSS VSS gf180mcu_as_sc_mcu7t3v3__fillcap_16
XFILLER_181_734 VDD VDD VSS VSS gf180mcu_as_sc_mcu7t3v3__fillcap_16
XFILLER_5_18 VDD VDD VSS VSS gf180mcu_as_sc_mcu7t3v3__fillcap_8
XFILLER_109_72 VDD VDD VSS VSS gf180mcu_as_sc_mcu7t3v3__fillcap_8
XFILLER_10_1145 VDD VDD VSS VSS gf180mcu_as_sc_mcu7t3v3__fillcap_8
XFILLER_153_458 VDD VDD VSS VSS gf180mcu_as_sc_mcu7t3v3__fill_1
XFILLER_153_469 VDD VDD VSS VSS gf180mcu_as_sc_mcu7t3v3__fillcap_16
XFILLER_180_244 VDD VDD VSS VSS gf180mcu_as_sc_mcu7t3v3__fill_1
XFILLER_49_1322 VDD VDD VSS VSS gf180mcu_as_sc_mcu7t3v3__fill_2
XFILLER_4_457 VDD VDD VSS VSS gf180mcu_as_sc_mcu7t3v3__fill_1
XFILLER_109_94 VDD VDD VSS VSS gf180mcu_as_sc_mcu7t3v3__fillcap_8
XTAP_TAPCELL_ROW_55_1_1008 VDD VSS gf180mcu_as_sc_mcu7t3v3__tap_2
XFILLER_21_1285 VDD VDD VSS VSS gf180mcu_as_sc_mcu7t3v3__fill_2
XFILLER_143_1307 VDD VDD VSS VSS gf180mcu_as_sc_mcu7t3v3__fill_1
XTAP_TAPCELL_ROW_83_3_1994 VDD VSS gf180mcu_as_sc_mcu7t3v3__tap_2
XFILLER_188_399 VDD VDD VSS VSS gf180mcu_as_sc_mcu7t3v3__fillcap_16
X_2780_ VDD VDD VSS VSS _4105_/A _2900_/B _2780_/C _2780_/D _2990_/A gf180mcu_as_sc_mcu7t3v3__ao211_2
XFILLER_172_701 VDD VDD VSS VSS gf180mcu_as_sc_mcu7t3v3__fillcap_16
XFILLER_172_734 VDD VDD VSS VSS gf180mcu_as_sc_mcu7t3v3__fill_1
XFILLER_172_745 VDD VDD VSS VSS gf180mcu_as_sc_mcu7t3v3__fillcap_4
XFILLER_176_1127 VDD VDD VSS VSS gf180mcu_as_sc_mcu7t3v3__fillcap_8
X_4450_ VDD VDD VSS VSS _4829_/CLK _4450_/D _4450_/Q gf180mcu_as_sc_mcu7t3v3__dfxtp_2
X_4381_ VDD VDD VSS VSS _4445_/CLK _4381_/D _4381_/Q gf180mcu_as_sc_mcu7t3v3__dfxtp_2
X_3401_ VDD VDD VSS VSS _3402_/D _3401_/B _3409_/A gf180mcu_as_sc_mcu7t3v3__nor2_2
X_3332_ VDD VDD VSS VSS _3340_/A _3332_/B _3332_/C _3332_/D _4532_/D gf180mcu_as_sc_mcu7t3v3__ao211_2
X_3263_ VDD VDD VSS VSS _3266_/C _4424_/Q _3312_/S gf180mcu_as_sc_mcu7t3v3__nand2_2
XTAP_TAPCELL_ROW_168_1437 VDD VSS gf180mcu_as_sc_mcu7t3v3__tap_2
XFILLER_152_1160 VDD VDD VSS VSS gf180mcu_as_sc_mcu7t3v3__fill_1
XFILLER_38_100 VDD VDD VSS VSS gf180mcu_as_sc_mcu7t3v3__fillcap_4
X_3194_ VDD VDD VSS VSS _3196_/B _4359_/Q _3410_/A gf180mcu_as_sc_mcu7t3v3__nand2b_2
X_2214_ VDD VDD VSS VSS _3584_/A _4632_/Q gf180mcu_as_sc_mcu7t3v3__inv_2
XTAP_TAPCELL_ROW_185_1762 VDD VSS gf180mcu_as_sc_mcu7t3v3__tap_2
XFILLER_187_1245 VDD VDD VSS VSS gf180mcu_as_sc_mcu7t3v3__fillcap_8
XFILLER_179_322 VDD VDD VSS VSS gf180mcu_as_sc_mcu7t3v3__fillcap_16
X_2978_ VDD VDD VSS VSS _2978_/A _3004_/B _3004_/C _4390_/Q _4390_/D gf180mcu_as_sc_mcu7t3v3__ao22_2
XFILLER_182_509 VDD VDD VSS VSS gf180mcu_as_sc_mcu7t3v3__fillcap_4
X_4717_ VDD VDD VSS VSS _4726_/CLK _4717_/D _4717_/Q gf180mcu_as_sc_mcu7t3v3__dfxtp_2
XFILLER_162_200 VDD VDD VSS VSS gf180mcu_as_sc_mcu7t3v3__fillcap_16
X_4648_ VDD VDD VSS VSS _4809_/CLK _4648_/D _4648_/Q gf180mcu_as_sc_mcu7t3v3__dfxtp_2
XFILLER_146_37 VDD VDD VSS VSS gf180mcu_as_sc_mcu7t3v3__fillcap_16
XFILLER_162_244 VDD VDD VSS VSS gf180mcu_as_sc_mcu7t3v3__fill_1
XFILLER_30_48 VDD VDD VSS VSS gf180mcu_as_sc_mcu7t3v3__fillcap_4
XFILLER_190_597 VDD VDD VSS VSS gf180mcu_as_sc_mcu7t3v3__fillcap_16
XFILLER_2_939 VDD VDD VSS VSS gf180mcu_as_sc_mcu7t3v3__fillcap_4
X_4579_ VDD VDD VSS VSS _4602_/CLK _4579_/D _4579_/Q gf180mcu_as_sc_mcu7t3v3__dfxtp_2
XFILLER_39_57 VDD VDD VSS VSS gf180mcu_as_sc_mcu7t3v3__fillcap_4
XFILLER_162_69 VDD VDD VSS VSS gf180mcu_as_sc_mcu7t3v3__fill_1
XFILLER_44_1285 VDD VDD VSS VSS gf180mcu_as_sc_mcu7t3v3__fillcap_4
XTAP_TAPCELL_ROW_5_788 VDD VSS gf180mcu_as_sc_mcu7t3v3__tap_2
XTAP_TAPCELL_ROW_5_777 VDD VSS gf180mcu_as_sc_mcu7t3v3__tap_2
XFILLER_131_1288 VDD VDD VSS VSS gf180mcu_as_sc_mcu7t3v3__fillcap_8
XFILLER_79_1326 VDD VDD VSS VSS gf180mcu_as_sc_mcu7t3v3__fillcap_4
XTAP_TAPCELL_ROW_116_1_1069 VDD VSS gf180mcu_as_sc_mcu7t3v3__tap_2
XFILLER_13_512 VDD VDD VSS VSS gf180mcu_as_sc_mcu7t3v3__fill_2
XFILLER_111_84 VDD VDD VSS VSS gf180mcu_as_sc_mcu7t3v3__fillcap_4
XFILLER_187_55 VDD VDD VSS VSS gf180mcu_as_sc_mcu7t3v3__fillcap_8
XFILLER_71_99 VDD VDD VSS VSS gf180mcu_as_sc_mcu7t3v3__fillcap_4
XFILLER_90_1272 VDD VDD VSS VSS gf180mcu_as_sc_mcu7t3v3__fillcap_16
XFILLER_51_1267 VDD VDD VSS VSS gf180mcu_as_sc_mcu7t3v3__fill_1
XFILLER_154_723 VDD VDD VSS VSS gf180mcu_as_sc_mcu7t3v3__fill_1
XFILLER_181_531 VDD VDD VSS VSS gf180mcu_as_sc_mcu7t3v3__fillcap_4
XFILLER_5_733 VDD VDD VSS VSS gf180mcu_as_sc_mcu7t3v3__fillcap_4
XFILLER_171_1013 VDD VDD VSS VSS gf180mcu_as_sc_mcu7t3v3__fill_2
XFILLER_20_81 VDD VDD VSS VSS gf180mcu_as_sc_mcu7t3v3__fill_1
XFILLER_1_950 VDD VDD VSS VSS gf180mcu_as_sc_mcu7t3v3__fillcap_4
XFILLER_96_41 VDD VDD VSS VSS gf180mcu_as_sc_mcu7t3v3__fill_2
Xmesh_tile VDD VDD VSS VSS ne_out[0] gf180mcu_as_sc_mcu7t3v3__tiel_4
XTAP_TAPCELL_ROW_163_1345 VDD VSS gf180mcu_as_sc_mcu7t3v3__tap_2
XTAP_TAPCELL_ROW_163_1334 VDD VSS gf180mcu_as_sc_mcu7t3v3__tap_2
X_3950_ VDD VDD VSS VSS _3951_/B _3962_/A _3950_/B _3950_/C gf180mcu_as_sc_mcu7t3v3__ao21_2
XTAP_TAPCELL_ROW_180_1670 VDD VSS gf180mcu_as_sc_mcu7t3v3__tap_2
X_2901_ VDD VDD VSS VSS _4214_/D _2901_/B _2901_/C _4217_/D _2903_/C gf180mcu_as_sc_mcu7t3v3__ao22_2
XFILLER_147_1295 VDD VDD VSS VSS gf180mcu_as_sc_mcu7t3v3__fill_1
XFILLER_176_314 VDD VDD VSS VSS gf180mcu_as_sc_mcu7t3v3__fill_1
X_3881_ VDD VDD VSS VSS _4219_/A _3881_/B _3881_/C _4218_/A _3882_/D gf180mcu_as_sc_mcu7t3v3__ao22_2
X_2832_ VDD VDD VSS VSS _4153_/A _2896_/B _2832_/C _2832_/D _2834_/C gf180mcu_as_sc_mcu7t3v3__ao211_2
XPHY_EDGE_ROW_68_1_Left_260 VDD VSS gf180mcu_as_sc_mcu7t3v3__tap_2
XFILLER_164_509 VDD VDD VSS VSS gf180mcu_as_sc_mcu7t3v3__fill_2
X_2763_ VDD VDD VSS VSS _2827_/B _4093_/A _2765_/C gf180mcu_as_sc_mcu7t3v3__and2_2
XTAP_TAPCELL_ROW_31_3_1942 VDD VSS gf180mcu_as_sc_mcu7t3v3__tap_2
XPHY_EDGE_ROW_23_3_Right_64 VDD VSS gf180mcu_as_sc_mcu7t3v3__tap_2
XFILLER_157_594 VDD VDD VSS VSS gf180mcu_as_sc_mcu7t3v3__fillcap_4
X_4502_ VDD VDD VSS VSS _4708_/CLK _4502_/D _4502_/Q gf180mcu_as_sc_mcu7t3v3__dfxtp_2
X_2694_ VDD VDD VSS VSS _4029_/D _2901_/C _2694_/C _2694_/D _2695_/D gf180mcu_as_sc_mcu7t3v3__ao211_2
XFILLER_160_737 VDD VDD VSS VSS gf180mcu_as_sc_mcu7t3v3__fill_2
XFILLER_172_597 VDD VDD VSS VSS gf180mcu_as_sc_mcu7t3v3__fillcap_4
X_4433_ VDD VDD VSS VSS _4533_/CLK _4433_/D _4433_/Q gf180mcu_as_sc_mcu7t3v3__dfxtp_2
XFILLER_154_1211 VDD VDD VSS VSS gf180mcu_as_sc_mcu7t3v3__fill_2
Xfanout506 VDD VDD VSS VSS wire508/Y _2879_/B gf180mcu_as_sc_mcu7t3v3__buff_12
X_4364_ VDD VDD VSS VSS _4429_/CLK _4364_/D _4364_/Q gf180mcu_as_sc_mcu7t3v3__dfxtp_2
XTAP_TAPCELL_ROW_187_1802 VDD VSS gf180mcu_as_sc_mcu7t3v3__tap_2
Xfanout517 VDD VDD VSS VSS _4228_/B _4136_/C gf180mcu_as_sc_mcu7t3v3__buff_12
Xfanout539 VDD VDD VSS VSS _3364_/A _3348_/A gf180mcu_as_sc_mcu7t3v3__buff_12
X_4295_ VDD VDD VSS VSS _4318_/B _4519_/Q _4772_/D gf180mcu_as_sc_mcu7t3v3__and2_2
X_3315_ VDD VDD VSS VSS _4530_/Q _3315_/B _3315_/C _4531_/Q _3316_/C gf180mcu_as_sc_mcu7t3v3__ao22_2
Xmesh_tile_910 VDD VDD VSS VSS nw_out[10] gf180mcu_as_sc_mcu7t3v3__tiel_4
X_3246_ VDD VDD VSS VSS _3250_/B _4335_/Q _3304_/S gf180mcu_as_sc_mcu7t3v3__nand2b_2
XFILLER_189_1318 VDD VDD VSS VSS gf180mcu_as_sc_mcu7t3v3__fillcap_8
Xmesh_tile_954 VDD VDD VSS VSS se_out[18] gf180mcu_as_sc_mcu7t3v3__tiel_4
Xmesh_tile_943 VDD VDD VSS VSS se_out[7] gf180mcu_as_sc_mcu7t3v3__tiel_4
Xmesh_tile_932 VDD VDD VSS VSS nw_out[32] gf180mcu_as_sc_mcu7t3v3__tiel_4
Xmesh_tile_921 VDD VDD VSS VSS nw_out[21] gf180mcu_as_sc_mcu7t3v3__tiel_4
XFILLER_26_103 VDD VDD VSS VSS gf180mcu_as_sc_mcu7t3v3__fill_2
XFILLER_6_1087 VDD VDD VSS VSS gf180mcu_as_sc_mcu7t3v3__fillcap_4
Xmesh_tile_987 VDD VDD VSS VSS sw_out[15] gf180mcu_as_sc_mcu7t3v3__tiel_4
Xmesh_tile_976 VDD VDD VSS VSS sw_out[4] gf180mcu_as_sc_mcu7t3v3__tiel_4
Xmesh_tile_965 VDD VDD VSS VSS se_out[29] gf180mcu_as_sc_mcu7t3v3__tiel_4
X_3177_ VDD VDD VSS VSS _4512_/D _3177_/C _3210_/B _4512_/Q gf180mcu_as_sc_mcu7t3v3__aoi21b_2
XTAP_TAPCELL_ROW_2_736 VDD VSS gf180mcu_as_sc_mcu7t3v3__tap_2
XTAP_TAPCELL_ROW_2_725 VDD VSS gf180mcu_as_sc_mcu7t3v3__tap_2
Xmesh_tile_998 VDD VDD VSS VSS sw_out[26] gf180mcu_as_sc_mcu7t3v3__tiel_4
XPHY_EDGE_ROW_140_3_Left_512 VDD VSS gf180mcu_as_sc_mcu7t3v3__tap_2
XFILLER_168_804 VDD VDD VSS VSS gf180mcu_as_sc_mcu7t3v3__fill_1
XFILLER_25_37 VDD VDD VSS VSS gf180mcu_as_sc_mcu7t3v3__fillcap_16
XFILLER_168_815 VDD VDD VSS VSS gf180mcu_as_sc_mcu7t3v3__fill_2
XFILLER_74_1256 VDD VDD VSS VSS gf180mcu_as_sc_mcu7t3v3__fillcap_4
XFILLER_182_317 VDD VDD VSS VSS gf180mcu_as_sc_mcu7t3v3__fillcap_4
XFILLER_182_339 VDD VDD VSS VSS gf180mcu_as_sc_mcu7t3v3__fillcap_16
XFILLER_157_69 VDD VDD VSS VSS gf180mcu_as_sc_mcu7t3v3__fill_1
XFILLER_159_1133 VDD VDD VSS VSS gf180mcu_as_sc_mcu7t3v3__fill_1
XFILLER_46_1303 VDD VDD VSS VSS gf180mcu_as_sc_mcu7t3v3__fillcap_4
XTAP_TAPCELL_ROW_135_3_2046 VDD VSS gf180mcu_as_sc_mcu7t3v3__tap_2
XFILLER_172_1333 VDD VDD VSS VSS gf180mcu_as_sc_mcu7t3v3__fillcap_16
XFILLER_46_1347 VDD VDD VSS VSS gf180mcu_as_sc_mcu7t3v3__fillcap_8
XFILLER_181_2 VDD VDD VSS VSS gf180mcu_as_sc_mcu7t3v3__fillcap_16
XFILLER_66_66 VDD VDD VSS VSS gf180mcu_as_sc_mcu7t3v3__fill_1
XPHY_EDGE_ROW_72_3_Left_444 VDD VSS gf180mcu_as_sc_mcu7t3v3__tap_2
XFILLER_166_1115 VDD VDD VSS VSS gf180mcu_as_sc_mcu7t3v3__fillcap_16
XFILLER_13_342 VDD VDD VSS VSS gf180mcu_as_sc_mcu7t3v3__fillcap_4
XFILLER_158_314 VDD VDD VSS VSS gf180mcu_as_sc_mcu7t3v3__fill_1
XFILLER_185_122 VDD VDD VSS VSS gf180mcu_as_sc_mcu7t3v3__fill_1
XFILLER_186_645 VDD VDD VSS VSS gf180mcu_as_sc_mcu7t3v3__fillcap_16
XFILLER_174_807 VDD VDD VSS VSS gf180mcu_as_sc_mcu7t3v3__fillcap_16
XFILLER_186_667 VDD VDD VSS VSS gf180mcu_as_sc_mcu7t3v3__fillcap_16
XFILLER_9_368 VDD VDD VSS VSS gf180mcu_as_sc_mcu7t3v3__fillcap_4
XFILLER_12_1037 VDD VDD VSS VSS gf180mcu_as_sc_mcu7t3v3__fillcap_4
XFILLER_177_1233 VDD VDD VSS VSS gf180mcu_as_sc_mcu7t3v3__fillcap_4
XFILLER_182_862 VDD VDD VSS VSS gf180mcu_as_sc_mcu7t3v3__fillcap_8
XFILLER_182_895 VDD VDD VSS VSS gf180mcu_as_sc_mcu7t3v3__fill_1
XFILLER_154_597 VDD VDD VSS VSS gf180mcu_as_sc_mcu7t3v3__fillcap_8
X_3100_ VDD VDD VSS VSS _3116_/S _4488_/Q _4487_/Q _4487_/D gf180mcu_as_sc_mcu7t3v3__mux2_2
XFILLER_1_791 VDD VDD VSS VSS gf180mcu_as_sc_mcu7t3v3__fillcap_4
XFILLER_7_1341 VDD VDD VSS VSS gf180mcu_as_sc_mcu7t3v3__fill_2
XFILLER_7_1352 VDD VDD VSS VSS gf180mcu_as_sc_mcu7t3v3__fill_2
X_4080_ VDD VDD VSS VSS _4080_/A _4153_/B _4080_/C _4080_/D _4081_/C gf180mcu_as_sc_mcu7t3v3__ao211_2
XTAP_TAPCELL_ROW_182_1710 VDD VSS gf180mcu_as_sc_mcu7t3v3__tap_2
XFILLER_114_1272 VDD VDD VSS VSS gf180mcu_as_sc_mcu7t3v3__fillcap_4
Xinput180 VDD VDD VSS VSS nw_in[35] _3960_/B gf180mcu_as_sc_mcu7t3v3__buff_12
X_3031_ VDD VDD VSS VSS _4276_/A _4441_/Q _3031_/A _4441_/D gf180mcu_as_sc_mcu7t3v3__mux2_2
XFILLER_114_1283 VDD VDD VSS VSS gf180mcu_as_sc_mcu7t3v3__fillcap_4
Xinput191 VDD VDD VSS VSS se_in[11] _4097_/A gf180mcu_as_sc_mcu7t3v3__buff_12
XFILLER_97_1256 VDD VDD VSS VSS gf180mcu_as_sc_mcu7t3v3__fillcap_8
XFILLER_184_1215 VDD VDD VSS VSS gf180mcu_as_sc_mcu7t3v3__fillcap_8
X_3933_ VDD VDD VSS VSS _3933_/S _3933_/B _4269_/A _3934_/B gf180mcu_as_sc_mcu7t3v3__mux2_2
XFILLER_177_634 VDD VDD VSS VSS gf180mcu_as_sc_mcu7t3v3__fill_1
X_3864_ VDD VDD VSS VSS _3933_/S _3864_/B _4204_/A _3865_/B gf180mcu_as_sc_mcu7t3v3__mux2_2
XFILLER_165_829 VDD VDD VSS VSS gf180mcu_as_sc_mcu7t3v3__fillcap_4
X_2815_ VDD VDD VSS VSS _2879_/B _4136_/D _2816_/D gf180mcu_as_sc_mcu7t3v3__or2_2
XFILLER_158_881 VDD VDD VSS VSS gf180mcu_as_sc_mcu7t3v3__fill_2
XFILLER_164_317 VDD VDD VSS VSS gf180mcu_as_sc_mcu7t3v3__fillcap_16
XFILLER_176_177 VDD VDD VSS VSS gf180mcu_as_sc_mcu7t3v3__fillcap_4
XFILLER_192_648 VDD VDD VSS VSS gf180mcu_as_sc_mcu7t3v3__fill_2
X_3795_ VDD VDD VSS VSS _4142_/A _3795_/B _3795_/C _3795_/D _3797_/C gf180mcu_as_sc_mcu7t3v3__ao211_2
XFILLER_191_158 VDD VDD VSS VSS gf180mcu_as_sc_mcu7t3v3__fill_2
X_2746_ VDD VDD VSS VSS _4781_/Q _2828_/B _2827_/B _4077_/A _2748_/C gf180mcu_as_sc_mcu7t3v3__ao22_2
XFILLER_160_512 VDD VDD VSS VSS gf180mcu_as_sc_mcu7t3v3__fill_1
XFILLER_173_895 VDD VDD VSS VSS gf180mcu_as_sc_mcu7t3v3__fill_2
X_2677_ VDD VDD VSS VSS _2903_/B _4015_/A _2678_/D gf180mcu_as_sc_mcu7t3v3__and2_2
XFILLER_191_1208 VDD VDD VSS VSS gf180mcu_as_sc_mcu7t3v3__fillcap_16
X_4416_ VDD VDD VSS VSS _4440_/CLK _4416_/D _4416_/Q gf180mcu_as_sc_mcu7t3v3__dfxtp_2
XTAP_TAPCELL_ROW_7_828 VDD VSS gf180mcu_as_sc_mcu7t3v3__tap_2
XTAP_TAPCELL_ROW_7_817 VDD VSS gf180mcu_as_sc_mcu7t3v3__tap_2
XFILLER_8_1138 VDD VDD VSS VSS gf180mcu_as_sc_mcu7t3v3__fill_2
X_4347_ VDD VDD VSS VSS _4789_/CLK _4347_/D _4347_/Q gf180mcu_as_sc_mcu7t3v3__dfxtp_2
X_4278_ VDD VDD VSS VSS _4285_/B _4278_/B _4278_/A gf180mcu_as_sc_mcu7t3v3__nand2_2
XFILLER_80_1293 VDD VDD VSS VSS gf180mcu_as_sc_mcu7t3v3__fill_1
X_3229_ VDD VDD VSS VSS _3373_/B _4471_/Q _3236_/D gf180mcu_as_sc_mcu7t3v3__and2_2
XFILLER_36_69 VDD VDD VSS VSS gf180mcu_as_sc_mcu7t3v3__fill_2
XFILLER_187_409 VDD VDD VSS VSS gf180mcu_as_sc_mcu7t3v3__fill_1
XFILLER_161_1012 VDD VDD VSS VSS gf180mcu_as_sc_mcu7t3v3__fill_1
XFILLER_165_1181 VDD VDD VSS VSS gf180mcu_as_sc_mcu7t3v3__fill_2
XFILLER_165_1192 VDD VDD VSS VSS gf180mcu_as_sc_mcu7t3v3__fillcap_16
XFILLER_156_807 VDD VDD VSS VSS gf180mcu_as_sc_mcu7t3v3__fillcap_8
XFILLER_168_667 VDD VDD VSS VSS gf180mcu_as_sc_mcu7t3v3__fillcap_16
XFILLER_13_1324 VDD VDD VSS VSS gf180mcu_as_sc_mcu7t3v3__fill_2
XFILLER_183_626 VDD VDD VSS VSS gf180mcu_as_sc_mcu7t3v3__fillcap_4
XFILLER_7_828 VDD VDD VSS VSS gf180mcu_as_sc_mcu7t3v3__fillcap_4
XFILLER_100_1316 VDD VDD VSS VSS gf180mcu_as_sc_mcu7t3v3__fill_2
XFILLER_164_862 VDD VDD VSS VSS gf180mcu_as_sc_mcu7t3v3__fill_1
XFILLER_184_34 VDD VDD VSS VSS gf180mcu_as_sc_mcu7t3v3__fill_1
XFILLER_117_72 VDD VDD VSS VSS gf180mcu_as_sc_mcu7t3v3__fillcap_4
XFILLER_7_2 VDD VDD VSS VSS gf180mcu_as_sc_mcu7t3v3__fillcap_16
XFILLER_2_599 VDD VDD VSS VSS gf180mcu_as_sc_mcu7t3v3__fill_1
Xhold1090 VDD VDD VSS VSS _4813_/Q hold1090/Y gf180mcu_as_sc_mcu7t3v3__clkbuff_4
XFILLER_26_91 VDD VDD VSS VSS gf180mcu_as_sc_mcu7t3v3__fillcap_8
XFILLER_187_932 VDD VDD VSS VSS gf180mcu_as_sc_mcu7t3v3__fill_1
XFILLER_13_172 VDD VDD VSS VSS gf180mcu_as_sc_mcu7t3v3__fillcap_16
XFILLER_186_442 VDD VDD VSS VSS gf180mcu_as_sc_mcu7t3v3__fillcap_8
XTAP_TAPCELL_ROW_158_1255 VDD VSS gf180mcu_as_sc_mcu7t3v3__tap_2
XTAP_TAPCELL_ROW_158_1244 VDD VSS gf180mcu_as_sc_mcu7t3v3__tap_2
XFILLER_158_177 VDD VDD VSS VSS gf180mcu_as_sc_mcu7t3v3__fillcap_16
XFILLER_174_637 VDD VDD VSS VSS gf180mcu_as_sc_mcu7t3v3__fillcap_4
XFILLER_174_648 VDD VDD VSS VSS gf180mcu_as_sc_mcu7t3v3__fillcap_16
X_3580_ VDD VDD VSS VSS _3580_/A _3580_/B _3580_/C _3581_/C _3580_/D gf180mcu_as_sc_mcu7t3v3__aoi211_2
X_2600_ VDD VDD VSS VSS _2659_/A _2638_/A _2660_/A gf180mcu_as_sc_mcu7t3v3__nor2_2
XTAP_TAPCELL_ROW_175_1580 VDD VSS gf180mcu_as_sc_mcu7t3v3__tap_2
XFILLER_173_158 VDD VDD VSS VSS gf180mcu_as_sc_mcu7t3v3__fillcap_4
XFILLER_177_1052 VDD VDD VSS VSS gf180mcu_as_sc_mcu7t3v3__fill_2
XFILLER_6_861 VDD VDD VSS VSS gf180mcu_as_sc_mcu7t3v3__fillcap_8
X_2531_ VDD VDD VSS VSS _2531_/B _3571_/A _2556_/C gf180mcu_as_sc_mcu7t3v3__and2_2
XTAP_TAPCELL_ROW_171_1499 VDD VSS gf180mcu_as_sc_mcu7t3v3__tap_2
XTAP_TAPCELL_ROW_171_1488 VDD VSS gf180mcu_as_sc_mcu7t3v3__tap_2
X_4201_ VDD VDD VSS VSS _4209_/A _4201_/B _4201_/C _4204_/B _4203_/C gf180mcu_as_sc_mcu7t3v3__ao211_2
X_2462_ VDD VDD VSS VSS _2462_/D _2462_/A _2462_/B _2462_/C _2462_/Y gf180mcu_as_sc_mcu7t3v3__ao31_2
X_2393_ VDD VDD VSS VSS _4830_/Q _3608_/D _2393_/C _2407_/C gf180mcu_as_sc_mcu7t3v3__nor3_2
X_4132_ VDD VDD VSS VSS _4132_/A _4214_/B _4214_/C _4132_/D _4133_/C gf180mcu_as_sc_mcu7t3v3__ao22_2
X_4063_ VDD VDD VSS VSS _4066_/B _4063_/B _4063_/A gf180mcu_as_sc_mcu7t3v3__nor2_2
XFILLER_3_1024 VDD VDD VSS VSS gf180mcu_as_sc_mcu7t3v3__fill_1
X_3014_ VDD VDD VSS VSS _3014_/A _3019_/B _3020_/S _4424_/Q _4424_/D gf180mcu_as_sc_mcu7t3v3__ao22_2
XPHY_EDGE_ROW_20_1_Right_529 VDD VSS gf180mcu_as_sc_mcu7t3v3__tap_2
XTAP_TAPCELL_ROW_18_3_1929 VDD VSS gf180mcu_as_sc_mcu7t3v3__tap_2
XFILLER_178_943 VDD VDD VSS VSS gf180mcu_as_sc_mcu7t3v3__fill_2
Xsram2048.u_bank0_819 VDD VDD VSS VSS sram2048.u_bank0/WEN[6] gf180mcu_as_sc_mcu7t3v3__tiel_4
X_3916_ VDD VDD VSS VSS _3916_/B _4258_/A _3917_/B gf180mcu_as_sc_mcu7t3v3__and2_2
XFILLER_138_16 VDD VDD VSS VSS gf180mcu_as_sc_mcu7t3v3__fill_1
XFILLER_177_486 VDD VDD VSS VSS gf180mcu_as_sc_mcu7t3v3__fillcap_4
XFILLER_178_998 VDD VDD VSS VSS gf180mcu_as_sc_mcu7t3v3__fillcap_4
XFILLER_192_423 VDD VDD VSS VSS gf180mcu_as_sc_mcu7t3v3__fillcap_4
XFILLER_22_27 VDD VDD VSS VSS gf180mcu_as_sc_mcu7t3v3__fillcap_8
X_3847_ VDD VDD VSS VSS _4188_/A _3847_/B _3847_/C _4679_/D _4229_/D gf180mcu_as_sc_mcu7t3v3__aoi211_2
X_3778_ VDD VDD VSS VSS _3779_/D _4124_/A _3880_/A _3953_/C gf180mcu_as_sc_mcu7t3v3__ao21_2
XFILLER_180_629 VDD VDD VSS VSS gf180mcu_as_sc_mcu7t3v3__fill_2
XFILLER_192_478 VDD VDD VSS VSS gf180mcu_as_sc_mcu7t3v3__fillcap_4
X_2729_ VDD VDD VSS VSS _4060_/D _2901_/B _2729_/C _2729_/D _2731_/C gf180mcu_as_sc_mcu7t3v3__ao211_2
XFILLER_156_1103 VDD VDD VSS VSS gf180mcu_as_sc_mcu7t3v3__fill_1
XFILLER_154_37 VDD VDD VSS VSS gf180mcu_as_sc_mcu7t3v3__fillcap_16
XFILLER_160_342 VDD VDD VSS VSS gf180mcu_as_sc_mcu7t3v3__fillcap_8
Xoutput440 VDD VDD VSS VSS _4763_/Q west_out[34] gf180mcu_as_sc_mcu7t3v3__buff_12
XFILLER_156_1169 VDD VDD VSS VSS gf180mcu_as_sc_mcu7t3v3__fill_1
XPHY_EDGE_ROW_20_1_Left_212 VDD VSS gf180mcu_as_sc_mcu7t3v3__tap_2
XFILLER_167_1254 VDD VDD VSS VSS gf180mcu_as_sc_mcu7t3v3__fillcap_4
XFILLER_163_1118 VDD VDD VSS VSS gf180mcu_as_sc_mcu7t3v3__fill_2
XFILLER_11_632 VDD VDD VSS VSS gf180mcu_as_sc_mcu7t3v3__fillcap_4
XFILLER_169_998 VDD VDD VSS VSS gf180mcu_as_sc_mcu7t3v3__fillcap_16
Xwire523 VDD VDD VSS VSS _4268_/C _4237_/B gf180mcu_as_sc_mcu7t3v3__clkbuff_12
XFILLER_104_1260 VDD VDD VSS VSS gf180mcu_as_sc_mcu7t3v3__fill_2
XFILLER_7_636 VDD VDD VSS VSS gf180mcu_as_sc_mcu7t3v3__fill_1
XFILLER_13_1154 VDD VDD VSS VSS gf180mcu_as_sc_mcu7t3v3__fill_2
XFILLER_183_478 VDD VDD VSS VSS gf180mcu_as_sc_mcu7t3v3__fill_2
XFILLER_139_1323 VDD VDD VSS VSS gf180mcu_as_sc_mcu7t3v3__fill_1
XFILLER_152_843 VDD VDD VSS VSS gf180mcu_as_sc_mcu7t3v3__fillcap_4
XFILLER_174_1203 VDD VDD VSS VSS gf180mcu_as_sc_mcu7t3v3__fillcap_8
XTAP_TAPCELL_ROW_153_1152 VDD VSS gf180mcu_as_sc_mcu7t3v3__tap_2
XFILLER_3_842 VDD VDD VSS VSS gf180mcu_as_sc_mcu7t3v3__fillcap_8
XPHY_EDGE_ROW_155_Left_347 VDD VSS gf180mcu_as_sc_mcu7t3v3__tap_2
XFILLER_144_81 VDD VDD VSS VSS gf180mcu_as_sc_mcu7t3v3__fill_2
XFILLER_24_1272 VDD VDD VSS VSS gf180mcu_as_sc_mcu7t3v3__fill_1
XFILLER_4_1322 VDD VDD VSS VSS gf180mcu_as_sc_mcu7t3v3__fillcap_4
XFILLER_150_1291 VDD VDD VSS VSS gf180mcu_as_sc_mcu7t3v3__fillcap_16
XFILLER_185_1310 VDD VDD VSS VSS gf180mcu_as_sc_mcu7t3v3__fillcap_16
XPHY_EDGE_ROW_32_3_Right_73 VDD VSS gf180mcu_as_sc_mcu7t3v3__tap_2
XFILLER_111_1297 VDD VDD VSS VSS gf180mcu_as_sc_mcu7t3v3__fillcap_16
XFILLER_185_1332 VDD VDD VSS VSS gf180mcu_as_sc_mcu7t3v3__fillcap_16
XFILLER_185_1354 VDD VDD VSS VSS gf180mcu_as_sc_mcu7t3v3__fill_1
XFILLER_179_718 VDD VDD VSS VSS gf180mcu_as_sc_mcu7t3v3__fillcap_16
XFILLER_181_1229 VDD VDD VSS VSS gf180mcu_as_sc_mcu7t3v3__fillcap_4
XPHY_EDGE_ROW_35_3_Left_407 VDD VSS gf180mcu_as_sc_mcu7t3v3__tap_2
X_4750_ VDD VDD VSS VSS _4751_/CLK _4750_/D _4750_/Q gf180mcu_as_sc_mcu7t3v3__dfxtp_2
XPHY_EDGE_ROW_164_Left_356 VDD VSS gf180mcu_as_sc_mcu7t3v3__tap_2
X_4681_ VDD VDD VSS VSS clkload4/A _4681_/D _4681_/Q gf180mcu_as_sc_mcu7t3v3__dfxtp_2
X_3701_ VDD VDD VSS VSS _4057_/A _3800_/B _3701_/C _3701_/D _3702_/B gf180mcu_as_sc_mcu7t3v3__ao211_2
XFILLER_179_1114 VDD VDD VSS VSS gf180mcu_as_sc_mcu7t3v3__fillcap_4
X_3632_ VDD VDD VSS VSS _3632_/Y _3633_/B _3633_/A gf180mcu_as_sc_mcu7t3v3__nor2_2
XTAP_TAPCELL_ROW_173_1539 VDD VSS gf180mcu_as_sc_mcu7t3v3__tap_2
XTAP_TAPCELL_ROW_173_1528 VDD VSS gf180mcu_as_sc_mcu7t3v3__tap_2
XFILLER_162_629 VDD VDD VSS VSS gf180mcu_as_sc_mcu7t3v3__fillcap_16
XFILLER_179_1169 VDD VDD VSS VSS gf180mcu_as_sc_mcu7t3v3__fillcap_16
XTAP_TAPCELL_ROW_190_1864 VDD VSS gf180mcu_as_sc_mcu7t3v3__tap_2
XTAP_TAPCELL_ROW_190_1853 VDD VSS gf180mcu_as_sc_mcu7t3v3__tap_2
XFILLER_6_680 VDD VDD VSS VSS gf180mcu_as_sc_mcu7t3v3__fill_2
X_3563_ VDD VDD VSS VSS _3603_/C _3600_/A _3563_/C _4622_/D gf180mcu_as_sc_mcu7t3v3__nor3_2
X_3494_ VDD VDD VSS VSS _4468_/Q _3504_/C _3502_/C _4599_/Q _3495_/C gf180mcu_as_sc_mcu7t3v3__ao22_2
X_2514_ VDD VDD VSS VSS _3585_/A _4829_/Q _3540_/A _3447_/A _2514_/D gf180mcu_as_sc_mcu7t3v3__aoi31_2
X_2445_ VDD VDD VSS VSS _2446_/D _2461_/C _4807_/D _2445_/A gf180mcu_as_sc_mcu7t3v3__aoi21b_2
XPHY_EDGE_ROW_173_Left_365 VDD VSS gf180mcu_as_sc_mcu7t3v3__tap_2
XTAP_TAPCELL_ROW_73_1_1026 VDD VSS gf180mcu_as_sc_mcu7t3v3__tap_2
X_4115_ VDD VDD VSS VSS _4706_/D _4115_/C _4138_/B _4115_/A gf180mcu_as_sc_mcu7t3v3__aoi21_2
X_2376_ VDD VDD VSS VSS _2377_/C _2376_/C _2376_/B _2437_/B gf180mcu_as_sc_mcu7t3v3__aoi21b_2
X_4745__1027 VDD VDD VSS VSS _4745_/D gf180mcu_as_sc_mcu7t3v3__tiel_4
XFILLER_17_38 VDD VDD VSS VSS gf180mcu_as_sc_mcu7t3v3__fillcap_4
XFILLER_186_1118 VDD VDD VSS VSS gf180mcu_as_sc_mcu7t3v3__fillcap_4
X_4046_ VDD VDD VSS VSS _4048_/C _4216_/A _4046_/B _4046_/C gf180mcu_as_sc_mcu7t3v3__ao21_2
XPHY_EDGE_ROW_14_1_Left_385 VDD VSS gf180mcu_as_sc_mcu7t3v3__tap_2
XPHY_EDGE_ROW_182_Left_374 VDD VSS gf180mcu_as_sc_mcu7t3v3__tap_2
XFILLER_127_1260 VDD VDD VSS VSS gf180mcu_as_sc_mcu7t3v3__fill_2
XFILLER_162_1140 VDD VDD VSS VSS gf180mcu_as_sc_mcu7t3v3__fill_1
XFILLER_162_1151 VDD VDD VSS VSS gf180mcu_as_sc_mcu7t3v3__fillcap_4
XFILLER_33_48 VDD VDD VSS VSS gf180mcu_as_sc_mcu7t3v3__fillcap_16
XFILLER_162_1173 VDD VDD VSS VSS gf180mcu_as_sc_mcu7t3v3__fillcap_8
XFILLER_165_434 VDD VDD VSS VSS gf180mcu_as_sc_mcu7t3v3__fill_2
XFILLER_116_6 VDD VDD VSS VSS gf180mcu_as_sc_mcu7t3v3__fill_2
XFILLER_153_629 VDD VDD VSS VSS gf180mcu_as_sc_mcu7t3v3__fill_1
XFILLER_165_467 VDD VDD VSS VSS gf180mcu_as_sc_mcu7t3v3__fill_2
XFILLER_165_489 VDD VDD VSS VSS gf180mcu_as_sc_mcu7t3v3__fill_1
XPHY_EDGE_ROW_81_3_Left_453 VDD VSS gf180mcu_as_sc_mcu7t3v3__tap_2
XPHY_EDGE_ROW_191_Left_383 VDD VSS gf180mcu_as_sc_mcu7t3v3__tap_2
XFILLER_161_695 VDD VDD VSS VSS gf180mcu_as_sc_mcu7t3v3__fillcap_4
XFILLER_0_845 VDD VDD VSS VSS gf180mcu_as_sc_mcu7t3v3__fill_1
XFILLER_74_33 VDD VDD VSS VSS gf180mcu_as_sc_mcu7t3v3__fill_2
XFILLER_74_77 VDD VDD VSS VSS gf180mcu_as_sc_mcu7t3v3__fill_2
XFILLER_188_504 VDD VDD VSS VSS gf180mcu_as_sc_mcu7t3v3__fill_2
XFILLER_167_1084 VDD VDD VSS VSS gf180mcu_as_sc_mcu7t3v3__fillcap_16
XFILLER_12_930 VDD VDD VSS VSS gf180mcu_as_sc_mcu7t3v3__fillcap_8
XFILLER_7_422 VDD VDD VSS VSS gf180mcu_as_sc_mcu7t3v3__fill_1
XFILLER_89_1306 VDD VDD VSS VSS gf180mcu_as_sc_mcu7t3v3__fillcap_4
XFILLER_89_1317 VDD VDD VSS VSS gf180mcu_as_sc_mcu7t3v3__fillcap_4
XFILLER_184_765 VDD VDD VSS VSS gf180mcu_as_sc_mcu7t3v3__fillcap_4
XFILLER_156_489 VDD VDD VSS VSS gf180mcu_as_sc_mcu7t3v3__fillcap_16
XFILLER_174_1011 VDD VDD VSS VSS gf180mcu_as_sc_mcu7t3v3__fillcap_4
XFILLER_174_1033 VDD VDD VSS VSS gf180mcu_as_sc_mcu7t3v3__fillcap_16
XFILLER_2_171 VDD VDD VSS VSS gf180mcu_as_sc_mcu7t3v3__fillcap_4
X_2230_ VDD VDD VSS VSS _4806_/Q _2230_/B _2230_/A _5069_/A gf180mcu_as_sc_mcu7t3v3__mux2_2
XFILLER_113_1326 VDD VDD VSS VSS gf180mcu_as_sc_mcu7t3v3__fillcap_4
XTAP_TAPCELL_ROW_166_1398 VDD VSS gf180mcu_as_sc_mcu7t3v3__tap_2
XTAP_TAPCELL_ROW_134_1_1087 VDD VSS gf180mcu_as_sc_mcu7t3v3__tap_2
XFILLER_80_104 VDD VDD VSS VSS gf180mcu_as_sc_mcu7t3v3__fill_1
XFILLER_0_74 VDD VDD VSS VSS gf180mcu_as_sc_mcu7t3v3__fill_2
XFILLER_185_1151 VDD VDD VSS VSS gf180mcu_as_sc_mcu7t3v3__fillcap_16
XFILLER_179_559 VDD VDD VSS VSS gf180mcu_as_sc_mcu7t3v3__fill_1
X_4802_ VDD VDD VSS VSS _4804_/CLK _4802_/D _4802_/Q gf180mcu_as_sc_mcu7t3v3__dfxtp_2
X_2994_ VDD VDD VSS VSS _2994_/A _3004_/B _3004_/C _4406_/Q _4406_/D gf180mcu_as_sc_mcu7t3v3__ao22_2
X_4733_ VDD VDD VSS VSS clkload6/A _4733_/D _4733_/Q gf180mcu_as_sc_mcu7t3v3__dfxtp_2
XTAP_TAPCELL_ROW_192_1915 VDD VSS gf180mcu_as_sc_mcu7t3v3__tap_2
XTAP_TAPCELL_ROW_192_1904 VDD VSS gf180mcu_as_sc_mcu7t3v3__tap_2
XFILLER_159_272 VDD VDD VSS VSS gf180mcu_as_sc_mcu7t3v3__fill_1
XFILLER_175_732 VDD VDD VSS VSS gf180mcu_as_sc_mcu7t3v3__fillcap_16
XTAP_TAPCELL_ROW_92_3_2003 VDD VSS gf180mcu_as_sc_mcu7t3v3__tap_2
XFILLER_174_242 VDD VDD VSS VSS gf180mcu_as_sc_mcu7t3v3__fill_2
X_4664_ VDD VDD VSS VSS clkload5/A _4664_/D _4664_/Q gf180mcu_as_sc_mcu7t3v3__dfxtp_2
X_4595_ VDD VDD VSS VSS _4831_/CLK _4595_/D _4595_/Q gf180mcu_as_sc_mcu7t3v3__dfxtp_2
X_3615_ VDD VDD VSS VSS _3641_/A _3615_/B _3640_/A gf180mcu_as_sc_mcu7t3v3__nor2b_2
XFILLER_192_1111 VDD VDD VSS VSS gf180mcu_as_sc_mcu7t3v3__fillcap_4
X_3546_ VDD VDD VSS VSS _4617_/Q _3554_/B _3546_/C _3546_/D _4616_/D gf180mcu_as_sc_mcu7t3v3__ao211_2
Xmax_cap675 VDD VDD VSS VSS fanout674/Y _2874_/B gf180mcu_as_sc_mcu7t3v3__clkbuff_12
XFILLER_153_1117 VDD VDD VSS VSS gf180mcu_as_sc_mcu7t3v3__fill_2
XFILLER_192_1199 VDD VDD VSS VSS gf180mcu_as_sc_mcu7t3v3__fillcap_4
X_3477_ VDD VDD VSS VSS _3480_/B _3477_/B _4592_/Q _4592_/D gf180mcu_as_sc_mcu7t3v3__mux2_2
X_2428_ VDD VDD VSS VSS _2461_/C _2428_/B _2428_/C _2428_/D _2428_/Y gf180mcu_as_sc_mcu7t3v3__ao22_2
XFILLER_9_1052 VDD VDD VSS VSS gf180mcu_as_sc_mcu7t3v3__fillcap_8
XFILLER_28_37 VDD VDD VSS VSS gf180mcu_as_sc_mcu7t3v3__fillcap_4
X_2359_ VDD VDD VSS VSS _2360_/C _2359_/C _2359_/B _2405_/A gf180mcu_as_sc_mcu7t3v3__aoi21_2
XFILLER_9_1096 VDD VDD VSS VSS gf180mcu_as_sc_mcu7t3v3__fill_2
X_4029_ VDD VDD VSS VSS _4775_/Q _4134_/B _4217_/C _4029_/D _4030_/C gf180mcu_as_sc_mcu7t3v3__ao22_2
XTAP_TAPCELL_ROW_0_664 VDD VSS gf180mcu_as_sc_mcu7t3v3__tap_2
XFILLER_164_1213 VDD VDD VSS VSS gf180mcu_as_sc_mcu7t3v3__fillcap_8
XTAP_TAPCELL_ROW_0_697 VDD VSS gf180mcu_as_sc_mcu7t3v3__tap_2
XTAP_TAPCELL_ROW_0_686 VDD VSS gf180mcu_as_sc_mcu7t3v3__tap_2
XTAP_TAPCELL_ROW_0_675 VDD VSS gf180mcu_as_sc_mcu7t3v3__tap_2
XFILLER_77_1298 VDD VDD VSS VSS gf180mcu_as_sc_mcu7t3v3__fillcap_8
XFILLER_100_64 VDD VDD VSS VSS gf180mcu_as_sc_mcu7t3v3__fillcap_4
XFILLER_157_209 VDD VDD VSS VSS gf180mcu_as_sc_mcu7t3v3__fill_1
XTAP_TAPCELL_ROW_11_906 VDD VSS gf180mcu_as_sc_mcu7t3v3__tap_2
XFILLER_166_732 VDD VDD VSS VSS gf180mcu_as_sc_mcu7t3v3__fill_2
XFILLER_181_702 VDD VDD VSS VSS gf180mcu_as_sc_mcu7t3v3__fillcap_16
XFILLER_10_1168 VDD VDD VSS VSS gf180mcu_as_sc_mcu7t3v3__fill_2
XFILLER_109_84 VDD VDD VSS VSS gf180mcu_as_sc_mcu7t3v3__fill_2
XFILLER_161_470 VDD VDD VSS VSS gf180mcu_as_sc_mcu7t3v3__fillcap_4
XFILLER_180_267 VDD VDD VSS VSS gf180mcu_as_sc_mcu7t3v3__fill_2
XFILLER_69_55 VDD VDD VSS VSS gf180mcu_as_sc_mcu7t3v3__fillcap_8
XFILLER_161_492 VDD VDD VSS VSS gf180mcu_as_sc_mcu7t3v3__fillcap_16
XFILLER_69_99 VDD VDD VSS VSS gf180mcu_as_sc_mcu7t3v3__fillcap_4
XFILLER_125_61 VDD VDD VSS VSS gf180mcu_as_sc_mcu7t3v3__fillcap_8
XFILLER_125_72 VDD VDD VSS VSS gf180mcu_as_sc_mcu7t3v3__fillcap_4
XFILLER_47_101 VDD VDD VSS VSS gf180mcu_as_sc_mcu7t3v3__fillcap_4
XFILLER_85_76 VDD VDD VSS VSS gf180mcu_as_sc_mcu7t3v3__fill_1
XFILLER_169_1146 VDD VDD VSS VSS gf180mcu_as_sc_mcu7t3v3__fill_1
XFILLER_60_1291 VDD VDD VSS VSS gf180mcu_as_sc_mcu7t3v3__fillcap_8
XFILLER_62_104 VDD VDD VSS VSS gf180mcu_as_sc_mcu7t3v3__fill_1
XFILLER_141_60 VDD VDD VSS VSS gf180mcu_as_sc_mcu7t3v3__fillcap_8
XFILLER_143_1319 VDD VDD VSS VSS gf180mcu_as_sc_mcu7t3v3__fillcap_4
XFILLER_182_1346 VDD VDD VSS VSS gf180mcu_as_sc_mcu7t3v3__fillcap_8
XPHY_EDGE_ROW_108_1_Left_300 VDD VSS gf180mcu_as_sc_mcu7t3v3__tap_2
XFILLER_156_242 VDD VDD VSS VSS gf180mcu_as_sc_mcu7t3v3__fill_2
XFILLER_157_765 VDD VDD VSS VSS gf180mcu_as_sc_mcu7t3v3__fillcap_4
XFILLER_8_753 VDD VDD VSS VSS gf180mcu_as_sc_mcu7t3v3__fill_2
XFILLER_156_297 VDD VDD VSS VSS gf180mcu_as_sc_mcu7t3v3__fillcap_8
XFILLER_153_960 VDD VDD VSS VSS gf180mcu_as_sc_mcu7t3v3__fill_2
XFILLER_176_1139 VDD VDD VSS VSS gf180mcu_as_sc_mcu7t3v3__fill_1
X_4380_ VDD VDD VSS VSS _4445_/CLK _4380_/D _4380_/Q gf180mcu_as_sc_mcu7t3v3__dfxtp_2
X_3400_ VDD VDD VSS VSS _3410_/A _4383_/Q _4412_/Q _3401_/B gf180mcu_as_sc_mcu7t3v3__mux2_2
XFILLER_152_470 VDD VDD VSS VSS gf180mcu_as_sc_mcu7t3v3__fillcap_4
Xclkbuf_leaf_11_clk_regs VDD VDD VSS VSS clkbuf_leaf_9_clk_regs/A _4445_/CLK gf180mcu_as_sc_mcu7t3v3__clkbuff_12
X_3331_ VDD VDD VSS VSS _4532_/Q _3347_/B _3347_/C _4533_/Q _3332_/C gf180mcu_as_sc_mcu7t3v3__ao22_2
X_3262_ VDD VDD VSS VSS _3266_/B _4337_/Q _3312_/S gf180mcu_as_sc_mcu7t3v3__nand2b_2
XTAP_TAPCELL_ROW_168_1438 VDD VSS gf180mcu_as_sc_mcu7t3v3__tap_2
XFILLER_117_1270 VDD VDD VSS VSS gf180mcu_as_sc_mcu7t3v3__fill_2
X_3193_ VDD VDD VSS VSS _3196_/D _3193_/B _3409_/A gf180mcu_as_sc_mcu7t3v3__nor2_2
X_2213_ VDD VDD VSS VSS _2546_/B _4519_/Q gf180mcu_as_sc_mcu7t3v3__inv_2
XTAP_TAPCELL_ROW_185_1763 VDD VSS gf180mcu_as_sc_mcu7t3v3__tap_2
XTAP_TAPCELL_ROW_185_1752 VDD VSS gf180mcu_as_sc_mcu7t3v3__tap_2
XFILLER_187_1235 VDD VDD VSS VSS gf180mcu_as_sc_mcu7t3v3__fill_2
XFILLER_53_104 VDD VDD VSS VSS gf180mcu_as_sc_mcu7t3v3__fill_1
XFILLER_187_1257 VDD VDD VSS VSS gf180mcu_as_sc_mcu7t3v3__fill_2
XFILLER_187_1268 VDD VDD VSS VSS gf180mcu_as_sc_mcu7t3v3__fill_1
XFILLER_187_1279 VDD VDD VSS VSS gf180mcu_as_sc_mcu7t3v3__fillcap_16
XTAP_TAPCELL_ROW_68_1_1021 VDD VSS gf180mcu_as_sc_mcu7t3v3__tap_2
X_2977_ VDD VDD VSS VSS _2977_/Y _2989_/B _4122_/D gf180mcu_as_sc_mcu7t3v3__nor2_2
X_4716_ VDD VDD VSS VSS _4728_/CLK _4716_/D _4716_/Q gf180mcu_as_sc_mcu7t3v3__dfxtp_2
XFILLER_163_713 VDD VDD VSS VSS gf180mcu_as_sc_mcu7t3v3__fillcap_16
XFILLER_30_27 VDD VDD VSS VSS gf180mcu_as_sc_mcu7t3v3__fillcap_8
X_4647_ VDD VDD VSS VSS _4831_/CLK _4647_/D _4647_/Q gf180mcu_as_sc_mcu7t3v3__dfxtp_2
XFILLER_159_1348 VDD VDD VSS VSS gf180mcu_as_sc_mcu7t3v3__fill_2
XFILLER_163_768 VDD VDD VSS VSS gf180mcu_as_sc_mcu7t3v3__fill_2
XFILLER_190_554 VDD VDD VSS VSS gf180mcu_as_sc_mcu7t3v3__fillcap_16
X_4578_ VDD VDD VSS VSS _4602_/CLK _4578_/D _4578_/Q gf180mcu_as_sc_mcu7t3v3__dfxtp_2
X_3529_ VDD VDD VSS VSS _3529_/S _4610_/Q _3529_/A _4610_/D gf180mcu_as_sc_mcu7t3v3__mux2_2
XFILLER_162_37 VDD VDD VSS VSS gf180mcu_as_sc_mcu7t3v3__fillcap_16
XFILLER_44_1264 VDD VDD VSS VSS gf180mcu_as_sc_mcu7t3v3__fill_2
XFILLER_131_1256 VDD VDD VSS VSS gf180mcu_as_sc_mcu7t3v3__fillcap_16
XTAP_TAPCELL_ROW_88_3_1999 VDD VSS gf180mcu_as_sc_mcu7t3v3__tap_2
XTAP_TAPCELL_ROW_5_789 VDD VSS gf180mcu_as_sc_mcu7t3v3__tap_2
XTAP_TAPCELL_ROW_5_778 VDD VSS gf180mcu_as_sc_mcu7t3v3__tap_2
XFILLER_44_104 VDD VDD VSS VSS gf180mcu_as_sc_mcu7t3v3__fill_1
XFILLER_111_52 VDD VDD VSS VSS gf180mcu_as_sc_mcu7t3v3__fill_1
XFILLER_158_507 VDD VDD VSS VSS gf180mcu_as_sc_mcu7t3v3__fill_1
XFILLER_164_1065 VDD VDD VSS VSS gf180mcu_as_sc_mcu7t3v3__fill_1
XFILLER_164_1098 VDD VDD VSS VSS gf180mcu_as_sc_mcu7t3v3__fillcap_4
XFILLER_187_34 VDD VDD VSS VSS gf180mcu_as_sc_mcu7t3v3__fillcap_8
XFILLER_185_359 VDD VDD VSS VSS gf180mcu_as_sc_mcu7t3v3__fillcap_8
XFILLER_187_67 VDD VDD VSS VSS gf180mcu_as_sc_mcu7t3v3__fill_2
XPHY_EDGE_ROW_111_1_Right_620 VDD VSS gf180mcu_as_sc_mcu7t3v3__tap_2
XFILLER_153_212 VDD VDD VSS VSS gf180mcu_as_sc_mcu7t3v3__fill_2
XFILLER_154_757 VDD VDD VSS VSS gf180mcu_as_sc_mcu7t3v3__fillcap_16
XPHY_EDGE_ROW_41_3_Right_82 VDD VSS gf180mcu_as_sc_mcu7t3v3__tap_2
XPHY_EDGE_ROW_107_3_Left_479 VDD VSS gf180mcu_as_sc_mcu7t3v3__tap_2
XFILLER_153_278 VDD VDD VSS VSS gf180mcu_as_sc_mcu7t3v3__fill_2
XFILLER_181_598 VDD VDD VSS VSS gf180mcu_as_sc_mcu7t3v3__fillcap_16
X_4740__1032 VDD VDD VSS VSS _4740_/D gf180mcu_as_sc_mcu7t3v3__tiel_4
XFILLER_171_1036 VDD VDD VSS VSS gf180mcu_as_sc_mcu7t3v3__fill_2
XPHY_EDGE_ROW_44_3_Left_416 VDD VSS gf180mcu_as_sc_mcu7t3v3__tap_2
XFILLER_23_1326 VDD VDD VSS VSS gf180mcu_as_sc_mcu7t3v3__fill_2
XFILLER_35_104 VDD VDD VSS VSS gf180mcu_as_sc_mcu7t3v3__fill_1
XTAP_TAPCELL_ROW_163_1346 VDD VSS gf180mcu_as_sc_mcu7t3v3__tap_2
XTAP_TAPCELL_ROW_163_1335 VDD VSS gf180mcu_as_sc_mcu7t3v3__tap_2
XTAP_TAPCELL_ROW_180_1671 VDD VSS gf180mcu_as_sc_mcu7t3v3__tap_2
XTAP_TAPCELL_ROW_180_1660 VDD VSS gf180mcu_as_sc_mcu7t3v3__tap_2
XFILLER_182_1121 VDD VDD VSS VSS gf180mcu_as_sc_mcu7t3v3__fillcap_4
XFILLER_189_632 VDD VDD VSS VSS gf180mcu_as_sc_mcu7t3v3__fill_2
XFILLER_45_90 VDD VDD VSS VSS gf180mcu_as_sc_mcu7t3v3__fillcap_8
X_2900_ VDD VDD VSS VSS _2900_/B _4220_/A _2905_/C gf180mcu_as_sc_mcu7t3v3__and2_2
XFILLER_177_838 VDD VDD VSS VSS gf180mcu_as_sc_mcu7t3v3__fill_2
XFILLER_182_1154 VDD VDD VSS VSS gf180mcu_as_sc_mcu7t3v3__fill_1
X_3880_ VDD VDD VSS VSS _3880_/D _3880_/A _3880_/B _3880_/C _3882_/C gf180mcu_as_sc_mcu7t3v3__ao31_2
XFILLER_182_1187 VDD VDD VSS VSS gf180mcu_as_sc_mcu7t3v3__fill_2
X_2831_ VDD VDD VSS VSS _2891_/B _4152_/A _2832_/D gf180mcu_as_sc_mcu7t3v3__and2_2
XTAP_TAPCELL_ROW_129_1_1082 VDD VSS gf180mcu_as_sc_mcu7t3v3__tap_2
XFILLER_157_562 VDD VDD VSS VSS gf180mcu_as_sc_mcu7t3v3__fillcap_16
X_2762_ VDD VDD VSS VSS _4342_/Q _2826_/B _2988_/A _2808_/D _4342_/D gf180mcu_as_sc_mcu7t3v3__ao22_2
XFILLER_8_561 VDD VDD VSS VSS gf180mcu_as_sc_mcu7t3v3__fill_1
X_4501_ VDD VDD VSS VSS _4708_/CLK _4501_/D _4501_/Q gf180mcu_as_sc_mcu7t3v3__dfxtp_2
XFILLER_172_554 VDD VDD VSS VSS gf180mcu_as_sc_mcu7t3v3__fill_2
XFILLER_8_594 VDD VDD VSS VSS gf180mcu_as_sc_mcu7t3v3__fill_1
X_4432_ VDD VDD VSS VSS clkload9/A _4432_/D _4432_/Q gf180mcu_as_sc_mcu7t3v3__dfxtp_2
X_2693_ VDD VDD VSS VSS _2901_/B _4028_/D _2694_/D gf180mcu_as_sc_mcu7t3v3__and2_2
XFILLER_116_19 VDD VDD VSS VSS gf180mcu_as_sc_mcu7t3v3__fillcap_4
X_4363_ VDD VDD VSS VSS _4429_/CLK _4363_/D _4363_/Q gf180mcu_as_sc_mcu7t3v3__dfxtp_2
XTAP_TAPCELL_ROW_187_1803 VDD VSS gf180mcu_as_sc_mcu7t3v3__tap_2
Xfanout507 VDD VDD VSS VSS wire508/Y _2897_/B gf180mcu_as_sc_mcu7t3v3__buff_12
Xfanout518 VDD VDD VSS VSS _4228_/B _4154_/S gf180mcu_as_sc_mcu7t3v3__buff_12
Xfanout529 VDD VDD VSS VSS _3998_/Y _4268_/B gf180mcu_as_sc_mcu7t3v3__buff_12
X_4294_ VDD VDD VSS VSS _4294_/B _4294_/A _4294_/Y gf180mcu_as_sc_mcu7t3v3__and2_2
X_3314_ VDD VDD VSS VSS _3314_/A _3314_/B _3314_/C _3316_/B _3314_/D gf180mcu_as_sc_mcu7t3v3__aoi31_2
XTAP_TAPCELL_ROW_101_3_2012 VDD VSS gf180mcu_as_sc_mcu7t3v3__tap_2
Xmesh_tile_911 VDD VDD VSS VSS nw_out[11] gf180mcu_as_sc_mcu7t3v3__tiel_4
Xmesh_tile_900 VDD VDD VSS VSS nw_out[0] gf180mcu_as_sc_mcu7t3v3__tiel_4
X_3245_ VDD VDD VSS VSS _3373_/B _4473_/Q _3252_/D gf180mcu_as_sc_mcu7t3v3__and2_2
Xmesh_tile_944 VDD VDD VSS VSS se_out[8] gf180mcu_as_sc_mcu7t3v3__tiel_4
Xmesh_tile_933 VDD VDD VSS VSS nw_out[33] gf180mcu_as_sc_mcu7t3v3__tiel_4
Xmesh_tile_922 VDD VDD VSS VSS nw_out[22] gf180mcu_as_sc_mcu7t3v3__tiel_4
Xmesh_tile_977 VDD VDD VSS VSS sw_out[5] gf180mcu_as_sc_mcu7t3v3__tiel_4
Xmesh_tile_966 VDD VDD VSS VSS se_out[30] gf180mcu_as_sc_mcu7t3v3__tiel_4
Xmesh_tile_955 VDD VDD VSS VSS se_out[19] gf180mcu_as_sc_mcu7t3v3__tiel_4
X_3176_ VDD VDD VSS VSS _3210_/B _3176_/B _3176_/C _3177_/C gf180mcu_as_sc_mcu7t3v3__nor3_2
XTAP_TAPCELL_ROW_2_737 VDD VSS gf180mcu_as_sc_mcu7t3v3__tap_2
XTAP_TAPCELL_ROW_2_726 VDD VSS gf180mcu_as_sc_mcu7t3v3__tap_2
Xmesh_tile_999 VDD VDD VSS VSS sw_out[27] gf180mcu_as_sc_mcu7t3v3__tiel_4
Xmesh_tile_988 VDD VDD VSS VSS sw_out[16] gf180mcu_as_sc_mcu7t3v3__tiel_4
XPHY_EDGE_ROW_150_1_Right_659 VDD VSS gf180mcu_as_sc_mcu7t3v3__tap_2
XPHY_EDGE_ROW_90_3_Left_462 VDD VSS gf180mcu_as_sc_mcu7t3v3__tap_2
XFILLER_126_1325 VDD VDD VSS VSS gf180mcu_as_sc_mcu7t3v3__fill_1
XFILLER_161_1227 VDD VDD VSS VSS gf180mcu_as_sc_mcu7t3v3__fillcap_16
XFILLER_179_153 VDD VDD VSS VSS gf180mcu_as_sc_mcu7t3v3__fillcap_16
XFILLER_161_1249 VDD VDD VSS VSS gf180mcu_as_sc_mcu7t3v3__fill_1
XFILLER_157_37 VDD VDD VSS VSS gf180mcu_as_sc_mcu7t3v3__fill_1
XFILLER_176_893 VDD VDD VSS VSS gf180mcu_as_sc_mcu7t3v3__fillcap_16
XFILLER_159_1189 VDD VDD VSS VSS gf180mcu_as_sc_mcu7t3v3__fill_1
XFILLER_9_6 VDD VDD VSS VSS gf180mcu_as_sc_mcu7t3v3__fill_2
XFILLER_66_78 VDD VDD VSS VSS gf180mcu_as_sc_mcu7t3v3__fillcap_4
XFILLER_17_104 VDD VDD VSS VSS gf180mcu_as_sc_mcu7t3v3__fill_1
XTAP_TAPCELL_ROW_36_3_1947 VDD VSS gf180mcu_as_sc_mcu7t3v3__tap_2
XFILLER_122_84 VDD VDD VSS VSS gf180mcu_as_sc_mcu7t3v3__fill_1
XFILLER_82_33 VDD VDD VSS VSS gf180mcu_as_sc_mcu7t3v3__fill_2
XFILLER_186_613 VDD VDD VSS VSS gf180mcu_as_sc_mcu7t3v3__fillcap_16
X_4758__1014 VDD VDD VSS VSS _4758_/D gf180mcu_as_sc_mcu7t3v3__tiel_4
XFILLER_13_376 VDD VDD VSS VSS gf180mcu_as_sc_mcu7t3v3__fillcap_4
XFILLER_158_348 VDD VDD VSS VSS gf180mcu_as_sc_mcu7t3v3__fillcap_16
XPHY_EDGE_ROW_112_1_Right_621 VDD VSS gf180mcu_as_sc_mcu7t3v3__tap_2
XFILLER_182_874 VDD VDD VSS VSS gf180mcu_as_sc_mcu7t3v3__fill_1
XFILLER_147_92 VDD VDD VSS VSS gf180mcu_as_sc_mcu7t3v3__fill_1
XTAP_TAPCELL_ROW_9_870 VDD VSS gf180mcu_as_sc_mcu7t3v3__tap_2
XTAP_TAPCELL_ROW_182_1711 VDD VSS gf180mcu_as_sc_mcu7t3v3__tap_2
XTAP_TAPCELL_ROW_182_1700 VDD VSS gf180mcu_as_sc_mcu7t3v3__tap_2
Xinput170 VDD VDD VSS VSS nw_in[26] _4219_/A gf180mcu_as_sc_mcu7t3v3__buff_12
Xinput181 VDD VDD VSS VSS nw_in[3] _4032_/A gf180mcu_as_sc_mcu7t3v3__buff_12
X_3030_ VDD VDD VSS VSS _3030_/A _3034_/B _4276_/A _4440_/Q _4440_/D gf180mcu_as_sc_mcu7t3v3__ao22_2
Xinput192 VDD VDD VSS VSS se_in[12] wire798/A gf180mcu_as_sc_mcu7t3v3__buff_12
XFILLER_184_1227 VDD VDD VSS VSS gf180mcu_as_sc_mcu7t3v3__fillcap_16
X_3932_ VDD VDD VSS VSS _3932_/S _3932_/B _3932_/A _3933_/B gf180mcu_as_sc_mcu7t3v3__mux2_2
X_3863_ VDD VDD VSS VSS _4202_/D _3872_/B _3863_/C _3863_/D _3864_/B gf180mcu_as_sc_mcu7t3v3__ao211_2
XFILLER_176_134 VDD VDD VSS VSS gf180mcu_as_sc_mcu7t3v3__fillcap_8
X_2814_ VDD VDD VSS VSS _4136_/A _2904_/B _2814_/C _2900_/B _2816_/C gf180mcu_as_sc_mcu7t3v3__ao211_2
XFILLER_158_871 VDD VDD VSS VSS gf180mcu_as_sc_mcu7t3v3__fillcap_4
XFILLER_176_189 VDD VDD VSS VSS gf180mcu_as_sc_mcu7t3v3__fill_1
X_3794_ VDD VDD VSS VSS _3794_/B _4141_/D _3795_/C gf180mcu_as_sc_mcu7t3v3__and2_2
XFILLER_69_1326 VDD VDD VSS VSS gf180mcu_as_sc_mcu7t3v3__fillcap_4
X_2745_ VDD VDD VSS VSS _2796_/D _2745_/A _2752_/C gf180mcu_as_sc_mcu7t3v3__and2_2
X_2676_ VDD VDD VSS VSS _4013_/D _2901_/C _2676_/C _2676_/D _2678_/C gf180mcu_as_sc_mcu7t3v3__ao211_2
XFILLER_160_524 VDD VDD VSS VSS gf180mcu_as_sc_mcu7t3v3__fill_1
X_4415_ VDD VDD VSS VSS _4447_/CLK _4415_/D _4415_/Q gf180mcu_as_sc_mcu7t3v3__dfxtp_2
X_4346_ VDD VDD VSS VSS _4533_/CLK _4346_/D _4346_/Q gf180mcu_as_sc_mcu7t3v3__dfxtp_2
XTAP_TAPCELL_ROW_7_829 VDD VSS gf180mcu_as_sc_mcu7t3v3__tap_2
XTAP_TAPCELL_ROW_7_818 VDD VSS gf180mcu_as_sc_mcu7t3v3__tap_2
XFILLER_189_1116 VDD VDD VSS VSS gf180mcu_as_sc_mcu7t3v3__fillcap_4
X_4277_ VDD VDD VSS VSS _4278_/B _4278_/A _4287_/A gf180mcu_as_sc_mcu7t3v3__or2_2
XFILLER_189_1138 VDD VDD VSS VSS gf180mcu_as_sc_mcu7t3v3__fill_2
XFILLER_80_1272 VDD VDD VSS VSS gf180mcu_as_sc_mcu7t3v3__fill_2
X_3228_ VDD VDD VSS VSS _3364_/A _3228_/B _3228_/C _3228_/D _4519_/D gf180mcu_as_sc_mcu7t3v3__ao211_2
XFILLER_36_37 VDD VDD VSS VSS gf180mcu_as_sc_mcu7t3v3__fillcap_4
XFILLER_41_1256 VDD VDD VSS VSS gf180mcu_as_sc_mcu7t3v3__fillcap_8
X_3159_ VDD VDD VSS VSS _4294_/A _3159_/B _3159_/A gf180mcu_as_sc_mcu7t3v3__nor2_2
XFILLER_146_6 VDD VDD VSS VSS gf180mcu_as_sc_mcu7t3v3__fillcap_16
XFILLER_161_1068 VDD VDD VSS VSS gf180mcu_as_sc_mcu7t3v3__fillcap_16
XFILLER_10_346 VDD VDD VSS VSS gf180mcu_as_sc_mcu7t3v3__fill_1
XFILLER_6_328 VDD VDD VSS VSS gf180mcu_as_sc_mcu7t3v3__fillcap_4
XFILLER_163_340 VDD VDD VSS VSS gf180mcu_as_sc_mcu7t3v3__fillcap_8
XFILLER_164_874 VDD VDD VSS VSS gf180mcu_as_sc_mcu7t3v3__fill_1
XFILLER_11_1093 VDD VDD VSS VSS gf180mcu_as_sc_mcu7t3v3__fillcap_16
XFILLER_184_68 VDD VDD VSS VSS gf180mcu_as_sc_mcu7t3v3__fill_2
XFILLER_117_40 VDD VDD VSS VSS gf180mcu_as_sc_mcu7t3v3__fillcap_16
XFILLER_172_1131 VDD VDD VSS VSS gf180mcu_as_sc_mcu7t3v3__fillcap_8
XTAP_TAPCELL_ROW_91_1_1044 VDD VSS gf180mcu_as_sc_mcu7t3v3__tap_2
XFILLER_133_72 VDD VDD VSS VSS gf180mcu_as_sc_mcu7t3v3__fillcap_4
Xhold1080 VDD VDD VSS VSS hold1080/A _2330_/A gf180mcu_as_sc_mcu7t3v3__clkbuff_4
Xhold1091 VDD VDD VSS VSS _4822_/Q hold1091/Y gf180mcu_as_sc_mcu7t3v3__clkbuff_4
XFILLER_57_1263 VDD VDD VSS VSS gf180mcu_as_sc_mcu7t3v3__fillcap_16
XFILLER_186_454 VDD VDD VSS VSS gf180mcu_as_sc_mcu7t3v3__fill_1
XTAP_TAPCELL_ROW_158_1245 VDD VSS gf180mcu_as_sc_mcu7t3v3__tap_2
XFILLER_144_1288 VDD VDD VSS VSS gf180mcu_as_sc_mcu7t3v3__fill_1
XFILLER_144_1299 VDD VDD VSS VSS gf180mcu_as_sc_mcu7t3v3__fillcap_4
XTAP_TAPCELL_ROW_158_1256 VDD VSS gf180mcu_as_sc_mcu7t3v3__tap_2
XTAP_TAPCELL_ROW_175_1570 VDD VSS gf180mcu_as_sc_mcu7t3v3__tap_2
XFILLER_6_873 VDD VDD VSS VSS gf180mcu_as_sc_mcu7t3v3__fill_2
X_2530_ VDD VDD VSS VSS _3128_/A _3124_/S _2530_/C _2530_/D _2531_/B gf180mcu_as_sc_mcu7t3v3__ao211_2
XPHY_EDGE_ROW_113_1_Right_622 VDD VSS gf180mcu_as_sc_mcu7t3v3__tap_2
XFILLER_154_373 VDD VDD VSS VSS gf180mcu_as_sc_mcu7t3v3__fillcap_8
X_2461_ VDD VDD VSS VSS _2462_/C _2461_/C _4807_/D _2461_/A gf180mcu_as_sc_mcu7t3v3__aoi21b_2
XTAP_TAPCELL_ROW_171_1489 VDD VSS gf180mcu_as_sc_mcu7t3v3__tap_2
XFILLER_170_866 VDD VDD VSS VSS gf180mcu_as_sc_mcu7t3v3__fillcap_8
XFILLER_177_1097 VDD VDD VSS VSS gf180mcu_as_sc_mcu7t3v3__fillcap_16
X_4200_ VDD VDD VSS VSS _4796_/Q _4208_/B _4208_/C _4200_/D _4201_/C gf180mcu_as_sc_mcu7t3v3__ao22_2
XPHY_EDGE_ROW_49_1_Left_241 VDD VSS gf180mcu_as_sc_mcu7t3v3__tap_2
XFILLER_64_1256 VDD VDD VSS VSS gf180mcu_as_sc_mcu7t3v3__fillcap_16
X_2392_ VDD VDD VSS VSS _3587_/A _4613_/Q _4601_/Q _2394_/B gf180mcu_as_sc_mcu7t3v3__mux2_2
XFILLER_190_1286 VDD VDD VSS VSS gf180mcu_as_sc_mcu7t3v3__fillcap_8
X_4131_ VDD VDD VSS VSS _4131_/B _4131_/A _4708_/D gf180mcu_as_sc_mcu7t3v3__and2_2
XPHY_EDGE_ROW_101_1_Left_293 VDD VSS gf180mcu_as_sc_mcu7t3v3__tap_2
XFILLER_190_1297 VDD VDD VSS VSS gf180mcu_as_sc_mcu7t3v3__fillcap_16
X_4062_ VDD VDD VSS VSS _4062_/A _4225_/B _4217_/C _4062_/D _4063_/B gf180mcu_as_sc_mcu7t3v3__ao22_2
XFILLER_7_1172 VDD VDD VSS VSS gf180mcu_as_sc_mcu7t3v3__fill_1
X_3013_ VDD VDD VSS VSS _3013_/A _3019_/B _3020_/S _4423_/Q _4423_/D gf180mcu_as_sc_mcu7t3v3__ao22_2
XFILLER_188_1171 VDD VDD VSS VSS gf180mcu_as_sc_mcu7t3v3__fillcap_16
XFILLER_36_1303 VDD VDD VSS VSS gf180mcu_as_sc_mcu7t3v3__fill_2
X_3915_ VDD VDD VSS VSS _3919_/C _3928_/B _4254_/A gf180mcu_as_sc_mcu7t3v3__nor2_2
XFILLER_162_1344 VDD VDD VSS VSS gf180mcu_as_sc_mcu7t3v3__fillcap_4
XFILLER_164_104 VDD VDD VSS VSS gf180mcu_as_sc_mcu7t3v3__fill_1
X_3846_ VDD VDD VSS VSS _4187_/A _3872_/B _3846_/C _3847_/C _3846_/D gf180mcu_as_sc_mcu7t3v3__aoi211_2
XFILLER_138_28 VDD VDD VSS VSS gf180mcu_as_sc_mcu7t3v3__fillcap_4
XFILLER_164_115 VDD VDD VSS VSS gf180mcu_as_sc_mcu7t3v3__fillcap_4
XFILLER_164_148 VDD VDD VSS VSS gf180mcu_as_sc_mcu7t3v3__fillcap_16
XFILLER_165_649 VDD VDD VSS VSS gf180mcu_as_sc_mcu7t3v3__fillcap_4
X_3777_ VDD VDD VSS VSS _4125_/A _3876_/B _3777_/C _3876_/D _3779_/C gf180mcu_as_sc_mcu7t3v3__ao211_2
X_2728_ VDD VDD VSS VSS _4779_/Q _2810_/B _2901_/C _4062_/D _2729_/D gf180mcu_as_sc_mcu7t3v3__ao22_2
Xoutput430 VDD VDD VSS VSS _4754_/Q west_out[25] gf180mcu_as_sc_mcu7t3v3__buff_12
Xoutput441 VDD VDD VSS VSS _4732_/Q west_out[3] gf180mcu_as_sc_mcu7t3v3__buff_12
X_2659_ VDD VDD VSS VSS _2659_/B _2659_/A _2659_/Y gf180mcu_as_sc_mcu7t3v3__and2_2
XFILLER_160_376 VDD VDD VSS VSS gf180mcu_as_sc_mcu7t3v3__fillcap_8
XFILLER_160_398 VDD VDD VSS VSS gf180mcu_as_sc_mcu7t3v3__fillcap_8
X_4329_ VDD VDD VSS VSS _4329_/S _4329_/B _4806_/Q _4806_/D gf180mcu_as_sc_mcu7t3v3__mux2_2
XFILLER_170_37 VDD VDD VSS VSS gf180mcu_as_sc_mcu7t3v3__fillcap_4
XFILLER_47_58 VDD VDD VSS VSS gf180mcu_as_sc_mcu7t3v3__fill_1
XFILLER_167_1200 VDD VDD VSS VSS gf180mcu_as_sc_mcu7t3v3__fillcap_4
XFILLER_103_53 VDD VDD VSS VSS gf180mcu_as_sc_mcu7t3v3__fillcap_16
XFILLER_167_1233 VDD VDD VSS VSS gf180mcu_as_sc_mcu7t3v3__fillcap_4
XPHY_EDGE_ROW_50_3_Right_91 VDD VSS gf180mcu_as_sc_mcu7t3v3__tap_2
XPHY_EDGE_ROW_116_3_Left_488 VDD VSS gf180mcu_as_sc_mcu7t3v3__tap_2
XFILLER_179_57 VDD VDD VSS VSS gf180mcu_as_sc_mcu7t3v3__fillcap_8
XFILLER_168_454 VDD VDD VSS VSS gf180mcu_as_sc_mcu7t3v3__fill_1
XFILLER_169_966 VDD VDD VSS VSS gf180mcu_as_sc_mcu7t3v3__fillcap_8
XFILLER_179_79 VDD VDD VSS VSS gf180mcu_as_sc_mcu7t3v3__fill_1
XFILLER_10_132 VDD VDD VSS VSS gf180mcu_as_sc_mcu7t3v3__fill_2
XFILLER_156_616 VDD VDD VSS VSS gf180mcu_as_sc_mcu7t3v3__fillcap_16
XFILLER_168_465 VDD VDD VSS VSS gf180mcu_as_sc_mcu7t3v3__fillcap_4
XPHY_EDGE_ROW_53_3_Left_425 VDD VSS gf180mcu_as_sc_mcu7t3v3__tap_2
XFILLER_11_699 VDD VDD VSS VSS gf180mcu_as_sc_mcu7t3v3__fill_1
XFILLER_155_137 VDD VDD VSS VSS gf180mcu_as_sc_mcu7t3v3__fill_2
XFILLER_184_947 VDD VDD VSS VSS gf180mcu_as_sc_mcu7t3v3__fill_1
XFILLER_152_800 VDD VDD VSS VSS gf180mcu_as_sc_mcu7t3v3__fillcap_16
XFILLER_87_1256 VDD VDD VSS VSS gf180mcu_as_sc_mcu7t3v3__fillcap_8
XTAP_TAPCELL_ROW_153_1153 VDD VSS gf180mcu_as_sc_mcu7t3v3__tap_2
XFILLER_3_832 VDD VDD VSS VSS gf180mcu_as_sc_mcu7t3v3__fill_1
XPHY_EDGE_ROW_157_Right_19 VDD VSS gf180mcu_as_sc_mcu7t3v3__tap_2
XFILLER_2_397 VDD VDD VSS VSS gf180mcu_as_sc_mcu7t3v3__fill_2
Xfanout690 VDD VDD VSS VSS _3126_/B _2425_/B gf180mcu_as_sc_mcu7t3v3__buff_12
XFILLER_24_1284 VDD VDD VSS VSS gf180mcu_as_sc_mcu7t3v3__fillcap_4
Xclkbuf_leaf_36_clk_regs VDD VDD VSS VSS clkbuf_leaf_1_clk_regs/A clkload6/A gf180mcu_as_sc_mcu7t3v3__clkbuff_12
XFILLER_160_92 VDD VDD VSS VSS gf180mcu_as_sc_mcu7t3v3__fillcap_8
XPHY_EDGE_ROW_166_Right_28 VDD VSS gf180mcu_as_sc_mcu7t3v3__tap_2
XTAP_TAPCELL_ROW_177_1610 VDD VSS gf180mcu_as_sc_mcu7t3v3__tap_2
X_3700_ VDD VDD VSS VSS _4056_/A _3799_/B _3798_/B _4055_/A _3701_/D gf180mcu_as_sc_mcu7t3v3__ao22_2
XFILLER_146_104 VDD VDD VSS VSS gf180mcu_as_sc_mcu7t3v3__fill_1
XFILLER_186_273 VDD VDD VSS VSS gf180mcu_as_sc_mcu7t3v3__fill_1
X_4680_ VDD VDD VSS VSS clkload4/A _4680_/D _4680_/Q gf180mcu_as_sc_mcu7t3v3__dfxtp_2
X_3631_ VDD VDD VSS VSS _3968_/B _3957_/B _3633_/A gf180mcu_as_sc_mcu7t3v3__nand2b_2
XTAP_TAPCELL_ROW_173_1529 VDD VSS gf180mcu_as_sc_mcu7t3v3__tap_2
X_3562_ VDD VDD VSS VSS _3563_/C _3602_/C _4622_/Q gf180mcu_as_sc_mcu7t3v3__nor2_2
XTAP_TAPCELL_ROW_190_1854 VDD VSS gf180mcu_as_sc_mcu7t3v3__tap_2
XFILLER_155_671 VDD VDD VSS VSS gf180mcu_as_sc_mcu7t3v3__fillcap_4
XFILLER_161_107 VDD VDD VSS VSS gf180mcu_as_sc_mcu7t3v3__fill_1
X_2513_ VDD VDD VSS VSS _2514_/D _4830_/D _4633_/Q gf180mcu_as_sc_mcu7t3v3__nor2b_2
XTAP_TAPCELL_ROW_190_1865 VDD VSS gf180mcu_as_sc_mcu7t3v3__tap_2
XPHY_EDGE_ROW_175_Right_37 VDD VSS gf180mcu_as_sc_mcu7t3v3__tap_2
X_3493_ VDD VDD VSS VSS _4597_/D _4597_/Q _3503_/B _3493_/C gf180mcu_as_sc_mcu7t3v3__ao21_2
XPHY_EDGE_ROW_114_1_Right_623 VDD VSS gf180mcu_as_sc_mcu7t3v3__tap_2
XFILLER_170_685 VDD VDD VSS VSS gf180mcu_as_sc_mcu7t3v3__fillcap_4
X_2444_ VDD VDD VSS VSS _2444_/D _3071_/A _2492_/B _2444_/C _2446_/C gf180mcu_as_sc_mcu7t3v3__ao31_2
X_2375_ VDD VDD VSS VSS _2376_/C _2437_/B input4/Y _2494_/A gf180mcu_as_sc_mcu7t3v3__ao21_2
XFILLER_155_1192 VDD VDD VSS VSS gf180mcu_as_sc_mcu7t3v3__fillcap_16
X_4114_ VDD VDD VSS VSS _4138_/C _4221_/S _4114_/B _4114_/C _4115_/C gf180mcu_as_sc_mcu7t3v3__ao31_2
XFILLER_83_102 VDD VDD VSS VSS gf180mcu_as_sc_mcu7t3v3__fill_2
X_4045_ VDD VDD VSS VSS _4777_/Q _4134_/B _4217_/C _4045_/D _4046_/C gf180mcu_as_sc_mcu7t3v3__ao22_2
XFILLER_140_18 VDD VDD VSS VSS gf180mcu_as_sc_mcu7t3v3__fillcap_16
XPHY_EDGE_ROW_184_Right_46 VDD VSS gf180mcu_as_sc_mcu7t3v3__tap_2
XFILLER_162_1130 VDD VDD VSS VSS gf180mcu_as_sc_mcu7t3v3__fillcap_8
XFILLER_137_104 VDD VDD VSS VSS gf180mcu_as_sc_mcu7t3v3__fill_1
XFILLER_165_413 VDD VDD VSS VSS gf180mcu_as_sc_mcu7t3v3__fillcap_4
XFILLER_178_763 VDD VDD VSS VSS gf180mcu_as_sc_mcu7t3v3__fill_1
XFILLER_166_947 VDD VDD VSS VSS gf180mcu_as_sc_mcu7t3v3__fillcap_16
XFILLER_177_273 VDD VDD VSS VSS gf180mcu_as_sc_mcu7t3v3__fillcap_4
XFILLER_192_210 VDD VDD VSS VSS gf180mcu_as_sc_mcu7t3v3__fill_2
X_3829_ VDD VDD VSS VSS _3829_/B _3945_/A _4677_/D gf180mcu_as_sc_mcu7t3v3__and2_2
XFILLER_181_906 VDD VDD VSS VSS gf180mcu_as_sc_mcu7t3v3__fillcap_4
XFILLER_181_928 VDD VDD VSS VSS gf180mcu_as_sc_mcu7t3v3__fillcap_4
XFILLER_180_438 VDD VDD VSS VSS gf180mcu_as_sc_mcu7t3v3__fill_1
XFILLER_0_857 VDD VDD VSS VSS gf180mcu_as_sc_mcu7t3v3__fill_2
XFILLER_114_52 VDD VDD VSS VSS gf180mcu_as_sc_mcu7t3v3__fill_2
XFILLER_169_1306 VDD VDD VSS VSS gf180mcu_as_sc_mcu7t3v3__fill_1
XFILLER_181_69 VDD VDD VSS VSS gf180mcu_as_sc_mcu7t3v3__fill_1
XFILLER_169_1328 VDD VDD VSS VSS gf180mcu_as_sc_mcu7t3v3__fill_2
XFILLER_74_45 VDD VDD VSS VSS gf180mcu_as_sc_mcu7t3v3__fillcap_16
XTAP_TAPCELL_ROW_100_1_1053 VDD VSS gf180mcu_as_sc_mcu7t3v3__tap_2
XFILLER_167_1052 VDD VDD VSS VSS gf180mcu_as_sc_mcu7t3v3__fillcap_16
XFILLER_180_1241 VDD VDD VSS VSS gf180mcu_as_sc_mcu7t3v3__fillcap_8
XFILLER_90_33 VDD VDD VSS VSS gf180mcu_as_sc_mcu7t3v3__fill_2
XFILLER_11_441 VDD VDD VSS VSS gf180mcu_as_sc_mcu7t3v3__fill_2
XFILLER_12_942 VDD VDD VSS VSS gf180mcu_as_sc_mcu7t3v3__fill_2
XFILLER_157_903 VDD VDD VSS VSS gf180mcu_as_sc_mcu7t3v3__fillcap_4
XFILLER_180_1263 VDD VDD VSS VSS gf180mcu_as_sc_mcu7t3v3__fillcap_16
XFILLER_156_435 VDD VDD VSS VSS gf180mcu_as_sc_mcu7t3v3__fillcap_16
XFILLER_157_958 VDD VDD VSS VSS gf180mcu_as_sc_mcu7t3v3__fillcap_16
XFILLER_54_1299 VDD VDD VSS VSS gf180mcu_as_sc_mcu7t3v3__fillcap_4
XFILLER_156_457 VDD VDD VSS VSS gf180mcu_as_sc_mcu7t3v3__fillcap_16
XFILLER_183_298 VDD VDD VSS VSS gf180mcu_as_sc_mcu7t3v3__fillcap_16
XFILLER_184_799 VDD VDD VSS VSS gf180mcu_as_sc_mcu7t3v3__fillcap_4
XFILLER_99_64 VDD VDD VSS VSS gf180mcu_as_sc_mcu7t3v3__fillcap_4
XFILLER_152_1321 VDD VDD VSS VSS gf180mcu_as_sc_mcu7t3v3__fillcap_4
XTAP_TAPCELL_ROW_166_1399 VDD VSS gf180mcu_as_sc_mcu7t3v3__tap_2
XFILLER_0_1017 VDD VDD VSS VSS gf180mcu_as_sc_mcu7t3v3__fill_2
XFILLER_0_42 VDD VDD VSS VSS gf180mcu_as_sc_mcu7t3v3__fill_1
XFILLER_179_527 VDD VDD VSS VSS gf180mcu_as_sc_mcu7t3v3__fillcap_16
X_4801_ VDD VDD VSS VSS _4804_/CLK _4801_/D _4801_/Q gf180mcu_as_sc_mcu7t3v3__dfxtp_2
X_2993_ VDD VDD VSS VSS _2993_/A _2993_/B _2993_/C _4405_/Q _4405_/D gf180mcu_as_sc_mcu7t3v3__ao22_2
XFILLER_33_1317 VDD VDD VSS VSS gf180mcu_as_sc_mcu7t3v3__fillcap_4
X_4732_ VDD VDD VSS VSS clkload6/A _4732_/D _4732_/Q gf180mcu_as_sc_mcu7t3v3__dfxtp_2
XTAP_TAPCELL_ROW_192_1905 VDD VSS gf180mcu_as_sc_mcu7t3v3__tap_2
XFILLER_119_104 VDD VDD VSS VSS gf180mcu_as_sc_mcu7t3v3__fill_1
X_4663_ VDD VDD VSS VSS clkload5/A _4663_/D _4663_/Q gf180mcu_as_sc_mcu7t3v3__dfxtp_2
XTAP_TAPCELL_ROW_192_1916 VDD VSS gf180mcu_as_sc_mcu7t3v3__tap_2
XFILLER_9_84 VDD VDD VSS VSS gf180mcu_as_sc_mcu7t3v3__fill_2
XFILLER_163_928 VDD VDD VSS VSS gf180mcu_as_sc_mcu7t3v3__fillcap_8
XFILLER_175_788 VDD VDD VSS VSS gf180mcu_as_sc_mcu7t3v3__fillcap_8
X_3614_ VDD VDD VSS VSS _3614_/Y _3614_/B _4804_/Q gf180mcu_as_sc_mcu7t3v3__nor2b_2
XFILLER_162_438 VDD VDD VSS VSS gf180mcu_as_sc_mcu7t3v3__fillcap_4
XFILLER_174_265 VDD VDD VSS VSS gf180mcu_as_sc_mcu7t3v3__fill_1
XFILLER_174_287 VDD VDD VSS VSS gf180mcu_as_sc_mcu7t3v3__fillcap_4
X_4594_ VDD VDD VSS VSS _4808_/CLK _4594_/D _4594_/Q gf180mcu_as_sc_mcu7t3v3__dfxtp_2
Xmax_cap654 VDD VDD VSS VSS _3641_/Y fanout652/A gf180mcu_as_sc_mcu7t3v3__clkbuff_12
X_3545_ VDD VDD VSS VSS _3553_/C _4616_/Q _3546_/C gf180mcu_as_sc_mcu7t3v3__and2_2
X_3476_ VDD VDD VSS VSS _3477_/B _4593_/Q _3611_/A _3580_/D gf180mcu_as_sc_mcu7t3v3__ao21_2
XPHY_EDGE_ROW_115_1_Right_624 VDD VSS gf180mcu_as_sc_mcu7t3v3__tap_2
XFILLER_192_1167 VDD VDD VSS VSS gf180mcu_as_sc_mcu7t3v3__fillcap_4
X_2427_ VDD VDD VSS VSS _2428_/D _2461_/C _2437_/B _2427_/A gf180mcu_as_sc_mcu7t3v3__aoi21b_2
X_2358_ VDD VDD VSS VSS _2388_/A _2358_/B _2358_/C _2397_/D _2359_/C gf180mcu_as_sc_mcu7t3v3__ao211_2
XFILLER_9_1075 VDD VDD VSS VSS gf180mcu_as_sc_mcu7t3v3__fill_2
X_2289_ VDD VDD VSS VSS _4513_/Q _4511_/Q _4512_/Q _3189_/B gf180mcu_as_sc_mcu7t3v3__nor3_2
X_4028_ VDD VDD VSS VSS _4028_/A _4214_/B _4214_/C _4028_/D _4030_/B gf180mcu_as_sc_mcu7t3v3__ao22_2
XFILLER_129_1301 VDD VDD VSS VSS gf180mcu_as_sc_mcu7t3v3__fill_2
XFILLER_168_1350 VDD VDD VSS VSS gf180mcu_as_sc_mcu7t3v3__fill_1
XTAP_TAPCELL_ROW_0_665 VDD VSS gf180mcu_as_sc_mcu7t3v3__tap_2
XFILLER_44_48 VDD VDD VSS VSS gf180mcu_as_sc_mcu7t3v3__fillcap_16
XFILLER_77_1288 VDD VDD VSS VSS gf180mcu_as_sc_mcu7t3v3__fill_2
XTAP_TAPCELL_ROW_0_698 VDD VSS gf180mcu_as_sc_mcu7t3v3__tap_2
XTAP_TAPCELL_ROW_0_687 VDD VSS gf180mcu_as_sc_mcu7t3v3__tap_2
XTAP_TAPCELL_ROW_0_676 VDD VSS gf180mcu_as_sc_mcu7t3v3__tap_2
XFILLER_100_98 VDD VDD VSS VSS gf180mcu_as_sc_mcu7t3v3__fillcap_4
XTAP_TAPCELL_ROW_11_907 VDD VSS gf180mcu_as_sc_mcu7t3v3__tap_2
XFILLER_10_1103 VDD VDD VSS VSS gf180mcu_as_sc_mcu7t3v3__fill_2
XFILLER_154_939 VDD VDD VSS VSS gf180mcu_as_sc_mcu7t3v3__fillcap_4
XFILLER_166_799 VDD VDD VSS VSS gf180mcu_as_sc_mcu7t3v3__fillcap_4
XFILLER_176_69 VDD VDD VSS VSS gf180mcu_as_sc_mcu7t3v3__fillcap_4
XFILLER_5_938 VDD VDD VSS VSS gf180mcu_as_sc_mcu7t3v3__fillcap_8
XFILLER_175_1343 VDD VDD VSS VSS gf180mcu_as_sc_mcu7t3v3__fillcap_8
XFILLER_171_1218 VDD VDD VSS VSS gf180mcu_as_sc_mcu7t3v3__fillcap_16
XFILLER_69_67 VDD VDD VSS VSS gf180mcu_as_sc_mcu7t3v3__fill_2
XFILLER_141_72 VDD VDD VSS VSS gf180mcu_as_sc_mcu7t3v3__fillcap_8
XFILLER_21_1265 VDD VDD VSS VSS gf180mcu_as_sc_mcu7t3v3__fillcap_8
XFILLER_21_1287 VDD VDD VSS VSS gf180mcu_as_sc_mcu7t3v3__fill_1
XTAP_TAPCELL_ROW_97_3_2008 VDD VSS gf180mcu_as_sc_mcu7t3v3__tap_2
XFILLER_95_1322 VDD VDD VSS VSS gf180mcu_as_sc_mcu7t3v3__fill_2
XFILLER_141_94 VDD VDD VSS VSS gf180mcu_as_sc_mcu7t3v3__fillcap_8
XFILLER_56_1328 VDD VDD VSS VSS gf180mcu_as_sc_mcu7t3v3__fill_2
XTAP_TAPCELL_ROW_161_1296 VDD VSS gf180mcu_as_sc_mcu7t3v3__tap_2
XPHY_EDGE_ROW_58_1_Left_250 VDD VSS gf180mcu_as_sc_mcu7t3v3__tap_2
XFILLER_169_593 VDD VDD VSS VSS gf180mcu_as_sc_mcu7t3v3__fill_2
XFILLER_11_282 VDD VDD VSS VSS gf180mcu_as_sc_mcu7t3v3__fill_2
XFILLER_156_254 VDD VDD VSS VSS gf180mcu_as_sc_mcu7t3v3__fill_2
XFILLER_50_80 VDD VDD VSS VSS gf180mcu_as_sc_mcu7t3v3__fill_1
XFILLER_4_971 VDD VDD VSS VSS gf180mcu_as_sc_mcu7t3v3__fill_2
X_3330_ VDD VDD VSS VSS _3330_/A _3330_/B _3330_/C _3332_/B _3330_/D gf180mcu_as_sc_mcu7t3v3__aoi31_2
X_3261_ VDD VDD VSS VSS _3405_/B _4475_/Q _3268_/D gf180mcu_as_sc_mcu7t3v3__and2_2
XTAP_TAPCELL_ROW_168_1439 VDD VSS gf180mcu_as_sc_mcu7t3v3__tap_2
XFILLER_117_1260 VDD VDD VSS VSS gf180mcu_as_sc_mcu7t3v3__fill_2
XFILLER_152_1140 VDD VDD VSS VSS gf180mcu_as_sc_mcu7t3v3__fillcap_16
X_3192_ VDD VDD VSS VSS _3410_/A _4388_/Q _4417_/Q _3193_/B gf180mcu_as_sc_mcu7t3v3__mux2_2
X_2212_ VDD VDD VSS VSS _2550_/C _4535_/Q gf180mcu_as_sc_mcu7t3v3__inv_2
XTAP_TAPCELL_ROW_185_1753 VDD VSS gf180mcu_as_sc_mcu7t3v3__tap_2
XTAP_TAPCELL_ROW_185_1764 VDD VSS gf180mcu_as_sc_mcu7t3v3__tap_2
XTAP_TAPCELL_ROW_54_3_1965 VDD VSS gf180mcu_as_sc_mcu7t3v3__tap_2
XPHY_EDGE_ROW_130_3_Left_502 VDD VSS gf180mcu_as_sc_mcu7t3v3__tap_2
XFILLER_167_508 VDD VDD VSS VSS gf180mcu_as_sc_mcu7t3v3__fill_1
XFILLER_179_368 VDD VDD VSS VSS gf180mcu_as_sc_mcu7t3v3__fillcap_16
XFILLER_37_1283 VDD VDD VSS VSS gf180mcu_as_sc_mcu7t3v3__fillcap_16
X_2976_ VDD VDD VSS VSS _2976_/Y _4765_/Q _2976_/A gf180mcu_as_sc_mcu7t3v3__nor2b_2
X_4715_ VDD VDD VSS VSS _4727_/CLK _4715_/D _4715_/Q gf180mcu_as_sc_mcu7t3v3__dfxtp_2
X_4646_ VDD VDD VSS VSS _4831_/CLK _4646_/D _4646_/Q gf180mcu_as_sc_mcu7t3v3__dfxtp_2
X_4577_ VDD VDD VSS VSS _4606_/CLK _4577_/D _4577_/Q gf180mcu_as_sc_mcu7t3v3__dfxtp_2
XPHY_EDGE_ROW_100_3_Right_141 VDD VSS gf180mcu_as_sc_mcu7t3v3__tap_2
X_3528_ VDD VDD VSS VSS _3583_/A _3528_/B _3528_/A _3529_/A gf180mcu_as_sc_mcu7t3v3__mux2_2
XPHY_EDGE_ROW_125_3_Left_497 VDD VSS gf180mcu_as_sc_mcu7t3v3__tap_2
XFILLER_83_1270 VDD VDD VSS VSS gf180mcu_as_sc_mcu7t3v3__fill_1
X_3459_ VDD VDD VSS VSS _3504_/C _4468_/Q _3572_/B _4582_/D gf180mcu_as_sc_mcu7t3v3__mux2_2
XPHY_EDGE_ROW_116_1_Right_625 VDD VSS gf180mcu_as_sc_mcu7t3v3__tap_2
XFILLER_44_1276 VDD VDD VSS VSS gf180mcu_as_sc_mcu7t3v3__fill_2
XFILLER_44_1298 VDD VDD VSS VSS gf180mcu_as_sc_mcu7t3v3__fillcap_4
XTAP_TAPCELL_ROW_5_779 VDD VSS gf180mcu_as_sc_mcu7t3v3__tap_2
XPHY_EDGE_ROW_62_3_Left_434 VDD VSS gf180mcu_as_sc_mcu7t3v3__tap_2
XFILLER_176_6 VDD VDD VSS VSS gf180mcu_as_sc_mcu7t3v3__fillcap_16
XFILLER_55_58 VDD VDD VSS VSS gf180mcu_as_sc_mcu7t3v3__fill_2
XFILLER_111_64 VDD VDD VSS VSS gf180mcu_as_sc_mcu7t3v3__fillcap_4
XFILLER_13_514 VDD VDD VSS VSS gf180mcu_as_sc_mcu7t3v3__fill_1
XFILLER_164_1077 VDD VDD VSS VSS gf180mcu_as_sc_mcu7t3v3__fillcap_8
XFILLER_185_349 VDD VDD VSS VSS gf180mcu_as_sc_mcu7t3v3__fill_1
XFILLER_187_46 VDD VDD VSS VSS gf180mcu_as_sc_mcu7t3v3__fill_2
XFILLER_71_57 VDD VDD VSS VSS gf180mcu_as_sc_mcu7t3v3__fillcap_8
XFILLER_103_1326 VDD VDD VSS VSS gf180mcu_as_sc_mcu7t3v3__fill_2
XFILLER_181_511 VDD VDD VSS VSS gf180mcu_as_sc_mcu7t3v3__fillcap_4
XFILLER_5_702 VDD VDD VSS VSS gf180mcu_as_sc_mcu7t3v3__fillcap_16
XFILLER_153_246 VDD VDD VSS VSS gf180mcu_as_sc_mcu7t3v3__fillcap_16
XFILLER_5_768 VDD VDD VSS VSS gf180mcu_as_sc_mcu7t3v3__fill_2
XFILLER_162_791 VDD VDD VSS VSS gf180mcu_as_sc_mcu7t3v3__fill_2
XFILLER_175_1162 VDD VDD VSS VSS gf180mcu_as_sc_mcu7t3v3__fillcap_16
XFILLER_171_1015 VDD VDD VSS VSS gf180mcu_as_sc_mcu7t3v3__fill_1
XFILLER_62_1354 VDD VDD VSS VSS gf180mcu_as_sc_mcu7t3v3__fill_1
Xinput330 VDD VDD VSS VSS west_in[7] _4062_/A gf180mcu_as_sc_mcu7t3v3__buff_12
XFILLER_96_98 VDD VDD VSS VSS gf180mcu_as_sc_mcu7t3v3__fillcap_4
XFILLER_110_1319 VDD VDD VSS VSS gf180mcu_as_sc_mcu7t3v3__fill_2
XTAP_TAPCELL_ROW_163_1347 VDD VSS gf180mcu_as_sc_mcu7t3v3__tap_2
XTAP_TAPCELL_ROW_163_1336 VDD VSS gf180mcu_as_sc_mcu7t3v3__tap_2
XTAP_TAPCELL_ROW_180_1672 VDD VSS gf180mcu_as_sc_mcu7t3v3__tap_2
XTAP_TAPCELL_ROW_180_1661 VDD VSS gf180mcu_as_sc_mcu7t3v3__tap_2
XFILLER_1_1189 VDD VDD VSS VSS gf180mcu_as_sc_mcu7t3v3__fill_1
X_2830_ VDD VDD VSS VSS _2832_/C _4150_/A _2895_/B _2830_/C gf180mcu_as_sc_mcu7t3v3__ao21_2
XFILLER_192_809 VDD VDD VSS VSS gf180mcu_as_sc_mcu7t3v3__fillcap_4
X_2761_ VDD VDD VSS VSS _4090_/A _2796_/D _2761_/C _2761_/D _2988_/A gf180mcu_as_sc_mcu7t3v3__ao22_2
X_4500_ VDD VDD VSS VSS _4708_/CLK _4500_/D _4500_/Q gf180mcu_as_sc_mcu7t3v3__dfxtp_2
X_2692_ VDD VDD VSS VSS _4775_/Q _2810_/B _2902_/C _4028_/A _2694_/C gf180mcu_as_sc_mcu7t3v3__ao22_2
XANTENNA_1 VDD VDD VSS VSS _4693_/D gf180mcu_as_sc_mcu7t3v3__diode_2
X_4431_ VDD VDD VSS VSS _4533_/CLK _4431_/D _4431_/Q gf180mcu_as_sc_mcu7t3v3__dfxtp_2
XFILLER_160_739 VDD VDD VSS VSS gf180mcu_as_sc_mcu7t3v3__fill_1
X_4362_ VDD VDD VSS VSS _4429_/CLK _4362_/D _4362_/Q gf180mcu_as_sc_mcu7t3v3__dfxtp_2
XTAP_TAPCELL_ROW_187_1804 VDD VSS gf180mcu_as_sc_mcu7t3v3__tap_2
XFILLER_152_290 VDD VDD VSS VSS gf180mcu_as_sc_mcu7t3v3__fillcap_4
Xfanout519 VDD VDD VSS VSS fanout520/Y _4187_/B gf180mcu_as_sc_mcu7t3v3__buff_12
X_4293_ VDD VDD VSS VSS _4481_/Q _4293_/B _4293_/C _4294_/B gf180mcu_as_sc_mcu7t3v3__nor3_2
X_3313_ VDD VDD VSS VSS _3314_/D _3313_/B _3314_/A gf180mcu_as_sc_mcu7t3v3__nor2_2
Xmesh_tile_901 VDD VDD VSS VSS nw_out[1] gf180mcu_as_sc_mcu7t3v3__tiel_4
X_3244_ VDD VDD VSS VSS _3340_/A _3244_/B _3244_/C _3244_/D _4521_/D gf180mcu_as_sc_mcu7t3v3__ao211_2
Xmesh_tile_945 VDD VDD VSS VSS se_out[9] gf180mcu_as_sc_mcu7t3v3__tiel_4
Xmesh_tile_934 VDD VDD VSS VSS nw_out[34] gf180mcu_as_sc_mcu7t3v3__tiel_4
Xmesh_tile_923 VDD VDD VSS VSS nw_out[23] gf180mcu_as_sc_mcu7t3v3__tiel_4
Xmesh_tile_912 VDD VDD VSS VSS nw_out[12] gf180mcu_as_sc_mcu7t3v3__tiel_4
XFILLER_132_19 VDD VDD VSS VSS gf180mcu_as_sc_mcu7t3v3__fill_1
Xmesh_tile_978 VDD VDD VSS VSS sw_out[6] gf180mcu_as_sc_mcu7t3v3__tiel_4
Xmesh_tile_967 VDD VDD VSS VSS se_out[31] gf180mcu_as_sc_mcu7t3v3__tiel_4
Xmesh_tile_956 VDD VDD VSS VSS se_out[20] gf180mcu_as_sc_mcu7t3v3__tiel_4
X_3175_ VDD VDD VSS VSS _3514_/B _3373_/B _3412_/A _3175_/D _3176_/C gf180mcu_as_sc_mcu7t3v3__ao22_2
XTAP_TAPCELL_ROW_2_738 VDD VSS gf180mcu_as_sc_mcu7t3v3__tap_2
XTAP_TAPCELL_ROW_2_727 VDD VSS gf180mcu_as_sc_mcu7t3v3__tap_2
Xmesh_tile_989 VDD VDD VSS VSS sw_out[17] gf180mcu_as_sc_mcu7t3v3__tiel_4
XFILLER_167_305 VDD VDD VSS VSS gf180mcu_as_sc_mcu7t3v3__fill_2
XFILLER_179_132 VDD VDD VSS VSS gf180mcu_as_sc_mcu7t3v3__fillcap_8
XFILLER_176_861 VDD VDD VSS VSS gf180mcu_as_sc_mcu7t3v3__fillcap_8
X_2959_ VDD VDD VSS VSS _2998_/A _2966_/A _3029_/A gf180mcu_as_sc_mcu7t3v3__and2_2
XFILLER_163_566 VDD VDD VSS VSS gf180mcu_as_sc_mcu7t3v3__fill_1
XFILLER_190_352 VDD VDD VSS VSS gf180mcu_as_sc_mcu7t3v3__fillcap_4
X_4629_ VDD VDD VSS VSS _4809_/CLK _4629_/D _4629_/Q gf180mcu_as_sc_mcu7t3v3__dfxtp_2
XFILLER_173_26 VDD VDD VSS VSS gf180mcu_as_sc_mcu7t3v3__fill_1
XFILLER_2_716 VDD VDD VSS VSS gf180mcu_as_sc_mcu7t3v3__fill_2
XPHY_EDGE_ROW_101_3_Right_142 VDD VSS gf180mcu_as_sc_mcu7t3v3__tap_2
XPHY_EDGE_ROW_117_1_Right_626 VDD VSS gf180mcu_as_sc_mcu7t3v3__tap_2
XFILLER_106_75 VDD VDD VSS VSS gf180mcu_as_sc_mcu7t3v3__fillcap_4
XFILLER_166_1139 VDD VDD VSS VSS gf180mcu_as_sc_mcu7t3v3__fill_2
XFILLER_122_96 VDD VDD VSS VSS gf180mcu_as_sc_mcu7t3v3__fillcap_8
XFILLER_82_45 VDD VDD VSS VSS gf180mcu_as_sc_mcu7t3v3__fillcap_16
XFILLER_53_1309 VDD VDD VSS VSS gf180mcu_as_sc_mcu7t3v3__fillcap_4
XFILLER_15_72 VDD VDD VSS VSS gf180mcu_as_sc_mcu7t3v3__fillcap_16
XFILLER_167_850 VDD VDD VSS VSS gf180mcu_as_sc_mcu7t3v3__fill_2
XFILLER_12_1017 VDD VDD VSS VSS gf180mcu_as_sc_mcu7t3v3__fillcap_8
XTAP_TAPCELL_ROW_106_3_2017 VDD VSS gf180mcu_as_sc_mcu7t3v3__tap_2
XFILLER_177_1268 VDD VDD VSS VSS gf180mcu_as_sc_mcu7t3v3__fillcap_8
XFILLER_181_352 VDD VDD VSS VSS gf180mcu_as_sc_mcu7t3v3__fillcap_16
XFILLER_154_588 VDD VDD VSS VSS gf180mcu_as_sc_mcu7t3v3__fillcap_4
XTAP_TAPCELL_ROW_9_871 VDD VSS gf180mcu_as_sc_mcu7t3v3__tap_2
XTAP_TAPCELL_ROW_9_860 VDD VSS gf180mcu_as_sc_mcu7t3v3__tap_2
XFILLER_7_1354 VDD VDD VSS VSS gf180mcu_as_sc_mcu7t3v3__fill_1
XTAP_TAPCELL_ROW_182_1701 VDD VSS gf180mcu_as_sc_mcu7t3v3__tap_2
XFILLER_27_1293 VDD VDD VSS VSS gf180mcu_as_sc_mcu7t3v3__fillcap_4
Xinput160 VDD VDD VSS VSS nw_in[17] _4144_/A gf180mcu_as_sc_mcu7t3v3__buff_12
Xinput171 VDD VDD VSS VSS nw_in[27] _4227_/D gf180mcu_as_sc_mcu7t3v3__buff_12
XTAP_TAPCELL_ROW_182_1712 VDD VSS gf180mcu_as_sc_mcu7t3v3__tap_2
XFILLER_149_1304 VDD VDD VSS VSS gf180mcu_as_sc_mcu7t3v3__fillcap_4
XFILLER_188_1353 VDD VDD VSS VSS gf180mcu_as_sc_mcu7t3v3__fill_2
Xinput182 VDD VDD VSS VSS nw_in[4] _4040_/A gf180mcu_as_sc_mcu7t3v3__buff_12
Xinput193 VDD VDD VSS VSS se_in[13] _4113_/A gf180mcu_as_sc_mcu7t3v3__buff_12
XFILLER_149_1326 VDD VDD VSS VSS gf180mcu_as_sc_mcu7t3v3__fillcap_16
XFILLER_184_1206 VDD VDD VSS VSS gf180mcu_as_sc_mcu7t3v3__fill_2
XFILLER_189_441 VDD VDD VSS VSS gf180mcu_as_sc_mcu7t3v3__fillcap_8
X_3931_ VDD VDD VSS VSS _3931_/A _3931_/B _3931_/C _3931_/D _3932_/A gf180mcu_as_sc_mcu7t3v3__ao211_2
X_3862_ VDD VDD VSS VSS _4203_/A _3871_/B _3871_/C _4202_/A _3863_/D gf180mcu_as_sc_mcu7t3v3__ao22_2
XTAP_TAPCELL_ROW_49_3_1960 VDD VSS gf180mcu_as_sc_mcu7t3v3__tap_2
X_2813_ VDD VDD VSS VSS _4133_/A _2902_/B _2813_/C _2813_/D _2814_/C gf180mcu_as_sc_mcu7t3v3__ao211_2
XFILLER_158_883 VDD VDD VSS VSS gf180mcu_as_sc_mcu7t3v3__fill_1
XFILLER_176_168 VDD VDD VSS VSS gf180mcu_as_sc_mcu7t3v3__fillcap_4
XFILLER_192_639 VDD VDD VSS VSS gf180mcu_as_sc_mcu7t3v3__fill_2
X_3793_ VDD VDD VSS VSS _3793_/B _3884_/A _4673_/D gf180mcu_as_sc_mcu7t3v3__and2_2
XFILLER_9_860 VDD VDD VSS VSS gf180mcu_as_sc_mcu7t3v3__fillcap_8
XFILLER_11_19 VDD VDD VSS VSS gf180mcu_as_sc_mcu7t3v3__fillcap_4
XFILLER_121_1256 VDD VDD VSS VSS gf180mcu_as_sc_mcu7t3v3__fillcap_8
XFILLER_160_1294 VDD VDD VSS VSS gf180mcu_as_sc_mcu7t3v3__fill_1
XFILLER_185_680 VDD VDD VSS VSS gf180mcu_as_sc_mcu7t3v3__fillcap_16
X_2744_ VDD VDD VSS VSS _4340_/Q _2826_/B _2986_/A _2808_/D _4340_/D gf180mcu_as_sc_mcu7t3v3__ao22_2
XFILLER_172_341 VDD VDD VSS VSS gf180mcu_as_sc_mcu7t3v3__fill_1
X_2675_ VDD VDD VSS VSS _2901_/B _4012_/D _2676_/D gf180mcu_as_sc_mcu7t3v3__and2_2
X_4414_ VDD VDD VSS VSS _4447_/CLK _4414_/D _4414_/Q gf180mcu_as_sc_mcu7t3v3__dfxtp_2
X_4345_ VDD VDD VSS VSS clkload9/A _4345_/D _4345_/Q gf180mcu_as_sc_mcu7t3v3__dfxtp_2
XTAP_TAPCELL_ROW_7_819 VDD VSS gf180mcu_as_sc_mcu7t3v3__tap_2
XFILLER_100_102 VDD VDD VSS VSS gf180mcu_as_sc_mcu7t3v3__fill_2
X_4276_ VDD VDD VSS VSS _4276_/B _4276_/A _4765_/D gf180mcu_as_sc_mcu7t3v3__and2_2
X_3227_ VDD VDD VSS VSS _4519_/Q _3395_/B _3403_/C _4520_/Q _3228_/C gf180mcu_as_sc_mcu7t3v3__ao22_2
XFILLER_36_27 VDD VDD VSS VSS gf180mcu_as_sc_mcu7t3v3__fillcap_8
X_3158_ VDD VDD VSS VSS _3158_/A _3158_/B _3158_/C _3158_/D _3159_/B gf180mcu_as_sc_mcu7t3v3__nand4_2
XPHY_EDGE_ROW_41_1_Right_550 VDD VSS gf180mcu_as_sc_mcu7t3v3__tap_2
X_3089_ VDD VDD VSS VSS _3091_/A _3090_/C _3090_/B _3483_/S gf180mcu_as_sc_mcu7t3v3__aoi21_2
XFILLER_168_614 VDD VDD VSS VSS gf180mcu_as_sc_mcu7t3v3__fillcap_8
XFILLER_139_6 VDD VDD VSS VSS gf180mcu_as_sc_mcu7t3v3__fillcap_16
XFILLER_161_1047 VDD VDD VSS VSS gf180mcu_as_sc_mcu7t3v3__fill_2
XFILLER_168_37 VDD VDD VSS VSS gf180mcu_as_sc_mcu7t3v3__fillcap_4
XFILLER_52_59 VDD VDD VSS VSS gf180mcu_as_sc_mcu7t3v3__fillcap_16
XFILLER_10_358 VDD VDD VSS VSS gf180mcu_as_sc_mcu7t3v3__fill_2
XFILLER_52_1353 VDD VDD VSS VSS gf180mcu_as_sc_mcu7t3v3__fill_2
Xwire717 VDD VDD VSS VSS _5069_/A _3540_/A gf180mcu_as_sc_mcu7t3v3__clkbuff_12
XFILLER_100_1318 VDD VDD VSS VSS gf180mcu_as_sc_mcu7t3v3__fill_1
XFILLER_191_672 VDD VDD VSS VSS gf180mcu_as_sc_mcu7t3v3__fill_2
XPHY_EDGE_ROW_102_3_Right_143 VDD VSS gf180mcu_as_sc_mcu7t3v3__tap_2
XFILLER_172_1143 VDD VDD VSS VSS gf180mcu_as_sc_mcu7t3v3__fill_2
XFILLER_172_1198 VDD VDD VSS VSS gf180mcu_as_sc_mcu7t3v3__fillcap_16
XPHY_EDGE_ROW_118_1_Right_627 VDD VSS gf180mcu_as_sc_mcu7t3v3__tap_2
XPHY_EDGE_ROW_22_3_Right_63 VDD VSS gf180mcu_as_sc_mcu7t3v3__tap_2
XFILLER_93_33 VDD VDD VSS VSS gf180mcu_as_sc_mcu7t3v3__fillcap_4
Xhold1070 VDD VDD VSS VSS hold1103/Y _4825_/D gf180mcu_as_sc_mcu7t3v3__clkbuff_4
Xhold1081 VDD VDD VSS VSS _2330_/Y hold1081/Y gf180mcu_as_sc_mcu7t3v3__clkbuff_4
Xhold1092 VDD VDD VSS VSS _4825_/Q hold1092/Y gf180mcu_as_sc_mcu7t3v3__clkbuff_4
XFILLER_96_1291 VDD VDD VSS VSS gf180mcu_as_sc_mcu7t3v3__fill_2
XFILLER_159_636 VDD VDD VSS VSS gf180mcu_as_sc_mcu7t3v3__fill_2
XFILLER_144_1256 VDD VDD VSS VSS gf180mcu_as_sc_mcu7t3v3__fill_2
XTAP_TAPCELL_ROW_158_1246 VDD VSS gf180mcu_as_sc_mcu7t3v3__tap_2
XFILLER_13_196 VDD VDD VSS VSS gf180mcu_as_sc_mcu7t3v3__fillcap_4
XTAP_TAPCELL_ROW_158_1257 VDD VSS gf180mcu_as_sc_mcu7t3v3__tap_2
XFILLER_173_138 VDD VDD VSS VSS gf180mcu_as_sc_mcu7t3v3__fill_2
XTAP_TAPCELL_ROW_175_1571 VDD VSS gf180mcu_as_sc_mcu7t3v3__tap_2
XFILLER_155_886 VDD VDD VSS VSS gf180mcu_as_sc_mcu7t3v3__fillcap_4
XFILLER_182_661 VDD VDD VSS VSS gf180mcu_as_sc_mcu7t3v3__fillcap_4
XFILLER_154_363 VDD VDD VSS VSS gf180mcu_as_sc_mcu7t3v3__fill_2
X_2460_ VDD VDD VSS VSS _3071_/A _2460_/B _2460_/C _2489_/A _2462_/B gf180mcu_as_sc_mcu7t3v3__ao211_2
XPHY_EDGE_ROW_80_1_Right_589 VDD VSS gf180mcu_as_sc_mcu7t3v3__tap_2
XFILLER_170_889 VDD VDD VSS VSS gf180mcu_as_sc_mcu7t3v3__fillcap_16
X_4130_ VDD VDD VSS VSS _4131_/B _4229_/D _4138_/B _4130_/A gf180mcu_as_sc_mcu7t3v3__aoi21b_2
X_2391_ VDD VDD VSS VSS _2407_/B _2411_/S _4829_/D _2391_/A gf180mcu_as_sc_mcu7t3v3__aoi21b_2
XFILLER_95_100 VDD VDD VSS VSS gf180mcu_as_sc_mcu7t3v3__fillcap_4
X_4061_ VDD VDD VSS VSS _4779_/Q _4134_/B _4225_/D _4061_/D _4063_/A gf180mcu_as_sc_mcu7t3v3__ao22_2
X_3012_ VDD VDD VSS VSS _3012_/A _3019_/B _3020_/S _4422_/Q _4422_/D gf180mcu_as_sc_mcu7t3v3__ao22_2
XFILLER_184_1003 VDD VDD VSS VSS gf180mcu_as_sc_mcu7t3v3__fillcap_8
XFILLER_149_102 VDD VDD VSS VSS gf180mcu_as_sc_mcu7t3v3__fill_2
X_3914_ VDD VDD VSS VSS _3914_/B _4051_/A _4686_/D gf180mcu_as_sc_mcu7t3v3__and2_2
XFILLER_177_422 VDD VDD VSS VSS gf180mcu_as_sc_mcu7t3v3__fillcap_8
XFILLER_189_282 VDD VDD VSS VSS gf180mcu_as_sc_mcu7t3v3__fillcap_4
X_3845_ VDD VDD VSS VSS _4186_/A _3871_/B _3845_/C _3845_/D _3846_/C gf180mcu_as_sc_mcu7t3v3__ao211_2
XTAP_TAPCELL_ROW_96_1_1049 VDD VSS gf180mcu_as_sc_mcu7t3v3__tap_2
X_3776_ VDD VDD VSS VSS _3875_/B _4124_/D _3777_/C gf180mcu_as_sc_mcu7t3v3__and2_2
X_2727_ VDD VDD VSS VSS _2902_/C _4060_/A _2729_/C gf180mcu_as_sc_mcu7t3v3__and2_2
XPHY_EDGE_ROW_71_3_Left_443 VDD VSS gf180mcu_as_sc_mcu7t3v3__tap_2
XFILLER_161_834 VDD VDD VSS VSS gf180mcu_as_sc_mcu7t3v3__fillcap_4
Xoutput420 VDD VDD VSS VSS _4745_/Q west_out[16] gf180mcu_as_sc_mcu7t3v3__buff_12
Xclkbuf_leaf_6_clk_regs VDD VDD VSS VSS clkbuf_leaf_8_clk_regs/A clkload9/A gf180mcu_as_sc_mcu7t3v3__clkbuff_12
Xoutput431 VDD VDD VSS VSS _4755_/Q west_out[26] gf180mcu_as_sc_mcu7t3v3__buff_12
Xoutput442 VDD VDD VSS VSS _4733_/Q west_out[4] gf180mcu_as_sc_mcu7t3v3__buff_12
X_2658_ VDD VDD VSS VSS _3999_/B _3999_/A _2658_/C _2658_/Y _2658_/D gf180mcu_as_sc_mcu7t3v3__aoi211_2
X_2589_ VDD VDD VSS VSS _4284_/A _3039_/A _2660_/A gf180mcu_as_sc_mcu7t3v3__and2_2
X_4328_ VDD VDD VSS VSS _4328_/B _4328_/A _4805_/D gf180mcu_as_sc_mcu7t3v3__and2_2
X_4259_ VDD VDD VSS VSS _4259_/A _4268_/B _4261_/B _4259_/D _4260_/C gf180mcu_as_sc_mcu7t3v3__ao22_2
XPHY_EDGE_ROW_42_1_Right_551 VDD VSS gf180mcu_as_sc_mcu7t3v3__tap_2
XFILLER_167_1289 VDD VDD VSS VSS gf180mcu_as_sc_mcu7t3v3__fillcap_8
XFILLER_169_912 VDD VDD VSS VSS gf180mcu_as_sc_mcu7t3v3__fillcap_16
XFILLER_169_978 VDD VDD VSS VSS gf180mcu_as_sc_mcu7t3v3__fill_2
XFILLER_179_69 VDD VDD VSS VSS gf180mcu_as_sc_mcu7t3v3__fill_1
XFILLER_184_937 VDD VDD VSS VSS gf180mcu_as_sc_mcu7t3v3__fillcap_8
XFILLER_10_177 VDD VDD VSS VSS gf180mcu_as_sc_mcu7t3v3__fillcap_8
XFILLER_164_661 VDD VDD VSS VSS gf180mcu_as_sc_mcu7t3v3__fillcap_4
XFILLER_104_1295 VDD VDD VSS VSS gf180mcu_as_sc_mcu7t3v3__fill_1
XFILLER_13_1189 VDD VDD VSS VSS gf180mcu_as_sc_mcu7t3v3__fill_1
XFILLER_164_694 VDD VDD VSS VSS gf180mcu_as_sc_mcu7t3v3__fill_1
XTAP_TAPCELL_ROW_153_1154 VDD VSS gf180mcu_as_sc_mcu7t3v3__tap_2
XFILLER_174_1249 VDD VDD VSS VSS gf180mcu_as_sc_mcu7t3v3__fill_1
XFILLER_87_1268 VDD VDD VSS VSS gf180mcu_as_sc_mcu7t3v3__fill_2
XFILLER_3_866 VDD VDD VSS VSS gf180mcu_as_sc_mcu7t3v3__fill_1
XPHY_EDGE_ROW_103_3_Right_144 VDD VSS gf180mcu_as_sc_mcu7t3v3__tap_2
XFILLER_144_94 VDD VDD VSS VSS gf180mcu_as_sc_mcu7t3v3__fillcap_8
Xfanout691 VDD VDD VSS VSS _3530_/D _3611_/C gf180mcu_as_sc_mcu7t3v3__buff_12
XPHY_EDGE_ROW_119_1_Right_628 VDD VSS gf180mcu_as_sc_mcu7t3v3__tap_2
XFILLER_59_1304 VDD VDD VSS VSS gf180mcu_as_sc_mcu7t3v3__fill_1
XFILLER_59_1326 VDD VDD VSS VSS gf180mcu_as_sc_mcu7t3v3__fillcap_4
XTAP_TAPCELL_ROW_177_1600 VDD VSS gf180mcu_as_sc_mcu7t3v3__tap_2
XFILLER_159_433 VDD VDD VSS VSS gf180mcu_as_sc_mcu7t3v3__fillcap_8
XFILLER_183_1091 VDD VDD VSS VSS gf180mcu_as_sc_mcu7t3v3__fill_2
XTAP_TAPCELL_ROW_177_1611 VDD VSS gf180mcu_as_sc_mcu7t3v3__tap_2
XFILLER_159_466 VDD VDD VSS VSS gf180mcu_as_sc_mcu7t3v3__fillcap_16
XFILLER_174_403 VDD VDD VSS VSS gf180mcu_as_sc_mcu7t3v3__fillcap_4
XFILLER_186_263 VDD VDD VSS VSS gf180mcu_as_sc_mcu7t3v3__fillcap_8
XFILLER_179_1105 VDD VDD VSS VSS gf180mcu_as_sc_mcu7t3v3__fill_2
XFILLER_186_285 VDD VDD VSS VSS gf180mcu_as_sc_mcu7t3v3__fill_1
XFILLER_70_1272 VDD VDD VSS VSS gf180mcu_as_sc_mcu7t3v3__fillcap_16
X_3630_ VDD VDD VSS VSS _3633_/B _3968_/A _3957_/B gf180mcu_as_sc_mcu7t3v3__nand2_2
XFILLER_179_1138 VDD VDD VSS VSS gf180mcu_as_sc_mcu7t3v3__fillcap_16
X_3561_ VDD VDD VSS VSS _3602_/C _3580_/C _3571_/C _3561_/A gf180mcu_as_sc_mcu7t3v3__aoi21_2
XTAP_TAPCELL_ROW_190_1855 VDD VSS gf180mcu_as_sc_mcu7t3v3__tap_2
XFILLER_161_119 VDD VDD VSS VSS gf180mcu_as_sc_mcu7t3v3__fill_1
X_2512_ VDD VDD VSS VSS _3540_/A _3585_/A _2569_/B gf180mcu_as_sc_mcu7t3v3__and2_2
XFILLER_154_193 VDD VDD VSS VSS gf180mcu_as_sc_mcu7t3v3__fillcap_8
X_3492_ VDD VDD VSS VSS _4467_/Q _3520_/S _3502_/C _4598_/Q _3493_/C gf180mcu_as_sc_mcu7t3v3__ao22_2
X_2443_ VDD VDD VSS VSS _2491_/S _4528_/Q _4520_/Q _2444_/C gf180mcu_as_sc_mcu7t3v3__mux2_2
X_2374_ VDD VDD VSS VSS _2418_/A _2374_/B _2374_/A _2376_/B gf180mcu_as_sc_mcu7t3v3__mux2_2
XFILLER_190_1095 VDD VDD VSS VSS gf180mcu_as_sc_mcu7t3v3__fill_2
X_4113_ VDD VDD VSS VSS _4114_/C _4113_/C _4154_/S _4113_/A gf180mcu_as_sc_mcu7t3v3__aoi21_2
XFILLER_9_1257 VDD VDD VSS VSS gf180mcu_as_sc_mcu7t3v3__fill_2
XFILLER_42_1352 VDD VDD VSS VSS gf180mcu_as_sc_mcu7t3v3__fill_2
X_4044_ VDD VDD VSS VSS _4044_/A _4214_/B _4214_/C _4044_/D _4046_/B gf180mcu_as_sc_mcu7t3v3__ao22_2
XFILLER_127_1262 VDD VDD VSS VSS gf180mcu_as_sc_mcu7t3v3__fill_1
XFILLER_178_775 VDD VDD VSS VSS gf180mcu_as_sc_mcu7t3v3__fillcap_4
XFILLER_178_786 VDD VDD VSS VSS gf180mcu_as_sc_mcu7t3v3__fillcap_16
X_3828_ VDD VDD VSS VSS _3933_/S _3828_/B _4171_/A _3829_/B gf180mcu_as_sc_mcu7t3v3__mux2_2
XFILLER_165_469 VDD VDD VSS VSS gf180mcu_as_sc_mcu7t3v3__fill_1
XFILLER_180_406 VDD VDD VSS VSS gf180mcu_as_sc_mcu7t3v3__fill_2
XFILLER_192_244 VDD VDD VSS VSS gf180mcu_as_sc_mcu7t3v3__fill_2
X_3759_ VDD VDD VSS VSS _3794_/B _4108_/D _3760_/C gf180mcu_as_sc_mcu7t3v3__and2_2
XFILLER_160_174 VDD VDD VSS VSS gf180mcu_as_sc_mcu7t3v3__fill_1
XFILLER_160_185 VDD VDD VSS VSS gf180mcu_as_sc_mcu7t3v3__fill_1
XFILLER_0_869 VDD VDD VSS VSS gf180mcu_as_sc_mcu7t3v3__fill_2
XFILLER_134_1288 VDD VDD VSS VSS gf180mcu_as_sc_mcu7t3v3__fill_1
XTAP_TAPCELL_ROW_72_3_1983 VDD VSS gf180mcu_as_sc_mcu7t3v3__tap_2
XFILLER_74_79 VDD VDD VSS VSS gf180mcu_as_sc_mcu7t3v3__fill_1
XPHY_EDGE_ROW_43_1_Right_552 VDD VSS gf180mcu_as_sc_mcu7t3v3__tap_2
XFILLER_188_539 VDD VDD VSS VSS gf180mcu_as_sc_mcu7t3v3__fill_1
XFILLER_156_403 VDD VDD VSS VSS gf180mcu_as_sc_mcu7t3v3__fillcap_16
XFILLER_168_263 VDD VDD VSS VSS gf180mcu_as_sc_mcu7t3v3__fill_2
XFILLER_54_1256 VDD VDD VSS VSS gf180mcu_as_sc_mcu7t3v3__fillcap_8
XFILLER_8_914 VDD VDD VSS VSS gf180mcu_as_sc_mcu7t3v3__fillcap_4
XFILLER_180_1297 VDD VDD VSS VSS gf180mcu_as_sc_mcu7t3v3__fillcap_4
XFILLER_23_72 VDD VDD VSS VSS gf180mcu_as_sc_mcu7t3v3__fillcap_4
XFILLER_8_947 VDD VDD VSS VSS gf180mcu_as_sc_mcu7t3v3__fillcap_8
XFILLER_184_756 VDD VDD VSS VSS gf180mcu_as_sc_mcu7t3v3__fill_2
XFILLER_139_83 VDD VDD VSS VSS gf180mcu_as_sc_mcu7t3v3__fillcap_16
XFILLER_183_266 VDD VDD VSS VSS gf180mcu_as_sc_mcu7t3v3__fillcap_8
XFILLER_152_1344 VDD VDD VSS VSS gf180mcu_as_sc_mcu7t3v3__fill_2
XFILLER_26_1325 VDD VDD VSS VSS gf180mcu_as_sc_mcu7t3v3__fill_2
XFILLER_2_184 VDD VDD VSS VSS gf180mcu_as_sc_mcu7t3v3__fillcap_4
XPHY_EDGE_ROW_104_3_Right_145 VDD VSS gf180mcu_as_sc_mcu7t3v3__tap_2
XFILLER_4_1154 VDD VDD VSS VSS gf180mcu_as_sc_mcu7t3v3__fill_1
XFILLER_0_76 VDD VDD VSS VSS gf180mcu_as_sc_mcu7t3v3__fill_1
XFILLER_64_90 VDD VDD VSS VSS gf180mcu_as_sc_mcu7t3v3__fill_2
X_4800_ VDD VDD VSS VSS _4803_/CLK _4800_/D _4800_/Q gf180mcu_as_sc_mcu7t3v3__dfxtp_2
X_2992_ VDD VDD VSS VSS _3023_/A _2993_/B _2993_/C _4404_/Q _4404_/D gf180mcu_as_sc_mcu7t3v3__ao22_2
XFILLER_175_712 VDD VDD VSS VSS gf180mcu_as_sc_mcu7t3v3__fillcap_8
X_4731_ VDD VDD VSS VSS clkload6/A _4731_/D _4731_/Q gf180mcu_as_sc_mcu7t3v3__dfxtp_2
XTAP_TAPCELL_ROW_192_1906 VDD VSS gf180mcu_as_sc_mcu7t3v3__tap_2
XFILLER_9_41 VDD VDD VSS VSS gf180mcu_as_sc_mcu7t3v3__fillcap_8
X_4662_ VDD VDD VSS VSS clkload5/A _4662_/D _4662_/Q gf180mcu_as_sc_mcu7t3v3__dfxtp_2
XTAP_TAPCELL_ROW_192_1917 VDD VSS gf180mcu_as_sc_mcu7t3v3__tap_2
XTAP_TAPCELL_ROW_13_960 VDD VSS gf180mcu_as_sc_mcu7t3v3__tap_2
XFILLER_163_907 VDD VDD VSS VSS gf180mcu_as_sc_mcu7t3v3__fill_2
XFILLER_174_244 VDD VDD VSS VSS gf180mcu_as_sc_mcu7t3v3__fill_1
X_3613_ VDD VDD VSS VSS _3924_/B _3613_/B _3965_/B gf180mcu_as_sc_mcu7t3v3__nor2b_2
XFILLER_162_406 VDD VDD VSS VSS gf180mcu_as_sc_mcu7t3v3__fillcap_4
X_4593_ VDD VDD VSS VSS _4829_/CLK _4593_/D _4593_/Q gf180mcu_as_sc_mcu7t3v3__dfxtp_2
XFILLER_157_1211 VDD VDD VSS VSS gf180mcu_as_sc_mcu7t3v3__fillcap_4
XFILLER_157_1222 VDD VDD VSS VSS gf180mcu_as_sc_mcu7t3v3__fill_2
Xmax_cap644 VDD VDD VSS VSS _3974_/Y fanout642/A gf180mcu_as_sc_mcu7t3v3__clkbuff_12
X_3544_ VDD VDD VSS VSS _3553_/C _3544_/C _3544_/B _3609_/B gf180mcu_as_sc_mcu7t3v3__aoi21_2
XFILLER_171_962 VDD VDD VSS VSS gf180mcu_as_sc_mcu7t3v3__fillcap_16
XFILLER_192_1135 VDD VDD VSS VSS gf180mcu_as_sc_mcu7t3v3__fillcap_4
X_3475_ VDD VDD VSS VSS _3480_/B _3475_/B _4591_/Q _4591_/D gf180mcu_as_sc_mcu7t3v3__mux2_2
XFILLER_153_1119 VDD VDD VSS VSS gf180mcu_as_sc_mcu7t3v3__fill_1
X_2426_ VDD VDD VSS VSS _4552_/Q _3602_/B _2426_/C _2426_/D _2428_/C gf180mcu_as_sc_mcu7t3v3__ao211_2
XTAP_TAPCELL_ROW_105_1_1058 VDD VSS gf180mcu_as_sc_mcu7t3v3__tap_2
XFILLER_56_103 VDD VDD VSS VSS gf180mcu_as_sc_mcu7t3v3__fill_2
X_2357_ VDD VDD VSS VSS _2358_/C _2441_/A _4453_/Q gf180mcu_as_sc_mcu7t3v3__nor2_2
XFILLER_9_1098 VDD VDD VSS VSS gf180mcu_as_sc_mcu7t3v3__fill_1
X_5076_ VDD VDD VSS VSS _5076_/A _5076_/Y gf180mcu_as_sc_mcu7t3v3__buff_2
X_2288_ VDD VDD VSS VSS _4512_/Q _4511_/Q _3178_/B gf180mcu_as_sc_mcu7t3v3__or2_2
X_4027_ VDD VDD VSS VSS _4027_/B _4271_/A _4695_/D gf180mcu_as_sc_mcu7t3v3__and2_2
XFILLER_77_1256 VDD VDD VSS VSS gf180mcu_as_sc_mcu7t3v3__fillcap_16
XTAP_TAPCELL_ROW_0_688 VDD VSS gf180mcu_as_sc_mcu7t3v3__tap_2
XTAP_TAPCELL_ROW_0_677 VDD VSS gf180mcu_as_sc_mcu7t3v3__tap_2
XTAP_TAPCELL_ROW_0_666 VDD VSS gf180mcu_as_sc_mcu7t3v3__tap_2
XFILLER_164_1259 VDD VDD VSS VSS gf180mcu_as_sc_mcu7t3v3__fill_1
XTAP_TAPCELL_ROW_0_699 VDD VSS gf180mcu_as_sc_mcu7t3v3__tap_2
XFILLER_166_734 VDD VDD VSS VSS gf180mcu_as_sc_mcu7t3v3__fill_1
XFILLER_178_594 VDD VDD VSS VSS gf180mcu_as_sc_mcu7t3v3__fill_1
XTAP_TAPCELL_ROW_11_908 VDD VSS gf180mcu_as_sc_mcu7t3v3__tap_2
XFILLER_176_37 VDD VDD VSS VSS gf180mcu_as_sc_mcu7t3v3__fillcap_16
XFILLER_5_928 VDD VDD VSS VSS gf180mcu_as_sc_mcu7t3v3__fill_2
XPHY_EDGE_ROW_31_3_Right_72 VDD VSS gf180mcu_as_sc_mcu7t3v3__tap_2
XFILLER_10_1137 VDD VDD VSS VSS gf180mcu_as_sc_mcu7t3v3__fillcap_4
XFILLER_175_1311 VDD VDD VSS VSS gf180mcu_as_sc_mcu7t3v3__fillcap_8
XFILLER_180_247 VDD VDD VSS VSS gf180mcu_as_sc_mcu7t3v3__fillcap_16
XFILLER_109_86 VDD VDD VSS VSS gf180mcu_as_sc_mcu7t3v3__fill_1
XFILLER_192_36 VDD VDD VSS VSS gf180mcu_as_sc_mcu7t3v3__fillcap_16
XPHY_EDGE_ROW_34_3_Left_406 VDD VSS gf180mcu_as_sc_mcu7t3v3__tap_2
XFILLER_169_1104 VDD VDD VSS VSS gf180mcu_as_sc_mcu7t3v3__fill_2
XFILLER_60_1260 VDD VDD VSS VSS gf180mcu_as_sc_mcu7t3v3__fill_2
XFILLER_85_56 VDD VDD VSS VSS gf180mcu_as_sc_mcu7t3v3__fill_2
XFILLER_169_1126 VDD VDD VSS VSS gf180mcu_as_sc_mcu7t3v3__fill_1
XTAP_TAPCELL_ROW_20_3_1931 VDD VSS gf180mcu_as_sc_mcu7t3v3__tap_2
XFILLER_189_837 VDD VDD VSS VSS gf180mcu_as_sc_mcu7t3v3__fill_2
XPHY_EDGE_ROW_44_1_Right_553 VDD VSS gf180mcu_as_sc_mcu7t3v3__tap_2
XTAP_TAPCELL_ROW_161_1297 VDD VSS gf180mcu_as_sc_mcu7t3v3__tap_2
XFILLER_180_1083 VDD VDD VSS VSS gf180mcu_as_sc_mcu7t3v3__fill_2
XFILLER_156_222 VDD VDD VSS VSS gf180mcu_as_sc_mcu7t3v3__fillcap_16
XFILLER_156_244 VDD VDD VSS VSS gf180mcu_as_sc_mcu7t3v3__fill_1
X_4744__1028 VDD VDD VSS VSS _4744_/D gf180mcu_as_sc_mcu7t3v3__tiel_4
XFILLER_8_755 VDD VDD VSS VSS gf180mcu_as_sc_mcu7t3v3__fill_1
XFILLER_156_266 VDD VDD VSS VSS gf180mcu_as_sc_mcu7t3v3__fillcap_4
XFILLER_172_737 VDD VDD VSS VSS gf180mcu_as_sc_mcu7t3v3__fillcap_8
XFILLER_184_597 VDD VDD VSS VSS gf180mcu_as_sc_mcu7t3v3__fillcap_4
XFILLER_7_254 VDD VDD VSS VSS gf180mcu_as_sc_mcu7t3v3__fill_1
XFILLER_50_92 VDD VDD VSS VSS gf180mcu_as_sc_mcu7t3v3__fillcap_8
XFILLER_153_962 VDD VDD VSS VSS gf180mcu_as_sc_mcu7t3v3__fill_1
XFILLER_153_973 VDD VDD VSS VSS gf180mcu_as_sc_mcu7t3v3__fillcap_4
XFILLER_152_494 VDD VDD VSS VSS gf180mcu_as_sc_mcu7t3v3__fill_2
XPHY_EDGE_ROW_13_Left_206 VDD VSS gf180mcu_as_sc_mcu7t3v3__tap_2
X_3260_ VDD VDD VSS VSS _3340_/A _3260_/B _3260_/C _3260_/D _4523_/D gf180mcu_as_sc_mcu7t3v3__ao211_2
XTAP_TAPCELL_ROW_168_1429 VDD VSS gf180mcu_as_sc_mcu7t3v3__tap_2
X_3191_ VDD VDD VSS VSS _3191_/D _3191_/A _3200_/B _3191_/C _3199_/C gf180mcu_as_sc_mcu7t3v3__ao31_2
X_2211_ VDD VDD VSS VSS _2267_/D _4611_/Q gf180mcu_as_sc_mcu7t3v3__inv_2
XTAP_TAPCELL_ROW_185_1754 VDD VSS gf180mcu_as_sc_mcu7t3v3__tap_2
XFILLER_152_1196 VDD VDD VSS VSS gf180mcu_as_sc_mcu7t3v3__fill_1
XFILLER_187_1204 VDD VDD VSS VSS gf180mcu_as_sc_mcu7t3v3__fill_1
XTAP_TAPCELL_ROW_185_1765 VDD VSS gf180mcu_as_sc_mcu7t3v3__tap_2
XPHY_EDGE_ROW_105_3_Right_146 VDD VSS gf180mcu_as_sc_mcu7t3v3__tap_2
XFILLER_187_1237 VDD VDD VSS VSS gf180mcu_as_sc_mcu7t3v3__fill_1
XFILLER_187_1259 VDD VDD VSS VSS gf180mcu_as_sc_mcu7t3v3__fill_1
XPHY_EDGE_ROW_80_3_Left_452 VDD VSS gf180mcu_as_sc_mcu7t3v3__tap_2
Xclkbuf_leaf_20_clk_regs VDD VDD VSS VSS clkbuf_3_6__f_clk_regs/Y _4828_/CLK gf180mcu_as_sc_mcu7t3v3__clkbuff_12
X_4714_ VDD VDD VSS VSS _4727_/CLK _4714_/D _4714_/Q gf180mcu_as_sc_mcu7t3v3__dfxtp_2
X_2975_ VDD VDD VSS VSS _4389_/Q _2975_/B _3038_/A _2975_/D _4389_/D gf180mcu_as_sc_mcu7t3v3__ao22_2
XTAP_TAPCELL_ROW_124_3_2035 VDD VSS gf180mcu_as_sc_mcu7t3v3__tap_2
XFILLER_175_553 VDD VDD VSS VSS gf180mcu_as_sc_mcu7t3v3__fillcap_4
XFILLER_163_737 VDD VDD VSS VSS gf180mcu_as_sc_mcu7t3v3__fillcap_4
X_4645_ VDD VDD VSS VSS _4831_/CLK _4645_/D _4645_/Q gf180mcu_as_sc_mcu7t3v3__dfxtp_2
XFILLER_159_1328 VDD VDD VSS VSS gf180mcu_as_sc_mcu7t3v3__fill_2
XFILLER_162_247 VDD VDD VSS VSS gf180mcu_as_sc_mcu7t3v3__fillcap_16
XFILLER_175_597 VDD VDD VSS VSS gf180mcu_as_sc_mcu7t3v3__fill_2
X_4576_ VDD VDD VSS VSS _4576_/CLK _4576_/D _4576_/Q gf180mcu_as_sc_mcu7t3v3__dfxtp_2
XFILLER_190_578 VDD VDD VSS VSS gf180mcu_as_sc_mcu7t3v3__fillcap_4
X_3527_ VDD VDD VSS VSS _3527_/D _3527_/A _3527_/B _3527_/C _3528_/B gf180mcu_as_sc_mcu7t3v3__ao31_2
XFILLER_130_100 VDD VDD VSS VSS gf180mcu_as_sc_mcu7t3v3__fillcap_4
XFILLER_157_1052 VDD VDD VSS VSS gf180mcu_as_sc_mcu7t3v3__fill_2
XFILLER_171_781 VDD VDD VSS VSS gf180mcu_as_sc_mcu7t3v3__fillcap_4
XFILLER_1_419 VDD VDD VSS VSS gf180mcu_as_sc_mcu7t3v3__fill_1
X_3458_ VDD VDD VSS VSS _3520_/S _4467_/Q _3458_/A _4581_/D gf180mcu_as_sc_mcu7t3v3__mux2_2
XFILLER_39_49 VDD VDD VSS VSS gf180mcu_as_sc_mcu7t3v3__fillcap_8
X_3389_ VDD VDD VSS VSS _3389_/B _4459_/Q _3396_/D gf180mcu_as_sc_mcu7t3v3__and2_2
X_2409_ VDD VDD VSS VSS _3587_/A _4615_/Q _4603_/Q _2411_/A gf180mcu_as_sc_mcu7t3v3__mux2_2
XPHY_EDGE_ROW_179_Left_371 VDD VSS gf180mcu_as_sc_mcu7t3v3__tap_2
XFILLER_169_6 VDD VDD VSS VSS gf180mcu_as_sc_mcu7t3v3__fillcap_16
XFILLER_168_1192 VDD VDD VSS VSS gf180mcu_as_sc_mcu7t3v3__fill_1
XFILLER_186_807 VDD VDD VSS VSS gf180mcu_as_sc_mcu7t3v3__fillcap_16
XFILLER_9_508 VDD VDD VSS VSS gf180mcu_as_sc_mcu7t3v3__fill_2
XFILLER_16_1324 VDD VDD VSS VSS gf180mcu_as_sc_mcu7t3v3__fillcap_4
XFILLER_185_317 VDD VDD VSS VSS gf180mcu_as_sc_mcu7t3v3__fillcap_4
XFILLER_71_69 VDD VDD VSS VSS gf180mcu_as_sc_mcu7t3v3__fill_1
XFILLER_178_391 VDD VDD VSS VSS gf180mcu_as_sc_mcu7t3v3__fill_2
XFILLER_187_69 VDD VDD VSS VSS gf180mcu_as_sc_mcu7t3v3__fill_1
XPHY_EDGE_ROW_188_Left_380 VDD VSS gf180mcu_as_sc_mcu7t3v3__tap_2
XFILLER_166_575 VDD VDD VSS VSS gf180mcu_as_sc_mcu7t3v3__fillcap_16
XFILLER_154_737 VDD VDD VSS VSS gf180mcu_as_sc_mcu7t3v3__fillcap_4
XFILLER_166_597 VDD VDD VSS VSS gf180mcu_as_sc_mcu7t3v3__fillcap_16
XFILLER_181_523 VDD VDD VSS VSS gf180mcu_as_sc_mcu7t3v3__fillcap_8
XFILLER_1_920 VDD VDD VSS VSS gf180mcu_as_sc_mcu7t3v3__fill_2
Xinput320 VDD VDD VSS VSS west_in[30] _4254_/A gf180mcu_as_sc_mcu7t3v3__buff_12
Xinput331 VDD VDD VSS VSS west_in[8] _4071_/D gf180mcu_as_sc_mcu7t3v3__buff_12
XTAP_TAPCELL_ROW_163_1337 VDD VSS gf180mcu_as_sc_mcu7t3v3__tap_2
XTAP_TAPCELL_ROW_163_1348 VDD VSS gf180mcu_as_sc_mcu7t3v3__tap_2
XTAP_TAPCELL_ROW_180_1673 VDD VSS gf180mcu_as_sc_mcu7t3v3__tap_2
XTAP_TAPCELL_ROW_180_1662 VDD VSS gf180mcu_as_sc_mcu7t3v3__tap_2
XFILLER_182_1112 VDD VDD VSS VSS gf180mcu_as_sc_mcu7t3v3__fillcap_4
XFILLER_188_111 VDD VDD VSS VSS gf180mcu_as_sc_mcu7t3v3__fill_2
XFILLER_189_645 VDD VDD VSS VSS gf180mcu_as_sc_mcu7t3v3__fillcap_16
XPHY_EDGE_ROW_45_1_Right_554 VDD VSS gf180mcu_as_sc_mcu7t3v3__tap_2
XFILLER_176_317 VDD VDD VSS VSS gf180mcu_as_sc_mcu7t3v3__fillcap_16
XFILLER_182_1189 VDD VDD VSS VSS gf180mcu_as_sc_mcu7t3v3__fill_1
XFILLER_157_531 VDD VDD VSS VSS gf180mcu_as_sc_mcu7t3v3__fillcap_16
X_2760_ VDD VDD VSS VSS _2897_/B _4089_/A _2761_/D gf180mcu_as_sc_mcu7t3v3__or2_2
XFILLER_172_501 VDD VDD VSS VSS gf180mcu_as_sc_mcu7t3v3__fillcap_16
X_2691_ VDD VDD VSS VSS _2903_/B _4031_/A _2695_/C gf180mcu_as_sc_mcu7t3v3__and2_2
XANTENNA_2 VDD VDD VSS VSS _4700_/D gf180mcu_as_sc_mcu7t3v3__diode_2
X_4430_ VDD VDD VSS VSS clkload8/A _4430_/D _4430_/Q gf180mcu_as_sc_mcu7t3v3__dfxtp_2
XFILLER_172_556 VDD VDD VSS VSS gf180mcu_as_sc_mcu7t3v3__fill_1
XFILLER_6_53 VDD VDD VSS VSS gf180mcu_as_sc_mcu7t3v3__fill_2
XFILLER_6_75 VDD VDD VSS VSS gf180mcu_as_sc_mcu7t3v3__fillcap_4
XFILLER_160_729 VDD VDD VSS VSS gf180mcu_as_sc_mcu7t3v3__fillcap_4
X_4361_ VDD VDD VSS VSS _4795_/CLK _4361_/D _4361_/Q gf180mcu_as_sc_mcu7t3v3__dfxtp_2
XTAP_TAPCELL_ROW_187_1805 VDD VSS gf180mcu_as_sc_mcu7t3v3__tap_2
XFILLER_154_1247 VDD VDD VSS VSS gf180mcu_as_sc_mcu7t3v3__fillcap_16
XFILLER_67_1288 VDD VDD VSS VSS gf180mcu_as_sc_mcu7t3v3__fillcap_4
Xfanout509 VDD VDD VSS VSS _2914_/B _2900_/B gf180mcu_as_sc_mcu7t3v3__buff_12
X_4292_ VDD VDD VSS VSS _4292_/A _4805_/Q _4292_/C _4293_/C gf180mcu_as_sc_mcu7t3v3__nand3_2
X_3312_ VDD VDD VSS VSS _3312_/S _4372_/Q _4401_/Q _3313_/B gf180mcu_as_sc_mcu7t3v3__mux2_2
Xmesh_tile_902 VDD VDD VSS VSS nw_out[2] gf180mcu_as_sc_mcu7t3v3__tiel_4
X_3243_ VDD VDD VSS VSS _4521_/Q _3315_/B _3315_/C _4522_/Q _3244_/C gf180mcu_as_sc_mcu7t3v3__ao22_2
Xmesh_tile_935 VDD VDD VSS VSS nw_out[35] gf180mcu_as_sc_mcu7t3v3__tiel_4
Xmesh_tile_924 VDD VDD VSS VSS nw_out[24] gf180mcu_as_sc_mcu7t3v3__tiel_4
Xmesh_tile_913 VDD VDD VSS VSS nw_out[13] gf180mcu_as_sc_mcu7t3v3__tiel_4
Xmesh_tile_968 VDD VDD VSS VSS se_out[32] gf180mcu_as_sc_mcu7t3v3__tiel_4
Xmesh_tile_957 VDD VDD VSS VSS se_out[21] gf180mcu_as_sc_mcu7t3v3__tiel_4
Xmesh_tile_946 VDD VDD VSS VSS se_out[10] gf180mcu_as_sc_mcu7t3v3__tiel_4
X_3174_ VDD VDD VSS VSS _3206_/A _3174_/B _3174_/C _3175_/D _3174_/D gf180mcu_as_sc_mcu7t3v3__aoi31_2
XTAP_TAPCELL_ROW_2_728 VDD VSS gf180mcu_as_sc_mcu7t3v3__tap_2
XPHY_EDGE_ROW_106_3_Right_147 VDD VSS gf180mcu_as_sc_mcu7t3v3__tap_2
Xmesh_tile_979 VDD VDD VSS VSS sw_out[7] gf180mcu_as_sc_mcu7t3v3__tiel_4
XFILLER_130_1291 VDD VDD VSS VSS gf180mcu_as_sc_mcu7t3v3__fillcap_8
XFILLER_165_1332 VDD VDD VSS VSS gf180mcu_as_sc_mcu7t3v3__fillcap_16
XFILLER_168_807 VDD VDD VSS VSS gf180mcu_as_sc_mcu7t3v3__fillcap_8
XFILLER_168_829 VDD VDD VSS VSS gf180mcu_as_sc_mcu7t3v3__fillcap_16
X_2958_ VDD VDD VSS VSS _4380_/Q _2965_/B _3028_/A _2965_/D _4380_/D gf180mcu_as_sc_mcu7t3v3__ao22_2
XFILLER_176_873 VDD VDD VSS VSS gf180mcu_as_sc_mcu7t3v3__fill_2
XFILLER_191_854 VDD VDD VSS VSS gf180mcu_as_sc_mcu7t3v3__fill_1
XFILLER_50_1281 VDD VDD VSS VSS gf180mcu_as_sc_mcu7t3v3__fillcap_8
X_4628_ VDD VDD VSS VSS _4809_/CLK _4628_/D _4628_/Q gf180mcu_as_sc_mcu7t3v3__dfxtp_2
X_2889_ VDD VDD VSS VSS _4204_/A _2898_/B _2889_/C _2889_/D _3002_/A gf180mcu_as_sc_mcu7t3v3__ao22_2
XFILLER_85_1311 VDD VDD VSS VSS gf180mcu_as_sc_mcu7t3v3__fillcap_4
XFILLER_11_1298 VDD VDD VSS VSS gf180mcu_as_sc_mcu7t3v3__fill_2
X_4559_ VDD VDD VSS VSS _4728_/CLK _4559_/D _4559_/Q gf180mcu_as_sc_mcu7t3v3__dfxtp_2
XFILLER_170_1071 VDD VDD VSS VSS gf180mcu_as_sc_mcu7t3v3__fillcap_8
XFILLER_122_53 VDD VDD VSS VSS gf180mcu_as_sc_mcu7t3v3__fillcap_4
XFILLER_166_1107 VDD VDD VSS VSS gf180mcu_as_sc_mcu7t3v3__fill_1
XFILLER_13_312 VDD VDD VSS VSS gf180mcu_as_sc_mcu7t3v3__fill_1
XFILLER_158_306 VDD VDD VSS VSS gf180mcu_as_sc_mcu7t3v3__fillcap_8
XFILLER_158_317 VDD VDD VSS VSS gf180mcu_as_sc_mcu7t3v3__fillcap_4
XFILLER_185_114 VDD VDD VSS VSS gf180mcu_as_sc_mcu7t3v3__fillcap_8
XFILLER_185_158 VDD VDD VSS VSS gf180mcu_as_sc_mcu7t3v3__fillcap_4
XFILLER_181_331 VDD VDD VSS VSS gf180mcu_as_sc_mcu7t3v3__fillcap_16
XFILLER_147_72 VDD VDD VSS VSS gf180mcu_as_sc_mcu7t3v3__fillcap_16
XPHY_EDGE_ROW_39_1_Left_231 VDD VSS gf180mcu_as_sc_mcu7t3v3__tap_2
XTAP_TAPCELL_ROW_9_861 VDD VSS gf180mcu_as_sc_mcu7t3v3__tap_2
XFILLER_7_1300 VDD VDD VSS VSS gf180mcu_as_sc_mcu7t3v3__fill_2
XTAP_TAPCELL_ROW_182_1702 VDD VSS gf180mcu_as_sc_mcu7t3v3__tap_2
XFILLER_153_1291 VDD VDD VSS VSS gf180mcu_as_sc_mcu7t3v3__fillcap_16
Xinput150 VDD VDD VSS VSS north_in[8] _4069_/D gf180mcu_as_sc_mcu7t3v3__buff_12
Xinput161 VDD VDD VSS VSS nw_in[18] _4153_/A gf180mcu_as_sc_mcu7t3v3__buff_12
Xinput172 VDD VDD VSS VSS nw_in[28] _4236_/D gf180mcu_as_sc_mcu7t3v3__buff_12
XTAP_TAPCELL_ROW_182_1713 VDD VSS gf180mcu_as_sc_mcu7t3v3__tap_2
Xinput183 VDD VDD VSS VSS nw_in[5] _4048_/A gf180mcu_as_sc_mcu7t3v3__buff_12
Xinput194 VDD VDD VSS VSS se_in[14] _4121_/A gf180mcu_as_sc_mcu7t3v3__buff_12
X_3930_ VDD VDD VSS VSS _3930_/B _4268_/A _3931_/D gf180mcu_as_sc_mcu7t3v3__and2_2
XFILLER_189_453 VDD VDD VSS VSS gf180mcu_as_sc_mcu7t3v3__fill_2
X_3861_ VDD VDD VSS VSS _3861_/D _3870_/A _3861_/B _3861_/C _3863_/C gf180mcu_as_sc_mcu7t3v3__ao31_2
XPHY_EDGE_ROW_46_1_Right_555 VDD VSS gf180mcu_as_sc_mcu7t3v3__tap_2
X_3792_ VDD VDD VSS VSS _3810_/S _3792_/B _4138_/A _3793_/B gf180mcu_as_sc_mcu7t3v3__mux2_2
X_2812_ VDD VDD VSS VSS _4134_/D _2901_/C _2812_/C _2812_/D _2813_/D gf180mcu_as_sc_mcu7t3v3__ao211_2
XFILLER_192_607 VDD VDD VSS VSS gf180mcu_as_sc_mcu7t3v3__fill_1
XFILLER_192_618 VDD VDD VSS VSS gf180mcu_as_sc_mcu7t3v3__fill_1
X_2743_ VDD VDD VSS VSS _4074_/A _2796_/D _2743_/C _2743_/D _2986_/A gf180mcu_as_sc_mcu7t3v3__ao22_2
XFILLER_9_872 VDD VDD VSS VSS gf180mcu_as_sc_mcu7t3v3__fill_2
XFILLER_8_382 VDD VDD VSS VSS gf180mcu_as_sc_mcu7t3v3__fill_2
XFILLER_172_353 VDD VDD VSS VSS gf180mcu_as_sc_mcu7t3v3__fillcap_4
X_2674_ VDD VDD VSS VSS _4773_/Q _2810_/B _2902_/C _4012_/A _2676_/C gf180mcu_as_sc_mcu7t3v3__ao22_2
X_4413_ VDD VDD VSS VSS _4445_/CLK _4413_/D _4413_/Q gf180mcu_as_sc_mcu7t3v3__dfxtp_2
XFILLER_158_1191 VDD VDD VSS VSS gf180mcu_as_sc_mcu7t3v3__fillcap_8
X_4344_ VDD VDD VSS VSS _4533_/CLK _4344_/D _4344_/Q gf180mcu_as_sc_mcu7t3v3__dfxtp_2
XTAP_TAPCELL_ROW_119_3_2030 VDD VSS gf180mcu_as_sc_mcu7t3v3__tap_2
XFILLER_154_1044 VDD VDD VSS VSS gf180mcu_as_sc_mcu7t3v3__fill_1
XFILLER_143_19 VDD VDD VSS VSS gf180mcu_as_sc_mcu7t3v3__fillcap_4
X_4275_ VDD VDD VSS VSS _4275_/B _4765_/Q _4276_/B gf180mcu_as_sc_mcu7t3v3__or2_2
XFILLER_80_1274 VDD VDD VSS VSS gf180mcu_as_sc_mcu7t3v3__fill_1
X_3226_ VDD VDD VSS VSS _3411_/C _3226_/B _3574_/D gf180mcu_as_sc_mcu7t3v3__nor2_2
X_3157_ VDD VDD VSS VSS _3158_/D _4494_/Q _4490_/Q gf180mcu_as_sc_mcu7t3v3__nor2_2
XPHY_EDGE_ROW_40_3_Right_81 VDD VSS gf180mcu_as_sc_mcu7t3v3__tap_2
XPHY_EDGE_ROW_107_3_Right_148 VDD VSS gf180mcu_as_sc_mcu7t3v3__tap_2
XPHY_EDGE_ROW_106_3_Left_478 VDD VSS gf180mcu_as_sc_mcu7t3v3__tap_2
X_3088_ VDD VDD VSS VSS _3093_/S _4480_/Q _3128_/A _4479_/D gf180mcu_as_sc_mcu7t3v3__mux2_2
XPHY_EDGE_ROW_6_Left_199 VDD VSS gf180mcu_as_sc_mcu7t3v3__tap_2
XFILLER_168_626 VDD VDD VSS VSS gf180mcu_as_sc_mcu7t3v3__fill_2
XPHY_EDGE_ROW_43_3_Left_415 VDD VSS gf180mcu_as_sc_mcu7t3v3__tap_2
XFILLER_167_125 VDD VDD VSS VSS gf180mcu_as_sc_mcu7t3v3__fill_2
Xwire707 VDD VDD VSS VSS _5075_/A _3528_/A gf180mcu_as_sc_mcu7t3v3__clkbuff_12
XFILLER_167_158 VDD VDD VSS VSS gf180mcu_as_sc_mcu7t3v3__fillcap_8
XFILLER_100_1308 VDD VDD VSS VSS gf180mcu_as_sc_mcu7t3v3__fillcap_8
XFILLER_182_139 VDD VDD VSS VSS gf180mcu_as_sc_mcu7t3v3__fillcap_4
XFILLER_163_375 VDD VDD VSS VSS gf180mcu_as_sc_mcu7t3v3__fillcap_16
XFILLER_184_37 VDD VDD VSS VSS gf180mcu_as_sc_mcu7t3v3__fillcap_4
XFILLER_117_64 VDD VDD VSS VSS gf180mcu_as_sc_mcu7t3v3__fillcap_4
XFILLER_137_1264 VDD VDD VSS VSS gf180mcu_as_sc_mcu7t3v3__fill_2
XFILLER_137_1286 VDD VDD VSS VSS gf180mcu_as_sc_mcu7t3v3__fillcap_8
XPHY_EDGE_ROW_69_3_Right_110 VDD VSS gf180mcu_as_sc_mcu7t3v3__tap_2
Xhold1060 VDD VDD VSS VSS hold1092/Y _4824_/D gf180mcu_as_sc_mcu7t3v3__clkbuff_4
Xhold1071 VDD VDD VSS VSS hold1102/Y _4814_/D gf180mcu_as_sc_mcu7t3v3__clkbuff_4
Xhold1082 VDD VDD VSS VSS hold1082/A _2331_/B gf180mcu_as_sc_mcu7t3v3__clkbuff_4
Xhold1093 VDD VDD VSS VSS _4823_/Q hold1093/Y gf180mcu_as_sc_mcu7t3v3__clkbuff_4
XFILLER_96_1281 VDD VDD VSS VSS gf180mcu_as_sc_mcu7t3v3__fillcap_8
XFILLER_13_120 VDD VDD VSS VSS gf180mcu_as_sc_mcu7t3v3__fillcap_16
XFILLER_158_103 VDD VDD VSS VSS gf180mcu_as_sc_mcu7t3v3__fill_2
XFILLER_187_924 VDD VDD VSS VSS gf180mcu_as_sc_mcu7t3v3__fillcap_8
XFILLER_174_629 VDD VDD VSS VSS gf180mcu_as_sc_mcu7t3v3__fillcap_8
XTAP_TAPCELL_ROW_158_1247 VDD VSS gf180mcu_as_sc_mcu7t3v3__tap_2
XFILLER_10_871 VDD VDD VSS VSS gf180mcu_as_sc_mcu7t3v3__fillcap_4
XTAP_TAPCELL_ROW_62_1_1015 VDD VSS gf180mcu_as_sc_mcu7t3v3__tap_2
XTAP_TAPCELL_ROW_175_1572 VDD VSS gf180mcu_as_sc_mcu7t3v3__tap_2
XFILLER_170_802 VDD VDD VSS VSS gf180mcu_as_sc_mcu7t3v3__fill_2
XFILLER_6_831 VDD VDD VSS VSS gf180mcu_as_sc_mcu7t3v3__fillcap_4
XFILLER_177_1066 VDD VDD VSS VSS gf180mcu_as_sc_mcu7t3v3__fillcap_4
XFILLER_181_194 VDD VDD VSS VSS gf180mcu_as_sc_mcu7t3v3__fill_1
XFILLER_174_81 VDD VDD VSS VSS gf180mcu_as_sc_mcu7t3v3__fillcap_16
XFILLER_190_1222 VDD VDD VSS VSS gf180mcu_as_sc_mcu7t3v3__fill_2
X_2390_ VDD VDD VSS VSS _2390_/Y _2390_/C _2455_/A _2390_/A gf180mcu_as_sc_mcu7t3v3__aoi21b_2
XFILLER_3_65 VDD VDD VSS VSS gf180mcu_as_sc_mcu7t3v3__fillcap_4
X_4060_ VDD VDD VSS VSS _4060_/A _4231_/B _4224_/C _4060_/D _4061_/D gf180mcu_as_sc_mcu7t3v3__ao22_2
XFILLER_7_1196 VDD VDD VSS VSS gf180mcu_as_sc_mcu7t3v3__fill_2
X_3011_ VDD VDD VSS VSS _3011_/A _3019_/B _3020_/S _4421_/Q _4421_/D gf180mcu_as_sc_mcu7t3v3__ao22_2
XFILLER_75_1310 VDD VDD VSS VSS gf180mcu_as_sc_mcu7t3v3__fill_2
XFILLER_162_1313 VDD VDD VSS VSS gf180mcu_as_sc_mcu7t3v3__fillcap_16
XFILLER_178_935 VDD VDD VSS VSS gf180mcu_as_sc_mcu7t3v3__fillcap_8
X_3913_ VDD VDD VSS VSS _3933_/S _3913_/B _4240_/A _3914_/B gf180mcu_as_sc_mcu7t3v3__mux2_2
XFILLER_178_957 VDD VDD VSS VSS gf180mcu_as_sc_mcu7t3v3__fill_2
X_3844_ VDD VDD VSS VSS _3844_/D _3870_/A _3844_/B _3844_/C _3845_/D gf180mcu_as_sc_mcu7t3v3__ao31_2
XFILLER_165_618 VDD VDD VSS VSS gf180mcu_as_sc_mcu7t3v3__fill_2
XPHY_EDGE_ROW_47_1_Right_556 VDD VSS gf180mcu_as_sc_mcu7t3v3__tap_2
XFILLER_192_415 VDD VDD VSS VSS gf180mcu_as_sc_mcu7t3v3__fillcap_4
XFILLER_192_448 VDD VDD VSS VSS gf180mcu_as_sc_mcu7t3v3__fill_2
X_3775_ VDD VDD VSS VSS _4123_/A _3855_/B _3775_/C _4671_/D _4138_/C gf180mcu_as_sc_mcu7t3v3__aoi211_2
XFILLER_161_802 VDD VDD VSS VSS gf180mcu_as_sc_mcu7t3v3__fillcap_16
X_2726_ VDD VDD VSS VSS _4338_/Q _2772_/B _2984_/A _2772_/D _4338_/D gf180mcu_as_sc_mcu7t3v3__ao22_2
Xoutput410 VDD VDD VSS VSS _4664_/Q south_out[7] gf180mcu_as_sc_mcu7t3v3__buff_12
X_2657_ VDD VDD VSS VSS _2900_/B _4008_/D _2670_/D gf180mcu_as_sc_mcu7t3v3__and2_2
Xoutput421 VDD VDD VSS VSS _4746_/Q west_out[17] gf180mcu_as_sc_mcu7t3v3__buff_12
Xoutput432 VDD VDD VSS VSS _4756_/Q west_out[27] gf180mcu_as_sc_mcu7t3v3__buff_12
Xoutput443 VDD VDD VSS VSS _4734_/Q west_out[5] gf180mcu_as_sc_mcu7t3v3__buff_12
X_2588_ VDD VDD VSS VSS _4288_/C _4768_/Q _4769_/Q gf180mcu_as_sc_mcu7t3v3__nor2_2
X_4757__1015 VDD VDD VSS VSS _4757_/D gf180mcu_as_sc_mcu7t3v3__tiel_4
X_4327_ VDD VDD VSS VSS _4328_/B _4805_/Q _4327_/A gf180mcu_as_sc_mcu7t3v3__nor2_2
XFILLER_47_27 VDD VDD VSS VSS gf180mcu_as_sc_mcu7t3v3__fill_2
X_4258_ VDD VDD VSS VSS _4258_/A _4265_/B _4258_/C _4261_/B _4258_/D gf180mcu_as_sc_mcu7t3v3__aoi211_2
X_3209_ VDD VDD VSS VSS _3210_/C _3209_/C _3209_/B _3218_/B gf180mcu_as_sc_mcu7t3v3__aoi21_2
X_4189_ VDD VDD VSS VSS _4795_/Q _4244_/C _4226_/B _4189_/D _4194_/C gf180mcu_as_sc_mcu7t3v3__ao22_2
XFILLER_167_1213 VDD VDD VSS VSS gf180mcu_as_sc_mcu7t3v3__fill_2
XPHY_EDGE_ROW_108_3_Right_149 VDD VSS gf180mcu_as_sc_mcu7t3v3__tap_2
XFILLER_103_88 VDD VDD VSS VSS gf180mcu_as_sc_mcu7t3v3__fillcap_16
XFILLER_151_6 VDD VDD VSS VSS gf180mcu_as_sc_mcu7t3v3__fillcap_16
XFILLER_179_48 VDD VDD VSS VSS gf180mcu_as_sc_mcu7t3v3__fill_2
XFILLER_10_134 VDD VDD VSS VSS gf180mcu_as_sc_mcu7t3v3__fill_1
XFILLER_13_1124 VDD VDD VSS VSS gf180mcu_as_sc_mcu7t3v3__fill_1
XFILLER_17_1271 VDD VDD VSS VSS gf180mcu_as_sc_mcu7t3v3__fill_2
XFILLER_7_628 VDD VDD VSS VSS gf180mcu_as_sc_mcu7t3v3__fill_2
XFILLER_155_139 VDD VDD VSS VSS gf180mcu_as_sc_mcu7t3v3__fill_1
XFILLER_139_1326 VDD VDD VSS VSS gf180mcu_as_sc_mcu7t3v3__fillcap_4
XFILLER_191_470 VDD VDD VSS VSS gf180mcu_as_sc_mcu7t3v3__fillcap_16
XFILLER_3_812 VDD VDD VSS VSS gf180mcu_as_sc_mcu7t3v3__fillcap_16
XTAP_TAPCELL_ROW_153_1155 VDD VSS gf180mcu_as_sc_mcu7t3v3__tap_2
XTAP_TAPCELL_ROW_153_1144 VDD VSS gf180mcu_as_sc_mcu7t3v3__tap_2
XFILLER_128_85 VDD VDD VSS VSS gf180mcu_as_sc_mcu7t3v3__fillcap_16
XFILLER_152_868 VDD VDD VSS VSS gf180mcu_as_sc_mcu7t3v3__fill_2
XFILLER_191_492 VDD VDD VSS VSS gf180mcu_as_sc_mcu7t3v3__fillcap_16
XTAP_TAPCELL_ROW_170_1480 VDD VSS gf180mcu_as_sc_mcu7t3v3__tap_2
XFILLER_5_2 VDD VDD VSS VSS gf180mcu_as_sc_mcu7t3v3__fillcap_16
XTAP_TAPCELL_ROW_123_1_1076 VDD VSS gf180mcu_as_sc_mcu7t3v3__tap_2
XFILLER_2_399 VDD VDD VSS VSS gf180mcu_as_sc_mcu7t3v3__fill_1
Xfanout670 VDD VDD VSS VSS _3450_/Y _3544_/C gf180mcu_as_sc_mcu7t3v3__buff_12
Xfanout681 VDD VDD VSS VSS _3927_/B _3852_/B gf180mcu_as_sc_mcu7t3v3__buff_12
Xfanout692 VDD VDD VSS VSS wire695/A _3890_/S gf180mcu_as_sc_mcu7t3v3__buff_12
XFILLER_111_1267 VDD VDD VSS VSS gf180mcu_as_sc_mcu7t3v3__fill_2
XFILLER_146_1308 VDD VDD VSS VSS gf180mcu_as_sc_mcu7t3v3__fill_1
XTAP_TAPCELL_ROW_177_1601 VDD VSS gf180mcu_as_sc_mcu7t3v3__tap_2
XFILLER_159_445 VDD VDD VSS VSS gf180mcu_as_sc_mcu7t3v3__fill_2
XFILLER_187_754 VDD VDD VSS VSS gf180mcu_as_sc_mcu7t3v3__fill_2
XTAP_TAPCELL_ROW_177_1612 VDD VSS gf180mcu_as_sc_mcu7t3v3__tap_2
XFILLER_186_231 VDD VDD VSS VSS gf180mcu_as_sc_mcu7t3v3__fill_2
XFILLER_174_437 VDD VDD VSS VSS gf180mcu_as_sc_mcu7t3v3__fillcap_16
XFILLER_70_1295 VDD VDD VSS VSS gf180mcu_as_sc_mcu7t3v3__fill_2
X_3560_ VDD VDD VSS VSS _3580_/A _3580_/B _3580_/D _3560_/D _3571_/C gf180mcu_as_sc_mcu7t3v3__ao211_2
XFILLER_183_982 VDD VDD VSS VSS gf180mcu_as_sc_mcu7t3v3__fillcap_16
XFILLER_6_661 VDD VDD VSS VSS gf180mcu_as_sc_mcu7t3v3__fillcap_4
Xmax_cap804 VDD VDD VSS VSS _4272_/C _4204_/C gf180mcu_as_sc_mcu7t3v3__clkbuff_12
X_2511_ VDD VDD VSS VSS _4292_/C _4587_/Q _2563_/D _3571_/D _2519_/C gf180mcu_as_sc_mcu7t3v3__ao211_2
XTAP_TAPCELL_ROW_190_1856 VDD VSS gf180mcu_as_sc_mcu7t3v3__tap_2
XFILLER_170_632 VDD VDD VSS VSS gf180mcu_as_sc_mcu7t3v3__fillcap_4
XFILLER_192_1328 VDD VDD VSS VSS gf180mcu_as_sc_mcu7t3v3__fillcap_16
X_3491_ VDD VDD VSS VSS _4596_/D _4596_/Q _3503_/B _3491_/C gf180mcu_as_sc_mcu7t3v3__ao21_2
XTAP_TAPCELL_ROW_26_1_979 VDD VSS gf180mcu_as_sc_mcu7t3v3__tap_2
X_2442_ VDD VDD VSS VSS _2444_/D _2442_/C _2490_/B _2442_/A gf180mcu_as_sc_mcu7t3v3__aoi21b_2
XFILLER_155_1161 VDD VDD VSS VSS gf180mcu_as_sc_mcu7t3v3__fill_1
X_2373_ VDD VDD VSS VSS _2425_/B _4481_/Q _4545_/Q _2374_/B gf180mcu_as_sc_mcu7t3v3__mux2_2
X_4112_ VDD VDD VSS VSS _4112_/A _4143_/B _4153_/B _4112_/D _4113_/C gf180mcu_as_sc_mcu7t3v3__ao22_2
XFILLER_83_104 VDD VDD VSS VSS gf180mcu_as_sc_mcu7t3v3__fill_1
X_4043_ VDD VDD VSS VSS _4043_/B _4213_/A _4697_/D gf180mcu_as_sc_mcu7t3v3__and2_2
XFILLER_177_220 VDD VDD VSS VSS gf180mcu_as_sc_mcu7t3v3__fill_2
XFILLER_178_732 VDD VDD VSS VSS gf180mcu_as_sc_mcu7t3v3__fill_2
XFILLER_192_212 VDD VDD VSS VSS gf180mcu_as_sc_mcu7t3v3__fill_1
X_3827_ VDD VDD VSS VSS _4170_/A _3872_/B _3827_/C _3827_/D _3828_/B gf180mcu_as_sc_mcu7t3v3__ao211_2
XPHY_EDGE_ROW_48_1_Right_557 VDD VSS gf180mcu_as_sc_mcu7t3v3__tap_2
XFILLER_165_459 VDD VDD VSS VSS gf180mcu_as_sc_mcu7t3v3__fillcap_8
X_3758_ VDD VDD VSS VSS _3798_/B _4112_/A _3764_/C gf180mcu_as_sc_mcu7t3v3__and2_2
XFILLER_192_278 VDD VDD VSS VSS gf180mcu_as_sc_mcu7t3v3__fill_2
X_2709_ VDD VDD VSS VSS _2903_/B _4047_/A _2713_/C gf180mcu_as_sc_mcu7t3v3__and2_2
XFILLER_161_632 VDD VDD VSS VSS gf180mcu_as_sc_mcu7t3v3__fillcap_4
XFILLER_173_481 VDD VDD VSS VSS gf180mcu_as_sc_mcu7t3v3__fillcap_8
XFILLER_173_492 VDD VDD VSS VSS gf180mcu_as_sc_mcu7t3v3__fillcap_16
X_3689_ VDD VDD VSS VSS _4777_/Q _3927_/B _3689_/C _3689_/D _3690_/C gf180mcu_as_sc_mcu7t3v3__ao22_2
XFILLER_0_804 VDD VDD VSS VSS gf180mcu_as_sc_mcu7t3v3__fill_1
XFILLER_160_142 VDD VDD VSS VSS gf180mcu_as_sc_mcu7t3v3__fill_1
XFILLER_0_815 VDD VDD VSS VSS gf180mcu_as_sc_mcu7t3v3__fill_1
XFILLER_58_37 VDD VDD VSS VSS gf180mcu_as_sc_mcu7t3v3__fillcap_16
XFILLER_86_1291 VDD VDD VSS VSS gf180mcu_as_sc_mcu7t3v3__fillcap_4
XFILLER_134_1256 VDD VDD VSS VSS gf180mcu_as_sc_mcu7t3v3__fillcap_16
XFILLER_173_1294 VDD VDD VSS VSS gf180mcu_as_sc_mcu7t3v3__fillcap_16
XPHY_EDGE_ROW_160_Left_352 VDD VSS gf180mcu_as_sc_mcu7t3v3__tap_2
XFILLER_114_65 VDD VDD VSS VSS gf180mcu_as_sc_mcu7t3v3__fill_1
XFILLER_167_1010 VDD VDD VSS VSS gf180mcu_as_sc_mcu7t3v3__fillcap_8
XPHY_EDGE_ROW_48_1_Left_240 VDD VSS gf180mcu_as_sc_mcu7t3v3__tap_2
XFILLER_106_1303 VDD VDD VSS VSS gf180mcu_as_sc_mcu7t3v3__fill_2
XFILLER_12_944 VDD VDD VSS VSS gf180mcu_as_sc_mcu7t3v3__fill_1
XFILLER_12_955 VDD VDD VSS VSS gf180mcu_as_sc_mcu7t3v3__fill_2
XTAP_TAPCELL_ROW_142_3_2053 VDD VSS gf180mcu_as_sc_mcu7t3v3__tap_2
XPHY_EDGE_ROW_100_1_Left_292 VDD VSS gf180mcu_as_sc_mcu7t3v3__tap_2
XFILLER_183_212 VDD VDD VSS VSS gf180mcu_as_sc_mcu7t3v3__fillcap_16
XFILLER_7_403 VDD VDD VSS VSS gf180mcu_as_sc_mcu7t3v3__fill_1
XFILLER_8_926 VDD VDD VSS VSS gf180mcu_as_sc_mcu7t3v3__fillcap_16
XFILLER_139_51 VDD VDD VSS VSS gf180mcu_as_sc_mcu7t3v3__fillcap_16
XTAP_TAPCELL_ROW_172_1520 VDD VSS gf180mcu_as_sc_mcu7t3v3__tap_2
XFILLER_165_982 VDD VDD VSS VSS gf180mcu_as_sc_mcu7t3v3__fillcap_16
XFILLER_171_429 VDD VDD VSS VSS gf180mcu_as_sc_mcu7t3v3__fill_1
XFILLER_183_278 VDD VDD VSS VSS gf180mcu_as_sc_mcu7t3v3__fill_2
XFILLER_180_974 VDD VDD VSS VSS gf180mcu_as_sc_mcu7t3v3__fill_1
XFILLER_99_99 VDD VDD VSS VSS gf180mcu_as_sc_mcu7t3v3__fillcap_4
XFILLER_2_163 VDD VDD VSS VSS gf180mcu_as_sc_mcu7t3v3__fillcap_8
XTAP_TAPCELL_ROW_57_1_1010 VDD VSS gf180mcu_as_sc_mcu7t3v3__tap_2
XFILLER_0_1019 VDD VDD VSS VSS gf180mcu_as_sc_mcu7t3v3__fill_1
XFILLER_181_1018 VDD VDD VSS VSS gf180mcu_as_sc_mcu7t3v3__fill_2
XFILLER_185_1187 VDD VDD VSS VSS gf180mcu_as_sc_mcu7t3v3__fill_2
X_2991_ VDD VDD VSS VSS _3022_/A _2993_/B _2993_/C _4403_/Q _4403_/D gf180mcu_as_sc_mcu7t3v3__ao22_2
XFILLER_159_231 VDD VDD VSS VSS gf180mcu_as_sc_mcu7t3v3__fillcap_8
XFILLER_187_540 VDD VDD VSS VSS gf180mcu_as_sc_mcu7t3v3__fillcap_8
XFILLER_187_562 VDD VDD VSS VSS gf180mcu_as_sc_mcu7t3v3__fillcap_16
X_4730_ VDD VDD VSS VSS clkload6/A _4730_/D _4730_/Q gf180mcu_as_sc_mcu7t3v3__dfxtp_2
XFILLER_9_53 VDD VDD VSS VSS gf180mcu_as_sc_mcu7t3v3__fill_2
XFILLER_174_212 VDD VDD VSS VSS gf180mcu_as_sc_mcu7t3v3__fill_1
X_4661_ VDD VDD VSS VSS clkload5/A _4661_/D _4661_/Q gf180mcu_as_sc_mcu7t3v3__dfxtp_2
XTAP_TAPCELL_ROW_192_1918 VDD VSS gf180mcu_as_sc_mcu7t3v3__tap_2
XTAP_TAPCELL_ROW_192_1907 VDD VSS gf180mcu_as_sc_mcu7t3v3__tap_2
XTAP_TAPCELL_ROW_13_961 VDD VSS gf180mcu_as_sc_mcu7t3v3__tap_2
XTAP_TAPCELL_ROW_13_950 VDD VSS gf180mcu_as_sc_mcu7t3v3__tap_2
XFILLER_9_86 VDD VDD VSS VSS gf180mcu_as_sc_mcu7t3v3__fill_1
XFILLER_175_768 VDD VDD VSS VSS gf180mcu_as_sc_mcu7t3v3__fill_2
X_3612_ VDD VDD VSS VSS _4649_/Q _3612_/B _4656_/Q _4656_/D gf180mcu_as_sc_mcu7t3v3__mux2_2
XFILLER_156_960 VDD VDD VSS VSS gf180mcu_as_sc_mcu7t3v3__fillcap_16
X_4592_ VDD VDD VSS VSS _4829_/CLK _4592_/D _4592_/Q gf180mcu_as_sc_mcu7t3v3__dfxtp_2
XFILLER_155_470 VDD VDD VSS VSS gf180mcu_as_sc_mcu7t3v3__fillcap_16
XFILLER_155_492 VDD VDD VSS VSS gf180mcu_as_sc_mcu7t3v3__fillcap_16
XFILLER_190_749 VDD VDD VSS VSS gf180mcu_as_sc_mcu7t3v3__fillcap_4
XFILLER_192_1103 VDD VDD VSS VSS gf180mcu_as_sc_mcu7t3v3__fillcap_4
Xmax_cap634 VDD VDD VSS VSS _2663_/Y fanout632/A gf180mcu_as_sc_mcu7t3v3__clkbuff_12
X_3543_ VDD VDD VSS VSS _3611_/C _3544_/C _3608_/B _3554_/B gf180mcu_as_sc_mcu7t3v3__nor3_2
XTAP_TAPCELL_ROW_77_3_1988 VDD VSS gf180mcu_as_sc_mcu7t3v3__tap_2
XFILLER_157_1245 VDD VDD VSS VSS gf180mcu_as_sc_mcu7t3v3__fillcap_4
X_3474_ VDD VDD VSS VSS _3474_/A _4592_/Q _3474_/C _3478_/B _3475_/B gf180mcu_as_sc_mcu7t3v3__ao211_2
XPHY_EDGE_ROW_115_3_Left_487 VDD VSS gf180mcu_as_sc_mcu7t3v3__tap_2
XFILLER_157_1289 VDD VDD VSS VSS gf180mcu_as_sc_mcu7t3v3__fillcap_4
XFILLER_192_1158 VDD VDD VSS VSS gf180mcu_as_sc_mcu7t3v3__fillcap_4
X_2425_ VDD VDD VSS VSS _2425_/B _4488_/Q _2426_/D gf180mcu_as_sc_mcu7t3v3__and2_2
X_2356_ VDD VDD VSS VSS _2356_/B _4652_/Q _2359_/B gf180mcu_as_sc_mcu7t3v3__xnor2_2
XPHY_EDGE_ROW_52_3_Left_424 VDD VSS gf180mcu_as_sc_mcu7t3v3__tap_2
XFILLER_9_1077 VDD VDD VSS VSS gf180mcu_as_sc_mcu7t3v3__fill_1
X_5075_ VDD VDD VSS VSS _5075_/A _5075_/Y gf180mcu_as_sc_mcu7t3v3__buff_2
X_2287_ VDD VDD VSS VSS _3573_/D _2287_/A _2287_/B _2287_/C _3201_/S gf180mcu_as_sc_mcu7t3v3__ao31_2
X_4026_ VDD VDD VSS VSS _4221_/S _4026_/B _4026_/A _4027_/B gf180mcu_as_sc_mcu7t3v3__mux2_2
XFILLER_168_1330 VDD VDD VSS VSS gf180mcu_as_sc_mcu7t3v3__fillcap_16
XFILLER_164_1227 VDD VDD VSS VSS gf180mcu_as_sc_mcu7t3v3__fillcap_16
XTAP_TAPCELL_ROW_0_689 VDD VSS gf180mcu_as_sc_mcu7t3v3__tap_2
XTAP_TAPCELL_ROW_0_678 VDD VSS gf180mcu_as_sc_mcu7t3v3__tap_2
XTAP_TAPCELL_ROW_0_667 VDD VSS gf180mcu_as_sc_mcu7t3v3__tap_2
XFILLER_100_23 VDD VDD VSS VSS gf180mcu_as_sc_mcu7t3v3__fill_1
XFILLER_12_229 VDD VDD VSS VSS gf180mcu_as_sc_mcu7t3v3__fill_1
XFILLER_165_212 VDD VDD VSS VSS gf180mcu_as_sc_mcu7t3v3__fillcap_4
XTAP_TAPCELL_ROW_11_909 VDD VSS gf180mcu_as_sc_mcu7t3v3__tap_2
XFILLER_165_245 VDD VDD VSS VSS gf180mcu_as_sc_mcu7t3v3__fillcap_4
XPHY_EDGE_ROW_49_1_Right_558 VDD VSS gf180mcu_as_sc_mcu7t3v3__tap_2
XFILLER_109_54 VDD VDD VSS VSS gf180mcu_as_sc_mcu7t3v3__fillcap_16
XFILLER_180_215 VDD VDD VSS VSS gf180mcu_as_sc_mcu7t3v3__fillcap_4
XFILLER_49_1326 VDD VDD VSS VSS gf180mcu_as_sc_mcu7t3v3__fillcap_4
XFILLER_88_1353 VDD VDD VSS VSS gf180mcu_as_sc_mcu7t3v3__fill_2
XFILLER_136_1307 VDD VDD VSS VSS gf180mcu_as_sc_mcu7t3v3__fillcap_16
XFILLER_162_974 VDD VDD VSS VSS gf180mcu_as_sc_mcu7t3v3__fillcap_4
XFILLER_69_69 VDD VDD VSS VSS gf180mcu_as_sc_mcu7t3v3__fill_1
XFILLER_169_1138 VDD VDD VSS VSS gf180mcu_as_sc_mcu7t3v3__fillcap_8
XTAP_TAPCELL_ROW_118_1_1071 VDD VSS gf180mcu_as_sc_mcu7t3v3__tap_2
XFILLER_1_1328 VDD VDD VSS VSS gf180mcu_as_sc_mcu7t3v3__fill_2
XTAP_TAPCELL_ROW_165_1390 VDD VSS gf180mcu_as_sc_mcu7t3v3__tap_2
XTAP_TAPCELL_ROW_25_1_978 VDD VSS gf180mcu_as_sc_mcu7t3v3__tap_2
XTAP_TAPCELL_ROW_161_1298 VDD VSS gf180mcu_as_sc_mcu7t3v3__tap_2
XFILLER_157_702 VDD VDD VSS VSS gf180mcu_as_sc_mcu7t3v3__fill_1
XFILLER_34_61 VDD VDD VSS VSS gf180mcu_as_sc_mcu7t3v3__fillcap_4
XFILLER_169_562 VDD VDD VSS VSS gf180mcu_as_sc_mcu7t3v3__fillcap_4
XFILLER_8_734 VDD VDD VSS VSS gf180mcu_as_sc_mcu7t3v3__fill_1
X_4752__1020 VDD VDD VSS VSS _4752_/D gf180mcu_as_sc_mcu7t3v3__tiel_4
XFILLER_8_789 VDD VDD VSS VSS gf180mcu_as_sc_mcu7t3v3__fill_1
XFILLER_171_226 VDD VDD VSS VSS gf180mcu_as_sc_mcu7t3v3__fillcap_4
XFILLER_172_749 VDD VDD VSS VSS gf180mcu_as_sc_mcu7t3v3__fill_2
XFILLER_4_973 VDD VDD VSS VSS gf180mcu_as_sc_mcu7t3v3__fill_1
X_2210_ VDD VDD VSS VSS _2292_/A _4516_/Q gf180mcu_as_sc_mcu7t3v3__inv_2
XFILLER_117_1262 VDD VDD VSS VSS gf180mcu_as_sc_mcu7t3v3__fill_1
X_3190_ VDD VDD VSS VSS _3191_/D _3210_/A _3201_/S _3574_/D gf180mcu_as_sc_mcu7t3v3__ao21_2
XFILLER_152_1186 VDD VDD VSS VSS gf180mcu_as_sc_mcu7t3v3__fillcap_4
XFILLER_38_104 VDD VDD VSS VSS gf180mcu_as_sc_mcu7t3v3__fill_1
XTAP_TAPCELL_ROW_185_1766 VDD VSS gf180mcu_as_sc_mcu7t3v3__tap_2
XTAP_TAPCELL_ROW_185_1755 VDD VSS gf180mcu_as_sc_mcu7t3v3__tap_2
X_2974_ VDD VDD VSS VSS _3006_/A _2974_/A _3038_/A gf180mcu_as_sc_mcu7t3v3__and2_2
X_4713_ VDD VDD VSS VSS _4727_/CLK _4713_/D _4713_/Q gf180mcu_as_sc_mcu7t3v3__dfxtp_2
XFILLER_159_1307 VDD VDD VSS VSS gf180mcu_as_sc_mcu7t3v3__fillcap_4
X_4644_ VDD VDD VSS VSS _4808_/CLK _4644_/D _4644_/Q gf180mcu_as_sc_mcu7t3v3__dfxtp_2
X_4575_ VDD VDD VSS VSS _4576_/CLK _4575_/D _4575_/Q gf180mcu_as_sc_mcu7t3v3__dfxtp_2
X_3526_ VDD VDD VSS VSS _3527_/C _3526_/A _3526_/B _4595_/Q gf180mcu_as_sc_mcu7t3v3__ao21_2
XFILLER_157_1086 VDD VDD VSS VSS gf180mcu_as_sc_mcu7t3v3__fillcap_8
X_3457_ VDD VDD VSS VSS _3504_/C _4466_/Q _4580_/Q _4580_/D gf180mcu_as_sc_mcu7t3v3__mux2_2
XTAP_TAPCELL_ROW_25_3_1936 VDD VSS gf180mcu_as_sc_mcu7t3v3__tap_2
XFILLER_44_1256 VDD VDD VSS VSS gf180mcu_as_sc_mcu7t3v3__fillcap_8
XFILLER_83_1283 VDD VDD VSS VSS gf180mcu_as_sc_mcu7t3v3__fillcap_16
X_3388_ VDD VDD VSS VSS _3396_/A _3388_/B _3388_/C _3388_/D _4539_/D gf180mcu_as_sc_mcu7t3v3__ao211_2
X_2408_ VDD VDD VSS VSS _2408_/B _2408_/A _2418_/D gf180mcu_as_sc_mcu7t3v3__or2_2
XFILLER_170_1275 VDD VDD VSS VSS gf180mcu_as_sc_mcu7t3v3__fillcap_16
XFILLER_29_104 VDD VDD VSS VSS gf180mcu_as_sc_mcu7t3v3__fill_1
X_2339_ VDD VDD VSS VSS _2340_/B _2339_/C _3458_/A _4453_/Q gf180mcu_as_sc_mcu7t3v3__aoi21_2
XFILLER_170_1297 VDD VDD VSS VSS gf180mcu_as_sc_mcu7t3v3__fillcap_8
XPHY_EDGE_ROW_2_Right_2 VDD VSS gf180mcu_as_sc_mcu7t3v3__tap_2
X_4009_ VDD VDD VSS VSS _4009_/A _4009_/B _4138_/B _4009_/D _4011_/A gf180mcu_as_sc_mcu7t3v3__ao211_2
XFILLER_164_1002 VDD VDD VSS VSS gf180mcu_as_sc_mcu7t3v3__fill_2
XFILLER_111_88 VDD VDD VSS VSS gf180mcu_as_sc_mcu7t3v3__fill_2
XFILLER_103_1306 VDD VDD VSS VSS gf180mcu_as_sc_mcu7t3v3__fill_2
XFILLER_166_543 VDD VDD VSS VSS gf180mcu_as_sc_mcu7t3v3__fillcap_16
XFILLER_5_737 VDD VDD VSS VSS gf180mcu_as_sc_mcu7t3v3__fill_2
XFILLER_162_771 VDD VDD VSS VSS gf180mcu_as_sc_mcu7t3v3__fillcap_16
XFILLER_162_793 VDD VDD VSS VSS gf180mcu_as_sc_mcu7t3v3__fill_1
XFILLER_175_1142 VDD VDD VSS VSS gf180mcu_as_sc_mcu7t3v3__fill_2
XFILLER_136_85 VDD VDD VSS VSS gf180mcu_as_sc_mcu7t3v3__fillcap_16
XFILLER_171_1028 VDD VDD VSS VSS gf180mcu_as_sc_mcu7t3v3__fillcap_8
XFILLER_175_1186 VDD VDD VSS VSS gf180mcu_as_sc_mcu7t3v3__fillcap_4
XFILLER_1_954 VDD VDD VSS VSS gf180mcu_as_sc_mcu7t3v3__fill_1
Xinput310 VDD VDD VSS VSS west_in[21] _4175_/A gf180mcu_as_sc_mcu7t3v3__buff_12
Xinput321 VDD VDD VSS VSS west_in[31] _4263_/A gf180mcu_as_sc_mcu7t3v3__buff_12
Xinput332 VDD VDD VSS VSS west_in[9] _4078_/A gf180mcu_as_sc_mcu7t3v3__buff_12
XFILLER_29_72 VDD VDD VSS VSS gf180mcu_as_sc_mcu7t3v3__fillcap_4
XTAP_TAPCELL_ROW_4_770 VDD VSS gf180mcu_as_sc_mcu7t3v3__tap_2
XTAP_TAPCELL_ROW_163_1338 VDD VSS gf180mcu_as_sc_mcu7t3v3__tap_2
XTAP_TAPCELL_ROW_163_1349 VDD VSS gf180mcu_as_sc_mcu7t3v3__tap_2
XTAP_TAPCELL_ROW_180_1674 VDD VSS gf180mcu_as_sc_mcu7t3v3__tap_2
XTAP_TAPCELL_ROW_180_1663 VDD VSS gf180mcu_as_sc_mcu7t3v3__tap_2
XFILLER_182_1157 VDD VDD VSS VSS gf180mcu_as_sc_mcu7t3v3__fillcap_4
XFILLER_182_1168 VDD VDD VSS VSS gf180mcu_as_sc_mcu7t3v3__fill_1
XFILLER_182_1179 VDD VDD VSS VSS gf180mcu_as_sc_mcu7t3v3__fillcap_8
XFILLER_188_189 VDD VDD VSS VSS gf180mcu_as_sc_mcu7t3v3__fillcap_4
XFILLER_169_381 VDD VDD VSS VSS gf180mcu_as_sc_mcu7t3v3__fill_2
X_2690_ VDD VDD VSS VSS _4334_/Q _2772_/B _2980_/A _2772_/D _4334_/D gf180mcu_as_sc_mcu7t3v3__ao22_2
XANTENNA_3 VDD VDD VSS VSS _4702_/D gf180mcu_as_sc_mcu7t3v3__diode_2
XFILLER_157_598 VDD VDD VSS VSS gf180mcu_as_sc_mcu7t3v3__fill_1
XFILLER_184_384 VDD VDD VSS VSS gf180mcu_as_sc_mcu7t3v3__fill_1
X_4360_ VDD VDD VSS VSS _4804_/CLK _4360_/D _4360_/Q gf180mcu_as_sc_mcu7t3v3__dfxtp_2
XFILLER_67_1256 VDD VDD VSS VSS gf180mcu_as_sc_mcu7t3v3__fillcap_16
X_3311_ VDD VDD VSS VSS _3314_/C _4430_/Q _3312_/S gf180mcu_as_sc_mcu7t3v3__nand2_2
X_4291_ VDD VDD VSS VSS _4771_/D _4291_/B _4327_/A gf180mcu_as_sc_mcu7t3v3__nor2_2
XTAP_TAPCELL_ROW_187_1806 VDD VSS gf180mcu_as_sc_mcu7t3v3__tap_2
X_3242_ VDD VDD VSS VSS _3306_/A _3242_/B _3242_/C _3244_/B _3242_/D gf180mcu_as_sc_mcu7t3v3__aoi31_2
XFILLER_6_1014 VDD VDD VSS VSS gf180mcu_as_sc_mcu7t3v3__fill_1
XFILLER_6_1025 VDD VDD VSS VSS gf180mcu_as_sc_mcu7t3v3__fill_2
Xmesh_tile_936 VDD VDD VSS VSS se_out[0] gf180mcu_as_sc_mcu7t3v3__tiel_4
Xmesh_tile_925 VDD VDD VSS VSS nw_out[25] gf180mcu_as_sc_mcu7t3v3__tiel_4
Xmesh_tile_914 VDD VDD VSS VSS nw_out[14] gf180mcu_as_sc_mcu7t3v3__tiel_4
Xmesh_tile_903 VDD VDD VSS VSS nw_out[3] gf180mcu_as_sc_mcu7t3v3__tiel_4
X_3173_ VDD VDD VSS VSS _3174_/C _4444_/Q _3205_/A gf180mcu_as_sc_mcu7t3v3__nand2_2
XFILLER_6_1058 VDD VDD VSS VSS gf180mcu_as_sc_mcu7t3v3__fill_2
Xmesh_tile_969 VDD VDD VSS VSS se_out[33] gf180mcu_as_sc_mcu7t3v3__tiel_4
Xmesh_tile_958 VDD VDD VSS VSS se_out[22] gf180mcu_as_sc_mcu7t3v3__tiel_4
Xmesh_tile_947 VDD VDD VSS VSS se_out[11] gf180mcu_as_sc_mcu7t3v3__tiel_4
XTAP_TAPCELL_ROW_2_729 VDD VSS gf180mcu_as_sc_mcu7t3v3__tap_2
XFILLER_161_1208 VDD VDD VSS VSS gf180mcu_as_sc_mcu7t3v3__fill_2
XFILLER_167_307 VDD VDD VSS VSS gf180mcu_as_sc_mcu7t3v3__fill_1
XFILLER_176_830 VDD VDD VSS VSS gf180mcu_as_sc_mcu7t3v3__fill_2
X_2957_ VDD VDD VSS VSS _2997_/A _2966_/A _3028_/A gf180mcu_as_sc_mcu7t3v3__and2_2
XFILLER_175_340 VDD VDD VSS VSS gf180mcu_as_sc_mcu7t3v3__fillcap_8
X_2888_ VDD VDD VSS VSS _2897_/B _4202_/D _2889_/D gf180mcu_as_sc_mcu7t3v3__or2_2
XTAP_TAPCELL_ROW_80_1_1033 VDD VSS gf180mcu_as_sc_mcu7t3v3__tap_2
XFILLER_163_535 VDD VDD VSS VSS gf180mcu_as_sc_mcu7t3v3__fillcap_16
X_4627_ VDD VDD VSS VSS _4809_/CLK _4627_/D _4627_/Q gf180mcu_as_sc_mcu7t3v3__dfxtp_2
XFILLER_190_387 VDD VDD VSS VSS gf180mcu_as_sc_mcu7t3v3__fillcap_8
XFILLER_2_718 VDD VDD VSS VSS gf180mcu_as_sc_mcu7t3v3__fill_1
XFILLER_46_1307 VDD VDD VSS VSS gf180mcu_as_sc_mcu7t3v3__fill_1
X_4558_ VDD VDD VSS VSS _4728_/CLK _4558_/D _4558_/Q gf180mcu_as_sc_mcu7t3v3__dfxtp_2
X_4489_ VDD VDD VSS VSS _4708_/CLK _4489_/D _4489_/Q gf180mcu_as_sc_mcu7t3v3__dfxtp_2
X_3509_ VDD VDD VSS VSS _3522_/S _4477_/Q _3546_/D gf180mcu_as_sc_mcu7t3v3__and2_2
XTAP_TAPCELL_ROW_24_1_977 VDD VSS gf180mcu_as_sc_mcu7t3v3__tap_2
XFILLER_170_1083 VDD VDD VSS VSS gf180mcu_as_sc_mcu7t3v3__fill_2
XFILLER_92_1327 VDD VDD VSS VSS gf180mcu_as_sc_mcu7t3v3__fill_1
XFILLER_13_346 VDD VDD VSS VSS gf180mcu_as_sc_mcu7t3v3__fill_2
XFILLER_167_830 VDD VDD VSS VSS gf180mcu_as_sc_mcu7t3v3__fillcap_4
XFILLER_167_852 VDD VDD VSS VSS gf180mcu_as_sc_mcu7t3v3__fill_1
XFILLER_185_137 VDD VDD VSS VSS gf180mcu_as_sc_mcu7t3v3__fill_2
XFILLER_12_1008 VDD VDD VSS VSS gf180mcu_as_sc_mcu7t3v3__fillcap_4
XFILLER_154_502 VDD VDD VSS VSS gf180mcu_as_sc_mcu7t3v3__fill_2
XFILLER_154_524 VDD VDD VSS VSS gf180mcu_as_sc_mcu7t3v3__fill_1
XFILLER_182_844 VDD VDD VSS VSS gf180mcu_as_sc_mcu7t3v3__fillcap_4
XFILLER_177_1237 VDD VDD VSS VSS gf180mcu_as_sc_mcu7t3v3__fill_2
XFILLER_182_877 VDD VDD VSS VSS gf180mcu_as_sc_mcu7t3v3__fillcap_16
XFILLER_31_84 VDD VDD VSS VSS gf180mcu_as_sc_mcu7t3v3__fillcap_16
XFILLER_181_376 VDD VDD VSS VSS gf180mcu_as_sc_mcu7t3v3__fillcap_4
XTAP_TAPCELL_ROW_9_862 VDD VSS gf180mcu_as_sc_mcu7t3v3__tap_2
XFILLER_163_72 VDD VDD VSS VSS gf180mcu_as_sc_mcu7t3v3__fillcap_4
XFILLER_1_795 VDD VDD VSS VSS gf180mcu_as_sc_mcu7t3v3__fill_1
Xinput140 VDD VDD VSS VSS north_in[31] _4264_/D gf180mcu_as_sc_mcu7t3v3__buff_12
Xinput151 VDD VDD VSS VSS north_in[9] _4076_/D gf180mcu_as_sc_mcu7t3v3__buff_12
Xinput162 VDD VDD VSS VSS nw_in[19] _4161_/A gf180mcu_as_sc_mcu7t3v3__buff_12
XTAP_TAPCELL_ROW_182_1703 VDD VSS gf180mcu_as_sc_mcu7t3v3__tap_2
XFILLER_114_1287 VDD VDD VSS VSS gf180mcu_as_sc_mcu7t3v3__fill_2
Xinput173 VDD VDD VSS VSS nw_in[29] wire810/A gf180mcu_as_sc_mcu7t3v3__buff_12
Xinput184 VDD VDD VSS VSS nw_in[6] _4056_/A gf180mcu_as_sc_mcu7t3v3__buff_12
Xinput195 VDD VDD VSS VSS se_in[15] _4127_/D gf180mcu_as_sc_mcu7t3v3__buff_12
XPHY_EDGE_ROW_124_3_Left_496 VDD VSS gf180mcu_as_sc_mcu7t3v3__tap_2
X_3860_ VDD VDD VSS VSS _4796_/Q _3869_/B _3869_/C _4200_/D _3861_/D gf180mcu_as_sc_mcu7t3v3__ao22_2
X_3791_ VDD VDD VSS VSS _4136_/D _3882_/B _3791_/C _3791_/D _3792_/B gf180mcu_as_sc_mcu7t3v3__ao211_2
X_2811_ VDD VDD VSS VSS _2901_/B _4132_/D _2812_/D gf180mcu_as_sc_mcu7t3v3__and2_2
X_2742_ VDD VDD VSS VSS _2879_/B _4073_/A _2743_/D gf180mcu_as_sc_mcu7t3v3__or2_2
XPHY_EDGE_ROW_61_3_Left_433 VDD VSS gf180mcu_as_sc_mcu7t3v3__tap_2
XFILLER_157_384 VDD VDD VSS VSS gf180mcu_as_sc_mcu7t3v3__fillcap_16
X_4412_ VDD VDD VSS VSS _4445_/CLK _4412_/D _4412_/Q gf180mcu_as_sc_mcu7t3v3__dfxtp_2
X_2673_ VDD VDD VSS VSS _2905_/B _4018_/A _2680_/C gf180mcu_as_sc_mcu7t3v3__and2_2
XFILLER_160_527 VDD VDD VSS VSS gf180mcu_as_sc_mcu7t3v3__fillcap_16
XFILLER_172_387 VDD VDD VSS VSS gf180mcu_as_sc_mcu7t3v3__fill_1
XTAP_TAPCELL_ROW_141_1_1094 VDD VSS gf180mcu_as_sc_mcu7t3v3__tap_2
X_4343_ VDD VDD VSS VSS clkload8/A _4343_/D _4343_/Q gf180mcu_as_sc_mcu7t3v3__dfxtp_2
X_4274_ VDD VDD VSS VSS _4274_/B _4274_/A _4764_/D gf180mcu_as_sc_mcu7t3v3__and2_2
XFILLER_100_104 VDD VDD VSS VSS gf180mcu_as_sc_mcu7t3v3__fill_1
XFILLER_45_1351 VDD VDD VSS VSS gf180mcu_as_sc_mcu7t3v3__fillcap_4
X_3225_ VDD VDD VSS VSS _3369_/A _3225_/B _3225_/C _3228_/B _3225_/D gf180mcu_as_sc_mcu7t3v3__aoi31_2
XFILLER_189_1108 VDD VDD VSS VSS gf180mcu_as_sc_mcu7t3v3__fillcap_8
X_3156_ VDD VDD VSS VSS _3158_/C _4491_/Q _4492_/Q gf180mcu_as_sc_mcu7t3v3__nor2_2
X_3087_ VDD VDD VSS VSS _3608_/A _3124_/S _3447_/B _3093_/S gf180mcu_as_sc_mcu7t3v3__mux2_2
XFILLER_168_605 VDD VDD VSS VSS gf180mcu_as_sc_mcu7t3v3__fill_2
XFILLER_11_839 VDD VDD VSS VSS gf180mcu_as_sc_mcu7t3v3__fill_1
XFILLER_161_1049 VDD VDD VSS VSS gf180mcu_as_sc_mcu7t3v3__fill_1
XFILLER_164_800 VDD VDD VSS VSS gf180mcu_as_sc_mcu7t3v3__fillcap_4
X_3989_ VDD VDD VSS VSS _3989_/Y _3989_/B _4231_/B gf180mcu_as_sc_mcu7t3v3__nor2_2
XFILLER_182_107 VDD VDD VSS VSS gf180mcu_as_sc_mcu7t3v3__fillcap_16
XFILLER_164_877 VDD VDD VSS VSS gf180mcu_as_sc_mcu7t3v3__fillcap_16
XFILLER_11_1052 VDD VDD VSS VSS gf180mcu_as_sc_mcu7t3v3__fillcap_16
XFILLER_191_674 VDD VDD VSS VSS gf180mcu_as_sc_mcu7t3v3__fill_1
XFILLER_117_76 VDD VDD VSS VSS gf180mcu_as_sc_mcu7t3v3__fill_1
XTAP_TAPCELL_ROW_6_810 VDD VSS gf180mcu_as_sc_mcu7t3v3__tap_2
Xdelaybuf_0_clk VDD VDD VSS VSS clk delaybuf_1_clk/A gf180mcu_as_sc_mcu7t3v3__clkbuff_12
XFILLER_133_53 VDD VDD VSS VSS gf180mcu_as_sc_mcu7t3v3__fillcap_16
Xhold1050 VDD VDD VSS VSS hold1081/Y hold1082/A gf180mcu_as_sc_mcu7t3v3__clkbuff_4
XFILLER_172_2 VDD VDD VSS VSS gf180mcu_as_sc_mcu7t3v3__fillcap_4
XFILLER_2_1220 VDD VDD VSS VSS gf180mcu_as_sc_mcu7t3v3__fill_1
Xhold1061 VDD VDD VSS VSS hold1093/Y _4822_/D gf180mcu_as_sc_mcu7t3v3__clkbuff_4
Xhold1072 VDD VDD VSS VSS _4593_/Q _3480_/A gf180mcu_as_sc_mcu7t3v3__clkbuff_4
Xhold1083 VDD VDD VSS VSS _2332_/Y hold1083/Y gf180mcu_as_sc_mcu7t3v3__clkbuff_4
Xhold1094 VDD VDD VSS VSS _4828_/Q hold1094/Y gf180mcu_as_sc_mcu7t3v3__clkbuff_4
XFILLER_183_1252 VDD VDD VSS VSS gf180mcu_as_sc_mcu7t3v3__fillcap_8
XFILLER_13_154 VDD VDD VSS VSS gf180mcu_as_sc_mcu7t3v3__fillcap_16
XFILLER_144_1258 VDD VDD VSS VSS gf180mcu_as_sc_mcu7t3v3__fill_1
XFILLER_158_115 VDD VDD VSS VSS gf180mcu_as_sc_mcu7t3v3__fillcap_4
XFILLER_159_649 VDD VDD VSS VSS gf180mcu_as_sc_mcu7t3v3__fill_1
XFILLER_186_468 VDD VDD VSS VSS gf180mcu_as_sc_mcu7t3v3__fill_1
XFILLER_42_61 VDD VDD VSS VSS gf180mcu_as_sc_mcu7t3v3__fill_2
XTAP_TAPCELL_ROW_158_1248 VDD VSS gf180mcu_as_sc_mcu7t3v3__tap_2
XFILLER_154_310 VDD VDD VSS VSS gf180mcu_as_sc_mcu7t3v3__fillcap_4
XFILLER_167_693 VDD VDD VSS VSS gf180mcu_as_sc_mcu7t3v3__fillcap_4
XFILLER_173_118 VDD VDD VSS VSS gf180mcu_as_sc_mcu7t3v3__fill_1
XTAP_TAPCELL_ROW_175_1573 VDD VSS gf180mcu_as_sc_mcu7t3v3__tap_2
XTAP_TAPCELL_ROW_175_1562 VDD VSS gf180mcu_as_sc_mcu7t3v3__tap_2
XFILLER_154_365 VDD VDD VSS VSS gf180mcu_as_sc_mcu7t3v3__fill_1
XFILLER_5_342 VDD VDD VSS VSS gf180mcu_as_sc_mcu7t3v3__fillcap_8
XFILLER_5_364 VDD VDD VSS VSS gf180mcu_as_sc_mcu7t3v3__fillcap_4
XFILLER_120_1291 VDD VDD VSS VSS gf180mcu_as_sc_mcu7t3v3__fill_2
XFILLER_155_1310 VDD VDD VSS VSS gf180mcu_as_sc_mcu7t3v3__fillcap_16
XFILLER_68_1351 VDD VDD VSS VSS gf180mcu_as_sc_mcu7t3v3__fillcap_4
XFILLER_116_1327 VDD VDD VSS VSS gf180mcu_as_sc_mcu7t3v3__fill_2
X_3010_ VDD VDD VSS VSS _3010_/A _3019_/B _3020_/S _4420_/Q _4420_/D gf180mcu_as_sc_mcu7t3v3__ao22_2
XFILLER_188_1130 VDD VDD VSS VSS gf180mcu_as_sc_mcu7t3v3__fillcap_16
XFILLER_40_1281 VDD VDD VSS VSS gf180mcu_as_sc_mcu7t3v3__fillcap_8
XFILLER_177_402 VDD VDD VSS VSS gf180mcu_as_sc_mcu7t3v3__fillcap_4
X_3912_ VDD VDD VSS VSS _3912_/A _3921_/B _3912_/C _3912_/D _3913_/B gf180mcu_as_sc_mcu7t3v3__ao211_2
XTAP_TAPCELL_ROW_23_1_976 VDD VSS gf180mcu_as_sc_mcu7t3v3__tap_2
XFILLER_149_104 VDD VDD VSS VSS gf180mcu_as_sc_mcu7t3v3__fill_1
X_3843_ VDD VDD VSS VSS _4794_/Q _3869_/B _3869_/C _4182_/D _3844_/D gf180mcu_as_sc_mcu7t3v3__ao22_2
XFILLER_158_671 VDD VDD VSS VSS gf180mcu_as_sc_mcu7t3v3__fill_2
XFILLER_164_107 VDD VDD VSS VSS gf180mcu_as_sc_mcu7t3v3__fillcap_8
X_3774_ VDD VDD VSS VSS _4121_/A _3800_/B _3774_/C _3775_/C _3846_/D gf180mcu_as_sc_mcu7t3v3__aoi211_2
XFILLER_9_670 VDD VDD VSS VSS gf180mcu_as_sc_mcu7t3v3__fill_1
X_2725_ VDD VDD VSS VSS _4058_/A _2796_/D _2725_/C _2725_/D _2984_/A gf180mcu_as_sc_mcu7t3v3__ao22_2
Xoutput411 VDD VDD VSS VSS _4665_/Q south_out[8] gf180mcu_as_sc_mcu7t3v3__buff_12
Xoutput400 VDD VDD VSS VSS _4687_/Q south_out[30] gf180mcu_as_sc_mcu7t3v3__buff_12
X_2656_ VDD VDD VSS VSS _2658_/D _2656_/A _2656_/Y gf180mcu_as_sc_mcu7t3v3__or2_2
XFILLER_161_858 VDD VDD VSS VSS gf180mcu_as_sc_mcu7t3v3__fillcap_16
XFILLER_173_696 VDD VDD VSS VSS gf180mcu_as_sc_mcu7t3v3__fillcap_4
Xoutput422 VDD VDD VSS VSS _4747_/Q west_out[18] gf180mcu_as_sc_mcu7t3v3__buff_12
Xoutput433 VDD VDD VSS VSS _4757_/Q west_out[28] gf180mcu_as_sc_mcu7t3v3__buff_12
Xoutput444 VDD VDD VSS VSS _4735_/Q west_out[6] gf180mcu_as_sc_mcu7t3v3__buff_12
X_2587_ VDD VDD VSS VSS _4830_/D _2587_/B _4639_/Q _4638_/D gf180mcu_as_sc_mcu7t3v3__mux2_2
XFILLER_86_102 VDD VDD VSS VSS gf180mcu_as_sc_mcu7t3v3__fill_2
X_4326_ VDD VDD VSS VSS _4326_/B _4518_/Q _4803_/D gf180mcu_as_sc_mcu7t3v3__and2_2
X_4257_ VDD VDD VSS VSS _4257_/A _4264_/C _4257_/C _4257_/D _4258_/D gf180mcu_as_sc_mcu7t3v3__ao211_2
X_4188_ VDD VDD VSS VSS _4188_/A _4204_/B _4188_/C _4188_/Y _4331_/A gf180mcu_as_sc_mcu7t3v3__aoi211_2
X_3208_ VDD VDD VSS VSS _3520_/B _3397_/B _3208_/C _3219_/S _3209_/C gf180mcu_as_sc_mcu7t3v3__ao211_2
X_3139_ VDD VDD VSS VSS _3205_/A _4385_/Q _4414_/Q _3140_/B gf180mcu_as_sc_mcu7t3v3__mux2_2
XFILLER_167_1225 VDD VDD VSS VSS gf180mcu_as_sc_mcu7t3v3__fillcap_8
XFILLER_167_1258 VDD VDD VSS VSS gf180mcu_as_sc_mcu7t3v3__fill_2
XFILLER_169_903 VDD VDD VSS VSS gf180mcu_as_sc_mcu7t3v3__fillcap_4
XFILLER_144_6 VDD VDD VSS VSS gf180mcu_as_sc_mcu7t3v3__fillcap_16
XFILLER_11_636 VDD VDD VSS VSS gf180mcu_as_sc_mcu7t3v3__fill_1
XFILLER_168_446 VDD VDD VSS VSS gf180mcu_as_sc_mcu7t3v3__fillcap_8
XFILLER_168_457 VDD VDD VSS VSS gf180mcu_as_sc_mcu7t3v3__fillcap_8
XFILLER_13_1103 VDD VDD VSS VSS gf180mcu_as_sc_mcu7t3v3__fillcap_4
XFILLER_183_438 VDD VDD VSS VSS gf180mcu_as_sc_mcu7t3v3__fill_1
XFILLER_128_53 VDD VDD VSS VSS gf180mcu_as_sc_mcu7t3v3__fillcap_16
XFILLER_12_64 VDD VDD VSS VSS gf180mcu_as_sc_mcu7t3v3__fillcap_16
XFILLER_192_983 VDD VDD VSS VSS gf180mcu_as_sc_mcu7t3v3__fill_2
XTAP_TAPCELL_ROW_153_1156 VDD VSS gf180mcu_as_sc_mcu7t3v3__tap_2
XTAP_TAPCELL_ROW_153_1145 VDD VSS gf180mcu_as_sc_mcu7t3v3__tap_2
XFILLER_152_847 VDD VDD VSS VSS gf180mcu_as_sc_mcu7t3v3__fill_2
XTAP_TAPCELL_ROW_170_1470 VDD VSS gf180mcu_as_sc_mcu7t3v3__tap_2
XTAP_TAPCELL_ROW_170_1481 VDD VSS gf180mcu_as_sc_mcu7t3v3__tap_2
XFILLER_144_30 VDD VDD VSS VSS gf180mcu_as_sc_mcu7t3v3__fillcap_4
Xfanout660 VDD VDD VSS VSS _3964_/C _3926_/D gf180mcu_as_sc_mcu7t3v3__buff_12
XFILLER_4_1326 VDD VDD VSS VSS gf180mcu_as_sc_mcu7t3v3__fill_2
Xfanout671 VDD VDD VSS VSS _2874_/B _2810_/B gf180mcu_as_sc_mcu7t3v3__buff_12
Xfanout682 VDD VDD VSS VSS fanout682/A _3927_/B gf180mcu_as_sc_mcu7t3v3__buff_12
Xfanout693 VDD VDD VSS VSS wire695/A _3925_/S gf180mcu_as_sc_mcu7t3v3__buff_12
XFILLER_37_72 VDD VDD VSS VSS gf180mcu_as_sc_mcu7t3v3__fillcap_16
XFILLER_160_73 VDD VDD VSS VSS gf180mcu_as_sc_mcu7t3v3__fillcap_8
XFILLER_159_413 VDD VDD VSS VSS gf180mcu_as_sc_mcu7t3v3__fillcap_4
XFILLER_183_1060 VDD VDD VSS VSS gf180mcu_as_sc_mcu7t3v3__fillcap_4
XFILLER_187_733 VDD VDD VSS VSS gf180mcu_as_sc_mcu7t3v3__fill_2
XTAP_TAPCELL_ROW_177_1613 VDD VSS gf180mcu_as_sc_mcu7t3v3__tap_2
XTAP_TAPCELL_ROW_177_1602 VDD VSS gf180mcu_as_sc_mcu7t3v3__tap_2
XFILLER_175_928 VDD VDD VSS VSS gf180mcu_as_sc_mcu7t3v3__fillcap_16
XFILLER_168_980 VDD VDD VSS VSS gf180mcu_as_sc_mcu7t3v3__fillcap_4
XFILLER_179_1118 VDD VDD VSS VSS gf180mcu_as_sc_mcu7t3v3__fill_2
Xclkbuf_3_7__f_clk_regs VDD VDD VSS VSS clkbuf_2_3_0_clk_regs/Y clkload2/A gf180mcu_as_sc_mcu7t3v3__clkbuff_12
X_3490_ VDD VDD VSS VSS _4466_/Q _3504_/C _3502_/C _4597_/Q _3491_/C gf180mcu_as_sc_mcu7t3v3__ao22_2
X_2510_ VDD VDD VSS VSS _4292_/C _4587_/Q _2563_/D _2567_/B _2510_/D gf180mcu_as_sc_mcu7t3v3__aoi211_2
XTAP_TAPCELL_ROW_190_1857 VDD VSS gf180mcu_as_sc_mcu7t3v3__tap_2
XFILLER_154_184 VDD VDD VSS VSS gf180mcu_as_sc_mcu7t3v3__fillcap_4
XFILLER_182_493 VDD VDD VSS VSS gf180mcu_as_sc_mcu7t3v3__fillcap_16
X_2441_ VDD VDD VSS VSS _2442_/C _2441_/B _2441_/A gf180mcu_as_sc_mcu7t3v3__nor2_2
XFILLER_170_677 VDD VDD VSS VSS gf180mcu_as_sc_mcu7t3v3__fillcap_8
Xclkbuf_leaf_14_clk_regs VDD VDD VSS VSS clkload0/A _4804_/CLK gf180mcu_as_sc_mcu7t3v3__clkbuff_12
X_2372_ VDD VDD VSS VSS _2411_/S _2372_/B _2372_/A _2374_/A gf180mcu_as_sc_mcu7t3v3__mux2_2
X_4111_ VDD VDD VSS VSS _4114_/B _4111_/B _4111_/A gf180mcu_as_sc_mcu7t3v3__nor2_2
XFILLER_9_1259 VDD VDD VSS VSS gf180mcu_as_sc_mcu7t3v3__fill_1
XFILLER_190_1097 VDD VDD VSS VSS gf180mcu_as_sc_mcu7t3v3__fill_1
XFILLER_42_1354 VDD VDD VSS VSS gf180mcu_as_sc_mcu7t3v3__fill_1
X_4042_ VDD VDD VSS VSS _4163_/S _4042_/B _4042_/A _4043_/B gf180mcu_as_sc_mcu7t3v3__mux2_2
XPHY_EDGE_ROW_153_Right_15 VDD VSS gf180mcu_as_sc_mcu7t3v3__tap_2
XFILLER_166_928 VDD VDD VSS VSS gf180mcu_as_sc_mcu7t3v3__fill_2
XFILLER_177_265 VDD VDD VSS VSS gf180mcu_as_sc_mcu7t3v3__fillcap_8
X_3826_ VDD VDD VSS VSS _4169_/D _3871_/B _3869_/C _4167_/D _3827_/D gf180mcu_as_sc_mcu7t3v3__ao22_2
XFILLER_177_298 VDD VDD VSS VSS gf180mcu_as_sc_mcu7t3v3__fillcap_4
XFILLER_192_246 VDD VDD VSS VSS gf180mcu_as_sc_mcu7t3v3__fill_1
X_3757_ VDD VDD VSS VSS _4107_/A _3855_/B _3757_/C _4669_/D _4138_/C gf180mcu_as_sc_mcu7t3v3__aoi211_2
XPHY_EDGE_ROW_21_3_Right_62 VDD VSS gf180mcu_as_sc_mcu7t3v3__tap_2
XFILLER_180_408 VDD VDD VSS VSS gf180mcu_as_sc_mcu7t3v3__fill_1
X_2708_ VDD VDD VSS VSS _4336_/Q _2772_/B _2982_/A _2808_/D _4336_/D gf180mcu_as_sc_mcu7t3v3__ao22_2
X_3688_ VDD VDD VSS VSS _3689_/D _4044_/A _3926_/D _3953_/C gf180mcu_as_sc_mcu7t3v3__ao21_2
X_2639_ VDD VDD VSS VSS _3912_/A _3921_/A _4267_/B gf180mcu_as_sc_mcu7t3v3__or2_2
XPHY_EDGE_ROW_162_Right_24 VDD VSS gf180mcu_as_sc_mcu7t3v3__tap_2
XFILLER_0_827 VDD VDD VSS VSS gf180mcu_as_sc_mcu7t3v3__fill_2
XFILLER_161_699 VDD VDD VSS VSS gf180mcu_as_sc_mcu7t3v3__fill_1
XFILLER_173_1262 VDD VDD VSS VSS gf180mcu_as_sc_mcu7t3v3__fillcap_16
XPHY_EDGE_ROW_149_3_Left_521 VDD VSS gf180mcu_as_sc_mcu7t3v3__tap_2
X_4309_ VDD VDD VSS VSS _4310_/B _4533_/Q _4786_/D gf180mcu_as_sc_mcu7t3v3__and2_2
XFILLER_114_77 VDD VDD VSS VSS gf180mcu_as_sc_mcu7t3v3__fill_2
XFILLER_74_37 VDD VDD VSS VSS gf180mcu_as_sc_mcu7t3v3__fillcap_4
XPHY_EDGE_ROW_171_Right_33 VDD VSS gf180mcu_as_sc_mcu7t3v3__tap_2
XFILLER_130_76 VDD VDD VSS VSS gf180mcu_as_sc_mcu7t3v3__fillcap_4
XFILLER_145_1320 VDD VDD VSS VSS gf180mcu_as_sc_mcu7t3v3__fillcap_4
XFILLER_145_1342 VDD VDD VSS VSS gf180mcu_as_sc_mcu7t3v3__fill_1
XFILLER_180_1200 VDD VDD VSS VSS gf180mcu_as_sc_mcu7t3v3__fillcap_16
XFILLER_168_243 VDD VDD VSS VSS gf180mcu_as_sc_mcu7t3v3__fill_2
XFILLER_157_928 VDD VDD VSS VSS gf180mcu_as_sc_mcu7t3v3__fillcap_4
XFILLER_169_788 VDD VDD VSS VSS gf180mcu_as_sc_mcu7t3v3__fillcap_16
XFILLER_184_769 VDD VDD VSS VSS gf180mcu_as_sc_mcu7t3v3__fill_2
XTAP_TAPCELL_ROW_172_1521 VDD VSS gf180mcu_as_sc_mcu7t3v3__tap_2
XTAP_TAPCELL_ROW_172_1510 VDD VSS gf180mcu_as_sc_mcu7t3v3__tap_2
XFILLER_180_931 VDD VDD VSS VSS gf180mcu_as_sc_mcu7t3v3__fill_2
XPHY_EDGE_ROW_180_Right_42 VDD VSS gf180mcu_as_sc_mcu7t3v3__tap_2
XFILLER_191_290 VDD VDD VSS VSS gf180mcu_as_sc_mcu7t3v3__fill_2
XFILLER_30_1291 VDD VDD VSS VSS gf180mcu_as_sc_mcu7t3v3__fill_2
XTAP_TAPCELL_ROW_43_3_1954 VDD VSS gf180mcu_as_sc_mcu7t3v3__tap_2
XFILLER_26_1305 VDD VDD VSS VSS gf180mcu_as_sc_mcu7t3v3__fillcap_16
XFILLER_3_698 VDD VDD VSS VSS gf180mcu_as_sc_mcu7t3v3__fill_2
XFILLER_152_1346 VDD VDD VSS VSS gf180mcu_as_sc_mcu7t3v3__fill_1
XFILLER_26_1327 VDD VDD VSS VSS gf180mcu_as_sc_mcu7t3v3__fill_1
XTAP_TAPCELL_ROW_22_1_975 VDD VSS gf180mcu_as_sc_mcu7t3v3__tap_2
XFILLER_171_50 VDD VDD VSS VSS gf180mcu_as_sc_mcu7t3v3__fillcap_16
XFILLER_171_72 VDD VDD VSS VSS gf180mcu_as_sc_mcu7t3v3__fillcap_4
XPHY_EDGE_ROW_70_3_Left_442 VDD VSS gf180mcu_as_sc_mcu7t3v3__tap_2
XFILLER_185_1122 VDD VDD VSS VSS gf180mcu_as_sc_mcu7t3v3__fill_1
XFILLER_179_508 VDD VDD VSS VSS gf180mcu_as_sc_mcu7t3v3__fillcap_8
X_2990_ VDD VDD VSS VSS _2990_/A _2993_/B _2993_/C _4402_/Q _4402_/D gf180mcu_as_sc_mcu7t3v3__ao22_2
XFILLER_187_552 VDD VDD VSS VSS gf180mcu_as_sc_mcu7t3v3__fill_1
X_4660_ VDD VDD VSS VSS clkload6/A _4660_/D _4660_/Q gf180mcu_as_sc_mcu7t3v3__dfxtp_2
XTAP_TAPCELL_ROW_192_1919 VDD VSS gf180mcu_as_sc_mcu7t3v3__tap_2
XTAP_TAPCELL_ROW_192_1908 VDD VSS gf180mcu_as_sc_mcu7t3v3__tap_2
XTAP_TAPCELL_ROW_13_962 VDD VSS gf180mcu_as_sc_mcu7t3v3__tap_2
XTAP_TAPCELL_ROW_13_951 VDD VSS gf180mcu_as_sc_mcu7t3v3__tap_2
XTAP_TAPCELL_ROW_13_940 VDD VSS gf180mcu_as_sc_mcu7t3v3__tap_2
XFILLER_163_909 VDD VDD VSS VSS gf180mcu_as_sc_mcu7t3v3__fill_1
X_3611_ VDD VDD VSS VSS _3612_/B _3611_/C _3611_/B _3611_/A gf180mcu_as_sc_mcu7t3v3__aoi21_2
X_4591_ VDD VDD VSS VSS _4829_/CLK _4591_/D _4591_/Q gf180mcu_as_sc_mcu7t3v3__dfxtp_2
XFILLER_157_1224 VDD VDD VSS VSS gf180mcu_as_sc_mcu7t3v3__fill_1
XFILLER_6_470 VDD VDD VSS VSS gf180mcu_as_sc_mcu7t3v3__fill_1
XFILLER_7_982 VDD VDD VSS VSS gf180mcu_as_sc_mcu7t3v3__fillcap_16
Xmax_cap613 VDD VDD VSS VSS _3988_/Y fanout611/A gf180mcu_as_sc_mcu7t3v3__clkbuff_12
X_3542_ VDD VDD VSS VSS _3608_/B _3544_/B gf180mcu_as_sc_mcu7t3v3__inv_2
XFILLER_157_1257 VDD VDD VSS VSS gf180mcu_as_sc_mcu7t3v3__fill_2
XFILLER_182_290 VDD VDD VSS VSS gf180mcu_as_sc_mcu7t3v3__fillcap_8
X_3473_ VDD VDD VSS VSS _3480_/B _3473_/B _4590_/Q _4590_/D gf180mcu_as_sc_mcu7t3v3__mux2_2
X_2424_ VDD VDD VSS VSS _2424_/A _2424_/B _2424_/C _2424_/D _2424_/Y gf180mcu_as_sc_mcu7t3v3__ao22_2
X_2355_ VDD VDD VSS VSS _3053_/B _2408_/A _2481_/C gf180mcu_as_sc_mcu7t3v3__or2_2
XFILLER_9_1067 VDD VDD VSS VSS gf180mcu_as_sc_mcu7t3v3__fillcap_8
X_5074_ VDD VDD VSS VSS _5074_/A _5074_/Y gf180mcu_as_sc_mcu7t3v3__buff_2
X_2286_ VDD VDD VSS VSS _3191_/A _3212_/B _3573_/D gf180mcu_as_sc_mcu7t3v3__nor2_2
X_4025_ VDD VDD VSS VSS _4026_/B _4025_/A _4136_/C _4025_/C gf180mcu_as_sc_mcu7t3v3__ao21_2
XTAP_TAPCELL_ROW_147_3_2058 VDD VSS gf180mcu_as_sc_mcu7t3v3__tap_2
XFILLER_129_1326 VDD VDD VSS VSS gf180mcu_as_sc_mcu7t3v3__fill_2
XTAP_TAPCELL_ROW_0_679 VDD VSS gf180mcu_as_sc_mcu7t3v3__tap_2
XTAP_TAPCELL_ROW_0_668 VDD VSS gf180mcu_as_sc_mcu7t3v3__tap_2
XFILLER_178_541 VDD VDD VSS VSS gf180mcu_as_sc_mcu7t3v3__fill_1
XFILLER_100_68 VDD VDD VSS VSS gf180mcu_as_sc_mcu7t3v3__fill_1
X_3809_ VDD VDD VSS VSS _4154_/B _3872_/B _3809_/C _3809_/D _3810_/B gf180mcu_as_sc_mcu7t3v3__ao211_2
XFILLER_165_279 VDD VDD VSS VSS gf180mcu_as_sc_mcu7t3v3__fill_1
X_4789_ VDD VDD VSS VSS _4789_/CLK _4789_/D _4789_/Q gf180mcu_as_sc_mcu7t3v3__dfxtp_2
XFILLER_101_1256 VDD VDD VSS VSS gf180mcu_as_sc_mcu7t3v3__fillcap_16
XFILLER_140_1283 VDD VDD VSS VSS gf180mcu_as_sc_mcu7t3v3__fillcap_4
XFILLER_162_920 VDD VDD VSS VSS gf180mcu_as_sc_mcu7t3v3__fillcap_8
XFILLER_161_474 VDD VDD VSS VSS gf180mcu_as_sc_mcu7t3v3__fill_1
XFILLER_125_76 VDD VDD VSS VSS gf180mcu_as_sc_mcu7t3v3__fill_1
XFILLER_85_58 VDD VDD VSS VSS gf180mcu_as_sc_mcu7t3v3__fill_1
XFILLER_169_1117 VDD VDD VSS VSS gf180mcu_as_sc_mcu7t3v3__fill_2
XTAP_TAPCELL_ROW_165_1380 VDD VSS gf180mcu_as_sc_mcu7t3v3__tap_2
XFILLER_182_1317 VDD VDD VSS VSS gf180mcu_as_sc_mcu7t3v3__fill_2
XFILLER_189_839 VDD VDD VSS VSS gf180mcu_as_sc_mcu7t3v3__fill_1
XTAP_TAPCELL_ROW_161_1299 VDD VSS gf180mcu_as_sc_mcu7t3v3__tap_2
XFILLER_157_714 VDD VDD VSS VSS gf180mcu_as_sc_mcu7t3v3__fill_1
XFILLER_8_702 VDD VDD VSS VSS gf180mcu_as_sc_mcu7t3v3__fill_2
XFILLER_157_769 VDD VDD VSS VSS gf180mcu_as_sc_mcu7t3v3__fill_1
XFILLER_7_212 VDD VDD VSS VSS gf180mcu_as_sc_mcu7t3v3__fillcap_4
XFILLER_172_717 VDD VDD VSS VSS gf180mcu_as_sc_mcu7t3v3__fillcap_4
XFILLER_165_780 VDD VDD VSS VSS gf180mcu_as_sc_mcu7t3v3__fillcap_4
XFILLER_152_474 VDD VDD VSS VSS gf180mcu_as_sc_mcu7t3v3__fill_2
XFILLER_191_1170 VDD VDD VSS VSS gf180mcu_as_sc_mcu7t3v3__fillcap_16
XFILLER_191_1192 VDD VDD VSS VSS gf180mcu_as_sc_mcu7t3v3__fillcap_16
XFILLER_182_93 VDD VDD VSS VSS gf180mcu_as_sc_mcu7t3v3__fillcap_8
XTAP_TAPCELL_ROW_185_1767 VDD VSS gf180mcu_as_sc_mcu7t3v3__tap_2
XTAP_TAPCELL_ROW_185_1756 VDD VSS gf180mcu_as_sc_mcu7t3v3__tap_2
XFILLER_179_338 VDD VDD VSS VSS gf180mcu_as_sc_mcu7t3v3__fill_1
X_2973_ VDD VDD VSS VSS _2973_/D _4274_/A _3037_/B _2975_/D _4388_/D gf180mcu_as_sc_mcu7t3v3__ao31_2
XFILLER_188_872 VDD VDD VSS VSS gf180mcu_as_sc_mcu7t3v3__fill_2
X_4712_ VDD VDD VSS VSS _4727_/CLK _4712_/D _4712_/Q gf180mcu_as_sc_mcu7t3v3__dfxtp_2
XFILLER_163_1294 VDD VDD VSS VSS gf180mcu_as_sc_mcu7t3v3__fillcap_16
X_4643_ VDD VDD VSS VSS _4808_/CLK _4643_/D _4643_/Q gf180mcu_as_sc_mcu7t3v3__dfxtp_2
XFILLER_162_216 VDD VDD VSS VSS gf180mcu_as_sc_mcu7t3v3__fillcap_16
X_4574_ VDD VDD VSS VSS _4719_/CLK _4574_/D _4574_/Q gf180mcu_as_sc_mcu7t3v3__dfxtp_2
X_3525_ VDD VDD VSS VSS _3526_/A _3525_/B _3526_/B _3527_/B gf180mcu_as_sc_mcu7t3v3__nand3_2
XFILLER_157_1043 VDD VDD VSS VSS gf180mcu_as_sc_mcu7t3v3__fillcap_4
XFILLER_157_1054 VDD VDD VSS VSS gf180mcu_as_sc_mcu7t3v3__fill_1
XFILLER_171_772 VDD VDD VSS VSS gf180mcu_as_sc_mcu7t3v3__fillcap_4
Xmax_cap498 VDD VDD VSS VSS _3932_/S _3921_/B gf180mcu_as_sc_mcu7t3v3__clkbuff_12
X_3456_ VDD VDD VSS VSS _3522_/S _4476_/Q _3505_/A _4579_/D gf180mcu_as_sc_mcu7t3v3__mux2_2
XFILLER_170_1243 VDD VDD VSS VSS gf180mcu_as_sc_mcu7t3v3__fillcap_16
X_3387_ VDD VDD VSS VSS _4539_/Q _3395_/B _3403_/C _4540_/Q _3388_/C gf180mcu_as_sc_mcu7t3v3__ao22_2
X_2407_ VDD VDD VSS VSS _3053_/B _2407_/B _2407_/C _2408_/B gf180mcu_as_sc_mcu7t3v3__nor3_2
X_2338_ VDD VDD VSS VSS _2340_/A _2338_/B _2550_/A gf180mcu_as_sc_mcu7t3v3__nand2_2
X_2269_ VDD VDD VSS VSS _2269_/D _3568_/A _2269_/B _2269_/C _2523_/B gf180mcu_as_sc_mcu7t3v3__ao31_2
X_4008_ VDD VDD VSS VSS _4008_/A _4136_/B _4136_/C _4008_/D _4009_/D gf180mcu_as_sc_mcu7t3v3__ao22_2
XFILLER_168_1172 VDD VDD VSS VSS gf180mcu_as_sc_mcu7t3v3__fillcap_16
XTAP_TAPCELL_ROW_21_1_974 VDD VSS gf180mcu_as_sc_mcu7t3v3__tap_2
XFILLER_178_393 VDD VDD VSS VSS gf180mcu_as_sc_mcu7t3v3__fill_1
XFILLER_90_1299 VDD VDD VSS VSS gf180mcu_as_sc_mcu7t3v3__fillcap_4
XFILLER_90_1288 VDD VDD VSS VSS gf180mcu_as_sc_mcu7t3v3__fill_1
XFILLER_181_503 VDD VDD VSS VSS gf180mcu_as_sc_mcu7t3v3__fillcap_8
XPHY_EDGE_ROW_29_1_Left_221 VDD VSS gf180mcu_as_sc_mcu7t3v3__tap_2
XFILLER_20_53 VDD VDD VSS VSS gf180mcu_as_sc_mcu7t3v3__fillcap_4
XFILLER_0_410 VDD VDD VSS VSS gf180mcu_as_sc_mcu7t3v3__fillcap_4
XFILLER_136_64 VDD VDD VSS VSS gf180mcu_as_sc_mcu7t3v3__fill_2
XFILLER_161_282 VDD VDD VSS VSS gf180mcu_as_sc_mcu7t3v3__fillcap_16
XFILLER_62_1346 VDD VDD VSS VSS gf180mcu_as_sc_mcu7t3v3__fillcap_8
Xinput300 VDD VDD VSS VSS west_in[12] _4102_/A gf180mcu_as_sc_mcu7t3v3__buff_12
Xinput311 VDD VDD VSS VSS west_in[22] _4184_/A gf180mcu_as_sc_mcu7t3v3__buff_12
XTAP_TAPCELL_ROW_167_1420 VDD VSS gf180mcu_as_sc_mcu7t3v3__tap_2
XFILLER_29_51 VDD VDD VSS VSS gf180mcu_as_sc_mcu7t3v3__fillcap_16
Xinput322 VDD VDD VSS VSS west_in[32] _3938_/A gf180mcu_as_sc_mcu7t3v3__buff_12
XFILLER_96_79 VDD VDD VSS VSS gf180mcu_as_sc_mcu7t3v3__fill_1
XFILLER_152_52 VDD VDD VSS VSS gf180mcu_as_sc_mcu7t3v3__fillcap_16
XTAP_TAPCELL_ROW_4_771 VDD VSS gf180mcu_as_sc_mcu7t3v3__tap_2
XTAP_TAPCELL_ROW_4_760 VDD VSS gf180mcu_as_sc_mcu7t3v3__tap_2
XTAP_TAPCELL_ROW_163_1339 VDD VSS gf180mcu_as_sc_mcu7t3v3__tap_2
XTAP_TAPCELL_ROW_180_1675 VDD VSS gf180mcu_as_sc_mcu7t3v3__tap_2
XTAP_TAPCELL_ROW_180_1664 VDD VSS gf180mcu_as_sc_mcu7t3v3__tap_2
XFILLER_182_1125 VDD VDD VSS VSS gf180mcu_as_sc_mcu7t3v3__fill_2
XFILLER_189_614 VDD VDD VSS VSS gf180mcu_as_sc_mcu7t3v3__fillcap_16
XFILLER_45_72 VDD VDD VSS VSS gf180mcu_as_sc_mcu7t3v3__fillcap_8
XFILLER_182_1147 VDD VDD VSS VSS gf180mcu_as_sc_mcu7t3v3__fill_2
XFILLER_147_1289 VDD VDD VSS VSS gf180mcu_as_sc_mcu7t3v3__fillcap_4
XFILLER_185_842 VDD VDD VSS VSS gf180mcu_as_sc_mcu7t3v3__fillcap_4
XFILLER_157_555 VDD VDD VSS VSS gf180mcu_as_sc_mcu7t3v3__fillcap_4
XFILLER_184_352 VDD VDD VSS VSS gf180mcu_as_sc_mcu7t3v3__fillcap_4
XFILLER_185_886 VDD VDD VSS VSS gf180mcu_as_sc_mcu7t3v3__fillcap_16
XANTENNA_4 VDD VDD VSS VSS _4705_/D gf180mcu_as_sc_mcu7t3v3__diode_2
XFILLER_153_772 VDD VDD VSS VSS gf180mcu_as_sc_mcu7t3v3__fillcap_16
X_3310_ VDD VDD VSS VSS _3314_/B _4343_/Q _3312_/S gf180mcu_as_sc_mcu7t3v3__nand2b_2
XFILLER_112_102 VDD VDD VSS VSS gf180mcu_as_sc_mcu7t3v3__fill_2
XFILLER_180_591 VDD VDD VSS VSS gf180mcu_as_sc_mcu7t3v3__fillcap_4
X_4290_ VDD VDD VSS VSS _4770_/D _4290_/B _4327_/A gf180mcu_as_sc_mcu7t3v3__nor2_2
XTAP_TAPCELL_ROW_187_1807 VDD VSS gf180mcu_as_sc_mcu7t3v3__tap_2
X_3241_ VDD VDD VSS VSS _3242_/D _3241_/B _3306_/A gf180mcu_as_sc_mcu7t3v3__nor2_2
Xmesh_tile_926 VDD VDD VSS VSS nw_out[26] gf180mcu_as_sc_mcu7t3v3__tiel_4
Xmesh_tile_915 VDD VDD VSS VSS nw_out[15] gf180mcu_as_sc_mcu7t3v3__tiel_4
Xmesh_tile_904 VDD VDD VSS VSS nw_out[4] gf180mcu_as_sc_mcu7t3v3__tiel_4
X_3172_ VDD VDD VSS VSS _3174_/B _4357_/Q _3205_/A gf180mcu_as_sc_mcu7t3v3__nand2b_2
Xmesh_tile_959 VDD VDD VSS VSS se_out[23] gf180mcu_as_sc_mcu7t3v3__tiel_4
Xmesh_tile_948 VDD VDD VSS VSS se_out[12] gf180mcu_as_sc_mcu7t3v3__tiel_4
Xmesh_tile_937 VDD VDD VSS VSS se_out[1] gf180mcu_as_sc_mcu7t3v3__tiel_4
XPHY_EDGE_ROW_30_3_Right_71 VDD VSS gf180mcu_as_sc_mcu7t3v3__tap_2
XFILLER_39_1326 VDD VDD VSS VSS gf180mcu_as_sc_mcu7t3v3__fill_2
XPHY_EDGE_ROW_33_3_Left_405 VDD VSS gf180mcu_as_sc_mcu7t3v3__tap_2
XFILLER_167_319 VDD VDD VSS VSS gf180mcu_as_sc_mcu7t3v3__fillcap_16
X_2956_ VDD VDD VSS VSS _3027_/A _2965_/D _2965_/B _4379_/Q _4379_/D gf180mcu_as_sc_mcu7t3v3__ao22_2
XFILLER_175_352 VDD VDD VSS VSS gf180mcu_as_sc_mcu7t3v3__fillcap_16
X_2887_ VDD VDD VSS VSS _4203_/A _2896_/B _2887_/C _2896_/D _2889_/C gf180mcu_as_sc_mcu7t3v3__ao211_2
X_4626_ VDD VDD VSS VSS _4809_/CLK _4626_/D _4626_/Q gf180mcu_as_sc_mcu7t3v3__dfxtp_2
X_4557_ VDD VDD VSS VSS _4728_/CLK _4557_/D _4557_/Q gf180mcu_as_sc_mcu7t3v3__dfxtp_2
XFILLER_172_1305 VDD VDD VSS VSS gf180mcu_as_sc_mcu7t3v3__fillcap_4
XFILLER_190_399 VDD VDD VSS VSS gf180mcu_as_sc_mcu7t3v3__fillcap_16
X_4488_ VDD VDD VSS VSS _4720_/CLK _4488_/D _4488_/Q gf180mcu_as_sc_mcu7t3v3__dfxtp_2
X_3508_ VDD VDD VSS VSS _3611_/C _3525_/B _3600_/A _3511_/D gf180mcu_as_sc_mcu7t3v3__nor3_2
XFILLER_106_34 VDD VDD VSS VSS gf180mcu_as_sc_mcu7t3v3__fill_1
XFILLER_172_1349 VDD VDD VSS VSS gf180mcu_as_sc_mcu7t3v3__fillcap_4
X_3439_ VDD VDD VSS VSS _4568_/Q _3439_/B _3439_/C _4567_/Q _4567_/D gf180mcu_as_sc_mcu7t3v3__ao22_2
X_4743__1029 VDD VDD VSS VSS _4743_/D gf180mcu_as_sc_mcu7t3v3__tiel_4
XFILLER_174_6 VDD VDD VSS VSS gf180mcu_as_sc_mcu7t3v3__fillcap_16
XFILLER_15_31 VDD VDD VSS VSS gf180mcu_as_sc_mcu7t3v3__fill_1
XFILLER_167_842 VDD VDD VSS VSS gf180mcu_as_sc_mcu7t3v3__fillcap_8
XFILLER_107_1284 VDD VDD VSS VSS gf180mcu_as_sc_mcu7t3v3__fillcap_16
XFILLER_147_41 VDD VDD VSS VSS gf180mcu_as_sc_mcu7t3v3__fillcap_8
XTAP_TAPCELL_ROW_9_863 VDD VSS gf180mcu_as_sc_mcu7t3v3__tap_2
XFILLER_153_1282 VDD VDD VSS VSS gf180mcu_as_sc_mcu7t3v3__fill_2
Xinput130 VDD VDD VSS VSS north_in[22] _4182_/D gf180mcu_as_sc_mcu7t3v3__buff_12
Xinput141 VDD VDD VSS VSS north_in[32] _3941_/C gf180mcu_as_sc_mcu7t3v3__buff_12
Xinput152 VDD VDD VSS VSS nw_in[0] _4008_/A gf180mcu_as_sc_mcu7t3v3__buff_12
Xinput163 VDD VDD VSS VSS nw_in[1] _4016_/A gf180mcu_as_sc_mcu7t3v3__buff_12
XTAP_TAPCELL_ROW_182_1704 VDD VSS gf180mcu_as_sc_mcu7t3v3__tap_2
XFILLER_188_1345 VDD VDD VSS VSS gf180mcu_as_sc_mcu7t3v3__fillcap_8
Xinput174 VDD VDD VSS VSS nw_in[2] _4024_/A gf180mcu_as_sc_mcu7t3v3__buff_12
Xinput185 VDD VDD VSS VSS nw_in[7] _4064_/D gf180mcu_as_sc_mcu7t3v3__buff_12
Xinput196 VDD VDD VSS VSS se_in[16] wire797/A gf180mcu_as_sc_mcu7t3v3__buff_12
XFILLER_149_1318 VDD VDD VSS VSS gf180mcu_as_sc_mcu7t3v3__fillcap_4
XTAP_TAPCELL_ROW_85_1_1038 VDD VSS gf180mcu_as_sc_mcu7t3v3__tap_2
XFILLER_186_1080 VDD VDD VSS VSS gf180mcu_as_sc_mcu7t3v3__fillcap_4
XFILLER_31_100 VDD VDD VSS VSS gf180mcu_as_sc_mcu7t3v3__fillcap_4
XFILLER_177_628 VDD VDD VSS VSS gf180mcu_as_sc_mcu7t3v3__fill_2
XFILLER_189_466 VDD VDD VSS VSS gf180mcu_as_sc_mcu7t3v3__fillcap_16
X_3790_ VDD VDD VSS VSS _4136_/A _3881_/B _3879_/B _4134_/D _3791_/D gf180mcu_as_sc_mcu7t3v3__ao22_2
X_2810_ VDD VDD VSS VSS _4788_/Q _2810_/B _2902_/C _4132_/A _2812_/C gf180mcu_as_sc_mcu7t3v3__ao22_2
XFILLER_157_352 VDD VDD VSS VSS gf180mcu_as_sc_mcu7t3v3__fillcap_16
XFILLER_188_81 VDD VDD VSS VSS gf180mcu_as_sc_mcu7t3v3__fillcap_16
X_2741_ VDD VDD VSS VSS _4072_/A _2823_/B _2741_/C _2823_/D _2743_/C gf180mcu_as_sc_mcu7t3v3__ao211_2
XFILLER_160_1275 VDD VDD VSS VSS gf180mcu_as_sc_mcu7t3v3__fillcap_8
XFILLER_160_1297 VDD VDD VSS VSS gf180mcu_as_sc_mcu7t3v3__fill_2
XFILLER_173_823 VDD VDD VSS VSS gf180mcu_as_sc_mcu7t3v3__fill_1
XFILLER_9_896 VDD VDD VSS VSS gf180mcu_as_sc_mcu7t3v3__fillcap_4
XFILLER_9_874 VDD VDD VSS VSS gf180mcu_as_sc_mcu7t3v3__fill_1
XFILLER_172_333 VDD VDD VSS VSS gf180mcu_as_sc_mcu7t3v3__fillcap_8
XFILLER_173_867 VDD VDD VSS VSS gf180mcu_as_sc_mcu7t3v3__fillcap_16
XFILLER_8_384 VDD VDD VSS VSS gf180mcu_as_sc_mcu7t3v3__fill_1
X_4411_ VDD VDD VSS VSS _4440_/CLK _4411_/D _4411_/Q gf180mcu_as_sc_mcu7t3v3__dfxtp_2
X_2672_ VDD VDD VSS VSS _2808_/D _2978_/A _2826_/B _4332_/Q _4332_/D gf180mcu_as_sc_mcu7t3v3__ao22_2
XFILLER_154_1013 VDD VDD VSS VSS gf180mcu_as_sc_mcu7t3v3__fill_2
X_4342_ VDD VDD VSS VSS clkload9/A _4342_/D _4342_/Q gf180mcu_as_sc_mcu7t3v3__dfxtp_2
XFILLER_98_100 VDD VDD VSS VSS gf180mcu_as_sc_mcu7t3v3__fillcap_4
X_4273_ VDD VDD VSS VSS _4278_/A _4764_/Q _4274_/B gf180mcu_as_sc_mcu7t3v3__xnor2_2
XFILLER_132_1311 VDD VDD VSS VSS gf180mcu_as_sc_mcu7t3v3__fill_2
X_3224_ VDD VDD VSS VSS _3225_/D _3224_/B _3369_/A gf180mcu_as_sc_mcu7t3v3__nor2_2
XTAP_TAPCELL_ROW_20_1_973 VDD VSS gf180mcu_as_sc_mcu7t3v3__tap_2
.ends
