* NGSPICE file created from mesh_tile.ext - technology: gf180mcuD

* Black-box entry subcircuit for gf180mcu_as_sc_mcu7t3v3__ao22_2 abstract view
.subckt gf180mcu_as_sc_mcu7t3v3__ao22_2 VDD VNW VPW VSS A B C D Y
.ends

* Black-box entry subcircuit for gf180mcu_as_sc_mcu7t3v3__or2_2 abstract view
.subckt gf180mcu_as_sc_mcu7t3v3__or2_2 VDD VNW VPW VSS B A Y
.ends

* Black-box entry subcircuit for gf180mcu_as_sc_mcu7t3v3__fill_2 abstract view
.subckt gf180mcu_as_sc_mcu7t3v3__fill_2 VDD VNW VPW VSS
.ends

* Black-box entry subcircuit for gf180mcu_as_sc_mcu7t3v3__fillcap_4 abstract view
.subckt gf180mcu_as_sc_mcu7t3v3__fillcap_4 VDD VNW VPW VSS
.ends

* Black-box entry subcircuit for gf180mcu_as_sc_mcu7t3v3__fillcap_8 abstract view
.subckt gf180mcu_as_sc_mcu7t3v3__fillcap_8 VDD VNW VPW VSS
.ends

* Black-box entry subcircuit for gf180mcu_as_sc_mcu7t3v3__fillcap_16 abstract view
.subckt gf180mcu_as_sc_mcu7t3v3__fillcap_16 VDD VNW VPW VSS
.ends

* Black-box entry subcircuit for gf180mcu_as_sc_mcu7t3v3__nor2_2 abstract view
.subckt gf180mcu_as_sc_mcu7t3v3__nor2_2 VDD VNW VPW VSS Y B A
.ends

* Black-box entry subcircuit for gf180mcu_as_sc_mcu7t3v3__fill_1 abstract view
.subckt gf180mcu_as_sc_mcu7t3v3__fill_1 VDD VNW VPW VSS
.ends

* Black-box entry subcircuit for gf180mcu_as_sc_mcu7t3v3__tap_2 abstract view
.subckt gf180mcu_as_sc_mcu7t3v3__tap_2 VDD VSS
.ends

* Black-box entry subcircuit for gf180mcu_as_sc_mcu7t3v3__buff_12 abstract view
.subckt gf180mcu_as_sc_mcu7t3v3__buff_12 VDD VNW VPW VSS A Y
.ends

* Black-box entry subcircuit for gf180mcu_as_sc_mcu7t3v3__clkbuff_12 abstract view
.subckt gf180mcu_as_sc_mcu7t3v3__clkbuff_12 VDD VNW VPW VSS A Y
.ends

* Black-box entry subcircuit for gf180mcu_as_sc_mcu7t3v3__dfxtp_2 abstract view
.subckt gf180mcu_as_sc_mcu7t3v3__dfxtp_2 VDD VNW VPW VSS CLK D Q
.ends

* Black-box entry subcircuit for gf180mcu_as_sc_mcu7t3v3__nand2b_2 abstract view
.subckt gf180mcu_as_sc_mcu7t3v3__nand2b_2 VDD VNW VPW VSS Y B A
.ends

* Black-box entry subcircuit for gf180mcu_as_sc_mcu7t3v3__ao211_2 abstract view
.subckt gf180mcu_as_sc_mcu7t3v3__ao211_2 VDD VNW VPW VSS A B C D Y
.ends

* Black-box entry subcircuit for gf180mcu_as_sc_mcu7t3v3__mux2_2 abstract view
.subckt gf180mcu_as_sc_mcu7t3v3__mux2_2 VDD VNW VPW VSS S B A Y
.ends

* Black-box entry subcircuit for gf180mcu_as_sc_mcu7t3v3__inv_2 abstract view
.subckt gf180mcu_as_sc_mcu7t3v3__inv_2 VDD VNW VPW VSS Y A
.ends

* Black-box entry subcircuit for gf180mcu_as_sc_mcu7t3v3__aoi211_2 abstract view
.subckt gf180mcu_as_sc_mcu7t3v3__aoi211_2 VDD VNW VPW VSS A B C Y D
.ends

* Black-box entry subcircuit for gf180mcu_as_sc_mcu7t3v3__tiel_4 abstract view
.subckt gf180mcu_as_sc_mcu7t3v3__tiel_4 VDD VNW VPW VSS ZERO
.ends

* Black-box entry subcircuit for gf180mcu_as_sc_mcu7t3v3__ao21_2 abstract view
.subckt gf180mcu_as_sc_mcu7t3v3__ao21_2 VDD VNW VPW VSS Y A B C
.ends

* Black-box entry subcircuit for gf180mcu_as_sc_mcu7t3v3__aoi21_2 abstract view
.subckt gf180mcu_as_sc_mcu7t3v3__aoi21_2 VDD VNW VPW VSS Y C B A
.ends

* Black-box entry subcircuit for gf180mcu_as_sc_mcu7t3v3__nand2_2 abstract view
.subckt gf180mcu_as_sc_mcu7t3v3__nand2_2 VDD VNW VPW VSS Y B A
.ends

* Black-box entry subcircuit for gf180mcu_as_sc_mcu7t3v3__nor3_2 abstract view
.subckt gf180mcu_as_sc_mcu7t3v3__nor3_2 VDD VNW VPW VSS A B C Y
.ends

* Black-box entry subcircuit for gf180mcu_as_sc_mcu7t3v3__ao31_2 abstract view
.subckt gf180mcu_as_sc_mcu7t3v3__ao31_2 VDD VNW VPW VSS D A B C Y
.ends

* Black-box entry subcircuit for gf180mcu_as_sc_mcu7t3v3__diode_2 abstract view
.subckt gf180mcu_as_sc_mcu7t3v3__diode_2 VDD VNW VPW VSS DIODE
.ends

* Black-box entry subcircuit for gf180mcu_as_sc_mcu7t3v3__and2_2 abstract view
.subckt gf180mcu_as_sc_mcu7t3v3__and2_2 VDD VNW VPW VSS B A Y
.ends

* Black-box entry subcircuit for gf180mcu_as_sc_mcu7t3v3__aoi21b_2 abstract view
.subckt gf180mcu_as_sc_mcu7t3v3__aoi21b_2 VDD VNW VPW VSS Y C B A
.ends

* Black-box entry subcircuit for gf180mcu_as_sc_mcu7t3v3__nor2b_2 abstract view
.subckt gf180mcu_as_sc_mcu7t3v3__nor2b_2 VDD VNW VPW VSS Y B A
.ends

* Black-box entry subcircuit for gf180mcu_as_sc_mcu7t3v3__xnor2_2 abstract view
.subckt gf180mcu_as_sc_mcu7t3v3__xnor2_2 VDD VNW VPW VSS B A Y
.ends

* Black-box entry subcircuit for gf180mcu_as_sc_mcu7t3v3__nand3_2 abstract view
.subckt gf180mcu_as_sc_mcu7t3v3__nand3_2 VDD VNW VPW VSS A B C Y
.ends

* Black-box entry subcircuit for gf180mcu_as_sc_mcu7t3v3__oai211_2 abstract view
.subckt gf180mcu_as_sc_mcu7t3v3__oai211_2 VDD VNW VPW VSS A B C Y D
.ends

* Black-box entry subcircuit for gf180mcu_as_sc_mcu7t3v3__aoi22_2 abstract view
.subckt gf180mcu_as_sc_mcu7t3v3__aoi22_2 VDD VNW VPW VSS Y A B C D
.ends

* Black-box entry subcircuit for gf180mcu_as_sc_mcu7t3v3__inv_4 abstract view
.subckt gf180mcu_as_sc_mcu7t3v3__inv_4 VDD VNW VPW VSS Y A
.ends

* Black-box entry subcircuit for gf180mcu_as_sc_mcu7t3v3__maj3_2 abstract view
.subckt gf180mcu_as_sc_mcu7t3v3__maj3_2 VDD VNW VPW VSS Y A B C
.ends

* Black-box entry subcircuit for gf180mcu_as_sc_mcu7t3v3__nand4_2 abstract view
.subckt gf180mcu_as_sc_mcu7t3v3__nand4_2 VDD VNW VPW VSS A B C D Y
.ends

* Black-box entry subcircuit for gf180mcu_as_sc_mcu7t3v3__aoi31_2 abstract view
.subckt gf180mcu_as_sc_mcu7t3v3__aoi31_2 VDD VNW VPW VSS A B C Y D
.ends

* Black-box entry subcircuit for gf180mcu_as_sc_mcu7t3v3__buff_2 abstract view
.subckt gf180mcu_as_sc_mcu7t3v3__buff_2 VDD VNW VPW VSS A Y
.ends

* Black-box entry subcircuit for gf180mcu_as_sc_mcu7t3v3__inv_6 abstract view
.subckt gf180mcu_as_sc_mcu7t3v3__inv_6 VDD VNW VPW VSS Y A
.ends

* Black-box entry subcircuit for gf180mcu_as_sc_mcu7t3v3__clkbuff_4 abstract view
.subckt gf180mcu_as_sc_mcu7t3v3__clkbuff_4 VDD VNW VPW VSS A Y
.ends

* Black-box entry subcircuit for gf180mcu_as_sc_mcu7t3v3__dfsrtp_2 abstract view
.subckt gf180mcu_as_sc_mcu7t3v3__dfsrtp_2 VDD VNW VPW VSS CLK Q RN SN D
.ends

* Black-box entry subcircuit for gf180mcu_ocd_ip_sram__sram1024x8m8wm1 abstract view
.subckt gf180mcu_ocd_ip_sram__sram1024x8m8wm1 A[8] A[7] A[6] A[5] A[4] A[3] A[2] A[1]
+ A[0] CEN CLK D[7] D[6] D[5] D[4] D[3] D[2] D[1] D[0] GWEN Q[7] Q[6] Q[5] Q[4] Q[3]
+ Q[2] Q[1] Q[0] VDD VSS WEN[7] WEN[6] WEN[5] WEN[4] WEN[3] WEN[2] WEN[1] WEN[0] A[9]
.ends

* Black-box entry subcircuit for gf180mcu_as_sc_mcu7t3v3__ao21b_2 abstract view
.subckt gf180mcu_as_sc_mcu7t3v3__ao21b_2 VDD VNW VPW VSS Y C B A
.ends

* Black-box entry subcircuit for gf180mcu_as_sc_mcu7t3v3__tieh_4 abstract view
.subckt gf180mcu_as_sc_mcu7t3v3__tieh_4 VDD VNW VPW VSS ONE
.ends

.subckt mesh_tile VDD VSS boot_addr[0] boot_addr[10] boot_addr[1] boot_addr[2] boot_addr[3]
+ boot_addr[4] boot_addr[5] boot_addr[6] boot_addr[7] boot_addr[8] boot_addr[9] boot_data[0]
+ boot_data[1] boot_data[2] boot_data[3] boot_data[4] boot_data[5] boot_data[6] boot_data[7]
+ boot_mode boot_wen clk dft_addr[0] dft_addr[10] dft_addr[1] dft_addr[2] dft_addr[3]
+ dft_addr[4] dft_addr[5] dft_addr[6] dft_addr[7] dft_addr[8] dft_addr[9] dft_ce dft_mode
+ dft_rdata[0] dft_rdata[1] dft_rdata[2] dft_rdata[3] dft_rdata[4] dft_rdata[5] dft_rdata[6]
+ dft_rdata[7] dft_wdata[0] dft_wdata[1] dft_wdata[2] dft_wdata[3] dft_wdata[4] dft_wdata[5]
+ dft_wdata[6] dft_wdata[7] dft_we east_in[0] east_in[10] east_in[11] east_in[12]
+ east_in[13] east_in[14] east_in[15] east_in[16] east_in[17] east_in[18] east_in[19]
+ east_in[1] east_in[20] east_in[21] east_in[22] east_in[23] east_in[24] east_in[25]
+ east_in[26] east_in[27] east_in[28] east_in[29] east_in[2] east_in[30] east_in[31]
+ east_in[32] east_in[33] east_in[3] east_in[4] east_in[5] east_in[6] east_in[7] east_in[8]
+ east_in[9] east_out[0] east_out[10] east_out[11] east_out[12] east_out[13] east_out[14]
+ east_out[15] east_out[16] east_out[17] east_out[18] east_out[19] east_out[1] east_out[20]
+ east_out[21] east_out[22] east_out[23] east_out[24] east_out[25] east_out[26] east_out[27]
+ east_out[28] east_out[29] east_out[2] east_out[30] east_out[31] east_out[32] east_out[33]
+ east_out[3] east_out[4] east_out[5] east_out[6] east_out[7] east_out[8] east_out[9]
+ ne_in[0] ne_in[10] ne_in[11] ne_in[12] ne_in[13] ne_in[14] ne_in[15] ne_in[16] ne_in[17]
+ ne_in[18] ne_in[19] ne_in[1] ne_in[20] ne_in[21] ne_in[22] ne_in[23] ne_in[24] ne_in[25]
+ ne_in[26] ne_in[27] ne_in[28] ne_in[29] ne_in[2] ne_in[30] ne_in[31] ne_in[32] ne_in[33]
+ ne_in[3] ne_in[4] ne_in[5] ne_in[6] ne_in[7] ne_in[8] ne_in[9] ne_out[0] ne_out[10]
+ ne_out[11] ne_out[12] ne_out[13] ne_out[14] ne_out[15] ne_out[16] ne_out[17] ne_out[18]
+ ne_out[19] ne_out[1] ne_out[20] ne_out[21] ne_out[22] ne_out[23] ne_out[24] ne_out[25]
+ ne_out[26] ne_out[27] ne_out[28] ne_out[29] ne_out[2] ne_out[30] ne_out[31] ne_out[32]
+ ne_out[33] ne_out[3] ne_out[4] ne_out[5] ne_out[6] ne_out[7] ne_out[8] ne_out[9]
+ north_in[0] north_in[10] north_in[11] north_in[12] north_in[13] north_in[14] north_in[15]
+ north_in[16] north_in[17] north_in[18] north_in[19] north_in[1] north_in[20] north_in[21]
+ north_in[22] north_in[23] north_in[24] north_in[25] north_in[26] north_in[27] north_in[28]
+ north_in[29] north_in[2] north_in[30] north_in[31] north_in[32] north_in[33] north_in[3]
+ north_in[4] north_in[5] north_in[6] north_in[7] north_in[8] north_in[9] north_out[0]
+ north_out[10] north_out[11] north_out[12] north_out[13] north_out[14] north_out[15]
+ north_out[16] north_out[17] north_out[18] north_out[19] north_out[1] north_out[20]
+ north_out[21] north_out[22] north_out[23] north_out[24] north_out[25] north_out[26]
+ north_out[27] north_out[28] north_out[29] north_out[2] north_out[30] north_out[31]
+ north_out[32] north_out[33] north_out[3] north_out[4] north_out[5] north_out[6]
+ north_out[7] north_out[8] north_out[9] nw_in[0] nw_in[10] nw_in[11] nw_in[12] nw_in[13]
+ nw_in[14] nw_in[15] nw_in[16] nw_in[17] nw_in[18] nw_in[19] nw_in[1] nw_in[20] nw_in[21]
+ nw_in[22] nw_in[23] nw_in[24] nw_in[25] nw_in[26] nw_in[27] nw_in[28] nw_in[29]
+ nw_in[2] nw_in[30] nw_in[31] nw_in[32] nw_in[33] nw_in[3] nw_in[4] nw_in[5] nw_in[6]
+ nw_in[7] nw_in[8] nw_in[9] nw_out[0] nw_out[10] nw_out[11] nw_out[12] nw_out[13]
+ nw_out[14] nw_out[15] nw_out[16] nw_out[17] nw_out[18] nw_out[19] nw_out[1] nw_out[20]
+ nw_out[21] nw_out[22] nw_out[23] nw_out[24] nw_out[25] nw_out[26] nw_out[27] nw_out[28]
+ nw_out[29] nw_out[2] nw_out[30] nw_out[31] nw_out[32] nw_out[33] nw_out[3] nw_out[4]
+ nw_out[5] nw_out[6] nw_out[7] nw_out[8] nw_out[9] rst se_in[0] se_in[10] se_in[11]
+ se_in[12] se_in[13] se_in[14] se_in[15] se_in[16] se_in[17] se_in[18] se_in[19]
+ se_in[1] se_in[20] se_in[21] se_in[22] se_in[23] se_in[24] se_in[25] se_in[26] se_in[27]
+ se_in[28] se_in[29] se_in[2] se_in[30] se_in[31] se_in[32] se_in[33] se_in[3] se_in[4]
+ se_in[5] se_in[6] se_in[7] se_in[8] se_in[9] se_out[0] se_out[10] se_out[11] se_out[12]
+ se_out[13] se_out[14] se_out[15] se_out[16] se_out[17] se_out[18] se_out[19] se_out[1]
+ se_out[20] se_out[21] se_out[22] se_out[23] se_out[24] se_out[25] se_out[26] se_out[27]
+ se_out[28] se_out[29] se_out[2] se_out[30] se_out[31] se_out[32] se_out[33] se_out[3]
+ se_out[4] se_out[5] se_out[6] se_out[7] se_out[8] se_out[9] south_in[0] south_in[10]
+ south_in[11] south_in[12] south_in[13] south_in[14] south_in[15] south_in[16] south_in[17]
+ south_in[18] south_in[19] south_in[1] south_in[20] south_in[21] south_in[22] south_in[23]
+ south_in[24] south_in[25] south_in[26] south_in[27] south_in[28] south_in[29] south_in[2]
+ south_in[30] south_in[31] south_in[32] south_in[33] south_in[3] south_in[4] south_in[5]
+ south_in[6] south_in[7] south_in[8] south_in[9] south_out[0] south_out[10] south_out[11]
+ south_out[12] south_out[13] south_out[14] south_out[15] south_out[16] south_out[17]
+ south_out[18] south_out[19] south_out[1] south_out[20] south_out[21] south_out[22]
+ south_out[23] south_out[24] south_out[25] south_out[26] south_out[27] south_out[28]
+ south_out[29] south_out[2] south_out[30] south_out[31] south_out[32] south_out[33]
+ south_out[3] south_out[4] south_out[5] south_out[6] south_out[7] south_out[8] south_out[9]
+ sw_in[0] sw_in[10] sw_in[11] sw_in[12] sw_in[13] sw_in[14] sw_in[15] sw_in[16] sw_in[17]
+ sw_in[18] sw_in[19] sw_in[1] sw_in[20] sw_in[21] sw_in[22] sw_in[23] sw_in[24] sw_in[25]
+ sw_in[26] sw_in[27] sw_in[28] sw_in[29] sw_in[2] sw_in[30] sw_in[31] sw_in[32] sw_in[33]
+ sw_in[3] sw_in[4] sw_in[5] sw_in[6] sw_in[7] sw_in[8] sw_in[9] sw_out[0] sw_out[10]
+ sw_out[11] sw_out[12] sw_out[13] sw_out[14] sw_out[15] sw_out[16] sw_out[17] sw_out[18]
+ sw_out[19] sw_out[1] sw_out[20] sw_out[21] sw_out[22] sw_out[23] sw_out[24] sw_out[25]
+ sw_out[26] sw_out[27] sw_out[28] sw_out[29] sw_out[2] sw_out[30] sw_out[31] sw_out[32]
+ sw_out[33] sw_out[3] sw_out[4] sw_out[5] sw_out[6] sw_out[7] sw_out[8] sw_out[9]
+ west_in[0] west_in[10] west_in[11] west_in[12] west_in[13] west_in[14] west_in[15]
+ west_in[16] west_in[17] west_in[18] west_in[19] west_in[1] west_in[20] west_in[21]
+ west_in[22] west_in[23] west_in[24] west_in[25] west_in[26] west_in[27] west_in[28]
+ west_in[29] west_in[2] west_in[30] west_in[31] west_in[32] west_in[33] west_in[3]
+ west_in[4] west_in[5] west_in[6] west_in[7] west_in[8] west_in[9] west_out[0] west_out[10]
+ west_out[11] west_out[12] west_out[13] west_out[14] west_out[15] west_out[16] west_out[17]
+ west_out[18] west_out[19] west_out[1] west_out[20] west_out[21] west_out[22] west_out[23]
+ west_out[24] west_out[25] west_out[26] west_out[27] west_out[28] west_out[29] west_out[2]
+ west_out[30] west_out[31] west_out[32] west_out[33] west_out[3] west_out[4] west_out[5]
+ west_out[6] west_out[7] west_out[8] west_out[9]
X_3155_ VDD VDD VSS VSS _4131_/A _3241_/B _3155_/C _3155_/D _3156_/C gf180mcu_as_sc_mcu7t3v3__ao22_2
X_3086_ VDD VDD VSS VSS _3129_/B _4931_/Q _3087_/D gf180mcu_as_sc_mcu7t3v3__or2_2
XFILLER_161_1006 VDD VDD VSS VSS gf180mcu_as_sc_mcu7t3v3__fill_2
XFILLER_165_1186 VDD VDD VSS VSS gf180mcu_as_sc_mcu7t3v3__fillcap_4
XFILLER_10_317 VDD VDD VSS VSS gf180mcu_as_sc_mcu7t3v3__fillcap_8
XFILLER_167_138 VDD VDD VSS VSS gf180mcu_as_sc_mcu7t3v3__fill_2
XFILLER_168_18 VDD VDD VSS VSS gf180mcu_as_sc_mcu7t3v3__fillcap_16
X_3988_ VDD VDD VSS VSS _4984_/Q _4150_/B _4235_/B _4150_/D _4984_/D gf180mcu_as_sc_mcu7t3v3__ao22_2
X_2939_ VDD VDD VSS VSS _3817_/B _3794_/A _3803_/A gf180mcu_as_sc_mcu7t3v3__nor2_2
XFILLER_164_823 VDD VDD VSS VSS gf180mcu_as_sc_mcu7t3v3__fillcap_16
XFILLER_163_366 VDD VDD VSS VSS gf180mcu_as_sc_mcu7t3v3__fill_2
X_4609_ VDD VDD VSS VSS _5203_/Q _4609_/B _4609_/C _5204_/Q _5203_/D gf180mcu_as_sc_mcu7t3v3__ao22_2
XFILLER_190_185 VDD VDD VSS VSS gf180mcu_as_sc_mcu7t3v3__fillcap_4
XFILLER_2_527 VDD VDD VSS VSS gf180mcu_as_sc_mcu7t3v3__fill_1
XFILLER_176_1293 VDD VDD VSS VSS gf180mcu_as_sc_mcu7t3v3__fill_2
XTAP_TAPCELL_ROW_6_811 VDD VSS gf180mcu_as_sc_mcu7t3v3__tap_2
XTAP_TAPCELL_ROW_6_800 VDD VSS gf180mcu_as_sc_mcu7t3v3__tap_2
XFILLER_172_1157 VDD VDD VSS VSS gf180mcu_as_sc_mcu7t3v3__fillcap_8
Xfanout820 VDD VDD VSS VSS _4528_/A _4581_/A gf180mcu_as_sc_mcu7t3v3__buff_12
Xfanout831 VDD VDD VSS VSS fanout835/Y _4341_/S gf180mcu_as_sc_mcu7t3v3__buff_12
Xfanout842 VDD VDD VSS VSS _2666_/A _2701_/A gf180mcu_as_sc_mcu7t3v3__buff_12
Xfanout886 VDD VDD VSS VSS _3699_/D _3615_/D gf180mcu_as_sc_mcu7t3v3__buff_12
XFILLER_93_47 VDD VDD VSS VSS gf180mcu_as_sc_mcu7t3v3__fillcap_16
XFILLER_93_69 VDD VDD VSS VSS gf180mcu_as_sc_mcu7t3v3__fill_1
XPHY_EDGE_ROW_129_3_Right_170 VDD VSS gf180mcu_as_sc_mcu7t3v3__tap_2
XFILLER_13_100 VDD VDD VSS VSS gf180mcu_as_sc_mcu7t3v3__fill_2
XFILLER_165_2 VDD VDD VSS VSS gf180mcu_as_sc_mcu7t3v3__fillcap_8
XFILLER_159_617 VDD VDD VSS VSS gf180mcu_as_sc_mcu7t3v3__fill_2
XFILLER_186_403 VDD VDD VSS VSS gf180mcu_as_sc_mcu7t3v3__fillcap_16
XFILLER_9_104 VDD VDD VSS VSS gf180mcu_as_sc_mcu7t3v3__fillcap_4
XTAP_TAPCELL_ROW_146_1_1099 VDD VSS gf180mcu_as_sc_mcu7t3v3__tap_2
XFILLER_13_188 VDD VDD VSS VSS gf180mcu_as_sc_mcu7t3v3__fillcap_8
XFILLER_9_137 VDD VDD VSS VSS gf180mcu_as_sc_mcu7t3v3__fill_2
Xclkbuf_3_6__f_clk_regs VDD VDD VSS VSS clkbuf_2_3_0_clk_regs/Y clkbuf_3_6__f_clk_regs/Y
+ gf180mcu_as_sc_mcu7t3v3__clkbuff_12
XTAP_TAPCELL_ROW_158_1249 VDD VSS gf180mcu_as_sc_mcu7t3v3__tap_2
XTAP_TAPCELL_ROW_175_1574 VDD VSS gf180mcu_as_sc_mcu7t3v3__tap_2
XTAP_TAPCELL_ROW_175_1563 VDD VSS gf180mcu_as_sc_mcu7t3v3__tap_2
XFILLER_155_867 VDD VDD VSS VSS gf180mcu_as_sc_mcu7t3v3__fill_1
XFILLER_166_193 VDD VDD VSS VSS gf180mcu_as_sc_mcu7t3v3__fill_2
XFILLER_170_804 VDD VDD VSS VSS gf180mcu_as_sc_mcu7t3v3__fill_1
XFILLER_177_1046 VDD VDD VSS VSS gf180mcu_as_sc_mcu7t3v3__fillcap_4
XFILLER_6_877 VDD VDD VSS VSS gf180mcu_as_sc_mcu7t3v3__fillcap_16
XFILLER_177_1068 VDD VDD VSS VSS gf180mcu_as_sc_mcu7t3v3__fill_2
XFILLER_68_1352 VDD VDD VSS VSS gf180mcu_as_sc_mcu7t3v3__fill_2
XFILLER_3_1007 VDD VDD VSS VSS gf180mcu_as_sc_mcu7t3v3__fillcap_4
XFILLER_184_1017 VDD VDD VSS VSS gf180mcu_as_sc_mcu7t3v3__fillcap_4
XFILLER_40_1282 VDD VDD VSS VSS gf180mcu_as_sc_mcu7t3v3__fillcap_4
X_4960_ VDD VDD VSS VSS _5164_/CLK _4960_/D _4960_/Q gf180mcu_as_sc_mcu7t3v3__dfxtp_2
XFILLER_177_403 VDD VDD VSS VSS gf180mcu_as_sc_mcu7t3v3__fill_2
XFILLER_189_230 VDD VDD VSS VSS gf180mcu_as_sc_mcu7t3v3__fill_1
XFILLER_36_1307 VDD VDD VSS VSS gf180mcu_as_sc_mcu7t3v3__fill_2
X_4891_ VDD VDD VSS VSS _4895_/CLK _4891_/D _4891_/Q gf180mcu_as_sc_mcu7t3v3__dfxtp_2
X_3911_ VDD VDD VSS VSS _4198_/A _4099_/D _4907_/Q gf180mcu_as_sc_mcu7t3v3__nor2_2
XFILLER_178_937 VDD VDD VSS VSS gf180mcu_as_sc_mcu7t3v3__fillcap_8
X_3842_ VDD VDD VSS VSS _3843_/S _3845_/B _3846_/B gf180mcu_as_sc_mcu7t3v3__nand2b_2
XFILLER_192_417 VDD VDD VSS VSS gf180mcu_as_sc_mcu7t3v3__fillcap_4
XFILLER_9_671 VDD VDD VSS VSS gf180mcu_as_sc_mcu7t3v3__fillcap_16
X_3773_ VDD VDD VSS VSS _4151_/A _3773_/B _3773_/C _3773_/D _3774_/D gf180mcu_as_sc_mcu7t3v3__ao211_2
XFILLER_160_1083 VDD VDD VSS VSS gf180mcu_as_sc_mcu7t3v3__fill_2
X_2724_ VDD VDD VSS VSS _2724_/S _5179_/Q _5171_/Q _2728_/B gf180mcu_as_sc_mcu7t3v3__mux2_2
XFILLER_12_1351 VDD VDD VSS VSS gf180mcu_as_sc_mcu7t3v3__fillcap_4
Xoutput401 VDD VDD VSS VSS _4822_/Q south_out[17] gf180mcu_as_sc_mcu7t3v3__buff_12
X_2655_ VDD VDD VSS VSS _2656_/C _2655_/B _4262_/B gf180mcu_as_sc_mcu7t3v3__nor2_2
XFILLER_160_314 VDD VDD VSS VSS gf180mcu_as_sc_mcu7t3v3__fill_1
XFILLER_161_837 VDD VDD VSS VSS gf180mcu_as_sc_mcu7t3v3__fill_2
Xoutput434 VDD VDD VSS VSS _4889_/Q west_out[16] gf180mcu_as_sc_mcu7t3v3__buff_12
Xoutput423 VDD VDD VSS VSS _4811_/Q south_out[6] gf180mcu_as_sc_mcu7t3v3__buff_12
Xoutput412 VDD VDD VSS VSS _4832_/Q south_out[27] gf180mcu_as_sc_mcu7t3v3__buff_12
XTAP_TAPCELL_ROW_61_3_1972 VDD VSS gf180mcu_as_sc_mcu7t3v3__tap_2
Xoutput456 VDD VDD VSS VSS _4878_/Q west_out[5] gf180mcu_as_sc_mcu7t3v3__buff_12
Xoutput445 VDD VDD VSS VSS _4899_/Q west_out[26] gf180mcu_as_sc_mcu7t3v3__buff_12
X_4325_ VDD VDD VSS VSS _4325_/S _5155_/Q _5154_/Q _5154_/D gf180mcu_as_sc_mcu7t3v3__mux2_2
X_2586_ VDD VDD VSS VSS _2676_/A _2586_/B _2586_/A _3906_/S gf180mcu_as_sc_mcu7t3v3__mux2_2
X_4256_ VDD VDD VSS VSS _4256_/S _4256_/B _5092_/Q _5092_/D gf180mcu_as_sc_mcu7t3v3__mux2_2
XPHY_EDGE_ROW_100_1_Right_609 VDD VSS gf180mcu_as_sc_mcu7t3v3__tap_2
X_4187_ VDD VDD VSS VSS _4247_/B _4189_/B _4189_/C _5025_/Q _5025_/D gf180mcu_as_sc_mcu7t3v3__ao22_2
X_3207_ VDD VDD VSS VSS _3207_/S _3793_/A _3207_/A _3208_/C gf180mcu_as_sc_mcu7t3v3__mux2_2
X_3138_ VDD VDD VSS VSS _4110_/A _3206_/B _3138_/C _3138_/D _3139_/C gf180mcu_as_sc_mcu7t3v3__ao22_2
XFILLER_103_57 VDD VDD VSS VSS gf180mcu_as_sc_mcu7t3v3__fill_2
X_3069_ VDD VDD VSS VSS _3128_/A _3069_/B _3069_/C _3128_/D _3071_/C gf180mcu_as_sc_mcu7t3v3__ao211_2
XPHY_EDGE_ROW_38_1_Left_230 VDD VSS gf180mcu_as_sc_mcu7t3v3__tap_2
XFILLER_168_414 VDD VDD VSS VSS gf180mcu_as_sc_mcu7t3v3__fill_1
XFILLER_169_948 VDD VDD VSS VSS gf180mcu_as_sc_mcu7t3v3__fill_1
XFILLER_10_114 VDD VDD VSS VSS gf180mcu_as_sc_mcu7t3v3__fillcap_16
Xwire506 VDD VDD VSS VSS _3715_/B _3723_/B gf180mcu_as_sc_mcu7t3v3__clkbuff_12
XFILLER_13_1115 VDD VDD VSS VSS gf180mcu_as_sc_mcu7t3v3__fillcap_4
XFILLER_13_1126 VDD VDD VSS VSS gf180mcu_as_sc_mcu7t3v3__fill_1
XFILLER_6_107 VDD VDD VSS VSS gf180mcu_as_sc_mcu7t3v3__fillcap_8
XFILLER_104_1276 VDD VDD VSS VSS gf180mcu_as_sc_mcu7t3v3__fill_2
XFILLER_192_951 VDD VDD VSS VSS gf180mcu_as_sc_mcu7t3v3__fill_1
XFILLER_152_815 VDD VDD VSS VSS gf180mcu_as_sc_mcu7t3v3__fill_1
XTAP_TAPCELL_ROW_153_1157 VDD VSS gf180mcu_as_sc_mcu7t3v3__tap_2
XTAP_TAPCELL_ROW_153_1146 VDD VSS gf180mcu_as_sc_mcu7t3v3__tap_2
XFILLER_163_163 VDD VDD VSS VSS gf180mcu_as_sc_mcu7t3v3__fillcap_16
XFILLER_164_686 VDD VDD VSS VSS gf180mcu_as_sc_mcu7t3v3__fillcap_16
XFILLER_174_1208 VDD VDD VSS VSS gf180mcu_as_sc_mcu7t3v3__fillcap_4
XTAP_TAPCELL_ROW_170_1471 VDD VSS gf180mcu_as_sc_mcu7t3v3__tap_2
XTAP_TAPCELL_ROW_170_1482 VDD VSS gf180mcu_as_sc_mcu7t3v3__tap_2
XFILLER_144_53 VDD VDD VSS VSS gf180mcu_as_sc_mcu7t3v3__fillcap_4
Xfanout650 VDD VDD VSS VSS fanout650/A _3389_/S gf180mcu_as_sc_mcu7t3v3__buff_12
Xfanout661 VDD VDD VSS VSS _3130_/B _3047_/B gf180mcu_as_sc_mcu7t3v3__buff_12
Xfanout672 VDD VDD VSS VSS _4325_/S _4319_/S gf180mcu_as_sc_mcu7t3v3__buff_12
Xfanout683 VDD VDD VSS VSS _4611_/B _4621_/B gf180mcu_as_sc_mcu7t3v3__buff_12
XFILLER_24_1266 VDD VDD VSS VSS gf180mcu_as_sc_mcu7t3v3__fill_1
XFILLER_185_1304 VDD VDD VSS VSS gf180mcu_as_sc_mcu7t3v3__fill_1
XFILLER_24_1299 VDD VDD VSS VSS gf180mcu_as_sc_mcu7t3v3__fillcap_4
XFILLER_185_1348 VDD VDD VSS VSS gf180mcu_as_sc_mcu7t3v3__fillcap_4
XFILLER_53_72 VDD VDD VSS VSS gf180mcu_as_sc_mcu7t3v3__fillcap_4
XTAP_TAPCELL_ROW_177_1614 VDD VSS gf180mcu_as_sc_mcu7t3v3__tap_2
XTAP_TAPCELL_ROW_177_1603 VDD VSS gf180mcu_as_sc_mcu7t3v3__tap_2
XFILLER_159_458 VDD VDD VSS VSS gf180mcu_as_sc_mcu7t3v3__fill_2
XFILLER_169_72 VDD VDD VSS VSS gf180mcu_as_sc_mcu7t3v3__fillcap_16
XFILLER_70_1264 VDD VDD VSS VSS gf180mcu_as_sc_mcu7t3v3__fillcap_4
XFILLER_70_1286 VDD VDD VSS VSS gf180mcu_as_sc_mcu7t3v3__fill_2
XPHY_EDGE_ROW_105_3_Left_477 VDD VSS gf180mcu_as_sc_mcu7t3v3__tap_2
XTAP_TAPCELL_ROW_190_1858 VDD VSS gf180mcu_as_sc_mcu7t3v3__tap_2
XTAP_TAPCELL_ROW_190_1847 VDD VSS gf180mcu_as_sc_mcu7t3v3__tap_2
XFILLER_154_174 VDD VDD VSS VSS gf180mcu_as_sc_mcu7t3v3__fill_1
XFILLER_155_686 VDD VDD VSS VSS gf180mcu_as_sc_mcu7t3v3__fill_2
XFILLER_170_612 VDD VDD VSS VSS gf180mcu_as_sc_mcu7t3v3__fill_1
X_2440_ VDD VDD VSS VSS _4083_/A _2440_/A gf180mcu_as_sc_mcu7t3v3__inv_2
XPHY_EDGE_ROW_42_3_Left_414 VDD VSS gf180mcu_as_sc_mcu7t3v3__tap_2
XFILLER_155_1185 VDD VDD VSS VSS gf180mcu_as_sc_mcu7t3v3__fillcap_4
XFILLER_190_1087 VDD VDD VSS VSS gf180mcu_as_sc_mcu7t3v3__fillcap_16
X_5090_ VDD VDD VSS VSS _5175_/CLK _5090_/D _5090_/Q gf180mcu_as_sc_mcu7t3v3__dfxtp_2
X_4110_ VDD VDD VSS VSS _4110_/A _4162_/B _4127_/C _4115_/C _4110_/D gf180mcu_as_sc_mcu7t3v3__aoi211_2
X_4041_ VDD VDD VSS VSS _4041_/A _4041_/B _4041_/C _4041_/D _4042_/B gf180mcu_as_sc_mcu7t3v3__ao211_2
Xmesh_tile_1060 VDD VDD VSS VSS sw_out[32] gf180mcu_as_sc_mcu7t3v3__tiel_4
X_4943_ VDD VDD VSS VSS clkload1/A _4943_/D _4943_/Q gf180mcu_as_sc_mcu7t3v3__dfxtp_2
XFILLER_178_734 VDD VDD VSS VSS gf180mcu_as_sc_mcu7t3v3__fill_1
X_4874_ VDD VDD VSS VSS clkload4/A _4874_/D _4874_/Q gf180mcu_as_sc_mcu7t3v3__dfxtp_2
XFILLER_127_1298 VDD VDD VSS VSS gf180mcu_as_sc_mcu7t3v3__fill_1
X_3825_ VDD VDD VSS VSS _3825_/Y _4908_/Q _3826_/B _4753_/A gf180mcu_as_sc_mcu7t3v3__ao21_2
XFILLER_174_951 VDD VDD VSS VSS gf180mcu_as_sc_mcu7t3v3__fill_1
X_3756_ VDD VDD VSS VSS _4135_/D _3773_/B _3756_/C _3756_/D _3757_/C gf180mcu_as_sc_mcu7t3v3__ao211_2
X_2707_ VDD VDD VSS VSS _2735_/A _2707_/B _2707_/C _2735_/D _2709_/C gf180mcu_as_sc_mcu7t3v3__ao211_2
XFILLER_12_1181 VDD VDD VSS VSS gf180mcu_as_sc_mcu7t3v3__fillcap_8
XFILLER_174_995 VDD VDD VSS VSS gf180mcu_as_sc_mcu7t3v3__fillcap_16
X_3687_ VDD VDD VSS VSS _3691_/B _3687_/C _3726_/B _4064_/A gf180mcu_as_sc_mcu7t3v3__aoi21_2
XFILLER_160_144 VDD VDD VSS VSS gf180mcu_as_sc_mcu7t3v3__fillcap_16
X_2638_ VDD VDD VSS VSS _2673_/B _5128_/Q _5192_/Q _2639_/B gf180mcu_as_sc_mcu7t3v3__mux2_2
XFILLER_160_177 VDD VDD VSS VSS gf180mcu_as_sc_mcu7t3v3__fillcap_8
X_2569_ VDD VDD VSS VSS _2875_/B _2747_/A _2795_/A gf180mcu_as_sc_mcu7t3v3__nor2_2
XFILLER_0_839 VDD VDD VSS VSS gf180mcu_as_sc_mcu7t3v3__fill_2
X_4308_ VDD VDD VSS VSS _4314_/S _5138_/Q _5137_/Q _5137_/D gf180mcu_as_sc_mcu7t3v3__mux2_2
XPHY_EDGE_ROW_99_3_Left_471 VDD VSS gf180mcu_as_sc_mcu7t3v3__tap_2
X_4239_ VDD VDD VSS VSS _4256_/S _4239_/B _5075_/Q _5075_/D gf180mcu_as_sc_mcu7t3v3__mux2_2
XFILLER_110_1291 VDD VDD VSS VSS gf180mcu_as_sc_mcu7t3v3__fillcap_16
XFILLER_167_1056 VDD VDD VSS VSS gf180mcu_as_sc_mcu7t3v3__fill_2
XFILLER_12_902 VDD VDD VSS VSS gf180mcu_as_sc_mcu7t3v3__fill_1
XFILLER_90_37 VDD VDD VSS VSS gf180mcu_as_sc_mcu7t3v3__fill_2
XFILLER_12_979 VDD VDD VSS VSS gf180mcu_as_sc_mcu7t3v3__fillcap_16
XFILLER_128_2 VDD VDD VSS VSS gf180mcu_as_sc_mcu7t3v3__fill_2
XFILLER_23_97 VDD VDD VSS VSS gf180mcu_as_sc_mcu7t3v3__fillcap_8
XTAP_TAPCELL_ROW_172_1522 VDD VSS gf180mcu_as_sc_mcu7t3v3__tap_2
XTAP_TAPCELL_ROW_172_1511 VDD VSS gf180mcu_as_sc_mcu7t3v3__tap_2
XFILLER_192_781 VDD VDD VSS VSS gf180mcu_as_sc_mcu7t3v3__fill_1
XFILLER_152_656 VDD VDD VSS VSS gf180mcu_as_sc_mcu7t3v3__fill_2
XFILLER_2_187 VDD VDD VSS VSS gf180mcu_as_sc_mcu7t3v3__fill_2
Xfanout480 VDD VDD VSS VSS _3560_/Y _3706_/A gf180mcu_as_sc_mcu7t3v3__buff_12
Xfanout491 VDD VDD VSS VSS _4347_/Y _4582_/A gf180mcu_as_sc_mcu7t3v3__buff_12
XTAP_TAPCELL_ROW_99_3_2010 VDD VSS gf180mcu_as_sc_mcu7t3v3__tap_2
XTAP_TAPCELL_ROW_113_3_2024 VDD VSS gf180mcu_as_sc_mcu7t3v3__tap_2
XFILLER_179_509 VDD VDD VSS VSS gf180mcu_as_sc_mcu7t3v3__fillcap_16
XFILLER_185_1189 VDD VDD VSS VSS gf180mcu_as_sc_mcu7t3v3__fill_1
XFILLER_175_726 VDD VDD VSS VSS gf180mcu_as_sc_mcu7t3v3__fillcap_4
XFILLER_9_88 VDD VDD VSS VSS gf180mcu_as_sc_mcu7t3v3__fillcap_16
XTAP_TAPCELL_ROW_192_1909 VDD VSS gf180mcu_as_sc_mcu7t3v3__tap_2
XTAP_TAPCELL_ROW_13_952 VDD VSS gf180mcu_as_sc_mcu7t3v3__tap_2
XTAP_TAPCELL_ROW_13_941 VDD VSS gf180mcu_as_sc_mcu7t3v3__tap_2
XTAP_TAPCELL_ROW_13_930 VDD VSS gf180mcu_as_sc_mcu7t3v3__tap_2
X_4590_ VDD VDD VSS VSS _5157_/Q _4590_/B _4590_/C _5107_/Q _4591_/B gf180mcu_as_sc_mcu7t3v3__ao22_2
X_3610_ VDD VDD VSS VSS _3611_/C _3981_/A _3650_/B _3610_/C gf180mcu_as_sc_mcu7t3v3__ao21_2
XTAP_TAPCELL_ROW_13_963 VDD VSS gf180mcu_as_sc_mcu7t3v3__tap_2
XFILLER_174_247 VDD VDD VSS VSS gf180mcu_as_sc_mcu7t3v3__fillcap_16
X_3541_ VDD VDD VSS VSS _3799_/D _3914_/B _4943_/Q gf180mcu_as_sc_mcu7t3v3__nand2_2
XFILLER_171_943 VDD VDD VSS VSS gf180mcu_as_sc_mcu7t3v3__fill_2
Xwire881 VDD VDD VSS VSS wire881/A _3943_/A gf180mcu_as_sc_mcu7t3v3__clkbuff_12
XFILLER_170_453 VDD VDD VSS VSS gf180mcu_as_sc_mcu7t3v3__fill_2
X_3472_ VDD VDD VSS VSS _4939_/Q _3493_/B _3493_/C _4129_/A _3473_/D gf180mcu_as_sc_mcu7t3v3__ao22_2
XFILLER_157_1269 VDD VDD VSS VSS gf180mcu_as_sc_mcu7t3v3__fillcap_16
X_5211_ VDD VDD VSS VSS _5212_/CLK _5211_/D _5211_/Q gf180mcu_as_sc_mcu7t3v3__dfxtp_2
X_2423_ VDD VDD VSS VSS _3936_/A _2955_/A gf180mcu_as_sc_mcu7t3v3__inv_2
X_5142_ VDD VDD VSS VSS _5152_/CLK _5142_/D _5142_/Q gf180mcu_as_sc_mcu7t3v3__dfxtp_2
X_5073_ VDD VDD VSS VSS clkload8/A _5073_/D _5073_/Q gf180mcu_as_sc_mcu7t3v3__dfxtp_2
X_4024_ VDD VDD VSS VSS _4024_/A _4024_/B _4024_/C _4024_/D _4025_/D gf180mcu_as_sc_mcu7t3v3__ao22_2
XTAP_TAPCELL_ROW_0_669 VDD VSS gf180mcu_as_sc_mcu7t3v3__tap_2
Xsram2048.u_bank1_919 VDD VDD VSS VSS sram2048.u_bank1/WEN[0] gf180mcu_as_sc_mcu7t3v3__tiel_4
X_4926_ VDD VDD VSS VSS clkload2/A _4926_/D _4926_/Q gf180mcu_as_sc_mcu7t3v3__dfxtp_2
XFILLER_166_704 VDD VDD VSS VSS gf180mcu_as_sc_mcu7t3v3__fillcap_16
X_4857_ VDD VDD VSS VSS _5278_/CLK _4857_/D _4857_/Q gf180mcu_as_sc_mcu7t3v3__dfxtp_2
XTAP_TAPCELL_ROW_48_3_1959 VDD VSS gf180mcu_as_sc_mcu7t3v3__tap_2
XFILLER_166_748 VDD VDD VSS VSS gf180mcu_as_sc_mcu7t3v3__fillcap_4
XFILLER_178_597 VDD VDD VSS VSS gf180mcu_as_sc_mcu7t3v3__fillcap_4
X_3808_ VDD VDD VSS VSS _3923_/A _3918_/A gf180mcu_as_sc_mcu7t3v3__inv_2
XFILLER_153_409 VDD VDD VSS VSS gf180mcu_as_sc_mcu7t3v3__fillcap_8
XFILLER_181_718 VDD VDD VSS VSS gf180mcu_as_sc_mcu7t3v3__fillcap_8
X_4788_ VDD VDD VSS VSS _5275_/CLK _4788_/D _4788_/Q gf180mcu_as_sc_mcu7t3v3__dfxtp_2
XFILLER_174_770 VDD VDD VSS VSS gf180mcu_as_sc_mcu7t3v3__fill_1
XFILLER_49_1306 VDD VDD VSS VSS gf180mcu_as_sc_mcu7t3v3__fill_2
X_3739_ VDD VDD VSS VSS _4861_/D _3739_/C _3739_/B _4115_/A gf180mcu_as_sc_mcu7t3v3__aoi21_2
XFILLER_162_965 VDD VDD VSS VSS gf180mcu_as_sc_mcu7t3v3__fill_1
XFILLER_125_99 VDD VDD VSS VSS gf180mcu_as_sc_mcu7t3v3__fillcap_4
XFILLER_112_1342 VDD VDD VSS VSS gf180mcu_as_sc_mcu7t3v3__fill_1
XFILLER_95_1326 VDD VDD VSS VSS gf180mcu_as_sc_mcu7t3v3__fillcap_4
XTAP_TAPCELL_ROW_165_1381 VDD VSS gf180mcu_as_sc_mcu7t3v3__tap_2
XFILLER_141_76 VDD VDD VSS VSS gf180mcu_as_sc_mcu7t3v3__fill_2
XFILLER_188_317 VDD VDD VSS VSS gf180mcu_as_sc_mcu7t3v3__fillcap_16
XFILLER_11_231 VDD VDD VSS VSS gf180mcu_as_sc_mcu7t3v3__fillcap_8
XFILLER_157_704 VDD VDD VSS VSS gf180mcu_as_sc_mcu7t3v3__fill_1
XFILLER_169_586 VDD VDD VSS VSS gf180mcu_as_sc_mcu7t3v3__fillcap_4
XFILLER_156_247 VDD VDD VSS VSS gf180mcu_as_sc_mcu7t3v3__fill_2
XFILLER_184_578 VDD VDD VSS VSS gf180mcu_as_sc_mcu7t3v3__fill_2
XFILLER_8_769 VDD VDD VSS VSS gf180mcu_as_sc_mcu7t3v3__fill_2
XFILLER_172_729 VDD VDD VSS VSS gf180mcu_as_sc_mcu7t3v3__fillcap_4
XFILLER_180_751 VDD VDD VSS VSS gf180mcu_as_sc_mcu7t3v3__fillcap_4
XFILLER_4_942 VDD VDD VSS VSS gf180mcu_as_sc_mcu7t3v3__fill_2
XFILLER_117_1264 VDD VDD VSS VSS gf180mcu_as_sc_mcu7t3v3__fill_1
XFILLER_152_1155 VDD VDD VSS VSS gf180mcu_as_sc_mcu7t3v3__fill_1
XTAP_TAPCELL_ROW_185_1768 VDD VSS gf180mcu_as_sc_mcu7t3v3__tap_2
XTAP_TAPCELL_ROW_185_1757 VDD VSS gf180mcu_as_sc_mcu7t3v3__tap_2
X_2972_ VDD VDD VSS VSS _3049_/B _2972_/B _2972_/C _2973_/C gf180mcu_as_sc_mcu7t3v3__nor3_2
XFILLER_37_1276 VDD VDD VSS VSS gf180mcu_as_sc_mcu7t3v3__fill_2
XFILLER_91_91 VDD VDD VSS VSS gf180mcu_as_sc_mcu7t3v3__fillcap_8
X_4711_ VDD VDD VSS VSS _4717_/S _5258_/Q _5259_/Q _4712_/B gf180mcu_as_sc_mcu7t3v3__mux2_2
X_4642_ VDD VDD VSS VSS _4733_/C _4706_/A _5233_/Q _5233_/D gf180mcu_as_sc_mcu7t3v3__mux2_2
XFILLER_163_718 VDD VDD VSS VSS gf180mcu_as_sc_mcu7t3v3__fillcap_16
X_4573_ VDD VDD VSS VSS _4574_/D _4573_/B _4573_/A gf180mcu_as_sc_mcu7t3v3__nor2_2
XFILLER_190_548 VDD VDD VSS VSS gf180mcu_as_sc_mcu7t3v3__fillcap_16
X_3524_ VDD VDD VSS VSS _3524_/D _3524_/A _3817_/A _3524_/C _3525_/B gf180mcu_as_sc_mcu7t3v3__ao31_2
XFILLER_157_1044 VDD VDD VSS VSS gf180mcu_as_sc_mcu7t3v3__fillcap_4
X_3455_ VDD VDD VSS VSS _3731_/A _3477_/B _3455_/C _4826_/D _3730_/D gf180mcu_as_sc_mcu7t3v3__aoi211_2
XFILLER_157_1099 VDD VDD VSS VSS gf180mcu_as_sc_mcu7t3v3__fill_1
X_2406_ VDD VDD VSS VSS _2546_/A _4955_/Q gf180mcu_as_sc_mcu7t3v3__inv_2
X_3386_ VDD VDD VSS VSS _4040_/D _3386_/B _3386_/C _3386_/D _3388_/C gf180mcu_as_sc_mcu7t3v3__ao211_2
XFILLER_170_1255 VDD VDD VSS VSS gf180mcu_as_sc_mcu7t3v3__fill_2
X_5125_ VDD VDD VSS VSS _5275_/CLK _5125_/D _5125_/Q gf180mcu_as_sc_mcu7t3v3__dfxtp_2
X_5056_ VDD VDD VSS VSS _5185_/CLK _5056_/D _5056_/Q gf180mcu_as_sc_mcu7t3v3__dfxtp_2
X_4007_ VDD VDD VSS VSS _4007_/A _4024_/C _4007_/C _4007_/D _4009_/C gf180mcu_as_sc_mcu7t3v3__ao211_2
XFILLER_168_1184 VDD VDD VSS VSS gf180mcu_as_sc_mcu7t3v3__fillcap_16
XFILLER_111_68 VDD VDD VSS VSS gf180mcu_as_sc_mcu7t3v3__fill_2
X_4909_ VDD VDD VSS VSS _5095_/CLK _4909_/D _4909_/Q gf180mcu_as_sc_mcu7t3v3__dfxtp_2
XFILLER_153_228 VDD VDD VSS VSS gf180mcu_as_sc_mcu7t3v3__fillcap_4
XFILLER_154_729 VDD VDD VSS VSS gf180mcu_as_sc_mcu7t3v3__fillcap_4
XFILLER_181_504 VDD VDD VSS VSS gf180mcu_as_sc_mcu7t3v3__fill_2
XFILLER_5_739 VDD VDD VSS VSS gf180mcu_as_sc_mcu7t3v3__fillcap_16
XFILLER_175_1122 VDD VDD VSS VSS gf180mcu_as_sc_mcu7t3v3__fillcap_16
XFILLER_162_784 VDD VDD VSS VSS gf180mcu_as_sc_mcu7t3v3__fillcap_16
XFILLER_1_901 VDD VDD VSS VSS gf180mcu_as_sc_mcu7t3v3__fillcap_8
XFILLER_1_912 VDD VDD VSS VSS gf180mcu_as_sc_mcu7t3v3__fillcap_8
XFILLER_121_103 VDD VDD VSS VSS gf180mcu_as_sc_mcu7t3v3__fill_2
XFILLER_161_294 VDD VDD VSS VSS gf180mcu_as_sc_mcu7t3v3__fill_2
XFILLER_0_444 VDD VDD VSS VSS gf180mcu_as_sc_mcu7t3v3__fillcap_4
XFILLER_96_69 VDD VDD VSS VSS gf180mcu_as_sc_mcu7t3v3__fillcap_16
Xinput301 VDD VDD VSS VSS west_in[26] _4143_/A gf180mcu_as_sc_mcu7t3v3__buff_12
Xinput312 VDD VDD VSS VSS west_in[5] _3973_/A gf180mcu_as_sc_mcu7t3v3__buff_12
XTAP_TAPCELL_ROW_167_1421 VDD VSS gf180mcu_as_sc_mcu7t3v3__tap_2
XTAP_TAPCELL_ROW_167_1410 VDD VSS gf180mcu_as_sc_mcu7t3v3__tap_2
XFILLER_152_64 VDD VDD VSS VSS gf180mcu_as_sc_mcu7t3v3__fillcap_4
XTAP_TAPCELL_ROW_4_761 VDD VSS gf180mcu_as_sc_mcu7t3v3__tap_2
XTAP_TAPCELL_ROW_4_772 VDD VSS gf180mcu_as_sc_mcu7t3v3__tap_2
XFILLER_186_1251 VDD VDD VSS VSS gf180mcu_as_sc_mcu7t3v3__fillcap_4
XTAP_TAPCELL_ROW_180_1665 VDD VSS gf180mcu_as_sc_mcu7t3v3__tap_2
XPHY_EDGE_ROW_114_3_Left_486 VDD VSS gf180mcu_as_sc_mcu7t3v3__tap_2
XFILLER_147_1268 VDD VDD VSS VSS gf180mcu_as_sc_mcu7t3v3__fill_2
XFILLER_12_562 VDD VDD VSS VSS gf180mcu_as_sc_mcu7t3v3__fill_1
XPHY_EDGE_ROW_51_3_Left_423 VDD VSS gf180mcu_as_sc_mcu7t3v3__tap_2
XFILLER_172_515 VDD VDD VSS VSS gf180mcu_as_sc_mcu7t3v3__fillcap_8
XFILLER_177_72 VDD VDD VSS VSS gf180mcu_as_sc_mcu7t3v3__fill_2
XANTENNA_5 VDD VDD VSS VSS _4857_/D gf180mcu_as_sc_mcu7t3v3__diode_2
XFILLER_153_762 VDD VDD VSS VSS gf180mcu_as_sc_mcu7t3v3__fill_1
XFILLER_4_750 VDD VDD VSS VSS gf180mcu_as_sc_mcu7t3v3__fillcap_4
XFILLER_119_1326 VDD VDD VSS VSS gf180mcu_as_sc_mcu7t3v3__fillcap_4
XFILLER_154_1217 VDD VDD VSS VSS gf180mcu_as_sc_mcu7t3v3__fill_1
XFILLER_154_1239 VDD VDD VSS VSS gf180mcu_as_sc_mcu7t3v3__fill_2
XTAP_TAPCELL_ROW_187_1808 VDD VSS gf180mcu_as_sc_mcu7t3v3__tap_2
X_3240_ VDD VDD VSS VSS _3240_/A _3240_/B _3240_/C _3240_/D _3242_/A gf180mcu_as_sc_mcu7t3v3__ao211_2
Xmesh_tile_927 VDD VDD VSS VSS ne_out[1] gf180mcu_as_sc_mcu7t3v3__tiel_4
X_3171_ VDD VDD VSS VSS _4146_/A _3240_/B _3171_/C _3171_/D _3172_/D gf180mcu_as_sc_mcu7t3v3__ao22_2
Xmesh_tile_949 VDD VDD VSS VSS ne_out[23] gf180mcu_as_sc_mcu7t3v3__tiel_4
Xmesh_tile_938 VDD VDD VSS VSS ne_out[12] gf180mcu_as_sc_mcu7t3v3__tiel_4
XFILLER_179_136 VDD VDD VSS VSS gf180mcu_as_sc_mcu7t3v3__fillcap_4
X_2955_ VDD VDD VSS VSS _3097_/A _2955_/B _2955_/A _2956_/B gf180mcu_as_sc_mcu7t3v3__mux2_2
X_2886_ VDD VDD VSS VSS _3511_/A _3520_/A _3776_/A gf180mcu_as_sc_mcu7t3v3__or2_2
X_4625_ VDD VDD VSS VSS _5219_/Q _4629_/B _4629_/C _5220_/Q _5219_/D gf180mcu_as_sc_mcu7t3v3__ao22_2
XFILLER_163_548 VDD VDD VSS VSS gf180mcu_as_sc_mcu7t3v3__fill_1
XFILLER_175_397 VDD VDD VSS VSS gf180mcu_as_sc_mcu7t3v3__fill_2
X_4556_ VDD VDD VSS VSS _5184_/Q _4565_/B _4556_/C _4556_/D _5184_/D gf180mcu_as_sc_mcu7t3v3__ao211_2
XFILLER_190_356 VDD VDD VSS VSS gf180mcu_as_sc_mcu7t3v3__fillcap_16
X_3507_ VDD VDD VSS VSS _3533_/B _3533_/A _3812_/B gf180mcu_as_sc_mcu7t3v3__and2_2
XFILLER_103_103 VDD VDD VSS VSS gf180mcu_as_sc_mcu7t3v3__fill_2
XFILLER_171_570 VDD VDD VSS VSS gf180mcu_as_sc_mcu7t3v3__fillcap_4
X_4487_ VDD VDD VSS VSS _4491_/B _5077_/Q _4570_/S gf180mcu_as_sc_mcu7t3v3__nand2_2
Xclkbuf_leaf_9_clk_regs VDD VDD VSS VSS clkbuf_leaf_9_clk_regs/A clkload9/A gf180mcu_as_sc_mcu7t3v3__clkbuff_12
X_3438_ VDD VDD VSS VSS _4089_/A _3513_/C _3438_/C _3439_/C _3462_/A gf180mcu_as_sc_mcu7t3v3__aoi211_2
X_3369_ VDD VDD VSS VSS _4926_/Q _3369_/B _3369_/C _4023_/A _3370_/C gf180mcu_as_sc_mcu7t3v3__ao22_2
XFILLER_106_79 VDD VDD VSS VSS gf180mcu_as_sc_mcu7t3v3__fill_1
X_5108_ VDD VDD VSS VSS _5266_/CLK _5108_/D _5108_/Q gf180mcu_as_sc_mcu7t3v3__dfxtp_2
X_5039_ VDD VDD VSS VSS clkload8/A _5039_/D _5039_/Q gf180mcu_as_sc_mcu7t3v3__dfxtp_2
XFILLER_167_6 VDD VDD VSS VSS gf180mcu_as_sc_mcu7t3v3__fillcap_16
XFILLER_82_27 VDD VDD VSS VSS gf180mcu_as_sc_mcu7t3v3__fill_1
XTAP_TAPCELL_ROW_51_1_1004 VDD VSS gf180mcu_as_sc_mcu7t3v3__tap_2
XFILLER_13_326 VDD VDD VSS VSS gf180mcu_as_sc_mcu7t3v3__fillcap_8
XFILLER_158_309 VDD VDD VSS VSS gf180mcu_as_sc_mcu7t3v3__fillcap_4
XFILLER_186_629 VDD VDD VSS VSS gf180mcu_as_sc_mcu7t3v3__fillcap_16
XFILLER_179_692 VDD VDD VSS VSS gf180mcu_as_sc_mcu7t3v3__fillcap_8
Xclkbuf_3_5__f_clk_regs VDD VDD VSS VSS clkbuf_2_2_0_clk_regs/Y clkbuf_3_5__f_clk_regs/Y
+ gf180mcu_as_sc_mcu7t3v3__clkbuff_12
XFILLER_166_342 VDD VDD VSS VSS gf180mcu_as_sc_mcu7t3v3__fillcap_4
XFILLER_181_1192 VDD VDD VSS VSS gf180mcu_as_sc_mcu7t3v3__fillcap_4
XFILLER_182_802 VDD VDD VSS VSS gf180mcu_as_sc_mcu7t3v3__fill_2
XFILLER_182_846 VDD VDD VSS VSS gf180mcu_as_sc_mcu7t3v3__fillcap_8
XFILLER_181_378 VDD VDD VSS VSS gf180mcu_as_sc_mcu7t3v3__fillcap_8
XFILLER_162_570 VDD VDD VSS VSS gf180mcu_as_sc_mcu7t3v3__fillcap_16
XTAP_TAPCELL_ROW_9_853 VDD VSS gf180mcu_as_sc_mcu7t3v3__tap_2
XFILLER_1_753 VDD VDD VSS VSS gf180mcu_as_sc_mcu7t3v3__fillcap_16
XTAP_TAPCELL_ROW_9_864 VDD VSS gf180mcu_as_sc_mcu7t3v3__tap_2
XFILLER_1_786 VDD VDD VSS VSS gf180mcu_as_sc_mcu7t3v3__fillcap_16
XFILLER_66_1291 VDD VDD VSS VSS gf180mcu_as_sc_mcu7t3v3__fillcap_8
Xinput120 VDD VDD VSS VSS north_in[17] _4071_/A gf180mcu_as_sc_mcu7t3v3__buff_12
Xinput131 VDD VDD VSS VSS north_in[27] _4152_/A gf180mcu_as_sc_mcu7t3v3__buff_12
Xinput142 VDD VDD VSS VSS north_in[6] _3982_/A gf180mcu_as_sc_mcu7t3v3__buff_12
Xinput153 VDD VDD VSS VSS nw_in[16] _4064_/A gf180mcu_as_sc_mcu7t3v3__buff_12
XTAP_TAPCELL_ROW_182_1705 VDD VSS gf180mcu_as_sc_mcu7t3v3__tap_2
XFILLER_114_1256 VDD VDD VSS VSS gf180mcu_as_sc_mcu7t3v3__fillcap_8
Xinput164 VDD VDD VSS VSS nw_in[26] _4146_/A gf180mcu_as_sc_mcu7t3v3__buff_12
Xinput175 VDD VDD VSS VSS nw_in[5] _3976_/A gf180mcu_as_sc_mcu7t3v3__buff_12
Xinput186 VDD VDD VSS VSS se_in[14] _4049_/A gf180mcu_as_sc_mcu7t3v3__buff_12
Xinput197 VDD VDD VSS VSS se_in[24] _4131_/A gf180mcu_as_sc_mcu7t3v3__buff_12
XFILLER_160_1210 VDD VDD VSS VSS gf180mcu_as_sc_mcu7t3v3__fill_2
XFILLER_177_629 VDD VDD VSS VSS gf180mcu_as_sc_mcu7t3v3__fill_1
XFILLER_189_489 VDD VDD VSS VSS gf180mcu_as_sc_mcu7t3v3__fill_1
XFILLER_9_842 VDD VDD VSS VSS gf180mcu_as_sc_mcu7t3v3__fillcap_4
X_2740_ VDD VDD VSS VSS _4947_/Q _2740_/B _2740_/A _5481_/A gf180mcu_as_sc_mcu7t3v3__mux2_2
XFILLER_185_673 VDD VDD VSS VSS gf180mcu_as_sc_mcu7t3v3__fillcap_16
XFILLER_34_1279 VDD VDD VSS VSS gf180mcu_as_sc_mcu7t3v3__fillcap_8
X_2671_ VDD VDD VSS VSS _2672_/D _2723_/A _2736_/B _2671_/A gf180mcu_as_sc_mcu7t3v3__aoi21b_2
X_4410_ VDD VDD VSS VSS _4414_/B _5068_/Q _4456_/S gf180mcu_as_sc_mcu7t3v3__nand2_2
XFILLER_173_879 VDD VDD VSS VSS gf180mcu_as_sc_mcu7t3v3__fill_2
XFILLER_154_1014 VDD VDD VSS VSS gf180mcu_as_sc_mcu7t3v3__fill_1
X_4341_ VDD VDD VSS VSS _4341_/S _5031_/Q _5060_/Q _4342_/A gf180mcu_as_sc_mcu7t3v3__mux2_2
X_4272_ VDD VDD VSS VSS _4272_/S _4706_/A _5106_/Q _5106_/D gf180mcu_as_sc_mcu7t3v3__mux2_2
X_3223_ VDD VDD VSS VSS _3223_/D _3508_/A _3223_/B _3223_/C _3225_/A gf180mcu_as_sc_mcu7t3v3__ao31_2
XFILLER_80_1299 VDD VDD VSS VSS gf180mcu_as_sc_mcu7t3v3__fillcap_4
X_3154_ VDD VDD VSS VSS _3179_/B _4939_/Q _3155_/D gf180mcu_as_sc_mcu7t3v3__or2_2
X_3085_ VDD VDD VSS VSS _3128_/A _3085_/B _3085_/C _3128_/D _3087_/C gf180mcu_as_sc_mcu7t3v3__ao211_2
XFILLER_168_629 VDD VDD VSS VSS gf180mcu_as_sc_mcu7t3v3__fillcap_16
XFILLER_52_1302 VDD VDD VSS VSS gf180mcu_as_sc_mcu7t3v3__fill_1
X_3987_ VDD VDD VSS VSS _3987_/B _4165_/A _4235_/B gf180mcu_as_sc_mcu7t3v3__and2_2
XTAP_TAPCELL_ROW_98_1_1051 VDD VSS gf180mcu_as_sc_mcu7t3v3__tap_2
X_2938_ VDD VDD VSS VSS _3243_/A _2947_/A _2947_/B gf180mcu_as_sc_mcu7t3v3__nor2b_2
XTAP_TAPCELL_ROW_112_1_1065 VDD VSS gf180mcu_as_sc_mcu7t3v3__tap_2
XFILLER_191_610 VDD VDD VSS VSS gf180mcu_as_sc_mcu7t3v3__fillcap_16
XFILLER_191_632 VDD VDD VSS VSS gf180mcu_as_sc_mcu7t3v3__fillcap_16
X_2869_ VDD VDD VSS VSS _4742_/A _2871_/B _2869_/C _4765_/D gf180mcu_as_sc_mcu7t3v3__nor3_2
XFILLER_190_142 VDD VDD VSS VSS gf180mcu_as_sc_mcu7t3v3__fillcap_4
XFILLER_2_506 VDD VDD VSS VSS gf180mcu_as_sc_mcu7t3v3__fill_2
X_4608_ VDD VDD VSS VSS _5202_/Q _4609_/B _4609_/C _5203_/Q _5202_/D gf180mcu_as_sc_mcu7t3v3__ao22_2
XFILLER_172_1103 VDD VDD VSS VSS gf180mcu_as_sc_mcu7t3v3__fillcap_4
X_4539_ VDD VDD VSS VSS _5182_/Q _4565_/B _4539_/C _4539_/D _5182_/D gf180mcu_as_sc_mcu7t3v3__ao211_2
XFILLER_137_1256 VDD VDD VSS VSS gf180mcu_as_sc_mcu7t3v3__fillcap_4
XFILLER_176_1283 VDD VDD VSS VSS gf180mcu_as_sc_mcu7t3v3__fill_2
XTAP_TAPCELL_ROW_6_812 VDD VSS gf180mcu_as_sc_mcu7t3v3__tap_2
XTAP_TAPCELL_ROW_6_801 VDD VSS gf180mcu_as_sc_mcu7t3v3__tap_2
XFILLER_137_1289 VDD VDD VSS VSS gf180mcu_as_sc_mcu7t3v3__fill_2
Xfanout810 VDD VDD VSS VSS _5223_/Q _2747_/A gf180mcu_as_sc_mcu7t3v3__buff_12
Xfanout821 VDD VDD VSS VSS _4588_/A _4572_/A gf180mcu_as_sc_mcu7t3v3__buff_12
Xfanout832 VDD VDD VSS VSS fanout835/Y _4585_/A gf180mcu_as_sc_mcu7t3v3__buff_12
Xfanout843 VDD VDD VSS VSS _2736_/B _2722_/B gf180mcu_as_sc_mcu7t3v3__buff_12
Xfanout887 VDD VDD VSS VSS _2563_/A _3699_/D gf180mcu_as_sc_mcu7t3v3__buff_12
Xfanout898 VDD VDD VSS VSS input180/Y wire899/A gf180mcu_as_sc_mcu7t3v3__buff_12
XFILLER_158_2 VDD VDD VSS VSS gf180mcu_as_sc_mcu7t3v3__fillcap_16
XTAP_TAPCELL_ROW_158_1239 VDD VSS gf180mcu_as_sc_mcu7t3v3__tap_2
XTAP_TAPCELL_ROW_175_1564 VDD VSS gf180mcu_as_sc_mcu7t3v3__tap_2
XFILLER_10_885 VDD VDD VSS VSS gf180mcu_as_sc_mcu7t3v3__fillcap_4
XFILLER_154_323 VDD VDD VSS VSS gf180mcu_as_sc_mcu7t3v3__fill_1
XFILLER_158_74 VDD VDD VSS VSS gf180mcu_as_sc_mcu7t3v3__fillcap_4
XFILLER_158_85 VDD VDD VSS VSS gf180mcu_as_sc_mcu7t3v3__fillcap_8
XFILLER_6_845 VDD VDD VSS VSS gf180mcu_as_sc_mcu7t3v3__fillcap_16
XTAP_TAPCELL_ROW_175_1575 VDD VSS gf180mcu_as_sc_mcu7t3v3__tap_2
XFILLER_155_1312 VDD VDD VSS VSS gf180mcu_as_sc_mcu7t3v3__fill_1
XPHY_EDGE_ROW_2_Left_195 VDD VSS gf180mcu_as_sc_mcu7t3v3__tap_2
XFILLER_1_550 VDD VDD VSS VSS gf180mcu_as_sc_mcu7t3v3__fill_2
XFILLER_95_104 VDD VDD VSS VSS gf180mcu_as_sc_mcu7t3v3__fill_1
XFILLER_7_1122 VDD VDD VSS VSS gf180mcu_as_sc_mcu7t3v3__fill_1
XFILLER_188_1154 VDD VDD VSS VSS gf180mcu_as_sc_mcu7t3v3__fill_1
X_4890_ VDD VDD VSS VSS _4895_/CLK _4890_/D _4890_/Q gf180mcu_as_sc_mcu7t3v3__dfxtp_2
X_3910_ VDD VDD VSS VSS _4157_/A _4141_/D gf180mcu_as_sc_mcu7t3v3__inv_2
X_3841_ VDD VDD VSS VSS _3845_/B _4911_/Q _4912_/Q gf180mcu_as_sc_mcu7t3v3__nand2_2
X_3772_ VDD VDD VSS VSS _4154_/A _3772_/B _3772_/C _4154_/D _3773_/D gf180mcu_as_sc_mcu7t3v3__ao22_2
XFILLER_158_662 VDD VDD VSS VSS gf180mcu_as_sc_mcu7t3v3__fill_2
XFILLER_192_407 VDD VDD VSS VSS gf180mcu_as_sc_mcu7t3v3__fill_1
X_2723_ VDD VDD VSS VSS _2723_/A _2723_/B _2723_/C _2723_/D _2723_/Y gf180mcu_as_sc_mcu7t3v3__ao22_2
XFILLER_8_193 VDD VDD VSS VSS gf180mcu_as_sc_mcu7t3v3__fillcap_4
Xoutput402 VDD VDD VSS VSS _4823_/Q south_out[18] gf180mcu_as_sc_mcu7t3v3__buff_12
X_2654_ VDD VDD VSS VSS _2673_/B _5130_/Q _5194_/Q _2655_/B gf180mcu_as_sc_mcu7t3v3__mux2_2
XTAP_TAPCELL_ROW_11_891 VDD VSS gf180mcu_as_sc_mcu7t3v3__tap_2
Xoutput435 VDD VDD VSS VSS _4890_/Q west_out[17] gf180mcu_as_sc_mcu7t3v3__buff_12
Xoutput424 VDD VDD VSS VSS _4812_/Q south_out[7] gf180mcu_as_sc_mcu7t3v3__buff_12
Xoutput413 VDD VDD VSS VSS _4833_/Q south_out[28] gf180mcu_as_sc_mcu7t3v3__buff_12
X_2585_ VDD VDD VSS VSS _2585_/Y _2585_/B _2701_/A gf180mcu_as_sc_mcu7t3v3__nand2_2
XFILLER_160_348 VDD VDD VSS VSS gf180mcu_as_sc_mcu7t3v3__fillcap_8
XFILLER_82_1317 VDD VDD VSS VSS gf180mcu_as_sc_mcu7t3v3__fillcap_8
Xoutput457 VDD VDD VSS VSS _4879_/Q west_out[6] gf180mcu_as_sc_mcu7t3v3__buff_12
Xoutput446 VDD VDD VSS VSS _4900_/Q west_out[27] gf180mcu_as_sc_mcu7t3v3__buff_12
X_4324_ VDD VDD VSS VSS _4325_/S _5154_/Q _5153_/Q _5153_/D gf180mcu_as_sc_mcu7t3v3__mux2_2
XPHY_EDGE_ROW_139_3_Left_511 VDD VSS gf180mcu_as_sc_mcu7t3v3__tap_2
X_4255_ VDD VDD VSS VSS _4256_/S _4255_/B _5091_/Q _5091_/D gf180mcu_as_sc_mcu7t3v3__mux2_2
X_4186_ VDD VDD VSS VSS _4246_/B _4186_/B _4186_/C _5024_/Q _5024_/D gf180mcu_as_sc_mcu7t3v3__ao22_2
X_3206_ VDD VDD VSS VSS _3792_/A _3206_/B _3206_/C _3206_/D _3207_/A gf180mcu_as_sc_mcu7t3v3__ao22_2
X_3137_ VDD VDD VSS VSS _3187_/B _4937_/Q _3138_/D gf180mcu_as_sc_mcu7t3v3__or2_2
XTAP_TAPCELL_ROW_131_3_2042 VDD VSS gf180mcu_as_sc_mcu7t3v3__tap_2
XFILLER_167_1249 VDD VDD VSS VSS gf180mcu_as_sc_mcu7t3v3__fillcap_4
X_3068_ VDD VDD VSS VSS _4045_/A _3127_/B _3127_/C _4047_/A _3069_/C gf180mcu_as_sc_mcu7t3v3__ao22_2
XFILLER_11_605 VDD VDD VSS VSS gf180mcu_as_sc_mcu7t3v3__fillcap_8
XFILLER_184_919 VDD VDD VSS VSS gf180mcu_as_sc_mcu7t3v3__fill_1
XFILLER_10_159 VDD VDD VSS VSS gf180mcu_as_sc_mcu7t3v3__fillcap_4
XFILLER_177_982 VDD VDD VSS VSS gf180mcu_as_sc_mcu7t3v3__fillcap_8
XFILLER_183_407 VDD VDD VSS VSS gf180mcu_as_sc_mcu7t3v3__fill_1
XFILLER_7_609 VDD VDD VSS VSS gf180mcu_as_sc_mcu7t3v3__fill_2
Xwire518 VDD VDD VSS VSS _3556_/Y wire518/Y gf180mcu_as_sc_mcu7t3v3__clkbuff_12
XFILLER_104_1288 VDD VDD VSS VSS gf180mcu_as_sc_mcu7t3v3__fill_1
XFILLER_163_142 VDD VDD VSS VSS gf180mcu_as_sc_mcu7t3v3__fillcap_8
XFILLER_192_985 VDD VDD VSS VSS gf180mcu_as_sc_mcu7t3v3__fill_1
XTAP_TAPCELL_ROW_153_1158 VDD VSS gf180mcu_as_sc_mcu7t3v3__tap_2
XTAP_TAPCELL_ROW_153_1147 VDD VSS gf180mcu_as_sc_mcu7t3v3__tap_2
XFILLER_88_37 VDD VDD VSS VSS gf180mcu_as_sc_mcu7t3v3__fillcap_4
XTAP_TAPCELL_ROW_170_1483 VDD VSS gf180mcu_as_sc_mcu7t3v3__tap_2
XTAP_TAPCELL_ROW_170_1472 VDD VSS gf180mcu_as_sc_mcu7t3v3__tap_2
XPHY_EDGE_ROW_123_3_Left_495 VDD VSS gf180mcu_as_sc_mcu7t3v3__tap_2
Xfanout662 VDD VDD VSS VSS _2947_/Y _3063_/B gf180mcu_as_sc_mcu7t3v3__buff_12
Xfanout673 VDD VDD VSS VSS _4325_/S _4326_/S gf180mcu_as_sc_mcu7t3v3__buff_12
Xfanout684 VDD VDD VSS VSS _4629_/B _4611_/B gf180mcu_as_sc_mcu7t3v3__buff_12
XPHY_EDGE_ROW_60_3_Left_432 VDD VSS gf180mcu_as_sc_mcu7t3v3__tap_2
Xfanout695 VDD VDD VSS VSS _3449_/B _3370_/B gf180mcu_as_sc_mcu7t3v3__buff_12
XFILLER_160_75 VDD VDD VSS VSS gf180mcu_as_sc_mcu7t3v3__fillcap_4
XFILLER_187_702 VDD VDD VSS VSS gf180mcu_as_sc_mcu7t3v3__fillcap_16
XTAP_TAPCELL_ROW_66_3_1977 VDD VSS gf180mcu_as_sc_mcu7t3v3__tap_2
XTAP_TAPCELL_ROW_177_1615 VDD VSS gf180mcu_as_sc_mcu7t3v3__tap_2
XTAP_TAPCELL_ROW_177_1604 VDD VSS gf180mcu_as_sc_mcu7t3v3__tap_2
XFILLER_167_492 VDD VDD VSS VSS gf180mcu_as_sc_mcu7t3v3__fillcap_4
XFILLER_186_289 VDD VDD VSS VSS gf180mcu_as_sc_mcu7t3v3__fill_2
XFILLER_10_693 VDD VDD VSS VSS gf180mcu_as_sc_mcu7t3v3__fillcap_8
XFILLER_155_665 VDD VDD VSS VSS gf180mcu_as_sc_mcu7t3v3__fillcap_4
XFILLER_183_974 VDD VDD VSS VSS gf180mcu_as_sc_mcu7t3v3__fillcap_4
XFILLER_185_50 VDD VDD VSS VSS gf180mcu_as_sc_mcu7t3v3__fillcap_16
XTAP_TAPCELL_ROW_190_1859 VDD VSS gf180mcu_as_sc_mcu7t3v3__tap_2
XTAP_TAPCELL_ROW_190_1848 VDD VSS gf180mcu_as_sc_mcu7t3v3__tap_2
XFILLER_185_72 VDD VDD VSS VSS gf180mcu_as_sc_mcu7t3v3__fillcap_16
XFILLER_6_664 VDD VDD VSS VSS gf180mcu_as_sc_mcu7t3v3__fill_1
XFILLER_155_1164 VDD VDD VSS VSS gf180mcu_as_sc_mcu7t3v3__fill_2
XFILLER_68_104 VDD VDD VSS VSS gf180mcu_as_sc_mcu7t3v3__fill_1
XFILLER_2_881 VDD VDD VSS VSS gf180mcu_as_sc_mcu7t3v3__fillcap_4
X_4040_ VDD VDD VSS VSS _4040_/A _4103_/B _4101_/C _4040_/D _4041_/D gf180mcu_as_sc_mcu7t3v3__ao22_2
Xmesh_tile_1061 VDD VDD VSS VSS sw_out[33] gf180mcu_as_sc_mcu7t3v3__tiel_4
Xmesh_tile_1050 VDD VDD VSS VSS sw_out[22] gf180mcu_as_sc_mcu7t3v3__tiel_4
Xclkbuf_leaf_23_clk_regs VDD VDD VSS VSS clkload0/A _5267_/CLK gf180mcu_as_sc_mcu7t3v3__clkbuff_12
X_4942_ VDD VDD VSS VSS _5158_/CLK _4942_/D _4942_/Q gf180mcu_as_sc_mcu7t3v3__dfxtp_2
XFILLER_162_1124 VDD VDD VSS VSS gf180mcu_as_sc_mcu7t3v3__fill_1
XFILLER_177_212 VDD VDD VSS VSS gf180mcu_as_sc_mcu7t3v3__fill_2
XFILLER_162_1157 VDD VDD VSS VSS gf180mcu_as_sc_mcu7t3v3__fillcap_16
X_4873_ VDD VDD VSS VSS clkload4/A _4873_/D _4873_/Q gf180mcu_as_sc_mcu7t3v3__dfxtp_2
XFILLER_127_1288 VDD VDD VSS VSS gf180mcu_as_sc_mcu7t3v3__fillcap_8
XFILLER_159_982 VDD VDD VSS VSS gf180mcu_as_sc_mcu7t3v3__fillcap_4
XFILLER_166_919 VDD VDD VSS VSS gf180mcu_as_sc_mcu7t3v3__fill_1
XFILLER_177_267 VDD VDD VSS VSS gf180mcu_as_sc_mcu7t3v3__fillcap_8
X_3824_ VDD VDD VSS VSS _4907_/D _3824_/C _4168_/A _4907_/Q gf180mcu_as_sc_mcu7t3v3__aoi21b_2
XFILLER_174_941 VDD VDD VSS VSS gf180mcu_as_sc_mcu7t3v3__fillcap_4
X_3755_ VDD VDD VSS VSS _4138_/A _3771_/B _3769_/B _4138_/D _3756_/D gf180mcu_as_sc_mcu7t3v3__ao22_2
X_3686_ VDD VDD VSS VSS _3687_/C _4065_/A _3725_/B _3686_/C gf180mcu_as_sc_mcu7t3v3__ao21_2
X_2706_ VDD VDD VSS VSS _2734_/S _2706_/B _2706_/A _2707_/C gf180mcu_as_sc_mcu7t3v3__mux2_2
XFILLER_161_602 VDD VDD VSS VSS gf180mcu_as_sc_mcu7t3v3__fill_1
XFILLER_173_462 VDD VDD VSS VSS gf180mcu_as_sc_mcu7t3v3__fill_2
X_2637_ VDD VDD VSS VSS _2639_/A _2637_/A gf180mcu_as_sc_mcu7t3v3__inv_2
XPHY_EDGE_ROW_12_Right_12 VDD VSS gf180mcu_as_sc_mcu7t3v3__tap_2
XFILLER_161_668 VDD VDD VSS VSS gf180mcu_as_sc_mcu7t3v3__fill_2
XTAP_TAPCELL_ROW_107_1_1060 VDD VSS gf180mcu_as_sc_mcu7t3v3__tap_2
XFILLER_86_1283 VDD VDD VSS VSS gf180mcu_as_sc_mcu7t3v3__fillcap_4
X_2568_ VDD VDD VSS VSS _5227_/Q _5126_/Q _2806_/D _5125_/Q _2855_/A gf180mcu_as_sc_mcu7t3v3__ao22_2
X_4307_ VDD VDD VSS VSS _4314_/S _5137_/Q _5136_/Q _5136_/D gf180mcu_as_sc_mcu7t3v3__mux2_2
X_2499_ VDD VDD VSS VSS _4708_/A _2747_/A _2795_/A gf180mcu_as_sc_mcu7t3v3__nand2_2
X_4238_ VDD VDD VSS VSS _4256_/S _4238_/B _5074_/Q _5074_/D gf180mcu_as_sc_mcu7t3v3__mux2_2
XFILLER_114_68 VDD VDD VSS VSS gf180mcu_as_sc_mcu7t3v3__fill_1
X_4169_ VDD VDD VSS VSS _4229_/B _4189_/B _4186_/C _5007_/Q _5007_/D gf180mcu_as_sc_mcu7t3v3__ao22_2
XFILLER_130_45 VDD VDD VSS VSS gf180mcu_as_sc_mcu7t3v3__fillcap_4
XFILLER_167_1068 VDD VDD VSS VSS gf180mcu_as_sc_mcu7t3v3__fillcap_16
XFILLER_169_702 VDD VDD VSS VSS gf180mcu_as_sc_mcu7t3v3__fill_1
XFILLER_12_947 VDD VDD VSS VSS gf180mcu_as_sc_mcu7t3v3__fillcap_16
XFILLER_169_746 VDD VDD VSS VSS gf180mcu_as_sc_mcu7t3v3__fillcap_16
XFILLER_156_418 VDD VDD VSS VSS gf180mcu_as_sc_mcu7t3v3__fill_1
XFILLER_8_929 VDD VDD VSS VSS gf180mcu_as_sc_mcu7t3v3__fill_1
XFILLER_139_43 VDD VDD VSS VSS gf180mcu_as_sc_mcu7t3v3__fillcap_16
XFILLER_183_226 VDD VDD VSS VSS gf180mcu_as_sc_mcu7t3v3__fill_2
XTAP_TAPCELL_ROW_172_1512 VDD VSS gf180mcu_as_sc_mcu7t3v3__tap_2
XFILLER_139_98 VDD VDD VSS VSS gf180mcu_as_sc_mcu7t3v3__fillcap_4
XTAP_TAPCELL_ROW_172_1523 VDD VSS gf180mcu_as_sc_mcu7t3v3__tap_2
XFILLER_99_69 VDD VDD VSS VSS gf180mcu_as_sc_mcu7t3v3__fill_1
XFILLER_174_1017 VDD VDD VSS VSS gf180mcu_as_sc_mcu7t3v3__fillcap_4
XFILLER_180_944 VDD VDD VSS VSS gf180mcu_as_sc_mcu7t3v3__fill_1
XFILLER_152_679 VDD VDD VSS VSS gf180mcu_as_sc_mcu7t3v3__fill_1
XFILLER_180_999 VDD VDD VSS VSS gf180mcu_as_sc_mcu7t3v3__fillcap_16
XFILLER_65_1323 VDD VDD VSS VSS gf180mcu_as_sc_mcu7t3v3__fill_1
Xfanout492 VDD VDD VSS VSS _4589_/A _4573_/A gf180mcu_as_sc_mcu7t3v3__buff_12
XFILLER_0_36 VDD VDD VSS VSS gf180mcu_as_sc_mcu7t3v3__fillcap_16
XFILLER_159_212 VDD VDD VSS VSS gf180mcu_as_sc_mcu7t3v3__fillcap_16
XFILLER_187_543 VDD VDD VSS VSS gf180mcu_as_sc_mcu7t3v3__fill_1
XFILLER_159_278 VDD VDD VSS VSS gf180mcu_as_sc_mcu7t3v3__fill_2
XTAP_TAPCELL_ROW_13_953 VDD VSS gf180mcu_as_sc_mcu7t3v3__tap_2
XTAP_TAPCELL_ROW_13_942 VDD VSS gf180mcu_as_sc_mcu7t3v3__tap_2
XTAP_TAPCELL_ROW_13_931 VDD VSS gf180mcu_as_sc_mcu7t3v3__tap_2
XFILLER_156_941 VDD VDD VSS VSS gf180mcu_as_sc_mcu7t3v3__fillcap_4
XTAP_TAPCELL_ROW_14_3_1925 VDD VSS gf180mcu_as_sc_mcu7t3v3__tap_2
XTAP_TAPCELL_ROW_13_964 VDD VSS gf180mcu_as_sc_mcu7t3v3__tap_2
Xwire860 VDD VDD VSS VSS wire860/A _4145_/A gf180mcu_as_sc_mcu7t3v3__clkbuff_12
X_3540_ VDD VDD VSS VSS _3914_/B _4977_/Q _3792_/D gf180mcu_as_sc_mcu7t3v3__and2_2
XPHY_EDGE_ROW_30_1_Right_539 VDD VSS gf180mcu_as_sc_mcu7t3v3__tap_2
XFILLER_142_101 VDD VDD VSS VSS gf180mcu_as_sc_mcu7t3v3__fillcap_4
Xwire882 VDD VDD VSS VSS wire882/A _4025_/A gf180mcu_as_sc_mcu7t3v3__clkbuff_12
XFILLER_192_1117 VDD VDD VSS VSS gf180mcu_as_sc_mcu7t3v3__fillcap_4
XFILLER_192_1128 VDD VDD VSS VSS gf180mcu_as_sc_mcu7t3v3__fillcap_4
X_5210_ VDD VDD VSS VSS _5212_/CLK _5210_/D _5210_/Q gf180mcu_as_sc_mcu7t3v3__dfxtp_2
X_3471_ VDD VDD VSS VSS _3494_/B _4130_/A _3473_/C gf180mcu_as_sc_mcu7t3v3__and2_2
XFILLER_170_476 VDD VDD VSS VSS gf180mcu_as_sc_mcu7t3v3__fill_2
XFILLER_171_977 VDD VDD VSS VSS gf180mcu_as_sc_mcu7t3v3__fill_2
X_2422_ VDD VDD VSS VSS _2663_/A input8/Y gf180mcu_as_sc_mcu7t3v3__inv_2
X_5141_ VDD VDD VSS VSS _5152_/CLK _5141_/D _5141_/Q gf180mcu_as_sc_mcu7t3v3__dfxtp_2
X_5072_ VDD VDD VSS VSS _5178_/CLK _5072_/D _5072_/Q gf180mcu_as_sc_mcu7t3v3__dfxtp_2
X_4023_ VDD VDD VSS VSS _4023_/A _4023_/B _4023_/C _4926_/Q _4025_/C gf180mcu_as_sc_mcu7t3v3__ao22_2
XFILLER_100_37 VDD VDD VSS VSS gf180mcu_as_sc_mcu7t3v3__fillcap_4
X_4925_ VDD VDD VSS VSS _5075_/CLK _4925_/D _4925_/Q gf180mcu_as_sc_mcu7t3v3__dfxtp_2
X_4856_ VDD VDD VSS VSS _5278_/CLK _4856_/D _4856_/Q gf180mcu_as_sc_mcu7t3v3__dfxtp_2
XFILLER_53_1260 VDD VDD VSS VSS gf180mcu_as_sc_mcu7t3v3__fill_2
X_3807_ VDD VDD VSS VSS _3918_/A _3807_/B _3807_/A gf180mcu_as_sc_mcu7t3v3__nand2_2
XFILLER_88_1301 VDD VDD VSS VSS gf180mcu_as_sc_mcu7t3v3__fillcap_4
X_4787_ VDD VDD VSS VSS _5150_/CLK _4787_/D _4787_/Q gf180mcu_as_sc_mcu7t3v3__dfxtp_2
XPHY_EDGE_ROW_19_1_Left_211 VDD VSS gf180mcu_as_sc_mcu7t3v3__tap_2
XFILLER_88_1334 VDD VDD VSS VSS gf180mcu_as_sc_mcu7t3v3__fillcap_16
X_3738_ VDD VDD VSS VSS _3738_/D _3794_/S _3738_/B _3738_/C _3739_/C gf180mcu_as_sc_mcu7t3v3__ao31_2
XFILLER_109_68 VDD VDD VSS VSS gf180mcu_as_sc_mcu7t3v3__fill_2
XFILLER_162_944 VDD VDD VSS VSS gf180mcu_as_sc_mcu7t3v3__fill_1
X_3669_ VDD VDD VSS VSS _4852_/D _3669_/C _3723_/B _4043_/A gf180mcu_as_sc_mcu7t3v3__aoi21_2
XFILLER_161_476 VDD VDD VSS VSS gf180mcu_as_sc_mcu7t3v3__fillcap_8
XFILLER_175_1348 VDD VDD VSS VSS gf180mcu_as_sc_mcu7t3v3__fillcap_4
XTAP_TAPCELL_ROW_118_3_2029 VDD VSS gf180mcu_as_sc_mcu7t3v3__tap_2
XFILLER_0_648 VDD VDD VSS VSS gf180mcu_as_sc_mcu7t3v3__fill_2
XFILLER_125_56 VDD VDD VSS VSS gf180mcu_as_sc_mcu7t3v3__fillcap_4
XFILLER_173_1072 VDD VDD VSS VSS gf180mcu_as_sc_mcu7t3v3__fill_2
XFILLER_169_1119 VDD VDD VSS VSS gf180mcu_as_sc_mcu7t3v3__fill_1
XFILLER_112_1354 VDD VDD VSS VSS gf180mcu_as_sc_mcu7t3v3__fill_1
XTAP_TAPCELL_ROW_165_1382 VDD VSS gf180mcu_as_sc_mcu7t3v3__tap_2
XFILLER_180_1065 VDD VDD VSS VSS gf180mcu_as_sc_mcu7t3v3__fillcap_8
XFILLER_184_502 VDD VDD VSS VSS gf180mcu_as_sc_mcu7t3v3__fill_1
XFILLER_12_777 VDD VDD VSS VSS gf180mcu_as_sc_mcu7t3v3__fillcap_16
XFILLER_180_1087 VDD VDD VSS VSS gf180mcu_as_sc_mcu7t3v3__fillcap_16
XFILLER_184_524 VDD VDD VSS VSS gf180mcu_as_sc_mcu7t3v3__fill_1
XFILLER_184_535 VDD VDD VSS VSS gf180mcu_as_sc_mcu7t3v3__fill_2
XFILLER_8_737 VDD VDD VSS VSS gf180mcu_as_sc_mcu7t3v3__fillcap_16
XFILLER_7_269 VDD VDD VSS VSS gf180mcu_as_sc_mcu7t3v3__fill_1
XFILLER_152_410 VDD VDD VSS VSS gf180mcu_as_sc_mcu7t3v3__fillcap_4
XFILLER_152_1145 VDD VDD VSS VSS gf180mcu_as_sc_mcu7t3v3__fillcap_8
XFILLER_59_72 VDD VDD VSS VSS gf180mcu_as_sc_mcu7t3v3__fill_1
XTAP_TAPCELL_ROW_185_1769 VDD VSS gf180mcu_as_sc_mcu7t3v3__tap_2
XTAP_TAPCELL_ROW_185_1758 VDD VSS gf180mcu_as_sc_mcu7t3v3__tap_2
XFILLER_187_1208 VDD VDD VSS VSS gf180mcu_as_sc_mcu7t3v3__fillcap_16
XPHY_EDGE_ROW_20_3_Right_61 VDD VSS gf180mcu_as_sc_mcu7t3v3__tap_2
XPHY_EDGE_ROW_147_1_Left_339 VDD VSS gf180mcu_as_sc_mcu7t3v3__tap_2
XFILLER_179_329 VDD VDD VSS VSS gf180mcu_as_sc_mcu7t3v3__fill_1
XFILLER_163_1241 VDD VDD VSS VSS gf180mcu_as_sc_mcu7t3v3__fillcap_4
X_2971_ VDD VDD VSS VSS _3952_/A _3047_/B _2971_/C _2971_/D _2972_/C gf180mcu_as_sc_mcu7t3v3__ao22_2
XPHY_EDGE_ROW_148_3_Left_520 VDD VSS gf180mcu_as_sc_mcu7t3v3__tap_2
XFILLER_188_874 VDD VDD VSS VSS gf180mcu_as_sc_mcu7t3v3__fill_1
XFILLER_188_885 VDD VDD VSS VSS gf180mcu_as_sc_mcu7t3v3__fill_2
X_4710_ VDD VDD VSS VSS _4721_/A _4710_/B _5104_/Q _5257_/D gf180mcu_as_sc_mcu7t3v3__mux2_2
X_4641_ VDD VDD VSS VSS _4728_/B _4694_/B _5232_/Q _5232_/D gf180mcu_as_sc_mcu7t3v3__mux2_2
XFILLER_190_527 VDD VDD VSS VSS gf180mcu_as_sc_mcu7t3v3__fillcap_8
X_4572_ VDD VDD VSS VSS _4572_/D _4572_/A _4572_/B _4572_/C _4573_/B gf180mcu_as_sc_mcu7t3v3__ao31_2
XFILLER_7_792 VDD VDD VSS VSS gf180mcu_as_sc_mcu7t3v3__fill_2
X_3523_ VDD VDD VSS VSS _3524_/D _3523_/C _3523_/B _3523_/A gf180mcu_as_sc_mcu7t3v3__aoi21b_2
XFILLER_157_1034 VDD VDD VSS VSS gf180mcu_as_sc_mcu7t3v3__fill_1
X_3454_ VDD VDD VSS VSS _3454_/A _3454_/B _3454_/C _3455_/C gf180mcu_as_sc_mcu7t3v3__nor3_2
XFILLER_130_104 VDD VDD VSS VSS gf180mcu_as_sc_mcu7t3v3__fill_1
XFILLER_170_1201 VDD VDD VSS VSS gf180mcu_as_sc_mcu7t3v3__fillcap_8
X_2405_ VDD VDD VSS VSS _4704_/A _5222_/Q gf180mcu_as_sc_mcu7t3v3__inv_2
X_3385_ VDD VDD VSS VSS _4928_/Q _3448_/B _3448_/C _4039_/A _3386_/C gf180mcu_as_sc_mcu7t3v3__ao22_2
X_5124_ VDD VDD VSS VSS _5267_/CLK _5124_/D _5124_/Q gf180mcu_as_sc_mcu7t3v3__dfxtp_2
X_5055_ VDD VDD VSS VSS _5185_/CLK _5055_/D _5055_/Q gf180mcu_as_sc_mcu7t3v3__dfxtp_2
X_4006_ VDD VDD VSS VSS _4006_/A _4021_/C _4024_/B _4006_/D _4007_/D gf180mcu_as_sc_mcu7t3v3__ao22_2
XFILLER_0_1353 VDD VDD VSS VSS gf180mcu_as_sc_mcu7t3v3__fill_2
XFILLER_164_1005 VDD VDD VSS VSS gf180mcu_as_sc_mcu7t3v3__fillcap_8
XFILLER_55_1322 VDD VDD VSS VSS gf180mcu_as_sc_mcu7t3v3__fill_2
XTAP_TAPCELL_ROW_160_1290 VDD VSS gf180mcu_as_sc_mcu7t3v3__tap_2
XFILLER_179_874 VDD VDD VSS VSS gf180mcu_as_sc_mcu7t3v3__fill_2
XFILLER_181_1352 VDD VDD VSS VSS gf180mcu_as_sc_mcu7t3v3__fill_2
Xclkbuf_3_4__f_clk_regs VDD VDD VSS VSS clkbuf_2_2_0_clk_regs/Y clkbuf_3_4__f_clk_regs/Y
+ gf180mcu_as_sc_mcu7t3v3__clkbuff_12
X_4908_ VDD VDD VSS VSS _5095_/CLK _4908_/D _4908_/Q gf180mcu_as_sc_mcu7t3v3__dfxtp_2
XFILLER_178_384 VDD VDD VSS VSS gf180mcu_as_sc_mcu7t3v3__fill_1
X_4839_ VDD VDD VSS VSS _5150_/CLK _4839_/D _4839_/Q gf180mcu_as_sc_mcu7t3v3__dfxtp_2
XPHY_EDGE_ROW_159_Right_21 VDD VSS gf180mcu_as_sc_mcu7t3v3__tap_2
XFILLER_5_718 VDD VDD VSS VSS gf180mcu_as_sc_mcu7t3v3__fillcap_8
XFILLER_4_228 VDD VDD VSS VSS gf180mcu_as_sc_mcu7t3v3__fillcap_4
XFILLER_20_77 VDD VDD VSS VSS gf180mcu_as_sc_mcu7t3v3__fillcap_16
XFILLER_175_1178 VDD VDD VSS VSS gf180mcu_as_sc_mcu7t3v3__fillcap_8
XFILLER_1_924 VDD VDD VSS VSS gf180mcu_as_sc_mcu7t3v3__fill_1
XFILLER_62_1304 VDD VDD VSS VSS gf180mcu_as_sc_mcu7t3v3__fill_1
XFILLER_96_37 VDD VDD VSS VSS gf180mcu_as_sc_mcu7t3v3__fillcap_16
Xinput302 VDD VDD VSS VSS west_in[27] _4151_/A gf180mcu_as_sc_mcu7t3v3__buff_12
XTAP_TAPCELL_ROW_167_1411 VDD VSS gf180mcu_as_sc_mcu7t3v3__tap_2
XFILLER_0_478 VDD VDD VSS VSS gf180mcu_as_sc_mcu7t3v3__fillcap_4
XFILLER_152_10 VDD VDD VSS VSS gf180mcu_as_sc_mcu7t3v3__fill_1
Xinput313 VDD VDD VSS VSS west_in[6] _3981_/A gf180mcu_as_sc_mcu7t3v3__buff_12
XTAP_TAPCELL_ROW_167_1422 VDD VSS gf180mcu_as_sc_mcu7t3v3__tap_2
XPHY_EDGE_ROW_168_Right_30 VDD VSS gf180mcu_as_sc_mcu7t3v3__tap_2
XFILLER_188_2 VDD VDD VSS VSS gf180mcu_as_sc_mcu7t3v3__fillcap_16
XFILLER_29_64 VDD VDD VSS VSS gf180mcu_as_sc_mcu7t3v3__fillcap_4
XTAP_TAPCELL_ROW_149_1_1102 VDD VSS gf180mcu_as_sc_mcu7t3v3__tap_2
XFILLER_5_1253 VDD VDD VSS VSS gf180mcu_as_sc_mcu7t3v3__fillcap_4
XTAP_TAPCELL_ROW_4_773 VDD VSS gf180mcu_as_sc_mcu7t3v3__tap_2
XTAP_TAPCELL_ROW_4_762 VDD VSS gf180mcu_as_sc_mcu7t3v3__tap_2
XFILLER_99_1271 VDD VDD VSS VSS gf180mcu_as_sc_mcu7t3v3__fill_1
XTAP_TAPCELL_ROW_180_1666 VDD VSS gf180mcu_as_sc_mcu7t3v3__tap_2
XFILLER_188_104 VDD VDD VSS VSS gf180mcu_as_sc_mcu7t3v3__fill_1
XFILLER_45_74 VDD VDD VSS VSS gf180mcu_as_sc_mcu7t3v3__fill_1
XTAP_TAPCELL_ROW_130_1_1083 VDD VSS gf180mcu_as_sc_mcu7t3v3__tap_2
XFILLER_157_524 VDD VDD VSS VSS gf180mcu_as_sc_mcu7t3v3__fill_2
XFILLER_184_310 VDD VDD VSS VSS gf180mcu_as_sc_mcu7t3v3__fillcap_4
XFILLER_157_557 VDD VDD VSS VSS gf180mcu_as_sc_mcu7t3v3__fill_2
XFILLER_123_1280 VDD VDD VSS VSS gf180mcu_as_sc_mcu7t3v3__fill_1
XFILLER_172_527 VDD VDD VSS VSS gf180mcu_as_sc_mcu7t3v3__fill_2
XFILLER_184_387 VDD VDD VSS VSS gf180mcu_as_sc_mcu7t3v3__fillcap_16
XFILLER_185_899 VDD VDD VSS VSS gf180mcu_as_sc_mcu7t3v3__fill_1
XANTENNA_6 VDD VDD VSS VSS _4858_/D gf180mcu_as_sc_mcu7t3v3__diode_2
XFILLER_152_240 VDD VDD VSS VSS gf180mcu_as_sc_mcu7t3v3__fill_2
XFILLER_6_68 VDD VDD VSS VSS gf180mcu_as_sc_mcu7t3v3__fill_1
XFILLER_112_104 VDD VDD VSS VSS gf180mcu_as_sc_mcu7t3v3__fill_1
XFILLER_180_571 VDD VDD VSS VSS gf180mcu_as_sc_mcu7t3v3__fillcap_16
X_3170_ VDD VDD VSS VSS _3178_/A _3170_/B _3170_/C _3178_/D _3171_/D gf180mcu_as_sc_mcu7t3v3__ao211_2
Xmesh_tile_939 VDD VDD VSS VSS ne_out[13] gf180mcu_as_sc_mcu7t3v3__tiel_4
Xmesh_tile_928 VDD VDD VSS VSS ne_out[2] gf180mcu_as_sc_mcu7t3v3__tiel_4
XFILLER_78_1322 VDD VDD VSS VSS gf180mcu_as_sc_mcu7t3v3__fillcap_4
XFILLER_130_1295 VDD VDD VSS VSS gf180mcu_as_sc_mcu7t3v3__fill_2
XFILLER_126_1309 VDD VDD VSS VSS gf180mcu_as_sc_mcu7t3v3__fill_1
X_4885__1083 VDD VDD VSS VSS _4885_/D gf180mcu_as_sc_mcu7t3v3__tiel_4
XFILLER_175_310 VDD VDD VSS VSS gf180mcu_as_sc_mcu7t3v3__fillcap_4
XFILLER_176_811 VDD VDD VSS VSS gf180mcu_as_sc_mcu7t3v3__fill_1
X_2954_ VDD VDD VSS VSS _3934_/A _3207_/S _2954_/C _2954_/D _2955_/B gf180mcu_as_sc_mcu7t3v3__ao211_2
XFILLER_176_877 VDD VDD VSS VSS gf180mcu_as_sc_mcu7t3v3__fillcap_16
XFILLER_187_192 VDD VDD VSS VSS gf180mcu_as_sc_mcu7t3v3__fill_2
X_2885_ VDD VDD VSS VSS _3780_/A _3511_/A _3520_/A gf180mcu_as_sc_mcu7t3v3__nor2_2
X_4624_ VDD VDD VSS VSS _5218_/Q _4629_/B _4629_/C _5219_/Q _5218_/D gf180mcu_as_sc_mcu7t3v3__ao22_2
XPHY_EDGE_ROW_6_Right_6 VDD VSS gf180mcu_as_sc_mcu7t3v3__tap_2
XFILLER_156_590 VDD VDD VSS VSS gf180mcu_as_sc_mcu7t3v3__fillcap_4
X_4555_ VDD VDD VSS VSS _4555_/B _4591_/A _4556_/D gf180mcu_as_sc_mcu7t3v3__and2_2
XFILLER_11_1258 VDD VDD VSS VSS gf180mcu_as_sc_mcu7t3v3__fill_2
XFILLER_85_1326 VDD VDD VSS VSS gf180mcu_as_sc_mcu7t3v3__fill_2
X_3506_ VDD VDD VSS VSS _3506_/B _3525_/A _4833_/D gf180mcu_as_sc_mcu7t3v3__and2_2
X_4486_ VDD VDD VSS VSS _5176_/Q _4565_/B _4486_/C _4486_/D _5176_/D gf180mcu_as_sc_mcu7t3v3__ao211_2
X_3437_ VDD VDD VSS VSS _4085_/D _3500_/B _3437_/C _3437_/D _3438_/C gf180mcu_as_sc_mcu7t3v3__ao211_2
XFILLER_106_69 VDD VDD VSS VSS gf180mcu_as_sc_mcu7t3v3__fillcap_8
X_3368_ VDD VDD VSS VSS _3647_/A _3454_/A _3368_/C _4815_/D _3615_/D gf180mcu_as_sc_mcu7t3v3__aoi211_2
X_5107_ VDD VDD VSS VSS _5266_/CLK _5107_/D _5107_/Q gf180mcu_as_sc_mcu7t3v3__dfxtp_2
X_3299_ VDD VDD VSS VSS _3949_/A _3370_/B _3299_/C _3299_/D _3301_/C gf180mcu_as_sc_mcu7t3v3__ao211_2
XTAP_TAPCELL_ROW_1_710 VDD VSS gf180mcu_as_sc_mcu7t3v3__tap_2
XFILLER_122_24 VDD VDD VSS VSS gf180mcu_as_sc_mcu7t3v3__fillcap_4
X_5038_ VDD VDD VSS VSS clkload8/A _5038_/D _5038_/Q gf180mcu_as_sc_mcu7t3v3__dfxtp_2
XTAP_TAPCELL_ROW_162_1330 VDD VSS gf180mcu_as_sc_mcu7t3v3__tap_2
XFILLER_0_1183 VDD VDD VSS VSS gf180mcu_as_sc_mcu7t3v3__fillcap_4
XFILLER_13_338 VDD VDD VSS VSS gf180mcu_as_sc_mcu7t3v3__fill_2
XFILLER_15_88 VDD VDD VSS VSS gf180mcu_as_sc_mcu7t3v3__fillcap_16
XFILLER_181_1160 VDD VDD VSS VSS gf180mcu_as_sc_mcu7t3v3__fill_2
XFILLER_167_866 VDD VDD VSS VSS gf180mcu_as_sc_mcu7t3v3__fillcap_4
XFILLER_147_10 VDD VDD VSS VSS gf180mcu_as_sc_mcu7t3v3__fill_2
XFILLER_182_825 VDD VDD VSS VSS gf180mcu_as_sc_mcu7t3v3__fill_2
XFILLER_154_527 VDD VDD VSS VSS gf180mcu_as_sc_mcu7t3v3__fillcap_16
XFILLER_166_398 VDD VDD VSS VSS gf180mcu_as_sc_mcu7t3v3__fill_2
XFILLER_31_76 VDD VDD VSS VSS gf180mcu_as_sc_mcu7t3v3__fill_1
XFILLER_147_98 VDD VDD VSS VSS gf180mcu_as_sc_mcu7t3v3__fillcap_4
XTAP_TAPCELL_ROW_9_865 VDD VSS gf180mcu_as_sc_mcu7t3v3__tap_2
XTAP_TAPCELL_ROW_9_854 VDD VSS gf180mcu_as_sc_mcu7t3v3__tap_2
XFILLER_153_1262 VDD VDD VSS VSS gf180mcu_as_sc_mcu7t3v3__fillcap_8
XFILLER_66_1281 VDD VDD VSS VSS gf180mcu_as_sc_mcu7t3v3__fillcap_8
Xinput110 VDD VDD VSS VSS ne_in[8] _3997_/A gf180mcu_as_sc_mcu7t3v3__buff_12
XFILLER_7_1348 VDD VDD VSS VSS gf180mcu_as_sc_mcu7t3v3__fillcap_4
Xinput121 VDD VDD VSS VSS north_in[18] _4079_/A gf180mcu_as_sc_mcu7t3v3__buff_12
Xinput132 VDD VDD VSS VSS north_in[28] _4160_/D gf180mcu_as_sc_mcu7t3v3__buff_12
Xinput143 VDD VDD VSS VSS north_in[7] _3990_/A gf180mcu_as_sc_mcu7t3v3__buff_12
Xinput154 VDD VDD VSS VSS nw_in[17] _4070_/A gf180mcu_as_sc_mcu7t3v3__buff_12
XTAP_TAPCELL_ROW_182_1706 VDD VSS gf180mcu_as_sc_mcu7t3v3__tap_2
Xinput165 VDD VDD VSS VSS nw_in[27] _4154_/A gf180mcu_as_sc_mcu7t3v3__buff_12
Xinput176 VDD VDD VSS VSS nw_in[6] _3984_/A gf180mcu_as_sc_mcu7t3v3__buff_12
Xinput187 VDD VDD VSS VSS se_in[15] _4057_/A gf180mcu_as_sc_mcu7t3v3__buff_12
XFILLER_149_1309 VDD VDD VSS VSS gf180mcu_as_sc_mcu7t3v3__fill_2
Xinput198 VDD VDD VSS VSS se_in[25] _4139_/A gf180mcu_as_sc_mcu7t3v3__buff_12
XFILLER_186_1093 VDD VDD VSS VSS gf180mcu_as_sc_mcu7t3v3__fill_1
XFILLER_160_1222 VDD VDD VSS VSS gf180mcu_as_sc_mcu7t3v3__fill_2
XFILLER_176_107 VDD VDD VSS VSS gf180mcu_as_sc_mcu7t3v3__fill_2
XFILLER_9_810 VDD VDD VSS VSS gf180mcu_as_sc_mcu7t3v3__fillcap_16
XFILLER_157_343 VDD VDD VSS VSS gf180mcu_as_sc_mcu7t3v3__fillcap_4
XFILLER_158_855 VDD VDD VSS VSS gf180mcu_as_sc_mcu7t3v3__fillcap_16
XFILLER_160_1233 VDD VDD VSS VSS gf180mcu_as_sc_mcu7t3v3__fill_1
XFILLER_169_181 VDD VDD VSS VSS gf180mcu_as_sc_mcu7t3v3__fillcap_16
XPHY_EDGE_ROW_167_Left_359 VDD VSS gf180mcu_as_sc_mcu7t3v3__tap_2
XFILLER_157_365 VDD VDD VSS VSS gf180mcu_as_sc_mcu7t3v3__fill_1
XFILLER_158_877 VDD VDD VSS VSS gf180mcu_as_sc_mcu7t3v3__fillcap_8
XFILLER_160_1288 VDD VDD VSS VSS gf180mcu_as_sc_mcu7t3v3__fillcap_4
XFILLER_9_876 VDD VDD VSS VSS gf180mcu_as_sc_mcu7t3v3__fillcap_8
X_2670_ VDD VDD VSS VSS _5197_/Q _2858_/B _2674_/C _2670_/D _2672_/C gf180mcu_as_sc_mcu7t3v3__ao211_2
XFILLER_153_582 VDD VDD VSS VSS gf180mcu_as_sc_mcu7t3v3__fill_2
X_4340_ VDD VDD VSS VSS _4341_/S _5089_/Q _5002_/Q _4342_/B gf180mcu_as_sc_mcu7t3v3__mux2_2
X_4271_ VDD VDD VSS VSS _4273_/S _5483_/A _5105_/Q _5105_/D gf180mcu_as_sc_mcu7t3v3__mux2_2
X_3222_ VDD VDD VSS VSS _3222_/D _3253_/A _3787_/A _3544_/C _3223_/D gf180mcu_as_sc_mcu7t3v3__ao31_2
XTAP_TAPCELL_ROW_56_1_1009 VDD VSS gf180mcu_as_sc_mcu7t3v3__tap_2
XPHY_EDGE_ROW_176_Left_368 VDD VSS gf180mcu_as_sc_mcu7t3v3__tap_2
XFILLER_80_1256 VDD VDD VSS VSS gf180mcu_as_sc_mcu7t3v3__fillcap_4
X_3153_ VDD VDD VSS VSS _3153_/A _3153_/B _3153_/C _3153_/D _3155_/C gf180mcu_as_sc_mcu7t3v3__ao211_2
X_3084_ VDD VDD VSS VSS _4061_/A _3127_/B _3127_/C _4062_/A _3085_/C gf180mcu_as_sc_mcu7t3v3__ao22_2
XPHY_EDGE_ROW_28_1_Left_220 VDD VSS gf180mcu_as_sc_mcu7t3v3__tap_2
XFILLER_165_1122 VDD VDD VSS VSS gf180mcu_as_sc_mcu7t3v3__fillcap_16
XTAP_TAPCELL_ROW_84_3_1995 VDD VSS gf180mcu_as_sc_mcu7t3v3__tap_2
XFILLER_167_118 VDD VDD VSS VSS gf180mcu_as_sc_mcu7t3v3__fillcap_16
X_3986_ VDD VDD VSS VSS _4106_/S _3986_/B _3986_/A _3987_/B gf180mcu_as_sc_mcu7t3v3__mux2_2
XPHY_EDGE_ROW_185_Left_377 VDD VSS gf180mcu_as_sc_mcu7t3v3__tap_2
X_2937_ VDD VDD VSS VSS _2947_/B _3281_/B _3559_/A gf180mcu_as_sc_mcu7t3v3__nand2_2
XFILLER_11_1022 VDD VDD VSS VSS gf180mcu_as_sc_mcu7t3v3__fill_2
X_4607_ VDD VDD VSS VSS _5201_/Q _4609_/B _4609_/C _5202_/Q _5201_/D gf180mcu_as_sc_mcu7t3v3__ao22_2
X_2868_ VDD VDD VSS VSS _2868_/B _4765_/Q _2869_/C gf180mcu_as_sc_mcu7t3v3__xnor2_2
XFILLER_163_368 VDD VDD VSS VSS gf180mcu_as_sc_mcu7t3v3__fill_1
XFILLER_164_869 VDD VDD VSS VSS gf180mcu_as_sc_mcu7t3v3__fillcap_4
X_2799_ VDD VDD VSS VSS _2845_/D _4626_/B _2799_/C _4655_/B _2800_/B gf180mcu_as_sc_mcu7t3v3__ao211_2
X_4538_ VDD VDD VSS VSS _4538_/A _4538_/B _4538_/C _4539_/D _4553_/D gf180mcu_as_sc_mcu7t3v3__aoi211_2
XFILLER_117_79 VDD VDD VSS VSS gf180mcu_as_sc_mcu7t3v3__fillcap_16
Xfanout800 VDD VDD VSS VSS _4748_/A _4747_/D gf180mcu_as_sc_mcu7t3v3__buff_12
X_4469_ VDD VDD VSS VSS _5174_/Q _4548_/B _4469_/C _4469_/D _5174_/D gf180mcu_as_sc_mcu7t3v3__ao211_2
XTAP_TAPCELL_ROW_6_802 VDD VSS gf180mcu_as_sc_mcu7t3v3__tap_2
Xfanout811 VDD VDD VSS VSS _5223_/Q _4703_/A gf180mcu_as_sc_mcu7t3v3__buff_12
Xfanout822 VDD VDD VSS VSS _4528_/A _4588_/A gf180mcu_as_sc_mcu7t3v3__buff_12
Xfanout833 VDD VDD VSS VSS fanout835/Y _4570_/S gf180mcu_as_sc_mcu7t3v3__buff_12
XTAP_TAPCELL_ROW_6_813 VDD VSS gf180mcu_as_sc_mcu7t3v3__tap_2
Xfanout844 VDD VDD VSS VSS _2735_/D _2736_/B gf180mcu_as_sc_mcu7t3v3__buff_12
Xfanout888 VDD VDD VSS VSS _2563_/A _3730_/D gf180mcu_as_sc_mcu7t3v3__buff_12
XPHY_EDGE_ROW_121_1_Right_630 VDD VSS gf180mcu_as_sc_mcu7t3v3__tap_2
XFILLER_109_1304 VDD VDD VSS VSS gf180mcu_as_sc_mcu7t3v3__fillcap_4
XFILLER_109_1326 VDD VDD VSS VSS gf180mcu_as_sc_mcu7t3v3__fill_2
XFILLER_26_87 VDD VDD VSS VSS gf180mcu_as_sc_mcu7t3v3__fill_2
XFILLER_158_107 VDD VDD VSS VSS gf180mcu_as_sc_mcu7t3v3__fillcap_16
XFILLER_186_427 VDD VDD VSS VSS gf180mcu_as_sc_mcu7t3v3__fill_2
XFILLER_9_139 VDD VDD VSS VSS gf180mcu_as_sc_mcu7t3v3__fill_1
XFILLER_10_831 VDD VDD VSS VSS gf180mcu_as_sc_mcu7t3v3__fill_1
XFILLER_10_842 VDD VDD VSS VSS gf180mcu_as_sc_mcu7t3v3__fillcap_4
XFILLER_158_53 VDD VDD VSS VSS gf180mcu_as_sc_mcu7t3v3__fillcap_4
XTAP_TAPCELL_ROW_175_1565 VDD VSS gf180mcu_as_sc_mcu7t3v3__tap_2
XFILLER_166_173 VDD VDD VSS VSS gf180mcu_as_sc_mcu7t3v3__fill_2
XFILLER_182_644 VDD VDD VSS VSS gf180mcu_as_sc_mcu7t3v3__fillcap_4
XTAP_TAPCELL_ROW_175_1576 VDD VSS gf180mcu_as_sc_mcu7t3v3__tap_2
XFILLER_5_356 VDD VDD VSS VSS gf180mcu_as_sc_mcu7t3v3__fill_2
XTAP_TAPCELL_ROW_192_1890 VDD VSS gf180mcu_as_sc_mcu7t3v3__tap_2
XFILLER_120_1283 VDD VDD VSS VSS gf180mcu_as_sc_mcu7t3v3__fillcap_4
XFILLER_174_30 VDD VDD VSS VSS gf180mcu_as_sc_mcu7t3v3__fillcap_4
XFILLER_68_1354 VDD VDD VSS VSS gf180mcu_as_sc_mcu7t3v3__fill_1
XFILLER_155_1324 VDD VDD VSS VSS gf180mcu_as_sc_mcu7t3v3__fill_2
XFILLER_190_1215 VDD VDD VSS VSS gf180mcu_as_sc_mcu7t3v3__fillcap_8
XPHY_EDGE_ROW_32_3_Left_404 VDD VSS gf180mcu_as_sc_mcu7t3v3__tap_2
XFILLER_174_96 VDD VDD VSS VSS gf180mcu_as_sc_mcu7t3v3__fillcap_8
XFILLER_3_69 VDD VDD VSS VSS gf180mcu_as_sc_mcu7t3v3__fill_1
XFILLER_67_72 VDD VDD VSS VSS gf180mcu_as_sc_mcu7t3v3__fill_2
XFILLER_184_1008 VDD VDD VSS VSS gf180mcu_as_sc_mcu7t3v3__fillcap_4
XFILLER_188_1166 VDD VDD VSS VSS gf180mcu_as_sc_mcu7t3v3__fillcap_4
XFILLER_177_405 VDD VDD VSS VSS gf180mcu_as_sc_mcu7t3v3__fill_1
XFILLER_177_416 VDD VDD VSS VSS gf180mcu_as_sc_mcu7t3v3__fillcap_4
X_3840_ VDD VDD VSS VSS _4912_/Q _3845_/A _3843_/B _3844_/A gf180mcu_as_sc_mcu7t3v3__nand3_2
X_3771_ VDD VDD VSS VSS _4153_/A _3771_/B _3771_/C _3771_/D _3773_/C gf180mcu_as_sc_mcu7t3v3__ao211_2
XFILLER_186_972 VDD VDD VSS VSS gf180mcu_as_sc_mcu7t3v3__fill_1
X_2722_ VDD VDD VSS VSS _2723_/D _2832_/S _2722_/B _2722_/A gf180mcu_as_sc_mcu7t3v3__aoi21b_2
XPHY_EDGE_ROW_27_3_Left_399 VDD VSS gf180mcu_as_sc_mcu7t3v3__tap_2
XFILLER_66_2 VDD VDD VSS VSS gf180mcu_as_sc_mcu7t3v3__fill_2
X_2653_ VDD VDD VSS VSS _2659_/S _2653_/B _5265_/Q _2656_/B gf180mcu_as_sc_mcu7t3v3__mux2_2
XTAP_TAPCELL_ROW_11_892 VDD VSS gf180mcu_as_sc_mcu7t3v3__tap_2
XFILLER_161_839 VDD VDD VSS VSS gf180mcu_as_sc_mcu7t3v3__fill_1
Xoutput425 VDD VDD VSS VSS _4813_/Q south_out[8] gf180mcu_as_sc_mcu7t3v3__buff_12
Xoutput414 VDD VDD VSS VSS _4834_/Q south_out[29] gf180mcu_as_sc_mcu7t3v3__buff_12
Xoutput403 VDD VDD VSS VSS _4824_/Q south_out[19] gf180mcu_as_sc_mcu7t3v3__buff_12
X_2584_ VDD VDD VSS VSS _2584_/B _4952_/D _2584_/Y gf180mcu_as_sc_mcu7t3v3__or2_2
Xoutput458 VDD VDD VSS VSS _4880_/Q west_out[7] gf180mcu_as_sc_mcu7t3v3__buff_12
Xoutput447 VDD VDD VSS VSS _4901_/Q west_out[28] gf180mcu_as_sc_mcu7t3v3__buff_12
Xoutput436 VDD VDD VSS VSS _4891_/Q west_out[18] gf180mcu_as_sc_mcu7t3v3__buff_12
X_4323_ VDD VDD VSS VSS _4325_/S _5153_/Q _5152_/Q _5152_/D gf180mcu_as_sc_mcu7t3v3__mux2_2
XFILLER_82_1329 VDD VDD VSS VSS gf180mcu_as_sc_mcu7t3v3__fill_1
XPHY_EDGE_ROW_89_3_Left_461 VDD VSS gf180mcu_as_sc_mcu7t3v3__tap_2
X_4254_ VDD VDD VSS VSS _4254_/S _4254_/B _5090_/Q _5090_/D gf180mcu_as_sc_mcu7t3v3__mux2_2
X_4185_ VDD VDD VSS VSS _4245_/B _4195_/B _4195_/C _5023_/Q _5023_/D gf180mcu_as_sc_mcu7t3v3__ao22_2
X_3205_ VDD VDD VSS VSS _3213_/A _3205_/B _3228_/A _3206_/D gf180mcu_as_sc_mcu7t3v3__nand3_2
X_3136_ VDD VDD VSS VSS _3153_/A _3136_/B _3136_/C _3153_/D _3138_/C gf180mcu_as_sc_mcu7t3v3__ao211_2
X_3067_ VDD VDD VSS VSS _3126_/S _4046_/A _4046_/D _3069_/B gf180mcu_as_sc_mcu7t3v3__mux2_2
XFILLER_169_906 VDD VDD VSS VSS gf180mcu_as_sc_mcu7t3v3__fillcap_4
XFILLER_169_928 VDD VDD VSS VSS gf180mcu_as_sc_mcu7t3v3__fillcap_16
XFILLER_11_617 VDD VDD VSS VSS gf180mcu_as_sc_mcu7t3v3__fill_2
XTAP_TAPCELL_ROW_32_3_1943 VDD VSS gf180mcu_as_sc_mcu7t3v3__tap_2
XFILLER_10_138 VDD VDD VSS VSS gf180mcu_as_sc_mcu7t3v3__fill_2
Xwire519 VDD VDD VSS VSS _3285_/Y _3505_/S gf180mcu_as_sc_mcu7t3v3__clkbuff_12
X_3969_ VDD VDD VSS VSS _3969_/A _4025_/B _3969_/C _3969_/D _3970_/B gf180mcu_as_sc_mcu7t3v3__ao211_2
XFILLER_104_1256 VDD VDD VSS VSS gf180mcu_as_sc_mcu7t3v3__fillcap_8
XFILLER_164_633 VDD VDD VSS VSS gf180mcu_as_sc_mcu7t3v3__fill_2
XFILLER_104_1278 VDD VDD VSS VSS gf180mcu_as_sc_mcu7t3v3__fill_1
XFILLER_128_45 VDD VDD VSS VSS gf180mcu_as_sc_mcu7t3v3__fillcap_8
XFILLER_12_56 VDD VDD VSS VSS gf180mcu_as_sc_mcu7t3v3__fill_1
XFILLER_139_1308 VDD VDD VSS VSS gf180mcu_as_sc_mcu7t3v3__fillcap_4
XTAP_TAPCELL_ROW_153_1148 VDD VSS gf180mcu_as_sc_mcu7t3v3__tap_2
XFILLER_163_154 VDD VDD VSS VSS gf180mcu_as_sc_mcu7t3v3__fill_2
XTAP_TAPCELL_ROW_153_1159 VDD VSS gf180mcu_as_sc_mcu7t3v3__tap_2
XFILLER_176_1070 VDD VDD VSS VSS gf180mcu_as_sc_mcu7t3v3__fill_2
XTAP_TAPCELL_ROW_170_1484 VDD VSS gf180mcu_as_sc_mcu7t3v3__tap_2
XTAP_TAPCELL_ROW_170_1473 VDD VSS gf180mcu_as_sc_mcu7t3v3__tap_2
XFILLER_160_850 VDD VDD VSS VSS gf180mcu_as_sc_mcu7t3v3__fillcap_16
Xfanout630 VDD VDD VSS VSS _4104_/C _4021_/B gf180mcu_as_sc_mcu7t3v3__buff_12
Xfanout641 VDD VDD VSS VSS _3725_/B _3650_/B gf180mcu_as_sc_mcu7t3v3__buff_12
Xfanout652 VDD VDD VSS VSS _3267_/Y _3467_/B gf180mcu_as_sc_mcu7t3v3__buff_12
Xfanout674 VDD VDD VSS VSS _4328_/A _4325_/S gf180mcu_as_sc_mcu7t3v3__buff_12
Xfanout685 VDD VDD VSS VSS _4750_/D _4629_/B gf180mcu_as_sc_mcu7t3v3__buff_12
XFILLER_24_1279 VDD VDD VSS VSS gf180mcu_as_sc_mcu7t3v3__fillcap_8
XFILLER_37_31 VDD VDD VSS VSS gf180mcu_as_sc_mcu7t3v3__fill_1
Xfanout696 VDD VDD VSS VSS wire700/Y _3386_/B gf180mcu_as_sc_mcu7t3v3__buff_12
XPHY_EDGE_ROW_122_1_Right_631 VDD VSS gf180mcu_as_sc_mcu7t3v3__tap_2
XFILLER_150_1287 VDD VDD VSS VSS gf180mcu_as_sc_mcu7t3v3__fill_2
XFILLER_183_1052 VDD VDD VSS VSS gf180mcu_as_sc_mcu7t3v3__fillcap_16
XTAP_TAPCELL_ROW_177_1616 VDD VSS gf180mcu_as_sc_mcu7t3v3__tap_2
XTAP_TAPCELL_ROW_177_1605 VDD VSS gf180mcu_as_sc_mcu7t3v3__tap_2
XFILLER_187_769 VDD VDD VSS VSS gf180mcu_as_sc_mcu7t3v3__fill_1
XFILLER_161_1350 VDD VDD VSS VSS gf180mcu_as_sc_mcu7t3v3__fillcap_4
XFILLER_186_257 VDD VDD VSS VSS gf180mcu_as_sc_mcu7t3v3__fillcap_16
XFILLER_155_622 VDD VDD VSS VSS gf180mcu_as_sc_mcu7t3v3__fillcap_8
XFILLER_183_931 VDD VDD VSS VSS gf180mcu_as_sc_mcu7t3v3__fillcap_4
XFILLER_70_1288 VDD VDD VSS VSS gf180mcu_as_sc_mcu7t3v3__fill_1
XFILLER_70_1299 VDD VDD VSS VSS gf180mcu_as_sc_mcu7t3v3__fillcap_4
XTAP_TAPCELL_ROW_190_1849 VDD VSS gf180mcu_as_sc_mcu7t3v3__tap_2
XFILLER_155_688 VDD VDD VSS VSS gf180mcu_as_sc_mcu7t3v3__fill_1
XFILLER_183_986 VDD VDD VSS VSS gf180mcu_as_sc_mcu7t3v3__fill_2
XFILLER_5_142 VDD VDD VSS VSS gf180mcu_as_sc_mcu7t3v3__fillcap_4
XFILLER_154_187 VDD VDD VSS VSS gf180mcu_as_sc_mcu7t3v3__fillcap_8
XTAP_TAPCELL_ROW_136_3_2047 VDD VSS gf180mcu_as_sc_mcu7t3v3__tap_2
XFILLER_42_1324 VDD VDD VSS VSS gf180mcu_as_sc_mcu7t3v3__fillcap_4
XFILLER_94_70 VDD VDD VSS VSS gf180mcu_as_sc_mcu7t3v3__fill_2
Xmesh_tile_1051 VDD VDD VSS VSS sw_out[23] gf180mcu_as_sc_mcu7t3v3__tiel_4
Xmesh_tile_1040 VDD VDD VSS VSS sw_out[12] gf180mcu_as_sc_mcu7t3v3__tiel_4
X_4941_ VDD VDD VSS VSS _5075_/CLK _4941_/D _4941_/Q gf180mcu_as_sc_mcu7t3v3__dfxtp_2
XFILLER_166_1272 VDD VDD VSS VSS gf180mcu_as_sc_mcu7t3v3__fillcap_16
XFILLER_178_714 VDD VDD VSS VSS gf180mcu_as_sc_mcu7t3v3__fillcap_16
X_4872_ VDD VDD VSS VSS _5097_/CLK _4872_/D _4872_/Q gf180mcu_as_sc_mcu7t3v3__dfxtp_2
XFILLER_127_1256 VDD VDD VSS VSS gf180mcu_as_sc_mcu7t3v3__fillcap_4
X_3823_ VDD VDD VSS VSS _3826_/B _4753_/A _3824_/C gf180mcu_as_sc_mcu7t3v3__or2_2
XFILLER_177_279 VDD VDD VSS VSS gf180mcu_as_sc_mcu7t3v3__fill_1
XFILLER_158_482 VDD VDD VSS VSS gf180mcu_as_sc_mcu7t3v3__fill_1
X_3754_ VDD VDD VSS VSS _4940_/Q _3770_/B _3770_/C _4137_/A _3756_/C gf180mcu_as_sc_mcu7t3v3__ao22_2
XFILLER_9_492 VDD VDD VSS VSS gf180mcu_as_sc_mcu7t3v3__fill_2
X_3685_ VDD VDD VSS VSS _4063_/A _3724_/B _3724_/C _4061_/A _3686_/C gf180mcu_as_sc_mcu7t3v3__ao22_2
X_2705_ VDD VDD VSS VSS _5160_/Q _4272_/S _4275_/S _5184_/Q _2706_/B gf180mcu_as_sc_mcu7t3v3__ao22_2
XTAP_TAPCELL_ROW_79_3_1990 VDD VSS gf180mcu_as_sc_mcu7t3v3__tap_2
XFILLER_161_625 VDD VDD VSS VSS gf180mcu_as_sc_mcu7t3v3__fillcap_4
X_2636_ VDD VDD VSS VSS _2831_/A _2636_/B _2636_/A _2637_/A gf180mcu_as_sc_mcu7t3v3__mux2_2
XFILLER_160_113 VDD VDD VSS VSS gf180mcu_as_sc_mcu7t3v3__fill_1
X_2567_ VDD VDD VSS VSS _2852_/B _4748_/A _5278_/Q gf180mcu_as_sc_mcu7t3v3__nand2_2
X_4306_ VDD VDD VSS VSS _4314_/S _5136_/Q _5135_/Q _5135_/D gf180mcu_as_sc_mcu7t3v3__mux2_2
X_2498_ VDD VDD VSS VSS _2747_/A _2795_/A _2525_/A gf180mcu_as_sc_mcu7t3v3__and2_2
X_4237_ VDD VDD VSS VSS _4246_/S _4237_/B _5073_/Q _5073_/D gf180mcu_as_sc_mcu7t3v3__mux2_2
X_4168_ VDD VDD VSS VSS _4168_/Y _4753_/A _4186_/B _4168_/A gf180mcu_as_sc_mcu7t3v3__aoi21b_2
XFILLER_167_1014 VDD VDD VSS VSS gf180mcu_as_sc_mcu7t3v3__fillcap_8
X_4099_ VDD VDD VSS VSS _4099_/A _4127_/C _4099_/C _4249_/B _4099_/D gf180mcu_as_sc_mcu7t3v3__aoi211_2
X_3119_ VDD VDD VSS VSS _4095_/A _3233_/B _3236_/C _4096_/D _3120_/C gf180mcu_as_sc_mcu7t3v3__ao22_2
XFILLER_145_1301 VDD VDD VSS VSS gf180mcu_as_sc_mcu7t3v3__fillcap_8
XFILLER_169_714 VDD VDD VSS VSS gf180mcu_as_sc_mcu7t3v3__fillcap_16
XFILLER_19_1326 VDD VDD VSS VSS gf180mcu_as_sc_mcu7t3v3__fillcap_4
XFILLER_168_224 VDD VDD VSS VSS gf180mcu_as_sc_mcu7t3v3__fillcap_4
XTAP_TAPCELL_ROW_172_1513 VDD VSS gf180mcu_as_sc_mcu7t3v3__tap_2
X_4898__1070 VDD VDD VSS VSS _4898_/D gf180mcu_as_sc_mcu7t3v3__tiel_4
XFILLER_152_614 VDD VDD VSS VSS gf180mcu_as_sc_mcu7t3v3__fillcap_16
XFILLER_164_452 VDD VDD VSS VSS gf180mcu_as_sc_mcu7t3v3__fill_2
XFILLER_152_658 VDD VDD VSS VSS gf180mcu_as_sc_mcu7t3v3__fill_1
XFILLER_191_282 VDD VDD VSS VSS gf180mcu_as_sc_mcu7t3v3__fillcap_4
XFILLER_152_1316 VDD VDD VSS VSS gf180mcu_as_sc_mcu7t3v3__fillcap_8
XFILLER_2_189 VDD VDD VSS VSS gf180mcu_as_sc_mcu7t3v3__fill_1
Xfanout471 VDD VDD VSS VSS _4199_/Y _4218_/C gf180mcu_as_sc_mcu7t3v3__buff_12
Xfanout482 VDD VDD VSS VSS _3560_/Y _3794_/S gf180mcu_as_sc_mcu7t3v3__buff_12
Xfanout493 VDD VDD VSS VSS _4347_/Y _4589_/A gf180mcu_as_sc_mcu7t3v3__buff_12
XPHY_EDGE_ROW_123_1_Right_632 VDD VSS gf180mcu_as_sc_mcu7t3v3__tap_2
XFILLER_64_62 VDD VDD VSS VSS gf180mcu_as_sc_mcu7t3v3__fillcap_4
XFILLER_187_500 VDD VDD VSS VSS gf180mcu_as_sc_mcu7t3v3__fill_1
XFILLER_187_511 VDD VDD VSS VSS gf180mcu_as_sc_mcu7t3v3__fillcap_16
XFILLER_9_46 VDD VDD VSS VSS gf180mcu_as_sc_mcu7t3v3__fillcap_16
XTAP_TAPCELL_ROW_13_943 VDD VSS gf180mcu_as_sc_mcu7t3v3__tap_2
XTAP_TAPCELL_ROW_13_932 VDD VSS gf180mcu_as_sc_mcu7t3v3__tap_2
XFILLER_156_931 VDD VDD VSS VSS gf180mcu_as_sc_mcu7t3v3__fill_2
XFILLER_168_791 VDD VDD VSS VSS gf180mcu_as_sc_mcu7t3v3__fillcap_8
XFILLER_174_216 VDD VDD VSS VSS gf180mcu_as_sc_mcu7t3v3__fillcap_4
XTAP_TAPCELL_ROW_13_965 VDD VSS gf180mcu_as_sc_mcu7t3v3__tap_2
XTAP_TAPCELL_ROW_13_954 VDD VSS gf180mcu_as_sc_mcu7t3v3__tap_2
Xwire861 VDD VDD VSS VSS wire861/A _4113_/A gf180mcu_as_sc_mcu7t3v3__clkbuff_12
XFILLER_183_772 VDD VDD VSS VSS gf180mcu_as_sc_mcu7t3v3__fillcap_16
XFILLER_155_496 VDD VDD VSS VSS gf180mcu_as_sc_mcu7t3v3__fill_2
XFILLER_170_422 VDD VDD VSS VSS gf180mcu_as_sc_mcu7t3v3__fillcap_4
XFILLER_192_1107 VDD VDD VSS VSS gf180mcu_as_sc_mcu7t3v3__fillcap_4
X_3470_ VDD VDD VSS VSS _4124_/A _3477_/B _3470_/C _4828_/D _3730_/D gf180mcu_as_sc_mcu7t3v3__aoi211_2
X_2421_ VDD VDD VSS VSS _2657_/B _2421_/A gf180mcu_as_sc_mcu7t3v3__inv_2
X_5140_ VDD VDD VSS VSS _5152_/CLK _5140_/D _5140_/Q gf180mcu_as_sc_mcu7t3v3__dfxtp_2
X_5071_ VDD VDD VSS VSS clkload9/A _5071_/D _5071_/Q gf180mcu_as_sc_mcu7t3v3__dfxtp_2
X_4022_ VDD VDD VSS VSS _4022_/A _4022_/B _4027_/B _4022_/D _4026_/A gf180mcu_as_sc_mcu7t3v3__ao211_2
Xclkbuf_3_3__f_clk_regs VDD VDD VSS VSS clkbuf_2_1_0_clk_regs/Y clkbuf_3_3__f_clk_regs/Y
+ gf180mcu_as_sc_mcu7t3v3__clkbuff_12
X_4924_ VDD VDD VSS VSS clkload2/A _4924_/D _4924_/Q gf180mcu_as_sc_mcu7t3v3__dfxtp_2
XFILLER_100_27 VDD VDD VSS VSS gf180mcu_as_sc_mcu7t3v3__fillcap_8
XFILLER_166_1091 VDD VDD VSS VSS gf180mcu_as_sc_mcu7t3v3__fill_2
XFILLER_178_555 VDD VDD VSS VSS gf180mcu_as_sc_mcu7t3v3__fillcap_8
X_4855_ VDD VDD VSS VSS _5278_/CLK _4855_/D _4855_/Q gf180mcu_as_sc_mcu7t3v3__dfxtp_2
X_4871__1096 VDD VDD VSS VSS _4871_/D gf180mcu_as_sc_mcu7t3v3__tiel_4
X_4786_ VDD VDD VSS VSS _5216_/CLK _4786_/D _4786_/Q gf180mcu_as_sc_mcu7t3v3__dfxtp_2
X_3806_ VDD VDD VSS VSS _3846_/B _4913_/Q _3929_/A gf180mcu_as_sc_mcu7t3v3__and2_2
XFILLER_14_1256 VDD VDD VSS VSS gf180mcu_as_sc_mcu7t3v3__fillcap_8
XFILLER_53_1294 VDD VDD VSS VSS gf180mcu_as_sc_mcu7t3v3__fill_2
X_3737_ VDD VDD VSS VSS _3738_/C _3737_/C _3745_/B _4114_/A gf180mcu_as_sc_mcu7t3v3__aoi21_2
XFILLER_161_400 VDD VDD VSS VSS gf180mcu_as_sc_mcu7t3v3__fillcap_16
XFILLER_49_1308 VDD VDD VSS VSS gf180mcu_as_sc_mcu7t3v3__fill_1
XFILLER_161_433 VDD VDD VSS VSS gf180mcu_as_sc_mcu7t3v3__fillcap_4
XFILLER_173_282 VDD VDD VSS VSS gf180mcu_as_sc_mcu7t3v3__fillcap_4
XFILLER_175_1316 VDD VDD VSS VSS gf180mcu_as_sc_mcu7t3v3__fillcap_4
X_3668_ VDD VDD VSS VSS _3699_/D _3730_/A _3668_/B _3668_/C _3669_/C gf180mcu_as_sc_mcu7t3v3__ao31_2
X_3599_ VDD VDD VSS VSS _3966_/A _3652_/B _3599_/C _3723_/B _3600_/C gf180mcu_as_sc_mcu7t3v3__ao211_2
X_2619_ VDD VDD VSS VSS _2620_/D _5257_/Q _2634_/B _2619_/C gf180mcu_as_sc_mcu7t3v3__ao21_2
XFILLER_161_488 VDD VDD VSS VSS gf180mcu_as_sc_mcu7t3v3__fill_2
XPHY_EDGE_ROW_49_3_Right_90 VDD VSS gf180mcu_as_sc_mcu7t3v3__tap_2
X_5269_ VDD VDD VSS VSS _5277_/CLK _5269_/D _5269_/Q gf180mcu_as_sc_mcu7t3v3__dfxtp_2
XFILLER_141_34 VDD VDD VSS VSS gf180mcu_as_sc_mcu7t3v3__fill_2
XFILLER_60_1298 VDD VDD VSS VSS gf180mcu_as_sc_mcu7t3v3__fill_2
XPHY_EDGE_ROW_104_3_Left_476 VDD VSS gf180mcu_as_sc_mcu7t3v3__tap_2
XTAP_TAPCELL_ROW_165_1383 VDD VSS gf180mcu_as_sc_mcu7t3v3__tap_2
XTAP_TAPCELL_ROW_165_1372 VDD VSS gf180mcu_as_sc_mcu7t3v3__tap_2
XFILLER_141_78 VDD VDD VSS VSS gf180mcu_as_sc_mcu7t3v3__fill_1
XFILLER_188_308 VDD VDD VSS VSS gf180mcu_as_sc_mcu7t3v3__fillcap_4
XPHY_EDGE_ROW_41_3_Left_413 VDD VSS gf180mcu_as_sc_mcu7t3v3__tap_2
XFILLER_180_1033 VDD VDD VSS VSS gf180mcu_as_sc_mcu7t3v3__fillcap_16
XFILLER_157_728 VDD VDD VSS VSS gf180mcu_as_sc_mcu7t3v3__fillcap_16
XFILLER_184_514 VDD VDD VSS VSS gf180mcu_as_sc_mcu7t3v3__fillcap_8
XFILLER_153_912 VDD VDD VSS VSS gf180mcu_as_sc_mcu7t3v3__fill_2
XFILLER_165_783 VDD VDD VSS VSS gf180mcu_as_sc_mcu7t3v3__fill_2
XFILLER_164_293 VDD VDD VSS VSS gf180mcu_as_sc_mcu7t3v3__fillcap_16
XFILLER_166_53 VDD VDD VSS VSS gf180mcu_as_sc_mcu7t3v3__fill_2
XFILLER_192_580 VDD VDD VSS VSS gf180mcu_as_sc_mcu7t3v3__fill_2
XFILLER_192_591 VDD VDD VSS VSS gf180mcu_as_sc_mcu7t3v3__fill_2
XFILLER_4_944 VDD VDD VSS VSS gf180mcu_as_sc_mcu7t3v3__fill_1
XFILLER_153_978 VDD VDD VSS VSS gf180mcu_as_sc_mcu7t3v3__fill_2
XFILLER_3_487 VDD VDD VSS VSS gf180mcu_as_sc_mcu7t3v3__fill_2
XTAP_TAPCELL_ROW_189_1840 VDD VSS gf180mcu_as_sc_mcu7t3v3__tap_2
XFILLER_152_1124 VDD VDD VSS VSS gf180mcu_as_sc_mcu7t3v3__fillcap_8
XFILLER_156_1282 VDD VDD VSS VSS gf180mcu_as_sc_mcu7t3v3__fillcap_8
XFILLER_182_85 VDD VDD VSS VSS gf180mcu_as_sc_mcu7t3v3__fillcap_16
XTAP_TAPCELL_ROW_185_1759 VDD VSS gf180mcu_as_sc_mcu7t3v3__tap_2
XFILLER_75_72 VDD VDD VSS VSS gf180mcu_as_sc_mcu7t3v3__fill_1
XPHY_EDGE_ROW_97_1_Left_289 VDD VSS gf180mcu_as_sc_mcu7t3v3__tap_2
XPHY_EDGE_ROW_124_1_Right_633 VDD VSS gf180mcu_as_sc_mcu7t3v3__tap_2
XFILLER_188_842 VDD VDD VSS VSS gf180mcu_as_sc_mcu7t3v3__fill_1
X_2970_ VDD VDD VSS VSS _3046_/B _4917_/Q _2971_/D gf180mcu_as_sc_mcu7t3v3__or2_2
XFILLER_187_352 VDD VDD VSS VSS gf180mcu_as_sc_mcu7t3v3__fillcap_8
XFILLER_37_1256 VDD VDD VSS VSS gf180mcu_as_sc_mcu7t3v3__fillcap_16
XPHY_EDGE_ROW_98_3_Left_470 VDD VSS gf180mcu_as_sc_mcu7t3v3__tap_2
XFILLER_37_1278 VDD VDD VSS VSS gf180mcu_as_sc_mcu7t3v3__fill_1
X_4640_ VDD VDD VSS VSS _4728_/B _5106_/Q _5231_/Q _5231_/D gf180mcu_as_sc_mcu7t3v3__mux2_2
X_4571_ VDD VDD VSS VSS _4572_/D _4571_/B _4572_/A gf180mcu_as_sc_mcu7t3v3__nor2_2
XFILLER_155_282 VDD VDD VSS VSS gf180mcu_as_sc_mcu7t3v3__fillcap_16
X_3522_ VDD VDD VSS VSS _3522_/A _3522_/B _3523_/B _3523_/C _3522_/D gf180mcu_as_sc_mcu7t3v3__aoi211_2
XFILLER_100_1270 VDD VDD VSS VSS gf180mcu_as_sc_mcu7t3v3__fill_1
XFILLER_171_764 VDD VDD VSS VSS gf180mcu_as_sc_mcu7t3v3__fillcap_4
X_3453_ VDD VDD VSS VSS _4104_/A _3453_/B _3453_/C _4105_/A _3454_/C gf180mcu_as_sc_mcu7t3v3__ao22_2
XFILLER_48_1352 VDD VDD VSS VSS gf180mcu_as_sc_mcu7t3v3__fill_2
X_2404_ VDD VDD VSS VSS _4746_/A _4630_/A gf180mcu_as_sc_mcu7t3v3__inv_2
XFILLER_170_1213 VDD VDD VSS VSS gf180mcu_as_sc_mcu7t3v3__fill_2
XFILLER_170_1224 VDD VDD VSS VSS gf180mcu_as_sc_mcu7t3v3__fill_1
XFILLER_170_1235 VDD VDD VSS VSS gf180mcu_as_sc_mcu7t3v3__fillcap_4
X_5123_ VDD VDD VSS VSS _5188_/CLK _5123_/D _5123_/Q gf180mcu_as_sc_mcu7t3v3__dfxtp_2
X_3384_ VDD VDD VSS VSS _3661_/A _3454_/A _3384_/C _4817_/D _3730_/D gf180mcu_as_sc_mcu7t3v3__aoi211_2
X_5054_ VDD VDD VSS VSS _5182_/CLK _5054_/D _5054_/Q gf180mcu_as_sc_mcu7t3v3__dfxtp_2
X_4005_ VDD VDD VSS VSS _4005_/A _4023_/B _4023_/C _4924_/Q _4007_/C gf180mcu_as_sc_mcu7t3v3__ao22_2
XFILLER_164_1017 VDD VDD VSS VSS gf180mcu_as_sc_mcu7t3v3__fillcap_16
XFILLER_179_842 VDD VDD VSS VSS gf180mcu_as_sc_mcu7t3v3__fillcap_16
XTAP_TAPCELL_ROW_160_1291 VDD VSS gf180mcu_as_sc_mcu7t3v3__tap_2
XTAP_TAPCELL_ROW_160_1280 VDD VSS gf180mcu_as_sc_mcu7t3v3__tap_2
X_4907_ VDD VDD VSS VSS _5095_/CLK _4907_/D _4907_/Q gf180mcu_as_sc_mcu7t3v3__dfxtp_2
X_4838_ VDD VDD VSS VSS clkload6/A _4838_/D _4838_/Q gf180mcu_as_sc_mcu7t3v3__dfxtp_2
XFILLER_181_506 VDD VDD VSS VSS gf180mcu_as_sc_mcu7t3v3__fill_1
X_4769_ VDD VDD VSS VSS _5275_/CLK _4769_/D _4769_/Q gf180mcu_as_sc_mcu7t3v3__dfxtp_2
XFILLER_179_1282 VDD VDD VSS VSS gf180mcu_as_sc_mcu7t3v3__fill_2
XFILLER_136_34 VDD VDD VSS VSS gf180mcu_as_sc_mcu7t3v3__fill_1
XFILLER_175_1146 VDD VDD VSS VSS gf180mcu_as_sc_mcu7t3v3__fillcap_4
XFILLER_161_296 VDD VDD VSS VSS gf180mcu_as_sc_mcu7t3v3__fill_1
Xinput303 VDD VDD VSS VSS west_in[28] _4161_/A gf180mcu_as_sc_mcu7t3v3__buff_12
XTAP_TAPCELL_ROW_74_1_1027 VDD VSS gf180mcu_as_sc_mcu7t3v3__tap_2
XTAP_TAPCELL_ROW_167_1412 VDD VSS gf180mcu_as_sc_mcu7t3v3__tap_2
Xinput314 VDD VDD VSS VSS west_in[7] _3989_/A gf180mcu_as_sc_mcu7t3v3__buff_12
XTAP_TAPCELL_ROW_167_1423 VDD VSS gf180mcu_as_sc_mcu7t3v3__tap_2
XFILLER_152_33 VDD VDD VSS VSS gf180mcu_as_sc_mcu7t3v3__fill_1
XFILLER_152_77 VDD VDD VSS VSS gf180mcu_as_sc_mcu7t3v3__fillcap_4
XTAP_TAPCELL_ROW_4_774 VDD VSS gf180mcu_as_sc_mcu7t3v3__tap_2
XTAP_TAPCELL_ROW_4_763 VDD VSS gf180mcu_as_sc_mcu7t3v3__tap_2
XFILLER_189_606 VDD VDD VSS VSS gf180mcu_as_sc_mcu7t3v3__fill_2
XTAP_TAPCELL_ROW_180_1667 VDD VSS gf180mcu_as_sc_mcu7t3v3__tap_2
XFILLER_182_1139 VDD VDD VSS VSS gf180mcu_as_sc_mcu7t3v3__fillcap_16
XFILLER_186_1297 VDD VDD VSS VSS gf180mcu_as_sc_mcu7t3v3__fill_2
XFILLER_169_330 VDD VDD VSS VSS gf180mcu_as_sc_mcu7t3v3__fillcap_4
XFILLER_169_352 VDD VDD VSS VSS gf180mcu_as_sc_mcu7t3v3__fillcap_16
XFILLER_157_503 VDD VDD VSS VSS gf180mcu_as_sc_mcu7t3v3__fillcap_8
XFILLER_177_85 VDD VDD VSS VSS gf180mcu_as_sc_mcu7t3v3__fill_1
XANTENNA_7 VDD VDD VSS VSS _4859_/D gf180mcu_as_sc_mcu7t3v3__diode_2
XFILLER_119_1317 VDD VDD VSS VSS gf180mcu_as_sc_mcu7t3v3__fillcap_4
XFILLER_152_252 VDD VDD VSS VSS gf180mcu_as_sc_mcu7t3v3__fillcap_16
XFILLER_152_274 VDD VDD VSS VSS gf180mcu_as_sc_mcu7t3v3__fillcap_16
Xmesh_tile_929 VDD VDD VSS VSS ne_out[3] gf180mcu_as_sc_mcu7t3v3__tiel_4
XPHY_EDGE_ROW_125_1_Right_634 VDD VSS gf180mcu_as_sc_mcu7t3v3__tap_2
X_2953_ VDD VDD VSS VSS _4915_/Q _3153_/D _3206_/B _3926_/A _2954_/D gf180mcu_as_sc_mcu7t3v3__ao22_2
XFILLER_188_694 VDD VDD VSS VSS gf180mcu_as_sc_mcu7t3v3__fillcap_4
X_2884_ VDD VDD VSS VSS _4763_/Q _2884_/B _4770_/Q _4770_/D gf180mcu_as_sc_mcu7t3v3__mux2_2
XFILLER_15_1351 VDD VDD VSS VSS gf180mcu_as_sc_mcu7t3v3__fillcap_4
X_4623_ VDD VDD VSS VSS _5217_/Q _4629_/B _4629_/C _5218_/Q _5217_/D gf180mcu_as_sc_mcu7t3v3__ao22_2
XFILLER_102_1354 VDD VDD VSS VSS gf180mcu_as_sc_mcu7t3v3__fill_1
X_4554_ VDD VDD VSS VSS _5185_/Q _4554_/B _4563_/C _5103_/Q _4555_/B gf180mcu_as_sc_mcu7t3v3__ao22_2
XFILLER_85_1305 VDD VDD VSS VSS gf180mcu_as_sc_mcu7t3v3__fillcap_8
X_3505_ VDD VDD VSS VSS _3505_/S _3505_/B _4164_/A _3506_/B gf180mcu_as_sc_mcu7t3v3__mux2_2
X_4485_ VDD VDD VSS VSS _4538_/A _4485_/B _4485_/C _4486_/D _4553_/D gf180mcu_as_sc_mcu7t3v3__aoi211_2
X_3436_ VDD VDD VSS VSS _4085_/A _3467_/B _3504_/B _4086_/A _3437_/D gf180mcu_as_sc_mcu7t3v3__ao22_2
XFILLER_106_37 VDD VDD VSS VSS gf180mcu_as_sc_mcu7t3v3__fillcap_16
X_3367_ VDD VDD VSS VSS _3454_/A _3367_/B _3367_/C _3368_/C gf180mcu_as_sc_mcu7t3v3__nor3_2
X_5106_ VDD VDD VSS VSS _5164_/CLK _5106_/D _5106_/Q gf180mcu_as_sc_mcu7t3v3__dfxtp_2
XFILLER_170_1098 VDD VDD VSS VSS gf180mcu_as_sc_mcu7t3v3__fillcap_4
X_5037_ VDD VDD VSS VSS _5182_/CLK _5037_/D _5037_/Q gf180mcu_as_sc_mcu7t3v3__dfxtp_2
X_3298_ VDD VDD VSS VSS _3947_/D _3372_/B _3386_/D _3951_/A _3299_/D gf180mcu_as_sc_mcu7t3v3__ao22_2
XTAP_TAPCELL_ROW_1_711 VDD VSS gf180mcu_as_sc_mcu7t3v3__tap_2
XTAP_TAPCELL_ROW_135_1_1088 VDD VSS gf180mcu_as_sc_mcu7t3v3__tap_2
XTAP_TAPCELL_ROW_162_1331 VDD VSS gf180mcu_as_sc_mcu7t3v3__tap_2
XTAP_TAPCELL_ROW_162_1320 VDD VSS gf180mcu_as_sc_mcu7t3v3__tap_2
XFILLER_185_108 VDD VDD VSS VSS gf180mcu_as_sc_mcu7t3v3__fill_2
XTAP_TAPCELL_ROW_93_3_2004 VDD VSS gf180mcu_as_sc_mcu7t3v3__tap_2
XFILLER_182_804 VDD VDD VSS VSS gf180mcu_as_sc_mcu7t3v3__fill_1
XFILLER_177_1208 VDD VDD VSS VSS gf180mcu_as_sc_mcu7t3v3__fillcap_16
XFILLER_181_314 VDD VDD VSS VSS gf180mcu_as_sc_mcu7t3v3__fill_2
XFILLER_181_347 VDD VDD VSS VSS gf180mcu_as_sc_mcu7t3v3__fill_2
XFILLER_31_88 VDD VDD VSS VSS gf180mcu_as_sc_mcu7t3v3__fillcap_4
XFILLER_0_210 VDD VDD VSS VSS gf180mcu_as_sc_mcu7t3v3__fill_2
XFILLER_162_594 VDD VDD VSS VSS gf180mcu_as_sc_mcu7t3v3__fill_1
XTAP_TAPCELL_ROW_9_866 VDD VSS gf180mcu_as_sc_mcu7t3v3__tap_2
XTAP_TAPCELL_ROW_9_855 VDD VSS gf180mcu_as_sc_mcu7t3v3__tap_2
XFILLER_118_1350 VDD VDD VSS VSS gf180mcu_as_sc_mcu7t3v3__fillcap_4
XFILLER_163_65 VDD VDD VSS VSS gf180mcu_as_sc_mcu7t3v3__fillcap_4
XFILLER_7_1327 VDD VDD VSS VSS gf180mcu_as_sc_mcu7t3v3__fill_2
Xinput100 VDD VDD VSS VSS ne_in[2] wire910/A gf180mcu_as_sc_mcu7t3v3__buff_12
Xinput111 VDD VDD VSS VSS ne_in[9] wire906/A gf180mcu_as_sc_mcu7t3v3__buff_12
XFILLER_153_1274 VDD VDD VSS VSS gf180mcu_as_sc_mcu7t3v3__fill_2
XFILLER_27_1288 VDD VDD VSS VSS gf180mcu_as_sc_mcu7t3v3__fillcap_8
Xinput122 VDD VDD VSS VSS north_in[19] _4087_/A gf180mcu_as_sc_mcu7t3v3__buff_12
Xinput133 VDD VDD VSS VSS north_in[29] _3790_/A gf180mcu_as_sc_mcu7t3v3__buff_12
Xinput144 VDD VDD VSS VSS north_in[8] _3999_/A gf180mcu_as_sc_mcu7t3v3__buff_12
XTAP_TAPCELL_ROW_182_1707 VDD VSS gf180mcu_as_sc_mcu7t3v3__tap_2
Xinput155 VDD VDD VSS VSS nw_in[18] _4078_/A gf180mcu_as_sc_mcu7t3v3__buff_12
Xinput166 VDD VDD VSS VSS nw_in[28] _4162_/A gf180mcu_as_sc_mcu7t3v3__buff_12
Xinput177 VDD VDD VSS VSS nw_in[7] _3992_/A gf180mcu_as_sc_mcu7t3v3__buff_12
Xinput188 VDD VDD VSS VSS se_in[16] _4066_/A gf180mcu_as_sc_mcu7t3v3__buff_12
Xinput199 VDD VDD VSS VSS se_in[26] _4147_/A gf180mcu_as_sc_mcu7t3v3__buff_12
XFILLER_186_1061 VDD VDD VSS VSS gf180mcu_as_sc_mcu7t3v3__fillcap_16
XFILLER_189_436 VDD VDD VSS VSS gf180mcu_as_sc_mcu7t3v3__fillcap_8
XFILLER_158_823 VDD VDD VSS VSS gf180mcu_as_sc_mcu7t3v3__fillcap_16
XTAP_TAPCELL_ROW_50_3_1961 VDD VSS gf180mcu_as_sc_mcu7t3v3__tap_2
XFILLER_160_1245 VDD VDD VSS VSS gf180mcu_as_sc_mcu7t3v3__fill_1
XFILLER_8_321 VDD VDD VSS VSS gf180mcu_as_sc_mcu7t3v3__fill_2
XFILLER_157_377 VDD VDD VSS VSS gf180mcu_as_sc_mcu7t3v3__fill_1
XFILLER_173_815 VDD VDD VSS VSS gf180mcu_as_sc_mcu7t3v3__fillcap_4
XFILLER_185_697 VDD VDD VSS VSS gf180mcu_as_sc_mcu7t3v3__fill_2
XFILLER_8_387 VDD VDD VSS VSS gf180mcu_as_sc_mcu7t3v3__fill_2
XPHY_EDGE_ROW_129_3_Left_501 VDD VSS gf180mcu_as_sc_mcu7t3v3__tap_2
XFILLER_181_881 VDD VDD VSS VSS gf180mcu_as_sc_mcu7t3v3__fillcap_16
X_4270_ VDD VDD VSS VSS _4273_/S _4698_/B _5104_/Q _5104_/D gf180mcu_as_sc_mcu7t3v3__mux2_2
X_3221_ VDD VDD VSS VSS _3558_/B _3243_/A _3241_/C gf180mcu_as_sc_mcu7t3v3__and2_2
XFILLER_171_1352 VDD VDD VSS VSS gf180mcu_as_sc_mcu7t3v3__fill_2
Xclkbuf_leaf_17_clk_regs VDD VDD VSS VSS clkbuf_3_3__f_clk_regs/Y _5164_/CLK gf180mcu_as_sc_mcu7t3v3__clkbuff_12
X_3152_ VDD VDD VSS VSS _4129_/A _3177_/B _3177_/C _4128_/A _3153_/C gf180mcu_as_sc_mcu7t3v3__ao22_2
X_3083_ VDD VDD VSS VSS _3126_/S _4065_/A _4063_/A _3085_/B gf180mcu_as_sc_mcu7t3v3__mux2_2
XPHY_EDGE_ROW_110_3_Right_151 VDD VSS gf180mcu_as_sc_mcu7t3v3__tap_2
XPHY_EDGE_ROW_187_Right_49 VDD VSS gf180mcu_as_sc_mcu7t3v3__tap_2
XFILLER_91_1320 VDD VDD VSS VSS gf180mcu_as_sc_mcu7t3v3__fillcap_4
XPHY_EDGE_ROW_126_1_Right_635 VDD VSS gf180mcu_as_sc_mcu7t3v3__tap_2
X_3985_ VDD VDD VSS VSS _3985_/A _4025_/B _3985_/C _3985_/D _3986_/B gf180mcu_as_sc_mcu7t3v3__ao211_2
XFILLER_10_309 VDD VDD VSS VSS gf180mcu_as_sc_mcu7t3v3__fillcap_4
X_2936_ VDD VDD VSS VSS _3528_/B _3528_/A _3281_/B gf180mcu_as_sc_mcu7t3v3__and2_2
XFILLER_164_804 VDD VDD VSS VSS gf180mcu_as_sc_mcu7t3v3__fill_1
XFILLER_176_664 VDD VDD VSS VSS gf180mcu_as_sc_mcu7t3v3__fill_1
XFILLER_176_675 VDD VDD VSS VSS gf180mcu_as_sc_mcu7t3v3__fill_2
X_2867_ VDD VDD VSS VSS _2868_/B _4765_/Q _2870_/B gf180mcu_as_sc_mcu7t3v3__and2_2
XFILLER_176_697 VDD VDD VSS VSS gf180mcu_as_sc_mcu7t3v3__fill_2
X_4606_ VDD VDD VSS VSS _5200_/Q _4609_/B _4609_/C _5201_/Q _5200_/D gf180mcu_as_sc_mcu7t3v3__ao22_2
XFILLER_191_656 VDD VDD VSS VSS gf180mcu_as_sc_mcu7t3v3__fillcap_4
XFILLER_89_1260 VDD VDD VSS VSS gf180mcu_as_sc_mcu7t3v3__fill_2
X_2798_ VDD VDD VSS VSS _2799_/C _2798_/B _2845_/D gf180mcu_as_sc_mcu7t3v3__nor2_2
XTAP_TAPCELL_ROW_155_1190 VDD VSS gf180mcu_as_sc_mcu7t3v3__tap_2
XFILLER_11_1078 VDD VDD VSS VSS gf180mcu_as_sc_mcu7t3v3__fill_1
XFILLER_11_1089 VDD VDD VSS VSS gf180mcu_as_sc_mcu7t3v3__fill_2
XFILLER_190_177 VDD VDD VSS VSS gf180mcu_as_sc_mcu7t3v3__fillcap_8
XFILLER_89_103 VDD VDD VSS VSS gf180mcu_as_sc_mcu7t3v3__fill_2
XPHY_EDGE_ROW_113_3_Left_485 VDD VSS gf180mcu_as_sc_mcu7t3v3__tap_2
X_4537_ VDD VDD VSS VSS _4538_/B _4537_/A gf180mcu_as_sc_mcu7t3v3__inv_2
XFILLER_171_380 VDD VDD VSS VSS gf180mcu_as_sc_mcu7t3v3__fillcap_16
XFILLER_172_892 VDD VDD VSS VSS gf180mcu_as_sc_mcu7t3v3__fill_1
X_4468_ VDD VDD VSS VSS _4468_/B _4541_/A _4469_/D gf180mcu_as_sc_mcu7t3v3__and2_2
XTAP_TAPCELL_ROW_6_803 VDD VSS gf180mcu_as_sc_mcu7t3v3__tap_2
Xfanout801 VDD VDD VSS VSS _2564_/Y _4748_/A gf180mcu_as_sc_mcu7t3v3__buff_12
Xfanout812 VDD VDD VSS VSS _5221_/Q _4630_/A gf180mcu_as_sc_mcu7t3v3__buff_12
Xfanout823 VDD VDD VSS VSS _5095_/Q _4528_/A gf180mcu_as_sc_mcu7t3v3__buff_12
Xfanout834 VDD VDD VSS VSS fanout835/Y _4525_/A gf180mcu_as_sc_mcu7t3v3__buff_12
X_3419_ VDD VDD VSS VSS _3419_/B _4072_/A _3420_/D gf180mcu_as_sc_mcu7t3v3__or2_2
XTAP_TAPCELL_ROW_6_814 VDD VSS gf180mcu_as_sc_mcu7t3v3__tap_2
Xfanout845 VDD VDD VSS VSS _2560_/Y _2735_/D gf180mcu_as_sc_mcu7t3v3__buff_12
Xfanout867 VDD VDD VSS VSS _2675_/C _2676_/A gf180mcu_as_sc_mcu7t3v3__buff_12
X_4399_ VDD VDD VSS VSS _5168_/Q _4493_/B _4540_/C _5118_/Q _4400_/B gf180mcu_as_sc_mcu7t3v3__ao22_2
XPHY_EDGE_ROW_50_3_Left_422 VDD VSS gf180mcu_as_sc_mcu7t3v3__tap_2
XFILLER_133_35 VDD VDD VSS VSS gf180mcu_as_sc_mcu7t3v3__fillcap_4
Xfanout889 VDD VDD VSS VSS _2563_/A _3676_/D gf180mcu_as_sc_mcu7t3v3__buff_12
XFILLER_133_68 VDD VDD VSS VSS gf180mcu_as_sc_mcu7t3v3__fill_2
XTAP_TAPCELL_ROW_69_1_1022 VDD VSS gf180mcu_as_sc_mcu7t3v3__tap_2
XFILLER_159_609 VDD VDD VSS VSS gf180mcu_as_sc_mcu7t3v3__fillcap_8
XFILLER_183_1278 VDD VDD VSS VSS gf180mcu_as_sc_mcu7t3v3__fillcap_4
XFILLER_155_815 VDD VDD VSS VSS gf180mcu_as_sc_mcu7t3v3__fillcap_4
XFILLER_154_314 VDD VDD VSS VSS gf180mcu_as_sc_mcu7t3v3__fill_1
XFILLER_167_697 VDD VDD VSS VSS gf180mcu_as_sc_mcu7t3v3__fill_2
XFILLER_181_100 VDD VDD VSS VSS gf180mcu_as_sc_mcu7t3v3__fill_2
XTAP_TAPCELL_ROW_175_1577 VDD VSS gf180mcu_as_sc_mcu7t3v3__tap_2
XTAP_TAPCELL_ROW_175_1566 VDD VSS gf180mcu_as_sc_mcu7t3v3__tap_2
XFILLER_154_336 VDD VDD VSS VSS gf180mcu_as_sc_mcu7t3v3__fillcap_16
XFILLER_155_859 VDD VDD VSS VSS gf180mcu_as_sc_mcu7t3v3__fillcap_8
XFILLER_170_807 VDD VDD VSS VSS gf180mcu_as_sc_mcu7t3v3__fillcap_4
XFILLER_182_667 VDD VDD VSS VSS gf180mcu_as_sc_mcu7t3v3__fill_2
XFILLER_33_1292 VDD VDD VSS VSS gf180mcu_as_sc_mcu7t3v3__fillcap_4
XFILLER_6_869 VDD VDD VSS VSS gf180mcu_as_sc_mcu7t3v3__fillcap_4
XTAP_TAPCELL_ROW_192_1891 VDD VSS gf180mcu_as_sc_mcu7t3v3__tap_2
XFILLER_174_64 VDD VDD VSS VSS gf180mcu_as_sc_mcu7t3v3__fillcap_16
XFILLER_1_552 VDD VDD VSS VSS gf180mcu_as_sc_mcu7t3v3__fill_1
X_3770_ VDD VDD VSS VSS _4942_/Q _3770_/B _3770_/C _4152_/A _3771_/D gf180mcu_as_sc_mcu7t3v3__ao22_2
XFILLER_158_664 VDD VDD VSS VSS gf180mcu_as_sc_mcu7t3v3__fill_1
XFILLER_185_450 VDD VDD VSS VSS gf180mcu_as_sc_mcu7t3v3__fill_2
X_2721_ VDD VDD VSS VSS _2735_/A _2721_/B _2721_/C _2735_/D _2723_/C gf180mcu_as_sc_mcu7t3v3__ao211_2
XFILLER_157_185 VDD VDD VSS VSS gf180mcu_as_sc_mcu7t3v3__fillcap_16
XFILLER_160_1097 VDD VDD VSS VSS gf180mcu_as_sc_mcu7t3v3__fillcap_4
XFILLER_172_122 VDD VDD VSS VSS gf180mcu_as_sc_mcu7t3v3__fill_2
X_2652_ VDD VDD VSS VSS _4974_/D _5260_/Q _5248_/Q _2653_/B gf180mcu_as_sc_mcu7t3v3__mux2_2
XTAP_TAPCELL_ROW_11_893 VDD VSS gf180mcu_as_sc_mcu7t3v3__tap_2
XFILLER_154_870 VDD VDD VSS VSS gf180mcu_as_sc_mcu7t3v3__fillcap_4
XFILLER_160_317 VDD VDD VSS VSS gf180mcu_as_sc_mcu7t3v3__fillcap_4
XFILLER_161_829 VDD VDD VSS VSS gf180mcu_as_sc_mcu7t3v3__fillcap_8
Xoutput426 VDD VDD VSS VSS _4814_/Q south_out[9] gf180mcu_as_sc_mcu7t3v3__buff_12
Xoutput415 VDD VDD VSS VSS _4807_/Q south_out[2] gf180mcu_as_sc_mcu7t3v3__buff_12
Xoutput404 VDD VDD VSS VSS _4806_/Q south_out[1] gf180mcu_as_sc_mcu7t3v3__buff_12
X_2583_ VDD VDD VSS VSS _2676_/A _2583_/B _2583_/C _2583_/D _3906_/B gf180mcu_as_sc_mcu7t3v3__ao22_2
XFILLER_5_880 VDD VDD VSS VSS gf180mcu_as_sc_mcu7t3v3__fill_1
Xoutput459 VDD VDD VSS VSS _4881_/Q west_out[8] gf180mcu_as_sc_mcu7t3v3__buff_12
Xoutput448 VDD VDD VSS VSS _4902_/Q west_out[29] gf180mcu_as_sc_mcu7t3v3__buff_12
Xoutput437 VDD VDD VSS VSS _4892_/Q west_out[19] gf180mcu_as_sc_mcu7t3v3__buff_12
X_4322_ VDD VDD VSS VSS _4325_/S _5152_/Q _5151_/Q _5151_/D gf180mcu_as_sc_mcu7t3v3__mux2_2
X_4253_ VDD VDD VSS VSS _4254_/S _4253_/B _5089_/Q _5089_/D gf180mcu_as_sc_mcu7t3v3__mux2_2
X_3204_ VDD VDD VSS VSS _3228_/A _3227_/S _3216_/B _3204_/C gf180mcu_as_sc_mcu7t3v3__ao21_2
XFILLER_136_1291 VDD VDD VSS VSS gf180mcu_as_sc_mcu7t3v3__fillcap_8
X_4184_ VDD VDD VSS VSS _4244_/B _4195_/B _4195_/C _5022_/Q _5022_/D gf180mcu_as_sc_mcu7t3v3__ao22_2
X_3135_ VDD VDD VSS VSS _4112_/A _3177_/B _3177_/C _4111_/A _3136_/C gf180mcu_as_sc_mcu7t3v3__ao22_2
XFILLER_103_38 VDD VDD VSS VSS gf180mcu_as_sc_mcu7t3v3__fillcap_4
X_3066_ VDD VDD VSS VSS _4048_/A _3125_/B _3125_/C _4048_/D _3072_/B gf180mcu_as_sc_mcu7t3v3__ao22_2
XPHY_EDGE_ROW_111_3_Right_152 VDD VSS gf180mcu_as_sc_mcu7t3v3__tap_2
XFILLER_56_1281 VDD VDD VSS VSS gf180mcu_as_sc_mcu7t3v3__fillcap_8
X_3968_ VDD VDD VSS VSS _3968_/A _4024_/B _4024_/C _3968_/D _3969_/D gf180mcu_as_sc_mcu7t3v3__ao22_2
XPHY_EDGE_ROW_127_1_Right_636 VDD VSS gf180mcu_as_sc_mcu7t3v3__tap_2
X_2919_ VDD VDD VSS VSS _3792_/A _3801_/A _3554_/A gf180mcu_as_sc_mcu7t3v3__or2_2
XTAP_TAPCELL_ROW_157_1230 VDD VSS gf180mcu_as_sc_mcu7t3v3__tap_2
XFILLER_163_100 VDD VDD VSS VSS gf180mcu_as_sc_mcu7t3v3__fillcap_4
X_3899_ VDD VDD VSS VSS _3905_/B _5157_/Q _4939_/D gf180mcu_as_sc_mcu7t3v3__and2_2
XFILLER_12_68 VDD VDD VSS VSS gf180mcu_as_sc_mcu7t3v3__fill_1
XFILLER_164_667 VDD VDD VSS VSS gf180mcu_as_sc_mcu7t3v3__fillcap_4
XFILLER_178_1325 VDD VDD VSS VSS gf180mcu_as_sc_mcu7t3v3__fill_1
XTAP_TAPCELL_ROW_153_1149 VDD VSS gf180mcu_as_sc_mcu7t3v3__tap_2
XFILLER_152_818 VDD VDD VSS VSS gf180mcu_as_sc_mcu7t3v3__fillcap_4
XFILLER_191_486 VDD VDD VSS VSS gf180mcu_as_sc_mcu7t3v3__fillcap_4
XTAP_TAPCELL_ROW_170_1485 VDD VSS gf180mcu_as_sc_mcu7t3v3__tap_2
XTAP_TAPCELL_ROW_170_1474 VDD VSS gf180mcu_as_sc_mcu7t3v3__tap_2
XTAP_TAPCELL_ROW_102_3_2013 VDD VSS gf180mcu_as_sc_mcu7t3v3__tap_2
Xfanout631 VDD VDD VSS VSS _3923_/Y wire632/A gf180mcu_as_sc_mcu7t3v3__buff_12
Xfanout642 VDD VDD VSS VSS wire645/Y _3725_/B gf180mcu_as_sc_mcu7t3v3__buff_12
Xfanout664 VDD VDD VSS VSS _3241_/B _3207_/S gf180mcu_as_sc_mcu7t3v3__buff_12
Xfanout675 VDD VDD VSS VSS _2541_/Y _4328_/A gf180mcu_as_sc_mcu7t3v3__buff_12
XFILLER_63_1296 VDD VDD VSS VSS gf180mcu_as_sc_mcu7t3v3__fill_1
Xfanout686 VDD VDD VSS VSS _4103_/B _4024_/B gf180mcu_as_sc_mcu7t3v3__buff_12
XFILLER_160_22 VDD VDD VSS VSS gf180mcu_as_sc_mcu7t3v3__fillcap_4
XFILLER_53_31 VDD VDD VSS VSS gf180mcu_as_sc_mcu7t3v3__fill_1
XTAP_TAPCELL_ROW_177_1606 VDD VSS gf180mcu_as_sc_mcu7t3v3__tap_2
XFILLER_186_225 VDD VDD VSS VSS gf180mcu_as_sc_mcu7t3v3__fillcap_16
XTAP_TAPCELL_ROW_177_1617 VDD VSS gf180mcu_as_sc_mcu7t3v3__tap_2
XFILLER_122_1302 VDD VDD VSS VSS gf180mcu_as_sc_mcu7t3v3__fillcap_4
XFILLER_169_64 VDD VDD VSS VSS gf180mcu_as_sc_mcu7t3v3__fillcap_4
XFILLER_167_461 VDD VDD VSS VSS gf180mcu_as_sc_mcu7t3v3__fillcap_16
XFILLER_6_611 VDD VDD VSS VSS gf180mcu_as_sc_mcu7t3v3__fill_1
XFILLER_70_1256 VDD VDD VSS VSS gf180mcu_as_sc_mcu7t3v3__fillcap_8
XFILLER_154_166 VDD VDD VSS VSS gf180mcu_as_sc_mcu7t3v3__fillcap_8
XFILLER_170_604 VDD VDD VSS VSS gf180mcu_as_sc_mcu7t3v3__fillcap_8
XFILLER_182_453 VDD VDD VSS VSS gf180mcu_as_sc_mcu7t3v3__fill_2
XFILLER_155_1166 VDD VDD VSS VSS gf180mcu_as_sc_mcu7t3v3__fill_1
XFILLER_155_1177 VDD VDD VSS VSS gf180mcu_as_sc_mcu7t3v3__fillcap_8
XFILLER_2_872 VDD VDD VSS VSS gf180mcu_as_sc_mcu7t3v3__fill_2
Xmesh_tile_1052 VDD VDD VSS VSS sw_out[24] gf180mcu_as_sc_mcu7t3v3__tiel_4
Xmesh_tile_1041 VDD VDD VSS VSS sw_out[13] gf180mcu_as_sc_mcu7t3v3__tiel_4
Xmesh_tile_1030 VDD VDD VSS VSS sw_out[2] gf180mcu_as_sc_mcu7t3v3__tiel_4
XTAP_TAPCELL_ROW_37_3_1948 VDD VSS gf180mcu_as_sc_mcu7t3v3__tap_2
XFILLER_166_1240 VDD VDD VSS VSS gf180mcu_as_sc_mcu7t3v3__fillcap_16
Xclkbuf_3_2__f_clk_regs VDD VDD VSS VSS clkbuf_2_1_0_clk_regs/Y clkbuf_leaf_9_clk_regs/A
+ gf180mcu_as_sc_mcu7t3v3__clkbuff_12
X_4940_ VDD VDD VSS VSS _5158_/CLK _4940_/D _4940_/Q gf180mcu_as_sc_mcu7t3v3__dfxtp_2
XFILLER_162_1104 VDD VDD VSS VSS gf180mcu_as_sc_mcu7t3v3__fillcap_16
X_4871_ VDD VDD VSS VSS _5097_/CLK _4871_/D _4871_/Q gf180mcu_as_sc_mcu7t3v3__dfxtp_2
XFILLER_162_1137 VDD VDD VSS VSS gf180mcu_as_sc_mcu7t3v3__fillcap_4
XFILLER_177_214 VDD VDD VSS VSS gf180mcu_as_sc_mcu7t3v3__fill_1
X_3822_ VDD VDD VSS VSS _3826_/B _4168_/A _4907_/Q gf180mcu_as_sc_mcu7t3v3__nor2b_2
XFILLER_158_450 VDD VDD VSS VSS gf180mcu_as_sc_mcu7t3v3__fillcap_4
XFILLER_192_206 VDD VDD VSS VSS gf180mcu_as_sc_mcu7t3v3__fillcap_4
X_3753_ VDD VDD VSS VSS _4132_/A _3803_/B _3753_/C _4863_/D _3775_/D gf180mcu_as_sc_mcu7t3v3__aoi211_2
XPHY_EDGE_ROW_51_1_Right_560 VDD VSS gf180mcu_as_sc_mcu7t3v3__tap_2
X_3684_ VDD VDD VSS VSS _4854_/D _3684_/C _3731_/B _3684_/A gf180mcu_as_sc_mcu7t3v3__aoi21_2
X_2704_ VDD VDD VSS VSS _2732_/S _4960_/Q _4969_/Q _2706_/A gf180mcu_as_sc_mcu7t3v3__mux2_2
XFILLER_173_464 VDD VDD VSS VSS gf180mcu_as_sc_mcu7t3v3__fill_1
X_2635_ VDD VDD VSS VSS _2818_/S _2635_/B _5246_/Q _2636_/B gf180mcu_as_sc_mcu7t3v3__mux2_2
XFILLER_161_648 VDD VDD VSS VSS gf180mcu_as_sc_mcu7t3v3__fillcap_16
Xclkbuf_leaf_32_clk_regs VDD VDD VSS VSS clkbuf_3_4__f_clk_regs/Y _5216_/CLK gf180mcu_as_sc_mcu7t3v3__clkbuff_12
XFILLER_0_809 VDD VDD VSS VSS gf180mcu_as_sc_mcu7t3v3__fill_2
XFILLER_160_169 VDD VDD VSS VSS gf180mcu_as_sc_mcu7t3v3__fillcap_4
XFILLER_173_1233 VDD VDD VSS VSS gf180mcu_as_sc_mcu7t3v3__fillcap_4
X_4305_ VDD VDD VSS VSS _4326_/S _5135_/Q _5134_/Q _5134_/D gf180mcu_as_sc_mcu7t3v3__mux2_2
X_2566_ VDD VDD VSS VSS _4748_/A _5278_/Q _2858_/B gf180mcu_as_sc_mcu7t3v3__and2_2
X_5285_ VDD VDD VSS VSS _5285_/CLK _5285_/D _5285_/Q gf180mcu_as_sc_mcu7t3v3__dfxtp_2
X_2497_ VDD VDD VSS VSS _4662_/C _5222_/Q _2747_/A gf180mcu_as_sc_mcu7t3v3__nor2_2
X_4236_ VDD VDD VSS VSS _4256_/S _4236_/B _5072_/Q _5072_/D gf180mcu_as_sc_mcu7t3v3__mux2_2
XTAP_TAPCELL_ROW_149_3_2060 VDD VSS gf180mcu_as_sc_mcu7t3v3__tap_2
XFILLER_114_37 VDD VDD VSS VSS gf180mcu_as_sc_mcu7t3v3__fill_2
X_4167_ VDD VDD VSS VSS _4167_/Y _4908_/Q _4907_/Q gf180mcu_as_sc_mcu7t3v3__nor2b_2
X_3118_ VDD VDD VSS VSS _3134_/S _4093_/D _4096_/A _3120_/B gf180mcu_as_sc_mcu7t3v3__mux2_2
X_4098_ VDD VDD VSS VSS _4099_/C _4098_/B _4098_/A gf180mcu_as_sc_mcu7t3v3__nor2_2
XFILLER_110_1272 VDD VDD VSS VSS gf180mcu_as_sc_mcu7t3v3__fillcap_4
X_3049_ VDD VDD VSS VSS _4027_/A _3049_/B _3049_/C _3049_/Y _3654_/D gf180mcu_as_sc_mcu7t3v3__aoi211_2
XFILLER_58_1354 VDD VDD VSS VSS gf180mcu_as_sc_mcu7t3v3__fill_1
XPHY_EDGE_ROW_112_3_Right_153 VDD VSS gf180mcu_as_sc_mcu7t3v3__tap_2
XFILLER_11_415 VDD VDD VSS VSS gf180mcu_as_sc_mcu7t3v3__fillcap_4
XFILLER_168_247 VDD VDD VSS VSS gf180mcu_as_sc_mcu7t3v3__fillcap_4
XFILLER_180_1259 VDD VDD VSS VSS gf180mcu_as_sc_mcu7t3v3__fillcap_16
XPHY_EDGE_ROW_128_1_Right_637 VDD VSS gf180mcu_as_sc_mcu7t3v3__tap_2
XFILLER_135_6 VDD VDD VSS VSS gf180mcu_as_sc_mcu7t3v3__fill_1
XFILLER_178_1111 VDD VDD VSS VSS gf180mcu_as_sc_mcu7t3v3__fill_1
XFILLER_99_38 VDD VDD VSS VSS gf180mcu_as_sc_mcu7t3v3__fillcap_4
XTAP_TAPCELL_ROW_172_1514 VDD VSS gf180mcu_as_sc_mcu7t3v3__tap_2
XFILLER_165_976 VDD VDD VSS VSS gf180mcu_as_sc_mcu7t3v3__fillcap_4
XFILLER_180_913 VDD VDD VSS VSS gf180mcu_as_sc_mcu7t3v3__fill_2
XFILLER_152_648 VDD VDD VSS VSS gf180mcu_as_sc_mcu7t3v3__fillcap_8
XFILLER_152_1306 VDD VDD VSS VSS gf180mcu_as_sc_mcu7t3v3__fill_2
XFILLER_152_1328 VDD VDD VSS VSS gf180mcu_as_sc_mcu7t3v3__fill_2
XFILLER_160_692 VDD VDD VSS VSS gf180mcu_as_sc_mcu7t3v3__fillcap_4
XFILLER_48_53 VDD VDD VSS VSS gf180mcu_as_sc_mcu7t3v3__fill_2
Xfanout472 VDD VDD VSS VSS _4199_/Y _4220_/C gf180mcu_as_sc_mcu7t3v3__buff_12
XTAP_TAPCELL_ROW_187_1790 VDD VSS gf180mcu_as_sc_mcu7t3v3__tap_2
Xfanout494 VDD VDD VSS VSS _4220_/B _4217_/B gf180mcu_as_sc_mcu7t3v3__buff_12
XPHY_EDGE_ROW_137_1_Left_329 VDD VSS gf180mcu_as_sc_mcu7t3v3__tap_2
XFILLER_0_27 VDD VDD VSS VSS gf180mcu_as_sc_mcu7t3v3__fillcap_4
XFILLER_185_1104 VDD VDD VSS VSS gf180mcu_as_sc_mcu7t3v3__fillcap_16
XPHY_EDGE_ROW_90_1_Right_599 VDD VSS gf180mcu_as_sc_mcu7t3v3__tap_2
XFILLER_72_1307 VDD VDD VSS VSS gf180mcu_as_sc_mcu7t3v3__fillcap_16
XPHY_EDGE_ROW_138_3_Left_510 VDD VSS gf180mcu_as_sc_mcu7t3v3__tap_2
XFILLER_187_556 VDD VDD VSS VSS gf180mcu_as_sc_mcu7t3v3__fillcap_4
XFILLER_187_578 VDD VDD VSS VSS gf180mcu_as_sc_mcu7t3v3__fill_1
XTAP_TAPCELL_ROW_13_944 VDD VSS gf180mcu_as_sc_mcu7t3v3__tap_2
XTAP_TAPCELL_ROW_13_933 VDD VSS gf180mcu_as_sc_mcu7t3v3__tap_2
XFILLER_168_781 VDD VDD VSS VSS gf180mcu_as_sc_mcu7t3v3__fill_2
XTAP_TAPCELL_ROW_13_966 VDD VSS gf180mcu_as_sc_mcu7t3v3__tap_2
XTAP_TAPCELL_ROW_13_955 VDD VSS gf180mcu_as_sc_mcu7t3v3__tap_2
XFILLER_11_982 VDD VDD VSS VSS gf180mcu_as_sc_mcu7t3v3__fillcap_16
XFILLER_127_100 VDD VDD VSS VSS gf180mcu_as_sc_mcu7t3v3__fillcap_4
XFILLER_161_1192 VDD VDD VSS VSS gf180mcu_as_sc_mcu7t3v3__fillcap_8
Xwire851 VDD VDD VSS VSS wire851/A _3938_/A gf180mcu_as_sc_mcu7t3v3__clkbuff_12
XFILLER_7_986 VDD VDD VSS VSS gf180mcu_as_sc_mcu7t3v3__fill_2
Xmax_cap606 VDD VDD VSS VSS _3772_/C fanout605/A gf180mcu_as_sc_mcu7t3v3__clkbuff_12
Xwire862 VDD VDD VSS VSS wire862/A _4096_/A gf180mcu_as_sc_mcu7t3v3__clkbuff_12
Xwire873 VDD VDD VSS VSS wire873/A _4009_/A gf180mcu_as_sc_mcu7t3v3__clkbuff_12
XFILLER_157_1228 VDD VDD VSS VSS gf180mcu_as_sc_mcu7t3v3__fillcap_16
XFILLER_50_6 VDD VDD VSS VSS gf180mcu_as_sc_mcu7t3v3__fill_2
X_2420_ VDD VDD VSS VSS _2650_/B _2420_/A gf180mcu_as_sc_mcu7t3v3__inv_2
XFILLER_171_979 VDD VDD VSS VSS gf180mcu_as_sc_mcu7t3v3__fill_1
XTAP_TAPCELL_ROW_92_1_1045 VDD VSS gf180mcu_as_sc_mcu7t3v3__tap_2
X_5070_ VDD VDD VSS VSS _5178_/CLK _5070_/D _5070_/Q gf180mcu_as_sc_mcu7t3v3__dfxtp_2
XFILLER_46_1291 VDD VDD VSS VSS gf180mcu_as_sc_mcu7t3v3__fillcap_4
X_4021_ VDD VDD VSS VSS _4021_/A _4021_/B _4021_/C _4021_/D _4022_/D gf180mcu_as_sc_mcu7t3v3__ao22_2
XFILLER_133_1272 VDD VDD VSS VSS gf180mcu_as_sc_mcu7t3v3__fillcap_16
X_4923_ VDD VDD VSS VSS clkload1/A _4923_/D _4923_/Q gf180mcu_as_sc_mcu7t3v3__dfxtp_2
XPHY_EDGE_ROW_122_3_Left_494 VDD VSS gf180mcu_as_sc_mcu7t3v3__tap_2
XFILLER_178_567 VDD VDD VSS VSS gf180mcu_as_sc_mcu7t3v3__fill_1
X_4854_ VDD VDD VSS VSS _5150_/CLK _4854_/D _4854_/Q gf180mcu_as_sc_mcu7t3v3__dfxtp_2
XFILLER_165_206 VDD VDD VSS VSS gf180mcu_as_sc_mcu7t3v3__fillcap_4
XFILLER_165_228 VDD VDD VSS VSS gf180mcu_as_sc_mcu7t3v3__fill_2
XFILLER_53_1262 VDD VDD VSS VSS gf180mcu_as_sc_mcu7t3v3__fill_1
X_4785_ VDD VDD VSS VSS _5150_/CLK _4785_/D _4785_/Q gf180mcu_as_sc_mcu7t3v3__dfxtp_2
X_3805_ VDD VDD VSS VSS _4872_/D _3805_/C _3805_/B _3805_/A gf180mcu_as_sc_mcu7t3v3__aoi21b_2
X_3736_ VDD VDD VSS VSS _3736_/D _4109_/A _3736_/B _3800_/C _3737_/C gf180mcu_as_sc_mcu7t3v3__ao31_2
XFILLER_162_913 VDD VDD VSS VSS gf180mcu_as_sc_mcu7t3v3__fill_2
XPHY_EDGE_ROW_52_1_Right_561 VDD VSS gf180mcu_as_sc_mcu7t3v3__tap_2
XFILLER_109_48 VDD VDD VSS VSS gf180mcu_as_sc_mcu7t3v3__fillcap_4
XFILLER_133_103 VDD VDD VSS VSS gf180mcu_as_sc_mcu7t3v3__fill_2
XFILLER_173_261 VDD VDD VSS VSS gf180mcu_as_sc_mcu7t3v3__fillcap_16
X_3667_ VDD VDD VSS VSS _3668_/C _3667_/C _3667_/B _4041_/A gf180mcu_as_sc_mcu7t3v3__aoi21_2
X_3598_ VDD VDD VSS VSS _3599_/C _3965_/A _3673_/C _3598_/C gf180mcu_as_sc_mcu7t3v3__ao21_2
X_2618_ VDD VDD VSS VSS _2621_/B _2883_/B _4655_/B _2619_/C _4974_/D gf180mcu_as_sc_mcu7t3v3__oai211_2
X_2549_ VDD VDD VSS VSS _4705_/A _4746_/A _2845_/D gf180mcu_as_sc_mcu7t3v3__nand2_2
XFILLER_173_1074 VDD VDD VSS VSS gf180mcu_as_sc_mcu7t3v3__fill_1
X_5268_ VDD VDD VSS VSS _5277_/CLK _5268_/D _5268_/Q gf180mcu_as_sc_mcu7t3v3__dfxtp_2
X_4219_ VDD VDD VSS VSS _4248_/B _4220_/B _4220_/C _5055_/Q _5055_/D gf180mcu_as_sc_mcu7t3v3__ao22_2
X_5199_ VDD VDD VSS VSS _5203_/CLK _5199_/D _5199_/Q gf180mcu_as_sc_mcu7t3v3__dfxtp_2
XFILLER_60_1288 VDD VDD VSS VSS gf180mcu_as_sc_mcu7t3v3__fill_1
XTAP_TAPCELL_ROW_165_1384 VDD VSS gf180mcu_as_sc_mcu7t3v3__tap_2
XTAP_TAPCELL_ROW_165_1373 VDD VSS gf180mcu_as_sc_mcu7t3v3__tap_2
XFILLER_141_68 VDD VDD VSS VSS gf180mcu_as_sc_mcu7t3v3__fill_2
XFILLER_3_1182 VDD VDD VSS VSS gf180mcu_as_sc_mcu7t3v3__fillcap_8
XFILLER_149_1290 VDD VDD VSS VSS gf180mcu_as_sc_mcu7t3v3__fill_1
XFILLER_184_1181 VDD VDD VSS VSS gf180mcu_as_sc_mcu7t3v3__fill_1
XPHY_EDGE_ROW_113_3_Right_154 VDD VSS gf180mcu_as_sc_mcu7t3v3__tap_2
XFILLER_11_212 VDD VDD VSS VSS gf180mcu_as_sc_mcu7t3v3__fillcap_4
XFILLER_12_746 VDD VDD VSS VSS gf180mcu_as_sc_mcu7t3v3__fillcap_4
XFILLER_34_77 VDD VDD VSS VSS gf180mcu_as_sc_mcu7t3v3__fill_2
Xsram2048.u_bank0_911 VDD VDD VSS VSS sram2048.u_bank0/WEN[0] gf180mcu_as_sc_mcu7t3v3__tiel_4
XFILLER_169_578 VDD VDD VSS VSS gf180mcu_as_sc_mcu7t3v3__fillcap_8
XFILLER_32_1302 VDD VDD VSS VSS gf180mcu_as_sc_mcu7t3v3__fill_1
XFILLER_71_1351 VDD VDD VSS VSS gf180mcu_as_sc_mcu7t3v3__fillcap_4
XPHY_EDGE_ROW_129_1_Right_638 VDD VSS gf180mcu_as_sc_mcu7t3v3__tap_2
XFILLER_184_548 VDD VDD VSS VSS gf180mcu_as_sc_mcu7t3v3__fillcap_4
XFILLER_4_901 VDD VDD VSS VSS gf180mcu_as_sc_mcu7t3v3__fillcap_8
XFILLER_4_934 VDD VDD VSS VSS gf180mcu_as_sc_mcu7t3v3__fillcap_8
XFILLER_152_456 VDD VDD VSS VSS gf180mcu_as_sc_mcu7t3v3__fillcap_16
XFILLER_3_422 VDD VDD VSS VSS gf180mcu_as_sc_mcu7t3v3__fill_1
XFILLER_152_478 VDD VDD VSS VSS gf180mcu_as_sc_mcu7t3v3__fillcap_4
XFILLER_156_1250 VDD VDD VSS VSS gf180mcu_as_sc_mcu7t3v3__fillcap_16
XTAP_TAPCELL_ROW_189_1841 VDD VSS gf180mcu_as_sc_mcu7t3v3__tap_2
XTAP_TAPCELL_ROW_189_1830 VDD VSS gf180mcu_as_sc_mcu7t3v3__tap_2
XFILLER_117_1256 VDD VDD VSS VSS gf180mcu_as_sc_mcu7t3v3__fillcap_8
XFILLER_156_1294 VDD VDD VSS VSS gf180mcu_as_sc_mcu7t3v3__fill_1
XFILLER_182_53 VDD VDD VSS VSS gf180mcu_as_sc_mcu7t3v3__fillcap_16
XFILLER_191_1185 VDD VDD VSS VSS gf180mcu_as_sc_mcu7t3v3__fillcap_4
XFILLER_8_1060 VDD VDD VSS VSS gf180mcu_as_sc_mcu7t3v3__fill_1
XFILLER_76_1284 VDD VDD VSS VSS gf180mcu_as_sc_mcu7t3v3__fillcap_4
XFILLER_91_72 VDD VDD VSS VSS gf180mcu_as_sc_mcu7t3v3__fillcap_8
XFILLER_163_1298 VDD VDD VSS VSS gf180mcu_as_sc_mcu7t3v3__fill_1
XFILLER_187_364 VDD VDD VSS VSS gf180mcu_as_sc_mcu7t3v3__fill_1
XFILLER_188_887 VDD VDD VSS VSS gf180mcu_as_sc_mcu7t3v3__fill_1
XPHY_EDGE_ROW_7_Left_200 VDD VSS gf180mcu_as_sc_mcu7t3v3__tap_2
XFILLER_175_559 VDD VDD VSS VSS gf180mcu_as_sc_mcu7t3v3__fill_1
X_4570_ VDD VDD VSS VSS _4570_/S _5028_/Q _5057_/Q _4571_/B gf180mcu_as_sc_mcu7t3v3__mux2_2
XFILLER_7_750 VDD VDD VSS VSS gf180mcu_as_sc_mcu7t3v3__fillcap_4
X_3521_ VDD VDD VSS VSS _3522_/D _3521_/A _3521_/B _3521_/C gf180mcu_as_sc_mcu7t3v3__ao21_2
XFILLER_157_1003 VDD VDD VSS VSS gf180mcu_as_sc_mcu7t3v3__fillcap_4
XFILLER_7_772 VDD VDD VSS VSS gf180mcu_as_sc_mcu7t3v3__fillcap_16
XFILLER_7_794 VDD VDD VSS VSS gf180mcu_as_sc_mcu7t3v3__fill_1
X_3452_ VDD VDD VSS VSS _3452_/S _4104_/D _3452_/A _3454_/B gf180mcu_as_sc_mcu7t3v3__mux2_2
XFILLER_135_1301 VDD VDD VSS VSS gf180mcu_as_sc_mcu7t3v3__fill_2
X_3383_ VDD VDD VSS VSS _3454_/A _3383_/B _3383_/C _3384_/C gf180mcu_as_sc_mcu7t3v3__nor3_2
X_2403_ VDD VDD VSS VSS _4691_/A _3871_/A gf180mcu_as_sc_mcu7t3v3__inv_2
X_5122_ VDD VDD VSS VSS _5181_/CLK _5122_/D _5122_/Q gf180mcu_as_sc_mcu7t3v3__dfxtp_2
X_5053_ VDD VDD VSS VSS clkload2/A _5053_/D _5053_/Q gf180mcu_as_sc_mcu7t3v3__dfxtp_2
X_4889__1079 VDD VDD VSS VSS _4889_/D gf180mcu_as_sc_mcu7t3v3__tiel_4
X_4004_ VDD VDD VSS VSS _4986_/Q _4076_/B _4237_/B _4076_/D _4986_/D gf180mcu_as_sc_mcu7t3v3__ao22_2
XFILLER_179_821 VDD VDD VSS VSS gf180mcu_as_sc_mcu7t3v3__fill_1
XTAP_TAPCELL_ROW_160_1281 VDD VSS gf180mcu_as_sc_mcu7t3v3__tap_2
XFILLER_181_1332 VDD VDD VSS VSS gf180mcu_as_sc_mcu7t3v3__fillcap_16
XFILLER_181_1354 VDD VDD VSS VSS gf180mcu_as_sc_mcu7t3v3__fill_1
X_4906_ VDD VDD VSS VSS clkload5/A _4906_/D _4906_/Q gf180mcu_as_sc_mcu7t3v3__dfxtp_2
XTAP_TAPCELL_ROW_160_1292 VDD VSS gf180mcu_as_sc_mcu7t3v3__tap_2
XFILLER_179_887 VDD VDD VSS VSS gf180mcu_as_sc_mcu7t3v3__fillcap_16
X_4837_ VDD VDD VSS VSS clkload6/A _4837_/D _4837_/Q gf180mcu_as_sc_mcu7t3v3__dfxtp_2
X_4768_ VDD VDD VSS VSS _5275_/CLK _4768_/D _4768_/Q gf180mcu_as_sc_mcu7t3v3__dfxtp_2
XFILLER_174_581 VDD VDD VSS VSS gf180mcu_as_sc_mcu7t3v3__fillcap_8
X_4699_ VDD VDD VSS VSS _4707_/S _5254_/Q _4699_/A _5254_/D gf180mcu_as_sc_mcu7t3v3__mux2_2
X_3719_ VDD VDD VSS VSS _4935_/Q _3799_/B _3778_/B _4096_/D _3720_/D gf180mcu_as_sc_mcu7t3v3__ao22_2
XPHY_EDGE_ROW_53_1_Right_562 VDD VSS gf180mcu_as_sc_mcu7t3v3__tap_2
XTAP_TAPCELL_ROW_36_1_989 VDD VSS gf180mcu_as_sc_mcu7t3v3__tap_2
XFILLER_136_79 VDD VDD VSS VSS gf180mcu_as_sc_mcu7t3v3__fill_1
Xinput304 VDD VDD VSS VSS west_in[29] _3788_/A gf180mcu_as_sc_mcu7t3v3__buff_12
Xinput315 VDD VDD VSS VSS west_in[8] _3997_/D gf180mcu_as_sc_mcu7t3v3__buff_12
XTAP_TAPCELL_ROW_167_1424 VDD VSS gf180mcu_as_sc_mcu7t3v3__tap_2
XTAP_TAPCELL_ROW_167_1413 VDD VSS gf180mcu_as_sc_mcu7t3v3__tap_2
XTAP_TAPCELL_ROW_4_775 VDD VSS gf180mcu_as_sc_mcu7t3v3__tap_2
XTAP_TAPCELL_ROW_4_764 VDD VSS gf180mcu_as_sc_mcu7t3v3__tap_2
XFILLER_1_1119 VDD VDD VSS VSS gf180mcu_as_sc_mcu7t3v3__fill_1
XTAP_TAPCELL_ROW_180_1657 VDD VSS gf180mcu_as_sc_mcu7t3v3__tap_2
XFILLER_182_1107 VDD VDD VSS VSS gf180mcu_as_sc_mcu7t3v3__fillcap_4
XFILLER_186_1243 VDD VDD VSS VSS gf180mcu_as_sc_mcu7t3v3__fillcap_8
XFILLER_186_1265 VDD VDD VSS VSS gf180mcu_as_sc_mcu7t3v3__fillcap_4
XTAP_TAPCELL_ROW_180_1668 VDD VSS gf180mcu_as_sc_mcu7t3v3__tap_2
XFILLER_185_835 VDD VDD VSS VSS gf180mcu_as_sc_mcu7t3v3__fillcap_4
XPHY_EDGE_ROW_114_3_Right_155 VDD VSS gf180mcu_as_sc_mcu7t3v3__tap_2
XFILLER_157_559 VDD VDD VSS VSS gf180mcu_as_sc_mcu7t3v3__fill_1
XFILLER_185_868 VDD VDD VSS VSS gf180mcu_as_sc_mcu7t3v3__fillcap_16
XFILLER_184_356 VDD VDD VSS VSS gf180mcu_as_sc_mcu7t3v3__fillcap_16
XFILLER_8_569 VDD VDD VSS VSS gf180mcu_as_sc_mcu7t3v3__fillcap_4
XANTENNA_8 VDD VDD VSS VSS _4869_/D gf180mcu_as_sc_mcu7t3v3__diode_2
XFILLER_6_48 VDD VDD VSS VSS gf180mcu_as_sc_mcu7t3v3__fillcap_4
XFILLER_153_754 VDD VDD VSS VSS gf180mcu_as_sc_mcu7t3v3__fillcap_8
XFILLER_4_797 VDD VDD VSS VSS gf180mcu_as_sc_mcu7t3v3__fillcap_8
XFILLER_43_1272 VDD VDD VSS VSS gf180mcu_as_sc_mcu7t3v3__fill_1
XFILLER_86_94 VDD VDD VSS VSS gf180mcu_as_sc_mcu7t3v3__fill_1
XTAP_TAPCELL_ROW_87_1_1040 VDD VSS gf180mcu_as_sc_mcu7t3v3__tap_2
XPHY_EDGE_ROW_18_1_Left_210 VDD VSS gf180mcu_as_sc_mcu7t3v3__tap_2
XFILLER_130_1264 VDD VDD VSS VSS gf180mcu_as_sc_mcu7t3v3__fillcap_4
XTAP_TAPCELL_ROW_101_1_1054 VDD VSS gf180mcu_as_sc_mcu7t3v3__tap_2
XFILLER_130_1297 VDD VDD VSS VSS gf180mcu_as_sc_mcu7t3v3__fill_1
XFILLER_179_128 VDD VDD VSS VSS gf180mcu_as_sc_mcu7t3v3__fillcap_8
XFILLER_188_651 VDD VDD VSS VSS gf180mcu_as_sc_mcu7t3v3__fill_2
X_2952_ VDD VDD VSS VSS _3925_/A _3192_/C _2952_/C _3187_/B _2954_/C gf180mcu_as_sc_mcu7t3v3__ao22_2
XFILLER_163_1084 VDD VDD VSS VSS gf180mcu_as_sc_mcu7t3v3__fill_2
XFILLER_187_194 VDD VDD VSS VSS gf180mcu_as_sc_mcu7t3v3__fill_1
X_2883_ VDD VDD VSS VSS _2884_/B _4708_/C _2883_/B _4655_/B gf180mcu_as_sc_mcu7t3v3__aoi21_2
X_4622_ VDD VDD VSS VSS _5216_/Q _4629_/B _4629_/C _5217_/Q _5216_/D gf180mcu_as_sc_mcu7t3v3__ao22_2
XFILLER_191_838 VDD VDD VSS VSS gf180mcu_as_sc_mcu7t3v3__fill_2
X_4553_ VDD VDD VSS VSS _4561_/A _4553_/B _4553_/C _4556_/C _4553_/D gf180mcu_as_sc_mcu7t3v3__aoi211_2
X_4484_ VDD VDD VSS VSS _4485_/B _4484_/A gf180mcu_as_sc_mcu7t3v3__inv_2
X_3504_ VDD VDD VSS VSS _4162_/A _3504_/B _3504_/C _3504_/D _3505_/B gf180mcu_as_sc_mcu7t3v3__ao211_2
XFILLER_171_562 VDD VDD VSS VSS gf180mcu_as_sc_mcu7t3v3__fillcap_8
X_3435_ VDD VDD VSS VSS _4088_/D _3503_/B _3435_/C _3435_/D _3437_/C gf180mcu_as_sc_mcu7t3v3__ao211_2
XFILLER_106_27 VDD VDD VSS VSS gf180mcu_as_sc_mcu7t3v3__fillcap_8
X_3366_ VDD VDD VSS VSS _4016_/A _3453_/B _3453_/C _4017_/A _3367_/C gf180mcu_as_sc_mcu7t3v3__ao22_2
XFILLER_170_1066 VDD VDD VSS VSS gf180mcu_as_sc_mcu7t3v3__fill_2
X_5105_ VDD VDD VSS VSS _5265_/CLK _5105_/D _5105_/Q gf180mcu_as_sc_mcu7t3v3__dfxtp_2
X_3297_ VDD VDD VSS VSS _4917_/Q _3369_/B _3369_/C _3950_/A _3299_/C gf180mcu_as_sc_mcu7t3v3__ao22_2
X_5036_ VDD VDD VSS VSS _5182_/CLK _5036_/D _5036_/Q gf180mcu_as_sc_mcu7t3v3__dfxtp_2
XTAP_TAPCELL_ROW_1_701 VDD VSS gf180mcu_as_sc_mcu7t3v3__tap_2
XTAP_TAPCELL_ROW_1_712 VDD VSS gf180mcu_as_sc_mcu7t3v3__tap_2
XTAP_TAPCELL_ROW_162_1332 VDD VSS gf180mcu_as_sc_mcu7t3v3__tap_2
XTAP_TAPCELL_ROW_162_1321 VDD VSS gf180mcu_as_sc_mcu7t3v3__tap_2
XFILLER_25_101 VDD VDD VSS VSS gf180mcu_as_sc_mcu7t3v3__fillcap_4
XFILLER_167_824 VDD VDD VSS VSS gf180mcu_as_sc_mcu7t3v3__fillcap_4
XFILLER_181_1162 VDD VDD VSS VSS gf180mcu_as_sc_mcu7t3v3__fill_1
XFILLER_154_507 VDD VDD VSS VSS gf180mcu_as_sc_mcu7t3v3__fillcap_16
XFILLER_147_12 VDD VDD VSS VSS gf180mcu_as_sc_mcu7t3v3__fill_1
XFILLER_175_890 VDD VDD VSS VSS gf180mcu_as_sc_mcu7t3v3__fillcap_16
XFILLER_182_827 VDD VDD VSS VSS gf180mcu_as_sc_mcu7t3v3__fill_1
XFILLER_31_56 VDD VDD VSS VSS gf180mcu_as_sc_mcu7t3v3__fill_2
XPHY_EDGE_ROW_146_1_Left_338 VDD VSS gf180mcu_as_sc_mcu7t3v3__tap_2
XPHY_EDGE_ROW_54_1_Right_563 VDD VSS gf180mcu_as_sc_mcu7t3v3__tap_2
XFILLER_163_22 VDD VDD VSS VSS gf180mcu_as_sc_mcu7t3v3__fillcap_16
XTAP_TAPCELL_ROW_9_867 VDD VSS gf180mcu_as_sc_mcu7t3v3__tap_2
XTAP_TAPCELL_ROW_9_856 VDD VSS gf180mcu_as_sc_mcu7t3v3__tap_2
XFILLER_0_244 VDD VDD VSS VSS gf180mcu_as_sc_mcu7t3v3__fill_2
XFILLER_153_1253 VDD VDD VSS VSS gf180mcu_as_sc_mcu7t3v3__fillcap_4
XFILLER_27_1256 VDD VDD VSS VSS gf180mcu_as_sc_mcu7t3v3__fillcap_16
Xinput101 VDD VDD VSS VSS ne_in[30] _3800_/A gf180mcu_as_sc_mcu7t3v3__buff_12
Xinput112 VDD VDD VSS VSS north_in[0] _3930_/A gf180mcu_as_sc_mcu7t3v3__buff_12
Xinput123 VDD VDD VSS VSS north_in[1] _3940_/A gf180mcu_as_sc_mcu7t3v3__buff_12
Xinput134 VDD VDD VSS VSS north_in[2] _3950_/A gf180mcu_as_sc_mcu7t3v3__buff_12
Xinput145 VDD VDD VSS VSS north_in[9] _4005_/A gf180mcu_as_sc_mcu7t3v3__buff_12
XTAP_TAPCELL_ROW_182_1708 VDD VSS gf180mcu_as_sc_mcu7t3v3__tap_2
Xinput156 VDD VDD VSS VSS nw_in[19] _4086_/A gf180mcu_as_sc_mcu7t3v3__buff_12
Xinput167 VDD VDD VSS VSS nw_in[29] _3792_/A gf180mcu_as_sc_mcu7t3v3__buff_12
Xinput178 VDD VDD VSS VSS nw_in[8] _3998_/A gf180mcu_as_sc_mcu7t3v3__buff_12
Xinput189 VDD VDD VSS VSS se_in[17] _4073_/A gf180mcu_as_sc_mcu7t3v3__buff_12
XFILLER_16_101 VDD VDD VSS VSS gf180mcu_as_sc_mcu7t3v3__fillcap_4
XFILLER_72_41 VDD VDD VSS VSS gf180mcu_as_sc_mcu7t3v3__fill_1
XFILLER_13_852 VDD VDD VSS VSS gf180mcu_as_sc_mcu7t3v3__fillcap_4
XFILLER_160_1202 VDD VDD VSS VSS gf180mcu_as_sc_mcu7t3v3__fillcap_8
XFILLER_176_109 VDD VDD VSS VSS gf180mcu_as_sc_mcu7t3v3__fill_1
XPHY_EDGE_ROW_17_3_Left_389 VDD VSS gf180mcu_as_sc_mcu7t3v3__tap_2
XFILLER_12_362 VDD VDD VSS VSS gf180mcu_as_sc_mcu7t3v3__fillcap_4
XFILLER_160_1224 VDD VDD VSS VSS gf180mcu_as_sc_mcu7t3v3__fill_1
XFILLER_185_610 VDD VDD VSS VSS gf180mcu_as_sc_mcu7t3v3__fillcap_16
XPHY_EDGE_ROW_115_3_Right_156 VDD VSS gf180mcu_as_sc_mcu7t3v3__tap_2
XFILLER_12_384 VDD VDD VSS VSS gf180mcu_as_sc_mcu7t3v3__fill_1
XFILLER_12_395 VDD VDD VSS VSS gf180mcu_as_sc_mcu7t3v3__fill_1
XFILLER_10_1260 VDD VDD VSS VSS gf180mcu_as_sc_mcu7t3v3__fill_2
XFILLER_153_551 VDD VDD VSS VSS gf180mcu_as_sc_mcu7t3v3__fillcap_8
XFILLER_153_562 VDD VDD VSS VSS gf180mcu_as_sc_mcu7t3v3__fillcap_16
XFILLER_158_1153 VDD VDD VSS VSS gf180mcu_as_sc_mcu7t3v3__fill_2
XFILLER_98_104 VDD VDD VSS VSS gf180mcu_as_sc_mcu7t3v3__fill_1
XTAP_TAPCELL_ROW_120_3_2031 VDD VSS gf180mcu_as_sc_mcu7t3v3__tap_2
XPHY_EDGE_ROW_79_3_Left_451 VDD VSS gf180mcu_as_sc_mcu7t3v3__tap_2
XFILLER_153_584 VDD VDD VSS VSS gf180mcu_as_sc_mcu7t3v3__fill_1
X_3220_ VDD VDD VSS VSS _3283_/A _3817_/A _3558_/B gf180mcu_as_sc_mcu7t3v3__and2_2
X_3151_ VDD VDD VSS VSS _3176_/S _4126_/D _4130_/A _3153_/B gf180mcu_as_sc_mcu7t3v3__mux2_2
X_3082_ VDD VDD VSS VSS _4064_/A _3125_/B _3125_/C _4064_/D _3088_/B gf180mcu_as_sc_mcu7t3v3__ao22_2
XTAP_TAPCELL_ROW_98_3_2009 VDD VSS gf180mcu_as_sc_mcu7t3v3__tap_2
XFILLER_165_1113 VDD VDD VSS VSS gf180mcu_as_sc_mcu7t3v3__fillcap_4
XFILLER_169_1293 VDD VDD VSS VSS gf180mcu_as_sc_mcu7t3v3__fill_1
XTAP_TAPCELL_ROW_35_1_988 VDD VSS gf180mcu_as_sc_mcu7t3v3__tap_2
XFILLER_22_104 VDD VDD VSS VSS gf180mcu_as_sc_mcu7t3v3__fill_1
XFILLER_189_960 VDD VDD VSS VSS gf180mcu_as_sc_mcu7t3v3__fillcap_4
XFILLER_189_982 VDD VDD VSS VSS gf180mcu_as_sc_mcu7t3v3__fillcap_4
X_3984_ VDD VDD VSS VSS _3984_/A _4022_/B _4021_/B _3984_/D _3985_/D gf180mcu_as_sc_mcu7t3v3__ao22_2
XFILLER_176_610 VDD VDD VSS VSS gf180mcu_as_sc_mcu7t3v3__fillcap_8
X_2935_ VDD VDD VSS VSS _3514_/A _3523_/A _3528_/B gf180mcu_as_sc_mcu7t3v3__or2_2
XFILLER_175_142 VDD VDD VSS VSS gf180mcu_as_sc_mcu7t3v3__fillcap_4
X_2866_ VDD VDD VSS VSS _4742_/A _2871_/B _2866_/C _4764_/D gf180mcu_as_sc_mcu7t3v3__nor3_2
XFILLER_175_153 VDD VDD VSS VSS gf180mcu_as_sc_mcu7t3v3__fill_2
X_4605_ VDD VDD VSS VSS _5199_/Q _4609_/B _4609_/C _5200_/Q _5199_/D gf180mcu_as_sc_mcu7t3v3__ao22_2
XFILLER_11_1024 VDD VDD VSS VSS gf180mcu_as_sc_mcu7t3v3__fill_1
XFILLER_11_1035 VDD VDD VSS VSS gf180mcu_as_sc_mcu7t3v3__fill_2
XFILLER_11_1046 VDD VDD VSS VSS gf180mcu_as_sc_mcu7t3v3__fillcap_4
XFILLER_163_348 VDD VDD VSS VSS gf180mcu_as_sc_mcu7t3v3__fill_2
XFILLER_7_91 VDD VDD VSS VSS gf180mcu_as_sc_mcu7t3v3__fillcap_4
X_2797_ VDD VDD VSS VSS _2797_/A _4626_/B _2806_/A _2797_/D _2800_/A gf180mcu_as_sc_mcu7t3v3__ao211_2
X_4536_ VDD VDD VSS VSS _4536_/S _5082_/Q _4995_/Q _4537_/A gf180mcu_as_sc_mcu7t3v3__mux2_2
XTAP_TAPCELL_ROW_155_1191 VDD VSS gf180mcu_as_sc_mcu7t3v3__tap_2
XFILLER_176_1297 VDD VDD VSS VSS gf180mcu_as_sc_mcu7t3v3__fillcap_4
XFILLER_190_189 VDD VDD VSS VSS gf180mcu_as_sc_mcu7t3v3__fill_2
X_4467_ VDD VDD VSS VSS _5175_/Q _4554_/B _4540_/C _5109_/Q _4468_/B gf180mcu_as_sc_mcu7t3v3__ao22_2
Xfanout813 VDD VDD VSS VSS _2731_/S _2724_/S gf180mcu_as_sc_mcu7t3v3__buff_12
Xfanout824 VDD VDD VSS VSS _4500_/S _4456_/S gf180mcu_as_sc_mcu7t3v3__buff_12
X_4398_ VDD VDD VSS VSS _5166_/Q _4565_/B _4398_/C _4398_/D _5166_/D gf180mcu_as_sc_mcu7t3v3__ao211_2
X_3418_ VDD VDD VSS VSS _4072_/D _3503_/B _3418_/C _3501_/C _3420_/C gf180mcu_as_sc_mcu7t3v3__ao211_2
XTAP_TAPCELL_ROW_6_804 VDD VSS gf180mcu_as_sc_mcu7t3v3__tap_2
Xfanout835 VDD VDD VSS VSS _4586_/S fanout835/Y gf180mcu_as_sc_mcu7t3v3__buff_12
Xfanout846 VDD VDD VSS VSS fanout849/Y _3525_/A gf180mcu_as_sc_mcu7t3v3__buff_12
X_3349_ VDD VDD VSS VSS _3502_/B _3997_/A _3349_/A _3351_/B gf180mcu_as_sc_mcu7t3v3__mux2_2
Xfanout868 VDD VDD VSS VSS _2730_/A _2723_/A gf180mcu_as_sc_mcu7t3v3__buff_12
XTAP_TAPCELL_ROW_55_3_1966 VDD VSS gf180mcu_as_sc_mcu7t3v3__tap_2
X_5019_ VDD VDD VSS VSS _5089_/CLK _5019_/D _5019_/Q gf180mcu_as_sc_mcu7t3v3__dfxtp_2
XFILLER_13_104 VDD VDD VSS VSS gf180mcu_as_sc_mcu7t3v3__fillcap_16
XFILLER_187_908 VDD VDD VSS VSS gf180mcu_as_sc_mcu7t3v3__fill_2
XFILLER_186_429 VDD VDD VSS VSS gf180mcu_as_sc_mcu7t3v3__fill_1
XFILLER_9_108 VDD VDD VSS VSS gf180mcu_as_sc_mcu7t3v3__fill_2
XFILLER_10_877 VDD VDD VSS VSS gf180mcu_as_sc_mcu7t3v3__fillcap_8
XFILLER_155_838 VDD VDD VSS VSS gf180mcu_as_sc_mcu7t3v3__fill_2
XFILLER_166_153 VDD VDD VSS VSS gf180mcu_as_sc_mcu7t3v3__fillcap_4
XFILLER_182_613 VDD VDD VSS VSS gf180mcu_as_sc_mcu7t3v3__fillcap_4
XFILLER_6_804 VDD VDD VSS VSS gf180mcu_as_sc_mcu7t3v3__fill_1
XTAP_TAPCELL_ROW_175_1578 VDD VSS gf180mcu_as_sc_mcu7t3v3__tap_2
XTAP_TAPCELL_ROW_175_1567 VDD VSS gf180mcu_as_sc_mcu7t3v3__tap_2
XTAP_TAPCELL_ROW_192_1892 VDD VSS gf180mcu_as_sc_mcu7t3v3__tap_2
XFILLER_5_358 VDD VDD VSS VSS gf180mcu_as_sc_mcu7t3v3__fill_1
XPHY_EDGE_ROW_55_1_Right_564 VDD VSS gf180mcu_as_sc_mcu7t3v3__tap_2
XFILLER_1_542 VDD VDD VSS VSS gf180mcu_as_sc_mcu7t3v3__fillcap_8
XFILLER_3_27 VDD VDD VSS VSS gf180mcu_as_sc_mcu7t3v3__fillcap_16
X_4884__1084 VDD VDD VSS VSS _4884_/D gf180mcu_as_sc_mcu7t3v3__tiel_4
XFILLER_153_1072 VDD VDD VSS VSS gf180mcu_as_sc_mcu7t3v3__fillcap_4
XFILLER_188_1157 VDD VDD VSS VSS gf180mcu_as_sc_mcu7t3v3__fill_2
XFILLER_40_1286 VDD VDD VSS VSS gf180mcu_as_sc_mcu7t3v3__fill_2
Xclkbuf_3_1__f_clk_regs VDD VDD VSS VSS clkbuf_2_0_0_clk_regs/Y clkbuf_leaf_7_clk_regs/A
+ gf180mcu_as_sc_mcu7t3v3__clkbuff_12
XFILLER_160_1010 VDD VDD VSS VSS gf180mcu_as_sc_mcu7t3v3__fillcap_4
XFILLER_13_682 VDD VDD VSS VSS gf180mcu_as_sc_mcu7t3v3__fillcap_16
XFILLER_157_142 VDD VDD VSS VSS gf180mcu_as_sc_mcu7t3v3__fill_2
XFILLER_160_1032 VDD VDD VSS VSS gf180mcu_as_sc_mcu7t3v3__fill_1
X_2720_ VDD VDD VSS VSS _2734_/S _2720_/B _2720_/A _2721_/C gf180mcu_as_sc_mcu7t3v3__mux2_2
XFILLER_12_1322 VDD VDD VSS VSS gf180mcu_as_sc_mcu7t3v3__fillcap_4
XFILLER_158_698 VDD VDD VSS VSS gf180mcu_as_sc_mcu7t3v3__fillcap_4
XFILLER_160_1087 VDD VDD VSS VSS gf180mcu_as_sc_mcu7t3v3__fill_1
XPHY_EDGE_ROW_116_3_Right_157 VDD VSS gf180mcu_as_sc_mcu7t3v3__tap_2
X_2651_ VDD VDD VSS VSS _2657_/C _2832_/S _2722_/B input7/Y gf180mcu_as_sc_mcu7t3v3__aoi21_2
XFILLER_173_657 VDD VDD VSS VSS gf180mcu_as_sc_mcu7t3v3__fillcap_4
XFILLER_66_4 VDD VDD VSS VSS gf180mcu_as_sc_mcu7t3v3__fill_1
XTAP_TAPCELL_ROW_11_894 VDD VSS gf180mcu_as_sc_mcu7t3v3__tap_2
Xoutput416 VDD VDD VSS VSS _4835_/Q south_out[30] gf180mcu_as_sc_mcu7t3v3__buff_12
Xoutput405 VDD VDD VSS VSS _4825_/Q south_out[20] gf180mcu_as_sc_mcu7t3v3__buff_12
X_2582_ VDD VDD VSS VSS _2583_/D _2723_/A _2736_/B input2/Y gf180mcu_as_sc_mcu7t3v3__aoi21b_2
XFILLER_172_189 VDD VDD VSS VSS gf180mcu_as_sc_mcu7t3v3__fillcap_4
Xoutput449 VDD VDD VSS VSS _4875_/Q west_out[2] gf180mcu_as_sc_mcu7t3v3__buff_12
Xoutput438 VDD VDD VSS VSS _4874_/Q west_out[1] gf180mcu_as_sc_mcu7t3v3__buff_12
Xoutput427 VDD VDD VSS VSS _4873_/Q west_out[0] gf180mcu_as_sc_mcu7t3v3__buff_12
X_4321_ VDD VDD VSS VSS _4325_/S _5151_/Q _5150_/Q _5150_/D gf180mcu_as_sc_mcu7t3v3__mux2_2
X_4252_ VDD VDD VSS VSS _4254_/S _4252_/B _5088_/Q _5088_/D gf180mcu_as_sc_mcu7t3v3__mux2_2
XFILLER_171_1150 VDD VDD VSS VSS gf180mcu_as_sc_mcu7t3v3__fillcap_8
X_3203_ VDD VDD VSS VSS _3213_/D _3203_/A _3203_/B _3210_/B _3205_/B gf180mcu_as_sc_mcu7t3v3__ao31_2
X_4183_ VDD VDD VSS VSS _4243_/B _4195_/B _4195_/C _5021_/Q _5021_/D gf180mcu_as_sc_mcu7t3v3__ao22_2
X_3134_ VDD VDD VSS VSS _3134_/S _4109_/D _4113_/A _3136_/B gf180mcu_as_sc_mcu7t3v3__mux2_2
X_3065_ VDD VDD VSS VSS _4043_/A _3065_/B _3065_/C _3065_/Y _3699_/D gf180mcu_as_sc_mcu7t3v3__aoi211_2
XFILLER_108_1350 VDD VDD VSS VSS gf180mcu_as_sc_mcu7t3v3__fillcap_4
X_3967_ VDD VDD VSS VSS _3967_/A _4023_/B _4023_/C _4919_/Q _3969_/C gf180mcu_as_sc_mcu7t3v3__ao22_2
XFILLER_143_1263 VDD VDD VSS VSS gf180mcu_as_sc_mcu7t3v3__fillcap_4
X_2918_ VDD VDD VSS VSS _3280_/B _3792_/A _3801_/A gf180mcu_as_sc_mcu7t3v3__nor2_2
XTAP_TAPCELL_ROW_157_1231 VDD VSS gf180mcu_as_sc_mcu7t3v3__tap_2
XTAP_TAPCELL_ROW_157_1220 VDD VSS gf180mcu_as_sc_mcu7t3v3__tap_2
XFILLER_13_1119 VDD VDD VSS VSS gf180mcu_as_sc_mcu7t3v3__fill_2
XFILLER_143_1296 VDD VDD VSS VSS gf180mcu_as_sc_mcu7t3v3__fillcap_4
X_3898_ VDD VDD VSS VSS _3908_/B _5188_/Q _4938_/D gf180mcu_as_sc_mcu7t3v3__and2_2
XFILLER_164_646 VDD VDD VSS VSS gf180mcu_as_sc_mcu7t3v3__fillcap_4
X_2849_ VDD VDD VSS VSS _2851_/B _3868_/C _4338_/A _2849_/A gf180mcu_as_sc_mcu7t3v3__aoi21_2
XFILLER_191_454 VDD VDD VSS VSS gf180mcu_as_sc_mcu7t3v3__fillcap_16
XFILLER_3_807 VDD VDD VSS VSS gf180mcu_as_sc_mcu7t3v3__fillcap_4
XFILLER_176_1072 VDD VDD VSS VSS gf180mcu_as_sc_mcu7t3v3__fill_1
XFILLER_2_317 VDD VDD VSS VSS gf180mcu_as_sc_mcu7t3v3__fillcap_4
X_4519_ VDD VDD VSS VSS _4520_/D _4519_/B _4572_/A gf180mcu_as_sc_mcu7t3v3__nor2_2
XTAP_TAPCELL_ROW_170_1475 VDD VSS gf180mcu_as_sc_mcu7t3v3__tap_2
Xfanout610 VDD VDD VSS VSS _3240_/B _3206_/B gf180mcu_as_sc_mcu7t3v3__buff_12
XFILLER_63_1264 VDD VDD VSS VSS gf180mcu_as_sc_mcu7t3v3__fillcap_4
Xfanout643 VDD VDD VSS VSS wire645/Y _3781_/S gf180mcu_as_sc_mcu7t3v3__buff_12
Xfanout654 VDD VDD VSS VSS _3267_/Y _3496_/B gf180mcu_as_sc_mcu7t3v3__buff_12
Xfanout665 VDD VDD VSS VSS _2947_/Y _3241_/B gf180mcu_as_sc_mcu7t3v3__buff_12
Xfanout676 VDD VDD VSS VSS _4611_/C _4609_/C gf180mcu_as_sc_mcu7t3v3__buff_12
XFILLER_150_1256 VDD VDD VSS VSS gf180mcu_as_sc_mcu7t3v3__fill_1
Xfanout687 VDD VDD VSS VSS _3931_/Y _4103_/B gf180mcu_as_sc_mcu7t3v3__buff_12
Xfanout698 VDD VDD VSS VSS wire700/Y _3503_/B gf180mcu_as_sc_mcu7t3v3__buff_12
XFILLER_160_34 VDD VDD VSS VSS gf180mcu_as_sc_mcu7t3v3__fill_1
XFILLER_160_67 VDD VDD VSS VSS gf180mcu_as_sc_mcu7t3v3__fillcap_8
Xclkbuf_leaf_2_clk_regs VDD VDD VSS VSS clkbuf_leaf_6_clk_regs/A clkload1/A gf180mcu_as_sc_mcu7t3v3__clkbuff_12
XTAP_TAPCELL_ROW_177_1607 VDD VSS gf180mcu_as_sc_mcu7t3v3__tap_2
XFILLER_183_1076 VDD VDD VSS VSS gf180mcu_as_sc_mcu7t3v3__fill_1
XFILLER_35_1322 VDD VDD VSS VSS gf180mcu_as_sc_mcu7t3v3__fill_2
XTAP_TAPCELL_ROW_177_1618 VDD VSS gf180mcu_as_sc_mcu7t3v3__tap_2
XFILLER_168_963 VDD VDD VSS VSS gf180mcu_as_sc_mcu7t3v3__fillcap_4
XFILLER_155_657 VDD VDD VSS VSS gf180mcu_as_sc_mcu7t3v3__fillcap_8
XFILLER_6_678 VDD VDD VSS VSS gf180mcu_as_sc_mcu7t3v3__fillcap_4
XTAP_TAPCELL_ROW_34_1_987 VDD VSS gf180mcu_as_sc_mcu7t3v3__tap_2
XFILLER_159_1292 VDD VDD VSS VSS gf180mcu_as_sc_mcu7t3v3__fill_2
XPHY_EDGE_ROW_56_1_Right_565 VDD VSS gf180mcu_as_sc_mcu7t3v3__tap_2
XFILLER_155_1189 VDD VDD VSS VSS gf180mcu_as_sc_mcu7t3v3__fill_1
Xmesh_tile_1020 VDD VDD VSS VSS nw_out[26] gf180mcu_as_sc_mcu7t3v3__tiel_4
XFILLER_94_72 VDD VDD VSS VSS gf180mcu_as_sc_mcu7t3v3__fill_1
Xmesh_tile_1053 VDD VDD VSS VSS sw_out[25] gf180mcu_as_sc_mcu7t3v3__tiel_4
Xmesh_tile_1042 VDD VDD VSS VSS sw_out[14] gf180mcu_as_sc_mcu7t3v3__tiel_4
Xmesh_tile_1031 VDD VDD VSS VSS sw_out[3] gf180mcu_as_sc_mcu7t3v3__tiel_4
X_4870_ VDD VDD VSS VSS _5097_/CLK _4870_/D _4870_/Q gf180mcu_as_sc_mcu7t3v3__dfxtp_2
X_3821_ VDD VDD VSS VSS _3929_/A _3918_/A _3917_/A _3821_/C _4168_/A gf180mcu_as_sc_mcu7t3v3__ao31_2
XFILLER_186_760 VDD VDD VSS VSS gf180mcu_as_sc_mcu7t3v3__fillcap_4
XFILLER_71_2 VDD VDD VSS VSS gf180mcu_as_sc_mcu7t3v3__fill_1
X_3752_ VDD VDD VSS VSS _4131_/A _3802_/B _3803_/B _3753_/C _3752_/D gf180mcu_as_sc_mcu7t3v3__aoi211_2
XTAP_TAPCELL_ROW_107_3_2018 VDD VSS gf180mcu_as_sc_mcu7t3v3__tap_2
X_3683_ VDD VDD VSS VSS _3730_/D _3730_/A _3683_/B _3683_/C _3684_/C gf180mcu_as_sc_mcu7t3v3__ao31_2
X_2703_ VDD VDD VSS VSS _2724_/S _5176_/Q _5168_/Q _2707_/B gf180mcu_as_sc_mcu7t3v3__mux2_2
XPHY_EDGE_ROW_117_3_Right_158 VDD VSS gf180mcu_as_sc_mcu7t3v3__tap_2
X_2634_ VDD VDD VSS VSS _2635_/B _5258_/Q _2634_/B _2634_/C gf180mcu_as_sc_mcu7t3v3__ao21_2
X_2565_ VDD VDD VSS VSS _2565_/B _2565_/A _4742_/C gf180mcu_as_sc_mcu7t3v3__or2_2
X_4304_ VDD VDD VSS VSS _4326_/S _5134_/Q _5133_/Q _5133_/D gf180mcu_as_sc_mcu7t3v3__mux2_2
XPHY_EDGE_ROW_39_3_Right_80 VDD VSS gf180mcu_as_sc_mcu7t3v3__tap_2
XFILLER_173_1278 VDD VDD VSS VSS gf180mcu_as_sc_mcu7t3v3__fillcap_8
X_5284_ VDD VDD VSS VSS _5285_/CLK _5284_/D _5284_/Q gf180mcu_as_sc_mcu7t3v3__dfxtp_2
X_2496_ VDD VDD VSS VSS _2876_/B _4630_/A _2747_/A gf180mcu_as_sc_mcu7t3v3__nor2_2
X_4235_ VDD VDD VSS VSS _4256_/S _4235_/B _5071_/Q _5071_/D gf180mcu_as_sc_mcu7t3v3__mux2_2
XFILLER_114_27 VDD VDD VSS VSS gf180mcu_as_sc_mcu7t3v3__fill_1
X_4166_ VDD VDD VSS VSS _5006_/Q _4166_/B _4257_/B _4166_/D _5006_/D gf180mcu_as_sc_mcu7t3v3__ao22_2
X_3117_ VDD VDD VSS VSS _4094_/A _3206_/B _3192_/C _4093_/A _3123_/B gf180mcu_as_sc_mcu7t3v3__ao22_2
XFILLER_23_1292 VDD VDD VSS VSS gf180mcu_as_sc_mcu7t3v3__fillcap_4
X_4097_ VDD VDD VSS VSS _4097_/A _4163_/B _4097_/C _4097_/D _4098_/B gf180mcu_as_sc_mcu7t3v3__ao211_2
XFILLER_110_1284 VDD VDD VSS VSS gf180mcu_as_sc_mcu7t3v3__fillcap_4
X_3048_ VDD VDD VSS VSS _3049_/B _3048_/B _3048_/C _3049_/C gf180mcu_as_sc_mcu7t3v3__nor3_2
XFILLER_130_37 VDD VDD VSS VSS gf180mcu_as_sc_mcu7t3v3__fillcap_8
XPHY_EDGE_ROW_31_3_Left_403 VDD VSS gf180mcu_as_sc_mcu7t3v3__tap_2
XFILLER_12_928 VDD VDD VSS VSS gf180mcu_as_sc_mcu7t3v3__fillcap_16
XFILLER_180_1227 VDD VDD VSS VSS gf180mcu_as_sc_mcu7t3v3__fillcap_16
XPHY_EDGE_ROW_79_3_Right_120 VDD VSS gf180mcu_as_sc_mcu7t3v3__tap_2
XFILLER_168_237 VDD VDD VSS VSS gf180mcu_as_sc_mcu7t3v3__fillcap_8
X_4999_ VDD VDD VSS VSS _5086_/CLK _4999_/D _4999_/Q gf180mcu_as_sc_mcu7t3v3__dfxtp_2
XFILLER_164_410 VDD VDD VSS VSS gf180mcu_as_sc_mcu7t3v3__fill_2
XFILLER_165_933 VDD VDD VSS VSS gf180mcu_as_sc_mcu7t3v3__fill_1
XFILLER_192_741 VDD VDD VSS VSS gf180mcu_as_sc_mcu7t3v3__fillcap_4
XTAP_TAPCELL_ROW_172_1515 VDD VSS gf180mcu_as_sc_mcu7t3v3__tap_2
XFILLER_164_454 VDD VDD VSS VSS gf180mcu_as_sc_mcu7t3v3__fill_1
XFILLER_164_476 VDD VDD VSS VSS gf180mcu_as_sc_mcu7t3v3__fill_1
XFILLER_180_947 VDD VDD VSS VSS gf180mcu_as_sc_mcu7t3v3__fillcap_16
XFILLER_155_34 VDD VDD VSS VSS gf180mcu_as_sc_mcu7t3v3__fillcap_8
XFILLER_155_67 VDD VDD VSS VSS gf180mcu_as_sc_mcu7t3v3__fill_2
XFILLER_65_1326 VDD VDD VSS VSS gf180mcu_as_sc_mcu7t3v3__fill_2
XFILLER_160_671 VDD VDD VSS VSS gf180mcu_as_sc_mcu7t3v3__fill_2
XFILLER_171_22 VDD VDD VSS VSS gf180mcu_as_sc_mcu7t3v3__fillcap_16
Xfanout473 VDD VDD VSS VSS _4228_/C _4227_/C gf180mcu_as_sc_mcu7t3v3__buff_12
XTAP_TAPCELL_ROW_187_1791 VDD VSS gf180mcu_as_sc_mcu7t3v3__tap_2
XPHY_EDGE_ROW_26_3_Left_398 VDD VSS gf180mcu_as_sc_mcu7t3v3__tap_2
XFILLER_8_1297 VDD VDD VSS VSS gf180mcu_as_sc_mcu7t3v3__fillcap_4
Xfanout495 VDD VDD VSS VSS _4198_/Y _4220_/B gf180mcu_as_sc_mcu7t3v3__buff_12
XFILLER_171_88 VDD VDD VSS VSS gf180mcu_as_sc_mcu7t3v3__fillcap_4
XPHY_EDGE_ROW_87_1_Left_279 VDD VSS gf180mcu_as_sc_mcu7t3v3__tap_2
XFILLER_185_1138 VDD VDD VSS VSS gf180mcu_as_sc_mcu7t3v3__fillcap_16
XFILLER_64_31 VDD VDD VSS VSS gf180mcu_as_sc_mcu7t3v3__fillcap_4
XPHY_EDGE_ROW_88_3_Left_460 VDD VSS gf180mcu_as_sc_mcu7t3v3__tap_2
XFILLER_80_41 VDD VDD VSS VSS gf180mcu_as_sc_mcu7t3v3__fill_2
XTAP_TAPCELL_ROW_13_934 VDD VSS gf180mcu_as_sc_mcu7t3v3__tap_2
XFILLER_161_1171 VDD VDD VSS VSS gf180mcu_as_sc_mcu7t3v3__fillcap_16
XTAP_TAPCELL_ROW_13_967 VDD VSS gf180mcu_as_sc_mcu7t3v3__tap_2
XTAP_TAPCELL_ROW_13_956 VDD VSS gf180mcu_as_sc_mcu7t3v3__tap_2
XTAP_TAPCELL_ROW_13_945 VDD VSS gf180mcu_as_sc_mcu7t3v3__tap_2
XFILLER_156_933 VDD VDD VSS VSS gf180mcu_as_sc_mcu7t3v3__fill_1
XFILLER_156_955 VDD VDD VSS VSS gf180mcu_as_sc_mcu7t3v3__fillcap_4
Xwire852 VDD VDD VSS VSS wire852/A _4021_/A gf180mcu_as_sc_mcu7t3v3__clkbuff_12
XFILLER_171_903 VDD VDD VSS VSS gf180mcu_as_sc_mcu7t3v3__fillcap_4
Xwire863 VDD VDD VSS VSS wire863/A _4088_/A gf180mcu_as_sc_mcu7t3v3__clkbuff_12
Xwire874 VDD VDD VSS VSS wire874/A _3993_/A gf180mcu_as_sc_mcu7t3v3__clkbuff_12
XFILLER_157_1218 VDD VDD VSS VSS gf180mcu_as_sc_mcu7t3v3__fill_2
XFILLER_183_796 VDD VDD VSS VSS gf180mcu_as_sc_mcu7t3v3__fill_2
XFILLER_170_457 VDD VDD VSS VSS gf180mcu_as_sc_mcu7t3v3__fillcap_8
XFILLER_89_72 VDD VDD VSS VSS gf180mcu_as_sc_mcu7t3v3__fillcap_4
XPHY_EDGE_ROW_57_1_Right_566 VDD VSS gf180mcu_as_sc_mcu7t3v3__tap_2
X_4020_ VDD VDD VSS VSS _4988_/Q _4150_/B _4239_/B _4150_/D _4988_/D gf180mcu_as_sc_mcu7t3v3__ao22_2
X_4922_ VDD VDD VSS VSS clkload1/A _4922_/D _4922_/Q gf180mcu_as_sc_mcu7t3v3__dfxtp_2
XFILLER_166_1093 VDD VDD VSS VSS gf180mcu_as_sc_mcu7t3v3__fill_1
X_4853_ VDD VDD VSS VSS _5278_/CLK _4853_/D _4853_/Q gf180mcu_as_sc_mcu7t3v3__dfxtp_2
X_4784_ VDD VDD VSS VSS _5278_/CLK _4784_/D _4784_/Q gf180mcu_as_sc_mcu7t3v3__dfxtp_2
X_3804_ VDD VDD VSS VSS _3804_/B _3804_/A _4869_/D gf180mcu_as_sc_mcu7t3v3__and2_2
XFILLER_174_741 VDD VDD VSS VSS gf180mcu_as_sc_mcu7t3v3__fill_2
XFILLER_53_1296 VDD VDD VSS VSS gf180mcu_as_sc_mcu7t3v3__fill_1
X_3735_ VDD VDD VSS VSS _4937_/Q _3770_/B _3778_/B _4111_/A _3736_/D gf180mcu_as_sc_mcu7t3v3__ao22_2
XFILLER_140_1288 VDD VDD VSS VSS gf180mcu_as_sc_mcu7t3v3__fill_1
XFILLER_162_947 VDD VDD VSS VSS gf180mcu_as_sc_mcu7t3v3__fillcap_16
XFILLER_175_1329 VDD VDD VSS VSS gf180mcu_as_sc_mcu7t3v3__fill_1
X_3666_ VDD VDD VSS VSS _3666_/D _4037_/A _3728_/B _3728_/C _3667_/C gf180mcu_as_sc_mcu7t3v3__ao31_2
XPHY_EDGE_ROW_118_3_Right_159 VDD VSS gf180mcu_as_sc_mcu7t3v3__tap_2
X_3597_ VDD VDD VSS VSS _3965_/D _3650_/B _3597_/C _3597_/D _3598_/C gf180mcu_as_sc_mcu7t3v3__ao211_2
X_2617_ VDD VDD VSS VSS _2643_/C _2634_/B gf180mcu_as_sc_mcu7t3v3__inv_2
X_2548_ VDD VDD VSS VSS _2556_/B _5222_/Q _2845_/D gf180mcu_as_sc_mcu7t3v3__nand2_2
XFILLER_125_48 VDD VDD VSS VSS gf180mcu_as_sc_mcu7t3v3__fillcap_8
XFILLER_173_1064 VDD VDD VSS VSS gf180mcu_as_sc_mcu7t3v3__fillcap_8
X_5267_ VDD VDD VSS VSS _5267_/CLK _5267_/D _5267_/Q gf180mcu_as_sc_mcu7t3v3__dfxtp_2
X_4218_ VDD VDD VSS VSS _4247_/B _4220_/B _4218_/C _5054_/Q _5054_/D gf180mcu_as_sc_mcu7t3v3__ao22_2
X_2479_ VDD VDD VSS VSS _5272_/Q _5273_/Q _4291_/A gf180mcu_as_sc_mcu7t3v3__or2_2
XFILLER_60_1256 VDD VDD VSS VSS gf180mcu_as_sc_mcu7t3v3__fillcap_4
X_5198_ VDD VDD VSS VSS _5203_/CLK _5198_/D _5198_/Q gf180mcu_as_sc_mcu7t3v3__dfxtp_2
XFILLER_141_36 VDD VDD VSS VSS gf180mcu_as_sc_mcu7t3v3__fill_1
XFILLER_95_1308 VDD VDD VSS VSS gf180mcu_as_sc_mcu7t3v3__fillcap_4
X_4149_ VDD VDD VSS VSS _4149_/B _4165_/A _4255_/B gf180mcu_as_sc_mcu7t3v3__and2_2
XTAP_TAPCELL_ROW_165_1385 VDD VSS gf180mcu_as_sc_mcu7t3v3__tap_2
XTAP_TAPCELL_ROW_165_1374 VDD VSS gf180mcu_as_sc_mcu7t3v3__tap_2
XFILLER_18_79 VDD VDD VSS VSS gf180mcu_as_sc_mcu7t3v3__fillcap_4
XFILLER_70_102 VDD VDD VSS VSS gf180mcu_as_sc_mcu7t3v3__fill_2
XTAP_TAPCELL_ROW_33_1_986 VDD VSS gf180mcu_as_sc_mcu7t3v3__tap_2
XFILLER_169_557 VDD VDD VSS VSS gf180mcu_as_sc_mcu7t3v3__fill_2
Xsram2048.u_bank0_912 VDD VDD VSS VSS sram2048.u_bank0/WEN[1] gf180mcu_as_sc_mcu7t3v3__tiel_4
XFILLER_184_527 VDD VDD VSS VSS gf180mcu_as_sc_mcu7t3v3__fillcap_8
XFILLER_8_718 VDD VDD VSS VSS gf180mcu_as_sc_mcu7t3v3__fillcap_16
XFILLER_50_33 VDD VDD VSS VSS gf180mcu_as_sc_mcu7t3v3__fill_2
XFILLER_7_206 VDD VDD VSS VSS gf180mcu_as_sc_mcu7t3v3__fillcap_4
Xclkload0 VDD VDD VSS VSS clkload0/A clkload0/Y gf180mcu_as_sc_mcu7t3v3__clkbuff_12
XFILLER_153_914 VDD VDD VSS VSS gf180mcu_as_sc_mcu7t3v3__fill_1
XFILLER_152_402 VDD VDD VSS VSS gf180mcu_as_sc_mcu7t3v3__fillcap_4
XFILLER_165_785 VDD VDD VSS VSS gf180mcu_as_sc_mcu7t3v3__fill_1
XFILLER_192_571 VDD VDD VSS VSS gf180mcu_as_sc_mcu7t3v3__fill_2
XFILLER_192_582 VDD VDD VSS VSS gf180mcu_as_sc_mcu7t3v3__fill_1
XFILLER_153_958 VDD VDD VSS VSS gf180mcu_as_sc_mcu7t3v3__fillcap_16
XFILLER_180_755 VDD VDD VSS VSS gf180mcu_as_sc_mcu7t3v3__fill_2
XTAP_TAPCELL_ROW_189_1842 VDD VSS gf180mcu_as_sc_mcu7t3v3__tap_2
XTAP_TAPCELL_ROW_189_1831 VDD VSS gf180mcu_as_sc_mcu7t3v3__tap_2
XFILLER_152_1115 VDD VDD VSS VSS gf180mcu_as_sc_mcu7t3v3__fillcap_4
XFILLER_3_489 VDD VDD VSS VSS gf180mcu_as_sc_mcu7t3v3__fill_1
XFILLER_189_1060 VDD VDD VSS VSS gf180mcu_as_sc_mcu7t3v3__fill_2
XFILLER_188_811 VDD VDD VSS VSS gf180mcu_as_sc_mcu7t3v3__fill_2
XFILLER_163_1233 VDD VDD VSS VSS gf180mcu_as_sc_mcu7t3v3__fillcap_8
XFILLER_163_1277 VDD VDD VSS VSS gf180mcu_as_sc_mcu7t3v3__fillcap_4
XFILLER_188_877 VDD VDD VSS VSS gf180mcu_as_sc_mcu7t3v3__fillcap_8
XFILLER_156_752 VDD VDD VSS VSS gf180mcu_as_sc_mcu7t3v3__fill_1
X_3520_ VDD VDD VSS VSS _3520_/A _3520_/B _3520_/C _3520_/D _3521_/C gf180mcu_as_sc_mcu7t3v3__ao211_2
XFILLER_156_796 VDD VDD VSS VSS gf180mcu_as_sc_mcu7t3v3__fillcap_8
XFILLER_157_1048 VDD VDD VSS VSS gf180mcu_as_sc_mcu7t3v3__fill_2
X_3451_ VDD VDD VSS VSS _4101_/A _3451_/B _3451_/C _3451_/D _3452_/A gf180mcu_as_sc_mcu7t3v3__ao211_2
XFILLER_171_788 VDD VDD VSS VSS gf180mcu_as_sc_mcu7t3v3__fillcap_16
XFILLER_48_1354 VDD VDD VSS VSS gf180mcu_as_sc_mcu7t3v3__fill_1
X_3382_ VDD VDD VSS VSS _4032_/A _3453_/B _3453_/C _4033_/A _3383_/C gf180mcu_as_sc_mcu7t3v3__ao22_2
X_2402_ VDD VDD VSS VSS _2815_/A _4976_/Q gf180mcu_as_sc_mcu7t3v3__inv_2
XFILLER_170_1215 VDD VDD VSS VSS gf180mcu_as_sc_mcu7t3v3__fill_1
XFILLER_83_1256 VDD VDD VSS VSS gf180mcu_as_sc_mcu7t3v3__fillcap_16
X_5121_ VDD VDD VSS VSS _5266_/CLK _5121_/D _5121_/Q gf180mcu_as_sc_mcu7t3v3__dfxtp_2
XPHY_EDGE_ROW_58_1_Right_567 VDD VSS gf180mcu_as_sc_mcu7t3v3__tap_2
X_5052_ VDD VDD VSS VSS _5086_/CLK _5052_/D _5052_/Q gf180mcu_as_sc_mcu7t3v3__dfxtp_2
X_4003_ VDD VDD VSS VSS _4003_/A _4086_/C _4003_/C _4237_/B _4099_/D gf180mcu_as_sc_mcu7t3v3__aoi211_2
X_4897__1071 VDD VDD VSS VSS _4897_/D gf180mcu_as_sc_mcu7t3v3__tiel_4
XFILLER_0_1323 VDD VDD VSS VSS gf180mcu_as_sc_mcu7t3v3__fill_2
XTAP_TAPCELL_ROW_160_1282 VDD VSS gf180mcu_as_sc_mcu7t3v3__tap_2
XFILLER_178_321 VDD VDD VSS VSS gf180mcu_as_sc_mcu7t3v3__fill_2
XFILLER_179_866 VDD VDD VSS VSS gf180mcu_as_sc_mcu7t3v3__fillcap_8
X_4905_ VDD VDD VSS VSS clkload5/A _4905_/D _4905_/Q gf180mcu_as_sc_mcu7t3v3__dfxtp_2
XTAP_TAPCELL_ROW_160_1293 VDD VSS gf180mcu_as_sc_mcu7t3v3__tap_2
X_4836_ VDD VDD VSS VSS clkload6/A _4836_/D _4836_/Q gf180mcu_as_sc_mcu7t3v3__dfxtp_2
XFILLER_166_527 VDD VDD VSS VSS gf180mcu_as_sc_mcu7t3v3__fill_2
XFILLER_178_387 VDD VDD VSS VSS gf180mcu_as_sc_mcu7t3v3__fillcap_16
X_4767_ VDD VDD VSS VSS _5097_/CLK _4767_/D _4767_/Q gf180mcu_as_sc_mcu7t3v3__dfxtp_2
XFILLER_162_711 VDD VDD VSS VSS gf180mcu_as_sc_mcu7t3v3__fillcap_16
XFILLER_179_1262 VDD VDD VSS VSS gf180mcu_as_sc_mcu7t3v3__fillcap_16
X_4698_ VDD VDD VSS VSS _4700_/S _4698_/B _5255_/Q _4699_/A gf180mcu_as_sc_mcu7t3v3__mux2_2
X_3718_ VDD VDD VSS VSS _3722_/B _3718_/C _3792_/B _4094_/A gf180mcu_as_sc_mcu7t3v3__aoi21_2
XFILLER_174_593 VDD VDD VSS VSS gf180mcu_as_sc_mcu7t3v3__fill_2
X_3649_ VDD VDD VSS VSS _4024_/A _3649_/B _3649_/C _4024_/D _3650_/D gf180mcu_as_sc_mcu7t3v3__ao22_2
XFILLER_161_276 VDD VDD VSS VSS gf180mcu_as_sc_mcu7t3v3__fillcap_4
XFILLER_0_415 VDD VDD VSS VSS gf180mcu_as_sc_mcu7t3v3__fill_2
XFILLER_96_29 VDD VDD VSS VSS gf180mcu_as_sc_mcu7t3v3__fillcap_4
XFILLER_0_448 VDD VDD VSS VSS gf180mcu_as_sc_mcu7t3v3__fill_2
Xinput305 VDD VDD VSS VSS west_in[2] _3947_/D gf180mcu_as_sc_mcu7t3v3__buff_12
Xinput316 VDD VDD VSS VSS west_in[9] _4006_/A gf180mcu_as_sc_mcu7t3v3__buff_12
XTAP_TAPCELL_ROW_167_1425 VDD VSS gf180mcu_as_sc_mcu7t3v3__tap_2
XTAP_TAPCELL_ROW_167_1414 VDD VSS gf180mcu_as_sc_mcu7t3v3__tap_2
XTAP_TAPCELL_ROW_4_776 VDD VSS gf180mcu_as_sc_mcu7t3v3__tap_2
XTAP_TAPCELL_ROW_4_765 VDD VSS gf180mcu_as_sc_mcu7t3v3__tap_2
XTAP_TAPCELL_ROW_184_1750 VDD VSS gf180mcu_as_sc_mcu7t3v3__tap_2
XTAP_TAPCELL_ROW_180_1669 VDD VSS gf180mcu_as_sc_mcu7t3v3__tap_2
XTAP_TAPCELL_ROW_180_1658 VDD VSS gf180mcu_as_sc_mcu7t3v3__tap_2
XFILLER_186_1299 VDD VDD VSS VSS gf180mcu_as_sc_mcu7t3v3__fill_1
XFILLER_188_107 VDD VDD VSS VSS gf180mcu_as_sc_mcu7t3v3__fillcap_4
XFILLER_101_72 VDD VDD VSS VSS gf180mcu_as_sc_mcu7t3v3__fillcap_16
XFILLER_169_376 VDD VDD VSS VSS gf180mcu_as_sc_mcu7t3v3__fillcap_4
XFILLER_12_588 VDD VDD VSS VSS gf180mcu_as_sc_mcu7t3v3__fillcap_4
XFILLER_184_324 VDD VDD VSS VSS gf180mcu_as_sc_mcu7t3v3__fillcap_16
XFILLER_36_1291 VDD VDD VSS VSS gf180mcu_as_sc_mcu7t3v3__fillcap_16
XFILLER_123_1272 VDD VDD VSS VSS gf180mcu_as_sc_mcu7t3v3__fillcap_8
XFILLER_177_54 VDD VDD VSS VSS gf180mcu_as_sc_mcu7t3v3__fillcap_16
XANTENNA_9 VDD VDD VSS VSS _2627_/B gf180mcu_as_sc_mcu7t3v3__diode_2
XFILLER_6_27 VDD VDD VSS VSS gf180mcu_as_sc_mcu7t3v3__fillcap_8
XFILLER_4_765 VDD VDD VSS VSS gf180mcu_as_sc_mcu7t3v3__fillcap_16
XFILLER_152_298 VDD VDD VSS VSS gf180mcu_as_sc_mcu7t3v3__fill_1
XFILLER_6_1009 VDD VDD VSS VSS gf180mcu_as_sc_mcu7t3v3__fillcap_4
XFILLER_86_62 VDD VDD VSS VSS gf180mcu_as_sc_mcu7t3v3__fill_2
XTAP_TAPCELL_ROW_73_3_1984 VDD VSS gf180mcu_as_sc_mcu7t3v3__tap_2
X_4870__1097 VDD VDD VSS VSS _4870_/D gf180mcu_as_sc_mcu7t3v3__tiel_4
X_2951_ VDD VDD VSS VSS _2952_/C _3153_/A _2951_/B _2951_/C gf180mcu_as_sc_mcu7t3v3__ao21_2
XFILLER_163_1052 VDD VDD VSS VSS gf180mcu_as_sc_mcu7t3v3__fillcap_16
XFILLER_176_814 VDD VDD VSS VSS gf180mcu_as_sc_mcu7t3v3__fillcap_16
X_4621_ VDD VDD VSS VSS _5215_/Q _4621_/B _4621_/C _5216_/Q _5215_/D gf180mcu_as_sc_mcu7t3v3__ao22_2
X_2882_ VDD VDD VSS VSS _2882_/A _4769_/Q _2882_/C _2882_/D _4769_/D gf180mcu_as_sc_mcu7t3v3__ao22_2
XFILLER_175_346 VDD VDD VSS VSS gf180mcu_as_sc_mcu7t3v3__fillcap_4
XFILLER_175_368 VDD VDD VSS VSS gf180mcu_as_sc_mcu7t3v3__fillcap_16
XFILLER_184_891 VDD VDD VSS VSS gf180mcu_as_sc_mcu7t3v3__fill_1
XPHY_EDGE_ROW_103_3_Left_475 VDD VSS gf180mcu_as_sc_mcu7t3v3__tap_2
X_4552_ VDD VDD VSS VSS _4553_/C _4552_/C _5055_/Q _4557_/A gf180mcu_as_sc_mcu7t3v3__aoi21b_2
X_4483_ VDD VDD VSS VSS _4536_/S _5076_/Q _4989_/Q _4484_/A gf180mcu_as_sc_mcu7t3v3__mux2_2
X_3503_ VDD VDD VSS VSS _4159_/D _3503_/B _3513_/C _4163_/A _3504_/D gf180mcu_as_sc_mcu7t3v3__ao22_2
XFILLER_171_574 VDD VDD VSS VSS gf180mcu_as_sc_mcu7t3v3__fill_1
X_3434_ VDD VDD VSS VSS _4934_/Q _3456_/B _3501_/B _4087_/A _3435_/D gf180mcu_as_sc_mcu7t3v3__ao22_2
XTAP_TAPCELL_ROW_32_1_985 VDD VSS gf180mcu_as_sc_mcu7t3v3__tap_2
XPHY_EDGE_ROW_40_3_Left_412 VDD VSS gf180mcu_as_sc_mcu7t3v3__tap_2
XFILLER_170_1012 VDD VDD VSS VSS gf180mcu_as_sc_mcu7t3v3__fill_2
X_3365_ VDD VDD VSS VSS _3452_/S _4016_/D _3365_/A _3367_/B gf180mcu_as_sc_mcu7t3v3__mux2_2
X_5104_ VDD VDD VSS VSS _5188_/CLK _5104_/D _5104_/Q gf180mcu_as_sc_mcu7t3v3__dfxtp_2
X_3296_ VDD VDD VSS VSS _3944_/A _3424_/B _3296_/C _4806_/D _3580_/D gf180mcu_as_sc_mcu7t3v3__aoi211_2
XFILLER_170_1078 VDD VDD VSS VSS gf180mcu_as_sc_mcu7t3v3__fillcap_4
X_5035_ VDD VDD VSS VSS _5185_/CLK _5035_/D _5035_/Q gf180mcu_as_sc_mcu7t3v3__dfxtp_2
XTAP_TAPCELL_ROW_1_702 VDD VSS gf180mcu_as_sc_mcu7t3v3__tap_2
XPHY_EDGE_ROW_59_1_Right_568 VDD VSS gf180mcu_as_sc_mcu7t3v3__tap_2
XTAP_TAPCELL_ROW_1_713 VDD VSS gf180mcu_as_sc_mcu7t3v3__tap_2
XTAP_TAPCELL_ROW_162_1333 VDD VSS gf180mcu_as_sc_mcu7t3v3__tap_2
XTAP_TAPCELL_ROW_162_1322 VDD VSS gf180mcu_as_sc_mcu7t3v3__tap_2
XFILLER_0_1153 VDD VDD VSS VSS gf180mcu_as_sc_mcu7t3v3__fill_2
XFILLER_13_308 VDD VDD VSS VSS gf180mcu_as_sc_mcu7t3v3__fillcap_8
XFILLER_181_1130 VDD VDD VSS VSS gf180mcu_as_sc_mcu7t3v3__fill_2
XFILLER_146_1272 VDD VDD VSS VSS gf180mcu_as_sc_mcu7t3v3__fillcap_8
XFILLER_15_69 VDD VDD VSS VSS gf180mcu_as_sc_mcu7t3v3__fill_1
XFILLER_107_1256 VDD VDD VSS VSS gf180mcu_as_sc_mcu7t3v3__fillcap_4
XFILLER_166_324 VDD VDD VSS VSS gf180mcu_as_sc_mcu7t3v3__fillcap_4
XFILLER_167_858 VDD VDD VSS VSS gf180mcu_as_sc_mcu7t3v3__fillcap_8
XFILLER_181_1196 VDD VDD VSS VSS gf180mcu_as_sc_mcu7t3v3__fill_2
XFILLER_166_346 VDD VDD VSS VSS gf180mcu_as_sc_mcu7t3v3__fill_2
XFILLER_182_817 VDD VDD VSS VSS gf180mcu_as_sc_mcu7t3v3__fillcap_8
X_4819_ VDD VDD VSS VSS clkload7/A _4819_/D _4819_/Q gf180mcu_as_sc_mcu7t3v3__dfxtp_2
XFILLER_179_1070 VDD VDD VSS VSS gf180mcu_as_sc_mcu7t3v3__fill_1
XFILLER_181_349 VDD VDD VSS VSS gf180mcu_as_sc_mcu7t3v3__fill_1
XPHY_EDGE_ROW_96_1_Left_288 VDD VSS gf180mcu_as_sc_mcu7t3v3__tap_2
XFILLER_147_79 VDD VDD VSS VSS gf180mcu_as_sc_mcu7t3v3__fillcap_4
XFILLER_162_552 VDD VDD VSS VSS gf180mcu_as_sc_mcu7t3v3__fillcap_4
XFILLER_1_702 VDD VDD VSS VSS gf180mcu_as_sc_mcu7t3v3__fill_1
XFILLER_0_201 VDD VDD VSS VSS gf180mcu_as_sc_mcu7t3v3__fill_2
XFILLER_0_212 VDD VDD VSS VSS gf180mcu_as_sc_mcu7t3v3__fill_1
XTAP_TAPCELL_ROW_9_868 VDD VSS gf180mcu_as_sc_mcu7t3v3__tap_2
XTAP_TAPCELL_ROW_9_857 VDD VSS gf180mcu_as_sc_mcu7t3v3__tap_2
XTAP_TAPCELL_ROW_106_1_1059 VDD VSS gf180mcu_as_sc_mcu7t3v3__tap_2
Xinput102 VDD VDD VSS VSS ne_in[31] _3512_/A gf180mcu_as_sc_mcu7t3v3__buff_12
XFILLER_153_1276 VDD VDD VSS VSS gf180mcu_as_sc_mcu7t3v3__fill_1
XFILLER_163_89 VDD VDD VSS VSS gf180mcu_as_sc_mcu7t3v3__fill_1
XFILLER_7_1329 VDD VDD VSS VSS gf180mcu_as_sc_mcu7t3v3__fill_1
Xinput113 VDD VDD VSS VSS north_in[10] _4014_/A gf180mcu_as_sc_mcu7t3v3__buff_12
Xinput124 VDD VDD VSS VSS north_in[20] _4095_/A gf180mcu_as_sc_mcu7t3v3__buff_12
Xinput135 VDD VDD VSS VSS north_in[30] _3535_/A gf180mcu_as_sc_mcu7t3v3__buff_12
Xinput146 VDD VDD VSS VSS nw_in[0] _3926_/A gf180mcu_as_sc_mcu7t3v3__buff_12
Xinput157 VDD VDD VSS VSS nw_in[1] _3939_/A gf180mcu_as_sc_mcu7t3v3__buff_12
Xinput168 VDD VDD VSS VSS nw_in[2] _3948_/A gf180mcu_as_sc_mcu7t3v3__buff_12
XTAP_TAPCELL_ROW_182_1709 VDD VSS gf180mcu_as_sc_mcu7t3v3__tap_2
Xclkbuf_3_0__f_clk_regs VDD VDD VSS VSS clkbuf_2_0_0_clk_regs/Y clkbuf_leaf_6_clk_regs/A
+ gf180mcu_as_sc_mcu7t3v3__clkbuff_12
Xinput179 VDD VDD VSS VSS nw_in[9] _4008_/A gf180mcu_as_sc_mcu7t3v3__buff_12
XFILLER_158_803 VDD VDD VSS VSS gf180mcu_as_sc_mcu7t3v3__fill_2
XFILLER_188_53 VDD VDD VSS VSS gf180mcu_as_sc_mcu7t3v3__fillcap_16
XFILLER_13_886 VDD VDD VSS VSS gf180mcu_as_sc_mcu7t3v3__fillcap_16
XFILLER_157_335 VDD VDD VSS VSS gf180mcu_as_sc_mcu7t3v3__fillcap_8
XFILLER_8_323 VDD VDD VSS VSS gf180mcu_as_sc_mcu7t3v3__fill_1
XFILLER_9_846 VDD VDD VSS VSS gf180mcu_as_sc_mcu7t3v3__fill_2
XFILLER_185_699 VDD VDD VSS VSS gf180mcu_as_sc_mcu7t3v3__fill_1
XFILLER_158_1165 VDD VDD VSS VSS gf180mcu_as_sc_mcu7t3v3__fillcap_4
XFILLER_181_850 VDD VDD VSS VSS gf180mcu_as_sc_mcu7t3v3__fillcap_4
XFILLER_171_1332 VDD VDD VSS VSS gf180mcu_as_sc_mcu7t3v3__fillcap_16
XFILLER_97_72 VDD VDD VSS VSS gf180mcu_as_sc_mcu7t3v3__fillcap_16
XFILLER_171_1354 VDD VDD VSS VSS gf180mcu_as_sc_mcu7t3v3__fill_1
X_3150_ VDD VDD VSS VSS _4127_/A _3240_/B _3239_/A _4126_/A _3156_/B gf180mcu_as_sc_mcu7t3v3__ao22_2
X_3081_ VDD VDD VSS VSS _3684_/A _3131_/A _3081_/C _4786_/D _3676_/D gf180mcu_as_sc_mcu7t3v3__aoi211_2
XTAP_TAPCELL_ROW_21_3_1932 VDD VSS gf180mcu_as_sc_mcu7t3v3__tap_2
Xclkbuf_leaf_26_clk_regs VDD VDD VSS VSS clkbuf_3_5__f_clk_regs/Y _5275_/CLK gf180mcu_as_sc_mcu7t3v3__clkbuff_12
X_3983_ VDD VDD VSS VSS _3983_/A _4024_/B _3983_/C _3983_/D _3985_/C gf180mcu_as_sc_mcu7t3v3__ao211_2
XFILLER_176_622 VDD VDD VSS VSS gf180mcu_as_sc_mcu7t3v3__fill_1
XFILLER_188_493 VDD VDD VSS VSS gf180mcu_as_sc_mcu7t3v3__fill_1
X_2934_ VDD VDD VSS VSS _3793_/A _3802_/A _3559_/A gf180mcu_as_sc_mcu7t3v3__or2_2
X_2865_ VDD VDD VSS VSS _2865_/B _4764_/Q _2866_/C gf180mcu_as_sc_mcu7t3v3__xnor2_2
XFILLER_11_1014 VDD VDD VSS VSS gf180mcu_as_sc_mcu7t3v3__fillcap_8
XFILLER_157_880 VDD VDD VSS VSS gf180mcu_as_sc_mcu7t3v3__fillcap_16
XFILLER_164_839 VDD VDD VSS VSS gf180mcu_as_sc_mcu7t3v3__fill_2
X_4604_ VDD VDD VSS VSS _5198_/Q _4609_/B _4609_/C _5199_/Q _5198_/D gf180mcu_as_sc_mcu7t3v3__ao22_2
XPHY_EDGE_ROW_154_Left_346 VDD VSS gf180mcu_as_sc_mcu7t3v3__tap_2
XFILLER_89_1262 VDD VDD VSS VSS gf180mcu_as_sc_mcu7t3v3__fill_1
X_4535_ VDD VDD VSS VSS _4538_/C _4535_/C _5053_/Q _4536_/S gf180mcu_as_sc_mcu7t3v3__aoi21b_2
X_2796_ VDD VDD VSS VSS _2845_/A _2796_/B _2796_/C _2796_/D _2797_/D gf180mcu_as_sc_mcu7t3v3__ao211_2
XFILLER_11_1058 VDD VDD VSS VSS gf180mcu_as_sc_mcu7t3v3__fillcap_8
XFILLER_172_850 VDD VDD VSS VSS gf180mcu_as_sc_mcu7t3v3__fillcap_4
XFILLER_176_1243 VDD VDD VSS VSS gf180mcu_as_sc_mcu7t3v3__fillcap_4
XFILLER_190_146 VDD VDD VSS VSS gf180mcu_as_sc_mcu7t3v3__fill_2
XFILLER_89_1295 VDD VDD VSS VSS gf180mcu_as_sc_mcu7t3v3__fillcap_4
XTAP_TAPCELL_ROW_155_1192 VDD VSS gf180mcu_as_sc_mcu7t3v3__tap_2
XFILLER_117_38 VDD VDD VSS VSS gf180mcu_as_sc_mcu7t3v3__fillcap_4
X_4466_ VDD VDD VSS VSS _4469_/C _4466_/B _4582_/A gf180mcu_as_sc_mcu7t3v3__nor2_2
Xfanout803 VDD VDD VSS VSS _2815_/A _2833_/A gf180mcu_as_sc_mcu7t3v3__buff_12
Xfanout814 VDD VDD VSS VSS _4264_/A _2731_/S gf180mcu_as_sc_mcu7t3v3__buff_12
Xfanout825 VDD VDD VSS VSS _4500_/S _4536_/S gf180mcu_as_sc_mcu7t3v3__buff_12
X_4397_ VDD VDD VSS VSS _4397_/B _4541_/A _4398_/D gf180mcu_as_sc_mcu7t3v3__and2_2
X_3417_ VDD VDD VSS VSS _4932_/Q _3456_/B _3501_/B _4071_/A _3418_/C gf180mcu_as_sc_mcu7t3v3__ao22_2
XTAP_TAPCELL_ROW_6_805 VDD VSS gf180mcu_as_sc_mcu7t3v3__tap_2
Xfanout836 VDD VDD VSS VSS fanout837/Y _4586_/S gf180mcu_as_sc_mcu7t3v3__buff_12
Xfanout847 VDD VDD VSS VSS _3795_/A _3907_/A gf180mcu_as_sc_mcu7t3v3__buff_12
X_3348_ VDD VDD VSS VSS _3349_/A _3997_/D _3500_/B _3348_/C gf180mcu_as_sc_mcu7t3v3__ao21_2
Xfanout869 VDD VDD VSS VSS _2730_/A _2832_/S gf180mcu_as_sc_mcu7t3v3__buff_12
XPHY_EDGE_ROW_163_Left_355 VDD VSS gf180mcu_as_sc_mcu7t3v3__tap_2
X_3279_ VDD VDD VSS VSS _3502_/B _3925_/A _3279_/A _3288_/A gf180mcu_as_sc_mcu7t3v3__mux2_2
X_5018_ VDD VDD VSS VSS clkload2/A _5018_/D _5018_/Q gf180mcu_as_sc_mcu7t3v3__dfxtp_2
XFILLER_13_138 VDD VDD VSS VSS gf180mcu_as_sc_mcu7t3v3__fillcap_16
XFILLER_183_1258 VDD VDD VSS VSS gf180mcu_as_sc_mcu7t3v3__fill_2
XFILLER_186_419 VDD VDD VSS VSS gf180mcu_as_sc_mcu7t3v3__fillcap_8
XFILLER_179_482 VDD VDD VSS VSS gf180mcu_as_sc_mcu7t3v3__fillcap_8
XTAP_TAPCELL_ROW_125_3_2036 VDD VSS gf180mcu_as_sc_mcu7t3v3__tap_2
XFILLER_158_34 VDD VDD VSS VSS gf180mcu_as_sc_mcu7t3v3__fill_1
XFILLER_158_45 VDD VDD VSS VSS gf180mcu_as_sc_mcu7t3v3__fillcap_8
XFILLER_167_655 VDD VDD VSS VSS gf180mcu_as_sc_mcu7t3v3__fill_1
XPHY_EDGE_ROW_172_Left_364 VDD VSS gf180mcu_as_sc_mcu7t3v3__tap_2
XFILLER_166_165 VDD VDD VSS VSS gf180mcu_as_sc_mcu7t3v3__fill_1
XFILLER_167_699 VDD VDD VSS VSS gf180mcu_as_sc_mcu7t3v3__fill_1
XTAP_TAPCELL_ROW_175_1579 VDD VSS gf180mcu_as_sc_mcu7t3v3__tap_2
XTAP_TAPCELL_ROW_175_1568 VDD VSS gf180mcu_as_sc_mcu7t3v3__tap_2
XTAP_TAPCELL_ROW_192_1893 VDD VSS gf180mcu_as_sc_mcu7t3v3__tap_2
XFILLER_174_22 VDD VDD VSS VSS gf180mcu_as_sc_mcu7t3v3__fillcap_8
XFILLER_182_669 VDD VDD VSS VSS gf180mcu_as_sc_mcu7t3v3__fill_1
XFILLER_29_1319 VDD VDD VSS VSS gf180mcu_as_sc_mcu7t3v3__fillcap_4
XPHY_EDGE_ROW_181_Left_373 VDD VSS gf180mcu_as_sc_mcu7t3v3__tap_2
XFILLER_190_32 VDD VDD VSS VSS gf180mcu_as_sc_mcu7t3v3__fill_2
XFILLER_7_1148 VDD VDD VSS VSS gf180mcu_as_sc_mcu7t3v3__fillcap_4
XFILLER_189_224 VDD VDD VSS VSS gf180mcu_as_sc_mcu7t3v3__fillcap_4
XTAP_TAPCELL_ROW_31_1_984 VDD VSS gf180mcu_as_sc_mcu7t3v3__tap_2
XPHY_EDGE_ROW_190_Left_382 VDD VSS gf180mcu_as_sc_mcu7t3v3__tap_2
XFILLER_12_171 VDD VDD VSS VSS gf180mcu_as_sc_mcu7t3v3__fillcap_4
XFILLER_8_120 VDD VDD VSS VSS gf180mcu_as_sc_mcu7t3v3__fill_2
XFILLER_9_621 VDD VDD VSS VSS gf180mcu_as_sc_mcu7t3v3__fill_2
XFILLER_172_102 VDD VDD VSS VSS gf180mcu_as_sc_mcu7t3v3__fill_2
XFILLER_173_614 VDD VDD VSS VSS gf180mcu_as_sc_mcu7t3v3__fillcap_4
XFILLER_9_687 VDD VDD VSS VSS gf180mcu_as_sc_mcu7t3v3__fill_1
X_2650_ VDD VDD VSS VSS _2650_/Y _2832_/S _2650_/B _2650_/C _2650_/D gf180mcu_as_sc_mcu7t3v3__aoi22_2
XFILLER_172_124 VDD VDD VSS VSS gf180mcu_as_sc_mcu7t3v3__fill_1
Xoutput417 VDD VDD VSS VSS _4836_/Q south_out[31] gf180mcu_as_sc_mcu7t3v3__buff_12
Xoutput406 VDD VDD VSS VSS _4826_/Q south_out[21] gf180mcu_as_sc_mcu7t3v3__buff_12
X_2581_ VDD VDD VSS VSS _2581_/A _2858_/B _2674_/C _2581_/D _2581_/Y gf180mcu_as_sc_mcu7t3v3__ao211_2
XTAP_TAPCELL_ROW_11_895 VDD VSS gf180mcu_as_sc_mcu7t3v3__tap_2
Xoutput439 VDD VDD VSS VSS _4893_/Q west_out[20] gf180mcu_as_sc_mcu7t3v3__buff_12
Xoutput428 VDD VDD VSS VSS _4883_/Q west_out[10] gf180mcu_as_sc_mcu7t3v3__buff_12
X_4320_ VDD VDD VSS VSS _4325_/S _5150_/Q _5149_/Q _5149_/D gf180mcu_as_sc_mcu7t3v3__mux2_2
X_4251_ VDD VDD VSS VSS _4256_/S _4251_/B _5087_/Q _5087_/D gf180mcu_as_sc_mcu7t3v3__mux2_2
X_3202_ VDD VDD VSS VSS _3210_/B _3202_/B _3790_/A gf180mcu_as_sc_mcu7t3v3__nand2_2
XFILLER_171_1162 VDD VDD VSS VSS gf180mcu_as_sc_mcu7t3v3__fill_1
X_4182_ VDD VDD VSS VSS _4242_/B _4186_/B _4186_/C _5020_/Q _5020_/D gf180mcu_as_sc_mcu7t3v3__ao22_2
X_3133_ VDD VDD VSS VSS _3140_/B _3207_/S _4114_/A gf180mcu_as_sc_mcu7t3v3__nand2_2
X_3064_ VDD VDD VSS VSS _3065_/B _3064_/B _3064_/C _3065_/C gf180mcu_as_sc_mcu7t3v3__nor3_2
XFILLER_168_408 VDD VDD VSS VSS gf180mcu_as_sc_mcu7t3v3__fillcap_4
XFILLER_182_1280 VDD VDD VSS VSS gf180mcu_as_sc_mcu7t3v3__fillcap_4
X_3966_ VDD VDD VSS VSS _3966_/A _4022_/B _4027_/B _3966_/D _3970_/A gf180mcu_as_sc_mcu7t3v3__ao211_2
XFILLER_177_964 VDD VDD VSS VSS gf180mcu_as_sc_mcu7t3v3__fillcap_4
XFILLER_17_1256 VDD VDD VSS VSS gf180mcu_as_sc_mcu7t3v3__fillcap_4
X_2917_ VDD VDD VSS VSS _2930_/A _3233_/C _3236_/B gf180mcu_as_sc_mcu7t3v3__nand2_2
XTAP_TAPCELL_ROW_157_1232 VDD VSS gf180mcu_as_sc_mcu7t3v3__tap_2
XTAP_TAPCELL_ROW_157_1221 VDD VSS gf180mcu_as_sc_mcu7t3v3__tap_2
XFILLER_178_1305 VDD VDD VSS VSS gf180mcu_as_sc_mcu7t3v3__fillcap_16
X_3897_ VDD VDD VSS VSS _3897_/B _5187_/Q _4937_/D gf180mcu_as_sc_mcu7t3v3__and2_2
XFILLER_128_37 VDD VDD VSS VSS gf180mcu_as_sc_mcu7t3v3__fill_1
XFILLER_12_48 VDD VDD VSS VSS gf180mcu_as_sc_mcu7t3v3__fillcap_8
XFILLER_191_422 VDD VDD VSS VSS gf180mcu_as_sc_mcu7t3v3__fillcap_16
XFILLER_192_945 VDD VDD VSS VSS gf180mcu_as_sc_mcu7t3v3__fillcap_4
X_2848_ VDD VDD VSS VSS _4948_/Q _3872_/A _3868_/C gf180mcu_as_sc_mcu7t3v3__and2_2
X_2779_ VDD VDD VSS VSS _5269_/Q _5275_/Q _4734_/B gf180mcu_as_sc_mcu7t3v3__or2_2
XFILLER_163_179 VDD VDD VSS VSS gf180mcu_as_sc_mcu7t3v3__fillcap_16
X_4518_ VDD VDD VSS VSS _4525_/A _5022_/Q _5051_/Q _4519_/B gf180mcu_as_sc_mcu7t3v3__mux2_2
XTAP_TAPCELL_ROW_170_1476 VDD VSS gf180mcu_as_sc_mcu7t3v3__tap_2
X_4449_ VDD VDD VSS VSS _4449_/D _4581_/A _4449_/B _4449_/C _4450_/B gf180mcu_as_sc_mcu7t3v3__ao31_2
Xfanout600 VDD VDD VSS VSS _3885_/B _3897_/B gf180mcu_as_sc_mcu7t3v3__buff_12
Xfanout611 VDD VDD VSS VSS _2928_/Y _3240_/B gf180mcu_as_sc_mcu7t3v3__buff_12
Xfanout622 VDD VDD VSS VSS _4264_/B _2734_/S gf180mcu_as_sc_mcu7t3v3__buff_12
Xfanout633 VDD VDD VSS VSS fanout634/A _4160_/B gf180mcu_as_sc_mcu7t3v3__buff_12
XFILLER_115_1322 VDD VDD VSS VSS gf180mcu_as_sc_mcu7t3v3__fill_2
Xfanout644 VDD VDD VSS VSS wire645/Y _3773_/B gf180mcu_as_sc_mcu7t3v3__buff_12
Xfanout666 VDD VDD VSS VSS _3125_/C _3042_/C gf180mcu_as_sc_mcu7t3v3__buff_12
XPHY_EDGE_ROW_127_1_Left_319 VDD VSS gf180mcu_as_sc_mcu7t3v3__tap_2
Xfanout677 VDD VDD VSS VSS _4621_/C _4617_/C gf180mcu_as_sc_mcu7t3v3__buff_12
Xfanout688 VDD VDD VSS VSS _3931_/Y _4159_/B gf180mcu_as_sc_mcu7t3v3__buff_12
Xfanout699 VDD VDD VSS VSS wire700/Y _3494_/C gf180mcu_as_sc_mcu7t3v3__buff_12
XFILLER_2_1023 VDD VDD VSS VSS gf180mcu_as_sc_mcu7t3v3__fill_1
XPHY_EDGE_ROW_128_3_Left_500 VDD VSS gf180mcu_as_sc_mcu7t3v3__tap_2
XFILLER_160_79 VDD VDD VSS VSS gf180mcu_as_sc_mcu7t3v3__fill_1
XFILLER_187_1180 VDD VDD VSS VSS gf180mcu_as_sc_mcu7t3v3__fillcap_8
XFILLER_183_1044 VDD VDD VSS VSS gf180mcu_as_sc_mcu7t3v3__fillcap_4
XFILLER_159_419 VDD VDD VSS VSS gf180mcu_as_sc_mcu7t3v3__fill_1
XFILLER_169_22 VDD VDD VSS VSS gf180mcu_as_sc_mcu7t3v3__fillcap_16
XTAP_TAPCELL_ROW_177_1608 VDD VSS gf180mcu_as_sc_mcu7t3v3__tap_2
XFILLER_169_88 VDD VDD VSS VSS gf180mcu_as_sc_mcu7t3v3__fill_1
XFILLER_183_923 VDD VDD VSS VSS gf180mcu_as_sc_mcu7t3v3__fillcap_8
XFILLER_167_485 VDD VDD VSS VSS gf180mcu_as_sc_mcu7t3v3__fillcap_4
XFILLER_155_669 VDD VDD VSS VSS gf180mcu_as_sc_mcu7t3v3__fill_2
XFILLER_183_978 VDD VDD VSS VSS gf180mcu_as_sc_mcu7t3v3__fill_2
XFILLER_182_499 VDD VDD VSS VSS gf180mcu_as_sc_mcu7t3v3__fill_1
XFILLER_78_41 VDD VDD VSS VSS gf180mcu_as_sc_mcu7t3v3__fill_2
XFILLER_2_874 VDD VDD VSS VSS gf180mcu_as_sc_mcu7t3v3__fill_1
XFILLER_2_885 VDD VDD VSS VSS gf180mcu_as_sc_mcu7t3v3__fill_1
Xmesh_tile_1010 VDD VDD VSS VSS nw_out[16] gf180mcu_as_sc_mcu7t3v3__tiel_4
Xmesh_tile_1043 VDD VDD VSS VSS sw_out[15] gf180mcu_as_sc_mcu7t3v3__tiel_4
Xmesh_tile_1032 VDD VDD VSS VSS sw_out[4] gf180mcu_as_sc_mcu7t3v3__tiel_4
Xmesh_tile_1021 VDD VDD VSS VSS nw_out[27] gf180mcu_as_sc_mcu7t3v3__tiel_4
Xmesh_tile_1054 VDD VDD VSS VSS sw_out[26] gf180mcu_as_sc_mcu7t3v3__tiel_4
XFILLER_166_1231 VDD VDD VSS VSS gf180mcu_as_sc_mcu7t3v3__fill_2
XFILLER_79_1272 VDD VDD VSS VSS gf180mcu_as_sc_mcu7t3v3__fill_1
XPHY_EDGE_ROW_112_3_Left_484 VDD VSS gf180mcu_as_sc_mcu7t3v3__tap_2
XFILLER_166_1297 VDD VDD VSS VSS gf180mcu_as_sc_mcu7t3v3__fillcap_4
X_3820_ VDD VDD VSS VSS _3821_/C _3820_/B _3915_/A gf180mcu_as_sc_mcu7t3v3__nor2_2
X_3751_ VDD VDD VSS VSS _4126_/D _3773_/B _3751_/C _3751_/D _3752_/D gf180mcu_as_sc_mcu7t3v3__ao211_2
XFILLER_159_986 VDD VDD VSS VSS gf180mcu_as_sc_mcu7t3v3__fill_1
XFILLER_9_462 VDD VDD VSS VSS gf180mcu_as_sc_mcu7t3v3__fill_2
X_2702_ VDD VDD VSS VSS _2730_/A _2702_/B _2702_/A _2702_/Y gf180mcu_as_sc_mcu7t3v3__mux2_2
XFILLER_145_102 VDD VDD VSS VSS gf180mcu_as_sc_mcu7t3v3__fill_2
XFILLER_173_422 VDD VDD VSS VSS gf180mcu_as_sc_mcu7t3v3__fillcap_16
XFILLER_185_282 VDD VDD VSS VSS gf180mcu_as_sc_mcu7t3v3__fillcap_16
X_3682_ VDD VDD VSS VSS _3683_/C _3682_/C _3729_/B _4057_/A gf180mcu_as_sc_mcu7t3v3__aoi21_2
XFILLER_103_1281 VDD VDD VSS VSS gf180mcu_as_sc_mcu7t3v3__fillcap_16
XFILLER_12_1164 VDD VDD VSS VSS gf180mcu_as_sc_mcu7t3v3__fillcap_8
XFILLER_64_2 VDD VDD VSS VSS gf180mcu_as_sc_mcu7t3v3__fill_2
X_2633_ VDD VDD VSS VSS _4646_/C _5232_/Q _5229_/Q _2776_/A _2634_/C gf180mcu_as_sc_mcu7t3v3__ao31_2
X_2564_ VDD VDD VSS VSS _2564_/Y _2565_/B _2565_/A gf180mcu_as_sc_mcu7t3v3__nor2_2
XTAP_TAPCELL_ROW_152_1140 VDD VSS gf180mcu_as_sc_mcu7t3v3__tap_2
XFILLER_86_1287 VDD VDD VSS VSS gf180mcu_as_sc_mcu7t3v3__fill_2
X_4303_ VDD VDD VSS VSS _4326_/S _5133_/Q _5132_/Q _5132_/D gf180mcu_as_sc_mcu7t3v3__mux2_2
X_5283_ VDD VDD VSS VSS _5285_/CLK _5283_/D _5283_/Q gf180mcu_as_sc_mcu7t3v3__dfxtp_2
X_2495_ VDD VDD VSS VSS _4954_/D _4594_/A _2495_/A gf180mcu_as_sc_mcu7t3v3__nor2b_2
X_4234_ VDD VDD VSS VSS _4257_/S _4234_/B _5070_/Q _5070_/D gf180mcu_as_sc_mcu7t3v3__mux2_2
X_4165_ VDD VDD VSS VSS _4165_/B _4165_/A _4257_/B gf180mcu_as_sc_mcu7t3v3__and2_2
X_3116_ VDD VDD VSS VSS _4790_/D _3116_/C _3148_/A _4091_/A gf180mcu_as_sc_mcu7t3v3__aoi21_2
XFILLER_3_1354 VDD VDD VSS VSS gf180mcu_as_sc_mcu7t3v3__fill_1
X_4096_ VDD VDD VSS VSS _4096_/A _4159_/B _4159_/C _4096_/D _4097_/D gf180mcu_as_sc_mcu7t3v3__ao22_2
XFILLER_130_27 VDD VDD VSS VSS gf180mcu_as_sc_mcu7t3v3__fill_1
X_3047_ VDD VDD VSS VSS _4025_/A _3047_/B _3047_/C _3047_/D _3048_/C gf180mcu_as_sc_mcu7t3v3__ao22_2
XFILLER_145_1326 VDD VDD VSS VSS gf180mcu_as_sc_mcu7t3v3__fillcap_4
XFILLER_168_216 VDD VDD VSS VSS gf180mcu_as_sc_mcu7t3v3__fillcap_8
X_4998_ VDD VDD VSS VSS _5178_/CLK _4998_/D _4998_/Q gf180mcu_as_sc_mcu7t3v3__dfxtp_2
XFILLER_177_772 VDD VDD VSS VSS gf180mcu_as_sc_mcu7t3v3__fillcap_16
X_3949_ VDD VDD VSS VSS _4024_/C _3949_/A _3951_/C gf180mcu_as_sc_mcu7t3v3__and2_2
XTAP_TAPCELL_ROW_172_1516 VDD VSS gf180mcu_as_sc_mcu7t3v3__tap_2
XTAP_TAPCELL_ROW_172_1505 VDD VSS gf180mcu_as_sc_mcu7t3v3__tap_2
XFILLER_180_915 VDD VDD VSS VSS gf180mcu_as_sc_mcu7t3v3__fill_1
XFILLER_192_775 VDD VDD VSS VSS gf180mcu_as_sc_mcu7t3v3__fillcap_4
XFILLER_178_1157 VDD VDD VSS VSS gf180mcu_as_sc_mcu7t3v3__fillcap_8
XFILLER_152_1308 VDD VDD VSS VSS gf180mcu_as_sc_mcu7t3v3__fill_1
XTAP_TAPCELL_ROW_30_1_983 VDD VSS gf180mcu_as_sc_mcu7t3v3__tap_2
Xfanout474 VDD VDD VSS VSS _4199_/Y _4228_/C gf180mcu_as_sc_mcu7t3v3__buff_12
XTAP_TAPCELL_ROW_187_1792 VDD VSS gf180mcu_as_sc_mcu7t3v3__tap_2
Xfanout496 VDD VDD VSS VSS _4228_/B _4227_/B gf180mcu_as_sc_mcu7t3v3__buff_12
XFILLER_104_94 VDD VDD VSS VSS gf180mcu_as_sc_mcu7t3v3__fillcap_8
XFILLER_9_27 VDD VDD VSS VSS gf180mcu_as_sc_mcu7t3v3__fillcap_8
XTAP_TAPCELL_ROW_13_935 VDD VSS gf180mcu_as_sc_mcu7t3v3__tap_2
XFILLER_156_901 VDD VDD VSS VSS gf180mcu_as_sc_mcu7t3v3__fill_2
XTAP_TAPCELL_ROW_13_957 VDD VSS gf180mcu_as_sc_mcu7t3v3__tap_2
XTAP_TAPCELL_ROW_13_946 VDD VSS gf180mcu_as_sc_mcu7t3v3__tap_2
XFILLER_11_962 VDD VDD VSS VSS gf180mcu_as_sc_mcu7t3v3__fillcap_4
XFILLER_155_422 VDD VDD VSS VSS gf180mcu_as_sc_mcu7t3v3__fill_2
XFILLER_167_271 VDD VDD VSS VSS gf180mcu_as_sc_mcu7t3v3__fill_2
XFILLER_167_282 VDD VDD VSS VSS gf180mcu_as_sc_mcu7t3v3__fillcap_4
XFILLER_168_783 VDD VDD VSS VSS gf180mcu_as_sc_mcu7t3v3__fill_1
Xwire853 VDD VDD VSS VSS wire853/A _4000_/A gf180mcu_as_sc_mcu7t3v3__clkbuff_12
Xwire864 VDD VDD VSS VSS wire864/A _4080_/A gf180mcu_as_sc_mcu7t3v3__clkbuff_12
Xwire875 VDD VDD VSS VSS wire875/A _3985_/A gf180mcu_as_sc_mcu7t3v3__clkbuff_12
XFILLER_182_285 VDD VDD VSS VSS gf180mcu_as_sc_mcu7t3v3__fill_1
XFILLER_7_988 VDD VDD VSS VSS gf180mcu_as_sc_mcu7t3v3__fill_1
XFILLER_170_436 VDD VDD VSS VSS gf180mcu_as_sc_mcu7t3v3__fill_1
XFILLER_133_1296 VDD VDD VSS VSS gf180mcu_as_sc_mcu7t3v3__fill_1
X_4921_ VDD VDD VSS VSS _5075_/CLK _4921_/D _4921_/Q gf180mcu_as_sc_mcu7t3v3__dfxtp_2
X_4852_ VDD VDD VSS VSS _5150_/CLK _4852_/D _4852_/Q gf180mcu_as_sc_mcu7t3v3__dfxtp_2
X_3803_ VDD VDD VSS VSS _3804_/B _3803_/C _3803_/B _3803_/A gf180mcu_as_sc_mcu7t3v3__aoi21b_2
XFILLER_159_772 VDD VDD VSS VSS gf180mcu_as_sc_mcu7t3v3__fillcap_4
XFILLER_92_1291 VDD VDD VSS VSS gf180mcu_as_sc_mcu7t3v3__fillcap_8
X_4783_ VDD VDD VSS VSS _5212_/CLK _4783_/D _4783_/Q gf180mcu_as_sc_mcu7t3v3__dfxtp_2
XFILLER_158_282 VDD VDD VSS VSS gf180mcu_as_sc_mcu7t3v3__fill_2
XFILLER_88_1305 VDD VDD VSS VSS gf180mcu_as_sc_mcu7t3v3__fill_2
X_3734_ VDD VDD VSS VSS _3738_/B _3734_/C _3792_/B _4110_/A gf180mcu_as_sc_mcu7t3v3__aoi21_2
XTAP_TAPCELL_ROW_63_1_1016 VDD VSS gf180mcu_as_sc_mcu7t3v3__tap_2
XFILLER_140_1256 VDD VDD VSS VSS gf180mcu_as_sc_mcu7t3v3__fillcap_16
X_3665_ VDD VDD VSS VSS _4928_/Q _3727_/B _3727_/C _4040_/D _3666_/D gf180mcu_as_sc_mcu7t3v3__ao22_2
XFILLER_162_926 VDD VDD VSS VSS gf180mcu_as_sc_mcu7t3v3__fillcap_16
X_2616_ VDD VDD VSS VSS _4628_/S _2883_/B _2634_/B gf180mcu_as_sc_mcu7t3v3__and2_2
X_3596_ VDD VDD VSS VSS _3968_/A _3649_/B _3649_/C _3968_/D _3597_/D gf180mcu_as_sc_mcu7t3v3__ao22_2
XFILLER_170_981 VDD VDD VSS VSS gf180mcu_as_sc_mcu7t3v3__fillcap_4
X_2547_ VDD VDD VSS VSS _4955_/D _2547_/B _4594_/A gf180mcu_as_sc_mcu7t3v3__nor2_2
X_5266_ VDD VDD VSS VSS _5266_/CLK _5266_/D _5266_/Q gf180mcu_as_sc_mcu7t3v3__dfxtp_2
X_2478_ VDD VDD VSS VSS _4947_/Q _2478_/B _2478_/A _5478_/A gf180mcu_as_sc_mcu7t3v3__mux2_2
X_4217_ VDD VDD VSS VSS _4246_/B _4217_/B _4218_/C _5053_/Q _5053_/D gf180mcu_as_sc_mcu7t3v3__ao22_2
X_5197_ VDD VDD VSS VSS _5203_/CLK _5197_/D _5197_/Q gf180mcu_as_sc_mcu7t3v3__dfxtp_2
X_4148_ VDD VDD VSS VSS _4156_/S _4148_/B _4148_/A _4149_/B gf180mcu_as_sc_mcu7t3v3__mux2_2
XTAP_TAPCELL_ROW_165_1375 VDD VSS gf180mcu_as_sc_mcu7t3v3__tap_2
XFILLER_141_48 VDD VDD VSS VSS gf180mcu_as_sc_mcu7t3v3__fillcap_16
X_4079_ VDD VDD VSS VSS _4079_/A _4160_/C _4129_/C _4933_/Q _4081_/C gf180mcu_as_sc_mcu7t3v3__ao22_2
XTAP_TAPCELL_ROW_165_1386 VDD VSS gf180mcu_as_sc_mcu7t3v3__tap_2
XFILLER_34_79 VDD VDD VSS VSS gf180mcu_as_sc_mcu7t3v3__fill_1
Xsram2048.u_bank0_913 VDD VDD VSS VSS sram2048.u_bank0/WEN[2] gf180mcu_as_sc_mcu7t3v3__tiel_4
XFILLER_156_208 VDD VDD VSS VSS gf180mcu_as_sc_mcu7t3v3__fillcap_4
Xclkload1 VDD VDD VSS VSS clkload1/Y clkload1/A gf180mcu_as_sc_mcu7t3v3__inv_4
XFILLER_192_550 VDD VDD VSS VSS gf180mcu_as_sc_mcu7t3v3__fill_2
XFILLER_152_414 VDD VDD VSS VSS gf180mcu_as_sc_mcu7t3v3__fill_2
XFILLER_180_734 VDD VDD VSS VSS gf180mcu_as_sc_mcu7t3v3__fill_1
XFILLER_192_561 VDD VDD VSS VSS gf180mcu_as_sc_mcu7t3v3__fill_2
XFILLER_50_78 VDD VDD VSS VSS gf180mcu_as_sc_mcu7t3v3__fill_2
XTAP_TAPCELL_ROW_189_1843 VDD VSS gf180mcu_as_sc_mcu7t3v3__tap_2
XTAP_TAPCELL_ROW_189_1832 VDD VSS gf180mcu_as_sc_mcu7t3v3__tap_2
XFILLER_163_1245 VDD VDD VSS VSS gf180mcu_as_sc_mcu7t3v3__fill_2
XFILLER_10_280 VDD VDD VSS VSS gf180mcu_as_sc_mcu7t3v3__fillcap_4
XFILLER_156_764 VDD VDD VSS VSS gf180mcu_as_sc_mcu7t3v3__fillcap_16
XFILLER_6_251 VDD VDD VSS VSS gf180mcu_as_sc_mcu7t3v3__fill_1
Xwire694 VDD VDD VSS VSS _3564_/Y wire694/Y gf180mcu_as_sc_mcu7t3v3__clkbuff_12
X_3450_ VDD VDD VSS VSS _3450_/B _4103_/A _3451_/D gf180mcu_as_sc_mcu7t3v3__and2_2
XTAP_TAPCELL_ROW_124_1_1077 VDD VSS gf180mcu_as_sc_mcu7t3v3__tap_2
XFILLER_152_970 VDD VDD VSS VSS gf180mcu_as_sc_mcu7t3v3__fillcap_16
X_3381_ VDD VDD VSS VSS _3452_/S _4032_/D _3381_/A _3383_/B gf180mcu_as_sc_mcu7t3v3__mux2_2
X_2401_ VDD VDD VSS VSS _2765_/D _4754_/Q gf180mcu_as_sc_mcu7t3v3__inv_2
X_5120_ VDD VDD VSS VSS _5188_/CLK _5120_/D _5120_/Q gf180mcu_as_sc_mcu7t3v3__dfxtp_2
XFILLER_170_1227 VDD VDD VSS VSS gf180mcu_as_sc_mcu7t3v3__fillcap_8
X_5051_ VDD VDD VSS VSS _5086_/CLK _5051_/D _5051_/Q gf180mcu_as_sc_mcu7t3v3__dfxtp_2
X_4002_ VDD VDD VSS VSS _4003_/C _4002_/B _4002_/A gf180mcu_as_sc_mcu7t3v3__nor2_2
XFILLER_1_72 VDD VDD VSS VSS gf180mcu_as_sc_mcu7t3v3__fill_2
XFILLER_52_103 VDD VDD VSS VSS gf180mcu_as_sc_mcu7t3v3__fill_2
XFILLER_55_1326 VDD VDD VSS VSS gf180mcu_as_sc_mcu7t3v3__fillcap_4
X_4904_ VDD VDD VSS VSS clkload5/A _4904_/D _4904_/Q gf180mcu_as_sc_mcu7t3v3__dfxtp_2
XTAP_TAPCELL_ROW_160_1294 VDD VSS gf180mcu_as_sc_mcu7t3v3__tap_2
XTAP_TAPCELL_ROW_160_1283 VDD VSS gf180mcu_as_sc_mcu7t3v3__tap_2
X_4835_ VDD VDD VSS VSS clkload7/A _4835_/D _4835_/Q gf180mcu_as_sc_mcu7t3v3__dfxtp_2
X_4766_ VDD VDD VSS VSS _5278_/CLK _4766_/D _4766_/Q gf180mcu_as_sc_mcu7t3v3__dfxtp_2
XFILLER_179_1230 VDD VDD VSS VSS gf180mcu_as_sc_mcu7t3v3__fillcap_8
XFILLER_181_509 VDD VDD VSS VSS gf180mcu_as_sc_mcu7t3v3__fillcap_8
X_3717_ VDD VDD VSS VSS _3718_/C _4093_/D _3781_/S _3717_/C gf180mcu_as_sc_mcu7t3v3__ao21_2
XPHY_EDGE_ROW_136_1_Left_328 VDD VSS gf180mcu_as_sc_mcu7t3v3__tap_2
XFILLER_179_1252 VDD VDD VSS VSS gf180mcu_as_sc_mcu7t3v3__fill_1
X_4697_ VDD VDD VSS VSS _4707_/S _5253_/Q _4697_/A _5253_/D gf180mcu_as_sc_mcu7t3v3__mux2_2
XFILLER_162_745 VDD VDD VSS VSS gf180mcu_as_sc_mcu7t3v3__fill_1
XFILLER_175_1116 VDD VDD VSS VSS gf180mcu_as_sc_mcu7t3v3__fillcap_4
XFILLER_175_1138 VDD VDD VSS VSS gf180mcu_as_sc_mcu7t3v3__fillcap_8
X_3648_ VDD VDD VSS VSS _4926_/Q _3648_/B _3648_/C _4023_/A _3650_/C gf180mcu_as_sc_mcu7t3v3__ao22_2
XFILLER_136_37 VDD VDD VSS VSS gf180mcu_as_sc_mcu7t3v3__fillcap_16
X_3579_ VDD VDD VSS VSS _3580_/C _3579_/C _3653_/B _3943_/A gf180mcu_as_sc_mcu7t3v3__aoi21_2
Xinput306 VDD VDD VSS VSS west_in[30] _3796_/A gf180mcu_as_sc_mcu7t3v3__buff_12
XTAP_TAPCELL_ROW_167_1426 VDD VSS gf180mcu_as_sc_mcu7t3v3__tap_2
XTAP_TAPCELL_ROW_167_1415 VDD VSS gf180mcu_as_sc_mcu7t3v3__tap_2
XFILLER_152_25 VDD VDD VSS VSS gf180mcu_as_sc_mcu7t3v3__fillcap_8
XFILLER_152_36 VDD VDD VSS VSS gf180mcu_as_sc_mcu7t3v3__fillcap_16
XFILLER_29_68 VDD VDD VSS VSS gf180mcu_as_sc_mcu7t3v3__fill_2
X_5249_ VDD VDD VSS VSS _5280_/CLK _5249_/D _5249_/Q gf180mcu_as_sc_mcu7t3v3__dfxtp_2
XTAP_TAPCELL_ROW_184_1740 VDD VSS gf180mcu_as_sc_mcu7t3v3__tap_2
XFILLER_5_1257 VDD VDD VSS VSS gf180mcu_as_sc_mcu7t3v3__fill_2
XTAP_TAPCELL_ROW_4_766 VDD VSS gf180mcu_as_sc_mcu7t3v3__tap_2
XTAP_TAPCELL_ROW_184_1751 VDD VSS gf180mcu_as_sc_mcu7t3v3__tap_2
XFILLER_186_1223 VDD VDD VSS VSS gf180mcu_as_sc_mcu7t3v3__fill_2
XTAP_TAPCELL_ROW_180_1659 VDD VSS gf180mcu_as_sc_mcu7t3v3__tap_2
XFILLER_177_22 VDD VDD VSS VSS gf180mcu_as_sc_mcu7t3v3__fillcap_16
XFILLER_184_314 VDD VDD VSS VSS gf180mcu_as_sc_mcu7t3v3__fill_1
XFILLER_61_55 VDD VDD VSS VSS gf180mcu_as_sc_mcu7t3v3__fill_2
XFILLER_8_527 VDD VDD VSS VSS gf180mcu_as_sc_mcu7t3v3__fill_2
XFILLER_152_222 VDD VDD VSS VSS gf180mcu_as_sc_mcu7t3v3__fillcap_16
XFILLER_192_380 VDD VDD VSS VSS gf180mcu_as_sc_mcu7t3v3__fill_2
XFILLER_192_391 VDD VDD VSS VSS gf180mcu_as_sc_mcu7t3v3__fill_2
XFILLER_4_722 VDD VDD VSS VSS gf180mcu_as_sc_mcu7t3v3__fill_2
XPHY_EDGE_ROW_69_3_Left_441 VDD VSS gf180mcu_as_sc_mcu7t3v3__tap_2
XFILLER_119_1309 VDD VDD VSS VSS gf180mcu_as_sc_mcu7t3v3__fillcap_8
XFILLER_180_553 VDD VDD VSS VSS gf180mcu_as_sc_mcu7t3v3__fillcap_4
XPHY_EDGE_ROW_121_3_Left_493 VDD VSS gf180mcu_as_sc_mcu7t3v3__tap_2
XFILLER_180_597 VDD VDD VSS VSS gf180mcu_as_sc_mcu7t3v3__fillcap_16
XFILLER_19_100 VDD VDD VSS VSS gf180mcu_as_sc_mcu7t3v3__fill_1
XFILLER_43_1285 VDD VDD VSS VSS gf180mcu_as_sc_mcu7t3v3__fill_2
XFILLER_130_1288 VDD VDD VSS VSS gf180mcu_as_sc_mcu7t3v3__fill_1
XFILLER_163_1020 VDD VDD VSS VSS gf180mcu_as_sc_mcu7t3v3__fillcap_8
X_2950_ VDD VDD VSS VSS _3930_/A _3222_/D _3236_/C _3933_/D _2951_/C gf180mcu_as_sc_mcu7t3v3__ao22_2
XTAP_TAPCELL_ROW_143_3_2054 VDD VSS gf180mcu_as_sc_mcu7t3v3__tap_2
XFILLER_188_653 VDD VDD VSS VSS gf180mcu_as_sc_mcu7t3v3__fill_1
X_2881_ VDD VDD VSS VSS _4719_/A _4763_/Q _2882_/D gf180mcu_as_sc_mcu7t3v3__and2_2
XFILLER_163_1086 VDD VDD VSS VSS gf180mcu_as_sc_mcu7t3v3__fill_1
X_4620_ VDD VDD VSS VSS _5214_/Q _4621_/B _4621_/C _5215_/Q _5214_/D gf180mcu_as_sc_mcu7t3v3__ao22_2
XFILLER_102_1324 VDD VDD VSS VSS gf180mcu_as_sc_mcu7t3v3__fill_1
XFILLER_184_870 VDD VDD VSS VSS gf180mcu_as_sc_mcu7t3v3__fillcap_4
XFILLER_190_317 VDD VDD VSS VSS gf180mcu_as_sc_mcu7t3v3__fill_1
XFILLER_50_1256 VDD VDD VSS VSS gf180mcu_as_sc_mcu7t3v3__fillcap_4
X_4551_ VDD VDD VSS VSS _4552_/C _4557_/A _5026_/Q _4560_/A gf180mcu_as_sc_mcu7t3v3__ao21_2
XFILLER_156_594 VDD VDD VSS VSS gf180mcu_as_sc_mcu7t3v3__fill_1
XFILLER_171_531 VDD VDD VSS VSS gf180mcu_as_sc_mcu7t3v3__fill_1
X_4482_ VDD VDD VSS VSS _4485_/C _4482_/C _5047_/Q _4536_/S gf180mcu_as_sc_mcu7t3v3__aoi21b_2
X_3502_ VDD VDD VSS VSS _4160_/A _3502_/B _3502_/C _3502_/D _3504_/C gf180mcu_as_sc_mcu7t3v3__ao211_2
X_3433_ VDD VDD VSS VSS _3501_/C _4088_/A _3435_/C gf180mcu_as_sc_mcu7t3v3__and2_2
XTAP_TAPCELL_ROW_58_1_1011 VDD VSS gf180mcu_as_sc_mcu7t3v3__tap_2
X_5103_ VDD VDD VSS VSS _5188_/CLK _5103_/D _5103_/Q gf180mcu_as_sc_mcu7t3v3__dfxtp_2
X_3364_ VDD VDD VSS VSS _4013_/A _3451_/B _3364_/C _3364_/D _3365_/A gf180mcu_as_sc_mcu7t3v3__ao211_2
X_3295_ VDD VDD VSS VSS _3943_/A _3374_/C _3295_/C _3296_/C _3424_/B gf180mcu_as_sc_mcu7t3v3__aoi211_2
X_5034_ VDD VDD VSS VSS _5175_/CLK _5034_/D _5034_/Q gf180mcu_as_sc_mcu7t3v3__dfxtp_2
XTAP_TAPCELL_ROW_1_714 VDD VSS gf180mcu_as_sc_mcu7t3v3__tap_2
XTAP_TAPCELL_ROW_1_703 VDD VSS gf180mcu_as_sc_mcu7t3v3__tap_2
XTAP_TAPCELL_ROW_162_1323 VDD VSS gf180mcu_as_sc_mcu7t3v3__tap_2
XFILLER_0_1121 VDD VDD VSS VSS gf180mcu_as_sc_mcu7t3v3__fill_1
XFILLER_0_1187 VDD VDD VSS VSS gf180mcu_as_sc_mcu7t3v3__fill_2
XFILLER_166_303 VDD VDD VSS VSS gf180mcu_as_sc_mcu7t3v3__fillcap_4
XFILLER_182_807 VDD VDD VSS VSS gf180mcu_as_sc_mcu7t3v3__fill_2
X_4818_ VDD VDD VSS VSS clkload3/A _4818_/D _4818_/Q gf180mcu_as_sc_mcu7t3v3__dfxtp_2
XFILLER_31_58 VDD VDD VSS VSS gf180mcu_as_sc_mcu7t3v3__fill_1
XFILLER_5_508 VDD VDD VSS VSS gf180mcu_as_sc_mcu7t3v3__fill_2
X_4749_ VDD VDD VSS VSS _4750_/C _4749_/B _4749_/A gf180mcu_as_sc_mcu7t3v3__nand2_2
XFILLER_174_391 VDD VDD VSS VSS gf180mcu_as_sc_mcu7t3v3__fill_2
XTAP_TAPCELL_ROW_78_3_1989 VDD VSS gf180mcu_as_sc_mcu7t3v3__tap_2
XFILLER_190_873 VDD VDD VSS VSS gf180mcu_as_sc_mcu7t3v3__fill_2
XFILLER_162_586 VDD VDD VSS VSS gf180mcu_as_sc_mcu7t3v3__fillcap_8
XFILLER_162_597 VDD VDD VSS VSS gf180mcu_as_sc_mcu7t3v3__fillcap_16
Xmax_cap780 VDD VDD VSS VSS _3091_/S _3134_/S gf180mcu_as_sc_mcu7t3v3__clkbuff_12
XTAP_TAPCELL_ROW_9_869 VDD VSS gf180mcu_as_sc_mcu7t3v3__tap_2
XTAP_TAPCELL_ROW_9_858 VDD VSS gf180mcu_as_sc_mcu7t3v3__tap_2
XFILLER_0_246 VDD VDD VSS VSS gf180mcu_as_sc_mcu7t3v3__fill_1
XFILLER_118_1331 VDD VDD VSS VSS gf180mcu_as_sc_mcu7t3v3__fillcap_8
XFILLER_192_1260 VDD VDD VSS VSS gf180mcu_as_sc_mcu7t3v3__fill_2
XFILLER_1_769 VDD VDD VSS VSS gf180mcu_as_sc_mcu7t3v3__fill_1
Xinput103 VDD VDD VSS VSS ne_in[32] _3521_/A gf180mcu_as_sc_mcu7t3v3__buff_12
Xinput114 VDD VDD VSS VSS north_in[11] _4023_/A gf180mcu_as_sc_mcu7t3v3__buff_12
Xinput125 VDD VDD VSS VSS north_in[21] wire901/A gf180mcu_as_sc_mcu7t3v3__buff_12
Xinput136 VDD VDD VSS VSS north_in[31] _3510_/A gf180mcu_as_sc_mcu7t3v3__buff_12
XFILLER_153_1288 VDD VDD VSS VSS gf180mcu_as_sc_mcu7t3v3__fill_2
Xinput147 VDD VDD VSS VSS nw_in[10] _4016_/A gf180mcu_as_sc_mcu7t3v3__buff_12
Xinput158 VDD VDD VSS VSS nw_in[20] _4094_/A gf180mcu_as_sc_mcu7t3v3__buff_12
Xinput169 VDD VDD VSS VSS nw_in[30] _3801_/A gf180mcu_as_sc_mcu7t3v3__buff_12
XFILLER_56_33 VDD VDD VSS VSS gf180mcu_as_sc_mcu7t3v3__fill_2
XFILLER_186_1042 VDD VDD VSS VSS gf180mcu_as_sc_mcu7t3v3__fillcap_4
XFILLER_169_130 VDD VDD VSS VSS gf180mcu_as_sc_mcu7t3v3__fill_2
XFILLER_73_1256 VDD VDD VSS VSS gf180mcu_as_sc_mcu7t3v3__fillcap_16
XFILLER_157_347 VDD VDD VSS VSS gf180mcu_as_sc_mcu7t3v3__fill_2
XFILLER_188_98 VDD VDD VSS VSS gf180mcu_as_sc_mcu7t3v3__fillcap_4
XFILLER_184_177 VDD VDD VSS VSS gf180mcu_as_sc_mcu7t3v3__fill_2
XFILLER_185_689 VDD VDD VSS VSS gf180mcu_as_sc_mcu7t3v3__fillcap_8
XFILLER_10_1262 VDD VDD VSS VSS gf180mcu_as_sc_mcu7t3v3__fill_1
XFILLER_4_530 VDD VDD VSS VSS gf180mcu_as_sc_mcu7t3v3__fillcap_4
XFILLER_137_80 VDD VDD VSS VSS gf180mcu_as_sc_mcu7t3v3__fillcap_4
X_3080_ VDD VDD VSS VSS _3131_/A _3080_/B _3080_/C _3081_/C gf180mcu_as_sc_mcu7t3v3__nor3_2
XTAP_TAPCELL_ROW_119_1_1072 VDD VSS gf180mcu_as_sc_mcu7t3v3__tap_2
XFILLER_169_1273 VDD VDD VSS VSS gf180mcu_as_sc_mcu7t3v3__fillcap_16
XFILLER_91_1312 VDD VDD VSS VSS gf180mcu_as_sc_mcu7t3v3__fill_1
X_3982_ VDD VDD VSS VSS _3982_/A _4023_/B _4023_/C _4921_/Q _3983_/D gf180mcu_as_sc_mcu7t3v3__ao22_2
XFILLER_94_2 VDD VDD VSS VSS gf180mcu_as_sc_mcu7t3v3__fill_2
X_2933_ VDD VDD VSS VSS _3922_/A _3793_/A _3802_/A gf180mcu_as_sc_mcu7t3v3__nor2_2
XFILLER_188_472 VDD VDD VSS VSS gf180mcu_as_sc_mcu7t3v3__fill_1
XPHY_EDGE_ROW_156_Right_18 VDD VSS gf180mcu_as_sc_mcu7t3v3__tap_2
XFILLER_164_807 VDD VDD VSS VSS gf180mcu_as_sc_mcu7t3v3__fillcap_16
XFILLER_176_667 VDD VDD VSS VSS gf180mcu_as_sc_mcu7t3v3__fillcap_8
X_2864_ VDD VDD VSS VSS _2865_/B _4764_/Q _2868_/B gf180mcu_as_sc_mcu7t3v3__and2_2
XFILLER_175_155 VDD VDD VSS VSS gf180mcu_as_sc_mcu7t3v3__fill_1
XFILLER_176_689 VDD VDD VSS VSS gf180mcu_as_sc_mcu7t3v3__fillcap_8
XFILLER_191_626 VDD VDD VSS VSS gf180mcu_as_sc_mcu7t3v3__fillcap_4
X_4603_ VDD VDD VSS VSS _5197_/Q _4609_/B _4609_/C _5198_/Q _5197_/D gf180mcu_as_sc_mcu7t3v3__ao22_2
X_2795_ VDD VDD VSS VSS _4643_/B _2795_/A _4630_/A _4626_/A _2796_/D gf180mcu_as_sc_mcu7t3v3__ao31_2
XFILLER_191_648 VDD VDD VSS VSS gf180mcu_as_sc_mcu7t3v3__fillcap_8
X_4534_ VDD VDD VSS VSS _4535_/C _4536_/S _5024_/Q _4538_/A gf180mcu_as_sc_mcu7t3v3__ao21_2
XFILLER_176_1222 VDD VDD VSS VSS gf180mcu_as_sc_mcu7t3v3__fill_2
XTAP_TAPCELL_ROW_155_1193 VDD VSS gf180mcu_as_sc_mcu7t3v3__tap_2
XTAP_TAPCELL_ROW_155_1182 VDD VSS gf180mcu_as_sc_mcu7t3v3__tap_2
X_4465_ VDD VDD VSS VSS _4465_/D _4528_/A _4465_/B _4465_/C _4466_/B gf180mcu_as_sc_mcu7t3v3__ao31_2
Xfanout804 VDD VDD VSS VSS _5271_/Q _4739_/A gf180mcu_as_sc_mcu7t3v3__buff_12
Xfanout815 VDD VDD VSS VSS _5098_/Q _4264_/A gf180mcu_as_sc_mcu7t3v3__buff_12
X_4396_ VDD VDD VSS VSS _5167_/Q _4493_/B _4540_/C _5117_/Q _4397_/B gf180mcu_as_sc_mcu7t3v3__ao22_2
X_3416_ VDD VDD VSS VSS _4067_/A _3454_/A _3416_/C _4821_/D _3615_/D gf180mcu_as_sc_mcu7t3v3__aoi211_2
XTAP_TAPCELL_ROW_6_806 VDD VSS gf180mcu_as_sc_mcu7t3v3__tap_2
Xfanout826 VDD VDD VSS VSS fanout837/Y _4500_/S gf180mcu_as_sc_mcu7t3v3__buff_12
Xfanout837 VDD VDD VSS VSS _5094_/Q fanout837/Y gf180mcu_as_sc_mcu7t3v3__buff_12
Xfanout848 VDD VDD VSS VSS fanout849/Y _3795_/A gf180mcu_as_sc_mcu7t3v3__buff_12
X_3347_ VDD VDD VSS VSS _4000_/D _3503_/B _3347_/C _3347_/D _3348_/C gf180mcu_as_sc_mcu7t3v3__ao211_2
XPHY_EDGE_ROW_165_Right_27 VDD VSS gf180mcu_as_sc_mcu7t3v3__tap_2
XFILLER_133_27 VDD VDD VSS VSS gf180mcu_as_sc_mcu7t3v3__fill_1
XFILLER_26_1291 VDD VDD VSS VSS gf180mcu_as_sc_mcu7t3v3__fill_2
X_5017_ VDD VDD VSS VSS _5075_/CLK _5017_/D _5017_/Q gf180mcu_as_sc_mcu7t3v3__dfxtp_2
X_3278_ VDD VDD VSS VSS _3522_/B _3814_/A _3278_/Y gf180mcu_as_sc_mcu7t3v3__and2_2
XFILLER_2_1227 VDD VDD VSS VSS gf180mcu_as_sc_mcu7t3v3__fill_2
XFILLER_179_450 VDD VDD VSS VSS gf180mcu_as_sc_mcu7t3v3__fillcap_16
XPHY_EDGE_ROW_174_Right_36 VDD VSS gf180mcu_as_sc_mcu7t3v3__tap_2
XTAP_TAPCELL_ROW_179_1650 VDD VSS gf180mcu_as_sc_mcu7t3v3__tap_2
XFILLER_155_807 VDD VDD VSS VSS gf180mcu_as_sc_mcu7t3v3__fillcap_8
XFILLER_166_122 VDD VDD VSS VSS gf180mcu_as_sc_mcu7t3v3__fillcap_4
XFILLER_10_846 VDD VDD VSS VSS gf180mcu_as_sc_mcu7t3v3__fill_2
XFILLER_154_306 VDD VDD VSS VSS gf180mcu_as_sc_mcu7t3v3__fillcap_8
XFILLER_154_317 VDD VDD VSS VSS gf180mcu_as_sc_mcu7t3v3__fillcap_4
XFILLER_158_57 VDD VDD VSS VSS gf180mcu_as_sc_mcu7t3v3__fill_2
XTAP_TAPCELL_ROW_175_1569 VDD VSS gf180mcu_as_sc_mcu7t3v3__tap_2
XFILLER_166_177 VDD VDD VSS VSS gf180mcu_as_sc_mcu7t3v3__fillcap_16
XFILLER_182_648 VDD VDD VSS VSS gf180mcu_as_sc_mcu7t3v3__fill_2
XFILLER_120_1287 VDD VDD VSS VSS gf180mcu_as_sc_mcu7t3v3__fill_2
XTAP_TAPCELL_ROW_192_1894 VDD VSS gf180mcu_as_sc_mcu7t3v3__tap_2
XFILLER_162_361 VDD VDD VSS VSS gf180mcu_as_sc_mcu7t3v3__fill_2
XFILLER_162_383 VDD VDD VSS VSS gf180mcu_as_sc_mcu7t3v3__fill_2
XFILLER_163_884 VDD VDD VSS VSS gf180mcu_as_sc_mcu7t3v3__fillcap_16
XFILLER_174_34 VDD VDD VSS VSS gf180mcu_as_sc_mcu7t3v3__fill_1
XTAP_TAPCELL_ROW_26_3_1937 VDD VSS gf180mcu_as_sc_mcu7t3v3__tap_2
XPHY_EDGE_ROW_183_Right_45 VDD VSS gf180mcu_as_sc_mcu7t3v3__tap_2
XFILLER_107_72 VDD VDD VSS VSS gf180mcu_as_sc_mcu7t3v3__fillcap_16
XFILLER_153_1052 VDD VDD VSS VSS gf180mcu_as_sc_mcu7t3v3__fill_2
XFILLER_192_1090 VDD VDD VSS VSS gf180mcu_as_sc_mcu7t3v3__fill_2
XFILLER_7_1105 VDD VDD VSS VSS gf180mcu_as_sc_mcu7t3v3__fill_2
XFILLER_40_1266 VDD VDD VSS VSS gf180mcu_as_sc_mcu7t3v3__fillcap_4
XFILLER_40_1288 VDD VDD VSS VSS gf180mcu_as_sc_mcu7t3v3__fill_1
XPHY_EDGE_ROW_192_Right_54 VDD VSS gf180mcu_as_sc_mcu7t3v3__tap_2
XFILLER_16_80 VDD VDD VSS VSS gf180mcu_as_sc_mcu7t3v3__fill_2
XFILLER_83_97 VDD VDD VSS VSS gf180mcu_as_sc_mcu7t3v3__fillcap_8
XFILLER_158_667 VDD VDD VSS VSS gf180mcu_as_sc_mcu7t3v3__fillcap_4
XFILLER_186_998 VDD VDD VSS VSS gf180mcu_as_sc_mcu7t3v3__fillcap_8
XFILLER_9_655 VDD VDD VSS VSS gf180mcu_as_sc_mcu7t3v3__fillcap_16
XFILLER_9_699 VDD VDD VSS VSS gf180mcu_as_sc_mcu7t3v3__fill_1
Xoutput407 VDD VDD VSS VSS _4827_/Q south_out[22] gf180mcu_as_sc_mcu7t3v3__buff_12
X_2580_ VDD VDD VSS VSS _2673_/B _2580_/A _2580_/Y gf180mcu_as_sc_mcu7t3v3__and2_2
XTAP_TAPCELL_ROW_11_896 VDD VSS gf180mcu_as_sc_mcu7t3v3__tap_2
XPHY_EDGE_ROW_29_3_Right_70 VDD VSS gf180mcu_as_sc_mcu7t3v3__tap_2
Xoutput429 VDD VDD VSS VSS _4884_/Q west_out[11] gf180mcu_as_sc_mcu7t3v3__buff_12
Xoutput418 VDD VDD VSS VSS _4837_/Q south_out[32] gf180mcu_as_sc_mcu7t3v3__buff_12
X_4250_ VDD VDD VSS VSS _4254_/S _4250_/B _5086_/Q _5086_/D gf180mcu_as_sc_mcu7t3v3__mux2_2
X_4181_ VDD VDD VSS VSS _4241_/B _4195_/B _4195_/C _5019_/Q _5019_/D gf180mcu_as_sc_mcu7t3v3__ao22_2
X_3201_ VDD VDD VSS VSS _3789_/A _3223_/B _3201_/C _3203_/B gf180mcu_as_sc_mcu7t3v3__nand3_2
X_3132_ VDD VDD VSS VSS _3731_/A _3132_/B _3132_/C _4792_/D _3676_/D gf180mcu_as_sc_mcu7t3v3__aoi211_2
X_3063_ VDD VDD VSS VSS _4041_/A _3063_/B _3063_/C _3063_/D _3064_/C gf180mcu_as_sc_mcu7t3v3__ao22_2
XPHY_EDGE_ROW_145_1_Left_337 VDD VSS gf180mcu_as_sc_mcu7t3v3__tap_2
X_3965_ VDD VDD VSS VSS _3965_/A _4021_/B _4021_/C _3965_/D _3966_/D gf180mcu_as_sc_mcu7t3v3__ao22_2
XFILLER_188_280 VDD VDD VSS VSS gf180mcu_as_sc_mcu7t3v3__fill_1
X_3896_ VDD VDD VSS VSS _3908_/B _5186_/Q _4936_/D gf180mcu_as_sc_mcu7t3v3__and2_2
X_2916_ VDD VDD VSS VSS _3201_/C _2948_/B _3233_/C gf180mcu_as_sc_mcu7t3v3__and2_2
XTAP_TAPCELL_ROW_157_1222 VDD VSS gf180mcu_as_sc_mcu7t3v3__tap_2
XFILLER_12_27 VDD VDD VSS VSS gf180mcu_as_sc_mcu7t3v3__fillcap_8
X_2847_ VDD VDD VSS VSS _2847_/A _4372_/D _2847_/C _4371_/B _2853_/A gf180mcu_as_sc_mcu7t3v3__ao211_2
XTAP_TAPCELL_ROW_157_1233 VDD VSS gf180mcu_as_sc_mcu7t3v3__tap_2
XFILLER_163_125 VDD VDD VSS VSS gf180mcu_as_sc_mcu7t3v3__fillcap_4
XFILLER_164_659 VDD VDD VSS VSS gf180mcu_as_sc_mcu7t3v3__fillcap_4
XFILLER_192_979 VDD VDD VSS VSS gf180mcu_as_sc_mcu7t3v3__fillcap_4
X_2778_ VDD VDD VSS VSS _2778_/B _5270_/Q _2781_/B gf180mcu_as_sc_mcu7t3v3__and2_2
XFILLER_160_821 VDD VDD VSS VSS gf180mcu_as_sc_mcu7t3v3__fill_2
XFILLER_176_1041 VDD VDD VSS VSS gf180mcu_as_sc_mcu7t3v3__fill_2
X_4517_ VDD VDD VSS VSS _4520_/C _4993_/Q _4525_/A gf180mcu_as_sc_mcu7t3v3__nand2b_2
XTAP_TAPCELL_ROW_170_1477 VDD VSS gf180mcu_as_sc_mcu7t3v3__tap_2
X_4448_ VDD VDD VSS VSS _4449_/D _4448_/B _4581_/A gf180mcu_as_sc_mcu7t3v3__nor2_2
XFILLER_144_37 VDD VDD VSS VSS gf180mcu_as_sc_mcu7t3v3__fillcap_16
Xfanout601 VDD VDD VSS VSS _3905_/B _3908_/B gf180mcu_as_sc_mcu7t3v3__buff_12
Xfanout612 VDD VDD VSS VSS _4532_/B _4493_/B gf180mcu_as_sc_mcu7t3v3__buff_12
Xfanout623 VDD VDD VSS VSS _2639_/S _4264_/B gf180mcu_as_sc_mcu7t3v3__buff_12
XPHY_EDGE_ROW_16_3_Left_388 VDD VSS gf180mcu_as_sc_mcu7t3v3__tap_2
Xfanout634 VDD VDD VSS VSS fanout634/A _4154_/C gf180mcu_as_sc_mcu7t3v3__buff_12
Xfanout656 VDD VDD VSS VSS _3451_/B _3372_/B gf180mcu_as_sc_mcu7t3v3__buff_12
Xfanout667 VDD VDD VSS VSS _2930_/Y _3058_/C gf180mcu_as_sc_mcu7t3v3__buff_12
X_4379_ VDD VDD VSS VSS _4379_/B _5164_/Q _4380_/B gf180mcu_as_sc_mcu7t3v3__or2_2
Xfanout678 VDD VDD VSS VSS _4611_/C _4621_/C gf180mcu_as_sc_mcu7t3v3__buff_12
Xfanout689 VDD VDD VSS VSS _3931_/Y _4153_/B gf180mcu_as_sc_mcu7t3v3__buff_12
XPHY_EDGE_ROW_77_1_Left_269 VDD VSS gf180mcu_as_sc_mcu7t3v3__tap_2
XFILLER_170_6 VDD VDD VSS VSS gf180mcu_as_sc_mcu7t3v3__fillcap_16
XFILLER_187_1192 VDD VDD VSS VSS gf180mcu_as_sc_mcu7t3v3__fillcap_16
XPHY_EDGE_ROW_78_3_Left_450 VDD VSS gf180mcu_as_sc_mcu7t3v3__tap_2
XFILLER_187_718 VDD VDD VSS VSS gf180mcu_as_sc_mcu7t3v3__fill_2
XTAP_TAPCELL_ROW_177_1609 VDD VSS gf180mcu_as_sc_mcu7t3v3__tap_2
XFILLER_161_1354 VDD VDD VSS VSS gf180mcu_as_sc_mcu7t3v3__fill_1
XFILLER_168_932 VDD VDD VSS VSS gf180mcu_as_sc_mcu7t3v3__fillcap_4
XTAP_TAPCELL_ROW_81_1_1034 VDD VSS gf180mcu_as_sc_mcu7t3v3__tap_2
XFILLER_5_113 VDD VDD VSS VSS gf180mcu_as_sc_mcu7t3v3__fill_2
XFILLER_185_66 VDD VDD VSS VSS gf180mcu_as_sc_mcu7t3v3__fillcap_4
XFILLER_5_146 VDD VDD VSS VSS gf180mcu_as_sc_mcu7t3v3__fill_2
XFILLER_185_88 VDD VDD VSS VSS gf180mcu_as_sc_mcu7t3v3__fillcap_16
XFILLER_159_1294 VDD VDD VSS VSS gf180mcu_as_sc_mcu7t3v3__fill_1
XFILLER_42_1328 VDD VDD VSS VSS gf180mcu_as_sc_mcu7t3v3__fill_2
X_4976__1100 VDD VDD VSS VSS _4976_/D gf180mcu_as_sc_mcu7t3v3__tiel_4
Xmesh_tile_1011 VDD VDD VSS VSS nw_out[17] gf180mcu_as_sc_mcu7t3v3__tiel_4
Xmesh_tile_1000 VDD VDD VSS VSS nw_out[6] gf180mcu_as_sc_mcu7t3v3__tiel_4
Xmesh_tile_1044 VDD VDD VSS VSS sw_out[16] gf180mcu_as_sc_mcu7t3v3__tiel_4
Xmesh_tile_1033 VDD VDD VSS VSS sw_out[5] gf180mcu_as_sc_mcu7t3v3__tiel_4
Xmesh_tile_1022 VDD VDD VSS VSS nw_out[28] gf180mcu_as_sc_mcu7t3v3__tiel_4
Xmesh_tile_1055 VDD VDD VSS VSS sw_out[27] gf180mcu_as_sc_mcu7t3v3__tiel_4
XFILLER_79_1295 VDD VDD VSS VSS gf180mcu_as_sc_mcu7t3v3__fillcap_4
X_3750_ VDD VDD VSS VSS _4127_/A _3772_/B _3791_/B _4126_/A _3751_/D gf180mcu_as_sc_mcu7t3v3__ao22_2
XFILLER_159_965 VDD VDD VSS VSS gf180mcu_as_sc_mcu7t3v3__fillcap_4
X_2701_ VDD VDD VSS VSS _2701_/D _2701_/A _2701_/B _2701_/C _2702_/A gf180mcu_as_sc_mcu7t3v3__ao31_2
X_3681_ VDD VDD VSS VSS _3681_/D _4056_/D _3728_/B _3728_/C _3682_/C gf180mcu_as_sc_mcu7t3v3__ao31_2
XFILLER_174_979 VDD VDD VSS VSS gf180mcu_as_sc_mcu7t3v3__fillcap_16
X_2632_ VDD VDD VSS VSS _2632_/B _5230_/Q _4646_/C gf180mcu_as_sc_mcu7t3v3__and2_2
XFILLER_161_629 VDD VDD VSS VSS gf180mcu_as_sc_mcu7t3v3__fill_1
X_2563_ VDD VDD VSS VSS _3872_/A _2563_/A _2565_/B gf180mcu_as_sc_mcu7t3v3__or2_2
XTAP_TAPCELL_ROW_152_1141 VDD VSS gf180mcu_as_sc_mcu7t3v3__tap_2
XTAP_TAPCELL_ROW_152_1130 VDD VSS gf180mcu_as_sc_mcu7t3v3__tap_2
XFILLER_138_1323 VDD VDD VSS VSS gf180mcu_as_sc_mcu7t3v3__fillcap_4
XFILLER_160_128 VDD VDD VSS VSS gf180mcu_as_sc_mcu7t3v3__fillcap_16
XFILLER_173_1225 VDD VDD VSS VSS gf180mcu_as_sc_mcu7t3v3__fillcap_8
X_5282_ VDD VDD VSS VSS _5285_/CLK _5282_/D _5282_/Q gf180mcu_as_sc_mcu7t3v3__dfxtp_2
X_4302_ VDD VDD VSS VSS _4326_/S _5132_/Q _5131_/Q _5131_/D gf180mcu_as_sc_mcu7t3v3__mux2_2
XFILLER_173_1258 VDD VDD VSS VSS gf180mcu_as_sc_mcu7t3v3__fill_2
XFILLER_86_1299 VDD VDD VSS VSS gf180mcu_as_sc_mcu7t3v3__fillcap_4
X_4233_ VDD VDD VSS VSS _4246_/S _4233_/B _5069_/Q _5069_/D gf180mcu_as_sc_mcu7t3v3__mux2_2
X_2494_ VDD VDD VSS VSS _2495_/A _4954_/Q _5189_/Q _2794_/A gf180mcu_as_sc_mcu7t3v3__maj3_2
XFILLER_4_94 VDD VDD VSS VSS gf180mcu_as_sc_mcu7t3v3__fill_1
X_4164_ VDD VDD VSS VSS _4164_/S _4164_/B _4164_/A _4165_/B gf180mcu_as_sc_mcu7t3v3__mux2_2
XFILLER_3_1300 VDD VDD VSS VSS gf180mcu_as_sc_mcu7t3v3__fill_2
X_4095_ VDD VDD VSS VSS _4095_/A _4160_/C _4129_/C _4935_/Q _4097_/C gf180mcu_as_sc_mcu7t3v3__ao22_2
X_3115_ VDD VDD VSS VSS _3738_/D _3115_/A _3115_/B _3115_/C _3116_/C gf180mcu_as_sc_mcu7t3v3__ao31_2
X_3046_ VDD VDD VSS VSS _3046_/B _4926_/Q _3047_/D gf180mcu_as_sc_mcu7t3v3__or2_2
X_4883__1085 VDD VDD VSS VSS _4883_/D gf180mcu_as_sc_mcu7t3v3__tiel_4
XFILLER_168_228 VDD VDD VSS VSS gf180mcu_as_sc_mcu7t3v3__fill_2
X_4997_ VDD VDD VSS VSS _5185_/CLK _4997_/D _4997_/Q gf180mcu_as_sc_mcu7t3v3__dfxtp_2
Xclkbuf_leaf_10_clk_regs VDD VDD VSS VSS clkbuf_3_3__f_clk_regs/Y _5175_/CLK gf180mcu_as_sc_mcu7t3v3__clkbuff_12
X_3948_ VDD VDD VSS VSS _3948_/A _4022_/B _4027_/B _3953_/C _3948_/D gf180mcu_as_sc_mcu7t3v3__aoi211_2
XFILLER_165_946 VDD VDD VSS VSS gf180mcu_as_sc_mcu7t3v3__fillcap_4
XFILLER_165_957 VDD VDD VSS VSS gf180mcu_as_sc_mcu7t3v3__fill_2
X_3879_ VDD VDD VSS VSS _4946_/D _5169_/Q _4919_/D gf180mcu_as_sc_mcu7t3v3__and2_2
XTAP_TAPCELL_ROW_172_1517 VDD VSS gf180mcu_as_sc_mcu7t3v3__tap_2
XTAP_TAPCELL_ROW_172_1506 VDD VSS gf180mcu_as_sc_mcu7t3v3__tap_2
XTAP_TAPCELL_ROW_142_1_1095 VDD VSS gf180mcu_as_sc_mcu7t3v3__tap_2
XPHY_EDGE_ROW_139_3_Right_180 VDD VSS gf180mcu_as_sc_mcu7t3v3__tap_2
XFILLER_155_69 VDD VDD VSS VSS gf180mcu_as_sc_mcu7t3v3__fill_1
XFILLER_160_684 VDD VDD VSS VSS gf180mcu_as_sc_mcu7t3v3__fillcap_8
XFILLER_8_1222 VDD VDD VSS VSS gf180mcu_as_sc_mcu7t3v3__fill_2
Xfanout475 VDD VDD VSS VSS fanout479/Y _4076_/B gf180mcu_as_sc_mcu7t3v3__buff_12
XTAP_TAPCELL_ROW_187_1793 VDD VSS gf180mcu_as_sc_mcu7t3v3__tap_2
XFILLER_171_46 VDD VDD VSS VSS gf180mcu_as_sc_mcu7t3v3__fillcap_4
XFILLER_189_1232 VDD VDD VSS VSS gf180mcu_as_sc_mcu7t3v3__fillcap_16
Xfanout497 VDD VDD VSS VSS _4198_/Y _4228_/B gf180mcu_as_sc_mcu7t3v3__buff_12
XFILLER_64_66 VDD VDD VSS VSS gf180mcu_as_sc_mcu7t3v3__fill_2
XFILLER_159_228 VDD VDD VSS VSS gf180mcu_as_sc_mcu7t3v3__fillcap_16
XFILLER_80_43 VDD VDD VSS VSS gf180mcu_as_sc_mcu7t3v3__fill_1
XTAP_TAPCELL_ROW_13_958 VDD VSS gf180mcu_as_sc_mcu7t3v3__tap_2
XTAP_TAPCELL_ROW_13_947 VDD VSS gf180mcu_as_sc_mcu7t3v3__tap_2
XTAP_TAPCELL_ROW_13_936 VDD VSS gf180mcu_as_sc_mcu7t3v3__tap_2
XFILLER_7_912 VDD VDD VSS VSS gf180mcu_as_sc_mcu7t3v3__fill_1
XFILLER_13_70 VDD VDD VSS VSS gf180mcu_as_sc_mcu7t3v3__fillcap_16
Xmax_cap609 VDD VDD VSS VSS _3058_/B _3125_/B gf180mcu_as_sc_mcu7t3v3__clkbuff_12
Xwire854 VDD VDD VSS VSS wire854/A _3533_/A gf180mcu_as_sc_mcu7t3v3__clkbuff_12
Xwire865 VDD VDD VSS VSS wire865/A _4072_/A gf180mcu_as_sc_mcu7t3v3__clkbuff_12
Xwire876 VDD VDD VSS VSS wire876/A _3977_/A gf180mcu_as_sc_mcu7t3v3__clkbuff_12
XFILLER_155_489 VDD VDD VSS VSS gf180mcu_as_sc_mcu7t3v3__fill_1
XFILLER_170_426 VDD VDD VSS VSS gf180mcu_as_sc_mcu7t3v3__fill_2
XFILLER_183_798 VDD VDD VSS VSS gf180mcu_as_sc_mcu7t3v3__fill_1
XFILLER_159_1080 VDD VDD VSS VSS gf180mcu_as_sc_mcu7t3v3__fill_2
XFILLER_89_63 VDD VDD VSS VSS gf180mcu_as_sc_mcu7t3v3__fillcap_4
XFILLER_46_1272 VDD VDD VSS VSS gf180mcu_as_sc_mcu7t3v3__fill_2
X_4920_ VDD VDD VSS VSS clkload2/A _4920_/D _4920_/Q gf180mcu_as_sc_mcu7t3v3__dfxtp_2
X_4851_ VDD VDD VSS VSS _5212_/CLK _4851_/D _4851_/Q gf180mcu_as_sc_mcu7t3v3__dfxtp_2
X_3802_ VDD VDD VSS VSS _3802_/A _3802_/B _3803_/B _3802_/D _3804_/A gf180mcu_as_sc_mcu7t3v3__ao211_2
XFILLER_105_1300 VDD VDD VSS VSS gf180mcu_as_sc_mcu7t3v3__fill_2
XPHY_EDGE_ROW_110_1_Right_619 VDD VSS gf180mcu_as_sc_mcu7t3v3__tap_2
X_4782_ VDD VDD VSS VSS _5150_/CLK _4782_/D _4782_/Q gf180mcu_as_sc_mcu7t3v3__dfxtp_2
XFILLER_186_592 VDD VDD VSS VSS gf180mcu_as_sc_mcu7t3v3__fill_2
X_3733_ VDD VDD VSS VSS _3734_/C _4109_/D _3781_/S _3733_/C gf180mcu_as_sc_mcu7t3v3__ao21_2
XFILLER_174_754 VDD VDD VSS VSS gf180mcu_as_sc_mcu7t3v3__fillcap_16
XFILLER_9_282 VDD VDD VSS VSS gf180mcu_as_sc_mcu7t3v3__fill_1
X_3664_ VDD VDD VSS VSS _3668_/B _3664_/C _3664_/B _4038_/A gf180mcu_as_sc_mcu7t3v3__aoi21_2
X_2615_ VDD VDD VSS VSS _4628_/S _2632_/B _5268_/Q gf180mcu_as_sc_mcu7t3v3__nor2_2
XFILLER_161_437 VDD VDD VSS VSS gf180mcu_as_sc_mcu7t3v3__fill_2
XFILLER_173_286 VDD VDD VSS VSS gf180mcu_as_sc_mcu7t3v3__fill_1
X_3595_ VDD VDD VSS VSS _4919_/Q _3648_/B _3648_/C _3967_/A _3597_/C gf180mcu_as_sc_mcu7t3v3__ao22_2
X_2546_ VDD VDD VSS VSS _2547_/B _2546_/A _2546_/B _2745_/B gf180mcu_as_sc_mcu7t3v3__maj3_2
X_5265_ VDD VDD VSS VSS _5265_/CLK _5265_/D _5265_/Q gf180mcu_as_sc_mcu7t3v3__dfxtp_2
X_2477_ VDD VDD VSS VSS _2477_/B _3907_/A _4950_/D gf180mcu_as_sc_mcu7t3v3__and2_2
X_5196_ VDD VDD VSS VSS _5203_/CLK _5196_/D _5196_/Q gf180mcu_as_sc_mcu7t3v3__dfxtp_2
X_4216_ VDD VDD VSS VSS _4245_/B _4227_/B _4227_/C _5052_/Q _5052_/D gf180mcu_as_sc_mcu7t3v3__ao22_2
X_4147_ VDD VDD VSS VSS _4147_/A _4155_/B _4147_/C _4147_/D _4148_/B gf180mcu_as_sc_mcu7t3v3__ao211_2
XFILLER_18_37 VDD VDD VSS VSS gf180mcu_as_sc_mcu7t3v3__fill_1
XTAP_TAPCELL_ROW_165_1376 VDD VSS gf180mcu_as_sc_mcu7t3v3__tap_2
X_4078_ VDD VDD VSS VSS _4078_/A _4162_/B _4086_/C _4078_/D _4082_/A gf180mcu_as_sc_mcu7t3v3__ao211_2
XTAP_TAPCELL_ROW_165_1387 VDD VSS gf180mcu_as_sc_mcu7t3v3__tap_2
XFILLER_70_104 VDD VDD VSS VSS gf180mcu_as_sc_mcu7t3v3__fill_1
X_3029_ VDD VDD VSS VSS _4008_/A _3042_/B _3029_/C _3029_/D _3030_/C gf180mcu_as_sc_mcu7t3v3__ao22_2
XFILLER_149_1260 VDD VDD VSS VSS gf180mcu_as_sc_mcu7t3v3__fill_2
XFILLER_184_1173 VDD VDD VSS VSS gf180mcu_as_sc_mcu7t3v3__fillcap_8
XFILLER_169_559 VDD VDD VSS VSS gf180mcu_as_sc_mcu7t3v3__fill_1
Xsram2048.u_bank0_914 VDD VDD VSS VSS sram2048.u_bank0/WEN[3] gf180mcu_as_sc_mcu7t3v3__tiel_4
XFILLER_109_103 VDD VDD VSS VSS gf180mcu_as_sc_mcu7t3v3__fill_2
XFILLER_177_581 VDD VDD VSS VSS gf180mcu_as_sc_mcu7t3v3__fillcap_8
Xclkload2 VDD VDD VSS VSS clkload2/A clkload2/Y gf180mcu_as_sc_mcu7t3v3__clkbuff_12
XFILLER_180_702 VDD VDD VSS VSS gf180mcu_as_sc_mcu7t3v3__fillcap_16
XFILLER_152_437 VDD VDD VSS VSS gf180mcu_as_sc_mcu7t3v3__fillcap_4
XFILLER_161_960 VDD VDD VSS VSS gf180mcu_as_sc_mcu7t3v3__fill_1
XFILLER_191_1122 VDD VDD VSS VSS gf180mcu_as_sc_mcu7t3v3__fillcap_16
XTAP_TAPCELL_ROW_189_1844 VDD VSS gf180mcu_as_sc_mcu7t3v3__tap_2
XTAP_TAPCELL_ROW_189_1833 VDD VSS gf180mcu_as_sc_mcu7t3v3__tap_2
XFILLER_161_982 VDD VDD VSS VSS gf180mcu_as_sc_mcu7t3v3__fillcap_4
XFILLER_182_34 VDD VDD VSS VSS gf180mcu_as_sc_mcu7t3v3__fill_1
XFILLER_156_1297 VDD VDD VSS VSS gf180mcu_as_sc_mcu7t3v3__fill_1
XFILLER_191_1177 VDD VDD VSS VSS gf180mcu_as_sc_mcu7t3v3__fillcap_8
XFILLER_115_72 VDD VDD VSS VSS gf180mcu_as_sc_mcu7t3v3__fillcap_8
XFILLER_61_104 VDD VDD VSS VSS gf180mcu_as_sc_mcu7t3v3__fill_1
XFILLER_163_1202 VDD VDD VSS VSS gf180mcu_as_sc_mcu7t3v3__fillcap_16
XFILLER_91_31 VDD VDD VSS VSS gf180mcu_as_sc_mcu7t3v3__fillcap_8
XFILLER_187_312 VDD VDD VSS VSS gf180mcu_as_sc_mcu7t3v3__fillcap_4
XFILLER_187_323 VDD VDD VSS VSS gf180mcu_as_sc_mcu7t3v3__fillcap_16
XFILLER_188_868 VDD VDD VSS VSS gf180mcu_as_sc_mcu7t3v3__fillcap_4
XFILLER_156_732 VDD VDD VSS VSS gf180mcu_as_sc_mcu7t3v3__fill_2
XFILLER_168_592 VDD VDD VSS VSS gf180mcu_as_sc_mcu7t3v3__fill_2
Xwire640 VDD VDD VSS VSS _3563_/Y wire640/Y gf180mcu_as_sc_mcu7t3v3__clkbuff_12
XFILLER_183_562 VDD VDD VSS VSS gf180mcu_as_sc_mcu7t3v3__fillcap_4
XFILLER_157_1028 VDD VDD VSS VSS gf180mcu_as_sc_mcu7t3v3__fillcap_4
XFILLER_170_223 VDD VDD VSS VSS gf180mcu_as_sc_mcu7t3v3__fillcap_16
XFILLER_6_263 VDD VDD VSS VSS gf180mcu_as_sc_mcu7t3v3__fill_2
X_2400_ VDD VDD VSS VSS _2792_/A _2847_/A gf180mcu_as_sc_mcu7t3v3__inv_2
XFILLER_156_90 VDD VDD VSS VSS gf180mcu_as_sc_mcu7t3v3__fill_1
XFILLER_171_768 VDD VDD VSS VSS gf180mcu_as_sc_mcu7t3v3__fill_2
X_3380_ VDD VDD VSS VSS _4030_/A _3451_/B _3380_/C _3380_/D _3381_/A gf180mcu_as_sc_mcu7t3v3__ao211_2
XPHY_EDGE_ROW_30_3_Left_402 VDD VSS gf180mcu_as_sc_mcu7t3v3__tap_2
XFILLER_135_1326 VDD VDD VSS VSS gf180mcu_as_sc_mcu7t3v3__fillcap_4
XFILLER_170_1239 VDD VDD VSS VSS gf180mcu_as_sc_mcu7t3v3__fill_2
X_5050_ VDD VDD VSS VSS _5086_/CLK _5050_/D _5050_/Q gf180mcu_as_sc_mcu7t3v3__dfxtp_2
X_4001_ VDD VDD VSS VSS _4001_/A _4163_/B _4001_/C _4001_/D _4002_/B gf180mcu_as_sc_mcu7t3v3__ao211_2
XFILLER_1_51 VDD VDD VSS VSS gf180mcu_as_sc_mcu7t3v3__fill_2
XFILLER_0_1325 VDD VDD VSS VSS gf180mcu_as_sc_mcu7t3v3__fill_1
X_4903_ VDD VDD VSS VSS clkload5/A _4903_/D _4903_/Q gf180mcu_as_sc_mcu7t3v3__dfxtp_2
XFILLER_178_312 VDD VDD VSS VSS gf180mcu_as_sc_mcu7t3v3__fill_2
XFILLER_178_323 VDD VDD VSS VSS gf180mcu_as_sc_mcu7t3v3__fill_1
XTAP_TAPCELL_ROW_160_1295 VDD VSS gf180mcu_as_sc_mcu7t3v3__tap_2
XTAP_TAPCELL_ROW_160_1284 VDD VSS gf180mcu_as_sc_mcu7t3v3__tap_2
X_4834_ VDD VDD VSS VSS clkload7/A _4834_/D _4834_/Q gf180mcu_as_sc_mcu7t3v3__dfxtp_2
XFILLER_178_378 VDD VDD VSS VSS gf180mcu_as_sc_mcu7t3v3__fillcap_4
X_4765_ VDD VDD VSS VSS _5278_/CLK _4765_/D _4765_/Q gf180mcu_as_sc_mcu7t3v3__dfxtp_2
XPHY_EDGE_ROW_25_3_Left_397 VDD VSS gf180mcu_as_sc_mcu7t3v3__tap_2
X_3716_ VDD VDD VSS VSS _4096_/A _3779_/B _3748_/C _4095_/A _3717_/C gf180mcu_as_sc_mcu7t3v3__ao22_2
X_4696_ VDD VDD VSS VSS _4731_/B _4696_/B _5254_/Q _4697_/A gf180mcu_as_sc_mcu7t3v3__mux2_2
XPHY_EDGE_ROW_86_1_Left_278 VDD VSS gf180mcu_as_sc_mcu7t3v3__tap_2
XFILLER_161_212 VDD VDD VSS VSS gf180mcu_as_sc_mcu7t3v3__fill_2
XFILLER_20_27 VDD VDD VSS VSS gf180mcu_as_sc_mcu7t3v3__fillcap_8
X_3647_ VDD VDD VSS VSS _4849_/D _3647_/C _3731_/B _3647_/A gf180mcu_as_sc_mcu7t3v3__aoi21_2
XFILLER_162_768 VDD VDD VSS VSS gf180mcu_as_sc_mcu7t3v3__fillcap_16
X_3578_ VDD VDD VSS VSS _3939_/A _3652_/B _3578_/C _3652_/D _3579_/C gf180mcu_as_sc_mcu7t3v3__ao211_2
XFILLER_1_929 VDD VDD VSS VSS gf180mcu_as_sc_mcu7t3v3__fillcap_4
X_2529_ VDD VDD VSS VSS _2534_/A _5268_/Q _2795_/A _2530_/B gf180mcu_as_sc_mcu7t3v3__nor3_2
Xinput307 VDD VDD VSS VSS west_in[31] _3511_/A gf180mcu_as_sc_mcu7t3v3__buff_12
XTAP_TAPCELL_ROW_167_1427 VDD VSS gf180mcu_as_sc_mcu7t3v3__tap_2
XTAP_TAPCELL_ROW_167_1416 VDD VSS gf180mcu_as_sc_mcu7t3v3__tap_2
X_5248_ VDD VDD VSS VSS _5266_/CLK _5248_/D _5248_/Q gf180mcu_as_sc_mcu7t3v3__dfxtp_2
XTAP_TAPCELL_ROW_137_1_1090 VDD VSS gf180mcu_as_sc_mcu7t3v3__tap_2
X_5179_ VDD VDD VSS VSS _5181_/CLK _5179_/D _5179_/Q gf180mcu_as_sc_mcu7t3v3__dfxtp_2
XTAP_TAPCELL_ROW_4_767 VDD VSS gf180mcu_as_sc_mcu7t3v3__tap_2
XTAP_TAPCELL_ROW_184_1741 VDD VSS gf180mcu_as_sc_mcu7t3v3__tap_2
XFILLER_169_334 VDD VDD VSS VSS gf180mcu_as_sc_mcu7t3v3__fill_2
XFILLER_124_2 VDD VDD VSS VSS gf180mcu_as_sc_mcu7t3v3__fill_1
XFILLER_165_562 VDD VDD VSS VSS gf180mcu_as_sc_mcu7t3v3__fill_1
XFILLER_180_587 VDD VDD VSS VSS gf180mcu_as_sc_mcu7t3v3__fillcap_8
XFILLER_10_93 VDD VDD VSS VSS gf180mcu_as_sc_mcu7t3v3__fill_1
XFILLER_82_1291 VDD VDD VSS VSS gf180mcu_as_sc_mcu7t3v3__fillcap_8
XFILLER_86_64 VDD VDD VSS VSS gf180mcu_as_sc_mcu7t3v3__fill_1
XFILLER_86_86 VDD VDD VSS VSS gf180mcu_as_sc_mcu7t3v3__fillcap_8
XFILLER_130_1256 VDD VDD VSS VSS gf180mcu_as_sc_mcu7t3v3__fillcap_8
XFILLER_142_70 VDD VDD VSS VSS gf180mcu_as_sc_mcu7t3v3__fillcap_4
XFILLER_163_1032 VDD VDD VSS VSS gf180mcu_as_sc_mcu7t3v3__fill_1
XFILLER_187_120 VDD VDD VSS VSS gf180mcu_as_sc_mcu7t3v3__fill_2
XFILLER_187_142 VDD VDD VSS VSS gf180mcu_as_sc_mcu7t3v3__fillcap_4
XFILLER_188_643 VDD VDD VSS VSS gf180mcu_as_sc_mcu7t3v3__fillcap_8
X_2880_ VDD VDD VSS VSS _2882_/C _4329_/A _2880_/B _4643_/B gf180mcu_as_sc_mcu7t3v3__ao21_2
XFILLER_15_1300 VDD VDD VSS VSS gf180mcu_as_sc_mcu7t3v3__fillcap_8
XFILLER_188_698 VDD VDD VSS VSS gf180mcu_as_sc_mcu7t3v3__fill_2
XFILLER_169_890 VDD VDD VSS VSS gf180mcu_as_sc_mcu7t3v3__fillcap_16
XFILLER_190_307 VDD VDD VSS VSS gf180mcu_as_sc_mcu7t3v3__fillcap_8
X_4550_ VDD VDD VSS VSS _4553_/B _4550_/A gf180mcu_as_sc_mcu7t3v3__inv_2
Xwire470 VDD VDD VSS VSS _3573_/Y _4839_/D gf180mcu_as_sc_mcu7t3v3__clkbuff_12
Xwire481 VDD VDD VSS VSS _3706_/A _3730_/A gf180mcu_as_sc_mcu7t3v3__clkbuff_12
X_4481_ VDD VDD VSS VSS _4482_/C _4536_/S _5018_/Q _4538_/A gf180mcu_as_sc_mcu7t3v3__ao21_2
X_3501_ VDD VDD VSS VSS _4160_/D _3501_/B _3501_/C _4159_/A _3502_/D gf180mcu_as_sc_mcu7t3v3__ao22_2
X_3432_ VDD VDD VSS VSS _4083_/A _3432_/B _3432_/C _4823_/D _3638_/D gf180mcu_as_sc_mcu7t3v3__aoi211_2
XTAP_TAPCELL_ROW_44_3_1955 VDD VSS gf180mcu_as_sc_mcu7t3v3__tap_2
X_3363_ VDD VDD VSS VSS _3449_/B _4013_/D _3363_/A _3364_/D gf180mcu_as_sc_mcu7t3v3__mux2_2
XFILLER_170_1014 VDD VDD VSS VSS gf180mcu_as_sc_mcu7t3v3__fill_1
XFILLER_170_1025 VDD VDD VSS VSS gf180mcu_as_sc_mcu7t3v3__fillcap_4
XFILLER_174_1161 VDD VDD VSS VSS gf180mcu_as_sc_mcu7t3v3__fill_2
X_5102_ VDD VDD VSS VSS _5266_/CLK _5102_/D _5102_/Q gf180mcu_as_sc_mcu7t3v3__dfxtp_2
XFILLER_170_1058 VDD VDD VSS VSS gf180mcu_as_sc_mcu7t3v3__fillcap_8
X_3294_ VDD VDD VSS VSS _3938_/D _3372_/B _3294_/C _3294_/D _3295_/C gf180mcu_as_sc_mcu7t3v3__ao211_2
X_5033_ VDD VDD VSS VSS _5175_/CLK _5033_/D _5033_/Q gf180mcu_as_sc_mcu7t3v3__dfxtp_2
XTAP_TAPCELL_ROW_1_715 VDD VSS gf180mcu_as_sc_mcu7t3v3__tap_2
XTAP_TAPCELL_ROW_1_704 VDD VSS gf180mcu_as_sc_mcu7t3v3__tap_2
XTAP_TAPCELL_ROW_162_1324 VDD VSS gf180mcu_as_sc_mcu7t3v3__tap_2
XFILLER_0_1155 VDD VDD VSS VSS gf180mcu_as_sc_mcu7t3v3__fill_1
XFILLER_179_621 VDD VDD VSS VSS gf180mcu_as_sc_mcu7t3v3__fillcap_8
XFILLER_179_632 VDD VDD VSS VSS gf180mcu_as_sc_mcu7t3v3__fillcap_8
XFILLER_181_1132 VDD VDD VSS VSS gf180mcu_as_sc_mcu7t3v3__fill_1
XFILLER_179_676 VDD VDD VSS VSS gf180mcu_as_sc_mcu7t3v3__fillcap_16
X_4817_ VDD VDD VSS VSS clkload6/A _4817_/D _4817_/Q gf180mcu_as_sc_mcu7t3v3__dfxtp_2
XFILLER_166_348 VDD VDD VSS VSS gf180mcu_as_sc_mcu7t3v3__fill_1
XFILLER_181_1198 VDD VDD VSS VSS gf180mcu_as_sc_mcu7t3v3__fill_1
X_4748_ VDD VDD VSS VSS _4748_/A _4748_/B _4750_/B _5277_/Q _5277_/D gf180mcu_as_sc_mcu7t3v3__ao22_2
X_4679_ VDD VDD VSS VSS _5247_/Q _4685_/C _4681_/C _5248_/Q _4680_/C gf180mcu_as_sc_mcu7t3v3__ao22_2
XPHY_EDGE_ROW_1_Right_1 VDD VSS gf180mcu_as_sc_mcu7t3v3__tap_2
XFILLER_0_203 VDD VDD VSS VSS gf180mcu_as_sc_mcu7t3v3__fill_1
XTAP_TAPCELL_ROW_9_859 VDD VSS gf180mcu_as_sc_mcu7t3v3__tap_2
XFILLER_118_1354 VDD VDD VSS VSS gf180mcu_as_sc_mcu7t3v3__fill_1
XFILLER_153_1245 VDD VDD VSS VSS gf180mcu_as_sc_mcu7t3v3__fillcap_8
XFILLER_163_69 VDD VDD VSS VSS gf180mcu_as_sc_mcu7t3v3__fill_1
Xinput104 VDD VDD VSS VSS ne_in[33] _3530_/A gf180mcu_as_sc_mcu7t3v3__buff_12
Xinput115 VDD VDD VSS VSS north_in[12] wire905/A gf180mcu_as_sc_mcu7t3v3__buff_12
Xinput126 VDD VDD VSS VSS north_in[22] _4112_/A gf180mcu_as_sc_mcu7t3v3__buff_12
Xinput137 VDD VDD VSS VSS north_in[32] _3519_/A gf180mcu_as_sc_mcu7t3v3__buff_12
Xinput148 VDD VDD VSS VSS nw_in[11] _4022_/A gf180mcu_as_sc_mcu7t3v3__buff_12
Xinput159 VDD VDD VSS VSS nw_in[21] wire900/A gf180mcu_as_sc_mcu7t3v3__buff_12
XTAP_TAPCELL_ROW_148_3_2059 VDD VSS gf180mcu_as_sc_mcu7t3v3__tap_2
XFILLER_186_1087 VDD VDD VSS VSS gf180mcu_as_sc_mcu7t3v3__fillcap_4
XFILLER_125_1303 VDD VDD VSS VSS gf180mcu_as_sc_mcu7t3v3__fill_2
XFILLER_13_844 VDD VDD VSS VSS gf180mcu_as_sc_mcu7t3v3__fill_2
XFILLER_160_1227 VDD VDD VSS VSS gf180mcu_as_sc_mcu7t3v3__fillcap_4
XFILLER_184_101 VDD VDD VSS VSS gf180mcu_as_sc_mcu7t3v3__fillcap_4
XFILLER_9_826 VDD VDD VSS VSS gf180mcu_as_sc_mcu7t3v3__fillcap_4
XFILLER_12_376 VDD VDD VSS VSS gf180mcu_as_sc_mcu7t3v3__fillcap_8
XFILLER_12_387 VDD VDD VSS VSS gf180mcu_as_sc_mcu7t3v3__fillcap_8
XFILLER_169_197 VDD VDD VSS VSS gf180mcu_as_sc_mcu7t3v3__fillcap_8
XFILLER_185_657 VDD VDD VSS VSS gf180mcu_as_sc_mcu7t3v3__fillcap_16
XFILLER_166_860 VDD VDD VSS VSS gf180mcu_as_sc_mcu7t3v3__fillcap_8
XFILLER_173_819 VDD VDD VSS VSS gf180mcu_as_sc_mcu7t3v3__fill_2
X_4896__1072 VDD VDD VSS VSS _4896_/D gf180mcu_as_sc_mcu7t3v3__tiel_4
XFILLER_158_1145 VDD VDD VSS VSS gf180mcu_as_sc_mcu7t3v3__fillcap_8
XFILLER_180_373 VDD VDD VSS VSS gf180mcu_as_sc_mcu7t3v3__fillcap_4
XFILLER_45_1326 VDD VDD VSS VSS gf180mcu_as_sc_mcu7t3v3__fillcap_4
XFILLER_4_597 VDD VDD VSS VSS gf180mcu_as_sc_mcu7t3v3__fillcap_4
XFILLER_84_1353 VDD VDD VSS VSS gf180mcu_as_sc_mcu7t3v3__fill_2
XFILLER_132_1318 VDD VDD VSS VSS gf180mcu_as_sc_mcu7t3v3__fill_2
XFILLER_0_781 VDD VDD VSS VSS gf180mcu_as_sc_mcu7t3v3__fill_1
XFILLER_0_792 VDD VDD VSS VSS gf180mcu_as_sc_mcu7t3v3__fill_1
XFILLER_153_80 VDD VDD VSS VSS gf180mcu_as_sc_mcu7t3v3__fillcap_4
XFILLER_165_1138 VDD VDD VSS VSS gf180mcu_as_sc_mcu7t3v3__fillcap_16
X_3981_ VDD VDD VSS VSS _3981_/A _4021_/C _4024_/C _3981_/D _3983_/C gf180mcu_as_sc_mcu7t3v3__ao22_2
X_2932_ VDD VDD VSS VSS _3236_/B _3233_/C _2932_/C _3216_/B _2947_/A gf180mcu_as_sc_mcu7t3v3__nand4_2
XFILLER_188_451 VDD VDD VSS VSS gf180mcu_as_sc_mcu7t3v3__fillcap_4
XFILLER_175_134 VDD VDD VSS VSS gf180mcu_as_sc_mcu7t3v3__fillcap_4
X_2863_ VDD VDD VSS VSS _4767_/Q _4763_/Q _2865_/B gf180mcu_as_sc_mcu7t3v3__and2_2
X_4602_ VDD VDD VSS VSS _5196_/Q _4609_/B _4609_/C _5197_/Q _5196_/D gf180mcu_as_sc_mcu7t3v3__ao22_2
X_2794_ VDD VDD VSS VSS _2794_/B _2794_/A _4626_/A gf180mcu_as_sc_mcu7t3v3__xnor2_2
XFILLER_106_1291 VDD VDD VSS VSS gf180mcu_as_sc_mcu7t3v3__fillcap_8
XFILLER_163_329 VDD VDD VSS VSS gf180mcu_as_sc_mcu7t3v3__fillcap_4
XFILLER_8_870 VDD VDD VSS VSS gf180mcu_as_sc_mcu7t3v3__fillcap_4
X_4533_ VDD VDD VSS VSS _4533_/B _4541_/A _4539_/C gf180mcu_as_sc_mcu7t3v3__and2_2
XFILLER_7_83 VDD VDD VSS VSS gf180mcu_as_sc_mcu7t3v3__fillcap_8
XTAP_TAPCELL_ROW_155_1194 VDD VSS gf180mcu_as_sc_mcu7t3v3__tap_2
XTAP_TAPCELL_ROW_155_1183 VDD VSS gf180mcu_as_sc_mcu7t3v3__tap_2
X_4464_ VDD VDD VSS VSS _4465_/D _4464_/B _4581_/A gf180mcu_as_sc_mcu7t3v3__nor2_2
XFILLER_176_1289 VDD VDD VSS VSS gf180mcu_as_sc_mcu7t3v3__fillcap_4
Xclkbuf_leaf_35_clk_regs VDD VDD VSS VSS clkbuf_leaf_7_clk_regs/A clkload6/A gf180mcu_as_sc_mcu7t3v3__clkbuff_12
Xfanout805 VDD VDD VSS VSS _5228_/Q _2847_/A gf180mcu_as_sc_mcu7t3v3__buff_12
Xfanout816 VDD VDD VSS VSS _4561_/A _4502_/A gf180mcu_as_sc_mcu7t3v3__buff_12
X_4395_ VDD VDD VSS VSS _4398_/C _4395_/B _4553_/D gf180mcu_as_sc_mcu7t3v3__nor2_2
X_3415_ VDD VDD VSS VSS _3454_/A _3415_/B _3415_/C _3416_/C gf180mcu_as_sc_mcu7t3v3__nor3_2
XTAP_TAPCELL_ROW_6_807 VDD VSS gf180mcu_as_sc_mcu7t3v3__tap_2
XPHY_EDGE_ROW_117_1_Left_309 VDD VSS gf180mcu_as_sc_mcu7t3v3__tap_2
Xfanout827 VDD VDD VSS VSS fanout837/Y _4559_/S gf180mcu_as_sc_mcu7t3v3__buff_12
Xfanout838 VDD VDD VSS VSS _2631_/C _2732_/S gf180mcu_as_sc_mcu7t3v3__buff_12
Xfanout849 VDD VDD VSS VSS _2394_/Y fanout849/Y gf180mcu_as_sc_mcu7t3v3__buff_12
X_3346_ VDD VDD VSS VSS _3501_/C _4000_/A _3347_/D gf180mcu_as_sc_mcu7t3v3__and2_2
X_5016_ VDD VDD VSS VSS clkload9/A _5016_/D _5016_/Q gf180mcu_as_sc_mcu7t3v3__dfxtp_2
X_3277_ VDD VDD VSS VSS _3522_/B _3814_/B _3280_/D gf180mcu_as_sc_mcu7t3v3__nor2_2
XFILLER_2_1217 VDD VDD VSS VSS gf180mcu_as_sc_mcu7t3v3__fillcap_8
XFILLER_187_1352 VDD VDD VSS VSS gf180mcu_as_sc_mcu7t3v3__fill_2
XFILLER_183_1216 VDD VDD VSS VSS gf180mcu_as_sc_mcu7t3v3__fill_2
XFILLER_26_59 VDD VDD VSS VSS gf180mcu_as_sc_mcu7t3v3__fill_2
XTAP_TAPCELL_ROW_179_1640 VDD VSS gf180mcu_as_sc_mcu7t3v3__tap_2
XFILLER_10_803 VDD VDD VSS VSS gf180mcu_as_sc_mcu7t3v3__fill_2
XTAP_TAPCELL_ROW_179_1651 VDD VSS gf180mcu_as_sc_mcu7t3v3__tap_2
XFILLER_10_825 VDD VDD VSS VSS gf180mcu_as_sc_mcu7t3v3__fillcap_4
XFILLER_155_819 VDD VDD VSS VSS gf180mcu_as_sc_mcu7t3v3__fill_1
XFILLER_33_1296 VDD VDD VSS VSS gf180mcu_as_sc_mcu7t3v3__fill_1
XFILLER_6_829 VDD VDD VSS VSS gf180mcu_as_sc_mcu7t3v3__fillcap_16
XTAP_TAPCELL_ROW_192_1895 VDD VSS gf180mcu_as_sc_mcu7t3v3__tap_2
XFILLER_163_874 VDD VDD VSS VSS gf180mcu_as_sc_mcu7t3v3__fill_2
XFILLER_153_1064 VDD VDD VSS VSS gf180mcu_as_sc_mcu7t3v3__fillcap_8
XFILLER_190_34 VDD VDD VSS VSS gf180mcu_as_sc_mcu7t3v3__fill_1
XFILLER_1_589 VDD VDD VSS VSS gf180mcu_as_sc_mcu7t3v3__fill_1
XFILLER_67_99 VDD VDD VSS VSS gf180mcu_as_sc_mcu7t3v3__fillcap_4
XFILLER_190_78 VDD VDD VSS VSS gf180mcu_as_sc_mcu7t3v3__fill_2
XPHY_EDGE_ROW_102_3_Left_474 VDD VSS gf180mcu_as_sc_mcu7t3v3__tap_2
XFILLER_123_83 VDD VDD VSS VSS gf180mcu_as_sc_mcu7t3v3__fillcap_16
XFILLER_13_652 VDD VDD VSS VSS gf180mcu_as_sc_mcu7t3v3__fill_2
XFILLER_158_613 VDD VDD VSS VSS gf180mcu_as_sc_mcu7t3v3__fill_1
XFILLER_158_646 VDD VDD VSS VSS gf180mcu_as_sc_mcu7t3v3__fillcap_16
XFILLER_9_623 VDD VDD VSS VSS gf180mcu_as_sc_mcu7t3v3__fill_1
XFILLER_172_104 VDD VDD VSS VSS gf180mcu_as_sc_mcu7t3v3__fill_1
XFILLER_185_487 VDD VDD VSS VSS gf180mcu_as_sc_mcu7t3v3__fill_2
XFILLER_8_177 VDD VDD VSS VSS gf180mcu_as_sc_mcu7t3v3__fillcap_16
Xoutput408 VDD VDD VSS VSS _4828_/Q south_out[23] gf180mcu_as_sc_mcu7t3v3__buff_12
XTAP_TAPCELL_ROW_11_897 VDD VSS gf180mcu_as_sc_mcu7t3v3__tap_2
XFILLER_154_874 VDD VDD VSS VSS gf180mcu_as_sc_mcu7t3v3__fill_1
Xoutput419 VDD VDD VSS VSS _4838_/Q south_out[33] gf180mcu_as_sc_mcu7t3v3__buff_12
XFILLER_4_383 VDD VDD VSS VSS gf180mcu_as_sc_mcu7t3v3__fill_2
X_4180_ VDD VDD VSS VSS _4240_/B _4186_/B _4186_/C _5018_/Q _5018_/D gf180mcu_as_sc_mcu7t3v3__ao22_2
X_3200_ VDD VDD VSS VSS _3203_/A _3236_/C _3788_/D gf180mcu_as_sc_mcu7t3v3__nand2_2
X_3131_ VDD VDD VSS VSS _3131_/A _3131_/B _3131_/C _3132_/C gf180mcu_as_sc_mcu7t3v3__nor3_2
XTAP_TAPCELL_ROW_39_3_1950 VDD VSS gf180mcu_as_sc_mcu7t3v3__tap_2
X_3062_ VDD VDD VSS VSS _3062_/B _4928_/Q _3063_/D gf180mcu_as_sc_mcu7t3v3__or2_2
XPHY_EDGE_ROW_95_1_Left_287 VDD VSS gf180mcu_as_sc_mcu7t3v3__tap_2
X_3964_ VDD VDD VSS VSS _4981_/Q _4076_/B _4232_/B _4076_/D _4981_/D gf180mcu_as_sc_mcu7t3v3__ao22_2
X_3895_ VDD VDD VSS VSS _3895_/B _5185_/Q _4935_/D gf180mcu_as_sc_mcu7t3v3__and2_2
X_2915_ VDD VDD VSS VSS _3787_/A _3255_/B _3544_/C _3201_/C _3222_/D gf180mcu_as_sc_mcu7t3v3__aoi31_2
XTAP_TAPCELL_ROW_157_1223 VDD VSS gf180mcu_as_sc_mcu7t3v3__tap_2
XFILLER_164_605 VDD VDD VSS VSS gf180mcu_as_sc_mcu7t3v3__fill_2
X_2846_ VDD VDD VSS VSS _5277_/Q _2847_/A _4708_/C _2847_/C _4748_/B gf180mcu_as_sc_mcu7t3v3__aoi31_2
XTAP_TAPCELL_ROW_157_1234 VDD VSS gf180mcu_as_sc_mcu7t3v3__tap_2
X_2777_ VDD VDD VSS VSS _2778_/B _4739_/A _5269_/Q _5272_/Q gf180mcu_as_sc_mcu7t3v3__aoi21b_2
XFILLER_160_800 VDD VDD VSS VSS gf180mcu_as_sc_mcu7t3v3__fillcap_4
XFILLER_160_811 VDD VDD VSS VSS gf180mcu_as_sc_mcu7t3v3__fill_2
X_4516_ VDD VDD VSS VSS _4520_/B _5080_/Q _4525_/A gf180mcu_as_sc_mcu7t3v3__nand2_2
XTAP_TAPCELL_ROW_170_1467 VDD VSS gf180mcu_as_sc_mcu7t3v3__tap_2
XFILLER_171_192 VDD VDD VSS VSS gf180mcu_as_sc_mcu7t3v3__fillcap_4
X_4447_ VDD VDD VSS VSS _4579_/S _5014_/Q _5043_/Q _4448_/B gf180mcu_as_sc_mcu7t3v3__mux2_2
XTAP_TAPCELL_ROW_170_1478 VDD VSS gf180mcu_as_sc_mcu7t3v3__tap_2
XFILLER_144_27 VDD VDD VSS VSS gf180mcu_as_sc_mcu7t3v3__fillcap_8
XFILLER_160_866 VDD VDD VSS VSS gf180mcu_as_sc_mcu7t3v3__fill_2
Xfanout602 VDD VDD VSS VSS _3885_/B _3905_/B gf180mcu_as_sc_mcu7t3v3__buff_12
Xfanout613 VDD VDD VSS VSS _4514_/B _4554_/B gf180mcu_as_sc_mcu7t3v3__buff_12
Xfanout624 VDD VDD VSS VSS _2576_/Y _2639_/S gf180mcu_as_sc_mcu7t3v3__buff_12
XFILLER_63_1256 VDD VDD VSS VSS gf180mcu_as_sc_mcu7t3v3__fillcap_8
Xfanout646 VDD VDD VSS VSS _3550_/Y _3551_/B gf180mcu_as_sc_mcu7t3v3__buff_12
Xfanout657 VDD VDD VSS VSS fanout658/A _3451_/B gf180mcu_as_sc_mcu7t3v3__buff_12
X_4378_ VDD VDD VSS VSS _5485_/A _4590_/C _4378_/C _4378_/D _4380_/A gf180mcu_as_sc_mcu7t3v3__ao211_2
Xfanout679 VDD VDD VSS VSS _4629_/C _4611_/C gf180mcu_as_sc_mcu7t3v3__buff_12
X_3329_ VDD VDD VSS VSS _3981_/D _3370_/B _3329_/C _3386_/D _3331_/C gf180mcu_as_sc_mcu7t3v3__ao211_2
XFILLER_160_26 VDD VDD VSS VSS gf180mcu_as_sc_mcu7t3v3__fill_1
XFILLER_37_69 VDD VDD VSS VSS gf180mcu_as_sc_mcu7t3v3__fill_1
XFILLER_163_6 VDD VDD VSS VSS gf180mcu_as_sc_mcu7t3v3__fillcap_16
XFILLER_168_900 VDD VDD VSS VSS gf180mcu_as_sc_mcu7t3v3__fillcap_16
XFILLER_183_1068 VDD VDD VSS VSS gf180mcu_as_sc_mcu7t3v3__fillcap_8
XFILLER_53_57 VDD VDD VSS VSS gf180mcu_as_sc_mcu7t3v3__fill_2
XFILLER_169_68 VDD VDD VSS VSS gf180mcu_as_sc_mcu7t3v3__fill_2
XFILLER_10_677 VDD VDD VSS VSS gf180mcu_as_sc_mcu7t3v3__fillcap_16
XFILLER_182_468 VDD VDD VSS VSS gf180mcu_as_sc_mcu7t3v3__fillcap_4
XFILLER_185_34 VDD VDD VSS VSS gf180mcu_as_sc_mcu7t3v3__fillcap_16
XFILLER_159_1262 VDD VDD VSS VSS gf180mcu_as_sc_mcu7t3v3__fillcap_4
XFILLER_163_660 VDD VDD VSS VSS gf180mcu_as_sc_mcu7t3v3__fill_1
XFILLER_2_843 VDD VDD VSS VSS gf180mcu_as_sc_mcu7t3v3__fill_1
XFILLER_78_43 VDD VDD VSS VSS gf180mcu_as_sc_mcu7t3v3__fill_1
Xmesh_tile_1001 VDD VDD VSS VSS nw_out[7] gf180mcu_as_sc_mcu7t3v3__tiel_4
Xmesh_tile_1034 VDD VDD VSS VSS sw_out[6] gf180mcu_as_sc_mcu7t3v3__tiel_4
Xmesh_tile_1023 VDD VDD VSS VSS nw_out[29] gf180mcu_as_sc_mcu7t3v3__tiel_4
Xmesh_tile_1012 VDD VDD VSS VSS nw_out[18] gf180mcu_as_sc_mcu7t3v3__tiel_4
Xmesh_tile_1056 VDD VDD VSS VSS sw_out[28] gf180mcu_as_sc_mcu7t3v3__tiel_4
Xmesh_tile_1045 VDD VDD VSS VSS sw_out[17] gf180mcu_as_sc_mcu7t3v3__tiel_4
XPHY_EDGE_ROW_60_3_Right_101 VDD VSS gf180mcu_as_sc_mcu7t3v3__tap_2
XFILLER_158_454 VDD VDD VSS VSS gf180mcu_as_sc_mcu7t3v3__fill_1
XFILLER_186_752 VDD VDD VSS VSS gf180mcu_as_sc_mcu7t3v3__fillcap_8
X_2700_ VDD VDD VSS VSS _2736_/B _2700_/A _2701_/D gf180mcu_as_sc_mcu7t3v3__and2_2
XFILLER_145_104 VDD VDD VSS VSS gf180mcu_as_sc_mcu7t3v3__fill_1
XFILLER_159_90 VDD VDD VSS VSS gf180mcu_as_sc_mcu7t3v3__fillcap_16
XFILLER_159_999 VDD VDD VSS VSS gf180mcu_as_sc_mcu7t3v3__fill_2
XFILLER_174_925 VDD VDD VSS VSS gf180mcu_as_sc_mcu7t3v3__fillcap_16
XFILLER_174_947 VDD VDD VSS VSS gf180mcu_as_sc_mcu7t3v3__fillcap_4
XFILLER_9_464 VDD VDD VSS VSS gf180mcu_as_sc_mcu7t3v3__fill_1
X_3680_ VDD VDD VSS VSS _4930_/Q _3727_/B _3727_/C _4053_/D _3681_/D gf180mcu_as_sc_mcu7t3v3__ao22_2
XFILLER_16_1291 VDD VDD VSS VSS gf180mcu_as_sc_mcu7t3v3__fill_1
X_2631_ VDD VDD VSS VSS _2631_/D _5232_/Q _5229_/Q _2631_/C _2636_/A gf180mcu_as_sc_mcu7t3v3__ao31_2
XTAP_TAPCELL_ROW_152_1120 VDD VSS gf180mcu_as_sc_mcu7t3v3__tap_2
XFILLER_154_671 VDD VDD VSS VSS gf180mcu_as_sc_mcu7t3v3__fill_1
XFILLER_160_107 VDD VDD VSS VSS gf180mcu_as_sc_mcu7t3v3__fill_2
X_2562_ VDD VDD VSS VSS _4975_/D _4769_/Q _4770_/Q _2631_/C _2601_/D gf180mcu_as_sc_mcu7t3v3__ao22_2
XTAP_TAPCELL_ROW_152_1142 VDD VSS gf180mcu_as_sc_mcu7t3v3__tap_2
XTAP_TAPCELL_ROW_152_1131 VDD VSS gf180mcu_as_sc_mcu7t3v3__tap_2
XFILLER_154_693 VDD VDD VSS VSS gf180mcu_as_sc_mcu7t3v3__fill_1
XFILLER_86_1256 VDD VDD VSS VSS gf180mcu_as_sc_mcu7t3v3__fillcap_16
X_5281_ VDD VDD VSS VSS _5285_/CLK _5281_/D _5281_/Q gf180mcu_as_sc_mcu7t3v3__dfxtp_2
X_4301_ VDD VDD VSS VSS _4326_/S _5131_/Q _5130_/Q _5130_/D gf180mcu_as_sc_mcu7t3v3__mux2_2
XFILLER_173_1237 VDD VDD VSS VSS gf180mcu_as_sc_mcu7t3v3__fill_2
X_4232_ VDD VDD VSS VSS _4246_/S _4232_/B _5068_/Q _5068_/D gf180mcu_as_sc_mcu7t3v3__mux2_2
X_2493_ VDD VDD VSS VSS _5189_/Q _4954_/Q _2794_/B gf180mcu_as_sc_mcu7t3v3__xnor2_2
X_4163_ VDD VDD VSS VSS _4163_/A _4163_/B _4163_/C _4163_/D _4164_/B gf180mcu_as_sc_mcu7t3v3__ao211_2
XFILLER_82_102 VDD VDD VSS VSS gf180mcu_as_sc_mcu7t3v3__fill_2
X_4094_ VDD VDD VSS VSS _4094_/A _4162_/B _4127_/C _4094_/D _4098_/A gf180mcu_as_sc_mcu7t3v3__ao211_2
X_3114_ VDD VDD VSS VSS _3115_/C _3114_/C _3192_/C _4085_/A gf180mcu_as_sc_mcu7t3v3__aoi21_2
X_3045_ VDD VDD VSS VSS _3045_/A _3045_/B _3045_/C _3045_/D _3047_/C gf180mcu_as_sc_mcu7t3v3__ao211_2
XTAP_TAPCELL_ROW_86_1_1039 VDD VSS gf180mcu_as_sc_mcu7t3v3__tap_2
XFILLER_110_1276 VDD VDD VSS VSS gf180mcu_as_sc_mcu7t3v3__fill_1
XFILLER_168_207 VDD VDD VSS VSS gf180mcu_as_sc_mcu7t3v3__fill_2
X_4996_ VDD VDD VSS VSS _5182_/CLK _4996_/D _4996_/Q gf180mcu_as_sc_mcu7t3v3__dfxtp_2
XFILLER_11_419 VDD VDD VSS VSS gf180mcu_as_sc_mcu7t3v3__fill_1
X_3947_ VDD VDD VSS VSS _3947_/A _4021_/B _4021_/C _3947_/D _3948_/D gf180mcu_as_sc_mcu7t3v3__ao22_2
XFILLER_139_27 VDD VDD VSS VSS gf180mcu_as_sc_mcu7t3v3__fillcap_16
XFILLER_165_903 VDD VDD VSS VSS gf180mcu_as_sc_mcu7t3v3__fillcap_4
XFILLER_177_763 VDD VDD VSS VSS gf180mcu_as_sc_mcu7t3v3__fillcap_4
XFILLER_23_38 VDD VDD VSS VSS gf180mcu_as_sc_mcu7t3v3__fill_2
XPHY_EDGE_ROW_12_Left_205 VDD VSS gf180mcu_as_sc_mcu7t3v3__tap_2
XFILLER_164_402 VDD VDD VSS VSS gf180mcu_as_sc_mcu7t3v3__fillcap_4
XFILLER_176_251 VDD VDD VSS VSS gf180mcu_as_sc_mcu7t3v3__fill_2
X_3878_ VDD VDD VSS VSS _4946_/D _5168_/Q _4918_/D gf180mcu_as_sc_mcu7t3v3__and2_2
XTAP_TAPCELL_ROW_172_1518 VDD VSS gf180mcu_as_sc_mcu7t3v3__tap_2
XTAP_TAPCELL_ROW_172_1507 VDD VSS gf180mcu_as_sc_mcu7t3v3__tap_2
X_2829_ VDD VDD VSS VSS _4751_/A _2829_/B _5284_/Q _5283_/D gf180mcu_as_sc_mcu7t3v3__mux2_2
XFILLER_164_468 VDD VDD VSS VSS gf180mcu_as_sc_mcu7t3v3__fillcap_8
XFILLER_180_928 VDD VDD VSS VSS gf180mcu_as_sc_mcu7t3v3__fillcap_16
XFILLER_30_1299 VDD VDD VSS VSS gf180mcu_as_sc_mcu7t3v3__fill_2
XFILLER_160_652 VDD VDD VSS VSS gf180mcu_as_sc_mcu7t3v3__fill_2
X_5479_ VDD VDD VSS VSS _5479_/A _5479_/Y gf180mcu_as_sc_mcu7t3v3__buff_2
XFILLER_160_696 VDD VDD VSS VSS gf180mcu_as_sc_mcu7t3v3__fill_1
XFILLER_154_1192 VDD VDD VSS VSS gf180mcu_as_sc_mcu7t3v3__fill_2
Xfanout476 VDD VDD VSS VSS fanout479/Y _4166_/B gf180mcu_as_sc_mcu7t3v3__buff_12
Xfanout498 VDD VDD VSS VSS fanout502/Y _4076_/D gf180mcu_as_sc_mcu7t3v3__buff_12
XTAP_TAPCELL_ROW_187_1794 VDD VSS gf180mcu_as_sc_mcu7t3v3__tap_2
XPHY_EDGE_ROW_169_Left_361 VDD VSS gf180mcu_as_sc_mcu7t3v3__tap_2
XFILLER_159_207 VDD VDD VSS VSS gf180mcu_as_sc_mcu7t3v3__fill_2
XFILLER_187_527 VDD VDD VSS VSS gf180mcu_as_sc_mcu7t3v3__fillcap_16
XFILLER_39_1291 VDD VDD VSS VSS gf180mcu_as_sc_mcu7t3v3__fillcap_8
XFILLER_156_903 VDD VDD VSS VSS gf180mcu_as_sc_mcu7t3v3__fill_1
XTAP_TAPCELL_ROW_13_959 VDD VSS gf180mcu_as_sc_mcu7t3v3__tap_2
XTAP_TAPCELL_ROW_13_948 VDD VSS gf180mcu_as_sc_mcu7t3v3__tap_2
XTAP_TAPCELL_ROW_13_937 VDD VSS gf180mcu_as_sc_mcu7t3v3__tap_2
XFILLER_127_104 VDD VDD VSS VSS gf180mcu_as_sc_mcu7t3v3__fill_1
XFILLER_155_424 VDD VDD VSS VSS gf180mcu_as_sc_mcu7t3v3__fill_1
XFILLER_156_947 VDD VDD VSS VSS gf180mcu_as_sc_mcu7t3v3__fillcap_8
Xwire855 VDD VDD VSS VSS wire855/A _3517_/A gf180mcu_as_sc_mcu7t3v3__clkbuff_12
Xwire866 VDD VDD VSS VSS wire866/A _3933_/A gf180mcu_as_sc_mcu7t3v3__clkbuff_12
Xwire877 VDD VDD VSS VSS wire877/A _3969_/A gf180mcu_as_sc_mcu7t3v3__clkbuff_12
XFILLER_171_939 VDD VDD VSS VSS gf180mcu_as_sc_mcu7t3v3__fillcap_4
XFILLER_183_788 VDD VDD VSS VSS gf180mcu_as_sc_mcu7t3v3__fillcap_8
XFILLER_7_979 VDD VDD VSS VSS gf180mcu_as_sc_mcu7t3v3__fill_1
Xwire899 VDD VDD VSS VSS wire899/A _3803_/C gf180mcu_as_sc_mcu7t3v3__clkbuff_12
XPHY_EDGE_ROW_178_Left_370 VDD VSS gf180mcu_as_sc_mcu7t3v3__tap_2
XFILLER_170_449 VDD VDD VSS VSS gf180mcu_as_sc_mcu7t3v3__fillcap_4
XFILLER_46_1295 VDD VDD VSS VSS gf180mcu_as_sc_mcu7t3v3__fill_2
Xclkbuf_2_3_0_clk_regs VDD VDD VSS VSS clkbuf_0_clk_regs/Y clkbuf_2_3_0_clk_regs/Y
+ gf180mcu_as_sc_mcu7t3v3__clkbuff_12
XFILLER_166_1041 VDD VDD VSS VSS gf180mcu_as_sc_mcu7t3v3__fillcap_16
X_4850_ VDD VDD VSS VSS _5150_/CLK _4850_/D _4850_/Q gf180mcu_as_sc_mcu7t3v3__dfxtp_2
XFILLER_159_730 VDD VDD VSS VSS gf180mcu_as_sc_mcu7t3v3__fill_1
XFILLER_178_527 VDD VDD VSS VSS gf180mcu_as_sc_mcu7t3v3__fill_1
X_3801_ VDD VDD VSS VSS _3801_/D _3801_/A _3801_/B _3801_/C _3802_/D gf180mcu_as_sc_mcu7t3v3__ao31_2
X_4781_ VDD VDD VSS VSS _5216_/CLK _4781_/D _4781_/Q gf180mcu_as_sc_mcu7t3v3__dfxtp_2
XPHY_EDGE_ROW_61_3_Right_102 VDD VSS gf180mcu_as_sc_mcu7t3v3__tap_2
XPHY_EDGE_ROW_126_1_Left_318 VDD VSS gf180mcu_as_sc_mcu7t3v3__tap_2
X_3732_ VDD VDD VSS VSS _4113_/A _3779_/B _3748_/C _4112_/A _3733_/C gf180mcu_as_sc_mcu7t3v3__ao22_2
XFILLER_173_232 VDD VDD VSS VSS gf180mcu_as_sc_mcu7t3v3__fill_2
XFILLER_9_294 VDD VDD VSS VSS gf180mcu_as_sc_mcu7t3v3__fillcap_16
Xclkload20 VDD VDD VSS VSS clkload20/Y _5275_/CLK gf180mcu_as_sc_mcu7t3v3__inv_2
X_3663_ VDD VDD VSS VSS _3664_/C _4037_/D _3725_/B _3663_/C gf180mcu_as_sc_mcu7t3v3__ao21_2
XFILLER_161_416 VDD VDD VSS VSS gf180mcu_as_sc_mcu7t3v3__fillcap_4
X_2614_ VDD VDD VSS VSS _2883_/B _2614_/B _2776_/A gf180mcu_as_sc_mcu7t3v3__nand2_2
X_3594_ VDD VDD VSS VSS _3962_/A _3652_/D _3594_/C _3594_/Y _3654_/D gf180mcu_as_sc_mcu7t3v3__aoi211_2
XFILLER_177_1192 VDD VDD VSS VSS gf180mcu_as_sc_mcu7t3v3__fillcap_16
X_2545_ VDD VDD VSS VSS _5125_/Q _2545_/B _4328_/A _2745_/B _2545_/D gf180mcu_as_sc_mcu7t3v3__aoi31_2
X_5264_ VDD VDD VSS VSS _5265_/CLK _5264_/D _5264_/Q gf180mcu_as_sc_mcu7t3v3__dfxtp_2
X_2476_ VDD VDD VSS VSS _2476_/B _3907_/A _4951_/D gf180mcu_as_sc_mcu7t3v3__and2_2
X_5195_ VDD VDD VSS VSS _5203_/CLK _5195_/D _5195_/Q gf180mcu_as_sc_mcu7t3v3__dfxtp_2
X_4215_ VDD VDD VSS VSS _4244_/B _4227_/B _4227_/C _5051_/Q _5051_/D gf180mcu_as_sc_mcu7t3v3__ao22_2
X_4146_ VDD VDD VSS VSS _4146_/A _4154_/B _4154_/C _4146_/D _4147_/D gf180mcu_as_sc_mcu7t3v3__ao22_2
XFILLER_112_1338 VDD VDD VSS VSS gf180mcu_as_sc_mcu7t3v3__fillcap_4
XFILLER_18_27 VDD VDD VSS VSS gf180mcu_as_sc_mcu7t3v3__fillcap_8
X_4077_ VDD VDD VSS VSS _4077_/A _4160_/B _4161_/B _4077_/D _4078_/D gf180mcu_as_sc_mcu7t3v3__ao22_2
XTAP_TAPCELL_ROW_165_1388 VDD VSS gf180mcu_as_sc_mcu7t3v3__tap_2
XTAP_TAPCELL_ROW_165_1377 VDD VSS gf180mcu_as_sc_mcu7t3v3__tap_2
X_3028_ VDD VDD VSS VSS _3046_/B _4924_/Q _3029_/D gf180mcu_as_sc_mcu7t3v3__or2_2
XFILLER_149_1272 VDD VDD VSS VSS gf180mcu_as_sc_mcu7t3v3__fillcap_16
Xsram2048.u_bank0_915 VDD VDD VSS VSS sram2048.u_bank0/WEN[4] gf180mcu_as_sc_mcu7t3v3__tiel_4
XFILLER_11_216 VDD VDD VSS VSS gf180mcu_as_sc_mcu7t3v3__fill_1
XFILLER_180_1049 VDD VDD VSS VSS gf180mcu_as_sc_mcu7t3v3__fillcap_16
X_4979_ VDD VDD VSS VSS _5182_/CLK _4979_/D _4979_/Q gf180mcu_as_sc_mcu7t3v3__dfxtp_2
Xclkload3 VDD VDD VSS VSS clkload3/Y clkload3/A gf180mcu_as_sc_mcu7t3v3__inv_6
XFILLER_165_755 VDD VDD VSS VSS gf180mcu_as_sc_mcu7t3v3__fill_1
XPHY_EDGE_ROW_59_3_Left_431 VDD VSS gf180mcu_as_sc_mcu7t3v3__tap_2
XFILLER_192_552 VDD VDD VSS VSS gf180mcu_as_sc_mcu7t3v3__fill_1
XTAP_TAPCELL_ROW_62_3_1973 VDD VSS gf180mcu_as_sc_mcu7t3v3__tap_2
XFILLER_152_416 VDD VDD VSS VSS gf180mcu_as_sc_mcu7t3v3__fill_1
XPHY_EDGE_ROW_111_3_Left_483 VDD VSS gf180mcu_as_sc_mcu7t3v3__tap_2
XFILLER_161_972 VDD VDD VSS VSS gf180mcu_as_sc_mcu7t3v3__fillcap_8
XFILLER_191_1101 VDD VDD VSS VSS gf180mcu_as_sc_mcu7t3v3__fillcap_16
XTAP_TAPCELL_ROW_189_1834 VDD VSS gf180mcu_as_sc_mcu7t3v3__tap_2
XTAP_TAPCELL_ROW_189_1845 VDD VSS gf180mcu_as_sc_mcu7t3v3__tap_2
XFILLER_191_1189 VDD VDD VSS VSS gf180mcu_as_sc_mcu7t3v3__fill_1
XFILLER_189_1052 VDD VDD VSS VSS gf180mcu_as_sc_mcu7t3v3__fillcap_4
XFILLER_131_72 VDD VDD VSS VSS gf180mcu_as_sc_mcu7t3v3__fill_1
XFILLER_163_1247 VDD VDD VSS VSS gf180mcu_as_sc_mcu7t3v3__fill_1
XFILLER_76_1288 VDD VDD VSS VSS gf180mcu_as_sc_mcu7t3v3__fill_1
XFILLER_91_43 VDD VDD VSS VSS gf180mcu_as_sc_mcu7t3v3__fill_1
XFILLER_163_1269 VDD VDD VSS VSS gf180mcu_as_sc_mcu7t3v3__fillcap_8
XFILLER_156_700 VDD VDD VSS VSS gf180mcu_as_sc_mcu7t3v3__fillcap_16
XFILLER_168_560 VDD VDD VSS VSS gf180mcu_as_sc_mcu7t3v3__fillcap_16
XFILLER_24_70 VDD VDD VSS VSS gf180mcu_as_sc_mcu7t3v3__fillcap_8
XFILLER_11_772 VDD VDD VSS VSS gf180mcu_as_sc_mcu7t3v3__fillcap_4
XFILLER_7_754 VDD VDD VSS VSS gf180mcu_as_sc_mcu7t3v3__fill_2
Xwire663 VDD VDD VSS VSS _3063_/B _3130_/B gf180mcu_as_sc_mcu7t3v3__clkbuff_12
XFILLER_155_298 VDD VDD VSS VSS gf180mcu_as_sc_mcu7t3v3__fillcap_16
XFILLER_157_1007 VDD VDD VSS VSS gf180mcu_as_sc_mcu7t3v3__fill_2
XFILLER_100_1264 VDD VDD VSS VSS gf180mcu_as_sc_mcu7t3v3__fillcap_4
XFILLER_170_279 VDD VDD VSS VSS gf180mcu_as_sc_mcu7t3v3__fill_2
X_4000_ VDD VDD VSS VSS _4000_/A _4159_/B _4159_/C _4000_/D _4001_/D gf180mcu_as_sc_mcu7t3v3__ao22_2
XFILLER_37_102 VDD VDD VSS VSS gf180mcu_as_sc_mcu7t3v3__fill_2
XFILLER_20_1287 VDD VDD VSS VSS gf180mcu_as_sc_mcu7t3v3__fill_2
X_4902_ VDD VDD VSS VSS clkload5/A _4902_/D _4902_/Q gf180mcu_as_sc_mcu7t3v3__dfxtp_2
XFILLER_179_858 VDD VDD VSS VSS gf180mcu_as_sc_mcu7t3v3__fill_1
XTAP_TAPCELL_ROW_160_1285 VDD VSS gf180mcu_as_sc_mcu7t3v3__tap_2
X_4833_ VDD VDD VSS VSS clkload7/A _4833_/D _4833_/Q gf180mcu_as_sc_mcu7t3v3__dfxtp_2
X_4764_ VDD VDD VSS VSS _5278_/CLK _4764_/D _4764_/Q gf180mcu_as_sc_mcu7t3v3__dfxtp_2
XPHY_EDGE_ROW_62_3_Right_103 VDD VSS gf180mcu_as_sc_mcu7t3v3__tap_2
X_3715_ VDD VDD VSS VSS _4858_/D _3715_/C _3715_/B _4091_/A gf180mcu_as_sc_mcu7t3v3__aoi21_2
XFILLER_174_552 VDD VDD VSS VSS gf180mcu_as_sc_mcu7t3v3__fillcap_16
X_4695_ VDD VDD VSS VSS _4707_/S _5252_/Q _4695_/A _5252_/D gf180mcu_as_sc_mcu7t3v3__mux2_2
X_3646_ VDD VDD VSS VSS _3699_/D _3730_/A _3646_/B _3646_/C _3647_/C gf180mcu_as_sc_mcu7t3v3__ao31_2
X_3577_ VDD VDD VSS VSS _3578_/C _3938_/A _3673_/C _3577_/C gf180mcu_as_sc_mcu7t3v3__ao21_2
X_2528_ VDD VDD VSS VSS _4657_/B _5268_/Q _4643_/B gf180mcu_as_sc_mcu7t3v3__or2_2
X_5247_ VDD VDD VSS VSS _5266_/CLK _5247_/D _5247_/Q gf180mcu_as_sc_mcu7t3v3__dfxtp_2
Xinput308 VDD VDD VSS VSS west_in[32] _3520_/A gf180mcu_as_sc_mcu7t3v3__buff_12
XTAP_TAPCELL_ROW_167_1428 VDD VSS gf180mcu_as_sc_mcu7t3v3__tap_2
XTAP_TAPCELL_ROW_167_1417 VDD VSS gf180mcu_as_sc_mcu7t3v3__tap_2
X_2459_ VDD VDD VSS VSS _3872_/A _4353_/A _3869_/A _2474_/A gf180mcu_as_sc_mcu7t3v3__nand3_2
XTAP_TAPCELL_ROW_150_1_1103 VDD VSS gf180mcu_as_sc_mcu7t3v3__tap_2
X_5178_ VDD VDD VSS VSS _5178_/CLK _5178_/D _5178_/Q gf180mcu_as_sc_mcu7t3v3__dfxtp_2
XTAP_TAPCELL_ROW_4_768 VDD VSS gf180mcu_as_sc_mcu7t3v3__tap_2
XTAP_TAPCELL_ROW_184_1742 VDD VSS gf180mcu_as_sc_mcu7t3v3__tap_2
XFILLER_5_1259 VDD VDD VSS VSS gf180mcu_as_sc_mcu7t3v3__fill_1
X_4129_ VDD VDD VSS VSS _4129_/A _4152_/B _4129_/C _4939_/Q _4130_/D gf180mcu_as_sc_mcu7t3v3__ao22_2
XFILLER_186_1269 VDD VDD VSS VSS gf180mcu_as_sc_mcu7t3v3__fill_1
XFILLER_101_53 VDD VDD VSS VSS gf180mcu_as_sc_mcu7t3v3__fillcap_16
XFILLER_169_368 VDD VDD VSS VSS gf180mcu_as_sc_mcu7t3v3__fillcap_8
XFILLER_185_839 VDD VDD VSS VSS gf180mcu_as_sc_mcu7t3v3__fill_1
XFILLER_61_68 VDD VDD VSS VSS gf180mcu_as_sc_mcu7t3v3__fill_2
XFILLER_152_202 VDD VDD VSS VSS gf180mcu_as_sc_mcu7t3v3__fill_2
XFILLER_158_1305 VDD VDD VSS VSS gf180mcu_as_sc_mcu7t3v3__fillcap_4
XFILLER_192_382 VDD VDD VSS VSS gf180mcu_as_sc_mcu7t3v3__fill_1
XFILLER_3_212 VDD VDD VSS VSS gf180mcu_as_sc_mcu7t3v3__fill_2
XFILLER_152_268 VDD VDD VSS VSS gf180mcu_as_sc_mcu7t3v3__fillcap_4
XPHY_EDGE_ROW_5_Left_198 VDD VSS gf180mcu_as_sc_mcu7t3v3__tap_2
XFILLER_0_985 VDD VDD VSS VSS gf180mcu_as_sc_mcu7t3v3__fill_1
XPHY_EDGE_ROW_40_1_Right_549 VDD VSS gf180mcu_as_sc_mcu7t3v3__tap_2
XFILLER_43_1287 VDD VDD VSS VSS gf180mcu_as_sc_mcu7t3v3__fill_1
XFILLER_130_1268 VDD VDD VSS VSS gf180mcu_as_sc_mcu7t3v3__fill_1
XFILLER_163_1044 VDD VDD VSS VSS gf180mcu_as_sc_mcu7t3v3__fillcap_4
XFILLER_15_1323 VDD VDD VSS VSS gf180mcu_as_sc_mcu7t3v3__fill_1
X_3500_ VDD VDD VSS VSS _3500_/B _4161_/A _3502_/C gf180mcu_as_sc_mcu7t3v3__and2_2
XFILLER_167_90 VDD VDD VSS VSS gf180mcu_as_sc_mcu7t3v3__fill_1
X_4480_ VDD VDD VSS VSS _4480_/B _4541_/A _4486_/C gf180mcu_as_sc_mcu7t3v3__and2_2
XFILLER_183_393 VDD VDD VSS VSS gf180mcu_as_sc_mcu7t3v3__fillcap_8
X_3431_ VDD VDD VSS VSS _3462_/A _3431_/B _3431_/C _3432_/C gf180mcu_as_sc_mcu7t3v3__nor3_2
X_3362_ VDD VDD VSS VSS _4925_/Q _3448_/B _3448_/C _4014_/A _3363_/A gf180mcu_as_sc_mcu7t3v3__ao22_2
XFILLER_174_1173 VDD VDD VSS VSS gf180mcu_as_sc_mcu7t3v3__fill_1
X_5101_ VDD VDD VSS VSS _5266_/CLK _5101_/D _5101_/Q gf180mcu_as_sc_mcu7t3v3__dfxtp_2
XFILLER_174_1195 VDD VDD VSS VSS gf180mcu_as_sc_mcu7t3v3__fill_2
X_3293_ VDD VDD VSS VSS _3938_/A _3373_/S _3374_/B _3939_/A _3294_/D gf180mcu_as_sc_mcu7t3v3__ao22_2
X_5032_ VDD VDD VSS VSS _5175_/CLK _5032_/D _5032_/Q gf180mcu_as_sc_mcu7t3v3__dfxtp_2
XTAP_TAPCELL_ROW_1_716 VDD VSS gf180mcu_as_sc_mcu7t3v3__tap_2
XTAP_TAPCELL_ROW_1_705 VDD VSS gf180mcu_as_sc_mcu7t3v3__tap_2
XTAP_TAPCELL_ROW_114_3_2025 VDD VSS gf180mcu_as_sc_mcu7t3v3__tap_2
XTAP_TAPCELL_ROW_162_1325 VDD VSS gf180mcu_as_sc_mcu7t3v3__tap_2
XFILLER_59_1272 VDD VDD VSS VSS gf180mcu_as_sc_mcu7t3v3__fill_1
XFILLER_0_1189 VDD VDD VSS VSS gf180mcu_as_sc_mcu7t3v3__fill_1
XFILLER_181_1122 VDD VDD VSS VSS gf180mcu_as_sc_mcu7t3v3__fillcap_8
X_4816_ VDD VDD VSS VSS clkload3/A _4816_/D _4816_/Q gf180mcu_as_sc_mcu7t3v3__dfxtp_2
XFILLER_178_198 VDD VDD VSS VSS gf180mcu_as_sc_mcu7t3v3__fill_2
XFILLER_182_809 VDD VDD VSS VSS gf180mcu_as_sc_mcu7t3v3__fill_1
X_4747_ VDD VDD VSS VSS _5276_/Q _4750_/B _4747_/C _4747_/D _5276_/D gf180mcu_as_sc_mcu7t3v3__ao22_2
XPHY_EDGE_ROW_63_3_Right_104 VDD VSS gf180mcu_as_sc_mcu7t3v3__tap_2
XFILLER_174_382 VDD VDD VSS VSS gf180mcu_as_sc_mcu7t3v3__fill_2
X_4678_ VDD VDD VSS VSS _5246_/D _5100_/Q _4700_/S _4678_/C gf180mcu_as_sc_mcu7t3v3__ao21_2
XFILLER_174_393 VDD VDD VSS VSS gf180mcu_as_sc_mcu7t3v3__fill_1
X_3629_ VDD VDD VSS VSS _3998_/A _3792_/B _3629_/C _3775_/B _3630_/C gf180mcu_as_sc_mcu7t3v3__ao211_2
Xmax_cap782 VDD VDD VSS VSS _2894_/Y fanout781/A gf180mcu_as_sc_mcu7t3v3__clkbuff_12
XFILLER_153_1213 VDD VDD VSS VSS gf180mcu_as_sc_mcu7t3v3__fillcap_16
XFILLER_192_1251 VDD VDD VSS VSS gf180mcu_as_sc_mcu7t3v3__fill_2
XFILLER_192_1262 VDD VDD VSS VSS gf180mcu_as_sc_mcu7t3v3__fill_1
XFILLER_153_1257 VDD VDD VSS VSS gf180mcu_as_sc_mcu7t3v3__fill_2
Xinput105 VDD VDD VSS VSS ne_in[3] wire909/A gf180mcu_as_sc_mcu7t3v3__buff_12
Xinput116 VDD VDD VSS VSS north_in[13] _4039_/A gf180mcu_as_sc_mcu7t3v3__buff_12
Xinput127 VDD VDD VSS VSS north_in[23] _4120_/A gf180mcu_as_sc_mcu7t3v3__buff_12
XFILLER_9_1192 VDD VDD VSS VSS gf180mcu_as_sc_mcu7t3v3__fillcap_4
Xinput138 VDD VDD VSS VSS north_in[33] _3534_/A gf180mcu_as_sc_mcu7t3v3__buff_12
Xinput149 VDD VDD VSS VSS nw_in[12] _4032_/A gf180mcu_as_sc_mcu7t3v3__buff_12
XFILLER_112_41 VDD VDD VSS VSS gf180mcu_as_sc_mcu7t3v3__fill_2
XFILLER_186_1077 VDD VDD VSS VSS gf180mcu_as_sc_mcu7t3v3__fillcap_8
XFILLER_169_132 VDD VDD VSS VSS gf180mcu_as_sc_mcu7t3v3__fill_1
XFILLER_188_34 VDD VDD VSS VSS gf180mcu_as_sc_mcu7t3v3__fill_1
XFILLER_125_1326 VDD VDD VSS VSS gf180mcu_as_sc_mcu7t3v3__fillcap_4
XFILLER_12_344 VDD VDD VSS VSS gf180mcu_as_sc_mcu7t3v3__fillcap_8
XFILLER_13_856 VDD VDD VSS VSS gf180mcu_as_sc_mcu7t3v3__fill_2
XFILLER_157_305 VDD VDD VSS VSS gf180mcu_as_sc_mcu7t3v3__fill_1
XFILLER_158_839 VDD VDD VSS VSS gf180mcu_as_sc_mcu7t3v3__fill_2
XFILLER_169_165 VDD VDD VSS VSS gf180mcu_as_sc_mcu7t3v3__fillcap_16
XFILLER_72_78 VDD VDD VSS VSS gf180mcu_as_sc_mcu7t3v3__fill_2
Xclkbuf_leaf_5_clk_regs VDD VDD VSS VSS clkbuf_leaf_7_clk_regs/A _5182_/CLK gf180mcu_as_sc_mcu7t3v3__clkbuff_12
XFILLER_157_349 VDD VDD VSS VSS gf180mcu_as_sc_mcu7t3v3__fill_1
XFILLER_166_872 VDD VDD VSS VSS gf180mcu_as_sc_mcu7t3v3__fill_2
XFILLER_165_360 VDD VDD VSS VSS gf180mcu_as_sc_mcu7t3v3__fill_2
XFILLER_181_831 VDD VDD VSS VSS gf180mcu_as_sc_mcu7t3v3__fillcap_8
XFILLER_184_179 VDD VDD VSS VSS gf180mcu_as_sc_mcu7t3v3__fill_1
XPHY_EDGE_ROW_19_3_Right_60 VDD VSS gf180mcu_as_sc_mcu7t3v3__tap_2
XFILLER_181_842 VDD VDD VSS VSS gf180mcu_as_sc_mcu7t3v3__fillcap_8
XFILLER_153_599 VDD VDD VSS VSS gf180mcu_as_sc_mcu7t3v3__fillcap_16
XFILLER_158_1157 VDD VDD VSS VSS gf180mcu_as_sc_mcu7t3v3__fillcap_8
XFILLER_180_352 VDD VDD VSS VSS gf180mcu_as_sc_mcu7t3v3__fill_2
XFILLER_181_897 VDD VDD VSS VSS gf180mcu_as_sc_mcu7t3v3__fill_2
XFILLER_10_1297 VDD VDD VSS VSS gf180mcu_as_sc_mcu7t3v3__fill_2
XFILLER_97_53 VDD VDD VSS VSS gf180mcu_as_sc_mcu7t3v3__fill_2
XPHY_EDGE_ROW_135_1_Left_327 VDD VSS gf180mcu_as_sc_mcu7t3v3__tap_2
XFILLER_169_1242 VDD VDD VSS VSS gf180mcu_as_sc_mcu7t3v3__fillcap_16
XFILLER_165_1117 VDD VDD VSS VSS gf180mcu_as_sc_mcu7t3v3__fill_2
XFILLER_189_931 VDD VDD VSS VSS gf180mcu_as_sc_mcu7t3v3__fill_2
X_3980_ VDD VDD VSS VSS _4983_/Q _4166_/B _4234_/B _4166_/D _4983_/D gf180mcu_as_sc_mcu7t3v3__ao22_2
XFILLER_189_964 VDD VDD VSS VSS gf180mcu_as_sc_mcu7t3v3__fill_2
X_2931_ VDD VDD VSS VSS _2931_/Y _3223_/C _3222_/D gf180mcu_as_sc_mcu7t3v3__nor2_2
XFILLER_189_986 VDD VDD VSS VSS gf180mcu_as_sc_mcu7t3v3__fill_1
XFILLER_94_4 VDD VDD VSS VSS gf180mcu_as_sc_mcu7t3v3__fill_1
Xclkbuf_0_clk VDD VDD VSS VSS clkbuf_0_clk/A clkbuf_0_clk/Y gf180mcu_as_sc_mcu7t3v3__clkbuff_12
XFILLER_175_113 VDD VDD VSS VSS gf180mcu_as_sc_mcu7t3v3__fillcap_4
XFILLER_188_485 VDD VDD VSS VSS gf180mcu_as_sc_mcu7t3v3__fillcap_8
X_4601_ VDD VDD VSS VSS _5195_/Q _4609_/B _4609_/C _5196_/Q _5195_/D gf180mcu_as_sc_mcu7t3v3__ao22_2
X_2862_ VDD VDD VSS VSS _4763_/Q _4742_/A _2871_/B _4763_/D gf180mcu_as_sc_mcu7t3v3__nor3_2
XFILLER_157_850 VDD VDD VSS VSS gf180mcu_as_sc_mcu7t3v3__fill_2
X_2793_ VDD VDD VSS VSS _2793_/B _2876_/B _2796_/C gf180mcu_as_sc_mcu7t3v3__and2_2
X_4532_ VDD VDD VSS VSS _5183_/Q _4532_/B _4540_/C _5101_/Q _4533_/B gf180mcu_as_sc_mcu7t3v3__ao22_2
XFILLER_176_1224 VDD VDD VSS VSS gf180mcu_as_sc_mcu7t3v3__fill_1
XFILLER_7_95 VDD VDD VSS VSS gf180mcu_as_sc_mcu7t3v3__fill_2
X_4463_ VDD VDD VSS VSS _4473_/A _5016_/Q _5045_/Q _4464_/B gf180mcu_as_sc_mcu7t3v3__mux2_2
XTAP_TAPCELL_ROW_155_1195 VDD VSS gf180mcu_as_sc_mcu7t3v3__tap_2
XTAP_TAPCELL_ROW_155_1184 VDD VSS gf180mcu_as_sc_mcu7t3v3__tap_2
XFILLER_171_352 VDD VDD VSS VSS gf180mcu_as_sc_mcu7t3v3__fill_1
XFILLER_176_1279 VDD VDD VSS VSS gf180mcu_as_sc_mcu7t3v3__fillcap_4
X_3414_ VDD VDD VSS VSS _4064_/A _3453_/B _3453_/C _4066_/A _3415_/C gf180mcu_as_sc_mcu7t3v3__ao22_2
XFILLER_171_396 VDD VDD VSS VSS gf180mcu_as_sc_mcu7t3v3__fillcap_16
Xfanout806 VDD VDD VSS VSS _2845_/D _2795_/A gf180mcu_as_sc_mcu7t3v3__buff_12
X_4394_ VDD VDD VSS VSS _4394_/D _4560_/A _4394_/B _4394_/C _4395_/B gf180mcu_as_sc_mcu7t3v3__ao31_2
XTAP_TAPCELL_ROW_6_808 VDD VSS gf180mcu_as_sc_mcu7t3v3__tap_2
Xfanout817 VDD VDD VSS VSS _4561_/A _4538_/A gf180mcu_as_sc_mcu7t3v3__buff_12
Xfanout828 VDD VDD VSS VSS fanout837/Y _4557_/A gf180mcu_as_sc_mcu7t3v3__buff_12
Xfanout839 VDD VDD VSS VSS _4975_/Q _2631_/C gf180mcu_as_sc_mcu7t3v3__buff_12
X_3345_ VDD VDD VSS VSS _4923_/Q _3456_/B _3501_/B _3999_/A _3347_/C gf180mcu_as_sc_mcu7t3v3__ao22_2
XFILLER_26_1260 VDD VDD VSS VSS gf180mcu_as_sc_mcu7t3v3__fill_2
X_3276_ VDD VDD VSS VSS _3814_/B _3280_/B _3553_/A gf180mcu_as_sc_mcu7t3v3__nand2_2
XPHY_EDGE_ROW_67_1_Left_259 VDD VSS gf180mcu_as_sc_mcu7t3v3__tap_2
XFILLER_152_1290 VDD VDD VSS VSS gf180mcu_as_sc_mcu7t3v3__fill_2
XFILLER_26_1293 VDD VDD VSS VSS gf180mcu_as_sc_mcu7t3v3__fill_1
XFILLER_6_1354 VDD VDD VSS VSS gf180mcu_as_sc_mcu7t3v3__fill_1
X_5015_ VDD VDD VSS VSS clkload8/A _5015_/D _5015_/Q gf180mcu_as_sc_mcu7t3v3__dfxtp_2
XFILLER_26_27 VDD VDD VSS VSS gf180mcu_as_sc_mcu7t3v3__fill_1
XPHY_EDGE_ROW_68_3_Left_440 VDD VSS gf180mcu_as_sc_mcu7t3v3__tap_2
XPHY_EDGE_ROW_120_3_Left_492 VDD VSS gf180mcu_as_sc_mcu7t3v3__tap_2
XTAP_TAPCELL_ROW_179_1652 VDD VSS gf180mcu_as_sc_mcu7t3v3__tap_2
XTAP_TAPCELL_ROW_179_1641 VDD VSS gf180mcu_as_sc_mcu7t3v3__tap_2
XFILLER_42_37 VDD VDD VSS VSS gf180mcu_as_sc_mcu7t3v3__fillcap_8
XFILLER_10_859 VDD VDD VSS VSS gf180mcu_as_sc_mcu7t3v3__fillcap_16
XFILLER_158_37 VDD VDD VSS VSS gf180mcu_as_sc_mcu7t3v3__fill_1
XFILLER_158_59 VDD VDD VSS VSS gf180mcu_as_sc_mcu7t3v3__fill_1
XFILLER_166_157 VDD VDD VSS VSS gf180mcu_as_sc_mcu7t3v3__fill_1
XFILLER_72_1291 VDD VDD VSS VSS gf180mcu_as_sc_mcu7t3v3__fillcap_16
XFILLER_163_820 VDD VDD VSS VSS gf180mcu_as_sc_mcu7t3v3__fillcap_16
XFILLER_181_127 VDD VDD VSS VSS gf180mcu_as_sc_mcu7t3v3__fill_2
XPHY_EDGE_ROW_64_3_Right_105 VDD VSS gf180mcu_as_sc_mcu7t3v3__tap_2
XFILLER_163_842 VDD VDD VSS VSS gf180mcu_as_sc_mcu7t3v3__fillcap_16
XTAP_TAPCELL_ROW_192_1896 VDD VSS gf180mcu_as_sc_mcu7t3v3__tap_2
XTAP_TAPCELL_ROW_192_1885 VDD VSS gf180mcu_as_sc_mcu7t3v3__tap_2
XFILLER_162_363 VDD VDD VSS VSS gf180mcu_as_sc_mcu7t3v3__fill_1
XFILLER_190_694 VDD VDD VSS VSS gf180mcu_as_sc_mcu7t3v3__fill_2
XFILLER_192_1081 VDD VDD VSS VSS gf180mcu_as_sc_mcu7t3v3__fill_2
XFILLER_192_1092 VDD VDD VSS VSS gf180mcu_as_sc_mcu7t3v3__fill_1
XFILLER_153_1054 VDD VDD VSS VSS gf180mcu_as_sc_mcu7t3v3__fill_1
XFILLER_153_1076 VDD VDD VSS VSS gf180mcu_as_sc_mcu7t3v3__fill_2
XFILLER_123_51 VDD VDD VSS VSS gf180mcu_as_sc_mcu7t3v3__fillcap_16
XFILLER_13_620 VDD VDD VSS VSS gf180mcu_as_sc_mcu7t3v3__fill_1
XFILLER_16_82 VDD VDD VSS VSS gf180mcu_as_sc_mcu7t3v3__fill_1
XFILLER_16_93 VDD VDD VSS VSS gf180mcu_as_sc_mcu7t3v3__fillcap_8
XFILLER_160_1014 VDD VDD VSS VSS gf180mcu_as_sc_mcu7t3v3__fill_1
XFILLER_185_422 VDD VDD VSS VSS gf180mcu_as_sc_mcu7t3v3__fillcap_16
XFILLER_9_613 VDD VDD VSS VSS gf180mcu_as_sc_mcu7t3v3__fillcap_8
XFILLER_160_1069 VDD VDD VSS VSS gf180mcu_as_sc_mcu7t3v3__fill_2
XFILLER_173_606 VDD VDD VSS VSS gf180mcu_as_sc_mcu7t3v3__fillcap_8
XFILLER_165_190 VDD VDD VSS VSS gf180mcu_as_sc_mcu7t3v3__fillcap_16
XTAP_TAPCELL_ROW_11_898 VDD VSS gf180mcu_as_sc_mcu7t3v3__tap_2
XFILLER_153_352 VDD VDD VSS VSS gf180mcu_as_sc_mcu7t3v3__fillcap_16
XFILLER_5_874 VDD VDD VSS VSS gf180mcu_as_sc_mcu7t3v3__fillcap_4
Xoutput409 VDD VDD VSS VSS _4829_/Q south_out[24] gf180mcu_as_sc_mcu7t3v3__buff_12
X_3130_ VDD VDD VSS VSS _4105_/A _3130_/B _3130_/C _3130_/D _3131_/C gf180mcu_as_sc_mcu7t3v3__ao22_2
X_3061_ VDD VDD VSS VSS _3128_/A _3061_/B _3061_/C _3128_/D _3063_/C gf180mcu_as_sc_mcu7t3v3__ao211_2
XFILLER_1_1251 VDD VDD VSS VSS gf180mcu_as_sc_mcu7t3v3__fillcap_8
XFILLER_1_1273 VDD VDD VSS VSS gf180mcu_as_sc_mcu7t3v3__fillcap_4
XFILLER_177_912 VDD VDD VSS VSS gf180mcu_as_sc_mcu7t3v3__fillcap_16
XFILLER_189_772 VDD VDD VSS VSS gf180mcu_as_sc_mcu7t3v3__fill_1
X_3963_ VDD VDD VSS VSS _4232_/B _3963_/B _4099_/D gf180mcu_as_sc_mcu7t3v3__nor2_2
XTAP_TAPCELL_ROW_109_3_2020 VDD VSS gf180mcu_as_sc_mcu7t3v3__tap_2
XFILLER_108_1354 VDD VDD VSS VSS gf180mcu_as_sc_mcu7t3v3__fill_1
XFILLER_148_102 VDD VDD VSS VSS gf180mcu_as_sc_mcu7t3v3__fill_2
X_3894_ VDD VDD VSS VSS _3897_/B _5184_/Q _4934_/D gf180mcu_as_sc_mcu7t3v3__and2_2
X_2914_ VDD VDD VSS VSS _3787_/A _3255_/B _3544_/C _3223_/C gf180mcu_as_sc_mcu7t3v3__nand3_2
XFILLER_143_1267 VDD VDD VSS VSS gf180mcu_as_sc_mcu7t3v3__fill_2
X_2845_ VDD VDD VSS VSS _2845_/A _2845_/B _2856_/A _2845_/D _2854_/B gf180mcu_as_sc_mcu7t3v3__ao22_2
XTAP_TAPCELL_ROW_157_1235 VDD VSS gf180mcu_as_sc_mcu7t3v3__tap_2
XTAP_TAPCELL_ROW_157_1224 VDD VSS gf180mcu_as_sc_mcu7t3v3__tap_2
XFILLER_157_680 VDD VDD VSS VSS gf180mcu_as_sc_mcu7t3v3__fillcap_16
XTAP_TAPCELL_ROW_174_1560 VDD VSS gf180mcu_as_sc_mcu7t3v3__tap_2
XFILLER_163_138 VDD VDD VSS VSS gf180mcu_as_sc_mcu7t3v3__fill_2
X_4515_ VDD VDD VSS VSS _4515_/B _4515_/A _4522_/C gf180mcu_as_sc_mcu7t3v3__and2_2
X_2776_ VDD VDD VSS VSS _2776_/B _2776_/A _2783_/A gf180mcu_as_sc_mcu7t3v3__and2_2
XTAP_TAPCELL_ROW_170_1468 VDD VSS gf180mcu_as_sc_mcu7t3v3__tap_2
XFILLER_172_694 VDD VDD VSS VSS gf180mcu_as_sc_mcu7t3v3__fillcap_8
XFILLER_176_1087 VDD VDD VSS VSS gf180mcu_as_sc_mcu7t3v3__fillcap_16
X_4446_ VDD VDD VSS VSS _4449_/C _4985_/Q _4579_/S gf180mcu_as_sc_mcu7t3v3__nand2b_2
XTAP_TAPCELL_ROW_170_1479 VDD VSS gf180mcu_as_sc_mcu7t3v3__tap_2
Xfanout614 VDD VDD VSS VSS _4514_/B _4532_/B gf180mcu_as_sc_mcu7t3v3__buff_12
X_4377_ VDD VDD VSS VSS _4377_/B _4377_/A _4378_/C gf180mcu_as_sc_mcu7t3v3__and2_2
XFILLER_63_1268 VDD VDD VSS VSS gf180mcu_as_sc_mcu7t3v3__fill_1
Xfanout625 VDD VDD VSS VSS _4101_/B _4021_/C gf180mcu_as_sc_mcu7t3v3__buff_12
Xfanout636 VDD VDD VSS VSS _3724_/B _3649_/B gf180mcu_as_sc_mcu7t3v3__buff_12
Xfanout658 VDD VDD VSS VSS fanout658/A _3500_/B gf180mcu_as_sc_mcu7t3v3__buff_12
X_3328_ VDD VDD VSS VSS _4921_/Q _3369_/B _3369_/C _3982_/A _3329_/C gf180mcu_as_sc_mcu7t3v3__ao22_2
Xfanout669 VDD VDD VSS VSS _3239_/A _3192_/C gf180mcu_as_sc_mcu7t3v3__buff_12
XFILLER_6_1151 VDD VDD VSS VSS gf180mcu_as_sc_mcu7t3v3__fillcap_4
X_3259_ VDD VDD VSS VSS _3811_/A _3548_/A _3261_/B gf180mcu_as_sc_mcu7t3v3__and2_2
XFILLER_156_6 VDD VDD VSS VSS gf180mcu_as_sc_mcu7t3v3__fillcap_16
XFILLER_139_102 VDD VDD VSS VSS gf180mcu_as_sc_mcu7t3v3__fill_2
XFILLER_35_1326 VDD VDD VSS VSS gf180mcu_as_sc_mcu7t3v3__fill_2
XFILLER_155_606 VDD VDD VSS VSS gf180mcu_as_sc_mcu7t3v3__fillcap_16
XFILLER_168_967 VDD VDD VSS VSS gf180mcu_as_sc_mcu7t3v3__fill_2
XFILLER_179_293 VDD VDD VSS VSS gf180mcu_as_sc_mcu7t3v3__fillcap_4
XFILLER_167_477 VDD VDD VSS VSS gf180mcu_as_sc_mcu7t3v3__fillcap_8
XFILLER_191_970 VDD VDD VSS VSS gf180mcu_as_sc_mcu7t3v3__fill_1
XFILLER_5_148 VDD VDD VSS VSS gf180mcu_as_sc_mcu7t3v3__fill_1
XPHY_EDGE_ROW_65_3_Right_106 VDD VSS gf180mcu_as_sc_mcu7t3v3__tap_2
XFILLER_163_683 VDD VDD VSS VSS gf180mcu_as_sc_mcu7t3v3__fillcap_16
XFILLER_155_1149 VDD VDD VSS VSS gf180mcu_as_sc_mcu7t3v3__fill_2
XFILLER_162_193 VDD VDD VSS VSS gf180mcu_as_sc_mcu7t3v3__fill_1
XFILLER_1_343 VDD VDD VSS VSS gf180mcu_as_sc_mcu7t3v3__fillcap_4
Xmesh_tile_1002 VDD VDD VSS VSS nw_out[8] gf180mcu_as_sc_mcu7t3v3__tiel_4
XFILLER_94_32 VDD VDD VSS VSS gf180mcu_as_sc_mcu7t3v3__fill_2
Xmesh_tile_1035 VDD VDD VSS VSS sw_out[7] gf180mcu_as_sc_mcu7t3v3__tiel_4
Xmesh_tile_1024 VDD VDD VSS VSS nw_out[30] gf180mcu_as_sc_mcu7t3v3__tiel_4
Xmesh_tile_1013 VDD VDD VSS VSS nw_out[19] gf180mcu_as_sc_mcu7t3v3__tiel_4
XFILLER_91_103 VDD VDD VSS VSS gf180mcu_as_sc_mcu7t3v3__fill_2
Xmesh_tile_1057 VDD VDD VSS VSS sw_out[29] gf180mcu_as_sc_mcu7t3v3__tiel_4
Xmesh_tile_1046 VDD VDD VSS VSS sw_out[18] gf180mcu_as_sc_mcu7t3v3__tiel_4
XFILLER_166_1201 VDD VDD VSS VSS gf180mcu_as_sc_mcu7t3v3__fillcap_16
XTAP_TAPCELL_ROW_52_1_1005 VDD VSS gf180mcu_as_sc_mcu7t3v3__tap_2
XFILLER_166_1256 VDD VDD VSS VSS gf180mcu_as_sc_mcu7t3v3__fillcap_16
XFILLER_159_912 VDD VDD VSS VSS gf180mcu_as_sc_mcu7t3v3__fillcap_16
XFILLER_186_764 VDD VDD VSS VSS gf180mcu_as_sc_mcu7t3v3__fill_2
X_2630_ VDD VDD VSS VSS _2631_/D _5263_/Q _2695_/A _4643_/B gf180mcu_as_sc_mcu7t3v3__ao21_2
XTAP_TAPCELL_ROW_80_3_1991 VDD VSS gf180mcu_as_sc_mcu7t3v3__tap_2
XTAP_TAPCELL_ROW_152_1110 VDD VSS gf180mcu_as_sc_mcu7t3v3__tap_2
XFILLER_177_1352 VDD VDD VSS VSS gf180mcu_as_sc_mcu7t3v3__fill_2
X_2561_ VDD VDD VSS VSS _2666_/A _4952_/D _2831_/B gf180mcu_as_sc_mcu7t3v3__nand2b_2
XTAP_TAPCELL_ROW_152_1143 VDD VSS gf180mcu_as_sc_mcu7t3v3__tap_2
XTAP_TAPCELL_ROW_152_1132 VDD VSS gf180mcu_as_sc_mcu7t3v3__tap_2
XTAP_TAPCELL_ROW_152_1121 VDD VSS gf180mcu_as_sc_mcu7t3v3__tap_2
XFILLER_173_1216 VDD VDD VSS VSS gf180mcu_as_sc_mcu7t3v3__fill_2
XFILLER_182_992 VDD VDD VSS VSS gf180mcu_as_sc_mcu7t3v3__fillcap_4
X_5280_ VDD VDD VSS VSS _5280_/CLK _5280_/D _5280_/Q gf180mcu_as_sc_mcu7t3v3__dfxtp_2
X_4300_ VDD VDD VSS VSS _4326_/S _5130_/Q _5129_/Q _5129_/D gf180mcu_as_sc_mcu7t3v3__mux2_2
X_2492_ VDD VDD VSS VSS _4649_/A _5274_/Q _2794_/A gf180mcu_as_sc_mcu7t3v3__and2_2
X_4231_ VDD VDD VSS VSS _4246_/S _4231_/B _5067_/Q _5067_/D gf180mcu_as_sc_mcu7t3v3__mux2_2
X_4162_ VDD VDD VSS VSS _4162_/B _4162_/A _4163_/D gf180mcu_as_sc_mcu7t3v3__and2_2
XFILLER_3_1302 VDD VDD VSS VSS gf180mcu_as_sc_mcu7t3v3__fill_1
X_4093_ VDD VDD VSS VSS _4093_/A _4160_/B _4161_/B _4093_/D _4094_/D gf180mcu_as_sc_mcu7t3v3__ao22_2
X_3113_ VDD VDD VSS VSS _4086_/A _3206_/B _3113_/C _3113_/D _3114_/C gf180mcu_as_sc_mcu7t3v3__ao22_2
X_3044_ VDD VDD VSS VSS _4023_/A _3044_/B _3044_/C _4024_/D _3045_/C gf180mcu_as_sc_mcu7t3v3__ao22_2
XFILLER_184_1301 VDD VDD VSS VSS gf180mcu_as_sc_mcu7t3v3__fill_2
XFILLER_23_1296 VDD VDD VSS VSS gf180mcu_as_sc_mcu7t3v3__fill_2
XFILLER_110_1288 VDD VDD VSS VSS gf180mcu_as_sc_mcu7t3v3__fill_1
X_4995_ VDD VDD VSS VSS clkload8/A _4995_/D _4995_/Q gf180mcu_as_sc_mcu7t3v3__dfxtp_2
X_3946_ VDD VDD VSS VSS _4979_/Q _4076_/B _4230_/B _4076_/D _4979_/D gf180mcu_as_sc_mcu7t3v3__ao22_2
XPHY_EDGE_ROW_131_1_Right_640 VDD VSS gf180mcu_as_sc_mcu7t3v3__tap_2
X_3877_ VDD VDD VSS VSS _4946_/D _5167_/Q _4917_/D gf180mcu_as_sc_mcu7t3v3__and2_2
XTAP_TAPCELL_ROW_172_1519 VDD VSS gf180mcu_as_sc_mcu7t3v3__tap_2
XTAP_TAPCELL_ROW_172_1508 VDD VSS gf180mcu_as_sc_mcu7t3v3__tap_2
XFILLER_165_959 VDD VDD VSS VSS gf180mcu_as_sc_mcu7t3v3__fill_1
XFILLER_192_745 VDD VDD VSS VSS gf180mcu_as_sc_mcu7t3v3__fill_2
X_2828_ VDD VDD VSS VSS _4751_/A _2828_/B _5283_/Q _5282_/D gf180mcu_as_sc_mcu7t3v3__mux2_2
XFILLER_30_1256 VDD VDD VSS VSS gf180mcu_as_sc_mcu7t3v3__fillcap_8
X_2759_ VDD VDD VSS VSS _3871_/A _5233_/Q _2806_/D _2795_/A _2761_/D gf180mcu_as_sc_mcu7t3v3__ao211_2
X_5478_ VDD VDD VSS VSS _5478_/A _5478_/Y gf180mcu_as_sc_mcu7t3v3__buff_2
X_4429_ VDD VDD VSS VSS _4557_/A _5012_/Q _5041_/Q _4430_/B gf180mcu_as_sc_mcu7t3v3__mux2_2
XFILLER_8_1224 VDD VDD VSS VSS gf180mcu_as_sc_mcu7t3v3__fill_1
Xfanout477 VDD VDD VSS VSS fanout479/Y _4150_/B gf180mcu_as_sc_mcu7t3v3__buff_12
Xfanout499 VDD VDD VSS VSS fanout502/Y _4166_/D gf180mcu_as_sc_mcu7t3v3__buff_12
XTAP_TAPCELL_ROW_187_1795 VDD VSS gf180mcu_as_sc_mcu7t3v3__tap_2
XFILLER_104_75 VDD VDD VSS VSS gf180mcu_as_sc_mcu7t3v3__fill_1
XFILLER_64_68 VDD VDD VSS VSS gf180mcu_as_sc_mcu7t3v3__fill_1
XTAP_TAPCELL_ROW_99_1_1052 VDD VSS gf180mcu_as_sc_mcu7t3v3__tap_2
XTAP_TAPCELL_ROW_113_1_1066 VDD VSS gf180mcu_as_sc_mcu7t3v3__tap_2
XFILLER_168_753 VDD VDD VSS VSS gf180mcu_as_sc_mcu7t3v3__fillcap_16
XTAP_TAPCELL_ROW_13_949 VDD VSS gf180mcu_as_sc_mcu7t3v3__tap_2
XTAP_TAPCELL_ROW_13_938 VDD VSS gf180mcu_as_sc_mcu7t3v3__tap_2
XFILLER_126_1284 VDD VDD VSS VSS gf180mcu_as_sc_mcu7t3v3__fillcap_4
XFILLER_11_998 VDD VDD VSS VSS gf180mcu_as_sc_mcu7t3v3__fillcap_16
XFILLER_156_959 VDD VDD VSS VSS gf180mcu_as_sc_mcu7t3v3__fill_1
XFILLER_167_296 VDD VDD VSS VSS gf180mcu_as_sc_mcu7t3v3__fill_1
XFILLER_171_907 VDD VDD VSS VSS gf180mcu_as_sc_mcu7t3v3__fill_2
XFILLER_183_734 VDD VDD VSS VSS gf180mcu_as_sc_mcu7t3v3__fillcap_4
Xwire856 VDD VDD VSS VSS wire856/A _3508_/A gf180mcu_as_sc_mcu7t3v3__clkbuff_12
XPHY_EDGE_ROW_144_1_Left_336 VDD VSS gf180mcu_as_sc_mcu7t3v3__tap_2
XFILLER_129_72 VDD VDD VSS VSS gf180mcu_as_sc_mcu7t3v3__fillcap_4
XFILLER_183_767 VDD VDD VSS VSS gf180mcu_as_sc_mcu7t3v3__fill_2
Xwire878 VDD VDD VSS VSS wire878/A _3961_/A gf180mcu_as_sc_mcu7t3v3__clkbuff_12
XFILLER_170_428 VDD VDD VSS VSS gf180mcu_as_sc_mcu7t3v3__fill_1
XFILLER_182_277 VDD VDD VSS VSS gf180mcu_as_sc_mcu7t3v3__fillcap_8
XPHY_EDGE_ROW_66_3_Right_107 VDD VSS gf180mcu_as_sc_mcu7t3v3__tap_2
XFILLER_89_87 VDD VDD VSS VSS gf180mcu_as_sc_mcu7t3v3__fillcap_16
XFILLER_145_60 VDD VDD VSS VSS gf180mcu_as_sc_mcu7t3v3__fillcap_8
XPHY_EDGE_ROW_189_Right_51 VDD VSS gf180mcu_as_sc_mcu7t3v3__tap_2
XFILLER_133_1288 VDD VDD VSS VSS gf180mcu_as_sc_mcu7t3v3__fillcap_8
X_4780_ VDD VDD VSS VSS _5220_/CLK _4780_/D _4780_/Q gf180mcu_as_sc_mcu7t3v3__dfxtp_2
X_3800_ VDD VDD VSS VSS _3800_/D _3800_/A _3807_/B _3800_/C _3801_/D gf180mcu_as_sc_mcu7t3v3__ao31_2
XPHY_EDGE_ROW_15_3_Left_387 VDD VSS gf180mcu_as_sc_mcu7t3v3__tap_2
XFILLER_105_1302 VDD VDD VSS VSS gf180mcu_as_sc_mcu7t3v3__fill_1
XFILLER_159_753 VDD VDD VSS VSS gf180mcu_as_sc_mcu7t3v3__fillcap_16
XFILLER_18_1354 VDD VDD VSS VSS gf180mcu_as_sc_mcu7t3v3__fill_1
X_3731_ VDD VDD VSS VSS _4860_/D _3731_/C _3731_/B _3731_/A gf180mcu_as_sc_mcu7t3v3__aoi21_2
XFILLER_186_572 VDD VDD VSS VSS gf180mcu_as_sc_mcu7t3v3__fillcap_16
XFILLER_53_1256 VDD VDD VSS VSS gf180mcu_as_sc_mcu7t3v3__fillcap_4
XPHY_EDGE_ROW_76_1_Left_268 VDD VSS gf180mcu_as_sc_mcu7t3v3__tap_2
XFILLER_186_594 VDD VDD VSS VSS gf180mcu_as_sc_mcu7t3v3__fill_1
Xclkload10 VDD VDD VSS VSS clkload10/Y _5075_/CLK gf180mcu_as_sc_mcu7t3v3__inv_6
X_3662_ VDD VDD VSS VSS _4040_/A _3724_/B _3724_/C _4039_/A _3663_/C gf180mcu_as_sc_mcu7t3v3__ao22_2
XFILLER_62_2 VDD VDD VSS VSS gf180mcu_as_sc_mcu7t3v3__fill_1
Xclkload21 VDD VDD VSS VSS clkload21/Y _5097_/CLK gf180mcu_as_sc_mcu7t3v3__inv_2
X_3593_ VDD VDD VSS VSS _3961_/A _3653_/B _3652_/D _3594_/C _3593_/D gf180mcu_as_sc_mcu7t3v3__aoi211_2
X_2613_ VDD VDD VSS VSS _2621_/B _5229_/Q _2614_/B gf180mcu_as_sc_mcu7t3v3__or2_2
XFILLER_154_480 VDD VDD VSS VSS gf180mcu_as_sc_mcu7t3v3__fill_2
XFILLER_161_439 VDD VDD VSS VSS gf180mcu_as_sc_mcu7t3v3__fill_1
XFILLER_173_277 VDD VDD VSS VSS gf180mcu_as_sc_mcu7t3v3__fill_2
X_2544_ VDD VDD VSS VSS _2771_/D _2798_/B gf180mcu_as_sc_mcu7t3v3__inv_2
X_5263_ VDD VDD VSS VSS _5265_/CLK _5263_/D _5263_/Q gf180mcu_as_sc_mcu7t3v3__dfxtp_2
X_2475_ VDD VDD VSS VSS _2589_/A _4949_/Q _2476_/B gf180mcu_as_sc_mcu7t3v3__and2_2
X_5194_ VDD VDD VSS VSS _5212_/CLK _5194_/D _5194_/Q gf180mcu_as_sc_mcu7t3v3__dfxtp_2
X_4214_ VDD VDD VSS VSS _4243_/B _4227_/B _4227_/C _5050_/Q _5050_/D gf180mcu_as_sc_mcu7t3v3__ao22_2
X_4145_ VDD VDD VSS VSS _4145_/A _4153_/B _4145_/C _4145_/D _4147_/C gf180mcu_as_sc_mcu7t3v3__ao211_2
XFILLER_3_1154 VDD VDD VSS VSS gf180mcu_as_sc_mcu7t3v3__fill_1
X_4076_ VDD VDD VSS VSS _4995_/Q _4076_/B _4246_/B _4076_/D _4995_/D gf180mcu_as_sc_mcu7t3v3__ao22_2
XTAP_TAPCELL_ROW_165_1389 VDD VSS gf180mcu_as_sc_mcu7t3v3__tap_2
XTAP_TAPCELL_ROW_165_1378 VDD VSS gf180mcu_as_sc_mcu7t3v3__tap_2
X_3027_ VDD VDD VSS VSS _3045_/A _3027_/B _3027_/C _3045_/D _3029_/C gf180mcu_as_sc_mcu7t3v3__ao211_2
XFILLER_34_27 VDD VDD VSS VSS gf180mcu_as_sc_mcu7t3v3__fill_1
XFILLER_180_1017 VDD VDD VSS VSS gf180mcu_as_sc_mcu7t3v3__fillcap_16
X_4978_ VDD VDD VSS VSS _5178_/CLK _4978_/D _4978_/Q gf180mcu_as_sc_mcu7t3v3__dfxtp_2
Xsram2048.u_bank0_916 VDD VDD VSS VSS sram2048.u_bank0/WEN[5] gf180mcu_as_sc_mcu7t3v3__tiel_4
Xclkload4 VDD VDD VSS VSS clkload4/Y clkload4/A gf180mcu_as_sc_mcu7t3v3__inv_6
X_3929_ VDD VDD VSS VSS _3929_/Y _3929_/B _3929_/A gf180mcu_as_sc_mcu7t3v3__nor2_2
XPHY_EDGE_ROW_132_1_Right_641 VDD VSS gf180mcu_as_sc_mcu7t3v3__tap_2
XFILLER_192_531 VDD VDD VSS VSS gf180mcu_as_sc_mcu7t3v3__fill_2
XFILLER_50_37 VDD VDD VSS VSS gf180mcu_as_sc_mcu7t3v3__fillcap_4
XFILLER_152_406 VDD VDD VSS VSS gf180mcu_as_sc_mcu7t3v3__fill_2
XFILLER_153_907 VDD VDD VSS VSS gf180mcu_as_sc_mcu7t3v3__fill_2
XFILLER_164_255 VDD VDD VSS VSS gf180mcu_as_sc_mcu7t3v3__fill_2
XFILLER_165_767 VDD VDD VSS VSS gf180mcu_as_sc_mcu7t3v3__fill_2
XFILLER_166_37 VDD VDD VSS VSS gf180mcu_as_sc_mcu7t3v3__fillcap_16
XFILLER_180_737 VDD VDD VSS VSS gf180mcu_as_sc_mcu7t3v3__fill_2
XFILLER_192_597 VDD VDD VSS VSS gf180mcu_as_sc_mcu7t3v3__fillcap_4
XFILLER_156_1222 VDD VDD VSS VSS gf180mcu_as_sc_mcu7t3v3__fill_2
XTAP_TAPCELL_ROW_189_1835 VDD VSS gf180mcu_as_sc_mcu7t3v3__tap_2
XFILLER_156_1266 VDD VDD VSS VSS gf180mcu_as_sc_mcu7t3v3__fillcap_16
XFILLER_191_1146 VDD VDD VSS VSS gf180mcu_as_sc_mcu7t3v3__fillcap_4
XTAP_TAPCELL_ROW_189_1846 VDD VSS gf180mcu_as_sc_mcu7t3v3__tap_2
XFILLER_152_1119 VDD VDD VSS VSS gf180mcu_as_sc_mcu7t3v3__fill_2
XFILLER_182_69 VDD VDD VSS VSS gf180mcu_as_sc_mcu7t3v3__fillcap_16
XTAP_TAPCELL_ROW_132_3_2043 VDD VSS gf180mcu_as_sc_mcu7t3v3__tap_2
XFILLER_46_103 VDD VDD VSS VSS gf180mcu_as_sc_mcu7t3v3__fill_2
XFILLER_8_1087 VDD VDD VSS VSS gf180mcu_as_sc_mcu7t3v3__fill_1
XFILLER_188_804 VDD VDD VSS VSS gf180mcu_as_sc_mcu7t3v3__fill_1
XFILLER_76_1256 VDD VDD VSS VSS gf180mcu_as_sc_mcu7t3v3__fill_2
XFILLER_91_55 VDD VDD VSS VSS gf180mcu_as_sc_mcu7t3v3__fillcap_4
XFILLER_187_347 VDD VDD VSS VSS gf180mcu_as_sc_mcu7t3v3__fill_2
XFILLER_91_99 VDD VDD VSS VSS gf180mcu_as_sc_mcu7t3v3__fillcap_4
XTAP_TAPCELL_ROW_47_1_1000 VDD VSS gf180mcu_as_sc_mcu7t3v3__tap_2
XFILLER_156_734 VDD VDD VSS VSS gf180mcu_as_sc_mcu7t3v3__fill_1
XFILLER_168_594 VDD VDD VSS VSS gf180mcu_as_sc_mcu7t3v3__fill_1
XFILLER_10_272 VDD VDD VSS VSS gf180mcu_as_sc_mcu7t3v3__fillcap_8
XFILLER_10_294 VDD VDD VSS VSS gf180mcu_as_sc_mcu7t3v3__fillcap_4
XFILLER_7_788 VDD VDD VSS VSS gf180mcu_as_sc_mcu7t3v3__fillcap_4
Xwire697 VDD VDD VSS VSS _3386_/B _3449_/B gf180mcu_as_sc_mcu7t3v3__clkbuff_12
XPHY_EDGE_ROW_67_3_Right_108 VDD VSS gf180mcu_as_sc_mcu7t3v3__tap_2
X_4882__1086 VDD VDD VSS VSS _4882_/D gf180mcu_as_sc_mcu7t3v3__tiel_4
XFILLER_168_1115 VDD VDD VSS VSS gf180mcu_as_sc_mcu7t3v3__fill_1
XFILLER_1_53 VDD VDD VSS VSS gf180mcu_as_sc_mcu7t3v3__fill_1
XFILLER_1_64 VDD VDD VSS VSS gf180mcu_as_sc_mcu7t3v3__fillcap_4
XFILLER_179_815 VDD VDD VSS VSS gf180mcu_as_sc_mcu7t3v3__fillcap_4
X_4901_ VDD VDD VSS VSS clkload5/A _4901_/D _4901_/Q gf180mcu_as_sc_mcu7t3v3__dfxtp_2
XFILLER_178_314 VDD VDD VSS VSS gf180mcu_as_sc_mcu7t3v3__fill_1
XFILLER_55_1318 VDD VDD VSS VSS gf180mcu_as_sc_mcu7t3v3__fillcap_4
XTAP_TAPCELL_ROW_67_3_1978 VDD VSS gf180mcu_as_sc_mcu7t3v3__tap_2
XTAP_TAPCELL_ROW_160_1286 VDD VSS gf180mcu_as_sc_mcu7t3v3__tap_2
XFILLER_181_1348 VDD VDD VSS VSS gf180mcu_as_sc_mcu7t3v3__fillcap_4
X_4832_ VDD VDD VSS VSS clkload6/A _4832_/D _4832_/Q gf180mcu_as_sc_mcu7t3v3__dfxtp_2
Xclkbuf_leaf_29_clk_regs VDD VDD VSS VSS clkbuf_3_5__f_clk_regs/Y _5150_/CLK gf180mcu_as_sc_mcu7t3v3__clkbuff_12
X_4763_ VDD VDD VSS VSS _5097_/CLK _4763_/D _4763_/Q gf180mcu_as_sc_mcu7t3v3__dfxtp_2
X_4694_ VDD VDD VSS VSS _4731_/B _4694_/B _5253_/Q _4695_/A gf180mcu_as_sc_mcu7t3v3__mux2_2
X_3714_ VDD VDD VSS VSS _3738_/D _3794_/S _3714_/B _3714_/C _3715_/C gf180mcu_as_sc_mcu7t3v3__ao31_2
XFILLER_162_704 VDD VDD VSS VSS gf180mcu_as_sc_mcu7t3v3__fillcap_4
XFILLER_161_214 VDD VDD VSS VSS gf180mcu_as_sc_mcu7t3v3__fill_1
XFILLER_162_737 VDD VDD VSS VSS gf180mcu_as_sc_mcu7t3v3__fillcap_8
XFILLER_174_597 VDD VDD VSS VSS gf180mcu_as_sc_mcu7t3v3__fillcap_16
XFILLER_175_1108 VDD VDD VSS VSS gf180mcu_as_sc_mcu7t3v3__fillcap_8
X_3645_ VDD VDD VSS VSS _3646_/C _3645_/C _3653_/B _4017_/A gf180mcu_as_sc_mcu7t3v3__aoi21_2
XFILLER_1_909 VDD VDD VSS VSS gf180mcu_as_sc_mcu7t3v3__fill_1
X_3576_ VDD VDD VSS VSS _3938_/D _3650_/B _3576_/C _3576_/D _3577_/C gf180mcu_as_sc_mcu7t3v3__ao211_2
X_2527_ VDD VDD VSS VSS _4655_/B _4657_/B _5268_/Q gf180mcu_as_sc_mcu7t3v3__nor2_2
XFILLER_170_792 VDD VDD VSS VSS gf180mcu_as_sc_mcu7t3v3__fillcap_8
X_5246_ VDD VDD VSS VSS _5285_/CLK _5246_/D _5246_/Q gf180mcu_as_sc_mcu7t3v3__dfxtp_2
Xinput309 VDD VDD VSS VSS west_in[33] _3548_/A gf180mcu_as_sc_mcu7t3v3__buff_12
X_2458_ VDD VDD VSS VSS _3828_/B _3846_/B _3847_/A gf180mcu_as_sc_mcu7t3v3__nand2_2
XTAP_TAPCELL_ROW_167_1418 VDD VSS gf180mcu_as_sc_mcu7t3v3__tap_2
XFILLER_9_1352 VDD VDD VSS VSS gf180mcu_as_sc_mcu7t3v3__fill_2
XFILLER_116_1272 VDD VDD VSS VSS gf180mcu_as_sc_mcu7t3v3__fill_2
XFILLER_28_103 VDD VDD VSS VSS gf180mcu_as_sc_mcu7t3v3__fill_2
X_5177_ VDD VDD VSS VSS _5181_/CLK _5177_/D _5177_/Q gf180mcu_as_sc_mcu7t3v3__dfxtp_2
XTAP_TAPCELL_ROW_4_758 VDD VSS gf180mcu_as_sc_mcu7t3v3__tap_2
XTAP_TAPCELL_ROW_184_1743 VDD VSS gf180mcu_as_sc_mcu7t3v3__tap_2
XFILLER_99_1256 VDD VDD VSS VSS gf180mcu_as_sc_mcu7t3v3__fillcap_8
X_4128_ VDD VDD VSS VSS _4151_/C _4128_/A _4130_/C gf180mcu_as_sc_mcu7t3v3__and2_2
XTAP_TAPCELL_ROW_4_769 VDD VSS gf180mcu_as_sc_mcu7t3v3__tap_2
X_4059_ VDD VDD VSS VSS _4059_/B _4157_/A _4244_/B gf180mcu_as_sc_mcu7t3v3__and2_2
XFILLER_169_314 VDD VDD VSS VSS gf180mcu_as_sc_mcu7t3v3__fillcap_16
XFILLER_162_1292 VDD VDD VSS VSS gf180mcu_as_sc_mcu7t3v3__fill_2
XPHY_EDGE_ROW_133_1_Right_642 VDD VSS gf180mcu_as_sc_mcu7t3v3__tap_2
XFILLER_4_714 VDD VDD VSS VSS gf180mcu_as_sc_mcu7t3v3__fillcap_8
XTAP_TAPCELL_ROW_108_1_1061 VDD VSS gf180mcu_as_sc_mcu7t3v3__tap_2
Xclkbuf_regs_0_clk VDD VDD VSS VSS clk clkbuf_regs_0_clk/Y gf180mcu_as_sc_mcu7t3v3__clkbuff_12
XFILLER_167_1192 VDD VDD VSS VSS gf180mcu_as_sc_mcu7t3v3__fillcap_4
XFILLER_176_807 VDD VDD VSS VSS gf180mcu_as_sc_mcu7t3v3__fillcap_4
XFILLER_188_667 VDD VDD VSS VSS gf180mcu_as_sc_mcu7t3v3__fill_2
XFILLER_141_1321 VDD VDD VSS VSS gf180mcu_as_sc_mcu7t3v3__fill_2
XFILLER_187_188 VDD VDD VSS VSS gf180mcu_as_sc_mcu7t3v3__fillcap_4
XFILLER_156_564 VDD VDD VSS VSS gf180mcu_as_sc_mcu7t3v3__fillcap_4
XFILLER_184_851 VDD VDD VSS VSS gf180mcu_as_sc_mcu7t3v3__fillcap_8
XFILLER_13_1070 VDD VDD VSS VSS gf180mcu_as_sc_mcu7t3v3__fill_1
XFILLER_156_575 VDD VDD VSS VSS gf180mcu_as_sc_mcu7t3v3__fill_1
XFILLER_156_597 VDD VDD VSS VSS gf180mcu_as_sc_mcu7t3v3__fill_1
XFILLER_171_523 VDD VDD VSS VSS gf180mcu_as_sc_mcu7t3v3__fillcap_8
XFILLER_7_574 VDD VDD VSS VSS gf180mcu_as_sc_mcu7t3v3__fill_2
Xwire461 VDD VDD VSS VSS _3760_/Y _4864_/D gf180mcu_as_sc_mcu7t3v3__clkbuff_12
Xwire483 VDD VDD VSS VSS _3065_/Y _4784_/D gf180mcu_as_sc_mcu7t3v3__clkbuff_12
X_3430_ VDD VDD VSS VSS _4078_/A _3504_/B _3513_/C _4081_/A _3431_/C gf180mcu_as_sc_mcu7t3v3__ao22_2
X_3361_ VDD VDD VSS VSS _3450_/B _4015_/A _3364_/C gf180mcu_as_sc_mcu7t3v3__and2_2
X_5100_ VDD VDD VSS VSS _5181_/CLK _5100_/D _5100_/Q gf180mcu_as_sc_mcu7t3v3__dfxtp_2
XPHY_EDGE_ROW_68_3_Right_109 VDD VSS gf180mcu_as_sc_mcu7t3v3__tap_2
X_5031_ VDD VDD VSS VSS _5089_/CLK _5031_/D _5031_/Q gf180mcu_as_sc_mcu7t3v3__dfxtp_2
X_3292_ VDD VDD VSS VSS _3941_/A _3370_/B _3292_/C _3292_/D _3294_/C gf180mcu_as_sc_mcu7t3v3__ao211_2
XTAP_TAPCELL_ROW_1_717 VDD VSS gf180mcu_as_sc_mcu7t3v3__tap_2
XTAP_TAPCELL_ROW_1_706 VDD VSS gf180mcu_as_sc_mcu7t3v3__tap_2
XTAP_TAPCELL_ROW_162_1315 VDD VSS gf180mcu_as_sc_mcu7t3v3__tap_2
XTAP_TAPCELL_ROW_162_1326 VDD VSS gf180mcu_as_sc_mcu7t3v3__tap_2
XFILLER_146_1287 VDD VDD VSS VSS gf180mcu_as_sc_mcu7t3v3__fill_2
X_4815_ VDD VDD VSS VSS clkload6/A _4815_/D _4815_/Q gf180mcu_as_sc_mcu7t3v3__dfxtp_2
XFILLER_166_328 VDD VDD VSS VSS gf180mcu_as_sc_mcu7t3v3__fill_2
XFILLER_178_177 VDD VDD VSS VSS gf180mcu_as_sc_mcu7t3v3__fill_1
XTAP_TAPCELL_ROW_15_3_1926 VDD VSS gf180mcu_as_sc_mcu7t3v3__tap_2
X_4746_ VDD VDD VSS VSS _4746_/A _4746_/B _4746_/C _4747_/C _4746_/D gf180mcu_as_sc_mcu7t3v3__aoi211_2
XFILLER_179_1052 VDD VDD VSS VSS gf180mcu_as_sc_mcu7t3v3__fillcap_16
X_4677_ VDD VDD VSS VSS _5246_/Q _4685_/C _4681_/C _5247_/Q _4678_/C gf180mcu_as_sc_mcu7t3v3__ao22_2
XFILLER_162_556 VDD VDD VSS VSS gf180mcu_as_sc_mcu7t3v3__fill_2
XFILLER_190_843 VDD VDD VSS VSS gf180mcu_as_sc_mcu7t3v3__fill_2
X_3628_ VDD VDD VSS VSS _3629_/C _3997_/A _3791_/B _3628_/C gf180mcu_as_sc_mcu7t3v3__ao21_2
XFILLER_157_1350 VDD VDD VSS VSS gf180mcu_as_sc_mcu7t3v3__fillcap_4
XFILLER_192_1230 VDD VDD VSS VSS gf180mcu_as_sc_mcu7t3v3__fill_2
XFILLER_192_1241 VDD VDD VSS VSS gf180mcu_as_sc_mcu7t3v3__fill_2
XFILLER_153_1203 VDD VDD VSS VSS gf180mcu_as_sc_mcu7t3v3__fill_2
XFILLER_163_38 VDD VDD VSS VSS gf180mcu_as_sc_mcu7t3v3__fillcap_16
Xmax_cap794 VDD VDD VSS VSS _5482_/A _4698_/B gf180mcu_as_sc_mcu7t3v3__clkbuff_12
X_3559_ VDD VDD VSS VSS _3559_/A _3922_/B _3559_/C _3559_/Y _3805_/B gf180mcu_as_sc_mcu7t3v3__aoi211_2
XFILLER_66_1299 VDD VDD VSS VSS gf180mcu_as_sc_mcu7t3v3__fillcap_4
Xinput106 VDD VDD VSS VSS ne_in[4] _3965_/A gf180mcu_as_sc_mcu7t3v3__buff_12
Xinput117 VDD VDD VSS VSS north_in[14] wire904/A gf180mcu_as_sc_mcu7t3v3__buff_12
X_5229_ VDD VDD VSS VSS _5267_/CLK _5229_/D _5229_/Q gf180mcu_as_sc_mcu7t3v3__dfxtp_2
Xinput128 VDD VDD VSS VSS north_in[24] _4129_/A gf180mcu_as_sc_mcu7t3v3__buff_12
Xinput139 VDD VDD VSS VSS north_in[3] _3959_/A gf180mcu_as_sc_mcu7t3v3__buff_12
XFILLER_186_6 VDD VDD VSS VSS gf180mcu_as_sc_mcu7t3v3__fillcap_16
XFILLER_125_1305 VDD VDD VSS VSS gf180mcu_as_sc_mcu7t3v3__fill_1
XFILLER_158_807 VDD VDD VSS VSS gf180mcu_as_sc_mcu7t3v3__fillcap_16
XFILLER_157_317 VDD VDD VSS VSS gf180mcu_as_sc_mcu7t3v3__fillcap_8
XFILLER_185_626 VDD VDD VSS VSS gf180mcu_as_sc_mcu7t3v3__fillcap_4
XFILLER_153_501 VDD VDD VSS VSS gf180mcu_as_sc_mcu7t3v3__fill_1
XPHY_EDGE_ROW_134_1_Right_643 VDD VSS gf180mcu_as_sc_mcu7t3v3__tap_2
XFILLER_153_523 VDD VDD VSS VSS gf180mcu_as_sc_mcu7t3v3__fill_2
XFILLER_181_865 VDD VDD VSS VSS gf180mcu_as_sc_mcu7t3v3__fillcap_16
XFILLER_21_50 VDD VDD VSS VSS gf180mcu_as_sc_mcu7t3v3__fill_2
XFILLER_21_72 VDD VDD VSS VSS gf180mcu_as_sc_mcu7t3v3__fillcap_16
XFILLER_137_72 VDD VDD VSS VSS gf180mcu_as_sc_mcu7t3v3__fillcap_8
XFILLER_153_578 VDD VDD VSS VSS gf180mcu_as_sc_mcu7t3v3__fillcap_4
XFILLER_84_1333 VDD VDD VSS VSS gf180mcu_as_sc_mcu7t3v3__fillcap_16
XFILLER_180_397 VDD VDD VSS VSS gf180mcu_as_sc_mcu7t3v3__fillcap_8
XTAP_TAPCELL_ROW_8_850 VDD VSS gf180mcu_as_sc_mcu7t3v3__tap_2
XPHY_EDGE_ROW_24_3_Left_396 VDD VSS gf180mcu_as_sc_mcu7t3v3__tap_2
XPHY_EDGE_ROW_85_1_Left_277 VDD VSS gf180mcu_as_sc_mcu7t3v3__tap_2
XFILLER_91_1326 VDD VDD VSS VSS gf180mcu_as_sc_mcu7t3v3__fill_2
X_2930_ VDD VDD VSS VSS _2930_/Y _3216_/B _2930_/A gf180mcu_as_sc_mcu7t3v3__nor2_2
X_4600_ VDD VDD VSS VSS _5194_/Q _4617_/B _4617_/C _5195_/Q _5194_/D gf180mcu_as_sc_mcu7t3v3__ao22_2
X_2861_ VDD VDD VSS VSS _2871_/B _2861_/B _4733_/B gf180mcu_as_sc_mcu7t3v3__nand2_2
XFILLER_106_1260 VDD VDD VSS VSS gf180mcu_as_sc_mcu7t3v3__fill_2
X_2792_ VDD VDD VSS VSS _4732_/C _2792_/A _5267_/Q _4732_/B _2793_/B gf180mcu_as_sc_mcu7t3v3__ao31_2
X_4531_ VDD VDD VSS VSS _5181_/Q _4574_/B _4531_/C _4531_/D _5181_/D gf180mcu_as_sc_mcu7t3v3__ao211_2
XFILLER_172_854 VDD VDD VSS VSS gf180mcu_as_sc_mcu7t3v3__fill_2
X_4462_ VDD VDD VSS VSS _4465_/C _4987_/Q _4473_/A gf180mcu_as_sc_mcu7t3v3__nand2b_2
XTAP_TAPCELL_ROW_155_1196 VDD VSS gf180mcu_as_sc_mcu7t3v3__tap_2
XTAP_TAPCELL_ROW_155_1185 VDD VSS gf180mcu_as_sc_mcu7t3v3__tap_2
X_3413_ VDD VDD VSS VSS _3452_/S _4064_/D _3413_/A _3415_/B gf180mcu_as_sc_mcu7t3v3__mux2_2
Xfanout807 VDD VDD VSS VSS _4684_/A _2845_/D gf180mcu_as_sc_mcu7t3v3__buff_12
X_4393_ VDD VDD VSS VSS _4394_/D _4393_/B _4502_/A gf180mcu_as_sc_mcu7t3v3__nor2_2
XTAP_TAPCELL_ROW_6_809 VDD VSS gf180mcu_as_sc_mcu7t3v3__tap_2
Xfanout818 VDD VDD VSS VSS _4561_/A _4560_/A gf180mcu_as_sc_mcu7t3v3__buff_12
Xfanout829 VDD VDD VSS VSS _4473_/A _4579_/S gf180mcu_as_sc_mcu7t3v3__buff_12
X_3344_ VDD VDD VSS VSS _3344_/B _3525_/A _4812_/D gf180mcu_as_sc_mcu7t3v3__and2_2
X_3275_ VDD VDD VSS VSS _3280_/D _3275_/B _3275_/A gf180mcu_as_sc_mcu7t3v3__nand2_2
X_5014_ VDD VDD VSS VSS _5178_/CLK _5014_/D _5014_/Q gf180mcu_as_sc_mcu7t3v3__dfxtp_2
XFILLER_113_1264 VDD VDD VSS VSS gf180mcu_as_sc_mcu7t3v3__fill_2
XFILLER_187_1332 VDD VDD VSS VSS gf180mcu_as_sc_mcu7t3v3__fillcap_16
XTAP_TAPCELL_ROW_70_1_1023 VDD VSS gf180mcu_as_sc_mcu7t3v3__tap_2
XFILLER_113_1297 VDD VDD VSS VSS gf180mcu_as_sc_mcu7t3v3__fill_2
XFILLER_148_1316 VDD VDD VSS VSS gf180mcu_as_sc_mcu7t3v3__fillcap_4
XFILLER_187_1354 VDD VDD VSS VSS gf180mcu_as_sc_mcu7t3v3__fill_1
XFILLER_183_1218 VDD VDD VSS VSS gf180mcu_as_sc_mcu7t3v3__fill_1
XTAP_TAPCELL_ROW_179_1653 VDD VSS gf180mcu_as_sc_mcu7t3v3__tap_2
XTAP_TAPCELL_ROW_179_1642 VDD VSS gf180mcu_as_sc_mcu7t3v3__tap_2
XFILLER_166_114 VDD VDD VSS VSS gf180mcu_as_sc_mcu7t3v3__fillcap_8
XFILLER_42_27 VDD VDD VSS VSS gf180mcu_as_sc_mcu7t3v3__fillcap_8
X_4729_ VDD VDD VSS VSS _5265_/D _5265_/Q _4730_/C _4729_/C gf180mcu_as_sc_mcu7t3v3__ao21_2
XTAP_TAPCELL_ROW_192_1897 VDD VSS gf180mcu_as_sc_mcu7t3v3__tap_2
XTAP_TAPCELL_ROW_192_1886 VDD VSS gf180mcu_as_sc_mcu7t3v3__tap_2
XFILLER_162_353 VDD VDD VSS VSS gf180mcu_as_sc_mcu7t3v3__fillcap_8
XFILLER_163_876 VDD VDD VSS VSS gf180mcu_as_sc_mcu7t3v3__fill_1
XFILLER_162_375 VDD VDD VSS VSS gf180mcu_as_sc_mcu7t3v3__fillcap_8
XFILLER_107_53 VDD VDD VSS VSS gf180mcu_as_sc_mcu7t3v3__fillcap_16
XFILLER_44_1350 VDD VDD VSS VSS gf180mcu_as_sc_mcu7t3v3__fillcap_4
XPHY_EDGE_ROW_152_Right_14 VDD VSS gf180mcu_as_sc_mcu7t3v3__tap_2
XFILLER_83_67 VDD VDD VSS VSS gf180mcu_as_sc_mcu7t3v3__fill_2
XFILLER_189_228 VDD VDD VSS VSS gf180mcu_as_sc_mcu7t3v3__fill_2
XFILLER_13_654 VDD VDD VSS VSS gf180mcu_as_sc_mcu7t3v3__fill_1
XPHY_EDGE_ROW_161_Right_23 VDD VSS gf180mcu_as_sc_mcu7t3v3__tap_2
XFILLER_13_698 VDD VDD VSS VSS gf180mcu_as_sc_mcu7t3v3__fill_1
XFILLER_157_169 VDD VDD VSS VSS gf180mcu_as_sc_mcu7t3v3__fill_2
XFILLER_173_618 VDD VDD VSS VSS gf180mcu_as_sc_mcu7t3v3__fill_1
XFILLER_185_489 VDD VDD VSS VSS gf180mcu_as_sc_mcu7t3v3__fill_1
XFILLER_154_854 VDD VDD VSS VSS gf180mcu_as_sc_mcu7t3v3__fillcap_16
XFILLER_5_842 VDD VDD VSS VSS gf180mcu_as_sc_mcu7t3v3__fillcap_4
XTAP_TAPCELL_ROW_46_1_999 VDD VSS gf180mcu_as_sc_mcu7t3v3__tap_2
XTAP_TAPCELL_ROW_11_899 VDD VSS gf180mcu_as_sc_mcu7t3v3__tap_2
XFILLER_181_662 VDD VDD VSS VSS gf180mcu_as_sc_mcu7t3v3__fill_1
XPHY_EDGE_ROW_135_1_Right_644 VDD VSS gf180mcu_as_sc_mcu7t3v3__tap_2
XPHY_EDGE_ROW_170_Right_32 VDD VSS gf180mcu_as_sc_mcu7t3v3__tap_2
XFILLER_0_580 VDD VDD VSS VSS gf180mcu_as_sc_mcu7t3v3__fillcap_4
X_3060_ VDD VDD VSS VSS _4039_/A _3127_/B _3127_/C _4040_/D _3061_/C gf180mcu_as_sc_mcu7t3v3__ao22_2
XFILLER_169_1095 VDD VDD VSS VSS gf180mcu_as_sc_mcu7t3v3__fillcap_16
XFILLER_189_762 VDD VDD VSS VSS gf180mcu_as_sc_mcu7t3v3__fillcap_8
XFILLER_92_2 VDD VDD VSS VSS gf180mcu_as_sc_mcu7t3v3__fill_2
X_3962_ VDD VDD VSS VSS _3962_/A _4027_/B _3962_/C _3962_/D _3963_/B gf180mcu_as_sc_mcu7t3v3__ao22_2
XTAP_TAPCELL_ROW_131_1_1084 VDD VSS gf180mcu_as_sc_mcu7t3v3__tap_2
XFILLER_182_1284 VDD VDD VSS VSS gf180mcu_as_sc_mcu7t3v3__fill_1
X_3893_ VDD VDD VSS VSS _3895_/B _5183_/Q _4933_/D gf180mcu_as_sc_mcu7t3v3__and2_2
X_2913_ VDD VDD VSS VSS _3788_/D _3796_/D _3544_/C gf180mcu_as_sc_mcu7t3v3__or2_2
X_2844_ VDD VDD VSS VSS _4746_/A _4746_/B _2844_/C _4746_/D _2856_/A gf180mcu_as_sc_mcu7t3v3__ao211_2
XTAP_TAPCELL_ROW_157_1236 VDD VSS gf180mcu_as_sc_mcu7t3v3__tap_2
XTAP_TAPCELL_ROW_157_1225 VDD VSS gf180mcu_as_sc_mcu7t3v3__tap_2
XFILLER_164_629 VDD VDD VSS VSS gf180mcu_as_sc_mcu7t3v3__fillcap_4
XFILLER_191_415 VDD VDD VSS VSS gf180mcu_as_sc_mcu7t3v3__fillcap_4
XFILLER_192_949 VDD VDD VSS VSS gf180mcu_as_sc_mcu7t3v3__fill_2
XTAP_TAPCELL_ROW_174_1561 VDD VSS gf180mcu_as_sc_mcu7t3v3__tap_2
XTAP_TAPCELL_ROW_174_1550 VDD VSS gf180mcu_as_sc_mcu7t3v3__tap_2
XFILLER_185_990 VDD VDD VSS VSS gf180mcu_as_sc_mcu7t3v3__fill_2
X_4514_ VDD VDD VSS VSS _5181_/Q _4514_/B _4523_/C _5115_/Q _4515_/B gf180mcu_as_sc_mcu7t3v3__ao22_2
X_2775_ VDD VDD VSS VSS _5232_/Q _5231_/Q _5229_/Q _2776_/B gf180mcu_as_sc_mcu7t3v3__nor3_2
XFILLER_160_813 VDD VDD VSS VSS gf180mcu_as_sc_mcu7t3v3__fill_1
XFILLER_171_150 VDD VDD VSS VSS gf180mcu_as_sc_mcu7t3v3__fillcap_4
X_4445_ VDD VDD VSS VSS _4449_/B _5072_/Q _4579_/S gf180mcu_as_sc_mcu7t3v3__nand2_2
XTAP_TAPCELL_ROW_170_1469 VDD VSS gf180mcu_as_sc_mcu7t3v3__tap_2
Xfanout604 VDD VDD VSS VSS fanout605/A _3791_/B gf180mcu_as_sc_mcu7t3v3__buff_12
Xfanout615 VDD VDD VSS VSS _4514_/B _4590_/B gf180mcu_as_sc_mcu7t3v3__buff_12
X_4376_ VDD VDD VSS VSS _4379_/B _4376_/B _5163_/Q _5163_/D gf180mcu_as_sc_mcu7t3v3__mux2_2
XFILLER_115_1326 VDD VDD VSS VSS gf180mcu_as_sc_mcu7t3v3__fillcap_4
Xfanout626 VDD VDD VSS VSS _3924_/Y _4101_/B gf180mcu_as_sc_mcu7t3v3__buff_12
Xfanout637 VDD VDD VSS VSS wire640/Y _3724_/B gf180mcu_as_sc_mcu7t3v3__buff_12
Xfanout648 VDD VDD VSS VSS _3550_/Y _3800_/C gf180mcu_as_sc_mcu7t3v3__buff_12
X_3327_ VDD VDD VSS VSS _3608_/A _3432_/B _3327_/C _4810_/D _3638_/D gf180mcu_as_sc_mcu7t3v3__aoi211_2
Xfanout659 VDD VDD VSS VSS _3262_/Y _3495_/B gf180mcu_as_sc_mcu7t3v3__buff_12
XFILLER_37_27 VDD VDD VSS VSS gf180mcu_as_sc_mcu7t3v3__fillcap_4
X_3258_ VDD VDD VSS VSS _3263_/A _3271_/A _3271_/B gf180mcu_as_sc_mcu7t3v3__nor2b_2
X_3189_ VDD VDD VSS VSS _3192_/C _3216_/C _3238_/C gf180mcu_as_sc_mcu7t3v3__or2_2
X_4895__1073 VDD VDD VSS VSS _4895_/D gf180mcu_as_sc_mcu7t3v3__tiel_4
XFILLER_183_1015 VDD VDD VSS VSS gf180mcu_as_sc_mcu7t3v3__fill_2
XFILLER_183_1048 VDD VDD VSS VSS gf180mcu_as_sc_mcu7t3v3__fill_2
XFILLER_186_209 VDD VDD VSS VSS gf180mcu_as_sc_mcu7t3v3__fillcap_16
XFILLER_149_6 VDD VDD VSS VSS gf180mcu_as_sc_mcu7t3v3__fillcap_16
XFILLER_167_445 VDD VDD VSS VSS gf180mcu_as_sc_mcu7t3v3__fillcap_16
XFILLER_10_646 VDD VDD VSS VSS gf180mcu_as_sc_mcu7t3v3__fillcap_8
XFILLER_167_489 VDD VDD VSS VSS gf180mcu_as_sc_mcu7t3v3__fill_1
XFILLER_182_437 VDD VDD VSS VSS gf180mcu_as_sc_mcu7t3v3__fillcap_16
XFILLER_118_52 VDD VDD VSS VSS gf180mcu_as_sc_mcu7t3v3__fill_2
XFILLER_155_1117 VDD VDD VSS VSS gf180mcu_as_sc_mcu7t3v3__fill_2
XFILLER_190_492 VDD VDD VSS VSS gf180mcu_as_sc_mcu7t3v3__fillcap_4
XFILLER_2_856 VDD VDD VSS VSS gf180mcu_as_sc_mcu7t3v3__fillcap_16
XFILLER_1_366 VDD VDD VSS VSS gf180mcu_as_sc_mcu7t3v3__fill_2
XFILLER_134_84 VDD VDD VSS VSS gf180mcu_as_sc_mcu7t3v3__fillcap_4
Xmesh_tile_1025 VDD VDD VSS VSS nw_out[31] gf180mcu_as_sc_mcu7t3v3__tiel_4
Xmesh_tile_1014 VDD VDD VSS VSS nw_out[20] gf180mcu_as_sc_mcu7t3v3__tiel_4
Xmesh_tile_1003 VDD VDD VSS VSS nw_out[9] gf180mcu_as_sc_mcu7t3v3__tiel_4
XFILLER_94_66 VDD VDD VSS VSS gf180mcu_as_sc_mcu7t3v3__fillcap_4
Xmesh_tile_1058 VDD VDD VSS VSS sw_out[30] gf180mcu_as_sc_mcu7t3v3__tiel_4
Xmesh_tile_1047 VDD VDD VSS VSS sw_out[19] gf180mcu_as_sc_mcu7t3v3__tiel_4
Xmesh_tile_1036 VDD VDD VSS VSS sw_out[8] gf180mcu_as_sc_mcu7t3v3__tiel_4
XFILLER_150_83 VDD VDD VSS VSS gf180mcu_as_sc_mcu7t3v3__fill_2
XFILLER_79_1287 VDD VDD VSS VSS gf180mcu_as_sc_mcu7t3v3__fillcap_8
XFILLER_159_935 VDD VDD VSS VSS gf180mcu_as_sc_mcu7t3v3__fill_2
XFILLER_186_710 VDD VDD VSS VSS gf180mcu_as_sc_mcu7t3v3__fillcap_16
XPHY_EDGE_ROW_116_1_Left_308 VDD VSS gf180mcu_as_sc_mcu7t3v3__tap_2
XFILLER_9_422 VDD VDD VSS VSS gf180mcu_as_sc_mcu7t3v3__fill_2
XFILLER_185_253 VDD VDD VSS VSS gf180mcu_as_sc_mcu7t3v3__fillcap_16
XTAP_TAPCELL_ROW_152_1111 VDD VSS gf180mcu_as_sc_mcu7t3v3__tap_2
XPHY_EDGE_ROW_120_3_Right_161 VDD VSS gf180mcu_as_sc_mcu7t3v3__tap_2
X_2560_ VDD VDD VSS VSS _2560_/Y _2831_/B _4952_/D gf180mcu_as_sc_mcu7t3v3__nor2b_2
XTAP_TAPCELL_ROW_152_1133 VDD VSS gf180mcu_as_sc_mcu7t3v3__tap_2
XTAP_TAPCELL_ROW_152_1122 VDD VSS gf180mcu_as_sc_mcu7t3v3__tap_2
XFILLER_175_80 VDD VDD VSS VSS gf180mcu_as_sc_mcu7t3v3__fill_2
X_2491_ VDD VDD VSS VSS _4649_/A _5269_/Q _4371_/A gf180mcu_as_sc_mcu7t3v3__nor2b_2
XPHY_EDGE_ROW_136_1_Right_645 VDD VSS gf180mcu_as_sc_mcu7t3v3__tap_2
XFILLER_173_1239 VDD VDD VSS VSS gf180mcu_as_sc_mcu7t3v3__fill_1
XFILLER_181_492 VDD VDD VSS VSS gf180mcu_as_sc_mcu7t3v3__fillcap_8
X_4230_ VDD VDD VSS VSS _4257_/S _4230_/B _5066_/Q _5066_/D gf180mcu_as_sc_mcu7t3v3__mux2_2
X_4161_ VDD VDD VSS VSS _4161_/A _4161_/B _4161_/C _4161_/D _4163_/C gf180mcu_as_sc_mcu7t3v3__ao211_2
XTAP_TAPCELL_ROW_150_3_2061 VDD VSS gf180mcu_as_sc_mcu7t3v3__tap_2
X_4092_ VDD VDD VSS VSS _4997_/Q _4166_/B _4248_/B _4166_/D _4997_/D gf180mcu_as_sc_mcu7t3v3__ao22_2
X_3112_ VDD VDD VSS VSS _3153_/A _3112_/B _3112_/C _3153_/D _3113_/D gf180mcu_as_sc_mcu7t3v3__ao211_2
XFILLER_23_1264 VDD VDD VSS VSS gf180mcu_as_sc_mcu7t3v3__fill_1
XFILLER_62_1291 VDD VDD VSS VSS gf180mcu_as_sc_mcu7t3v3__fill_2
XFILLER_82_104 VDD VDD VSS VSS gf180mcu_as_sc_mcu7t3v3__fill_1
X_3043_ VDD VDD VSS VSS _3043_/S _4021_/D _4024_/A _3045_/B gf180mcu_as_sc_mcu7t3v3__mux2_2
XFILLER_110_1256 VDD VDD VSS VSS gf180mcu_as_sc_mcu7t3v3__fillcap_16
X_4994_ VDD VDD VSS VSS _5089_/CLK _4994_/D _4994_/Q gf180mcu_as_sc_mcu7t3v3__dfxtp_2
XFILLER_189_570 VDD VDD VSS VSS gf180mcu_as_sc_mcu7t3v3__fillcap_4
X_3945_ VDD VDD VSS VSS _4230_/B _3945_/B _4099_/D gf180mcu_as_sc_mcu7t3v3__nor2_2
XFILLER_176_253 VDD VDD VSS VSS gf180mcu_as_sc_mcu7t3v3__fill_1
XFILLER_176_275 VDD VDD VSS VSS gf180mcu_as_sc_mcu7t3v3__fillcap_4
X_3876_ VDD VDD VSS VSS _3895_/B _5166_/Q _4916_/D gf180mcu_as_sc_mcu7t3v3__and2_2
XTAP_TAPCELL_ROW_172_1509 VDD VSS gf180mcu_as_sc_mcu7t3v3__tap_2
XPHY_EDGE_ROW_49_3_Left_421 VDD VSS gf180mcu_as_sc_mcu7t3v3__tap_2
XFILLER_164_437 VDD VDD VSS VSS gf180mcu_as_sc_mcu7t3v3__fillcap_4
XFILLER_191_212 VDD VDD VSS VSS gf180mcu_as_sc_mcu7t3v3__fillcap_16
XPHY_EDGE_ROW_101_3_Left_473 VDD VSS gf180mcu_as_sc_mcu7t3v3__tap_2
X_2827_ VDD VDD VSS VSS _4975_/D _2827_/B _5282_/Q _5281_/D gf180mcu_as_sc_mcu7t3v3__mux2_2
XFILLER_178_1139 VDD VDD VSS VSS gf180mcu_as_sc_mcu7t3v3__fillcap_16
XFILLER_192_779 VDD VDD VSS VSS gf180mcu_as_sc_mcu7t3v3__fill_2
X_2758_ VDD VDD VSS VSS _3871_/A _5233_/Q _2806_/D _2809_/B _2795_/A gf180mcu_as_sc_mcu7t3v3__aoi211_2
XFILLER_173_993 VDD VDD VSS VSS gf180mcu_as_sc_mcu7t3v3__fillcap_16
XFILLER_160_632 VDD VDD VSS VSS gf180mcu_as_sc_mcu7t3v3__fillcap_16
X_4428_ VDD VDD VSS VSS _4431_/C _4983_/Q _4557_/A gf180mcu_as_sc_mcu7t3v3__nand2b_2
X_2689_ VDD VDD VSS VSS _5158_/Q _4272_/S _4275_/S _5182_/Q _2690_/C gf180mcu_as_sc_mcu7t3v3__ao22_2
XFILLER_119_1281 VDD VDD VSS VSS gf180mcu_as_sc_mcu7t3v3__fillcap_8
XFILLER_48_37 VDD VDD VSS VSS gf180mcu_as_sc_mcu7t3v3__fill_2
X_4359_ VDD VDD VSS VSS _4364_/B _4364_/A _4360_/A gf180mcu_as_sc_mcu7t3v3__xnor2_2
XFILLER_154_1194 VDD VDD VSS VSS gf180mcu_as_sc_mcu7t3v3__fill_1
XFILLER_171_38 VDD VDD VSS VSS gf180mcu_as_sc_mcu7t3v3__fillcap_8
Xfanout478 VDD VDD VSS VSS fanout479/Y _4158_/B gf180mcu_as_sc_mcu7t3v3__buff_12
XTAP_TAPCELL_ROW_187_1796 VDD VSS gf180mcu_as_sc_mcu7t3v3__tap_2
XTAP_TAPCELL_ROW_85_3_1996 VDD VSS gf180mcu_as_sc_mcu7t3v3__tap_2
XTAP_TAPCELL_ROW_45_1_998 VDD VSS gf180mcu_as_sc_mcu7t3v3__tap_2
XFILLER_159_209 VDD VDD VSS VSS gf180mcu_as_sc_mcu7t3v3__fill_1
XFILLER_168_732 VDD VDD VSS VSS gf180mcu_as_sc_mcu7t3v3__fill_2
XTAP_TAPCELL_ROW_13_939 VDD VSS gf180mcu_as_sc_mcu7t3v3__tap_2
XFILLER_161_1187 VDD VDD VSS VSS gf180mcu_as_sc_mcu7t3v3__fill_2
XFILLER_183_702 VDD VDD VSS VSS gf180mcu_as_sc_mcu7t3v3__fillcap_4
Xwire802 VDD VDD VSS VSS _5478_/A _4718_/A gf180mcu_as_sc_mcu7t3v3__clkbuff_12
XFILLER_183_746 VDD VDD VSS VSS gf180mcu_as_sc_mcu7t3v3__fill_2
XFILLER_6_403 VDD VDD VSS VSS gf180mcu_as_sc_mcu7t3v3__fill_2
Xwire857 VDD VDD VSS VSS wire857/A _3797_/A gf180mcu_as_sc_mcu7t3v3__clkbuff_12
XFILLER_182_267 VDD VDD VSS VSS gf180mcu_as_sc_mcu7t3v3__fill_2
Xwire879 VDD VDD VSS VSS wire879/A _3952_/A gf180mcu_as_sc_mcu7t3v3__clkbuff_12
XPHY_EDGE_ROW_94_1_Left_286 VDD VSS gf180mcu_as_sc_mcu7t3v3__tap_2
XFILLER_163_470 VDD VDD VSS VSS gf180mcu_as_sc_mcu7t3v3__fillcap_16
XFILLER_163_492 VDD VDD VSS VSS gf180mcu_as_sc_mcu7t3v3__fill_2
XFILLER_145_94 VDD VDD VSS VSS gf180mcu_as_sc_mcu7t3v3__fillcap_8
XFILLER_46_1286 VDD VDD VSS VSS gf180mcu_as_sc_mcu7t3v3__fill_2
XFILLER_133_1256 VDD VDD VSS VSS gf180mcu_as_sc_mcu7t3v3__fillcap_16
XFILLER_166_1010 VDD VDD VSS VSS gf180mcu_as_sc_mcu7t3v3__fillcap_4
XFILLER_166_1021 VDD VDD VSS VSS gf180mcu_as_sc_mcu7t3v3__fill_1
XFILLER_159_710 VDD VDD VSS VSS gf180mcu_as_sc_mcu7t3v3__fillcap_16
XFILLER_166_1087 VDD VDD VSS VSS gf180mcu_as_sc_mcu7t3v3__fillcap_4
X_3730_ VDD VDD VSS VSS _3730_/D _3730_/A _3730_/B _3730_/C _3731_/C gf180mcu_as_sc_mcu7t3v3__ao31_2
XFILLER_159_776 VDD VDD VSS VSS gf180mcu_as_sc_mcu7t3v3__fill_1
XFILLER_9_241 VDD VDD VSS VSS gf180mcu_as_sc_mcu7t3v3__fill_1
XFILLER_173_212 VDD VDD VSS VSS gf180mcu_as_sc_mcu7t3v3__fillcap_16
X_3661_ VDD VDD VSS VSS _3661_/A _3731_/B _3661_/C _4851_/D _3676_/D gf180mcu_as_sc_mcu7t3v3__aoi211_2
Xclkload11 VDD VDD VSS VSS _5158_/CLK clkload11/Y gf180mcu_as_sc_mcu7t3v3__clkbuff_12
Xclkload22 VDD VDD VSS VSS _5150_/CLK clkload22/Y gf180mcu_as_sc_mcu7t3v3__clkbuff_4
X_3592_ VDD VDD VSS VSS _3956_/D _3650_/B _3592_/C _3592_/D _3593_/D gf180mcu_as_sc_mcu7t3v3__ao211_2
X_2612_ VDD VDD VSS VSS _2621_/B _5230_/Q _5232_/Q gf180mcu_as_sc_mcu7t3v3__nor2b_2
XPHY_EDGE_ROW_121_3_Right_162 VDD VSS gf180mcu_as_sc_mcu7t3v3__tap_2
XFILLER_55_2 VDD VDD VSS VSS gf180mcu_as_sc_mcu7t3v3__fill_2
X_2543_ VDD VDD VSS VSS _2798_/B _4328_/A _5125_/Q gf180mcu_as_sc_mcu7t3v3__nand2_2
XFILLER_170_996 VDD VDD VSS VSS gf180mcu_as_sc_mcu7t3v3__fillcap_16
XFILLER_173_1047 VDD VDD VSS VSS gf180mcu_as_sc_mcu7t3v3__fill_2
X_5262_ VDD VDD VSS VSS _5280_/CLK _5262_/D _5262_/Q gf180mcu_as_sc_mcu7t3v3__dfxtp_2
X_2474_ VDD VDD VSS VSS _2474_/A _4350_/D _2474_/C _2589_/A gf180mcu_as_sc_mcu7t3v3__nor3_2
XPHY_EDGE_ROW_137_1_Right_646 VDD VSS gf180mcu_as_sc_mcu7t3v3__tap_2
XFILLER_151_1301 VDD VDD VSS VSS gf180mcu_as_sc_mcu7t3v3__fillcap_8
XFILLER_25_1326 VDD VDD VSS VSS gf180mcu_as_sc_mcu7t3v3__fill_2
X_5193_ VDD VDD VSS VSS _5212_/CLK _5193_/D _5193_/Q gf180mcu_as_sc_mcu7t3v3__dfxtp_2
X_4213_ VDD VDD VSS VSS _4242_/B _4217_/B _4218_/C _5049_/Q _5049_/D gf180mcu_as_sc_mcu7t3v3__ao22_2
XTAP_TAPCELL_ROW_169_1460 VDD VSS gf180mcu_as_sc_mcu7t3v3__tap_2
X_4144_ VDD VDD VSS VSS _4144_/A _4152_/B _4152_/C _4941_/Q _4145_/D gf180mcu_as_sc_mcu7t3v3__ao22_2
XFILLER_3_1122 VDD VDD VSS VSS gf180mcu_as_sc_mcu7t3v3__fillcap_4
X_4075_ VDD VDD VSS VSS _4075_/A _4086_/C _4075_/C _4246_/B _4099_/D gf180mcu_as_sc_mcu7t3v3__aoi211_2
XTAP_TAPCELL_ROW_165_1379 VDD VSS gf180mcu_as_sc_mcu7t3v3__tap_2
X_3026_ VDD VDD VSS VSS _4005_/A _3044_/B _3044_/C _4007_/A _3027_/C gf180mcu_as_sc_mcu7t3v3__ao22_2
X_4977_ VDD VDD VSS VSS clkload1/A _4977_/D _4977_/Q gf180mcu_as_sc_mcu7t3v3__dfxtp_2
Xsram2048.u_bank0_917 VDD VDD VSS VSS sram2048.u_bank0/WEN[6] gf180mcu_as_sc_mcu7t3v3__tiel_4
XFILLER_165_713 VDD VDD VSS VSS gf180mcu_as_sc_mcu7t3v3__fillcap_4
Xclkload5 VDD VDD VSS VSS clkload5/A clkload5/Y gf180mcu_as_sc_mcu7t3v3__clkbuff_12
X_3928_ VDD VDD VSS VSS _3928_/Y _3932_/D _3928_/A gf180mcu_as_sc_mcu7t3v3__nor2_2
XFILLER_164_201 VDD VDD VSS VSS gf180mcu_as_sc_mcu7t3v3__fillcap_4
XFILLER_192_521 VDD VDD VSS VSS gf180mcu_as_sc_mcu7t3v3__fill_2
X_3859_ VDD VDD VSS VSS _3862_/A _3873_/A gf180mcu_as_sc_mcu7t3v3__inv_2
XFILLER_152_429 VDD VDD VSS VSS gf180mcu_as_sc_mcu7t3v3__fillcap_8
XFILLER_192_587 VDD VDD VSS VSS gf180mcu_as_sc_mcu7t3v3__fillcap_4
XFILLER_69_1264 VDD VDD VSS VSS gf180mcu_as_sc_mcu7t3v3__fillcap_4
XFILLER_160_440 VDD VDD VSS VSS gf180mcu_as_sc_mcu7t3v3__fill_1
XTAP_TAPCELL_ROW_189_1836 VDD VSS gf180mcu_as_sc_mcu7t3v3__tap_2
XFILLER_182_37 VDD VDD VSS VSS gf180mcu_as_sc_mcu7t3v3__fillcap_16
XFILLER_8_1011 VDD VDD VSS VSS gf180mcu_as_sc_mcu7t3v3__fillcap_4
XFILLER_188_838 VDD VDD VSS VSS gf180mcu_as_sc_mcu7t3v3__fillcap_4
XTAP_TAPCELL_ROW_33_3_1944 VDD VSS gf180mcu_as_sc_mcu7t3v3__tap_2
XFILLER_155_212 VDD VDD VSS VSS gf180mcu_as_sc_mcu7t3v3__fillcap_16
Xwire632 VDD VDD VSS VSS wire632/A _4104_/C gf180mcu_as_sc_mcu7t3v3__clkbuff_12
XFILLER_7_756 VDD VDD VSS VSS gf180mcu_as_sc_mcu7t3v3__fill_1
XFILLER_157_1009 VDD VDD VSS VSS gf180mcu_as_sc_mcu7t3v3__fill_1
XFILLER_164_790 VDD VDD VSS VSS gf180mcu_as_sc_mcu7t3v3__fillcap_4
XFILLER_174_1301 VDD VDD VSS VSS gf180mcu_as_sc_mcu7t3v3__fill_2
XFILLER_170_1209 VDD VDD VSS VSS gf180mcu_as_sc_mcu7t3v3__fillcap_4
XFILLER_172_1080 VDD VDD VSS VSS gf180mcu_as_sc_mcu7t3v3__fillcap_4
XPHY_EDGE_ROW_61_1_Right_570 VDD VSS gf180mcu_as_sc_mcu7t3v3__tap_2
XFILLER_37_104 VDD VDD VSS VSS gf180mcu_as_sc_mcu7t3v3__fill_1
XFILLER_1_43 VDD VDD VSS VSS gf180mcu_as_sc_mcu7t3v3__fillcap_8
X_4900_ VDD VDD VSS VSS clkload5/A _4900_/D _4900_/Q gf180mcu_as_sc_mcu7t3v3__dfxtp_2
X_4831_ VDD VDD VSS VSS clkload6/A _4831_/D _4831_/Q gf180mcu_as_sc_mcu7t3v3__dfxtp_2
XTAP_TAPCELL_ROW_160_1287 VDD VSS gf180mcu_as_sc_mcu7t3v3__tap_2
X_4762_ VDD VDD VSS VSS _5275_/CLK _4762_/D _4762_/Q gf180mcu_as_sc_mcu7t3v3__dfxtp_2
XFILLER_159_573 VDD VDD VSS VSS gf180mcu_as_sc_mcu7t3v3__fill_1
XFILLER_186_381 VDD VDD VSS VSS gf180mcu_as_sc_mcu7t3v3__fillcap_4
XFILLER_187_882 VDD VDD VSS VSS gf180mcu_as_sc_mcu7t3v3__fill_1
X_4693_ VDD VDD VSS VSS _4707_/S _5251_/Q _4693_/A _5251_/D gf180mcu_as_sc_mcu7t3v3__mux2_2
X_3713_ VDD VDD VSS VSS _3714_/C _3713_/C _3783_/B _4089_/A gf180mcu_as_sc_mcu7t3v3__aoi21_2
X_3644_ VDD VDD VSS VSS _3644_/D _4016_/D _3728_/B _3728_/C _3645_/C gf180mcu_as_sc_mcu7t3v3__ao31_2
XFILLER_162_727 VDD VDD VSS VSS gf180mcu_as_sc_mcu7t3v3__fillcap_8
XFILLER_179_1278 VDD VDD VSS VSS gf180mcu_as_sc_mcu7t3v3__fillcap_4
X_4835__1098 VDD VDD VSS VSS _4835_/D gf180mcu_as_sc_mcu7t3v3__tiel_4
XTAP_TAPCELL_ROW_137_3_2048 VDD VSS gf180mcu_as_sc_mcu7t3v3__tap_2
X_3575_ VDD VDD VSS VSS _3942_/A _3649_/B _3649_/C _3941_/A _3576_/D gf180mcu_as_sc_mcu7t3v3__ao22_2
XTAP_TAPCELL_ROW_44_1_997 VDD VSS gf180mcu_as_sc_mcu7t3v3__tap_2
XPHY_EDGE_ROW_122_3_Right_163 VDD VSS gf180mcu_as_sc_mcu7t3v3__tap_2
X_2526_ VDD VDD VSS VSS _4657_/B _5230_/Q _2632_/B gf180mcu_as_sc_mcu7t3v3__nor2b_2
X_5245_ VDD VDD VSS VSS _5285_/CLK _5245_/D _5245_/Q gf180mcu_as_sc_mcu7t3v3__dfxtp_2
X_2457_ VDD VDD VSS VSS _3846_/B _4911_/Q _4912_/Q gf180mcu_as_sc_mcu7t3v3__nor2_2
XTAP_TAPCELL_ROW_167_1419 VDD VSS gf180mcu_as_sc_mcu7t3v3__tap_2
XPHY_EDGE_ROW_138_1_Right_647 VDD VSS gf180mcu_as_sc_mcu7t3v3__tap_2
X_5176_ VDD VDD VSS VSS _5182_/CLK _5176_/D _5176_/Q gf180mcu_as_sc_mcu7t3v3__dfxtp_2
XTAP_TAPCELL_ROW_4_759 VDD VSS gf180mcu_as_sc_mcu7t3v3__tap_2
XTAP_TAPCELL_ROW_184_1744 VDD VSS gf180mcu_as_sc_mcu7t3v3__tap_2
XTAP_TAPCELL_ROW_184_1733 VDD VSS gf180mcu_as_sc_mcu7t3v3__tap_2
X_4127_ VDD VDD VSS VSS _4127_/A _4154_/B _4127_/C _4132_/C _4127_/D gf180mcu_as_sc_mcu7t3v3__aoi211_2
XFILLER_186_1227 VDD VDD VSS VSS gf180mcu_as_sc_mcu7t3v3__fillcap_16
XFILLER_99_1279 VDD VDD VSS VSS gf180mcu_as_sc_mcu7t3v3__fillcap_8
X_4058_ VDD VDD VSS VSS _4106_/S _4058_/B _4058_/A _4059_/B gf180mcu_as_sc_mcu7t3v3__mux2_2
X_3009_ VDD VDD VSS VSS _3990_/A _3044_/B _3044_/C _3989_/D _3010_/C gf180mcu_as_sc_mcu7t3v3__ao22_2
XFILLER_101_88 VDD VDD VSS VSS gf180mcu_as_sc_mcu7t3v3__fillcap_16
XFILLER_165_554 VDD VDD VSS VSS gf180mcu_as_sc_mcu7t3v3__fillcap_4
XFILLER_153_738 VDD VDD VSS VSS gf180mcu_as_sc_mcu7t3v3__fillcap_16
XFILLER_3_214 VDD VDD VSS VSS gf180mcu_as_sc_mcu7t3v3__fill_1
XFILLER_4_737 VDD VDD VSS VSS gf180mcu_as_sc_mcu7t3v3__fill_2
XFILLER_10_85 VDD VDD VSS VSS gf180mcu_as_sc_mcu7t3v3__fillcap_8
XFILLER_126_96 VDD VDD VSS VSS gf180mcu_as_sc_mcu7t3v3__fillcap_8
XFILLER_82_1272 VDD VDD VSS VSS gf180mcu_as_sc_mcu7t3v3__fillcap_16
Xoutput390 VDD VDD VSS VSS _4778_/Q se_out[7] gf180mcu_as_sc_mcu7t3v3__buff_12
XPHY_EDGE_ROW_125_1_Left_317 VDD VSS gf180mcu_as_sc_mcu7t3v3__tap_2
XFILLER_43_1256 VDD VDD VSS VSS gf180mcu_as_sc_mcu7t3v3__fillcap_16
XFILLER_19_50 VDD VDD VSS VSS gf180mcu_as_sc_mcu7t3v3__fillcap_4
XFILLER_19_72 VDD VDD VSS VSS gf180mcu_as_sc_mcu7t3v3__fillcap_16
XFILLER_142_62 VDD VDD VSS VSS gf180mcu_as_sc_mcu7t3v3__fill_1
XFILLER_188_613 VDD VDD VSS VSS gf180mcu_as_sc_mcu7t3v3__fill_2
XFILLER_163_1068 VDD VDD VSS VSS gf180mcu_as_sc_mcu7t3v3__fillcap_16
XFILLER_184_874 VDD VDD VSS VSS gf180mcu_as_sc_mcu7t3v3__fill_1
XFILLER_184_885 VDD VDD VSS VSS gf180mcu_as_sc_mcu7t3v3__fillcap_4
Xwire462 VDD VDD VSS VSS _3699_/Y _4856_/D gf180mcu_as_sc_mcu7t3v3__clkbuff_12
Xwire484 VDD VDD VSS VSS _3049_/Y _4782_/D gf180mcu_as_sc_mcu7t3v3__clkbuff_12
X_3360_ VDD VDD VSS VSS _3639_/A _3463_/B _3360_/C _4814_/D _3638_/D gf180mcu_as_sc_mcu7t3v3__aoi211_2
XFILLER_111_101 VDD VDD VSS VSS gf180mcu_as_sc_mcu7t3v3__fillcap_4
XFILLER_139_1284 VDD VDD VSS VSS gf180mcu_as_sc_mcu7t3v3__fillcap_16
XPHY_EDGE_ROW_57_1_Left_249 VDD VSS gf180mcu_as_sc_mcu7t3v3__tap_2
XFILLER_170_1017 VDD VDD VSS VSS gf180mcu_as_sc_mcu7t3v3__fillcap_8
XFILLER_174_1197 VDD VDD VSS VSS gf180mcu_as_sc_mcu7t3v3__fill_1
X_5030_ VDD VDD VSS VSS _5175_/CLK _5030_/D _5030_/Q gf180mcu_as_sc_mcu7t3v3__dfxtp_2
X_3291_ VDD VDD VSS VSS _4916_/Q _3369_/B _3369_/C _3940_/A _3292_/D gf180mcu_as_sc_mcu7t3v3__ao22_2
XTAP_TAPCELL_ROW_1_707 VDD VSS gf180mcu_as_sc_mcu7t3v3__tap_2
XPHY_EDGE_ROW_62_1_Right_571 VDD VSS gf180mcu_as_sc_mcu7t3v3__tap_2
XPHY_EDGE_ROW_58_3_Left_430 VDD VSS gf180mcu_as_sc_mcu7t3v3__tap_2
XTAP_TAPCELL_ROW_1_718 VDD VSS gf180mcu_as_sc_mcu7t3v3__tap_2
XTAP_TAPCELL_ROW_162_1327 VDD VSS gf180mcu_as_sc_mcu7t3v3__tap_2
XTAP_TAPCELL_ROW_162_1316 VDD VSS gf180mcu_as_sc_mcu7t3v3__tap_2
XFILLER_4_1294 VDD VDD VSS VSS gf180mcu_as_sc_mcu7t3v3__fill_1
XPHY_EDGE_ROW_110_3_Left_482 VDD VSS gf180mcu_as_sc_mcu7t3v3__tap_2
XFILLER_166_307 VDD VDD VSS VSS gf180mcu_as_sc_mcu7t3v3__fill_1
XFILLER_167_808 VDD VDD VSS VSS gf180mcu_as_sc_mcu7t3v3__fillcap_16
X_4814_ VDD VDD VSS VSS clkload7/A _4814_/D _4814_/Q gf180mcu_as_sc_mcu7t3v3__dfxtp_2
X_4745_ VDD VDD VSS VSS _4747_/D _4745_/A _5275_/D gf180mcu_as_sc_mcu7t3v3__and2_2
XFILLER_175_874 VDD VDD VSS VSS gf180mcu_as_sc_mcu7t3v3__fillcap_16
XFILLER_190_800 VDD VDD VSS VSS gf180mcu_as_sc_mcu7t3v3__fillcap_4
XFILLER_190_811 VDD VDD VSS VSS gf180mcu_as_sc_mcu7t3v3__fill_1
X_4676_ VDD VDD VSS VSS _5245_/D _5115_/Q _4700_/S _4676_/C gf180mcu_as_sc_mcu7t3v3__ao21_2
XFILLER_174_384 VDD VDD VSS VSS gf180mcu_as_sc_mcu7t3v3__fill_1
X_3627_ VDD VDD VSS VSS _3997_/D _3781_/S _3627_/C _3627_/D _3628_/C gf180mcu_as_sc_mcu7t3v3__ao211_2
Xmax_cap762 VDD VDD VSS VSS _3178_/D fanout760/A gf180mcu_as_sc_mcu7t3v3__clkbuff_12
X_3558_ VDD VDD VSS VSS _3805_/B _3558_/B _3817_/C gf180mcu_as_sc_mcu7t3v3__nand2_2
XPHY_EDGE_ROW_123_3_Right_164 VDD VSS gf180mcu_as_sc_mcu7t3v3__tap_2
XFILLER_0_206 VDD VDD VSS VSS gf180mcu_as_sc_mcu7t3v3__fillcap_4
XFILLER_102_101 VDD VDD VSS VSS gf180mcu_as_sc_mcu7t3v3__fillcap_4
Xmax_cap795 VDD VDD VSS VSS _5481_/A _4696_/B gf180mcu_as_sc_mcu7t3v3__clkbuff_12
X_2509_ VDD VDD VSS VSS _5275_/Q _5269_/Q _5270_/Q _4739_/A _4749_/A gf180mcu_as_sc_mcu7t3v3__nand4_2
XFILLER_153_1259 VDD VDD VSS VSS gf180mcu_as_sc_mcu7t3v3__fill_1
Xinput107 VDD VDD VSS VSS ne_in[5] wire908/A gf180mcu_as_sc_mcu7t3v3__buff_12
Xinput118 VDD VDD VSS VSS north_in[15] wire903/A gf180mcu_as_sc_mcu7t3v3__buff_12
X_3489_ VDD VDD VSS VSS _4146_/D _3496_/B _3523_/B _4147_/A _3490_/D gf180mcu_as_sc_mcu7t3v3__ao22_2
X_5228_ VDD VDD VSS VSS _5280_/CLK _5228_/D _5228_/Q gf180mcu_as_sc_mcu7t3v3__dfxtp_2
Xinput129 VDD VDD VSS VSS north_in[25] _4137_/A gf180mcu_as_sc_mcu7t3v3__buff_12
XPHY_EDGE_ROW_139_1_Right_648 VDD VSS gf180mcu_as_sc_mcu7t3v3__tap_2
XFILLER_56_37 VDD VDD VSS VSS gf180mcu_as_sc_mcu7t3v3__fill_2
XFILLER_5_1047 VDD VDD VSS VSS gf180mcu_as_sc_mcu7t3v3__fill_2
X_5159_ VDD VDD VSS VSS _5164_/CLK _5159_/D _5159_/Q gf180mcu_as_sc_mcu7t3v3__dfxtp_2
XFILLER_179_6 VDD VDD VSS VSS gf180mcu_as_sc_mcu7t3v3__fillcap_16
XFILLER_186_1046 VDD VDD VSS VSS gf180mcu_as_sc_mcu7t3v3__fill_2
XFILLER_112_65 VDD VDD VSS VSS gf180mcu_as_sc_mcu7t3v3__fillcap_8
XFILLER_112_98 VDD VDD VSS VSS gf180mcu_as_sc_mcu7t3v3__fillcap_4
XFILLER_13_814 VDD VDD VSS VSS gf180mcu_as_sc_mcu7t3v3__fill_2
XFILLER_169_101 VDD VDD VSS VSS gf180mcu_as_sc_mcu7t3v3__fillcap_4
XFILLER_13_858 VDD VDD VSS VSS gf180mcu_as_sc_mcu7t3v3__fill_1
XFILLER_188_69 VDD VDD VSS VSS gf180mcu_as_sc_mcu7t3v3__fillcap_4
XFILLER_8_317 VDD VDD VSS VSS gf180mcu_as_sc_mcu7t3v3__fillcap_4
XFILLER_165_373 VDD VDD VSS VSS gf180mcu_as_sc_mcu7t3v3__fill_2
XFILLER_166_874 VDD VDD VSS VSS gf180mcu_as_sc_mcu7t3v3__fill_1
XFILLER_158_1115 VDD VDD VSS VSS gf180mcu_as_sc_mcu7t3v3__fill_2
XFILLER_180_365 VDD VDD VSS VSS gf180mcu_as_sc_mcu7t3v3__fillcap_8
XFILLER_10_1299 VDD VDD VSS VSS gf180mcu_as_sc_mcu7t3v3__fill_1
XFILLER_137_84 VDD VDD VSS VSS gf180mcu_as_sc_mcu7t3v3__fill_1
XFILLER_97_33 VDD VDD VSS VSS gf180mcu_as_sc_mcu7t3v3__fillcap_16
XFILLER_97_55 VDD VDD VSS VSS gf180mcu_as_sc_mcu7t3v3__fill_1
XTAP_TAPCELL_ROW_8_840 VDD VSS gf180mcu_as_sc_mcu7t3v3__tap_2
XFILLER_171_1348 VDD VDD VSS VSS gf180mcu_as_sc_mcu7t3v3__fillcap_4
XFILLER_97_88 VDD VDD VSS VSS gf180mcu_as_sc_mcu7t3v3__fillcap_16
XTAP_TAPCELL_ROW_8_851 VDD VSS gf180mcu_as_sc_mcu7t3v3__tap_2
XFILLER_153_72 VDD VDD VSS VSS gf180mcu_as_sc_mcu7t3v3__fillcap_8
XFILLER_165_1119 VDD VDD VSS VSS gf180mcu_as_sc_mcu7t3v3__fill_1
XTAP_TAPCELL_ROW_43_1_996 VDD VSS gf180mcu_as_sc_mcu7t3v3__tap_2
X_2860_ VDD VDD VSS VSS _2861_/B _4733_/B _2873_/C gf180mcu_as_sc_mcu7t3v3__and2_2
XFILLER_62_80 VDD VDD VSS VSS gf180mcu_as_sc_mcu7t3v3__fillcap_4
XFILLER_157_852 VDD VDD VSS VSS gf180mcu_as_sc_mcu7t3v3__fill_1
XFILLER_178_91 VDD VDD VSS VSS gf180mcu_as_sc_mcu7t3v3__fillcap_8
X_2791_ VDD VDD VSS VSS _4732_/C _4732_/B _2791_/A gf180mcu_as_sc_mcu7t3v3__nor2b_2
XFILLER_157_896 VDD VDD VSS VSS gf180mcu_as_sc_mcu7t3v3__fillcap_4
XFILLER_184_671 VDD VDD VSS VSS gf180mcu_as_sc_mcu7t3v3__fill_2
XFILLER_190_107 VDD VDD VSS VSS gf180mcu_as_sc_mcu7t3v3__fillcap_8
XFILLER_8_851 VDD VDD VSS VSS gf180mcu_as_sc_mcu7t3v3__fill_1
XFILLER_8_862 VDD VDD VSS VSS gf180mcu_as_sc_mcu7t3v3__fillcap_8
X_4530_ VDD VDD VSS VSS _4531_/D _4530_/B _4589_/A gf180mcu_as_sc_mcu7t3v3__nor2_2
XFILLER_156_384 VDD VDD VSS VSS gf180mcu_as_sc_mcu7t3v3__fill_1
XFILLER_156_395 VDD VDD VSS VSS gf180mcu_as_sc_mcu7t3v3__fill_2
XFILLER_89_1256 VDD VDD VSS VSS gf180mcu_as_sc_mcu7t3v3__fillcap_4
X_4461_ VDD VDD VSS VSS _4465_/B _5074_/Q _4579_/S gf180mcu_as_sc_mcu7t3v3__nand2_2
XTAP_TAPCELL_ROW_155_1197 VDD VSS gf180mcu_as_sc_mcu7t3v3__tap_2
XTAP_TAPCELL_ROW_155_1186 VDD VSS gf180mcu_as_sc_mcu7t3v3__tap_2
XFILLER_172_888 VDD VDD VSS VSS gf180mcu_as_sc_mcu7t3v3__fillcap_4
X_3412_ VDD VDD VSS VSS _4065_/A _3451_/B _3412_/C _3412_/D _3413_/A gf180mcu_as_sc_mcu7t3v3__ao22_2
X_4392_ VDD VDD VSS VSS _4536_/S _5008_/Q _5037_/Q _4393_/B gf180mcu_as_sc_mcu7t3v3__mux2_2
Xfanout808 VDD VDD VSS VSS _5225_/Q _4684_/A gf180mcu_as_sc_mcu7t3v3__buff_12
Xfanout819 VDD VDD VSS VSS _5095_/Q _4561_/A gf180mcu_as_sc_mcu7t3v3__buff_12
X_3343_ VDD VDD VSS VSS _3505_/S _3343_/B _3994_/A _3344_/B gf180mcu_as_sc_mcu7t3v3__mux2_2
XFILLER_6_1301 VDD VDD VSS VSS gf180mcu_as_sc_mcu7t3v3__fill_1
X_3274_ VDD VDD VSS VSS _3925_/D _3500_/B _3274_/C _3274_/D _3279_/A gf180mcu_as_sc_mcu7t3v3__ao211_2
XFILLER_152_1270 VDD VDD VSS VSS gf180mcu_as_sc_mcu7t3v3__fillcap_8
X_5013_ VDD VDD VSS VSS clkload9/A _5013_/D _5013_/Q gf180mcu_as_sc_mcu7t3v3__dfxtp_2
XPHY_EDGE_ROW_63_1_Right_572 VDD VSS gf180mcu_as_sc_mcu7t3v3__tap_2
XFILLER_183_1208 VDD VDD VSS VSS gf180mcu_as_sc_mcu7t3v3__fillcap_8
XPHY_EDGE_ROW_5_Right_5 VDD VSS gf180mcu_as_sc_mcu7t3v3__tap_2
XFILLER_185_1090 VDD VDD VSS VSS gf180mcu_as_sc_mcu7t3v3__fill_2
XTAP_TAPCELL_ROW_179_1654 VDD VSS gf180mcu_as_sc_mcu7t3v3__tap_2
XTAP_TAPCELL_ROW_179_1643 VDD VSS gf180mcu_as_sc_mcu7t3v3__tap_2
XFILLER_10_817 VDD VDD VSS VSS gf180mcu_as_sc_mcu7t3v3__fillcap_8
Xclkbuf_leaf_13_clk_regs VDD VDD VSS VSS clkbuf_3_3__f_clk_regs/Y _5089_/CLK gf180mcu_as_sc_mcu7t3v3__clkbuff_12
X_2989_ VDD VDD VSS VSS _3699_/D _3097_/A _2989_/B _2989_/C _2990_/C gf180mcu_as_sc_mcu7t3v3__ao31_2
X_4728_ VDD VDD VSS VSS _5110_/Q _4728_/B _4730_/B _5266_/Q _4729_/C gf180mcu_as_sc_mcu7t3v3__ao22_2
X_4659_ VDD VDD VSS VSS _4660_/C _4659_/B _4659_/A gf180mcu_as_sc_mcu7t3v3__nor2_2
XTAP_TAPCELL_ROW_192_1898 VDD VSS gf180mcu_as_sc_mcu7t3v3__tap_2
XTAP_TAPCELL_ROW_192_1887 VDD VSS gf180mcu_as_sc_mcu7t3v3__tap_2
XFILLER_190_641 VDD VDD VSS VSS gf180mcu_as_sc_mcu7t3v3__fillcap_16
XFILLER_162_387 VDD VDD VSS VSS gf180mcu_as_sc_mcu7t3v3__fillcap_16
XFILLER_190_696 VDD VDD VSS VSS gf180mcu_as_sc_mcu7t3v3__fill_1
Xmax_cap581 VDD VDD VSS VSS _3132_/B _3041_/B gf180mcu_as_sc_mcu7t3v3__clkbuff_12
XPHY_EDGE_ROW_124_3_Right_165 VDD VSS gf180mcu_as_sc_mcu7t3v3__tap_2
XFILLER_153_1078 VDD VDD VSS VSS gf180mcu_as_sc_mcu7t3v3__fill_1
XFILLER_190_37 VDD VDD VSS VSS gf180mcu_as_sc_mcu7t3v3__fillcap_16
XFILLER_129_1272 VDD VDD VSS VSS gf180mcu_as_sc_mcu7t3v3__fillcap_16
XFILLER_164_1152 VDD VDD VSS VSS gf180mcu_as_sc_mcu7t3v3__fill_2
XFILLER_186_925 VDD VDD VSS VSS gf180mcu_as_sc_mcu7t3v3__fill_2
XFILLER_9_626 VDD VDD VSS VSS gf180mcu_as_sc_mcu7t3v3__fillcap_4
XFILLER_157_137 VDD VDD VSS VSS gf180mcu_as_sc_mcu7t3v3__fill_2
XFILLER_185_446 VDD VDD VSS VSS gf180mcu_as_sc_mcu7t3v3__fillcap_4
XFILLER_154_800 VDD VDD VSS VSS gf180mcu_as_sc_mcu7t3v3__fillcap_4
XFILLER_154_811 VDD VDD VSS VSS gf180mcu_as_sc_mcu7t3v3__fill_1
XFILLER_172_107 VDD VDD VSS VSS gf180mcu_as_sc_mcu7t3v3__fill_2
XFILLER_185_479 VDD VDD VSS VSS gf180mcu_as_sc_mcu7t3v3__fillcap_8
XFILLER_153_321 VDD VDD VSS VSS gf180mcu_as_sc_mcu7t3v3__fillcap_4
XFILLER_5_832 VDD VDD VSS VSS gf180mcu_as_sc_mcu7t3v3__fillcap_8
XFILLER_4_331 VDD VDD VSS VSS gf180mcu_as_sc_mcu7t3v3__fill_2
XFILLER_181_696 VDD VDD VSS VSS gf180mcu_as_sc_mcu7t3v3__fillcap_4
XTAP_TAPCELL_ROW_75_1_1028 VDD VSS gf180mcu_as_sc_mcu7t3v3__tap_2
XFILLER_171_1112 VDD VDD VSS VSS gf180mcu_as_sc_mcu7t3v3__fillcap_8
XFILLER_175_1281 VDD VDD VSS VSS gf180mcu_as_sc_mcu7t3v3__fill_2
XFILLER_180_184 VDD VDD VSS VSS gf180mcu_as_sc_mcu7t3v3__fillcap_16
XFILLER_171_1134 VDD VDD VSS VSS gf180mcu_as_sc_mcu7t3v3__fillcap_16
XFILLER_169_1052 VDD VDD VSS VSS gf180mcu_as_sc_mcu7t3v3__fillcap_16
X_3961_ VDD VDD VSS VSS _3962_/D _3961_/C _4025_/B _3961_/A gf180mcu_as_sc_mcu7t3v3__aoi21_2
X_2912_ VDD VDD VSS VSS _3255_/C _3788_/D _3796_/D gf180mcu_as_sc_mcu7t3v3__nor2_2
XFILLER_148_104 VDD VDD VSS VSS gf180mcu_as_sc_mcu7t3v3__fill_1
XFILLER_177_936 VDD VDD VSS VSS gf180mcu_as_sc_mcu7t3v3__fill_1
XFILLER_188_251 VDD VDD VSS VSS gf180mcu_as_sc_mcu7t3v3__fill_2
X_3892_ VDD VDD VSS VSS _3895_/B _5182_/Q _4932_/D gf180mcu_as_sc_mcu7t3v3__and2_2
XFILLER_176_457 VDD VDD VSS VSS gf180mcu_as_sc_mcu7t3v3__fill_2
X_2843_ VDD VDD VSS VSS _4290_/B _5226_/Q _4746_/B gf180mcu_as_sc_mcu7t3v3__xnor2_2
XTAP_TAPCELL_ROW_157_1237 VDD VSS gf180mcu_as_sc_mcu7t3v3__tap_2
XTAP_TAPCELL_ROW_157_1226 VDD VSS gf180mcu_as_sc_mcu7t3v3__tap_2
X_2774_ VDD VDD VSS VSS _4259_/B _4719_/A _4649_/B gf180mcu_as_sc_mcu7t3v3__and2_2
XTAP_TAPCELL_ROW_174_1551 VDD VSS gf180mcu_as_sc_mcu7t3v3__tap_2
XFILLER_163_129 VDD VDD VSS VSS gf180mcu_as_sc_mcu7t3v3__fill_2
XFILLER_176_1001 VDD VDD VSS VSS gf180mcu_as_sc_mcu7t3v3__fillcap_8
XFILLER_191_438 VDD VDD VSS VSS gf180mcu_as_sc_mcu7t3v3__fillcap_16
XFILLER_8_681 VDD VDD VSS VSS gf180mcu_as_sc_mcu7t3v3__fillcap_8
X_4513_ VDD VDD VSS VSS _5179_/Q _4574_/B _4513_/C _4513_/D _5179_/D gf180mcu_as_sc_mcu7t3v3__ao211_2
XFILLER_172_652 VDD VDD VSS VSS gf180mcu_as_sc_mcu7t3v3__fill_2
XFILLER_7_180 VDD VDD VSS VSS gf180mcu_as_sc_mcu7t3v3__fill_1
X_4444_ VDD VDD VSS VSS _4444_/B _4591_/A _4451_/C gf180mcu_as_sc_mcu7t3v3__and2_2
XFILLER_171_184 VDD VDD VSS VSS gf180mcu_as_sc_mcu7t3v3__fillcap_8
Xfanout605 VDD VDD VSS VSS fanout605/A _3673_/C gf180mcu_as_sc_mcu7t3v3__buff_12
X_4375_ VDD VDD VSS VSS _5164_/Q _4375_/B _4563_/C _4706_/A _4376_/B gf180mcu_as_sc_mcu7t3v3__ao22_2
Xfanout616 VDD VDD VSS VSS _4375_/B _4514_/B gf180mcu_as_sc_mcu7t3v3__buff_12
Xfanout627 VDD VDD VSS VSS fanout628/A _4161_/B gf180mcu_as_sc_mcu7t3v3__buff_12
Xfanout638 VDD VDD VSS VSS wire640/Y _3779_/B gf180mcu_as_sc_mcu7t3v3__buff_12
Xfanout649 VDD VDD VSS VSS _3389_/S _3373_/S gf180mcu_as_sc_mcu7t3v3__buff_12
X_3326_ VDD VDD VSS VSS _3424_/B _3326_/B _3326_/C _3327_/C gf180mcu_as_sc_mcu7t3v3__nor3_2
X_3257_ VDD VDD VSS VSS _3271_/B _3812_/A _3257_/A gf180mcu_as_sc_mcu7t3v3__nand2_2
X_3188_ VDD VDD VSS VSS _3235_/B _3188_/B _4159_/A _3191_/D gf180mcu_as_sc_mcu7t3v3__mux2_2
XPHY_EDGE_ROW_64_1_Right_573 VDD VSS gf180mcu_as_sc_mcu7t3v3__tap_2
XFILLER_139_104 VDD VDD VSS VSS gf180mcu_as_sc_mcu7t3v3__fill_1
XFILLER_168_936 VDD VDD VSS VSS gf180mcu_as_sc_mcu7t3v3__fill_2
XFILLER_168_947 VDD VDD VSS VSS gf180mcu_as_sc_mcu7t3v3__fillcap_16
XFILLER_169_38 VDD VDD VSS VSS gf180mcu_as_sc_mcu7t3v3__fillcap_16
XFILLER_168_969 VDD VDD VSS VSS gf180mcu_as_sc_mcu7t3v3__fill_1
XFILLER_182_405 VDD VDD VSS VSS gf180mcu_as_sc_mcu7t3v3__fillcap_4
XPHY_EDGE_ROW_134_1_Left_326 VDD VSS gf180mcu_as_sc_mcu7t3v3__tap_2
XFILLER_159_1243 VDD VDD VSS VSS gf180mcu_as_sc_mcu7t3v3__fillcap_4
XFILLER_159_1276 VDD VDD VSS VSS gf180mcu_as_sc_mcu7t3v3__fill_2
XFILLER_2_802 VDD VDD VSS VSS gf180mcu_as_sc_mcu7t3v3__fill_2
XFILLER_2_835 VDD VDD VSS VSS gf180mcu_as_sc_mcu7t3v3__fillcap_8
XTAP_TAPCELL_ROW_42_1_995 VDD VSS gf180mcu_as_sc_mcu7t3v3__tap_2
XFILLER_81_1326 VDD VDD VSS VSS gf180mcu_as_sc_mcu7t3v3__fillcap_4
XPHY_EDGE_ROW_125_3_Right_166 VDD VSS gf180mcu_as_sc_mcu7t3v3__tap_2
XFILLER_94_34 VDD VDD VSS VSS gf180mcu_as_sc_mcu7t3v3__fill_1
Xmesh_tile_1026 VDD VDD VSS VSS nw_out[32] gf180mcu_as_sc_mcu7t3v3__tiel_4
Xmesh_tile_1015 VDD VDD VSS VSS nw_out[21] gf180mcu_as_sc_mcu7t3v3__tiel_4
Xmesh_tile_1004 VDD VDD VSS VSS nw_out[10] gf180mcu_as_sc_mcu7t3v3__tiel_4
XTAP_TAPCELL_ROW_136_1_1089 VDD VSS gf180mcu_as_sc_mcu7t3v3__tap_2
Xmesh_tile_1059 VDD VDD VSS VSS sw_out[31] gf180mcu_as_sc_mcu7t3v3__tiel_4
Xmesh_tile_1048 VDD VDD VSS VSS sw_out[20] gf180mcu_as_sc_mcu7t3v3__tiel_4
Xmesh_tile_1037 VDD VDD VSS VSS sw_out[9] gf180mcu_as_sc_mcu7t3v3__tiel_4
XFILLER_27_83 VDD VDD VSS VSS gf180mcu_as_sc_mcu7t3v3__fill_2
XFILLER_79_1299 VDD VDD VSS VSS gf180mcu_as_sc_mcu7t3v3__fill_2
XFILLER_13_430 VDD VDD VSS VSS gf180mcu_as_sc_mcu7t3v3__fill_1
XTAP_TAPCELL_ROW_94_3_2005 VDD VSS gf180mcu_as_sc_mcu7t3v3__tap_2
XFILLER_158_435 VDD VDD VSS VSS gf180mcu_as_sc_mcu7t3v3__fill_2
XFILLER_159_969 VDD VDD VSS VSS gf180mcu_as_sc_mcu7t3v3__fill_2
XPHY_EDGE_ROW_66_1_Left_258 VDD VSS gf180mcu_as_sc_mcu7t3v3__tap_2
XFILLER_159_82 VDD VDD VSS VSS gf180mcu_as_sc_mcu7t3v3__fill_1
XFILLER_185_243 VDD VDD VSS VSS gf180mcu_as_sc_mcu7t3v3__fillcap_4
XFILLER_142_1280 VDD VDD VSS VSS gf180mcu_as_sc_mcu7t3v3__fillcap_8
XFILLER_16_1283 VDD VDD VSS VSS gf180mcu_as_sc_mcu7t3v3__fillcap_4
XFILLER_173_449 VDD VDD VSS VSS gf180mcu_as_sc_mcu7t3v3__fill_1
XFILLER_185_298 VDD VDD VSS VSS gf180mcu_as_sc_mcu7t3v3__fillcap_16
XFILLER_154_663 VDD VDD VSS VSS gf180mcu_as_sc_mcu7t3v3__fill_2
XFILLER_177_1332 VDD VDD VSS VSS gf180mcu_as_sc_mcu7t3v3__fillcap_16
XTAP_TAPCELL_ROW_152_1134 VDD VSS gf180mcu_as_sc_mcu7t3v3__tap_2
XTAP_TAPCELL_ROW_152_1123 VDD VSS gf180mcu_as_sc_mcu7t3v3__tap_2
XTAP_TAPCELL_ROW_152_1112 VDD VSS gf180mcu_as_sc_mcu7t3v3__tap_2
XFILLER_103_1297 VDD VDD VSS VSS gf180mcu_as_sc_mcu7t3v3__fill_2
XFILLER_138_1327 VDD VDD VSS VSS gf180mcu_as_sc_mcu7t3v3__fill_2
XFILLER_153_162 VDD VDD VSS VSS gf180mcu_as_sc_mcu7t3v3__fillcap_4
XFILLER_154_674 VDD VDD VSS VSS gf180mcu_as_sc_mcu7t3v3__fill_2
XFILLER_177_1354 VDD VDD VSS VSS gf180mcu_as_sc_mcu7t3v3__fill_1
X_2490_ VDD VDD VSS VSS _4371_/A _4739_/A _5270_/Q gf180mcu_as_sc_mcu7t3v3__nor2_2
X_4160_ VDD VDD VSS VSS _4160_/A _4160_/B _4160_/C _4160_/D _4161_/D gf180mcu_as_sc_mcu7t3v3__ao22_2
X_3111_ VDD VDD VSS VSS _4087_/A _3222_/D _3236_/C _4088_/D _3112_/C gf180mcu_as_sc_mcu7t3v3__ao22_2
XFILLER_62_1281 VDD VDD VSS VSS gf180mcu_as_sc_mcu7t3v3__fillcap_8
X_4091_ VDD VDD VSS VSS _4091_/A _4127_/C _4091_/C _4248_/B _4141_/D gf180mcu_as_sc_mcu7t3v3__aoi211_2
Xinput290 VDD VDD VSS VSS west_in[16] _4065_/A gf180mcu_as_sc_mcu7t3v3__buff_12
X_3042_ VDD VDD VSS VSS _4022_/A _3042_/B _3042_/C _4021_/A _3048_/B gf180mcu_as_sc_mcu7t3v3__ao22_2
XFILLER_23_1298 VDD VDD VSS VSS gf180mcu_as_sc_mcu7t3v3__fill_1
XFILLER_145_1309 VDD VDD VSS VSS gf180mcu_as_sc_mcu7t3v3__fillcap_4
X_4993_ VDD VDD VSS VSS _5086_/CLK _4993_/D _4993_/Q gf180mcu_as_sc_mcu7t3v3__dfxtp_2
XTAP_TAPCELL_ROW_51_3_1962 VDD VSS gf180mcu_as_sc_mcu7t3v3__tap_2
X_3944_ VDD VDD VSS VSS _3944_/A _4027_/B _3944_/C _3944_/D _3945_/B gf180mcu_as_sc_mcu7t3v3__ao22_2
XFILLER_177_733 VDD VDD VSS VSS gf180mcu_as_sc_mcu7t3v3__fill_2
XFILLER_182_1082 VDD VDD VSS VSS gf180mcu_as_sc_mcu7t3v3__fill_2
X_3875_ VDD VDD VSS VSS _4946_/D _5165_/Q _4915_/D gf180mcu_as_sc_mcu7t3v3__and2_2
XFILLER_177_788 VDD VDD VSS VSS gf180mcu_as_sc_mcu7t3v3__fillcap_16
X_2826_ VDD VDD VSS VSS _4751_/A _2826_/B _5281_/Q _5280_/D gf180mcu_as_sc_mcu7t3v3__mux2_2
XFILLER_158_980 VDD VDD VSS VSS gf180mcu_as_sc_mcu7t3v3__fillcap_4
XFILLER_178_1107 VDD VDD VSS VSS gf180mcu_as_sc_mcu7t3v3__fillcap_4
XFILLER_192_747 VDD VDD VSS VSS gf180mcu_as_sc_mcu7t3v3__fill_1
XFILLER_180_909 VDD VDD VSS VSS gf180mcu_as_sc_mcu7t3v3__fillcap_4
X_2757_ VDD VDD VSS VSS _4377_/A _2765_/C _2765_/B _4691_/A gf180mcu_as_sc_mcu7t3v3__aoi21_2
XFILLER_155_18 VDD VDD VSS VSS gf180mcu_as_sc_mcu7t3v3__fillcap_16
X_2688_ VDD VDD VSS VSS _2732_/S _4958_/Q _4967_/Q _2691_/B gf180mcu_as_sc_mcu7t3v3__mux2_2
X_4427_ VDD VDD VSS VSS _4431_/B _5070_/Q _4557_/A gf180mcu_as_sc_mcu7t3v3__nand2_2
XFILLER_48_27 VDD VDD VSS VSS gf180mcu_as_sc_mcu7t3v3__fill_1
X_4358_ VDD VDD VSS VSS _4379_/B _4358_/B _5159_/Q _5159_/D gf180mcu_as_sc_mcu7t3v3__mux2_2
Xfanout479 VDD VDD VSS VSS _3913_/Y fanout479/Y gf180mcu_as_sc_mcu7t3v3__buff_12
X_4289_ VDD VDD VSS VSS _4289_/S _5485_/A _5123_/Q _5123_/D gf180mcu_as_sc_mcu7t3v3__mux2_2
X_3309_ VDD VDD VSS VSS _3957_/A _3374_/B _3374_/C _3961_/A _3310_/C gf180mcu_as_sc_mcu7t3v3__ao22_2
XTAP_TAPCELL_ROW_187_1797 VDD VSS gf180mcu_as_sc_mcu7t3v3__tap_2
XFILLER_189_1269 VDD VDD VSS VSS gf180mcu_as_sc_mcu7t3v3__fillcap_8
XPHY_EDGE_ROW_65_1_Right_574 VDD VSS gf180mcu_as_sc_mcu7t3v3__tap_2
XFILLER_168_700 VDD VDD VSS VSS gf180mcu_as_sc_mcu7t3v3__fillcap_16
XFILLER_11_912 VDD VDD VSS VSS gf180mcu_as_sc_mcu7t3v3__fill_1
XFILLER_161_1122 VDD VDD VSS VSS gf180mcu_as_sc_mcu7t3v3__fillcap_4
XTAP_TAPCELL_ROW_13_929 VDD VSS gf180mcu_as_sc_mcu7t3v3__tap_2
XFILLER_168_777 VDD VDD VSS VSS gf180mcu_as_sc_mcu7t3v3__fillcap_4
XFILLER_168_799 VDD VDD VSS VSS gf180mcu_as_sc_mcu7t3v3__fillcap_4
XFILLER_7_949 VDD VDD VSS VSS gf180mcu_as_sc_mcu7t3v3__fill_1
Xwire858 VDD VDD VSS VSS wire858/A _3789_/A gf180mcu_as_sc_mcu7t3v3__clkbuff_12
XFILLER_13_96 VDD VDD VSS VSS gf180mcu_as_sc_mcu7t3v3__fillcap_4
XFILLER_164_961 VDD VDD VSS VSS gf180mcu_as_sc_mcu7t3v3__fill_2
XFILLER_171_909 VDD VDD VSS VSS gf180mcu_as_sc_mcu7t3v3__fill_1
XFILLER_183_769 VDD VDD VSS VSS gf180mcu_as_sc_mcu7t3v3__fill_1
XFILLER_89_67 VDD VDD VSS VSS gf180mcu_as_sc_mcu7t3v3__fill_2
XFILLER_11_1180 VDD VDD VSS VSS gf180mcu_as_sc_mcu7t3v3__fill_1
XFILLER_1_142 VDD VDD VSS VSS gf180mcu_as_sc_mcu7t3v3__fill_1
XPHY_EDGE_ROW_126_3_Right_167 VDD VSS gf180mcu_as_sc_mcu7t3v3__tap_2
XFILLER_105_1326 VDD VDD VSS VSS gf180mcu_as_sc_mcu7t3v3__fill_2
XFILLER_9_220 VDD VDD VSS VSS gf180mcu_as_sc_mcu7t3v3__fillcap_4
XFILLER_159_799 VDD VDD VSS VSS gf180mcu_as_sc_mcu7t3v3__fillcap_16
XFILLER_9_253 VDD VDD VSS VSS gf180mcu_as_sc_mcu7t3v3__fillcap_16
X_3660_ VDD VDD VSS VSS _3661_/C _3660_/C _3729_/B _4033_/A gf180mcu_as_sc_mcu7t3v3__aoi21_2
XFILLER_162_909 VDD VDD VSS VSS gf180mcu_as_sc_mcu7t3v3__fillcap_4
Xclkload12 VDD VDD VSS VSS clkload12/Y _5089_/CLK gf180mcu_as_sc_mcu7t3v3__inv_4
Xclkload23 VDD VDD VSS VSS clkload23/Y _5181_/CLK gf180mcu_as_sc_mcu7t3v3__inv_4
X_3591_ VDD VDD VSS VSS _3957_/A _3652_/B _3673_/C _3956_/A _3592_/D gf180mcu_as_sc_mcu7t3v3__ao22_2
X_2611_ VDD VDD VSS VSS _2776_/A _2771_/A _4708_/A gf180mcu_as_sc_mcu7t3v3__nor2_2
XFILLER_173_279 VDD VDD VSS VSS gf180mcu_as_sc_mcu7t3v3__fill_1
X_2542_ VDD VDD VSS VSS _4327_/C _4328_/A gf180mcu_as_sc_mcu7t3v3__inv_2
XFILLER_5_492 VDD VDD VSS VSS gf180mcu_as_sc_mcu7t3v3__fillcap_4
XFILLER_6_993 VDD VDD VSS VSS gf180mcu_as_sc_mcu7t3v3__fill_2
X_5261_ VDD VDD VSS VSS _5265_/CLK _5261_/D _5261_/Q gf180mcu_as_sc_mcu7t3v3__dfxtp_2
X_4212_ VDD VDD VSS VSS _4241_/B _4227_/B _4227_/C _5048_/Q _5048_/D gf180mcu_as_sc_mcu7t3v3__ao22_2
X_2473_ VDD VDD VSS VSS _2474_/C _4362_/B _4369_/B gf180mcu_as_sc_mcu7t3v3__nand2_2
XFILLER_151_1313 VDD VDD VSS VSS gf180mcu_as_sc_mcu7t3v3__fill_1
X_5192_ VDD VDD VSS VSS _5216_/CLK _5192_/D _5192_/Q gf180mcu_as_sc_mcu7t3v3__dfxtp_2
XTAP_TAPCELL_ROW_169_1450 VDD VSS gf180mcu_as_sc_mcu7t3v3__tap_2
X_4143_ VDD VDD VSS VSS _4143_/A _4151_/B _4151_/C _4143_/D _4145_/C gf180mcu_as_sc_mcu7t3v3__ao22_2
XTAP_TAPCELL_ROW_169_1461 VDD VSS gf180mcu_as_sc_mcu7t3v3__tap_2
X_4074_ VDD VDD VSS VSS _4075_/C _4074_/B _4074_/A gf180mcu_as_sc_mcu7t3v3__nor2_2
X_3025_ VDD VDD VSS VSS _3043_/S _4006_/A _4006_/D _3027_/B gf180mcu_as_sc_mcu7t3v3__mux2_2
XFILLER_188_1291 VDD VDD VSS VSS gf180mcu_as_sc_mcu7t3v3__fillcap_4
XTAP_TAPCELL_ROW_41_1_994 VDD VSS gf180mcu_as_sc_mcu7t3v3__tap_2
X_4976_ VDD VDD VSS VSS _5181_/CLK _4976_/D _4976_/Q gf180mcu_as_sc_mcu7t3v3__dfxtp_2
Xsram2048.u_bank0_918 VDD VDD VSS VSS sram2048.u_bank0/WEN[7] gf180mcu_as_sc_mcu7t3v3__tiel_4
X_3927_ VDD VDD VSS VSS _3927_/Y _3927_/B _3927_/A gf180mcu_as_sc_mcu7t3v3__nor2_2
XFILLER_165_747 VDD VDD VSS VSS gf180mcu_as_sc_mcu7t3v3__fillcap_8
Xclkload6 VDD VDD VSS VSS clkload6/Y clkload6/A gf180mcu_as_sc_mcu7t3v3__inv_6
X_3858_ VDD VDD VSS VSS _3858_/A _3858_/B _3858_/C _3858_/D _3873_/A gf180mcu_as_sc_mcu7t3v3__nand4_2
XFILLER_153_909 VDD VDD VSS VSS gf180mcu_as_sc_mcu7t3v3__fill_1
XFILLER_165_769 VDD VDD VSS VSS gf180mcu_as_sc_mcu7t3v3__fill_1
X_3789_ VDD VDD VSS VSS _3789_/D _3789_/A _3812_/B _3797_/C _3790_/D gf180mcu_as_sc_mcu7t3v3__ao31_2
X_2809_ VDD VDD VSS VSS _2809_/B _4708_/C _2811_/C gf180mcu_as_sc_mcu7t3v3__and2_2
XFILLER_180_739 VDD VDD VSS VSS gf180mcu_as_sc_mcu7t3v3__fill_1
XFILLER_192_577 VDD VDD VSS VSS gf180mcu_as_sc_mcu7t3v3__fill_1
XFILLER_156_1224 VDD VDD VSS VSS gf180mcu_as_sc_mcu7t3v3__fill_1
XFILLER_160_452 VDD VDD VSS VSS gf180mcu_as_sc_mcu7t3v3__fill_2
XTAP_TAPCELL_ROW_189_1837 VDD VSS gf180mcu_as_sc_mcu7t3v3__tap_2
XFILLER_160_485 VDD VDD VSS VSS gf180mcu_as_sc_mcu7t3v3__fillcap_16
XFILLER_115_65 VDD VDD VSS VSS gf180mcu_as_sc_mcu7t3v3__fillcap_4
XFILLER_167_1353 VDD VDD VSS VSS gf180mcu_as_sc_mcu7t3v3__fill_2
XFILLER_152_2 VDD VDD VSS VSS gf180mcu_as_sc_mcu7t3v3__fillcap_8
XFILLER_76_1258 VDD VDD VSS VSS gf180mcu_as_sc_mcu7t3v3__fill_1
XPHY_EDGE_ROW_66_1_Right_575 VDD VSS gf180mcu_as_sc_mcu7t3v3__tap_2
XFILLER_187_349 VDD VDD VSS VSS gf180mcu_as_sc_mcu7t3v3__fill_1
XFILLER_11_742 VDD VDD VSS VSS gf180mcu_as_sc_mcu7t3v3__fillcap_16
XFILLER_183_500 VDD VDD VSS VSS gf180mcu_as_sc_mcu7t3v3__fill_2
XFILLER_7_702 VDD VDD VSS VSS gf180mcu_as_sc_mcu7t3v3__fillcap_16
XFILLER_183_566 VDD VDD VSS VSS gf180mcu_as_sc_mcu7t3v3__fill_2
XFILLER_7_768 VDD VDD VSS VSS gf180mcu_as_sc_mcu7t3v3__fill_2
XFILLER_152_920 VDD VDD VSS VSS gf180mcu_as_sc_mcu7t3v3__fillcap_16
XFILLER_155_268 VDD VDD VSS VSS gf180mcu_as_sc_mcu7t3v3__fill_1
XFILLER_100_1256 VDD VDD VSS VSS gf180mcu_as_sc_mcu7t3v3__fillcap_8
XTAP_TAPCELL_ROW_89_3_2000 VDD VSS gf180mcu_as_sc_mcu7t3v3__tap_2
XTAP_TAPCELL_ROW_103_3_2014 VDD VSS gf180mcu_as_sc_mcu7t3v3__tap_2
XFILLER_172_71 VDD VDD VSS VSS gf180mcu_as_sc_mcu7t3v3__fill_1
XPHY_EDGE_ROW_127_3_Right_168 VDD VSS gf180mcu_as_sc_mcu7t3v3__tap_2
X_4830_ VDD VDD VSS VSS clkload6/A _4830_/D _4830_/Q gf180mcu_as_sc_mcu7t3v3__dfxtp_2
XTAP_TAPCELL_ROW_160_1288 VDD VSS gf180mcu_as_sc_mcu7t3v3__tap_2
XTAP_TAPCELL_ROW_160_1277 VDD VSS gf180mcu_as_sc_mcu7t3v3__tap_2
XFILLER_178_349 VDD VDD VSS VSS gf180mcu_as_sc_mcu7t3v3__fill_2
X_4761_ VDD VDD VSS VSS _5188_/CLK _4761_/D _4761_/Q gf180mcu_as_sc_mcu7t3v3__dfxtp_2
X_4692_ VDD VDD VSS VSS _4731_/B _4692_/B _5252_/Q _4693_/A gf180mcu_as_sc_mcu7t3v3__mux2_2
X_3712_ VDD VDD VSS VSS _3712_/D _4085_/A _3736_/B _3800_/C _3713_/C gf180mcu_as_sc_mcu7t3v3__ao31_2
X_3643_ VDD VDD VSS VSS _4925_/Q _3727_/B _3727_/C _4013_/D _3644_/D gf180mcu_as_sc_mcu7t3v3__ao22_2
XFILLER_179_1257 VDD VDD VSS VSS gf180mcu_as_sc_mcu7t3v3__fill_2
XFILLER_155_791 VDD VDD VSS VSS gf180mcu_as_sc_mcu7t3v3__fillcap_4
X_3574_ VDD VDD VSS VSS _4916_/Q _3648_/B _3648_/C _3940_/A _3576_/C gf180mcu_as_sc_mcu7t3v3__ao22_2
X_2525_ VDD VDD VSS VSS _2771_/A _2525_/A _2632_/B gf180mcu_as_sc_mcu7t3v3__and2_2
XFILLER_9_1332 VDD VDD VSS VSS gf180mcu_as_sc_mcu7t3v3__fillcap_16
X_5244_ VDD VDD VSS VSS _5280_/CLK _5244_/D _5244_/Q gf180mcu_as_sc_mcu7t3v3__dfxtp_2
X_2456_ VDD VDD VSS VSS _4353_/A _2456_/C _2456_/B _4588_/A gf180mcu_as_sc_mcu7t3v3__aoi21_2
XPHY_EDGE_ROW_89_3_Right_130 VDD VSS gf180mcu_as_sc_mcu7t3v3__tap_2
XFILLER_190_1181 VDD VDD VSS VSS gf180mcu_as_sc_mcu7t3v3__fillcap_4
XFILLER_9_1354 VDD VDD VSS VSS gf180mcu_as_sc_mcu7t3v3__fill_1
X_5175_ VDD VDD VSS VSS _5175_/CLK _5175_/D _5175_/Q gf180mcu_as_sc_mcu7t3v3__dfxtp_2
Xclkbuf_leaf_38_clk_regs VDD VDD VSS VSS clkbuf_leaf_6_clk_regs/A clkload4/A gf180mcu_as_sc_mcu7t3v3__clkbuff_12
XFILLER_116_1285 VDD VDD VSS VSS gf180mcu_as_sc_mcu7t3v3__fillcap_4
X_4126_ VDD VDD VSS VSS _4126_/A _4154_/C _4151_/B _4126_/D _4127_/D gf180mcu_as_sc_mcu7t3v3__ao22_2
XTAP_TAPCELL_ROW_184_1745 VDD VSS gf180mcu_as_sc_mcu7t3v3__tap_2
XTAP_TAPCELL_ROW_184_1734 VDD VSS gf180mcu_as_sc_mcu7t3v3__tap_2
XTAP_TAPCELL_ROW_38_3_1949 VDD VSS gf180mcu_as_sc_mcu7t3v3__tap_2
XPHY_EDGE_ROW_143_1_Left_335 VDD VSS gf180mcu_as_sc_mcu7t3v3__tap_2
X_4057_ VDD VDD VSS VSS _4057_/A _4105_/B _4057_/C _4057_/D _4058_/B gf180mcu_as_sc_mcu7t3v3__ao211_2
X_3008_ VDD VDD VSS VSS _3043_/S _3989_/A _3991_/A _3010_/B gf180mcu_as_sc_mcu7t3v3__mux2_2
XFILLER_61_27 VDD VDD VSS VSS gf180mcu_as_sc_mcu7t3v3__fill_1
X_4959_ VDD VDD VSS VSS _5265_/CLK _4959_/D _4959_/Q gf180mcu_as_sc_mcu7t3v3__dfxtp_2
XFILLER_162_1294 VDD VDD VSS VSS gf180mcu_as_sc_mcu7t3v3__fill_1
XFILLER_177_38 VDD VDD VSS VSS gf180mcu_as_sc_mcu7t3v3__fillcap_16
XFILLER_123_1256 VDD VDD VSS VSS gf180mcu_as_sc_mcu7t3v3__fillcap_16
XFILLER_180_514 VDD VDD VSS VSS gf180mcu_as_sc_mcu7t3v3__fill_2
Xclkbuf_2_2_0_clk_regs VDD VDD VSS VSS clkbuf_0_clk_regs/Y clkbuf_2_2_0_clk_regs/Y
+ gf180mcu_as_sc_mcu7t3v3__clkbuff_12
XFILLER_165_599 VDD VDD VSS VSS gf180mcu_as_sc_mcu7t3v3__fillcap_16
XFILLER_10_53 VDD VDD VSS VSS gf180mcu_as_sc_mcu7t3v3__fillcap_16
XFILLER_0_911 VDD VDD VSS VSS gf180mcu_as_sc_mcu7t3v3__fill_2
XFILLER_161_772 VDD VDD VSS VSS gf180mcu_as_sc_mcu7t3v3__fillcap_16
Xoutput380 VDD VDD VSS VSS _4800_/Q se_out[29] gf180mcu_as_sc_mcu7t3v3__buff_12
XPHY_EDGE_ROW_14_3_Left_386 VDD VSS gf180mcu_as_sc_mcu7t3v3__tap_2
Xoutput391 VDD VDD VSS VSS _4779_/Q se_out[8] gf180mcu_as_sc_mcu7t3v3__buff_12
XPHY_EDGE_ROW_75_1_Left_267 VDD VSS gf180mcu_as_sc_mcu7t3v3__tap_2
XFILLER_142_85 VDD VDD VSS VSS gf180mcu_as_sc_mcu7t3v3__fillcap_16
XFILLER_35_72 VDD VDD VSS VSS gf180mcu_as_sc_mcu7t3v3__fillcap_4
XPHY_EDGE_ROW_67_1_Right_576 VDD VSS gf180mcu_as_sc_mcu7t3v3__tap_2
XFILLER_141_1301 VDD VDD VSS VSS gf180mcu_as_sc_mcu7t3v3__fillcap_16
XFILLER_54_1353 VDD VDD VSS VSS gf180mcu_as_sc_mcu7t3v3__fill_2
XFILLER_141_1323 VDD VDD VSS VSS gf180mcu_as_sc_mcu7t3v3__fill_1
XFILLER_11_572 VDD VDD VSS VSS gf180mcu_as_sc_mcu7t3v3__fill_1
XFILLER_156_522 VDD VDD VSS VSS gf180mcu_as_sc_mcu7t3v3__fill_2
XFILLER_183_352 VDD VDD VSS VSS gf180mcu_as_sc_mcu7t3v3__fill_2
XFILLER_7_576 VDD VDD VSS VSS gf180mcu_as_sc_mcu7t3v3__fill_1
Xwire463 VDD VDD VSS VSS _3654_/Y _4850_/D gf180mcu_as_sc_mcu7t3v3__clkbuff_12
Xwire485 VDD VDD VSS VSS _3023_/Y _4779_/D gf180mcu_as_sc_mcu7t3v3__clkbuff_12
XFILLER_13_1083 VDD VDD VSS VSS gf180mcu_as_sc_mcu7t3v3__fill_1
XFILLER_152_750 VDD VDD VSS VSS gf180mcu_as_sc_mcu7t3v3__fillcap_16
XFILLER_174_1132 VDD VDD VSS VSS gf180mcu_as_sc_mcu7t3v3__fill_2
XFILLER_174_1154 VDD VDD VSS VSS gf180mcu_as_sc_mcu7t3v3__fill_1
X_3290_ VDD VDD VSS VSS _3386_/D _3942_/A _3292_/C gf180mcu_as_sc_mcu7t3v3__and2_2
XFILLER_170_1029 VDD VDD VSS VSS gf180mcu_as_sc_mcu7t3v3__fill_2
XFILLER_174_1187 VDD VDD VSS VSS gf180mcu_as_sc_mcu7t3v3__fillcap_8
XFILLER_183_92 VDD VDD VSS VSS gf180mcu_as_sc_mcu7t3v3__fill_2
XTAP_TAPCELL_ROW_40_1_993 VDD VSS gf180mcu_as_sc_mcu7t3v3__tap_2
XTAP_TAPCELL_ROW_1_708 VDD VSS gf180mcu_as_sc_mcu7t3v3__tap_2
XTAP_TAPCELL_ROW_1_719 VDD VSS gf180mcu_as_sc_mcu7t3v3__tap_2
XTAP_TAPCELL_ROW_162_1328 VDD VSS gf180mcu_as_sc_mcu7t3v3__tap_2
XTAP_TAPCELL_ROW_162_1317 VDD VSS gf180mcu_as_sc_mcu7t3v3__tap_2
XPHY_EDGE_ROW_128_3_Right_169 VDD VSS gf180mcu_as_sc_mcu7t3v3__tap_2
XFILLER_98_1291 VDD VDD VSS VSS gf180mcu_as_sc_mcu7t3v3__fillcap_8
XFILLER_146_1256 VDD VDD VSS VSS gf180mcu_as_sc_mcu7t3v3__fillcap_16
XFILLER_178_146 VDD VDD VSS VSS gf180mcu_as_sc_mcu7t3v3__fill_2
X_4813_ VDD VDD VSS VSS clkload3/A _4813_/D _4813_/Q gf180mcu_as_sc_mcu7t3v3__dfxtp_2
X_4744_ VDD VDD VSS VSS _4747_/D _4744_/A _5274_/D gf180mcu_as_sc_mcu7t3v3__and2_2
XPHY_EDGE_ROW_1_Left_194 VDD VSS gf180mcu_as_sc_mcu7t3v3__tap_2
XFILLER_175_842 VDD VDD VSS VSS gf180mcu_as_sc_mcu7t3v3__fillcap_16
XFILLER_174_374 VDD VDD VSS VSS gf180mcu_as_sc_mcu7t3v3__fillcap_8
X_4675_ VDD VDD VSS VSS _5245_/Q _4685_/C _4681_/C _5246_/Q _4676_/C gf180mcu_as_sc_mcu7t3v3__ao22_2
XFILLER_190_845 VDD VDD VSS VSS gf180mcu_as_sc_mcu7t3v3__fill_1
X_3626_ VDD VDD VSS VSS _4000_/A _3779_/B _3778_/B _4000_/D _3627_/D gf180mcu_as_sc_mcu7t3v3__ao22_2
XFILLER_162_558 VDD VDD VSS VSS gf180mcu_as_sc_mcu7t3v3__fill_1
XFILLER_179_1098 VDD VDD VSS VSS gf180mcu_as_sc_mcu7t3v3__fillcap_8
XFILLER_192_1232 VDD VDD VSS VSS gf180mcu_as_sc_mcu7t3v3__fill_1
X_3557_ VDD VDD VSS VSS _3805_/A _3557_/B _3559_/C gf180mcu_as_sc_mcu7t3v3__nand2b_2
XTAP_TAPCELL_ROW_93_1_1046 VDD VSS gf180mcu_as_sc_mcu7t3v3__tap_2
XFILLER_153_1205 VDD VDD VSS VSS gf180mcu_as_sc_mcu7t3v3__fill_1
X_2508_ VDD VDD VSS VSS _4739_/B _4739_/A _4643_/A gf180mcu_as_sc_mcu7t3v3__and2_2
XFILLER_192_1298 VDD VDD VSS VSS gf180mcu_as_sc_mcu7t3v3__fill_2
X_5227_ VDD VDD VSS VSS _5280_/CLK _5227_/D _5227_/Q gf180mcu_as_sc_mcu7t3v3__dfxtp_2
Xinput108 VDD VDD VSS VSS ne_in[6] _3984_/D gf180mcu_as_sc_mcu7t3v3__buff_12
X_3488_ VDD VDD VSS VSS _3490_/C _4143_/A _3495_/B _3488_/C gf180mcu_as_sc_mcu7t3v3__ao21_2
Xinput119 VDD VDD VSS VSS north_in[16] wire902/A gf180mcu_as_sc_mcu7t3v3__buff_12
X_2439_ VDD VDD VSS VSS _4075_/A _2439_/A gf180mcu_as_sc_mcu7t3v3__inv_2
X_5158_ VDD VDD VSS VSS _5158_/CLK _5158_/D _5158_/Q gf180mcu_as_sc_mcu7t3v3__dfxtp_2
X_5089_ VDD VDD VSS VSS _5089_/CLK _5089_/D _5089_/Q gf180mcu_as_sc_mcu7t3v3__dfxtp_2
X_4109_ VDD VDD VSS VSS _4109_/A _4160_/B _4161_/B _4109_/D _4110_/D gf180mcu_as_sc_mcu7t3v3__ao22_2
XFILLER_164_1301 VDD VDD VSS VSS gf180mcu_as_sc_mcu7t3v3__fill_2
XFILLER_72_37 VDD VDD VSS VSS gf180mcu_as_sc_mcu7t3v3__fillcap_4
XFILLER_12_314 VDD VDD VSS VSS gf180mcu_as_sc_mcu7t3v3__fill_1
XFILLER_188_37 VDD VDD VSS VSS gf180mcu_as_sc_mcu7t3v3__fillcap_16
X_4881__1087 VDD VDD VSS VSS _4881_/D gf180mcu_as_sc_mcu7t3v3__tiel_4
XFILLER_165_352 VDD VDD VSS VSS gf180mcu_as_sc_mcu7t3v3__fillcap_8
XFILLER_166_897 VDD VDD VSS VSS gf180mcu_as_sc_mcu7t3v3__fillcap_4
XFILLER_115_2 VDD VDD VSS VSS gf180mcu_as_sc_mcu7t3v3__fillcap_8
XFILLER_153_525 VDD VDD VSS VSS gf180mcu_as_sc_mcu7t3v3__fill_1
XFILLER_153_536 VDD VDD VSS VSS gf180mcu_as_sc_mcu7t3v3__fillcap_8
XFILLER_180_311 VDD VDD VSS VSS gf180mcu_as_sc_mcu7t3v3__fillcap_4
XFILLER_21_63 VDD VDD VSS VSS gf180mcu_as_sc_mcu7t3v3__fillcap_4
XFILLER_137_41 VDD VDD VSS VSS gf180mcu_as_sc_mcu7t3v3__fillcap_16
XFILLER_180_344 VDD VDD VSS VSS gf180mcu_as_sc_mcu7t3v3__fillcap_8
XFILLER_180_377 VDD VDD VSS VSS gf180mcu_as_sc_mcu7t3v3__fill_1
XTAP_TAPCELL_ROW_8_852 VDD VSS gf180mcu_as_sc_mcu7t3v3__tap_2
XTAP_TAPCELL_ROW_8_841 VDD VSS gf180mcu_as_sc_mcu7t3v3__tap_2
XFILLER_0_774 VDD VDD VSS VSS gf180mcu_as_sc_mcu7t3v3__fill_1
XFILLER_153_84 VDD VDD VSS VSS gf180mcu_as_sc_mcu7t3v3__fill_1
XFILLER_169_1289 VDD VDD VSS VSS gf180mcu_as_sc_mcu7t3v3__fillcap_4
XFILLER_189_923 VDD VDD VSS VSS gf180mcu_as_sc_mcu7t3v3__fillcap_8
XFILLER_189_978 VDD VDD VSS VSS gf180mcu_as_sc_mcu7t3v3__fill_2
XFILLER_30_100 VDD VDD VSS VSS gf180mcu_as_sc_mcu7t3v3__fillcap_4
XFILLER_175_105 VDD VDD VSS VSS gf180mcu_as_sc_mcu7t3v3__fillcap_8
XFILLER_19_1270 VDD VDD VSS VSS gf180mcu_as_sc_mcu7t3v3__fill_1
XPHY_EDGE_ROW_68_1_Right_577 VDD VSS gf180mcu_as_sc_mcu7t3v3__tap_2
XFILLER_157_842 VDD VDD VSS VSS gf180mcu_as_sc_mcu7t3v3__fillcap_8
XFILLER_175_138 VDD VDD VSS VSS gf180mcu_as_sc_mcu7t3v3__fill_2
X_2790_ VDD VDD VSS VSS _4739_/A _2802_/A _2790_/C _5270_/Q _4732_/B gf180mcu_as_sc_mcu7t3v3__ao22_2
XFILLER_156_352 VDD VDD VSS VSS gf180mcu_as_sc_mcu7t3v3__fillcap_16
XFILLER_8_874 VDD VDD VSS VSS gf180mcu_as_sc_mcu7t3v3__fill_1
XFILLER_171_311 VDD VDD VSS VSS gf180mcu_as_sc_mcu7t3v3__fillcap_8
XFILLER_176_1227 VDD VDD VSS VSS gf180mcu_as_sc_mcu7t3v3__fillcap_16
XFILLER_183_182 VDD VDD VSS VSS gf180mcu_as_sc_mcu7t3v3__fill_1
XFILLER_7_65 VDD VDD VSS VSS gf180mcu_as_sc_mcu7t3v3__fillcap_4
X_4460_ VDD VDD VSS VSS _5173_/Q _4565_/B _4460_/C _4460_/D _5173_/D gf180mcu_as_sc_mcu7t3v3__ao211_2
XTAP_TAPCELL_ROW_155_1187 VDD VSS gf180mcu_as_sc_mcu7t3v3__tap_2
XFILLER_172_856 VDD VDD VSS VSS gf180mcu_as_sc_mcu7t3v3__fill_1
X_4391_ VDD VDD VSS VSS _4394_/C _4979_/Q _4536_/S gf180mcu_as_sc_mcu7t3v3__nand2b_2
X_3411_ VDD VDD VSS VSS _3419_/B _4063_/A _3412_/D gf180mcu_as_sc_mcu7t3v3__or2_2
XTAP_TAPCELL_ROW_155_1198 VDD VSS gf180mcu_as_sc_mcu7t3v3__tap_2
X_3342_ VDD VDD VSS VSS _3342_/B _3342_/A _3343_/B gf180mcu_as_sc_mcu7t3v3__or2_2
XFILLER_152_580 VDD VDD VSS VSS gf180mcu_as_sc_mcu7t3v3__fillcap_4
Xfanout809 VDD VDD VSS VSS _5224_/Q _3871_/A gf180mcu_as_sc_mcu7t3v3__buff_12
X_3273_ VDD VDD VSS VSS _3933_/A _3501_/C _3503_/B _3933_/D _3274_/D gf180mcu_as_sc_mcu7t3v3__ao22_2
X_5012_ VDD VDD VSS VSS _5178_/CLK _5012_/D _5012_/Q gf180mcu_as_sc_mcu7t3v3__dfxtp_2
XFILLER_179_422 VDD VDD VSS VSS gf180mcu_as_sc_mcu7t3v3__fillcap_16
XFILLER_179_466 VDD VDD VSS VSS gf180mcu_as_sc_mcu7t3v3__fillcap_16
XTAP_TAPCELL_ROW_179_1655 VDD VSS gf180mcu_as_sc_mcu7t3v3__tap_2
XTAP_TAPCELL_ROW_179_1644 VDD VSS gf180mcu_as_sc_mcu7t3v3__tap_2
XFILLER_158_18 VDD VDD VSS VSS gf180mcu_as_sc_mcu7t3v3__fillcap_16
XFILLER_167_628 VDD VDD VSS VSS gf180mcu_as_sc_mcu7t3v3__fill_2
XFILLER_167_639 VDD VDD VSS VSS gf180mcu_as_sc_mcu7t3v3__fillcap_16
XFILLER_10_829 VDD VDD VSS VSS gf180mcu_as_sc_mcu7t3v3__fill_2
X_2988_ VDD VDD VSS VSS _2989_/C _2988_/C _3042_/C _3965_/A gf180mcu_as_sc_mcu7t3v3__aoi21_2
X_4727_ VDD VDD VSS VSS _5264_/D _5109_/Q _4728_/B _4727_/C gf180mcu_as_sc_mcu7t3v3__ao21_2
X_4658_ VDD VDD VSS VSS _4658_/B _4659_/B _4660_/B gf180mcu_as_sc_mcu7t3v3__and2_2
XTAP_TAPCELL_ROW_192_1899 VDD VSS gf180mcu_as_sc_mcu7t3v3__tap_2
XTAP_TAPCELL_ROW_192_1888 VDD VSS gf180mcu_as_sc_mcu7t3v3__tap_2
Xinput90 VDD VDD VSS VSS ne_in[20] _4093_/A gf180mcu_as_sc_mcu7t3v3__buff_12
X_3609_ VDD VDD VSS VSS _3983_/A _3649_/B _3648_/C _3982_/A _3610_/C gf180mcu_as_sc_mcu7t3v3__ao22_2
XFILLER_190_686 VDD VDD VSS VSS gf180mcu_as_sc_mcu7t3v3__fillcap_8
X_4589_ VDD VDD VSS VSS _4592_/C _4589_/B _4589_/A gf180mcu_as_sc_mcu7t3v3__nor2_2
XFILLER_192_1051 VDD VDD VSS VSS gf180mcu_as_sc_mcu7t3v3__fill_2
XFILLER_107_88 VDD VDD VSS VSS gf180mcu_as_sc_mcu7t3v3__fillcap_16
X_4899__1069 VDD VDD VSS VSS _4899_/D gf180mcu_as_sc_mcu7t3v3__tiel_4
XFILLER_83_69 VDD VDD VSS VSS gf180mcu_as_sc_mcu7t3v3__fill_1
XPHY_EDGE_ROW_11_Right_11 VDD VSS gf180mcu_as_sc_mcu7t3v3__tap_2
XFILLER_160_1028 VDD VDD VSS VSS gf180mcu_as_sc_mcu7t3v3__fillcap_4
XFILLER_164_1175 VDD VDD VSS VSS gf180mcu_as_sc_mcu7t3v3__fill_2
XFILLER_185_403 VDD VDD VSS VSS gf180mcu_as_sc_mcu7t3v3__fillcap_16
XFILLER_12_155 VDD VDD VSS VSS gf180mcu_as_sc_mcu7t3v3__fillcap_16
XFILLER_12_177 VDD VDD VSS VSS gf180mcu_as_sc_mcu7t3v3__fillcap_4
XFILLER_32_51 VDD VDD VSS VSS gf180mcu_as_sc_mcu7t3v3__fill_1
XFILLER_8_137 VDD VDD VSS VSS gf180mcu_as_sc_mcu7t3v3__fill_2
XFILLER_148_62 VDD VDD VSS VSS gf180mcu_as_sc_mcu7t3v3__fillcap_4
XFILLER_154_823 VDD VDD VSS VSS gf180mcu_as_sc_mcu7t3v3__fillcap_4
XFILLER_166_683 VDD VDD VSS VSS gf180mcu_as_sc_mcu7t3v3__fillcap_4
XFILLER_164_61 VDD VDD VSS VSS gf180mcu_as_sc_mcu7t3v3__fillcap_4
XFILLER_136_1299 VDD VDD VSS VSS gf180mcu_as_sc_mcu7t3v3__fillcap_4
XFILLER_180_82 VDD VDD VSS VSS gf180mcu_as_sc_mcu7t3v3__fillcap_16
X_3960_ VDD VDD VSS VSS _3960_/A _4024_/B _3960_/C _3960_/D _3961_/C gf180mcu_as_sc_mcu7t3v3__ao211_2
X_2911_ VDD VDD VSS VSS _3253_/A _3254_/A _3255_/B gf180mcu_as_sc_mcu7t3v3__or2_2
XFILLER_176_414 VDD VDD VSS VSS gf180mcu_as_sc_mcu7t3v3__fillcap_8
XFILLER_189_80 VDD VDD VSS VSS gf180mcu_as_sc_mcu7t3v3__fill_2
X_3891_ VDD VDD VSS VSS _3908_/B _5181_/Q _4931_/D gf180mcu_as_sc_mcu7t3v3__and2_2
XPHY_EDGE_ROW_39_3_Left_411 VDD VSS gf180mcu_as_sc_mcu7t3v3__tap_2
XFILLER_176_447 VDD VDD VSS VSS gf180mcu_as_sc_mcu7t3v3__fill_1
X_2842_ VDD VDD VSS VSS _2842_/A _2842_/B _2842_/C _2842_/D _4290_/B gf180mcu_as_sc_mcu7t3v3__ao22_2
XTAP_TAPCELL_ROW_157_1238 VDD VSS gf180mcu_as_sc_mcu7t3v3__tap_2
XTAP_TAPCELL_ROW_157_1227 VDD VSS gf180mcu_as_sc_mcu7t3v3__tap_2
XPHY_EDGE_ROW_69_1_Right_578 VDD VSS gf180mcu_as_sc_mcu7t3v3__tap_2
XFILLER_78_2 VDD VDD VSS VSS gf180mcu_as_sc_mcu7t3v3__fill_2
X_2773_ VDD VDD VSS VSS _4259_/B _2773_/B _5229_/Q gf180mcu_as_sc_mcu7t3v3__nor2_2
XTAP_TAPCELL_ROW_174_1552 VDD VSS gf180mcu_as_sc_mcu7t3v3__tap_2
XFILLER_185_992 VDD VDD VSS VSS gf180mcu_as_sc_mcu7t3v3__fill_1
X_4512_ VDD VDD VSS VSS _4513_/D _4512_/B _4573_/A gf180mcu_as_sc_mcu7t3v3__nor2_2
XFILLER_160_804 VDD VDD VSS VSS gf180mcu_as_sc_mcu7t3v3__fill_1
XFILLER_176_1013 VDD VDD VSS VSS gf180mcu_as_sc_mcu7t3v3__fill_2
XFILLER_8_693 VDD VDD VSS VSS gf180mcu_as_sc_mcu7t3v3__fill_2
XTAP_TAPCELL_ROW_10_890 VDD VSS gf180mcu_as_sc_mcu7t3v3__tap_2
X_4443_ VDD VDD VSS VSS _5173_/Q _4493_/B _4523_/C _5123_/Q _4444_/B gf180mcu_as_sc_mcu7t3v3__ao22_2
XFILLER_171_196 VDD VDD VSS VSS gf180mcu_as_sc_mcu7t3v3__fill_2
X_4374_ VDD VDD VSS VSS _4379_/B _4374_/B _5162_/Q _5162_/D gf180mcu_as_sc_mcu7t3v3__mux2_2
Xfanout617 VDD VDD VSS VSS _4377_/B _4375_/B gf180mcu_as_sc_mcu7t3v3__buff_12
Xfanout628 VDD VDD VSS VSS fanout628/A _4151_/B gf180mcu_as_sc_mcu7t3v3__buff_12
Xfanout639 VDD VDD VSS VSS wire640/Y _3771_/B gf180mcu_as_sc_mcu7t3v3__buff_12
X_3325_ VDD VDD VSS VSS _3976_/A _3374_/B _3374_/C _3977_/A _3326_/C gf180mcu_as_sc_mcu7t3v3__ao22_2
X_3256_ VDD VDD VSS VSS _3268_/A _3519_/C _3510_/C _3517_/D _3271_/A gf180mcu_as_sc_mcu7t3v3__nand4_2
XTAP_TAPCELL_ROW_88_1_1041 VDD VSS gf180mcu_as_sc_mcu7t3v3__tap_2
XTAP_TAPCELL_ROW_102_1_1055 VDD VSS gf180mcu_as_sc_mcu7t3v3__tap_2
X_3187_ VDD VDD VSS VSS _3223_/B _3187_/B _3201_/C _3235_/B gf180mcu_as_sc_mcu7t3v3__nand3_2
XFILLER_187_1164 VDD VDD VSS VSS gf180mcu_as_sc_mcu7t3v3__fillcap_16
XFILLER_179_252 VDD VDD VSS VSS gf180mcu_as_sc_mcu7t3v3__fill_2
XFILLER_35_1318 VDD VDD VSS VSS gf180mcu_as_sc_mcu7t3v3__fillcap_4
XPHY_EDGE_ROW_23_3_Left_395 VDD VSS gf180mcu_as_sc_mcu7t3v3__tap_2
XFILLER_159_1200 VDD VDD VSS VSS gf180mcu_as_sc_mcu7t3v3__fillcap_4
XPHY_EDGE_ROW_84_1_Left_276 VDD VSS gf180mcu_as_sc_mcu7t3v3__tap_2
XFILLER_11_1351 VDD VDD VSS VSS gf180mcu_as_sc_mcu7t3v3__fillcap_4
XFILLER_191_962 VDD VDD VSS VSS gf180mcu_as_sc_mcu7t3v3__fillcap_8
XFILLER_118_54 VDD VDD VSS VSS gf180mcu_as_sc_mcu7t3v3__fill_1
XFILLER_155_1119 VDD VDD VSS VSS gf180mcu_as_sc_mcu7t3v3__fill_1
XFILLER_159_1266 VDD VDD VSS VSS gf180mcu_as_sc_mcu7t3v3__fill_2
XFILLER_162_141 VDD VDD VSS VSS gf180mcu_as_sc_mcu7t3v3__fillcap_4
Xmesh_tile_1016 VDD VDD VSS VSS nw_out[22] gf180mcu_as_sc_mcu7t3v3__tiel_4
Xmesh_tile_1005 VDD VDD VSS VSS nw_out[11] gf180mcu_as_sc_mcu7t3v3__tiel_4
XFILLER_182_2 VDD VDD VSS VSS gf180mcu_as_sc_mcu7t3v3__fillcap_16
Xmesh_tile_1049 VDD VDD VSS VSS sw_out[21] gf180mcu_as_sc_mcu7t3v3__tiel_4
Xmesh_tile_1038 VDD VDD VSS VSS sw_out[10] gf180mcu_as_sc_mcu7t3v3__tiel_4
Xmesh_tile_1027 VDD VDD VSS VSS nw_out[33] gf180mcu_as_sc_mcu7t3v3__tiel_4
XFILLER_150_30 VDD VDD VSS VSS gf180mcu_as_sc_mcu7t3v3__fillcap_4
XFILLER_79_1256 VDD VDD VSS VSS gf180mcu_as_sc_mcu7t3v3__fillcap_16
XFILLER_150_52 VDD VDD VSS VSS gf180mcu_as_sc_mcu7t3v3__fillcap_16
XFILLER_159_937 VDD VDD VSS VSS gf180mcu_as_sc_mcu7t3v3__fill_1
XFILLER_186_734 VDD VDD VSS VSS gf180mcu_as_sc_mcu7t3v3__fill_1
XFILLER_43_72 VDD VDD VSS VSS gf180mcu_as_sc_mcu7t3v3__fillcap_8
XFILLER_9_424 VDD VDD VSS VSS gf180mcu_as_sc_mcu7t3v3__fill_1
XFILLER_159_61 VDD VDD VSS VSS gf180mcu_as_sc_mcu7t3v3__fill_2
XFILLER_167_970 VDD VDD VSS VSS gf180mcu_as_sc_mcu7t3v3__fillcap_8
XFILLER_12_1104 VDD VDD VSS VSS gf180mcu_as_sc_mcu7t3v3__fillcap_4
XFILLER_185_277 VDD VDD VSS VSS gf180mcu_as_sc_mcu7t3v3__fill_2
XTAP_TAPCELL_ROW_152_1135 VDD VSS gf180mcu_as_sc_mcu7t3v3__tap_2
XTAP_TAPCELL_ROW_152_1124 VDD VSS gf180mcu_as_sc_mcu7t3v3__tap_2
XTAP_TAPCELL_ROW_152_1113 VDD VSS gf180mcu_as_sc_mcu7t3v3__tap_2
XFILLER_173_1208 VDD VDD VSS VSS gf180mcu_as_sc_mcu7t3v3__fillcap_8
XFILLER_182_984 VDD VDD VSS VSS gf180mcu_as_sc_mcu7t3v3__fillcap_8
XFILLER_181_483 VDD VDD VSS VSS gf180mcu_as_sc_mcu7t3v3__fillcap_4
XFILLER_67_103 VDD VDD VSS VSS gf180mcu_as_sc_mcu7t3v3__fill_2
X_3110_ VDD VDD VSS VSS _3236_/B _4934_/Q _3113_/C gf180mcu_as_sc_mcu7t3v3__or2_2
X_4090_ VDD VDD VSS VSS _4091_/C _4090_/B _4090_/A gf180mcu_as_sc_mcu7t3v3__nor2_2
Xinput280 VDD VDD VSS VSS sw_in[7] _3994_/A gf180mcu_as_sc_mcu7t3v3__buff_12
X_3041_ VDD VDD VSS VSS _4781_/D _3041_/C _3041_/B _3647_/A gf180mcu_as_sc_mcu7t3v3__aoi21_2
Xinput291 VDD VDD VSS VSS west_in[17] _4069_/D gf180mcu_as_sc_mcu7t3v3__buff_12
X_4992_ VDD VDD VSS VSS _5086_/CLK _4992_/D _4992_/Q gf180mcu_as_sc_mcu7t3v3__dfxtp_2
X_3943_ VDD VDD VSS VSS _3944_/D _3943_/C _4025_/B _3943_/A gf180mcu_as_sc_mcu7t3v3__aoi21_2
X_3874_ VDD VDD VSS VSS _3874_/B _3874_/A _3874_/Y gf180mcu_as_sc_mcu7t3v3__and2_2
XFILLER_164_406 VDD VDD VSS VSS gf180mcu_as_sc_mcu7t3v3__fill_2
XFILLER_165_907 VDD VDD VSS VSS gf180mcu_as_sc_mcu7t3v3__fill_2
XFILLER_177_767 VDD VDD VSS VSS gf180mcu_as_sc_mcu7t3v3__fill_2
X_2825_ VDD VDD VSS VSS _4751_/A _2825_/B _5280_/Q _5279_/D gf180mcu_as_sc_mcu7t3v3__mux2_2
X_2756_ VDD VDD VSS VSS _4627_/A _3871_/A _2766_/C gf180mcu_as_sc_mcu7t3v3__and2_2
XFILLER_160_601 VDD VDD VSS VSS gf180mcu_as_sc_mcu7t3v3__fill_2
X_2687_ VDD VDD VSS VSS _2724_/S _5174_/Q _5166_/Q _2690_/B gf180mcu_as_sc_mcu7t3v3__mux2_2
XTAP_TAPCELL_ROW_121_3_2032 VDD VSS gf180mcu_as_sc_mcu7t3v3__tap_2
X_4426_ VDD VDD VSS VSS _4426_/B _4524_/A _4433_/C gf180mcu_as_sc_mcu7t3v3__and2_2
XFILLER_160_667 VDD VDD VSS VSS gf180mcu_as_sc_mcu7t3v3__fillcap_4
XFILLER_58_103 VDD VDD VSS VSS gf180mcu_as_sc_mcu7t3v3__fill_2
XFILLER_8_1227 VDD VDD VSS VSS gf180mcu_as_sc_mcu7t3v3__fill_2
X_4357_ VDD VDD VSS VSS _4694_/B _4563_/C _4357_/C _4357_/D _4358_/B gf180mcu_as_sc_mcu7t3v3__ao211_2
X_4288_ VDD VDD VSS VSS _4289_/S _4706_/A _5122_/Q _5122_/D gf180mcu_as_sc_mcu7t3v3__mux2_2
X_3308_ VDD VDD VSS VSS _3373_/S _3956_/A _3308_/A _3310_/B gf180mcu_as_sc_mcu7t3v3__mux2_2
XTAP_TAPCELL_ROW_187_1798 VDD VSS gf180mcu_as_sc_mcu7t3v3__tap_2
XFILLER_189_1248 VDD VDD VSS VSS gf180mcu_as_sc_mcu7t3v3__fill_2
X_3239_ VDD VDD VSS VSS _3240_/D _3521_/A _3239_/A gf180mcu_as_sc_mcu7t3v3__nor2b_2
XFILLER_104_67 VDD VDD VSS VSS gf180mcu_as_sc_mcu7t3v3__fillcap_8
XFILLER_120_55 VDD VDD VSS VSS gf180mcu_as_sc_mcu7t3v3__fillcap_4
XFILLER_154_6 VDD VDD VSS VSS gf180mcu_as_sc_mcu7t3v3__fillcap_4
XFILLER_165_1270 VDD VDD VSS VSS gf180mcu_as_sc_mcu7t3v3__fillcap_4
XFILLER_39_1262 VDD VDD VSS VSS gf180mcu_as_sc_mcu7t3v3__fill_2
XFILLER_168_734 VDD VDD VSS VSS gf180mcu_as_sc_mcu7t3v3__fill_1
XFILLER_80_37 VDD VDD VSS VSS gf180mcu_as_sc_mcu7t3v3__fillcap_4
XFILLER_11_935 VDD VDD VSS VSS gf180mcu_as_sc_mcu7t3v3__fillcap_16
XFILLER_126_1276 VDD VDD VSS VSS gf180mcu_as_sc_mcu7t3v3__fillcap_8
XFILLER_13_31 VDD VDD VSS VSS gf180mcu_as_sc_mcu7t3v3__fill_2
XFILLER_155_439 VDD VDD VSS VSS gf180mcu_as_sc_mcu7t3v3__fill_2
XFILLER_161_1189 VDD VDD VSS VSS gf180mcu_as_sc_mcu7t3v3__fill_1
XFILLER_182_214 VDD VDD VSS VSS gf180mcu_as_sc_mcu7t3v3__fillcap_4
Xwire859 VDD VDD VSS VSS wire859/A _4159_/A gf180mcu_as_sc_mcu7t3v3__clkbuff_12
XFILLER_164_940 VDD VDD VSS VSS gf180mcu_as_sc_mcu7t3v3__fillcap_4
XFILLER_183_759 VDD VDD VSS VSS gf180mcu_as_sc_mcu7t3v3__fillcap_8
XFILLER_182_269 VDD VDD VSS VSS gf180mcu_as_sc_mcu7t3v3__fill_1
XFILLER_11_1192 VDD VDD VSS VSS gf180mcu_as_sc_mcu7t3v3__fillcap_8
XFILLER_8_2 VDD VDD VSS VSS gf180mcu_as_sc_mcu7t3v3__fillcap_4
XFILLER_46_1288 VDD VDD VSS VSS gf180mcu_as_sc_mcu7t3v3__fill_1
XTAP_TAPCELL_ROW_56_3_1967 VDD VSS gf180mcu_as_sc_mcu7t3v3__tap_2
XPHY_EDGE_ROW_158_Right_20 VDD VSS gf180mcu_as_sc_mcu7t3v3__tap_2
XFILLER_105_1316 VDD VDD VSS VSS gf180mcu_as_sc_mcu7t3v3__fill_1
XFILLER_13_294 VDD VDD VSS VSS gf180mcu_as_sc_mcu7t3v3__fillcap_8
XFILLER_158_233 VDD VDD VSS VSS gf180mcu_as_sc_mcu7t3v3__fill_1
XFILLER_174_715 VDD VDD VSS VSS gf180mcu_as_sc_mcu7t3v3__fillcap_8
XFILLER_174_737 VDD VDD VSS VSS gf180mcu_as_sc_mcu7t3v3__fillcap_4
XFILLER_186_597 VDD VDD VSS VSS gf180mcu_as_sc_mcu7t3v3__fillcap_16
Xclkload13 VDD VDD VSS VSS _5086_/CLK clkload13/Y gf180mcu_as_sc_mcu7t3v3__clkbuff_12
Xclkload24 VDD VDD VSS VSS clkload24/Y _5188_/CLK gf180mcu_as_sc_mcu7t3v3__inv_2
X_3590_ VDD VDD VSS VSS _3960_/A _3649_/B _3590_/C _3590_/D _3592_/C gf180mcu_as_sc_mcu7t3v3__ao211_2
X_2610_ VDD VDD VSS VSS _2676_/A _2610_/B _2610_/A _2610_/Y gf180mcu_as_sc_mcu7t3v3__mux2_2
XTAP_TAPCELL_ROW_171_1500 VDD VSS gf180mcu_as_sc_mcu7t3v3__tap_2
XFILLER_154_461 VDD VDD VSS VSS gf180mcu_as_sc_mcu7t3v3__fill_2
XFILLER_177_1141 VDD VDD VSS VSS gf180mcu_as_sc_mcu7t3v3__fillcap_16
XFILLER_55_4 VDD VDD VSS VSS gf180mcu_as_sc_mcu7t3v3__fill_1
X_2541_ VDD VDD VSS VSS _4719_/A _2541_/B _2541_/C _5277_/Q _2541_/Y gf180mcu_as_sc_mcu7t3v3__ao22_2
X_5260_ VDD VDD VSS VSS _5265_/CLK _5260_/D _5260_/Q gf180mcu_as_sc_mcu7t3v3__dfxtp_2
X_4894__1074 VDD VDD VSS VSS _4894_/D gf180mcu_as_sc_mcu7t3v3__tiel_4
X_2472_ VDD VDD VSS VSS _4362_/B _2472_/C _2472_/B _4588_/A gf180mcu_as_sc_mcu7t3v3__aoi21_2
XFILLER_170_965 VDD VDD VSS VSS gf180mcu_as_sc_mcu7t3v3__fillcap_16
XFILLER_173_1049 VDD VDD VSS VSS gf180mcu_as_sc_mcu7t3v3__fill_1
X_4211_ VDD VDD VSS VSS _4240_/B _4217_/B _4218_/C _5047_/Q _5047_/D gf180mcu_as_sc_mcu7t3v3__ao22_2
X_5191_ VDD VDD VSS VSS _5220_/CLK _5191_/D _5191_/Q gf180mcu_as_sc_mcu7t3v3__dfxtp_2
XTAP_TAPCELL_ROW_169_1451 VDD VSS gf180mcu_as_sc_mcu7t3v3__tap_2
X_4142_ VDD VDD VSS VSS _5003_/Q _4158_/B _4254_/B _4158_/D _5003_/D gf180mcu_as_sc_mcu7t3v3__ao22_2
XTAP_TAPCELL_ROW_169_1462 VDD VSS gf180mcu_as_sc_mcu7t3v3__tap_2
X_4073_ VDD VDD VSS VSS _4073_/A _4163_/B _4073_/C _4073_/D _4074_/B gf180mcu_as_sc_mcu7t3v3__ao211_2
XFILLER_3_1113 VDD VDD VSS VSS gf180mcu_as_sc_mcu7t3v3__fill_1
X_3024_ VDD VDD VSS VSS _3031_/B _3047_/B _4009_/A gf180mcu_as_sc_mcu7t3v3__nand2_2
XTAP_TAPCELL_ROW_182_1695 VDD VSS gf180mcu_as_sc_mcu7t3v3__tap_2
X_4975_ VDD VDD VSS VSS _5232_/CLK _4975_/D _4975_/Q gf180mcu_as_sc_mcu7t3v3__dfxtp_2
X_3926_ VDD VDD VSS VSS _3926_/A _4162_/B _4086_/C _3926_/D _3935_/A gf180mcu_as_sc_mcu7t3v3__ao211_2
XFILLER_164_214 VDD VDD VSS VSS gf180mcu_as_sc_mcu7t3v3__fillcap_4
XFILLER_192_501 VDD VDD VSS VSS gf180mcu_as_sc_mcu7t3v3__fill_2
XFILLER_192_512 VDD VDD VSS VSS gf180mcu_as_sc_mcu7t3v3__fill_1
Xclkload7 VDD VDD VSS VSS clkload7/Y clkload7/A gf180mcu_as_sc_mcu7t3v3__inv_2
X_3857_ VDD VDD VSS VSS _5145_/Q _5146_/Q _3857_/C _3858_/D gf180mcu_as_sc_mcu7t3v3__nor3_2
XFILLER_164_247 VDD VDD VSS VSS gf180mcu_as_sc_mcu7t3v3__fillcap_8
X_3788_ VDD VDD VSS VSS _3788_/A _3796_/B _3796_/C _3788_/D _3789_/D gf180mcu_as_sc_mcu7t3v3__ao22_2
X_2808_ VDD VDD VSS VSS _4965_/D _5189_/Q _4643_/B _4660_/A gf180mcu_as_sc_mcu7t3v3__ao21_2
XFILLER_180_718 VDD VDD VSS VSS gf180mcu_as_sc_mcu7t3v3__fillcap_16
XFILLER_192_567 VDD VDD VSS VSS gf180mcu_as_sc_mcu7t3v3__fillcap_4
XFILLER_4_909 VDD VDD VSS VSS gf180mcu_as_sc_mcu7t3v3__fill_2
X_2739_ VDD VDD VSS VSS _4947_/Q _2739_/B _2739_/A _5480_/A gf180mcu_as_sc_mcu7t3v3__mux2_2
XFILLER_132_100 VDD VDD VSS VSS gf180mcu_as_sc_mcu7t3v3__fillcap_4
XFILLER_156_1214 VDD VDD VSS VSS gf180mcu_as_sc_mcu7t3v3__fillcap_8
XFILLER_161_943 VDD VDD VSS VSS gf180mcu_as_sc_mcu7t3v3__fill_1
XFILLER_191_1138 VDD VDD VSS VSS gf180mcu_as_sc_mcu7t3v3__fillcap_8
XTAP_TAPCELL_ROW_189_1838 VDD VSS gf180mcu_as_sc_mcu7t3v3__tap_2
XFILLER_161_998 VDD VDD VSS VSS gf180mcu_as_sc_mcu7t3v3__fillcap_8
XPHY_EDGE_ROW_115_1_Left_307 VDD VSS gf180mcu_as_sc_mcu7t3v3__tap_2
X_4409_ VDD VDD VSS VSS _4409_/B _4524_/A _4416_/C gf180mcu_as_sc_mcu7t3v3__and2_2
XFILLER_75_37 VDD VDD VSS VSS gf180mcu_as_sc_mcu7t3v3__fillcap_8
XFILLER_189_1045 VDD VDD VSS VSS gf180mcu_as_sc_mcu7t3v3__fillcap_4
XFILLER_132_1291 VDD VDD VSS VSS gf180mcu_as_sc_mcu7t3v3__fillcap_8
XFILLER_188_807 VDD VDD VSS VSS gf180mcu_as_sc_mcu7t3v3__fillcap_4
XFILLER_131_98 VDD VDD VSS VSS gf180mcu_as_sc_mcu7t3v3__fillcap_4
XFILLER_163_1218 VDD VDD VSS VSS gf180mcu_as_sc_mcu7t3v3__fillcap_8
XFILLER_187_339 VDD VDD VSS VSS gf180mcu_as_sc_mcu7t3v3__fillcap_8
XFILLER_11_710 VDD VDD VSS VSS gf180mcu_as_sc_mcu7t3v3__fillcap_4
XFILLER_11_776 VDD VDD VSS VSS gf180mcu_as_sc_mcu7t3v3__fill_2
XFILLER_168_597 VDD VDD VSS VSS gf180mcu_as_sc_mcu7t3v3__fillcap_16
Xclkbuf_leaf_8_clk_regs VDD VDD VSS VSS clkbuf_leaf_9_clk_regs/A _5178_/CLK gf180mcu_as_sc_mcu7t3v3__clkbuff_12
XFILLER_156_748 VDD VDD VSS VSS gf180mcu_as_sc_mcu7t3v3__fillcap_4
Xwire645 VDD VDD VSS VSS _3562_/Y wire645/Y gf180mcu_as_sc_mcu7t3v3__clkbuff_12
XFILLER_152_910 VDD VDD VSS VSS gf180mcu_as_sc_mcu7t3v3__fill_1
XFILLER_171_729 VDD VDD VSS VSS gf180mcu_as_sc_mcu7t3v3__fillcap_8
XFILLER_100_1268 VDD VDD VSS VSS gf180mcu_as_sc_mcu7t3v3__fill_2
XFILLER_170_239 VDD VDD VSS VSS gf180mcu_as_sc_mcu7t3v3__fill_2
XFILLER_3_920 VDD VDD VSS VSS gf180mcu_as_sc_mcu7t3v3__fillcap_4
XFILLER_152_954 VDD VDD VSS VSS gf180mcu_as_sc_mcu7t3v3__fillcap_16
XPHY_EDGE_ROW_47_1_Left_239 VDD VSS gf180mcu_as_sc_mcu7t3v3__tap_2
XPHY_EDGE_ROW_48_3_Left_420 VDD VSS gf180mcu_as_sc_mcu7t3v3__tap_2
XFILLER_1_56 VDD VDD VSS VSS gf180mcu_as_sc_mcu7t3v3__fillcap_8
XPHY_EDGE_ROW_100_3_Left_472 VDD VSS gf180mcu_as_sc_mcu7t3v3__tap_2
XFILLER_0_1319 VDD VDD VSS VSS gf180mcu_as_sc_mcu7t3v3__fillcap_4
XTAP_TAPCELL_ROW_164_1370 VDD VSS gf180mcu_as_sc_mcu7t3v3__tap_2
XTAP_TAPCELL_ROW_160_1278 VDD VSS gf180mcu_as_sc_mcu7t3v3__tap_2
XFILLER_178_317 VDD VDD VSS VSS gf180mcu_as_sc_mcu7t3v3__fillcap_4
XTAP_TAPCELL_ROW_160_1289 VDD VSS gf180mcu_as_sc_mcu7t3v3__tap_2
XFILLER_187_862 VDD VDD VSS VSS gf180mcu_as_sc_mcu7t3v3__fillcap_4
X_4760_ VDD VDD VSS VSS _5285_/CLK _4760_/D _4760_/Q gf180mcu_as_sc_mcu7t3v3__dfxtp_2
XFILLER_174_501 VDD VDD VSS VSS gf180mcu_as_sc_mcu7t3v3__fill_2
X_4691_ VDD VDD VSS VSS _4691_/D _4691_/A _4749_/B _4691_/C _4707_/S gf180mcu_as_sc_mcu7t3v3__ao31_2
X_3711_ VDD VDD VSS VSS _4934_/Q _3799_/B _3778_/B _4088_/D _3712_/D gf180mcu_as_sc_mcu7t3v3__ao22_2
X_3642_ VDD VDD VSS VSS _3646_/B _3642_/C _3726_/B _4016_/A gf180mcu_as_sc_mcu7t3v3__aoi21_2
XFILLER_174_589 VDD VDD VSS VSS gf180mcu_as_sc_mcu7t3v3__fillcap_4
XFILLER_60_2 VDD VDD VSS VSS gf180mcu_as_sc_mcu7t3v3__fill_2
XPHY_EDGE_ROW_157_Left_349 VDD VSS gf180mcu_as_sc_mcu7t3v3__tap_2
X_3573_ VDD VDD VSS VSS _3936_/A _3775_/B _3573_/C _3573_/Y _3805_/C gf180mcu_as_sc_mcu7t3v3__aoi211_2
X_2524_ VDD VDD VSS VSS _2771_/A _2806_/D _2847_/A gf180mcu_as_sc_mcu7t3v3__nor2_2
XFILLER_170_784 VDD VDD VSS VSS gf180mcu_as_sc_mcu7t3v3__fill_1
X_5243_ VDD VDD VSS VSS _5285_/CLK _5243_/D _5243_/Q gf180mcu_as_sc_mcu7t3v3__dfxtp_2
X_2455_ VDD VDD VSS VSS _2456_/B _2455_/A gf180mcu_as_sc_mcu7t3v3__inv_2
XFILLER_29_1272 VDD VDD VSS VSS gf180mcu_as_sc_mcu7t3v3__fill_1
X_5174_ VDD VDD VSS VSS clkload9/A _5174_/D _5174_/Q gf180mcu_as_sc_mcu7t3v3__dfxtp_2
X_4125_ VDD VDD VSS VSS _5001_/Q _4158_/B _4252_/B _4158_/D _5001_/D gf180mcu_as_sc_mcu7t3v3__ao22_2
XTAP_TAPCELL_ROW_184_1746 VDD VSS gf180mcu_as_sc_mcu7t3v3__tap_2
XTAP_TAPCELL_ROW_184_1735 VDD VSS gf180mcu_as_sc_mcu7t3v3__tap_2
XFILLER_186_1207 VDD VDD VSS VSS gf180mcu_as_sc_mcu7t3v3__fillcap_16
XFILLER_45_29 VDD VDD VSS VSS gf180mcu_as_sc_mcu7t3v3__fill_2
X_4056_ VDD VDD VSS VSS _4056_/A _4104_/B _4104_/C _4056_/D _4057_/D gf180mcu_as_sc_mcu7t3v3__ao22_2
XPHY_EDGE_ROW_93_1_Left_285 VDD VSS gf180mcu_as_sc_mcu7t3v3__tap_2
XPHY_EDGE_ROW_166_Left_358 VDD VSS gf180mcu_as_sc_mcu7t3v3__tap_2
X_3007_ VDD VDD VSS VSS _3047_/B _3993_/A _3013_/C gf180mcu_as_sc_mcu7t3v3__and2_2
X_4958_ VDD VDD VSS VSS _5265_/CLK _4958_/D _4958_/Q gf180mcu_as_sc_mcu7t3v3__dfxtp_2
XTAP_TAPCELL_ROW_108_3_2019 VDD VSS gf180mcu_as_sc_mcu7t3v3__tap_2
X_4889_ VDD VDD VSS VSS _4895_/CLK _4889_/D _4889_/Q gf180mcu_as_sc_mcu7t3v3__dfxtp_2
X_3909_ VDD VDD VSS VSS _4168_/A _4199_/A _3909_/Y gf180mcu_as_sc_mcu7t3v3__or2_2
XPHY_EDGE_ROW_175_Left_367 VDD VSS gf180mcu_as_sc_mcu7t3v3__tap_2
XFILLER_152_206 VDD VDD VSS VSS gf180mcu_as_sc_mcu7t3v3__fillcap_16
XFILLER_192_397 VDD VDD VSS VSS gf180mcu_as_sc_mcu7t3v3__fillcap_4
XFILLER_156_1011 VDD VDD VSS VSS gf180mcu_as_sc_mcu7t3v3__fillcap_4
XFILLER_120_103 VDD VDD VSS VSS gf180mcu_as_sc_mcu7t3v3__fill_2
Xoutput370 VDD VDD VSS VSS _4772_/Q se_out[1] gf180mcu_as_sc_mcu7t3v3__buff_12
Xoutput392 VDD VDD VSS VSS _4780_/Q se_out[9] gf180mcu_as_sc_mcu7t3v3__buff_12
Xoutput381 VDD VDD VSS VSS _4773_/Q se_out[2] gf180mcu_as_sc_mcu7t3v3__buff_12
XPHY_EDGE_ROW_184_Left_376 VDD VSS gf180mcu_as_sc_mcu7t3v3__tap_2
XFILLER_19_96 VDD VDD VSS VSS gf180mcu_as_sc_mcu7t3v3__fillcap_4
XTAP_TAPCELL_ROW_3_750 VDD VSS gf180mcu_as_sc_mcu7t3v3__tap_2
XFILLER_163_1004 VDD VDD VSS VSS gf180mcu_as_sc_mcu7t3v3__fillcap_16
XFILLER_188_615 VDD VDD VSS VSS gf180mcu_as_sc_mcu7t3v3__fill_1
XFILLER_163_1048 VDD VDD VSS VSS gf180mcu_as_sc_mcu7t3v3__fill_2
XFILLER_168_383 VDD VDD VSS VSS gf180mcu_as_sc_mcu7t3v3__fill_2
XFILLER_51_72 VDD VDD VSS VSS gf180mcu_as_sc_mcu7t3v3__fillcap_4
XFILLER_156_556 VDD VDD VSS VSS gf180mcu_as_sc_mcu7t3v3__fillcap_8
XFILLER_167_72 VDD VDD VSS VSS gf180mcu_as_sc_mcu7t3v3__fillcap_16
Xwire464 VDD VDD VSS VSS _3631_/Y _4847_/D gf180mcu_as_sc_mcu7t3v3__clkbuff_12
Xwire486 VDD VDD VSS VSS _3006_/Y _4777_/D gf180mcu_as_sc_mcu7t3v3__clkbuff_12
XFILLER_171_559 VDD VDD VSS VSS gf180mcu_as_sc_mcu7t3v3__fill_1
XFILLER_174_1111 VDD VDD VSS VSS gf180mcu_as_sc_mcu7t3v3__fillcap_4
XFILLER_152_784 VDD VDD VSS VSS gf180mcu_as_sc_mcu7t3v3__fillcap_4
XFILLER_3_783 VDD VDD VSS VSS gf180mcu_as_sc_mcu7t3v3__fillcap_16
XTAP_TAPCELL_ROW_1_709 VDD VSS gf180mcu_as_sc_mcu7t3v3__tap_2
XTAP_TAPCELL_ROW_162_1329 VDD VSS gf180mcu_as_sc_mcu7t3v3__tap_2
XTAP_TAPCELL_ROW_162_1318 VDD VSS gf180mcu_as_sc_mcu7t3v3__tap_2
XFILLER_4_1285 VDD VDD VSS VSS gf180mcu_as_sc_mcu7t3v3__fill_2
XFILLER_0_1149 VDD VDD VSS VSS gf180mcu_as_sc_mcu7t3v3__fillcap_4
XFILLER_185_1262 VDD VDD VSS VSS gf180mcu_as_sc_mcu7t3v3__fill_2
XFILLER_178_103 VDD VDD VSS VSS gf180mcu_as_sc_mcu7t3v3__fill_2
X_4812_ VDD VDD VSS VSS clkload7/A _4812_/D _4812_/Q gf180mcu_as_sc_mcu7t3v3__dfxtp_2
X_4743_ VDD VDD VSS VSS _4747_/D _5272_/Q _5273_/D gf180mcu_as_sc_mcu7t3v3__and2_2
XFILLER_174_342 VDD VDD VSS VSS gf180mcu_as_sc_mcu7t3v3__fillcap_16
X_4674_ VDD VDD VSS VSS _5244_/D _5244_/Q _4674_/B _4674_/C gf180mcu_as_sc_mcu7t3v3__ao21_2
X_3625_ VDD VDD VSS VSS _4923_/Q _3799_/B _3748_/C _3999_/A _3627_/C gf180mcu_as_sc_mcu7t3v3__ao22_2
XFILLER_192_1211 VDD VDD VSS VSS gf180mcu_as_sc_mcu7t3v3__fill_2
X_3556_ VDD VDD VSS VSS _3556_/Y _3559_/C _3557_/B gf180mcu_as_sc_mcu7t3v3__nor2_2
X_2507_ VDD VDD VSS VSS _5269_/Q _5270_/Q _4739_/A _4741_/B gf180mcu_as_sc_mcu7t3v3__nand3_2
X_5226_ VDD VDD VSS VSS _5226_/CLK _5226_/D _5226_/Q gf180mcu_as_sc_mcu7t3v3__dfxtp_2
Xinput109 VDD VDD VSS VSS ne_in[7] wire907/A gf180mcu_as_sc_mcu7t3v3__buff_12
X_3487_ VDD VDD VSS VSS _4143_/D _3494_/C _3487_/C _3487_/D _3488_/C gf180mcu_as_sc_mcu7t3v3__ao211_2
X_2438_ VDD VDD VSS VSS _4067_/A _2438_/A gf180mcu_as_sc_mcu7t3v3__inv_2
XFILLER_9_1185 VDD VDD VSS VSS gf180mcu_as_sc_mcu7t3v3__fillcap_4
X_5157_ VDD VDD VSS VSS _5181_/CLK _5157_/D _5157_/Q gf180mcu_as_sc_mcu7t3v3__dfxtp_2
XFILLER_5_1049 VDD VDD VSS VSS gf180mcu_as_sc_mcu7t3v3__fill_1
X_5088_ VDD VDD VSS VSS _5175_/CLK _5088_/D _5088_/Q gf180mcu_as_sc_mcu7t3v3__dfxtp_2
X_4108_ VDD VDD VSS VSS _4999_/Q _4158_/B _4250_/B _4158_/D _4999_/D gf180mcu_as_sc_mcu7t3v3__ao22_2
XFILLER_186_1048 VDD VDD VSS VSS gf180mcu_as_sc_mcu7t3v3__fill_1
XFILLER_42_1291 VDD VDD VSS VSS gf180mcu_as_sc_mcu7t3v3__fillcap_8
X_4039_ VDD VDD VSS VSS _4039_/A _4102_/B _4102_/C _4928_/Q _4041_/C gf180mcu_as_sc_mcu7t3v3__ao22_2
XFILLER_38_1327 VDD VDD VSS VSS gf180mcu_as_sc_mcu7t3v3__fill_2
XFILLER_166_821 VDD VDD VSS VSS gf180mcu_as_sc_mcu7t3v3__fill_2
XFILLER_153_515 VDD VDD VSS VSS gf180mcu_as_sc_mcu7t3v3__fillcap_8
XFILLER_158_1117 VDD VDD VSS VSS gf180mcu_as_sc_mcu7t3v3__fill_1
XFILLER_165_375 VDD VDD VSS VSS gf180mcu_as_sc_mcu7t3v3__fill_1
XFILLER_192_172 VDD VDD VSS VSS gf180mcu_as_sc_mcu7t3v3__fillcap_4
XFILLER_153_559 VDD VDD VSS VSS gf180mcu_as_sc_mcu7t3v3__fill_1
XFILLER_84_1303 VDD VDD VSS VSS gf180mcu_as_sc_mcu7t3v3__fill_2
XTAP_TAPCELL_ROW_8_842 VDD VSS gf180mcu_as_sc_mcu7t3v3__tap_2
XFILLER_0_797 VDD VDD VSS VSS gf180mcu_as_sc_mcu7t3v3__fill_2
XTAP_TAPCELL_ROW_120_1_1073 VDD VSS gf180mcu_as_sc_mcu7t3v3__tap_2
X_4834__1099 VDD VDD VSS VSS _4834_/D gf180mcu_as_sc_mcu7t3v3__tiel_4
XFILLER_176_618 VDD VDD VSS VSS gf180mcu_as_sc_mcu7t3v3__fillcap_4
XFILLER_180_1181 VDD VDD VSS VSS gf180mcu_as_sc_mcu7t3v3__fill_2
XFILLER_176_1206 VDD VDD VSS VSS gf180mcu_as_sc_mcu7t3v3__fillcap_16
XFILLER_184_673 VDD VDD VSS VSS gf180mcu_as_sc_mcu7t3v3__fill_1
XTAP_TAPCELL_ROW_155_1188 VDD VSS gf180mcu_as_sc_mcu7t3v3__tap_2
X_4390_ VDD VDD VSS VSS _4394_/B _5066_/Q _4559_/S gf180mcu_as_sc_mcu7t3v3__nand2_2
X_3410_ VDD VDD VSS VSS _4062_/A _3449_/B _3410_/C _3450_/B _3412_/C gf180mcu_as_sc_mcu7t3v3__ao211_2
XTAP_TAPCELL_ROW_155_1199 VDD VSS gf180mcu_as_sc_mcu7t3v3__tap_2
X_3341_ VDD VDD VSS VSS _3992_/A _3374_/B _3374_/C _3993_/A _3342_/B gf180mcu_as_sc_mcu7t3v3__ao22_2
X_3272_ VDD VDD VSS VSS _3272_/Y _3517_/D _3518_/C gf180mcu_as_sc_mcu7t3v3__nor2_2
X_5011_ VDD VDD VSS VSS clkload8/A _5011_/D _5011_/Q gf180mcu_as_sc_mcu7t3v3__dfxtp_2
XFILLER_113_1256 VDD VDD VSS VSS gf180mcu_as_sc_mcu7t3v3__fillcap_8
XFILLER_152_1294 VDD VDD VSS VSS gf180mcu_as_sc_mcu7t3v3__fillcap_8
XFILLER_113_1289 VDD VDD VSS VSS gf180mcu_as_sc_mcu7t3v3__fillcap_8
XFILLER_148_1308 VDD VDD VSS VSS gf180mcu_as_sc_mcu7t3v3__fillcap_8
XTAP_TAPCELL_ROW_179_1645 VDD VSS gf180mcu_as_sc_mcu7t3v3__tap_2
XTAP_TAPCELL_ROW_179_1656 VDD VSS gf180mcu_as_sc_mcu7t3v3__tap_2
XPHY_EDGE_ROW_124_1_Left_316 VDD VSS gf180mcu_as_sc_mcu7t3v3__tap_2
X_2987_ VDD VDD VSS VSS _3966_/A _3125_/B _2987_/C _2987_/D _2988_/C gf180mcu_as_sc_mcu7t3v3__ao22_2
X_4726_ VDD VDD VSS VSS _5265_/Q _4730_/B _4730_/C _5264_/Q _4727_/C gf180mcu_as_sc_mcu7t3v3__ao22_2
XFILLER_174_172 VDD VDD VSS VSS gf180mcu_as_sc_mcu7t3v3__fill_2
XFILLER_175_695 VDD VDD VSS VSS gf180mcu_as_sc_mcu7t3v3__fillcap_4
X_4657_ VDD VDD VSS VSS _4658_/B _4657_/B _5229_/Q gf180mcu_as_sc_mcu7t3v3__nand2b_2
XTAP_TAPCELL_ROW_192_1889 VDD VSS gf180mcu_as_sc_mcu7t3v3__tap_2
Xinput80 VDD VDD VSS VSS ne_in[11] wire852/A gf180mcu_as_sc_mcu7t3v3__buff_12
Xinput91 VDD VDD VSS VSS ne_in[21] _4104_/D gf180mcu_as_sc_mcu7t3v3__buff_12
X_3608_ VDD VDD VSS VSS _3608_/A _3652_/D _3608_/C _3608_/Y _3638_/D gf180mcu_as_sc_mcu7t3v3__aoi211_2
X_4588_ VDD VDD VSS VSS _4588_/D _4588_/A _4588_/B _4588_/C _4589_/B gf180mcu_as_sc_mcu7t3v3__ao31_2
Xmax_cap583 VDD VDD VSS VSS _3148_/A _3141_/B gf180mcu_as_sc_mcu7t3v3__clkbuff_12
X_3539_ VDD VDD VSS VSS _3539_/B _4946_/Q _3914_/B gf180mcu_as_sc_mcu7t3v3__and2_2
Xclkbuf_leaf_22_clk_regs VDD VDD VSS VSS clkload0/A _5226_/CLK gf180mcu_as_sc_mcu7t3v3__clkbuff_12
XFILLER_190_28 VDD VDD VSS VSS gf180mcu_as_sc_mcu7t3v3__fillcap_4
X_5209_ VDD VDD VSS VSS _5212_/CLK _5209_/D _5209_/Q gf180mcu_as_sc_mcu7t3v3__dfxtp_2
XFILLER_184_6 VDD VDD VSS VSS gf180mcu_as_sc_mcu7t3v3__fillcap_16
XFILLER_123_99 VDD VDD VSS VSS gf180mcu_as_sc_mcu7t3v3__fillcap_4
XFILLER_164_1154 VDD VDD VSS VSS gf180mcu_as_sc_mcu7t3v3__fill_1
XFILLER_16_64 VDD VDD VSS VSS gf180mcu_as_sc_mcu7t3v3__fill_1
XPHY_EDGE_ROW_56_1_Left_248 VDD VSS gf180mcu_as_sc_mcu7t3v3__tap_2
XFILLER_12_123 VDD VDD VSS VSS gf180mcu_as_sc_mcu7t3v3__fillcap_16
XFILLER_157_139 VDD VDD VSS VSS gf180mcu_as_sc_mcu7t3v3__fill_1
XFILLER_9_639 VDD VDD VSS VSS gf180mcu_as_sc_mcu7t3v3__fillcap_16
XFILLER_166_640 VDD VDD VSS VSS gf180mcu_as_sc_mcu7t3v3__fill_2
XFILLER_165_150 VDD VDD VSS VSS gf180mcu_as_sc_mcu7t3v3__fillcap_4
XFILLER_10_1032 VDD VDD VSS VSS gf180mcu_as_sc_mcu7t3v3__fillcap_4
XFILLER_181_632 VDD VDD VSS VSS gf180mcu_as_sc_mcu7t3v3__fill_1
XFILLER_10_1065 VDD VDD VSS VSS gf180mcu_as_sc_mcu7t3v3__fillcap_4
XFILLER_5_878 VDD VDD VSS VSS gf180mcu_as_sc_mcu7t3v3__fill_2
XFILLER_88_1280 VDD VDD VSS VSS gf180mcu_as_sc_mcu7t3v3__fillcap_8
XFILLER_175_1283 VDD VDD VSS VSS gf180mcu_as_sc_mcu7t3v3__fill_1
XFILLER_136_1256 VDD VDD VSS VSS gf180mcu_as_sc_mcu7t3v3__fillcap_16
XFILLER_0_550 VDD VDD VSS VSS gf180mcu_as_sc_mcu7t3v3__fill_2
XFILLER_171_1158 VDD VDD VSS VSS gf180mcu_as_sc_mcu7t3v3__fillcap_4
XFILLER_169_1021 VDD VDD VSS VSS gf180mcu_as_sc_mcu7t3v3__fillcap_4
XFILLER_1_1200 VDD VDD VSS VSS gf180mcu_as_sc_mcu7t3v3__fill_2
XFILLER_1_1277 VDD VDD VSS VSS gf180mcu_as_sc_mcu7t3v3__fill_1
XFILLER_108_1303 VDD VDD VSS VSS gf180mcu_as_sc_mcu7t3v3__fill_1
X_2910_ VDD VDD VSS VSS _3818_/D _3253_/A _3254_/A gf180mcu_as_sc_mcu7t3v3__nor2_2
XFILLER_189_798 VDD VDD VSS VSS gf180mcu_as_sc_mcu7t3v3__fillcap_4
X_3890_ VDD VDD VSS VSS _3908_/B _5180_/Q _4930_/D gf180mcu_as_sc_mcu7t3v3__and2_2
X_2841_ VDD VDD VSS VSS _2841_/B _2841_/A _2842_/C gf180mcu_as_sc_mcu7t3v3__xnor2_2
XTAP_TAPCELL_ROW_157_1228 VDD VSS gf180mcu_as_sc_mcu7t3v3__tap_2
XFILLER_176_459 VDD VDD VSS VSS gf180mcu_as_sc_mcu7t3v3__fill_1
X_2772_ VDD VDD VSS VSS _2773_/B _2776_/A _5230_/Q gf180mcu_as_sc_mcu7t3v3__nand2_2
XFILLER_185_982 VDD VDD VSS VSS gf180mcu_as_sc_mcu7t3v3__fillcap_8
X_4511_ VDD VDD VSS VSS _4511_/D _4572_/A _4511_/B _4511_/C _4512_/B gf180mcu_as_sc_mcu7t3v3__ao31_2
XTAP_TAPCELL_ROW_174_1553 VDD VSS gf180mcu_as_sc_mcu7t3v3__tap_2
X_4442_ VDD VDD VSS VSS _5171_/Q _4574_/B _4442_/C _4442_/D _5171_/D gf180mcu_as_sc_mcu7t3v3__ao211_2
XTAP_TAPCELL_ROW_10_880 VDD VSS gf180mcu_as_sc_mcu7t3v3__tap_2
XFILLER_171_142 VDD VDD VSS VSS gf180mcu_as_sc_mcu7t3v3__fillcap_8
X_4373_ VDD VDD VSS VSS _5483_/A _4590_/C _4373_/C _4377_/B _4374_/B gf180mcu_as_sc_mcu7t3v3__ao22_2
Xfanout607 VDD VDD VSS VSS _3125_/B _3042_/B gf180mcu_as_sc_mcu7t3v3__buff_12
Xfanout618 VDD VDD VSS VSS _2852_/Y _4377_/B gf180mcu_as_sc_mcu7t3v3__buff_12
X_3324_ VDD VDD VSS VSS _3373_/S _3976_/D _3324_/A _3326_/B gf180mcu_as_sc_mcu7t3v3__mux2_2
XFILLER_115_1318 VDD VDD VSS VSS gf180mcu_as_sc_mcu7t3v3__fillcap_4
X_3255_ VDD VDD VSS VSS _3787_/A _3255_/B _3255_/C _3517_/D gf180mcu_as_sc_mcu7t3v3__nand3_2
XTAP_TAPCELL_ROW_74_3_1985 VDD VSS gf180mcu_as_sc_mcu7t3v3__tap_2
XFILLER_152_1080 VDD VDD VSS VSS gf180mcu_as_sc_mcu7t3v3__fill_1
X_3186_ VDD VDD VSS VSS _3186_/D _4159_/D _3236_/B _3236_/C _3188_/B gf180mcu_as_sc_mcu7t3v3__ao31_2
XFILLER_187_1132 VDD VDD VSS VSS gf180mcu_as_sc_mcu7t3v3__fillcap_16
XFILLER_168_916 VDD VDD VSS VSS gf180mcu_as_sc_mcu7t3v3__fillcap_16
XFILLER_179_297 VDD VDD VSS VSS gf180mcu_as_sc_mcu7t3v3__fill_1
XFILLER_6_609 VDD VDD VSS VSS gf180mcu_as_sc_mcu7t3v3__fill_2
X_4709_ VDD VDD VSS VSS _4717_/S _5257_/Q _5258_/Q _4710_/B gf180mcu_as_sc_mcu7t3v3__mux2_2
XFILLER_2_804 VDD VDD VSS VSS gf180mcu_as_sc_mcu7t3v3__fill_1
XFILLER_190_484 VDD VDD VSS VSS gf180mcu_as_sc_mcu7t3v3__fillcap_8
XFILLER_78_37 VDD VDD VSS VSS gf180mcu_as_sc_mcu7t3v3__fillcap_4
XFILLER_1_347 VDD VDD VSS VSS gf180mcu_as_sc_mcu7t3v3__fill_2
Xmesh_tile_1017 VDD VDD VSS VSS nw_out[23] gf180mcu_as_sc_mcu7t3v3__tiel_4
Xmesh_tile_1006 VDD VDD VSS VSS nw_out[12] gf180mcu_as_sc_mcu7t3v3__tiel_4
XFILLER_94_58 VDD VDD VSS VSS gf180mcu_as_sc_mcu7t3v3__fillcap_8
Xmesh_tile_1039 VDD VDD VSS VSS sw_out[11] gf180mcu_as_sc_mcu7t3v3__tiel_4
Xmesh_tile_1028 VDD VDD VSS VSS sw_out[0] gf180mcu_as_sc_mcu7t3v3__tiel_4
XFILLER_175_2 VDD VDD VSS VSS gf180mcu_as_sc_mcu7t3v3__fillcap_16
XFILLER_27_52 VDD VDD VSS VSS gf180mcu_as_sc_mcu7t3v3__fillcap_4
XFILLER_166_1227 VDD VDD VSS VSS gf180mcu_as_sc_mcu7t3v3__fillcap_4
XFILLER_27_85 VDD VDD VSS VSS gf180mcu_as_sc_mcu7t3v3__fill_1
XFILLER_13_410 VDD VDD VSS VSS gf180mcu_as_sc_mcu7t3v3__fillcap_16
XFILLER_158_437 VDD VDD VSS VSS gf180mcu_as_sc_mcu7t3v3__fill_1
XFILLER_185_212 VDD VDD VSS VSS gf180mcu_as_sc_mcu7t3v3__fillcap_16
XFILLER_167_982 VDD VDD VSS VSS gf180mcu_as_sc_mcu7t3v3__fillcap_16
XFILLER_153_120 VDD VDD VSS VSS gf180mcu_as_sc_mcu7t3v3__fillcap_8
XTAP_TAPCELL_ROW_152_1125 VDD VSS gf180mcu_as_sc_mcu7t3v3__tap_2
XTAP_TAPCELL_ROW_152_1114 VDD VSS gf180mcu_as_sc_mcu7t3v3__tap_2
XFILLER_138_1307 VDD VDD VSS VSS gf180mcu_as_sc_mcu7t3v3__fillcap_16
XFILLER_153_142 VDD VDD VSS VSS gf180mcu_as_sc_mcu7t3v3__fill_1
XFILLER_182_996 VDD VDD VSS VSS gf180mcu_as_sc_mcu7t3v3__fill_1
XTAP_TAPCELL_ROW_152_1136 VDD VSS gf180mcu_as_sc_mcu7t3v3__tap_2
XFILLER_138_1329 VDD VDD VSS VSS gf180mcu_as_sc_mcu7t3v3__fill_1
XFILLER_153_197 VDD VDD VSS VSS gf180mcu_as_sc_mcu7t3v3__fill_2
XFILLER_175_72 VDD VDD VSS VSS gf180mcu_as_sc_mcu7t3v3__fillcap_8
XFILLER_5_697 VDD VDD VSS VSS gf180mcu_as_sc_mcu7t3v3__fill_2
XFILLER_23_1256 VDD VDD VSS VSS gf180mcu_as_sc_mcu7t3v3__fillcap_8
XFILLER_3_1328 VDD VDD VSS VSS gf180mcu_as_sc_mcu7t3v3__fill_2
Xinput270 VDD VDD VSS VSS sw_in[29] _3794_/A gf180mcu_as_sc_mcu7t3v3__buff_12
Xinput281 VDD VDD VSS VSS sw_in[8] _2430_/A gf180mcu_as_sc_mcu7t3v3__buff_12
X_3040_ VDD VDD VSS VSS _3615_/D _3097_/A _3040_/B _3040_/C _3041_/C gf180mcu_as_sc_mcu7t3v3__ao31_2
Xinput292 VDD VDD VSS VSS west_in[18] _4077_/D gf180mcu_as_sc_mcu7t3v3__buff_12
XFILLER_84_91 VDD VDD VSS VSS gf180mcu_as_sc_mcu7t3v3__fillcap_4
X_4991_ VDD VDD VSS VSS _5095_/CLK _4991_/D _4991_/Q gf180mcu_as_sc_mcu7t3v3__dfxtp_2
XFILLER_189_562 VDD VDD VSS VSS gf180mcu_as_sc_mcu7t3v3__fillcap_8
X_3942_ VDD VDD VSS VSS _3942_/A _4024_/B _3942_/C _3942_/D _3943_/C gf180mcu_as_sc_mcu7t3v3__ao211_2
XFILLER_177_735 VDD VDD VSS VSS gf180mcu_as_sc_mcu7t3v3__fill_1
XFILLER_182_1084 VDD VDD VSS VSS gf180mcu_as_sc_mcu7t3v3__fill_1
XFILLER_90_2 VDD VDD VSS VSS gf180mcu_as_sc_mcu7t3v3__fill_2
X_3873_ VDD VDD VSS VSS _3873_/A _3873_/B _3873_/C _3874_/B gf180mcu_as_sc_mcu7t3v3__nor3_2
X_2824_ VDD VDD VSS VSS _4974_/D _2830_/B _4761_/Q _4760_/D gf180mcu_as_sc_mcu7t3v3__mux2_2
XFILLER_176_267 VDD VDD VSS VSS gf180mcu_as_sc_mcu7t3v3__fillcap_8
X_2755_ VDD VDD VSS VSS _2780_/B _3871_/A _2765_/C gf180mcu_as_sc_mcu7t3v3__and2_2
X_2686_ VDD VDD VSS VSS _2723_/A _2686_/B _2686_/C _2686_/D _2686_/Y gf180mcu_as_sc_mcu7t3v3__ao22_2
X_4425_ VDD VDD VSS VSS _5171_/Q _4493_/B _4523_/C _5121_/Q _4426_/B gf180mcu_as_sc_mcu7t3v3__ao22_2
X_4356_ VDD VDD VSS VSS _4356_/B _4375_/B _4357_/D gf180mcu_as_sc_mcu7t3v3__and2_2
X_3307_ VDD VDD VSS VSS _3308_/A _3956_/D _3372_/B _3307_/C gf180mcu_as_sc_mcu7t3v3__ao21_2
X_4287_ VDD VDD VSS VSS _4289_/S _5483_/A _5121_/Q _5121_/D gf180mcu_as_sc_mcu7t3v3__mux2_2
XTAP_TAPCELL_ROW_187_1799 VDD VSS gf180mcu_as_sc_mcu7t3v3__tap_2
X_3238_ VDD VDD VSS VSS _3240_/C _3238_/C _3238_/B _3238_/A gf180mcu_as_sc_mcu7t3v3__aoi21_2
XTAP_TAPCELL_ROW_22_3_1933 VDD VSS gf180mcu_as_sc_mcu7t3v3__tap_2
X_3169_ VDD VDD VSS VSS _4144_/A _3177_/B _3177_/C _4143_/D _3170_/C gf180mcu_as_sc_mcu7t3v3__ao22_2
XFILLER_161_1102 VDD VDD VSS VSS gf180mcu_as_sc_mcu7t3v3__fillcap_16
XFILLER_147_6 VDD VDD VSS VSS gf180mcu_as_sc_mcu7t3v3__fillcap_4
XFILLER_167_212 VDD VDD VSS VSS gf180mcu_as_sc_mcu7t3v3__fill_1
XFILLER_126_1288 VDD VDD VSS VSS gf180mcu_as_sc_mcu7t3v3__fill_1
XFILLER_7_907 VDD VDD VSS VSS gf180mcu_as_sc_mcu7t3v3__fill_2
XFILLER_10_457 VDD VDD VSS VSS gf180mcu_as_sc_mcu7t3v3__fill_2
XFILLER_167_267 VDD VDD VSS VSS gf180mcu_as_sc_mcu7t3v3__fillcap_4
XFILLER_183_738 VDD VDD VSS VSS gf180mcu_as_sc_mcu7t3v3__fill_1
XFILLER_129_54 VDD VDD VSS VSS gf180mcu_as_sc_mcu7t3v3__fillcap_4
XFILLER_129_76 VDD VDD VSS VSS gf180mcu_as_sc_mcu7t3v3__fill_1
XFILLER_164_963 VDD VDD VSS VSS gf180mcu_as_sc_mcu7t3v3__fill_1
XFILLER_182_259 VDD VDD VSS VSS gf180mcu_as_sc_mcu7t3v3__fillcap_8
XFILLER_159_1064 VDD VDD VSS VSS gf180mcu_as_sc_mcu7t3v3__fillcap_16
XFILLER_89_69 VDD VDD VSS VSS gf180mcu_as_sc_mcu7t3v3__fill_1
XFILLER_2_667 VDD VDD VSS VSS gf180mcu_as_sc_mcu7t3v3__fill_1
XFILLER_172_1253 VDD VDD VSS VSS gf180mcu_as_sc_mcu7t3v3__fillcap_16
XFILLER_46_1256 VDD VDD VSS VSS gf180mcu_as_sc_mcu7t3v3__fillcap_16
XFILLER_172_1297 VDD VDD VSS VSS gf180mcu_as_sc_mcu7t3v3__fillcap_4
XFILLER_159_702 VDD VDD VSS VSS gf180mcu_as_sc_mcu7t3v3__fillcap_4
XFILLER_166_1057 VDD VDD VSS VSS gf180mcu_as_sc_mcu7t3v3__fill_1
XFILLER_13_240 VDD VDD VSS VSS gf180mcu_as_sc_mcu7t3v3__fillcap_16
XFILLER_186_521 VDD VDD VSS VSS gf180mcu_as_sc_mcu7t3v3__fillcap_4
XTAP_TAPCELL_ROW_126_3_2037 VDD VSS gf180mcu_as_sc_mcu7t3v3__tap_2
XFILLER_186_543 VDD VDD VSS VSS gf180mcu_as_sc_mcu7t3v3__fillcap_4
XTAP_TAPCELL_ROW_12_920 VDD VSS gf180mcu_as_sc_mcu7t3v3__tap_2
Xclkload14 VDD VDD VSS VSS _5164_/CLK clkload14/Y gf180mcu_as_sc_mcu7t3v3__clkbuff_4
Xclkload25 VDD VDD VSS VSS _5265_/CLK clkload25/Y gf180mcu_as_sc_mcu7t3v3__clkbuff_12
XTAP_TAPCELL_ROW_171_1501 VDD VSS gf180mcu_as_sc_mcu7t3v3__tap_2
X_2540_ VDD VDD VSS VSS _2541_/C _4371_/B _4372_/D _2792_/A gf180mcu_as_sc_mcu7t3v3__aoi21_2
XFILLER_170_944 VDD VDD VSS VSS gf180mcu_as_sc_mcu7t3v3__fill_1
XFILLER_6_984 VDD VDD VSS VSS gf180mcu_as_sc_mcu7t3v3__fill_1
X_2471_ VDD VDD VSS VSS _2472_/B _2471_/A gf180mcu_as_sc_mcu7t3v3__inv_2
X_4210_ VDD VDD VSS VSS _4239_/B _4228_/B _4228_/C _5046_/Q _5046_/D gf180mcu_as_sc_mcu7t3v3__ao22_2
X_5190_ VDD VDD VSS VSS _5220_/CLK _5190_/D _5190_/Q gf180mcu_as_sc_mcu7t3v3__dfxtp_2
XFILLER_151_1326 VDD VDD VSS VSS gf180mcu_as_sc_mcu7t3v3__fillcap_4
X_4141_ VDD VDD VSS VSS _4141_/A _4141_/B _4141_/C _4254_/B _4141_/D gf180mcu_as_sc_mcu7t3v3__aoi211_2
XTAP_TAPCELL_ROW_169_1463 VDD VSS gf180mcu_as_sc_mcu7t3v3__tap_2
XTAP_TAPCELL_ROW_169_1452 VDD VSS gf180mcu_as_sc_mcu7t3v3__tap_2
X_4072_ VDD VDD VSS VSS _4072_/A _4159_/B _4159_/C _4072_/D _4073_/D gf180mcu_as_sc_mcu7t3v3__ao22_2
XPHY_EDGE_ROW_133_1_Left_325 VDD VSS gf180mcu_as_sc_mcu7t3v3__tap_2
X_3023_ VDD VDD VSS VSS _4003_/A _3141_/B _3023_/C _3023_/Y _3805_/C gf180mcu_as_sc_mcu7t3v3__aoi211_2
XTAP_TAPCELL_ROW_182_1696 VDD VSS gf180mcu_as_sc_mcu7t3v3__tap_2
XTAP_TAPCELL_ROW_69_3_1980 VDD VSS gf180mcu_as_sc_mcu7t3v3__tap_2
XFILLER_149_1288 VDD VDD VSS VSS gf180mcu_as_sc_mcu7t3v3__fill_2
XFILLER_184_1157 VDD VDD VSS VSS gf180mcu_as_sc_mcu7t3v3__fillcap_16
X_4974_ VDD VDD VSS VSS _5188_/CLK _4974_/D _4974_/Q gf180mcu_as_sc_mcu7t3v3__dfxtp_2
X_3925_ VDD VDD VSS VSS _3925_/A _4160_/B _4161_/B _3925_/D _3926_/D gf180mcu_as_sc_mcu7t3v3__ao22_2
Xclkload8 VDD VDD VSS VSS clkload8/A clkload8/Y gf180mcu_as_sc_mcu7t3v3__clkbuff_4
X_3856_ VDD VDD VSS VSS _5144_/Q _5143_/Q _3857_/C gf180mcu_as_sc_mcu7t3v3__or2_2
XFILLER_192_546 VDD VDD VSS VSS gf180mcu_as_sc_mcu7t3v3__fillcap_4
XFILLER_192_557 VDD VDD VSS VSS gf180mcu_as_sc_mcu7t3v3__fillcap_4
X_3787_ VDD VDD VSS VSS _3818_/D _3787_/A _3796_/C gf180mcu_as_sc_mcu7t3v3__and2_2
X_2807_ VDD VDD VSS VSS _4660_/A _4259_/C _4643_/B gf180mcu_as_sc_mcu7t3v3__nor2_2
X_2738_ VDD VDD VSS VSS _4947_/Q _2738_/B _2738_/A _5479_/A gf180mcu_as_sc_mcu7t3v3__mux2_2
XFILLER_69_1256 VDD VDD VSS VSS gf180mcu_as_sc_mcu7t3v3__fillcap_8
XFILLER_160_432 VDD VDD VSS VSS gf180mcu_as_sc_mcu7t3v3__fillcap_8
XFILLER_160_454 VDD VDD VSS VSS gf180mcu_as_sc_mcu7t3v3__fill_1
XFILLER_182_18 VDD VDD VSS VSS gf180mcu_as_sc_mcu7t3v3__fillcap_16
XFILLER_191_1117 VDD VDD VSS VSS gf180mcu_as_sc_mcu7t3v3__fill_2
X_4408_ VDD VDD VSS VSS _5169_/Q _4493_/B _4540_/C _5119_/Q _4409_/B gf180mcu_as_sc_mcu7t3v3__ao22_2
X_2669_ VDD VDD VSS VSS _2673_/B _5133_/Q _2670_/D gf180mcu_as_sc_mcu7t3v3__and2_2
XTAP_TAPCELL_ROW_189_1839 VDD VSS gf180mcu_as_sc_mcu7t3v3__tap_2
XTAP_TAPCELL_ROW_189_1828 VDD VSS gf180mcu_as_sc_mcu7t3v3__tap_2
XFILLER_8_1025 VDD VDD VSS VSS gf180mcu_as_sc_mcu7t3v3__fill_2
XFILLER_8_1058 VDD VDD VSS VSS gf180mcu_as_sc_mcu7t3v3__fill_2
X_4339_ VDD VDD VSS VSS _4350_/C _4339_/B _4350_/A gf180mcu_as_sc_mcu7t3v3__nor2_2
XPHY_EDGE_ROW_65_1_Left_257 VDD VSS gf180mcu_as_sc_mcu7t3v3__tap_2
XFILLER_132_1270 VDD VDD VSS VSS gf180mcu_as_sc_mcu7t3v3__fill_2
XFILLER_138_2 VDD VDD VSS VSS gf180mcu_as_sc_mcu7t3v3__fillcap_8
XFILLER_13_1211 VDD VDD VSS VSS gf180mcu_as_sc_mcu7t3v3__fill_1
XFILLER_155_204 VDD VDD VSS VSS gf180mcu_as_sc_mcu7t3v3__fillcap_4
XFILLER_156_716 VDD VDD VSS VSS gf180mcu_as_sc_mcu7t3v3__fillcap_16
XFILLER_168_576 VDD VDD VSS VSS gf180mcu_as_sc_mcu7t3v3__fillcap_16
XFILLER_10_254 VDD VDD VSS VSS gf180mcu_as_sc_mcu7t3v3__fillcap_16
XFILLER_11_788 VDD VDD VSS VSS gf180mcu_as_sc_mcu7t3v3__fillcap_16
XFILLER_7_726 VDD VDD VSS VSS gf180mcu_as_sc_mcu7t3v3__fill_2
XFILLER_10_298 VDD VDD VSS VSS gf180mcu_as_sc_mcu7t3v3__fill_1
XFILLER_40_41 VDD VDD VSS VSS gf180mcu_as_sc_mcu7t3v3__fill_2
XFILLER_6_247 VDD VDD VSS VSS gf180mcu_as_sc_mcu7t3v3__fillcap_4
Xwire668 VDD VDD VSS VSS _3058_/C _3125_/C gf180mcu_as_sc_mcu7t3v3__clkbuff_12
XFILLER_152_944 VDD VDD VSS VSS gf180mcu_as_sc_mcu7t3v3__fill_1
XFILLER_164_782 VDD VDD VSS VSS gf180mcu_as_sc_mcu7t3v3__fillcap_8
XFILLER_152_988 VDD VDD VSS VSS gf180mcu_as_sc_mcu7t3v3__fillcap_16
Xload_slew629 VDD VDD VSS VSS _3924_/Y fanout628/A gf180mcu_as_sc_mcu7t3v3__clkbuff_12
XFILLER_49_72 VDD VDD VSS VSS gf180mcu_as_sc_mcu7t3v3__fillcap_8
Xfanout790 VDD VDD VSS VSS _4167_/Y _4189_/B gf180mcu_as_sc_mcu7t3v3__buff_12
XFILLER_1_68 VDD VDD VSS VSS gf180mcu_as_sc_mcu7t3v3__fill_2
XTAP_TAPCELL_ROW_164_1371 VDD VSS gf180mcu_as_sc_mcu7t3v3__tap_2
XTAP_TAPCELL_ROW_164_1360 VDD VSS gf180mcu_as_sc_mcu7t3v3__tap_2
XFILLER_179_819 VDD VDD VSS VSS gf180mcu_as_sc_mcu7t3v3__fill_2
XTAP_TAPCELL_ROW_160_1279 VDD VSS gf180mcu_as_sc_mcu7t3v3__tap_2
XFILLER_109_1272 VDD VDD VSS VSS gf180mcu_as_sc_mcu7t3v3__fillcap_16
X_3710_ VDD VDD VSS VSS _3714_/B _3710_/C _3792_/B _4086_/A gf180mcu_as_sc_mcu7t3v3__aoi21_2
XFILLER_186_351 VDD VDD VSS VSS gf180mcu_as_sc_mcu7t3v3__fillcap_16
X_4690_ VDD VDD VSS VSS _5250_/D _5250_/Q _4691_/D _4690_/C gf180mcu_as_sc_mcu7t3v3__ao21_2
X_3641_ VDD VDD VSS VSS _3642_/C _4013_/A _3725_/B _3641_/C gf180mcu_as_sc_mcu7t3v3__ao21_2
XFILLER_162_708 VDD VDD VSS VSS gf180mcu_as_sc_mcu7t3v3__fill_1
XFILLER_174_568 VDD VDD VSS VSS gf180mcu_as_sc_mcu7t3v3__fill_2
XFILLER_179_1259 VDD VDD VSS VSS gf180mcu_as_sc_mcu7t3v3__fill_1
X_3572_ VDD VDD VSS VSS _3934_/A _3783_/B _3775_/B _3573_/C _3572_/D gf180mcu_as_sc_mcu7t3v3__aoi211_2
XFILLER_161_207 VDD VDD VSS VSS gf180mcu_as_sc_mcu7t3v3__fill_2
XFILLER_53_2 VDD VDD VSS VSS gf180mcu_as_sc_mcu7t3v3__fill_2
XFILLER_6_770 VDD VDD VSS VSS gf180mcu_as_sc_mcu7t3v3__fillcap_16
X_2523_ VDD VDD VSS VSS _2847_/A _5227_/Q _2842_/D gf180mcu_as_sc_mcu7t3v3__or2_2
XFILLER_170_752 VDD VDD VSS VSS gf180mcu_as_sc_mcu7t3v3__fillcap_16
X_5242_ VDD VDD VSS VSS _5285_/CLK _5242_/D _5242_/Q gf180mcu_as_sc_mcu7t3v3__dfxtp_2
X_2454_ VDD VDD VSS VSS _4473_/A _5091_/Q _5004_/Q _2455_/A gf180mcu_as_sc_mcu7t3v3__mux2_2
XFILLER_190_1150 VDD VDD VSS VSS gf180mcu_as_sc_mcu7t3v3__fillcap_4
X_5173_ VDD VDD VSS VSS _5182_/CLK _5173_/D _5173_/Q gf180mcu_as_sc_mcu7t3v3__dfxtp_2
X_4124_ VDD VDD VSS VSS _4124_/A _4127_/C _4124_/C _4252_/B _4141_/D gf180mcu_as_sc_mcu7t3v3__aoi211_2
XTAP_TAPCELL_ROW_184_1747 VDD VSS gf180mcu_as_sc_mcu7t3v3__tap_2
XTAP_TAPCELL_ROW_184_1736 VDD VSS gf180mcu_as_sc_mcu7t3v3__tap_2
Xinput1 VDD VDD VSS VSS boot_addr[0] input1/Y gf180mcu_as_sc_mcu7t3v3__buff_12
XPHY_EDGE_ROW_149_3_Right_190 VDD VSS gf180mcu_as_sc_mcu7t3v3__tap_2
X_4055_ VDD VDD VSS VSS _4055_/A _4103_/B _4055_/C _4055_/D _4057_/C gf180mcu_as_sc_mcu7t3v3__ao211_2
X_3006_ VDD VDD VSS VSS _3616_/A _3065_/B _3006_/C _3006_/Y _3615_/D gf180mcu_as_sc_mcu7t3v3__aoi211_2
XFILLER_75_1260 VDD VDD VSS VSS gf180mcu_as_sc_mcu7t3v3__fill_1
XFILLER_101_69 VDD VDD VSS VSS gf180mcu_as_sc_mcu7t3v3__fill_1
XFILLER_178_841 VDD VDD VSS VSS gf180mcu_as_sc_mcu7t3v3__fill_1
X_4957_ VDD VDD VSS VSS _5265_/CLK _4957_/D _4957_/Q gf180mcu_as_sc_mcu7t3v3__dfxtp_2
XPHY_EDGE_ROW_177_Right_39 VDD VSS gf180mcu_as_sc_mcu7t3v3__tap_2
X_4888_ VDD VDD VSS VSS _4895_/CLK _4888_/D _4888_/Q gf180mcu_as_sc_mcu7t3v3__dfxtp_2
X_3908_ VDD VDD VSS VSS _3908_/B _5161_/Q _4977_/D gf180mcu_as_sc_mcu7t3v3__and2_2
XFILLER_177_395 VDD VDD VSS VSS gf180mcu_as_sc_mcu7t3v3__fillcap_8
X_3839_ VDD VDD VSS VSS _3839_/B _3839_/A _4911_/D gf180mcu_as_sc_mcu7t3v3__and2_2
XFILLER_180_505 VDD VDD VSS VSS gf180mcu_as_sc_mcu7t3v3__fill_2
XFILLER_180_527 VDD VDD VSS VSS gf180mcu_as_sc_mcu7t3v3__fill_1
XFILLER_192_376 VDD VDD VSS VSS gf180mcu_as_sc_mcu7t3v3__fillcap_4
XFILLER_192_387 VDD VDD VSS VSS gf180mcu_as_sc_mcu7t3v3__fillcap_4
XFILLER_173_590 VDD VDD VSS VSS gf180mcu_as_sc_mcu7t3v3__fillcap_16
XFILLER_126_55 VDD VDD VSS VSS gf180mcu_as_sc_mcu7t3v3__fillcap_4
XFILLER_160_262 VDD VDD VSS VSS gf180mcu_as_sc_mcu7t3v3__fill_1
XFILLER_161_796 VDD VDD VSS VSS gf180mcu_as_sc_mcu7t3v3__fillcap_4
Xoutput371 VDD VDD VSS VSS _4791_/Q se_out[20] gf180mcu_as_sc_mcu7t3v3__buff_12
Xoutput360 VDD VDD VSS VSS _4781_/Q se_out[10] gf180mcu_as_sc_mcu7t3v3__buff_12
XFILLER_0_924 VDD VDD VSS VSS gf180mcu_as_sc_mcu7t3v3__fill_2
Xoutput393 VDD VDD VSS VSS _4805_/Q south_out[0] gf180mcu_as_sc_mcu7t3v3__buff_12
Xoutput382 VDD VDD VSS VSS _4801_/Q se_out[30] gf180mcu_as_sc_mcu7t3v3__buff_12
XPHY_EDGE_ROW_186_Right_48 VDD VSS gf180mcu_as_sc_mcu7t3v3__tap_2
XFILLER_0_979 VDD VDD VSS VSS gf180mcu_as_sc_mcu7t3v3__fill_2
XTAP_TAPCELL_ROW_3_751 VDD VSS gf180mcu_as_sc_mcu7t3v3__tap_2
XTAP_TAPCELL_ROW_3_740 VDD VSS gf180mcu_as_sc_mcu7t3v3__tap_2
XFILLER_167_1152 VDD VDD VSS VSS gf180mcu_as_sc_mcu7t3v3__fill_2
XFILLER_167_1185 VDD VDD VSS VSS gf180mcu_as_sc_mcu7t3v3__fillcap_4
XFILLER_187_104 VDD VDD VSS VSS gf180mcu_as_sc_mcu7t3v3__fillcap_16
XFILLER_169_874 VDD VDD VSS VSS gf180mcu_as_sc_mcu7t3v3__fillcap_16
XFILLER_156_524 VDD VDD VSS VSS gf180mcu_as_sc_mcu7t3v3__fill_1
XFILLER_183_321 VDD VDD VSS VSS gf180mcu_as_sc_mcu7t3v3__fill_1
XFILLER_183_365 VDD VDD VSS VSS gf180mcu_as_sc_mcu7t3v3__fill_1
XFILLER_184_877 VDD VDD VSS VSS gf180mcu_as_sc_mcu7t3v3__fillcap_8
Xwire465 VDD VDD VSS VSS _3608_/Y _4844_/D gf180mcu_as_sc_mcu7t3v3__clkbuff_12
Xwire487 VDD VDD VSS VSS _2998_/Y _4776_/D gf180mcu_as_sc_mcu7t3v3__clkbuff_12
XFILLER_152_730 VDD VDD VSS VSS gf180mcu_as_sc_mcu7t3v3__fill_1
XFILLER_183_72 VDD VDD VSS VSS gf180mcu_as_sc_mcu7t3v3__fillcap_16
XFILLER_61_1326 VDD VDD VSS VSS gf180mcu_as_sc_mcu7t3v3__fill_2
XTAP_TAPCELL_ROW_166_1400 VDD VSS gf180mcu_as_sc_mcu7t3v3__tap_2
XPHY_EDGE_ROW_120_1_Right_629 VDD VSS gf180mcu_as_sc_mcu7t3v3__tap_2
XTAP_TAPCELL_ROW_162_1319 VDD VSS gf180mcu_as_sc_mcu7t3v3__tap_2
XFILLER_98_1260 VDD VDD VSS VSS gf180mcu_as_sc_mcu7t3v3__fill_2
XFILLER_178_115 VDD VDD VSS VSS gf180mcu_as_sc_mcu7t3v3__fillcap_4
X_4811_ VDD VDD VSS VSS clkload7/A _4811_/D _4811_/Q gf180mcu_as_sc_mcu7t3v3__dfxtp_2
XFILLER_92_91 VDD VDD VSS VSS gf180mcu_as_sc_mcu7t3v3__fillcap_8
X_4742_ VDD VDD VSS VSS _5272_/D _4742_/C _4742_/B _4742_/A gf180mcu_as_sc_mcu7t3v3__aoi21b_2
XFILLER_159_384 VDD VDD VSS VSS gf180mcu_as_sc_mcu7t3v3__fill_1
XFILLER_159_395 VDD VDD VSS VSS gf180mcu_as_sc_mcu7t3v3__fill_2
XFILLER_175_833 VDD VDD VSS VSS gf180mcu_as_sc_mcu7t3v3__fillcap_4
XFILLER_187_693 VDD VDD VSS VSS gf180mcu_as_sc_mcu7t3v3__fillcap_4
X_4673_ VDD VDD VSS VSS _5114_/Q _4683_/C _4681_/C _5245_/Q _4674_/C gf180mcu_as_sc_mcu7t3v3__ao22_2
XFILLER_179_1034 VDD VDD VSS VSS gf180mcu_as_sc_mcu7t3v3__fillcap_16
X_3624_ VDD VDD VSS VSS _3624_/B _3795_/A _4846_/D gf180mcu_as_sc_mcu7t3v3__and2_2
XFILLER_174_387 VDD VDD VSS VSS gf180mcu_as_sc_mcu7t3v3__fillcap_4
XFILLER_192_1201 VDD VDD VSS VSS gf180mcu_as_sc_mcu7t3v3__fill_2
X_3555_ VDD VDD VSS VSS _3559_/C _3561_/B _3561_/A gf180mcu_as_sc_mcu7t3v3__nand2b_2
XFILLER_157_1354 VDD VDD VSS VSS gf180mcu_as_sc_mcu7t3v3__fill_1
X_3486_ VDD VDD VSS VSS _4941_/Q _3493_/B _3493_/C _4144_/A _3487_/D gf180mcu_as_sc_mcu7t3v3__ao22_2
X_2506_ VDD VDD VSS VSS _4736_/B _5270_/Q _4739_/B gf180mcu_as_sc_mcu7t3v3__and2_2
XFILLER_153_1229 VDD VDD VSS VSS gf180mcu_as_sc_mcu7t3v3__fillcap_16
X_5225_ VDD VDD VSS VSS _5266_/CLK _5225_/D _5225_/Q gf180mcu_as_sc_mcu7t3v3__dfxtp_2
X_2437_ VDD VDD VSS VSS _3684_/A _4058_/A gf180mcu_as_sc_mcu7t3v3__inv_2
X_5156_ VDD VDD VSS VSS _5275_/CLK _5156_/D _5156_/Q gf180mcu_as_sc_mcu7t3v3__dfxtp_2
X_5087_ VDD VDD VSS VSS clkload9/A _5087_/D _5087_/Q gf180mcu_as_sc_mcu7t3v3__dfxtp_2
X_4107_ VDD VDD VSS VSS _4107_/B _4157_/A _4250_/B gf180mcu_as_sc_mcu7t3v3__and2_2
XFILLER_77_1300 VDD VDD VSS VSS gf180mcu_as_sc_mcu7t3v3__fillcap_4
X_4038_ VDD VDD VSS VSS _4038_/A _4104_/B _4067_/B _4038_/D _4042_/A gf180mcu_as_sc_mcu7t3v3__ao211_2
XFILLER_13_806 VDD VDD VSS VSS gf180mcu_as_sc_mcu7t3v3__fillcap_8
XANTENNA_50 VDD VDD VSS VSS _4054_/A gf180mcu_as_sc_mcu7t3v3__diode_2
XFILLER_162_1093 VDD VDD VSS VSS gf180mcu_as_sc_mcu7t3v3__fill_2
XTAP_TAPCELL_ROW_64_1_1017 VDD VSS gf180mcu_as_sc_mcu7t3v3__tap_2
X_4906__1062 VDD VDD VSS VSS _4906_/D gf180mcu_as_sc_mcu7t3v3__tiel_4
Xdelaybuf_2_clk VDD VDD VSS VSS delaybuf_2_clk/A clkbuf_0_clk/A gf180mcu_as_sc_mcu7t3v3__clkbuff_12
XTAP_TAPCELL_ROW_8_843 VDD VSS gf180mcu_as_sc_mcu7t3v3__tap_2
XFILLER_153_31 VDD VDD VSS VSS gf180mcu_as_sc_mcu7t3v3__fill_1
XFILLER_169_1258 VDD VDD VSS VSS gf180mcu_as_sc_mcu7t3v3__fill_2
XFILLER_91_1308 VDD VDD VSS VSS gf180mcu_as_sc_mcu7t3v3__fillcap_4
XFILLER_188_435 VDD VDD VSS VSS gf180mcu_as_sc_mcu7t3v3__fillcap_16
XFILLER_188_457 VDD VDD VSS VSS gf180mcu_as_sc_mcu7t3v3__fillcap_4
XPHY_EDGE_ROW_29_3_Left_401 VDD VSS gf180mcu_as_sc_mcu7t3v3__tap_2
XFILLER_157_833 VDD VDD VSS VSS gf180mcu_as_sc_mcu7t3v3__fillcap_4
XTAP_TAPCELL_ROW_159_1270 VDD VSS gf180mcu_as_sc_mcu7t3v3__tap_2
XFILLER_172_803 VDD VDD VSS VSS gf180mcu_as_sc_mcu7t3v3__fill_2
XFILLER_184_663 VDD VDD VSS VSS gf180mcu_as_sc_mcu7t3v3__fill_2
XPHY_EDGE_ROW_142_1_Left_334 VDD VSS gf180mcu_as_sc_mcu7t3v3__tap_2
XFILLER_156_387 VDD VDD VSS VSS gf180mcu_as_sc_mcu7t3v3__fillcap_8
XFILLER_184_685 VDD VDD VSS VSS gf180mcu_as_sc_mcu7t3v3__fillcap_16
XFILLER_171_346 VDD VDD VSS VSS gf180mcu_as_sc_mcu7t3v3__fillcap_4
XTAP_TAPCELL_ROW_155_1189 VDD VSS gf180mcu_as_sc_mcu7t3v3__tap_2
X_3340_ VDD VDD VSS VSS _3373_/S _3992_/D _3340_/A _3342_/A gf180mcu_as_sc_mcu7t3v3__mux2_2
X_5010_ VDD VDD VSS VSS _5095_/CLK _5010_/D _5010_/Q gf180mcu_as_sc_mcu7t3v3__dfxtp_2
X_3271_ VDD VDD VSS VSS _3271_/B _3271_/A _3442_/B gf180mcu_as_sc_mcu7t3v3__or2_2
XFILLER_4_1083 VDD VDD VSS VSS gf180mcu_as_sc_mcu7t3v3__fill_2
XFILLER_179_402 VDD VDD VSS VSS gf180mcu_as_sc_mcu7t3v3__fillcap_16
XFILLER_185_1082 VDD VDD VSS VSS gf180mcu_as_sc_mcu7t3v3__fillcap_8
XTAP_TAPCELL_ROW_179_1646 VDD VSS gf180mcu_as_sc_mcu7t3v3__tap_2
X_2986_ VDD VDD VSS VSS _3045_/A _2986_/B _2986_/C _3045_/D _2987_/D gf180mcu_as_sc_mcu7t3v3__ao211_2
XPHY_EDGE_ROW_74_1_Left_266 VDD VSS gf180mcu_as_sc_mcu7t3v3__tap_2
X_4725_ VDD VDD VSS VSS _5263_/D _5108_/Q _4728_/B _4725_/C gf180mcu_as_sc_mcu7t3v3__ao21_2
XFILLER_163_836 VDD VDD VSS VSS gf180mcu_as_sc_mcu7t3v3__fillcap_4
X_4656_ VDD VDD VSS VSS _4659_/B _4656_/B _5238_/Q _5238_/D gf180mcu_as_sc_mcu7t3v3__mux2_2
XFILLER_163_858 VDD VDD VSS VSS gf180mcu_as_sc_mcu7t3v3__fillcap_16
XFILLER_174_184 VDD VDD VSS VSS gf180mcu_as_sc_mcu7t3v3__fillcap_16
Xinput70 VDD VDD VSS VSS east_in[33] wire854/A gf180mcu_as_sc_mcu7t3v3__buff_12
Xinput81 VDD VDD VSS VSS ne_in[12] _4032_/D gf180mcu_as_sc_mcu7t3v3__buff_12
X_4587_ VDD VDD VSS VSS _4588_/D _4587_/B _4588_/A gf180mcu_as_sc_mcu7t3v3__nor2_2
X_3607_ VDD VDD VSS VSS _3977_/A _3653_/B _3652_/D _3608_/C _3607_/D gf180mcu_as_sc_mcu7t3v3__aoi211_2
XTAP_TAPCELL_ROW_125_1_1078 VDD VSS gf180mcu_as_sc_mcu7t3v3__tap_2
Xinput92 VDD VDD VSS VSS ne_in[22] _4109_/A gf180mcu_as_sc_mcu7t3v3__buff_12
X_3538_ VDD VDD VSS VSS _3539_/B _4944_/Q _4945_/Q gf180mcu_as_sc_mcu7t3v3__nor2_2
XFILLER_192_1053 VDD VDD VSS VSS gf180mcu_as_sc_mcu7t3v3__fill_1
XFILLER_88_102 VDD VDD VSS VSS gf180mcu_as_sc_mcu7t3v3__fill_2
XFILLER_192_1097 VDD VDD VSS VSS gf180mcu_as_sc_mcu7t3v3__fillcap_4
X_3469_ VDD VDD VSS VSS _4122_/A _3523_/B _3469_/C _3470_/C _3469_/D gf180mcu_as_sc_mcu7t3v3__aoi211_2
XFILLER_44_1354 VDD VDD VSS VSS gf180mcu_as_sc_mcu7t3v3__fill_1
X_5208_ VDD VDD VSS VSS _5212_/CLK _5208_/D _5208_/Q gf180mcu_as_sc_mcu7t3v3__dfxtp_2
X_5139_ VDD VDD VSS VSS _5152_/CLK _5139_/D _5139_/Q gf180mcu_as_sc_mcu7t3v3__dfxtp_2
XFILLER_123_67 VDD VDD VSS VSS gf180mcu_as_sc_mcu7t3v3__fill_2
XFILLER_177_6 VDD VDD VSS VSS gf180mcu_as_sc_mcu7t3v3__fillcap_16
XFILLER_13_614 VDD VDD VSS VSS gf180mcu_as_sc_mcu7t3v3__fillcap_4
XFILLER_16_76 VDD VDD VSS VSS gf180mcu_as_sc_mcu7t3v3__fillcap_4
XFILLER_185_438 VDD VDD VSS VSS gf180mcu_as_sc_mcu7t3v3__fillcap_8
XFILLER_153_313 VDD VDD VSS VSS gf180mcu_as_sc_mcu7t3v3__fillcap_8
XFILLER_181_600 VDD VDD VSS VSS gf180mcu_as_sc_mcu7t3v3__fillcap_16
XFILLER_5_846 VDD VDD VSS VSS gf180mcu_as_sc_mcu7t3v3__fill_1
XFILLER_153_368 VDD VDD VSS VSS gf180mcu_as_sc_mcu7t3v3__fillcap_16
XFILLER_181_688 VDD VDD VSS VSS gf180mcu_as_sc_mcu7t3v3__fillcap_8
XFILLER_164_30 VDD VDD VSS VSS gf180mcu_as_sc_mcu7t3v3__fillcap_4
XFILLER_175_1262 VDD VDD VSS VSS gf180mcu_as_sc_mcu7t3v3__fillcap_4
XTAP_TAPCELL_ROW_40_3_1951 VDD VSS gf180mcu_as_sc_mcu7t3v3__tap_2
XFILLER_0_584 VDD VDD VSS VSS gf180mcu_as_sc_mcu7t3v3__fill_2
XFILLER_57_72 VDD VDD VSS VSS gf180mcu_as_sc_mcu7t3v3__fillcap_4
XFILLER_189_733 VDD VDD VSS VSS gf180mcu_as_sc_mcu7t3v3__fill_2
XFILLER_95_1296 VDD VDD VSS VSS gf180mcu_as_sc_mcu7t3v3__fill_1
XFILLER_177_928 VDD VDD VSS VSS gf180mcu_as_sc_mcu7t3v3__fillcap_8
XFILLER_189_82 VDD VDD VSS VSS gf180mcu_as_sc_mcu7t3v3__fill_1
X_2840_ VDD VDD VSS VSS _2840_/A _2840_/B _2840_/C _2840_/D _2841_/B gf180mcu_as_sc_mcu7t3v3__nand4_2
XTAP_TAPCELL_ROW_157_1229 VDD VSS gf180mcu_as_sc_mcu7t3v3__tap_2
XFILLER_8_640 VDD VDD VSS VSS gf180mcu_as_sc_mcu7t3v3__fill_2
X_2771_ VDD VDD VSS VSS _2771_/A _2771_/B _2771_/C _2771_/D _2796_/B gf180mcu_as_sc_mcu7t3v3__ao211_2
XTAP_TAPCELL_ROW_174_1543 VDD VSS gf180mcu_as_sc_mcu7t3v3__tap_2
XFILLER_157_663 VDD VDD VSS VSS gf180mcu_as_sc_mcu7t3v3__fillcap_4
XFILLER_157_696 VDD VDD VSS VSS gf180mcu_as_sc_mcu7t3v3__fillcap_4
XFILLER_191_419 VDD VDD VSS VSS gf180mcu_as_sc_mcu7t3v3__fill_1
XFILLER_7_150 VDD VDD VSS VSS gf180mcu_as_sc_mcu7t3v3__fill_1
X_4510_ VDD VDD VSS VSS _4511_/D _4510_/B _4572_/A gf180mcu_as_sc_mcu7t3v3__nor2_2
XTAP_TAPCELL_ROW_174_1554 VDD VSS gf180mcu_as_sc_mcu7t3v3__tap_2
XFILLER_156_184 VDD VDD VSS VSS gf180mcu_as_sc_mcu7t3v3__fillcap_16
X_4441_ VDD VDD VSS VSS _4442_/D _4441_/B _4573_/A gf180mcu_as_sc_mcu7t3v3__nor2_2
XTAP_TAPCELL_ROW_10_881 VDD VSS gf180mcu_as_sc_mcu7t3v3__tap_2
XFILLER_171_154 VDD VDD VSS VSS gf180mcu_as_sc_mcu7t3v3__fill_2
XFILLER_176_1037 VDD VDD VSS VSS gf180mcu_as_sc_mcu7t3v3__fillcap_4
XPHY_EDGE_ROW_9_Right_9 VDD VSS gf180mcu_as_sc_mcu7t3v3__tap_2
XFILLER_154_1324 VDD VDD VSS VSS gf180mcu_as_sc_mcu7t3v3__fill_1
X_4372_ VDD VDD VSS VSS _4736_/B _4372_/B _4372_/C _4373_/C _4372_/D gf180mcu_as_sc_mcu7t3v3__aoi31_2
Xfanout608 VDD VDD VSS VSS _2928_/Y _3058_/B gf180mcu_as_sc_mcu7t3v3__buff_12
Xfanout619 VDD VDD VSS VSS _2659_/S _2605_/C gf180mcu_as_sc_mcu7t3v3__buff_12
X_3323_ VDD VDD VSS VSS _3973_/A _3372_/B _3323_/C _3323_/D _3324_/A gf180mcu_as_sc_mcu7t3v3__ao22_2
X_3254_ VDD VDD VSS VSS _3518_/A _3818_/C _3254_/A gf180mcu_as_sc_mcu7t3v3__nand2_2
X_4880__1088 VDD VDD VSS VSS _4880_/D gf180mcu_as_sc_mcu7t3v3__tiel_4
XFILLER_187_1122 VDD VDD VSS VSS gf180mcu_as_sc_mcu7t3v3__fill_2
X_3185_ VDD VDD VSS VSS _3185_/D _4160_/D _3236_/B _3233_/B _3186_/D gf180mcu_as_sc_mcu7t3v3__ao31_2
XFILLER_187_1188 VDD VDD VSS VSS gf180mcu_as_sc_mcu7t3v3__fill_2
XTAP_TAPCELL_ROW_144_3_2055 VDD VSS gf180mcu_as_sc_mcu7t3v3__tap_2
XFILLER_179_254 VDD VDD VSS VSS gf180mcu_as_sc_mcu7t3v3__fill_1
X_2969_ VDD VDD VSS VSS _3045_/A _2969_/B _2969_/C _3045_/D _2971_/C gf180mcu_as_sc_mcu7t3v3__ao211_2
XFILLER_185_18 VDD VDD VSS VSS gf180mcu_as_sc_mcu7t3v3__fillcap_16
X_4708_ VDD VDD VSS VSS _4717_/S _4708_/A _4708_/B _4708_/C gf180mcu_as_sc_mcu7t3v3__ao21_2
XFILLER_11_1320 VDD VDD VSS VSS gf180mcu_as_sc_mcu7t3v3__fillcap_8
XFILLER_163_644 VDD VDD VSS VSS gf180mcu_as_sc_mcu7t3v3__fillcap_16
XFILLER_159_1268 VDD VDD VSS VSS gf180mcu_as_sc_mcu7t3v3__fill_1
XFILLER_191_975 VDD VDD VSS VSS gf180mcu_as_sc_mcu7t3v3__fillcap_4
X_4639_ VDD VDD VSS VSS _4639_/S _5105_/Q _5230_/Q _5230_/D gf180mcu_as_sc_mcu7t3v3__mux2_2
XFILLER_163_699 VDD VDD VSS VSS gf180mcu_as_sc_mcu7t3v3__fill_1
XTAP_TAPCELL_ROW_59_1_1012 VDD VSS gf180mcu_as_sc_mcu7t3v3__tap_2
Xmesh_tile_1007 VDD VDD VSS VSS nw_out[13] gf180mcu_as_sc_mcu7t3v3__tiel_4
XFILLER_134_88 VDD VDD VSS VSS gf180mcu_as_sc_mcu7t3v3__fill_1
XFILLER_94_37 VDD VDD VSS VSS gf180mcu_as_sc_mcu7t3v3__fill_2
Xmesh_tile_1029 VDD VDD VSS VSS sw_out[1] gf180mcu_as_sc_mcu7t3v3__tiel_4
Xmesh_tile_1018 VDD VDD VSS VSS nw_out[24] gf180mcu_as_sc_mcu7t3v3__tiel_4
XFILLER_166_1217 VDD VDD VSS VSS gf180mcu_as_sc_mcu7t3v3__fillcap_8
XFILLER_168_2 VDD VDD VSS VSS gf180mcu_as_sc_mcu7t3v3__fillcap_16
XFILLER_150_98 VDD VDD VSS VSS gf180mcu_as_sc_mcu7t3v3__fillcap_4
XFILLER_158_427 VDD VDD VSS VSS gf180mcu_as_sc_mcu7t3v3__fillcap_8
XFILLER_174_909 VDD VDD VSS VSS gf180mcu_as_sc_mcu7t3v3__fillcap_16
XFILLER_142_1272 VDD VDD VSS VSS gf180mcu_as_sc_mcu7t3v3__fill_1
XFILLER_185_279 VDD VDD VSS VSS gf180mcu_as_sc_mcu7t3v3__fill_1
XFILLER_182_931 VDD VDD VSS VSS gf180mcu_as_sc_mcu7t3v3__fill_1
XTAP_TAPCELL_ROW_152_1126 VDD VSS gf180mcu_as_sc_mcu7t3v3__tap_2
XTAP_TAPCELL_ROW_152_1115 VDD VSS gf180mcu_as_sc_mcu7t3v3__tap_2
XTAP_TAPCELL_ROW_152_1137 VDD VSS gf180mcu_as_sc_mcu7t3v3__tap_2
XFILLER_175_1092 VDD VDD VSS VSS gf180mcu_as_sc_mcu7t3v3__fillcap_16
XFILLER_191_72 VDD VDD VSS VSS gf180mcu_as_sc_mcu7t3v3__fillcap_16
XFILLER_1_882 VDD VDD VSS VSS gf180mcu_as_sc_mcu7t3v3__fillcap_4
Xinput260 VDD VDD VSS VSS sw_in[1] _2424_/A gf180mcu_as_sc_mcu7t3v3__buff_12
Xinput271 VDD VDD VSS VSS sw_in[2] _3302_/A gf180mcu_as_sc_mcu7t3v3__buff_12
Xinput282 VDD VDD VSS VSS sw_in[9] _4010_/A gf180mcu_as_sc_mcu7t3v3__buff_12
Xinput293 VDD VDD VSS VSS west_in[19] _4085_/D gf180mcu_as_sc_mcu7t3v3__buff_12
X_4990_ VDD VDD VSS VSS _5089_/CLK _4990_/D _4990_/Q gf180mcu_as_sc_mcu7t3v3__dfxtp_2
X_3941_ VDD VDD VSS VSS _4024_/C _3941_/A _3942_/D gf180mcu_as_sc_mcu7t3v3__and2_2
XFILLER_182_1074 VDD VDD VSS VSS gf180mcu_as_sc_mcu7t3v3__fillcap_8
XFILLER_189_574 VDD VDD VSS VSS gf180mcu_as_sc_mcu7t3v3__fill_1
X_3872_ VDD VDD VSS VSS _3872_/A _4948_/Q _5127_/Q _3872_/D _3873_/C gf180mcu_as_sc_mcu7t3v3__ao211_2
XFILLER_165_909 VDD VDD VSS VSS gf180mcu_as_sc_mcu7t3v3__fill_1
XFILLER_177_769 VDD VDD VSS VSS gf180mcu_as_sc_mcu7t3v3__fill_1
XFILLER_83_2 VDD VDD VSS VSS gf180mcu_as_sc_mcu7t3v3__fill_2
X_2823_ VDD VDD VSS VSS _4706_/A _2833_/A _2830_/B gf180mcu_as_sc_mcu7t3v3__and2_2
XFILLER_158_972 VDD VDD VSS VSS gf180mcu_as_sc_mcu7t3v3__fillcap_8
X_2754_ VDD VDD VSS VSS _2754_/D _2833_/A _4751_/A _4718_/A _4627_/A gf180mcu_as_sc_mcu7t3v3__ao31_2
XFILLER_9_982 VDD VDD VSS VSS gf180mcu_as_sc_mcu7t3v3__fillcap_4
XFILLER_160_603 VDD VDD VSS VSS gf180mcu_as_sc_mcu7t3v3__fill_1
X_2685_ VDD VDD VSS VSS _2686_/D _2723_/A _2736_/B _2685_/A gf180mcu_as_sc_mcu7t3v3__aoi21b_2
X_4424_ VDD VDD VSS VSS _5169_/Q _4565_/B _4424_/C _4424_/D _5169_/D gf180mcu_as_sc_mcu7t3v3__ao211_2
X_4355_ VDD VDD VSS VSS _4366_/S _5160_/Q _4355_/A _4356_/B gf180mcu_as_sc_mcu7t3v3__mux2_2
XFILLER_8_1218 VDD VDD VSS VSS gf180mcu_as_sc_mcu7t3v3__fillcap_4
XFILLER_8_1229 VDD VDD VSS VSS gf180mcu_as_sc_mcu7t3v3__fill_1
X_3306_ VDD VDD VSS VSS _3958_/A _3370_/B _3306_/C _3306_/D _3307_/C gf180mcu_as_sc_mcu7t3v3__ao211_2
XFILLER_154_1176 VDD VDD VSS VSS gf180mcu_as_sc_mcu7t3v3__fillcap_16
X_4286_ VDD VDD VSS VSS _4289_/S _4698_/B _5120_/Q _5120_/D gf180mcu_as_sc_mcu7t3v3__mux2_2
X_3237_ VDD VDD VSS VSS _3238_/B _3237_/C _3237_/B _3520_/A gf180mcu_as_sc_mcu7t3v3__aoi21b_2
X_3168_ VDD VDD VSS VSS _3179_/B _4941_/Q _3171_/C gf180mcu_as_sc_mcu7t3v3__or2_2
X_3099_ VDD VDD VSS VSS _3106_/B _3207_/S _4081_/A gf180mcu_as_sc_mcu7t3v3__nand2_2
XFILLER_78_1291 VDD VDD VSS VSS gf180mcu_as_sc_mcu7t3v3__fill_2
XFILLER_126_1256 VDD VDD VSS VSS gf180mcu_as_sc_mcu7t3v3__fill_2
XFILLER_13_33 VDD VDD VSS VSS gf180mcu_as_sc_mcu7t3v3__fill_1
XFILLER_161_1136 VDD VDD VSS VSS gf180mcu_as_sc_mcu7t3v3__fillcap_8
XFILLER_168_769 VDD VDD VSS VSS gf180mcu_as_sc_mcu7t3v3__fillcap_8
XFILLER_183_706 VDD VDD VSS VSS gf180mcu_as_sc_mcu7t3v3__fill_1
XFILLER_13_55 VDD VDD VSS VSS gf180mcu_as_sc_mcu7t3v3__fill_2
XFILLER_164_920 VDD VDD VSS VSS gf180mcu_as_sc_mcu7t3v3__fillcap_8
XPHY_EDGE_ROW_37_1_Left_229 VDD VSS gf180mcu_as_sc_mcu7t3v3__tap_2
XFILLER_150_102 VDD VDD VSS VSS gf180mcu_as_sc_mcu7t3v3__fill_2
XPHY_EDGE_ROW_38_3_Left_410 VDD VSS gf180mcu_as_sc_mcu7t3v3__tap_2
XFILLER_38_41 VDD VDD VSS VSS gf180mcu_as_sc_mcu7t3v3__fill_1
XFILLER_161_64 VDD VDD VSS VSS gf180mcu_as_sc_mcu7t3v3__fillcap_4
XFILLER_166_1014 VDD VDD VSS VSS gf180mcu_as_sc_mcu7t3v3__fill_1
XPHY_EDGE_ROW_151_1_Left_343 VDD VSS gf180mcu_as_sc_mcu7t3v3__tap_2
XFILLER_159_769 VDD VDD VSS VSS gf180mcu_as_sc_mcu7t3v3__fill_1
XFILLER_92_1299 VDD VDD VSS VSS gf180mcu_as_sc_mcu7t3v3__fillcap_4
XFILLER_9_212 VDD VDD VSS VSS gf180mcu_as_sc_mcu7t3v3__fillcap_8
XTAP_TAPCELL_ROW_12_921 VDD VSS gf180mcu_as_sc_mcu7t3v3__tap_2
XTAP_TAPCELL_ROW_12_910 VDD VSS gf180mcu_as_sc_mcu7t3v3__tap_2
XFILLER_186_588 VDD VDD VSS VSS gf180mcu_as_sc_mcu7t3v3__fillcap_4
XFILLER_10_970 VDD VDD VSS VSS gf180mcu_as_sc_mcu7t3v3__fillcap_16
Xclkload15 VDD VDD VSS VSS _5152_/CLK clkload15/Y gf180mcu_as_sc_mcu7t3v3__clkbuff_12
Xclkload26 VDD VDD VSS VSS clkload26/Y _5232_/CLK gf180mcu_as_sc_mcu7t3v3__inv_6
XTAP_TAPCELL_ROW_171_1502 VDD VSS gf180mcu_as_sc_mcu7t3v3__tap_2
XFILLER_170_901 VDD VDD VSS VSS gf180mcu_as_sc_mcu7t3v3__fill_1
XFILLER_182_794 VDD VDD VSS VSS gf180mcu_as_sc_mcu7t3v3__fillcap_8
X_2470_ VDD VDD VSS VSS _4341_/S _5092_/Q _5005_/Q _2471_/A gf180mcu_as_sc_mcu7t3v3__mux2_2
XTAP_TAPCELL_ROW_27_3_1938 VDD VSS gf180mcu_as_sc_mcu7t3v3__tap_2
XFILLER_181_282 VDD VDD VSS VSS gf180mcu_as_sc_mcu7t3v3__fill_1
X_4140_ VDD VDD VSS VSS _4141_/C _4140_/B _4140_/A gf180mcu_as_sc_mcu7t3v3__nor2_2
XTAP_TAPCELL_ROW_169_1464 VDD VSS gf180mcu_as_sc_mcu7t3v3__tap_2
XTAP_TAPCELL_ROW_169_1453 VDD VSS gf180mcu_as_sc_mcu7t3v3__tap_2
XPHY_EDGE_ROW_22_3_Left_394 VDD VSS gf180mcu_as_sc_mcu7t3v3__tap_2
X_4071_ VDD VDD VSS VSS _4071_/A _4160_/C _4129_/C _4932_/Q _4073_/C gf180mcu_as_sc_mcu7t3v3__ao22_2
XFILLER_3_1126 VDD VDD VSS VSS gf180mcu_as_sc_mcu7t3v3__fill_2
XFILLER_7_1295 VDD VDD VSS VSS gf180mcu_as_sc_mcu7t3v3__fill_1
X_3022_ VDD VDD VSS VSS _3141_/B _3022_/B _3022_/C _3023_/C gf180mcu_as_sc_mcu7t3v3__nor3_2
XPHY_EDGE_ROW_83_1_Left_275 VDD VSS gf180mcu_as_sc_mcu7t3v3__tap_2
XFILLER_149_1256 VDD VDD VSS VSS gf180mcu_as_sc_mcu7t3v3__fillcap_4
XTAP_TAPCELL_ROW_182_1697 VDD VSS gf180mcu_as_sc_mcu7t3v3__tap_2
X_4973_ VDD VDD VSS VSS _5232_/CLK _4973_/D _4973_/Q gf180mcu_as_sc_mcu7t3v3__dfxtp_2
XFILLER_189_360 VDD VDD VSS VSS gf180mcu_as_sc_mcu7t3v3__fill_2
X_3924_ VDD VDD VSS VSS _3924_/A _3931_/A _3924_/C _3924_/Y gf180mcu_as_sc_mcu7t3v3__nor3_2
XFILLER_164_205 VDD VDD VSS VSS gf180mcu_as_sc_mcu7t3v3__fill_2
XFILLER_165_717 VDD VDD VSS VSS gf180mcu_as_sc_mcu7t3v3__fill_1
Xclkload9 VDD VDD VSS VSS clkload9/A clkload9/Y gf180mcu_as_sc_mcu7t3v3__clkbuff_4
X_3855_ VDD VDD VSS VSS _5149_/Q _5150_/Q _3855_/C _3858_/C gf180mcu_as_sc_mcu7t3v3__nor3_2
X_3786_ VDD VDD VSS VSS _3811_/B _3786_/A _3796_/B gf180mcu_as_sc_mcu7t3v3__and2_2
X_2806_ VDD VDD VSS VSS _4259_/C _2806_/A _2806_/B _2806_/C _2806_/D gf180mcu_as_sc_mcu7t3v3__aoi22_2
XTAP_TAPCELL_ROW_139_3_2050 VDD VSS gf180mcu_as_sc_mcu7t3v3__tap_2
X_2737_ VDD VDD VSS VSS _2832_/S _2737_/B _2737_/C _2737_/D _2737_/Y gf180mcu_as_sc_mcu7t3v3__ao22_2
XFILLER_160_411 VDD VDD VSS VSS gf180mcu_as_sc_mcu7t3v3__fill_2
XFILLER_161_923 VDD VDD VSS VSS gf180mcu_as_sc_mcu7t3v3__fillcap_16
XFILLER_69_1268 VDD VDD VSS VSS gf180mcu_as_sc_mcu7t3v3__fill_1
X_2668_ VDD VDD VSS VSS _2668_/Y _2668_/C _2676_/A _2668_/A gf180mcu_as_sc_mcu7t3v3__aoi21b_2
XFILLER_156_1227 VDD VDD VSS VSS gf180mcu_as_sc_mcu7t3v3__fillcap_16
XFILLER_161_956 VDD VDD VSS VSS gf180mcu_as_sc_mcu7t3v3__fillcap_4
XFILLER_172_282 VDD VDD VSS VSS gf180mcu_as_sc_mcu7t3v3__fillcap_4
X_4407_ VDD VDD VSS VSS _5167_/Q _4565_/B _4407_/C _4407_/D _5167_/D gf180mcu_as_sc_mcu7t3v3__ao211_2
XTAP_TAPCELL_ROW_189_1829 VDD VSS gf180mcu_as_sc_mcu7t3v3__tap_2
X_2599_ VDD VDD VSS VSS _2659_/S _2601_/D _2599_/B _2599_/A gf180mcu_as_sc_mcu7t3v3__aoi21b_2
X_4338_ VDD VDD VSS VSS _4338_/Y _4377_/B _4338_/A gf180mcu_as_sc_mcu7t3v3__nor2_2
XFILLER_115_57 VDD VDD VSS VSS gf180mcu_as_sc_mcu7t3v3__fillcap_8
X_4269_ VDD VDD VSS VSS _4273_/S _4696_/B _5103_/Q _5103_/D gf180mcu_as_sc_mcu7t3v3__mux2_2
XFILLER_132_1260 VDD VDD VSS VSS gf180mcu_as_sc_mcu7t3v3__fill_2
XFILLER_131_45 VDD VDD VSS VSS gf180mcu_as_sc_mcu7t3v3__fill_2
XFILLER_10_244 VDD VDD VSS VSS gf180mcu_as_sc_mcu7t3v3__fill_1
Xwire603 VDD VDD VSS VSS _3874_/Y _3885_/B gf180mcu_as_sc_mcu7t3v3__clkbuff_12
Xwire647 VDD VDD VSS VSS _3551_/B _3728_/C gf180mcu_as_sc_mcu7t3v3__clkbuff_12
XFILLER_156_53 VDD VDD VSS VSS gf180mcu_as_sc_mcu7t3v3__fillcap_16
XFILLER_164_794 VDD VDD VSS VSS gf180mcu_as_sc_mcu7t3v3__fill_2
XFILLER_156_86 VDD VDD VSS VSS gf180mcu_as_sc_mcu7t3v3__fillcap_4
XFILLER_163_282 VDD VDD VSS VSS gf180mcu_as_sc_mcu7t3v3__fillcap_16
XPHY_EDGE_ROW_70_3_Right_111 VDD VSS gf180mcu_as_sc_mcu7t3v3__tap_2
XFILLER_2_498 VDD VDD VSS VSS gf180mcu_as_sc_mcu7t3v3__fillcap_8
XFILLER_172_1084 VDD VDD VSS VSS gf180mcu_as_sc_mcu7t3v3__fill_1
Xfanout791 VDD VDD VSS VSS _4197_/B _4195_/B gf180mcu_as_sc_mcu7t3v3__buff_12
XTAP_TAPCELL_ROW_164_1361 VDD VSS gf180mcu_as_sc_mcu7t3v3__tap_2
XFILLER_65_72 VDD VDD VSS VSS gf180mcu_as_sc_mcu7t3v3__fillcap_8
XFILLER_179_809 VDD VDD VSS VSS gf180mcu_as_sc_mcu7t3v3__fillcap_4
XFILLER_187_842 VDD VDD VSS VSS gf180mcu_as_sc_mcu7t3v3__fillcap_8
XTAP_TAPCELL_ROW_82_1_1035 VDD VSS gf180mcu_as_sc_mcu7t3v3__tap_2
XFILLER_174_503 VDD VDD VSS VSS gf180mcu_as_sc_mcu7t3v3__fill_1
X_3640_ VDD VDD VSS VSS _4015_/A _3724_/B _3724_/C _4014_/A _3641_/C gf180mcu_as_sc_mcu7t3v3__ao22_2
XFILLER_179_1238 VDD VDD VSS VSS gf180mcu_as_sc_mcu7t3v3__fill_2
X_3571_ VDD VDD VSS VSS _3925_/D _3781_/S _3571_/C _3571_/D _3572_/D gf180mcu_as_sc_mcu7t3v3__ao211_2
XFILLER_155_783 VDD VDD VSS VSS gf180mcu_as_sc_mcu7t3v3__fillcap_8
X_2522_ VDD VDD VSS VSS _2765_/B _2545_/B _2522_/C _2545_/D gf180mcu_as_sc_mcu7t3v3__nor3_2
X_5241_ VDD VDD VSS VSS _5280_/CLK _5241_/D _5241_/Q gf180mcu_as_sc_mcu7t3v3__dfxtp_2
X_2453_ VDD VDD VSS VSS _2456_/C _2453_/C _5062_/Q _4341_/S gf180mcu_as_sc_mcu7t3v3__aoi21b_2
X_5172_ VDD VDD VSS VSS _5181_/CLK _5172_/D _5172_/Q gf180mcu_as_sc_mcu7t3v3__dfxtp_2
XFILLER_190_1173 VDD VDD VSS VSS gf180mcu_as_sc_mcu7t3v3__fillcap_8
X_4123_ VDD VDD VSS VSS _4124_/C _4123_/B _4123_/A gf180mcu_as_sc_mcu7t3v3__nor2_2
XTAP_TAPCELL_ROW_184_1737 VDD VSS gf180mcu_as_sc_mcu7t3v3__tap_2
Xinput2 VDD VDD VSS VSS boot_addr[10] input2/Y gf180mcu_as_sc_mcu7t3v3__buff_12
X_4054_ VDD VDD VSS VSS _4054_/A _4102_/B _4102_/C _4930_/Q _4055_/D gf180mcu_as_sc_mcu7t3v3__ao22_2
XTAP_TAPCELL_ROW_184_1748 VDD VSS gf180mcu_as_sc_mcu7t3v3__tap_2
X_3005_ VDD VDD VSS VSS _3065_/B _3005_/B _3005_/C _3006_/C gf180mcu_as_sc_mcu7t3v3__nor3_2
X_4956_ VDD VDD VSS VSS _5226_/CLK _4956_/D _4956_/Q gf180mcu_as_sc_mcu7t3v3__dfxtp_2
XFILLER_36_1256 VDD VDD VSS VSS gf180mcu_as_sc_mcu7t3v3__fillcap_8
X_4887_ VDD VDD VSS VSS _4895_/CLK _4887_/D _4887_/Q gf180mcu_as_sc_mcu7t3v3__dfxtp_2
X_3907_ VDD VDD VSS VSS _4950_/Q _3907_/A _4948_/D gf180mcu_as_sc_mcu7t3v3__and2_2
XFILLER_162_1297 VDD VDD VSS VSS gf180mcu_as_sc_mcu7t3v3__fillcap_8
X_3838_ VDD VDD VSS VSS _3839_/B _4753_/A _3838_/B _4911_/Q gf180mcu_as_sc_mcu7t3v3__aoi21_2
XFILLER_165_558 VDD VDD VSS VSS gf180mcu_as_sc_mcu7t3v3__fill_2
Xclkbuf_leaf_16_clk_regs VDD VDD VSS VSS clkbuf_3_6__f_clk_regs/Y _5188_/CLK gf180mcu_as_sc_mcu7t3v3__clkbuff_12
X_3769_ VDD VDD VSS VSS _3769_/B _4151_/D _3771_/C gf180mcu_as_sc_mcu7t3v3__and2_2
XFILLER_10_34 VDD VDD VSS VSS gf180mcu_as_sc_mcu7t3v3__fill_1
XFILLER_161_720 VDD VDD VSS VSS gf180mcu_as_sc_mcu7t3v3__fillcap_16
XFILLER_3_229 VDD VDD VSS VSS gf180mcu_as_sc_mcu7t3v3__fill_1
XFILLER_126_34 VDD VDD VSS VSS gf180mcu_as_sc_mcu7t3v3__fill_1
Xoutput361 VDD VDD VSS VSS _4782_/Q se_out[11] gf180mcu_as_sc_mcu7t3v3__buff_12
Xoutput350 VDD VDD VSS VSS _4871_/Q east_out[32] gf180mcu_as_sc_mcu7t3v3__buff_12
Xoutput394 VDD VDD VSS VSS _4815_/Q south_out[10] gf180mcu_as_sc_mcu7t3v3__buff_12
Xoutput383 VDD VDD VSS VSS _4802_/Q se_out[31] gf180mcu_as_sc_mcu7t3v3__buff_12
Xoutput372 VDD VDD VSS VSS _4792_/Q se_out[21] gf180mcu_as_sc_mcu7t3v3__buff_12
XFILLER_19_54 VDD VDD VSS VSS gf180mcu_as_sc_mcu7t3v3__fill_2
XFILLER_142_44 VDD VDD VSS VSS gf180mcu_as_sc_mcu7t3v3__fill_2
XTAP_TAPCELL_ROW_3_752 VDD VSS gf180mcu_as_sc_mcu7t3v3__tap_2
XTAP_TAPCELL_ROW_3_741 VDD VSS gf180mcu_as_sc_mcu7t3v3__tap_2
XFILLER_163_1028 VDD VDD VSS VSS gf180mcu_as_sc_mcu7t3v3__fillcap_4
X_4893__1075 VDD VDD VSS VSS _4893_/D gf180mcu_as_sc_mcu7t3v3__tiel_4
XFILLER_169_842 VDD VDD VSS VSS gf180mcu_as_sc_mcu7t3v3__fillcap_16
XFILLER_141_1326 VDD VDD VSS VSS gf180mcu_as_sc_mcu7t3v3__fillcap_4
XFILLER_156_503 VDD VDD VSS VSS gf180mcu_as_sc_mcu7t3v3__fillcap_8
XFILLER_180_1353 VDD VDD VSS VSS gf180mcu_as_sc_mcu7t3v3__fill_2
XFILLER_54_1345 VDD VDD VSS VSS gf180mcu_as_sc_mcu7t3v3__fillcap_8
XFILLER_13_1031 VDD VDD VSS VSS gf180mcu_as_sc_mcu7t3v3__fill_2
XFILLER_183_333 VDD VDD VSS VSS gf180mcu_as_sc_mcu7t3v3__fillcap_16
XFILLER_184_889 VDD VDD VSS VSS gf180mcu_as_sc_mcu7t3v3__fill_2
Xwire466 VDD VDD VSS VSS _3601_/Y _4843_/D gf180mcu_as_sc_mcu7t3v3__clkbuff_12
XTAP_TAPCELL_ROW_143_1_1096 VDD VSS gf180mcu_as_sc_mcu7t3v3__tap_2
XFILLER_13_1064 VDD VDD VSS VSS gf180mcu_as_sc_mcu7t3v3__fillcap_4
Xwire488 VDD VDD VSS VSS _2981_/Y _4774_/D gf180mcu_as_sc_mcu7t3v3__clkbuff_12
XFILLER_174_1146 VDD VDD VSS VSS gf180mcu_as_sc_mcu7t3v3__fillcap_8
XFILLER_174_1157 VDD VDD VSS VSS gf180mcu_as_sc_mcu7t3v3__fillcap_4
XPHY_EDGE_ROW_71_3_Right_112 VDD VSS gf180mcu_as_sc_mcu7t3v3__tap_2
XTAP_TAPCELL_ROW_166_1401 VDD VSS gf180mcu_as_sc_mcu7t3v3__tap_2
XFILLER_59_1256 VDD VDD VSS VSS gf180mcu_as_sc_mcu7t3v3__fillcap_16
XFILLER_181_1117 VDD VDD VSS VSS gf180mcu_as_sc_mcu7t3v3__fill_2
XFILLER_185_1264 VDD VDD VSS VSS gf180mcu_as_sc_mcu7t3v3__fill_1
X_4810_ VDD VDD VSS VSS clkload3/A _4810_/D _4810_/Q gf180mcu_as_sc_mcu7t3v3__dfxtp_2
XPHY_EDGE_ROW_114_1_Left_306 VDD VSS gf180mcu_as_sc_mcu7t3v3__tap_2
XFILLER_159_330 VDD VDD VSS VSS gf180mcu_as_sc_mcu7t3v3__fillcap_16
XFILLER_159_352 VDD VDD VSS VSS gf180mcu_as_sc_mcu7t3v3__fillcap_4
XFILLER_175_801 VDD VDD VSS VSS gf180mcu_as_sc_mcu7t3v3__fillcap_16
X_4741_ VDD VDD VSS VSS _4742_/B _4741_/C _4741_/B _5275_/Q gf180mcu_as_sc_mcu7t3v3__aoi21_2
X_4672_ VDD VDD VSS VSS _5243_/D _5243_/Q _4685_/C _4672_/C gf180mcu_as_sc_mcu7t3v3__ao21_2
XFILLER_186_193 VDD VDD VSS VSS gf180mcu_as_sc_mcu7t3v3__fillcap_16
XFILLER_190_804 VDD VDD VSS VSS gf180mcu_as_sc_mcu7t3v3__fill_1
X_3623_ VDD VDD VSS VSS _3730_/A _3623_/B _3994_/A _3624_/B gf180mcu_as_sc_mcu7t3v3__mux2_2
XFILLER_179_1068 VDD VDD VSS VSS gf180mcu_as_sc_mcu7t3v3__fill_2
X_3554_ VDD VDD VSS VSS _3561_/B _3801_/C _3554_/A gf180mcu_as_sc_mcu7t3v3__nand2_2
Xmax_cap788 VDD VDD VSS VSS _3828_/B _3869_/A gf180mcu_as_sc_mcu7t3v3__clkbuff_12
X_3485_ VDD VDD VSS VSS _3494_/B _4145_/A _3487_/C gf180mcu_as_sc_mcu7t3v3__and2_2
X_2505_ VDD VDD VSS VSS _5269_/Q _5275_/Q _4736_/B gf180mcu_as_sc_mcu7t3v3__and2_2
XFILLER_118_1339 VDD VDD VSS VSS gf180mcu_as_sc_mcu7t3v3__fillcap_4
XFILLER_192_1257 VDD VDD VSS VSS gf180mcu_as_sc_mcu7t3v3__fill_1
X_5224_ VDD VDD VSS VSS _5266_/CLK _5224_/D _5224_/Q gf180mcu_as_sc_mcu7t3v3__dfxtp_2
X_2436_ VDD VDD VSS VSS _3676_/A _4050_/A gf180mcu_as_sc_mcu7t3v3__inv_2
X_5155_ VDD VDD VSS VSS _5220_/CLK _5155_/D _5155_/Q gf180mcu_as_sc_mcu7t3v3__dfxtp_2
XFILLER_186_1006 VDD VDD VSS VSS gf180mcu_as_sc_mcu7t3v3__fill_2
XFILLER_42_1260 VDD VDD VSS VSS gf180mcu_as_sc_mcu7t3v3__fill_2
X_5086_ VDD VDD VSS VSS _5086_/CLK _5086_/D _5086_/Q gf180mcu_as_sc_mcu7t3v3__dfxtp_2
X_4106_ VDD VDD VSS VSS _4106_/S _4106_/B _4106_/A _4107_/B gf180mcu_as_sc_mcu7t3v3__mux2_2
X_4037_ VDD VDD VSS VSS _4037_/A _4104_/C _4101_/B _4037_/D _4038_/D gf180mcu_as_sc_mcu7t3v3__ao22_2
XTAP_TAPCELL_ROW_0_700 VDD VSS gf180mcu_as_sc_mcu7t3v3__tap_2
XFILLER_77_1323 VDD VDD VSS VSS gf180mcu_as_sc_mcu7t3v3__fill_1
XFILLER_38_1329 VDD VDD VSS VSS gf180mcu_as_sc_mcu7t3v3__fill_1
XPHY_EDGE_ROW_46_1_Left_238 VDD VSS gf180mcu_as_sc_mcu7t3v3__tap_2
XFILLER_12_306 VDD VDD VSS VSS gf180mcu_as_sc_mcu7t3v3__fillcap_8
XFILLER_12_317 VDD VDD VSS VSS gf180mcu_as_sc_mcu7t3v3__fill_1
XFILLER_13_818 VDD VDD VSS VSS gf180mcu_as_sc_mcu7t3v3__fill_1
XFILLER_169_149 VDD VDD VSS VSS gf180mcu_as_sc_mcu7t3v3__fillcap_16
XFILLER_188_18 VDD VDD VSS VSS gf180mcu_as_sc_mcu7t3v3__fillcap_16
XFILLER_12_328 VDD VDD VSS VSS gf180mcu_as_sc_mcu7t3v3__fillcap_16
X_4939_ VDD VDD VSS VSS _5158_/CLK _4939_/D _4939_/Q gf180mcu_as_sc_mcu7t3v3__dfxtp_2
XANTENNA_40 VDD VDD VSS VSS _4803_/D gf180mcu_as_sc_mcu7t3v3__diode_2
XFILLER_162_1083 VDD VDD VSS VSS gf180mcu_as_sc_mcu7t3v3__fill_2
XFILLER_166_823 VDD VDD VSS VSS gf180mcu_as_sc_mcu7t3v3__fill_1
XFILLER_178_694 VDD VDD VSS VSS gf180mcu_as_sc_mcu7t3v3__fillcap_8
XFILLER_184_119 VDD VDD VSS VSS gf180mcu_as_sc_mcu7t3v3__fillcap_4
XANTENNA_51 VDD VDD VSS VSS _4054_/A gf180mcu_as_sc_mcu7t3v3__diode_2
XFILLER_14_1351 VDD VDD VSS VSS gf180mcu_as_sc_mcu7t3v3__fillcap_4
XFILLER_165_344 VDD VDD VSS VSS gf180mcu_as_sc_mcu7t3v3__fillcap_4
XFILLER_166_889 VDD VDD VSS VSS gf180mcu_as_sc_mcu7t3v3__fillcap_8
XFILLER_181_815 VDD VDD VSS VSS gf180mcu_as_sc_mcu7t3v3__fillcap_16
XFILLER_21_88 VDD VDD VSS VSS gf180mcu_as_sc_mcu7t3v3__fillcap_16
XFILLER_4_527 VDD VDD VSS VSS gf180mcu_as_sc_mcu7t3v3__fill_1
XFILLER_84_1305 VDD VDD VSS VSS gf180mcu_as_sc_mcu7t3v3__fill_1
XFILLER_161_550 VDD VDD VSS VSS gf180mcu_as_sc_mcu7t3v3__fill_1
XFILLER_84_1349 VDD VDD VSS VSS gf180mcu_as_sc_mcu7t3v3__fillcap_4
XTAP_TAPCELL_ROW_8_844 VDD VSS gf180mcu_as_sc_mcu7t3v3__tap_2
XFILLER_153_10 VDD VDD VSS VSS gf180mcu_as_sc_mcu7t3v3__fill_1
XFILLER_46_52 VDD VDD VSS VSS gf180mcu_as_sc_mcu7t3v3__fill_1
XPHY_EDGE_ROW_58_3_Right_99 VDD VSS gf180mcu_as_sc_mcu7t3v3__tap_2
XFILLER_62_84 VDD VDD VSS VSS gf180mcu_as_sc_mcu7t3v3__fill_2
XFILLER_8_811 VDD VDD VSS VSS gf180mcu_as_sc_mcu7t3v3__fill_2
XTAP_TAPCELL_ROW_159_1271 VDD VSS gf180mcu_as_sc_mcu7t3v3__tap_2
XTAP_TAPCELL_ROW_159_1260 VDD VSS gf180mcu_as_sc_mcu7t3v3__tap_2
XFILLER_168_193 VDD VDD VSS VSS gf180mcu_as_sc_mcu7t3v3__fillcap_4
XFILLER_180_1194 VDD VDD VSS VSS gf180mcu_as_sc_mcu7t3v3__fillcap_4
XFILLER_172_837 VDD VDD VSS VSS gf180mcu_as_sc_mcu7t3v3__fill_1
XFILLER_8_877 VDD VDD VSS VSS gf180mcu_as_sc_mcu7t3v3__fill_2
XPHY_EDGE_ROW_92_1_Left_284 VDD VSS gf180mcu_as_sc_mcu7t3v3__tap_2
XTAP_TAPCELL_ROW_77_1_1030 VDD VSS gf180mcu_as_sc_mcu7t3v3__tap_2
XFILLER_152_594 VDD VDD VSS VSS gf180mcu_as_sc_mcu7t3v3__fillcap_16
X_3270_ VDD VDD VSS VSS _3270_/Y _3271_/B _3271_/A gf180mcu_as_sc_mcu7t3v3__nor2_2
XPHY_EDGE_ROW_72_3_Right_113 VDD VSS gf180mcu_as_sc_mcu7t3v3__tap_2
XFILLER_152_1252 VDD VDD VSS VSS gf180mcu_as_sc_mcu7t3v3__fillcap_4
Xclkbuf_2_1_0_clk_regs VDD VDD VSS VSS clkbuf_0_clk_regs/Y clkbuf_2_1_0_clk_regs/Y
+ gf180mcu_as_sc_mcu7t3v3__clkbuff_12
XFILLER_187_1348 VDD VDD VSS VSS gf180mcu_as_sc_mcu7t3v3__fillcap_4
XTAP_TAPCELL_ROW_179_1647 VDD VSS gf180mcu_as_sc_mcu7t3v3__tap_2
XFILLER_72_1264 VDD VDD VSS VSS gf180mcu_as_sc_mcu7t3v3__fill_2
X_4724_ VDD VDD VSS VSS _5264_/Q _4730_/B _4730_/C _5263_/Q _4725_/C gf180mcu_as_sc_mcu7t3v3__ao22_2
X_2985_ VDD VDD VSS VSS _3967_/A _3044_/B _3044_/C _3968_/D _2986_/C gf180mcu_as_sc_mcu7t3v3__ao22_2
XFILLER_72_1286 VDD VDD VSS VSS gf180mcu_as_sc_mcu7t3v3__fill_2
XFILLER_163_804 VDD VDD VSS VSS gf180mcu_as_sc_mcu7t3v3__fillcap_16
XFILLER_174_141 VDD VDD VSS VSS gf180mcu_as_sc_mcu7t3v3__fillcap_16
X_4655_ VDD VDD VSS VSS _4656_/B _5239_/Q _4655_/B _4746_/D gf180mcu_as_sc_mcu7t3v3__ao21_2
XFILLER_162_314 VDD VDD VSS VSS gf180mcu_as_sc_mcu7t3v3__fill_1
XFILLER_162_325 VDD VDD VSS VSS gf180mcu_as_sc_mcu7t3v3__fill_1
XFILLER_174_174 VDD VDD VSS VSS gf180mcu_as_sc_mcu7t3v3__fill_1
Xinput60 VDD VDD VSS VSS east_in[24] _4130_/A gf180mcu_as_sc_mcu7t3v3__buff_12
Xinput71 VDD VDD VSS VSS east_in[3] _3960_/A gf180mcu_as_sc_mcu7t3v3__buff_12
Xinput82 VDD VDD VSS VSS ne_in[13] _4037_/A gf180mcu_as_sc_mcu7t3v3__buff_12
X_4586_ VDD VDD VSS VSS _4586_/S _5030_/Q _5059_/Q _4587_/B gf180mcu_as_sc_mcu7t3v3__mux2_2
X_3606_ VDD VDD VSS VSS _3973_/A _3650_/B _3606_/C _3606_/D _3607_/D gf180mcu_as_sc_mcu7t3v3__ao211_2
XFILLER_190_667 VDD VDD VSS VSS gf180mcu_as_sc_mcu7t3v3__fill_2
Xinput93 VDD VDD VSS VSS ne_in[23] _4118_/A gf180mcu_as_sc_mcu7t3v3__buff_12
X_3537_ VDD VDD VSS VSS _3932_/B _3537_/A _3777_/B gf180mcu_as_sc_mcu7t3v3__and2_2
Xmax_cap585 VDD VDD VSS VSS _2945_/Y fanout580/A gf180mcu_as_sc_mcu7t3v3__clkbuff_12
XFILLER_107_69 VDD VDD VSS VSS gf180mcu_as_sc_mcu7t3v3__fill_1
XFILLER_192_1087 VDD VDD VSS VSS gf180mcu_as_sc_mcu7t3v3__fill_1
X_3468_ VDD VDD VSS VSS _4118_/D _3500_/B _3468_/C _3468_/D _3469_/C gf180mcu_as_sc_mcu7t3v3__ao211_2
X_5207_ VDD VDD VSS VSS _5212_/CLK _5207_/D _5207_/Q gf180mcu_as_sc_mcu7t3v3__dfxtp_2
X_3399_ VDD VDD VSS VSS _3505_/S _3399_/B _4050_/A _3400_/B gf180mcu_as_sc_mcu7t3v3__mux2_2
X_2419_ VDD VDD VSS VSS _3240_/A _3522_/A gf180mcu_as_sc_mcu7t3v3__inv_2
X_5138_ VDD VDD VSS VSS _5152_/CLK _5138_/D _5138_/Q gf180mcu_as_sc_mcu7t3v3__dfxtp_2
X_5069_ VDD VDD VSS VSS clkload8/A _5069_/D _5069_/Q gf180mcu_as_sc_mcu7t3v3__dfxtp_2
XFILLER_168_1292 VDD VDD VSS VSS gf180mcu_as_sc_mcu7t3v3__fill_2
XFILLER_164_1167 VDD VDD VSS VSS gf180mcu_as_sc_mcu7t3v3__fillcap_8
Xclkbuf_leaf_31_clk_regs VDD VDD VSS VSS clkbuf_3_4__f_clk_regs/Y _5220_/CLK gf180mcu_as_sc_mcu7t3v3__clkbuff_12
XFILLER_51_1326 VDD VDD VSS VSS gf180mcu_as_sc_mcu7t3v3__fillcap_4
XFILLER_8_107 VDD VDD VSS VSS gf180mcu_as_sc_mcu7t3v3__fill_2
XPHY_EDGE_ROW_50_1_Right_559 VDD VSS gf180mcu_as_sc_mcu7t3v3__tap_2
XFILLER_166_642 VDD VDD VSS VSS gf180mcu_as_sc_mcu7t3v3__fill_1
XFILLER_8_129 VDD VDD VSS VSS gf180mcu_as_sc_mcu7t3v3__fillcap_8
XFILLER_154_804 VDD VDD VSS VSS gf180mcu_as_sc_mcu7t3v3__fill_1
XFILLER_113_2 VDD VDD VSS VSS gf180mcu_as_sc_mcu7t3v3__fillcap_4
XFILLER_148_98 VDD VDD VSS VSS gf180mcu_as_sc_mcu7t3v3__fillcap_4
XFILLER_153_325 VDD VDD VSS VSS gf180mcu_as_sc_mcu7t3v3__fill_1
XFILLER_5_858 VDD VDD VSS VSS gf180mcu_as_sc_mcu7t3v3__fillcap_16
XFILLER_164_53 VDD VDD VSS VSS gf180mcu_as_sc_mcu7t3v3__fillcap_8
XFILLER_175_1296 VDD VDD VSS VSS gf180mcu_as_sc_mcu7t3v3__fillcap_4
XTAP_TAPCELL_ROW_138_1_1091 VDD VSS gf180mcu_as_sc_mcu7t3v3__tap_2
XFILLER_0_552 VDD VDD VSS VSS gf180mcu_as_sc_mcu7t3v3__fill_1
XFILLER_180_30 VDD VDD VSS VSS gf180mcu_as_sc_mcu7t3v3__fillcap_4
XFILLER_112_1291 VDD VDD VSS VSS gf180mcu_as_sc_mcu7t3v3__fillcap_8
XFILLER_147_1321 VDD VDD VSS VSS gf180mcu_as_sc_mcu7t3v3__fill_2
XFILLER_73_72 VDD VDD VSS VSS gf180mcu_as_sc_mcu7t3v3__fillcap_8
XFILLER_189_72 VDD VDD VSS VSS gf180mcu_as_sc_mcu7t3v3__fillcap_8
XTAP_TAPCELL_ROW_110_3_2021 VDD VSS gf180mcu_as_sc_mcu7t3v3__tap_2
X_2770_ VDD VDD VSS VSS _2840_/A _2840_/B _2770_/C _2771_/C _2770_/D gf180mcu_as_sc_mcu7t3v3__oai211_2
XFILLER_156_163 VDD VDD VSS VSS gf180mcu_as_sc_mcu7t3v3__fill_2
XTAP_TAPCELL_ROW_174_1555 VDD VSS gf180mcu_as_sc_mcu7t3v3__tap_2
XTAP_TAPCELL_ROW_174_1544 VDD VSS gf180mcu_as_sc_mcu7t3v3__tap_2
XFILLER_32_1281 VDD VDD VSS VSS gf180mcu_as_sc_mcu7t3v3__fillcap_8
X_4440_ VDD VDD VSS VSS _4440_/D _4581_/A _4440_/B _4440_/C _4441_/B gf180mcu_as_sc_mcu7t3v3__ao31_2
XTAP_TAPCELL_ROW_191_1880 VDD VSS gf180mcu_as_sc_mcu7t3v3__tap_2
XFILLER_160_807 VDD VDD VSS VSS gf180mcu_as_sc_mcu7t3v3__fillcap_4
XTAP_TAPCELL_ROW_10_882 VDD VSS gf180mcu_as_sc_mcu7t3v3__tap_2
X_4371_ VDD VDD VSS VSS _4372_/C _4371_/B _4371_/A gf180mcu_as_sc_mcu7t3v3__nor2b_2
X_3322_ VDD VDD VSS VSS _3419_/B _3975_/A _3323_/D gf180mcu_as_sc_mcu7t3v3__or2_2
X_3253_ VDD VDD VSS VSS _3509_/A _3818_/C _3253_/A gf180mcu_as_sc_mcu7t3v3__nand2_2
X_3184_ VDD VDD VSS VSS _3185_/D _3213_/A gf180mcu_as_sc_mcu7t3v3__inv_2
XPHY_EDGE_ROW_73_3_Right_114 VDD VSS gf180mcu_as_sc_mcu7t3v3__tap_2
XFILLER_187_1112 VDD VDD VSS VSS gf180mcu_as_sc_mcu7t3v3__fillcap_8
XFILLER_6_1157 VDD VDD VSS VSS gf180mcu_as_sc_mcu7t3v3__fill_2
XFILLER_179_200 VDD VDD VSS VSS gf180mcu_as_sc_mcu7t3v3__fillcap_8
XFILLER_179_244 VDD VDD VSS VSS gf180mcu_as_sc_mcu7t3v3__fillcap_8
X_2968_ VDD VDD VSS VSS _3950_/A _3044_/B _3044_/C _3949_/A _2969_/C gf180mcu_as_sc_mcu7t3v3__ao22_2
XFILLER_176_962 VDD VDD VSS VSS gf180mcu_as_sc_mcu7t3v3__fillcap_16
XFILLER_182_409 VDD VDD VSS VSS gf180mcu_as_sc_mcu7t3v3__fill_1
X_4707_ VDD VDD VSS VSS _4707_/S _5256_/Q _4707_/A _5256_/D gf180mcu_as_sc_mcu7t3v3__mux2_2
X_4638_ VDD VDD VSS VSS _4639_/S _5104_/Q _5229_/Q _5229_/D gf180mcu_as_sc_mcu7t3v3__mux2_2
X_2899_ VDD VDD VSS VSS _4946_/Q _4945_/Q _3249_/B gf180mcu_as_sc_mcu7t3v3__and2_2
XTAP_TAPCELL_ROW_45_3_1956 VDD VSS gf180mcu_as_sc_mcu7t3v3__tap_2
XFILLER_11_1343 VDD VDD VSS VSS gf180mcu_as_sc_mcu7t3v3__fillcap_8
XFILLER_159_1247 VDD VDD VSS VSS gf180mcu_as_sc_mcu7t3v3__fill_2
XFILLER_162_155 VDD VDD VSS VSS gf180mcu_as_sc_mcu7t3v3__fill_1
XFILLER_162_166 VDD VDD VSS VSS gf180mcu_as_sc_mcu7t3v3__fill_2
XFILLER_162_177 VDD VDD VSS VSS gf180mcu_as_sc_mcu7t3v3__fillcap_16
X_4569_ VDD VDD VSS VSS _4572_/C _4999_/Q _4570_/S gf180mcu_as_sc_mcu7t3v3__nand2b_2
XFILLER_1_349 VDD VDD VSS VSS gf180mcu_as_sc_mcu7t3v3__fill_1
XFILLER_134_34 VDD VDD VSS VSS gf180mcu_as_sc_mcu7t3v3__fill_1
XFILLER_134_45 VDD VDD VSS VSS gf180mcu_as_sc_mcu7t3v3__fill_2
XFILLER_135_1280 VDD VDD VSS VSS gf180mcu_as_sc_mcu7t3v3__fillcap_4
Xmesh_tile_1008 VDD VDD VSS VSS nw_out[14] gf180mcu_as_sc_mcu7t3v3__tiel_4
Xmesh_tile_1019 VDD VDD VSS VSS nw_out[25] gf180mcu_as_sc_mcu7t3v3__tiel_4
XFILLER_150_22 VDD VDD VSS VSS gf180mcu_as_sc_mcu7t3v3__fillcap_8
XFILLER_43_31 VDD VDD VSS VSS gf180mcu_as_sc_mcu7t3v3__fill_2
XFILLER_185_203 VDD VDD VSS VSS gf180mcu_as_sc_mcu7t3v3__fillcap_4
XFILLER_186_726 VDD VDD VSS VSS gf180mcu_as_sc_mcu7t3v3__fillcap_8
XFILLER_186_737 VDD VDD VSS VSS gf180mcu_as_sc_mcu7t3v3__fillcap_4
XFILLER_185_247 VDD VDD VSS VSS gf180mcu_as_sc_mcu7t3v3__fill_2
XFILLER_166_461 VDD VDD VSS VSS gf180mcu_as_sc_mcu7t3v3__fill_1
XFILLER_16_1287 VDD VDD VSS VSS gf180mcu_as_sc_mcu7t3v3__fill_2
XFILLER_185_269 VDD VDD VSS VSS gf180mcu_as_sc_mcu7t3v3__fillcap_8
XFILLER_182_943 VDD VDD VSS VSS gf180mcu_as_sc_mcu7t3v3__fill_2
XTAP_TAPCELL_ROW_152_1116 VDD VSS gf180mcu_as_sc_mcu7t3v3__tap_2
XTAP_TAPCELL_ROW_152_1105 VDD VSS gf180mcu_as_sc_mcu7t3v3__tap_2
XFILLER_154_667 VDD VDD VSS VSS gf180mcu_as_sc_mcu7t3v3__fillcap_4
XTAP_TAPCELL_ROW_152_1138 VDD VSS gf180mcu_as_sc_mcu7t3v3__tap_2
XTAP_TAPCELL_ROW_152_1127 VDD VSS gf180mcu_as_sc_mcu7t3v3__tap_2
XFILLER_153_166 VDD VDD VSS VSS gf180mcu_as_sc_mcu7t3v3__fill_2
XFILLER_154_689 VDD VDD VSS VSS gf180mcu_as_sc_mcu7t3v3__fillcap_4
XFILLER_5_699 VDD VDD VSS VSS gf180mcu_as_sc_mcu7t3v3__fill_1
XPHY_EDGE_ROW_123_1_Left_315 VDD VSS gf180mcu_as_sc_mcu7t3v3__tap_2
XFILLER_97_1304 VDD VDD VSS VSS gf180mcu_as_sc_mcu7t3v3__fillcap_4
Xinput250 VDD VDD VSS VSS sw_in[10] _4018_/A gf180mcu_as_sc_mcu7t3v3__buff_12
Xinput261 VDD VDD VSS VSS sw_in[20] _2442_/A gf180mcu_as_sc_mcu7t3v3__buff_12
Xinput272 VDD VDD VSS VSS sw_in[30] _3803_/A gf180mcu_as_sc_mcu7t3v3__buff_12
XFILLER_97_1326 VDD VDD VSS VSS gf180mcu_as_sc_mcu7t3v3__fillcap_4
Xinput283 VDD VDD VSS VSS west_in[0] _3925_/D gf180mcu_as_sc_mcu7t3v3__buff_12
Xinput294 VDD VDD VSS VSS west_in[1] _3938_/D gf180mcu_as_sc_mcu7t3v3__buff_12
XFILLER_1_1032 VDD VDD VSS VSS gf180mcu_as_sc_mcu7t3v3__fillcap_4
X_3940_ VDD VDD VSS VSS _3940_/A _4023_/B _4023_/C _4916_/Q _3942_/C gf180mcu_as_sc_mcu7t3v3__ao22_2
X_3871_ VDD VDD VSS VSS _3872_/D _3871_/B _3871_/A gf180mcu_as_sc_mcu7t3v3__nand2_2
X_2822_ VDD VDD VSS VSS _4974_/D _2829_/B _4760_/Q _4759_/D gf180mcu_as_sc_mcu7t3v3__mux2_2
XFILLER_158_984 VDD VDD VSS VSS gf180mcu_as_sc_mcu7t3v3__fill_2
XFILLER_9_972 VDD VDD VSS VSS gf180mcu_as_sc_mcu7t3v3__fillcap_8
X_2753_ VDD VDD VSS VSS _2833_/A _4751_/A _4718_/A _2780_/B _2754_/D gf180mcu_as_sc_mcu7t3v3__aoi31_2
XFILLER_172_420 VDD VDD VSS VSS gf180mcu_as_sc_mcu7t3v3__fillcap_8
XFILLER_191_228 VDD VDD VSS VSS gf180mcu_as_sc_mcu7t3v3__fill_2
X_2684_ VDD VDD VSS VSS _2735_/A _2684_/B _2684_/C _2735_/D _2686_/C gf180mcu_as_sc_mcu7t3v3__ao211_2
XFILLER_160_615 VDD VDD VSS VSS gf180mcu_as_sc_mcu7t3v3__fillcap_4
X_4423_ VDD VDD VSS VSS _4423_/B _4524_/A _4424_/D gf180mcu_as_sc_mcu7t3v3__and2_2
XFILLER_158_1280 VDD VDD VSS VSS gf180mcu_as_sc_mcu7t3v3__fill_1
XFILLER_160_648 VDD VDD VSS VSS gf180mcu_as_sc_mcu7t3v3__fillcap_4
X_4354_ VDD VDD VSS VSS _4354_/B _5159_/Q _4355_/A gf180mcu_as_sc_mcu7t3v3__xnor2_2
XPHY_EDGE_ROW_55_1_Left_247 VDD VSS gf180mcu_as_sc_mcu7t3v3__tap_2
XPHY_EDGE_ROW_119_3_Left_491 VDD VSS gf180mcu_as_sc_mcu7t3v3__tap_2
X_3305_ VDD VDD VSS VSS _3386_/D _3960_/A _3306_/D gf180mcu_as_sc_mcu7t3v3__and2_2
XFILLER_119_1297 VDD VDD VSS VSS gf180mcu_as_sc_mcu7t3v3__fillcap_4
X_4285_ VDD VDD VSS VSS _4289_/S _4696_/B _5119_/Q _5119_/D gf180mcu_as_sc_mcu7t3v3__mux2_2
X_3236_ VDD VDD VSS VSS _3236_/D _3236_/A _3236_/B _3236_/C _3237_/C gf180mcu_as_sc_mcu7t3v3__ao31_2
XPHY_EDGE_ROW_74_3_Right_115 VDD VSS gf180mcu_as_sc_mcu7t3v3__tap_2
XFILLER_104_37 VDD VDD VSS VSS gf180mcu_as_sc_mcu7t3v3__fillcap_8
X_3167_ VDD VDD VSS VSS _3176_/S _4143_/A _4145_/A _3170_/B gf180mcu_as_sc_mcu7t3v3__mux2_2
X_3098_ VDD VDD VSS VSS _4788_/D _3098_/C _3141_/B _4075_/A gf180mcu_as_sc_mcu7t3v3__aoi21_2
XFILLER_120_47 VDD VDD VSS VSS gf180mcu_as_sc_mcu7t3v3__fillcap_8
XFILLER_78_1281 VDD VDD VSS VSS gf180mcu_as_sc_mcu7t3v3__fillcap_8
XFILLER_11_905 VDD VDD VSS VSS gf180mcu_as_sc_mcu7t3v3__fillcap_4
XFILLER_161_1126 VDD VDD VSS VSS gf180mcu_as_sc_mcu7t3v3__fill_2
XFILLER_165_1262 VDD VDD VSS VSS gf180mcu_as_sc_mcu7t3v3__fillcap_8
XFILLER_168_737 VDD VDD VSS VSS gf180mcu_as_sc_mcu7t3v3__fillcap_16
XFILLER_80_29 VDD VDD VSS VSS gf180mcu_as_sc_mcu7t3v3__fill_2
XFILLER_10_459 VDD VDD VSS VSS gf180mcu_as_sc_mcu7t3v3__fill_1
XFILLER_7_909 VDD VDD VSS VSS gf180mcu_as_sc_mcu7t3v3__fill_1
XFILLER_164_932 VDD VDD VSS VSS gf180mcu_as_sc_mcu7t3v3__fill_1
XFILLER_163_486 VDD VDD VSS VSS gf180mcu_as_sc_mcu7t3v3__fillcap_4
XFILLER_145_22 VDD VDD VSS VSS gf180mcu_as_sc_mcu7t3v3__fill_2
XFILLER_172_1277 VDD VDD VSS VSS gf180mcu_as_sc_mcu7t3v3__fill_1
XFILLER_22_1291 VDD VDD VSS VSS gf180mcu_as_sc_mcu7t3v3__fillcap_8
XFILLER_57_1310 VDD VDD VSS VSS gf180mcu_as_sc_mcu7t3v3__fill_1
XFILLER_159_726 VDD VDD VSS VSS gf180mcu_as_sc_mcu7t3v3__fillcap_4
XFILLER_92_1256 VDD VDD VSS VSS gf180mcu_as_sc_mcu7t3v3__fill_1
XFILLER_186_556 VDD VDD VSS VSS gf180mcu_as_sc_mcu7t3v3__fillcap_16
XFILLER_9_224 VDD VDD VSS VSS gf180mcu_as_sc_mcu7t3v3__fill_2
XTAP_TAPCELL_ROW_12_922 VDD VSS gf180mcu_as_sc_mcu7t3v3__tap_2
XTAP_TAPCELL_ROW_12_911 VDD VSS gf180mcu_as_sc_mcu7t3v3__tap_2
XFILLER_167_792 VDD VDD VSS VSS gf180mcu_as_sc_mcu7t3v3__fillcap_16
XFILLER_173_228 VDD VDD VSS VSS gf180mcu_as_sc_mcu7t3v3__fillcap_4
Xclkload16 VDD VDD VSS VSS _5216_/CLK clkload16/Y gf180mcu_as_sc_mcu7t3v3__clkbuff_4
XTAP_TAPCELL_ROW_171_1503 VDD VSS gf180mcu_as_sc_mcu7t3v3__tap_2
XFILLER_177_1111 VDD VDD VSS VSS gf180mcu_as_sc_mcu7t3v3__fillcap_8
XFILLER_177_1122 VDD VDD VSS VSS gf180mcu_as_sc_mcu7t3v3__fillcap_8
Xclkload27 VDD VDD VSS VSS clkload27/Y _5285_/CLK gf180mcu_as_sc_mcu7t3v3__inv_2
XFILLER_170_913 VDD VDD VSS VSS gf180mcu_as_sc_mcu7t3v3__fill_2
XFILLER_181_294 VDD VDD VSS VSS gf180mcu_as_sc_mcu7t3v3__fillcap_16
XFILLER_5_496 VDD VDD VSS VSS gf180mcu_as_sc_mcu7t3v3__fill_1
XTAP_TAPCELL_ROW_169_1465 VDD VSS gf180mcu_as_sc_mcu7t3v3__tap_2
XTAP_TAPCELL_ROW_169_1454 VDD VSS gf180mcu_as_sc_mcu7t3v3__tap_2
X_4070_ VDD VDD VSS VSS _4070_/A _4162_/B _4086_/C _4070_/D _4074_/A gf180mcu_as_sc_mcu7t3v3__ao211_2
X_3021_ VDD VDD VSS VSS _4001_/A _3207_/S _3021_/C _3021_/D _3022_/C gf180mcu_as_sc_mcu7t3v3__ao22_2
XTAP_TAPCELL_ROW_182_1698 VDD VSS gf180mcu_as_sc_mcu7t3v3__tap_2
X_4972_ VDD VDD VSS VSS _5164_/CLK _4972_/D _4972_/Q gf180mcu_as_sc_mcu7t3v3__dfxtp_2
X_3923_ VDD VDD VSS VSS _3923_/B _3923_/A _3923_/Y gf180mcu_as_sc_mcu7t3v3__and2_2
XFILLER_177_523 VDD VDD VSS VSS gf180mcu_as_sc_mcu7t3v3__fill_1
X_3854_ VDD VDD VSS VSS _5148_/Q _5147_/Q _3855_/C gf180mcu_as_sc_mcu7t3v3__or2_2
XFILLER_177_556 VDD VDD VSS VSS gf180mcu_as_sc_mcu7t3v3__fillcap_4
XFILLER_177_589 VDD VDD VSS VSS gf180mcu_as_sc_mcu7t3v3__fill_1
X_2805_ VDD VDD VSS VSS _2840_/D _2805_/A _2806_/C gf180mcu_as_sc_mcu7t3v3__and2_2
XFILLER_192_537 VDD VDD VSS VSS gf180mcu_as_sc_mcu7t3v3__fill_2
X_3785_ VDD VDD VSS VSS _3785_/B _3795_/A _4867_/D gf180mcu_as_sc_mcu7t3v3__and2_2
X_2736_ VDD VDD VSS VSS _2737_/D _2736_/C _2736_/B _2736_/A gf180mcu_as_sc_mcu7t3v3__aoi21b_2
X_2667_ VDD VDD VSS VSS input9/Y _2722_/B _2667_/C _2668_/C _2736_/C gf180mcu_as_sc_mcu7t3v3__aoi211_2
XFILLER_191_1119 VDD VDD VSS VSS gf180mcu_as_sc_mcu7t3v3__fill_1
X_4406_ VDD VDD VSS VSS _4407_/D _4406_/B _4553_/D gf180mcu_as_sc_mcu7t3v3__nor2_2
X_2598_ VDD VDD VSS VSS _2598_/B _2598_/A _2599_/B gf180mcu_as_sc_mcu7t3v3__and2_2
XFILLER_8_1027 VDD VDD VSS VSS gf180mcu_as_sc_mcu7t3v3__fill_1
X_4337_ VDD VDD VSS VSS _4366_/S _4337_/B _5157_/Q _4345_/B gf180mcu_as_sc_mcu7t3v3__mux2_2
XFILLER_115_69 VDD VDD VSS VSS gf180mcu_as_sc_mcu7t3v3__fill_1
XFILLER_45_1280 VDD VDD VSS VSS gf180mcu_as_sc_mcu7t3v3__fill_2
X_4268_ VDD VDD VSS VSS _4273_/S _4694_/B _5102_/Q _5102_/D gf180mcu_as_sc_mcu7t3v3__mux2_2
X_3219_ VDD VDD VSS VSS _4801_/D _3219_/B _3775_/D gf180mcu_as_sc_mcu7t3v3__nor2_2
X_4199_ VDD VDD VSS VSS _4199_/Y _4217_/B _4199_/A gf180mcu_as_sc_mcu7t3v3__nor2_2
XPHY_EDGE_ROW_75_3_Right_116 VDD VSS gf180mcu_as_sc_mcu7t3v3__tap_2
XFILLER_91_39 VDD VDD VSS VSS gf180mcu_as_sc_mcu7t3v3__fillcap_4
XFILLER_11_702 VDD VDD VSS VSS gf180mcu_as_sc_mcu7t3v3__fillcap_8
XFILLER_168_523 VDD VDD VSS VSS gf180mcu_as_sc_mcu7t3v3__fill_2
XFILLER_10_212 VDD VDD VSS VSS gf180mcu_as_sc_mcu7t3v3__fillcap_16
XFILLER_24_99 VDD VDD VSS VSS gf180mcu_as_sc_mcu7t3v3__fillcap_4
XFILLER_104_1341 VDD VDD VSS VSS gf180mcu_as_sc_mcu7t3v3__fill_1
XFILLER_155_228 VDD VDD VSS VSS gf180mcu_as_sc_mcu7t3v3__fillcap_4
XFILLER_40_43 VDD VDD VSS VSS gf180mcu_as_sc_mcu7t3v3__fill_1
XFILLER_156_32 VDD VDD VSS VSS gf180mcu_as_sc_mcu7t3v3__fill_2
XFILLER_3_912 VDD VDD VSS VSS gf180mcu_as_sc_mcu7t3v3__fillcap_8
XFILLER_123_103 VDD VDD VSS VSS gf180mcu_as_sc_mcu7t3v3__fill_2
XFILLER_3_967 VDD VDD VSS VSS gf180mcu_as_sc_mcu7t3v3__fill_1
XFILLER_172_53 VDD VDD VSS VSS gf180mcu_as_sc_mcu7t3v3__fill_2
XFILLER_172_86 VDD VDD VSS VSS gf180mcu_as_sc_mcu7t3v3__fillcap_16
Xfanout770 VDD VDD VSS VSS _2857_/Y _4733_/C gf180mcu_as_sc_mcu7t3v3__buff_12
Xfanout781 VDD VDD VSS VSS fanout781/A _3176_/S gf180mcu_as_sc_mcu7t3v3__buff_12
Xfanout792 VDD VDD VSS VSS _4167_/Y _4197_/B gf180mcu_as_sc_mcu7t3v3__buff_12
XFILLER_105_80 VDD VDD VSS VSS gf180mcu_as_sc_mcu7t3v3__fillcap_4
XFILLER_111_1323 VDD VDD VSS VSS gf180mcu_as_sc_mcu7t3v3__fill_1
XTAP_TAPCELL_ROW_164_1362 VDD VSS gf180mcu_as_sc_mcu7t3v3__tap_2
XFILLER_94_1329 VDD VDD VSS VSS gf180mcu_as_sc_mcu7t3v3__fill_1
XFILLER_159_545 VDD VDD VSS VSS gf180mcu_as_sc_mcu7t3v3__fillcap_4
XFILLER_183_1192 VDD VDD VSS VSS gf180mcu_as_sc_mcu7t3v3__fillcap_16
X_3570_ VDD VDD VSS VSS _3926_/A _3792_/B _3791_/B _3925_/A _3571_/D gf180mcu_as_sc_mcu7t3v3__ao22_2
XFILLER_161_209 VDD VDD VSS VSS gf180mcu_as_sc_mcu7t3v3__fill_1
X_2521_ VDD VDD VSS VSS _2522_/C _4739_/A _5270_/Q _5269_/Q gf180mcu_as_sc_mcu7t3v3__aoi21_2
XFILLER_155_795 VDD VDD VSS VSS gf180mcu_as_sc_mcu7t3v3__fill_2
XFILLER_6_794 VDD VDD VSS VSS gf180mcu_as_sc_mcu7t3v3__fill_2
X_5240_ VDD VDD VSS VSS _5266_/CLK _5240_/D _5240_/Q gf180mcu_as_sc_mcu7t3v3__dfxtp_2
XFILLER_68_1291 VDD VDD VSS VSS gf180mcu_as_sc_mcu7t3v3__fillcap_4
X_2452_ VDD VDD VSS VSS _2453_/C _4341_/S _5033_/Q _4588_/A gf180mcu_as_sc_mcu7t3v3__ao21_2
X_5171_ VDD VDD VSS VSS _5181_/CLK _5171_/D _5171_/Q gf180mcu_as_sc_mcu7t3v3__dfxtp_2
XPHY_EDGE_ROW_141_1_Right_650 VDD VSS gf180mcu_as_sc_mcu7t3v3__tap_2
XFILLER_116_1256 VDD VDD VSS VSS gf180mcu_as_sc_mcu7t3v3__fillcap_16
XFILLER_155_1294 VDD VDD VSS VSS gf180mcu_as_sc_mcu7t3v3__fillcap_16
XFILLER_190_1185 VDD VDD VSS VSS gf180mcu_as_sc_mcu7t3v3__fill_2
X_4122_ VDD VDD VSS VSS _4122_/A _4163_/B _4122_/C _4122_/D _4123_/B gf180mcu_as_sc_mcu7t3v3__ao211_2
XTAP_TAPCELL_ROW_184_1738 VDD VSS gf180mcu_as_sc_mcu7t3v3__tap_2
X_4053_ VDD VDD VSS VSS _4053_/A _4101_/B _4101_/C _4053_/D _4055_/C gf180mcu_as_sc_mcu7t3v3__ao22_2
XTAP_TAPCELL_ROW_184_1749 VDD VSS gf180mcu_as_sc_mcu7t3v3__tap_2
Xinput3 VDD VDD VSS VSS boot_addr[1] input3/Y gf180mcu_as_sc_mcu7t3v3__buff_12
X_3004_ VDD VDD VSS VSS _3985_/A _3047_/B _3004_/C _3004_/D _3005_/C gf180mcu_as_sc_mcu7t3v3__ao22_2
XFILLER_51_101 VDD VDD VSS VSS gf180mcu_as_sc_mcu7t3v3__fillcap_4
XFILLER_101_38 VDD VDD VSS VSS gf180mcu_as_sc_mcu7t3v3__fillcap_4
X_4955_ VDD VDD VSS VSS _5277_/CLK _4955_/D _4955_/Q gf180mcu_as_sc_mcu7t3v3__dfxtp_2
XFILLER_162_1243 VDD VDD VSS VSS gf180mcu_as_sc_mcu7t3v3__fillcap_8
XFILLER_75_1295 VDD VDD VSS VSS gf180mcu_as_sc_mcu7t3v3__fill_2
X_3906_ VDD VDD VSS VSS _3906_/S _3906_/B _4947_/Q _4947_/D gf180mcu_as_sc_mcu7t3v3__mux2_2
XFILLER_162_1276 VDD VDD VSS VSS gf180mcu_as_sc_mcu7t3v3__fillcap_16
X_4886_ VDD VDD VSS VSS _4895_/CLK _4886_/D _4886_/Q gf180mcu_as_sc_mcu7t3v3__dfxtp_2
XFILLER_192_312 VDD VDD VSS VSS gf180mcu_as_sc_mcu7t3v3__fill_1
X_3837_ VDD VDD VSS VSS _3838_/B _4911_/Q _3839_/A gf180mcu_as_sc_mcu7t3v3__or2_2
X_3768_ VDD VDD VSS VSS _3768_/B _3795_/A _4865_/D gf180mcu_as_sc_mcu7t3v3__and2_2
XFILLER_192_367 VDD VDD VSS VSS gf180mcu_as_sc_mcu7t3v3__fill_2
X_2719_ VDD VDD VSS VSS _5162_/Q _4272_/S _4275_/S _5186_/Q _2720_/B gf180mcu_as_sc_mcu7t3v3__ao22_2
XFILLER_105_103 VDD VDD VSS VSS gf180mcu_as_sc_mcu7t3v3__fill_2
X_3699_ VDD VDD VSS VSS _4075_/A _3723_/B _3699_/C _3699_/Y _3699_/D gf180mcu_as_sc_mcu7t3v3__aoi211_2
XFILLER_160_242 VDD VDD VSS VSS gf180mcu_as_sc_mcu7t3v3__fill_2
Xoutput362 VDD VDD VSS VSS _4783_/Q se_out[12] gf180mcu_as_sc_mcu7t3v3__buff_12
Xoutput351 VDD VDD VSS VSS _4872_/Q east_out[33] gf180mcu_as_sc_mcu7t3v3__buff_12
Xoutput340 VDD VDD VSS VSS _4862_/Q east_out[23] gf180mcu_as_sc_mcu7t3v3__buff_12
XFILLER_0_926 VDD VDD VSS VSS gf180mcu_as_sc_mcu7t3v3__fill_1
Xoutput395 VDD VDD VSS VSS _4816_/Q south_out[11] gf180mcu_as_sc_mcu7t3v3__buff_12
Xoutput384 VDD VDD VSS VSS _4803_/Q se_out[32] gf180mcu_as_sc_mcu7t3v3__buff_12
Xoutput373 VDD VDD VSS VSS _4793_/Q se_out[22] gf180mcu_as_sc_mcu7t3v3__buff_12
XFILLER_82_1288 VDD VDD VSS VSS gf180mcu_as_sc_mcu7t3v3__fill_1
XFILLER_82_1299 VDD VDD VSS VSS gf180mcu_as_sc_mcu7t3v3__fillcap_4
XPHY_EDGE_ROW_15_1_Right_524 VDD VSS gf180mcu_as_sc_mcu7t3v3__tap_2
XFILLER_142_34 VDD VDD VSS VSS gf180mcu_as_sc_mcu7t3v3__fill_1
XFILLER_19_88 VDD VDD VSS VSS gf180mcu_as_sc_mcu7t3v3__fillcap_8
XTAP_TAPCELL_ROW_3_753 VDD VSS gf180mcu_as_sc_mcu7t3v3__tap_2
XTAP_TAPCELL_ROW_3_742 VDD VSS gf180mcu_as_sc_mcu7t3v3__tap_2
XPHY_EDGE_ROW_76_3_Right_117 VDD VSS gf180mcu_as_sc_mcu7t3v3__tap_2
XPHY_EDGE_ROW_153_Left_345 VDD VSS gf180mcu_as_sc_mcu7t3v3__tap_2
XFILLER_35_76 VDD VDD VSS VSS gf180mcu_as_sc_mcu7t3v3__fill_1
XFILLER_15_1319 VDD VDD VSS VSS gf180mcu_as_sc_mcu7t3v3__fillcap_4
XFILLER_184_835 VDD VDD VSS VSS gf180mcu_as_sc_mcu7t3v3__fillcap_16
XPHY_EDGE_ROW_132_1_Left_324 VDD VSS gf180mcu_as_sc_mcu7t3v3__tap_2
Xwire467 VDD VDD VSS VSS _3594_/Y _4842_/D gf180mcu_as_sc_mcu7t3v3__clkbuff_12
XFILLER_171_507 VDD VDD VSS VSS gf180mcu_as_sc_mcu7t3v3__fillcap_16
Xwire489 VDD VDD VSS VSS _2973_/Y _4773_/D gf180mcu_as_sc_mcu7t3v3__clkbuff_12
XPHY_EDGE_ROW_162_Left_354 VDD VSS gf180mcu_as_sc_mcu7t3v3__tap_2
XFILLER_174_1103 VDD VDD VSS VSS gf180mcu_as_sc_mcu7t3v3__fillcap_8
XFILLER_3_720 VDD VDD VSS VSS gf180mcu_as_sc_mcu7t3v3__fill_1
XFILLER_139_1256 VDD VDD VSS VSS gf180mcu_as_sc_mcu7t3v3__fill_2
XTAP_TAPCELL_ROW_166_1402 VDD VSS gf180mcu_as_sc_mcu7t3v3__tap_2
XFILLER_4_1211 VDD VDD VSS VSS gf180mcu_as_sc_mcu7t3v3__fill_2
XPHY_EDGE_ROW_171_Left_363 VDD VSS gf180mcu_as_sc_mcu7t3v3__tap_2
XFILLER_185_1221 VDD VDD VSS VSS gf180mcu_as_sc_mcu7t3v3__fillcap_8
XFILLER_179_629 VDD VDD VSS VSS gf180mcu_as_sc_mcu7t3v3__fill_1
XFILLER_92_71 VDD VDD VSS VSS gf180mcu_as_sc_mcu7t3v3__fill_1
X_4740_ VDD VDD VSS VSS _4740_/B _4750_/B _5271_/D gf180mcu_as_sc_mcu7t3v3__and2_2
XPHY_EDGE_ROW_64_1_Left_256 VDD VSS gf180mcu_as_sc_mcu7t3v3__tap_2
X_4671_ VDD VDD VSS VSS _5113_/Q _4683_/C _4681_/C _5244_/Q _4672_/C gf180mcu_as_sc_mcu7t3v3__ao22_2
XFILLER_179_1014 VDD VDD VSS VSS gf180mcu_as_sc_mcu7t3v3__fillcap_8
XFILLER_35_1290 VDD VDD VSS VSS gf180mcu_as_sc_mcu7t3v3__fill_1
X_3622_ VDD VDD VSS VSS _3623_/B _3993_/A _3653_/B _3622_/C gf180mcu_as_sc_mcu7t3v3__ao21_2
XPHY_EDGE_ROW_180_Left_372 VDD VSS gf180mcu_as_sc_mcu7t3v3__tap_2
XFILLER_155_581 VDD VDD VSS VSS gf180mcu_as_sc_mcu7t3v3__fill_1
XFILLER_157_1301 VDD VDD VSS VSS gf180mcu_as_sc_mcu7t3v3__fillcap_16
X_3553_ VDD VDD VSS VSS _3801_/C _3814_/A _3553_/A gf180mcu_as_sc_mcu7t3v3__nor2b_2
XFILLER_192_1247 VDD VDD VSS VSS gf180mcu_as_sc_mcu7t3v3__fillcap_4
Xmax_cap778 VDD VDD VSS VSS _3059_/S _3126_/S gf180mcu_as_sc_mcu7t3v3__clkbuff_12
X_3484_ VDD VDD VSS VSS _3484_/B _3525_/A _4830_/D gf180mcu_as_sc_mcu7t3v3__and2_2
X_2504_ VDD VDD VSS VSS _2546_/B _2546_/A _2745_/A gf180mcu_as_sc_mcu7t3v3__xnor2_2
XFILLER_9_1122 VDD VDD VSS VSS gf180mcu_as_sc_mcu7t3v3__fillcap_4
X_5223_ VDD VDD VSS VSS _5280_/CLK _5223_/D _5223_/Q gf180mcu_as_sc_mcu7t3v3__dfxtp_2
X_2435_ VDD VDD VSS VSS _4043_/A _2435_/A gf180mcu_as_sc_mcu7t3v3__inv_2
XPHY_EDGE_ROW_147_3_Left_519 VDD VSS gf180mcu_as_sc_mcu7t3v3__tap_2
X_5154_ VDD VDD VSS VSS _5278_/CLK _5154_/D _5154_/Q gf180mcu_as_sc_mcu7t3v3__dfxtp_2
XFILLER_9_1166 VDD VDD VSS VSS gf180mcu_as_sc_mcu7t3v3__fillcap_8
X_4105_ VDD VDD VSS VSS _4105_/A _4105_/B _4105_/C _4105_/D _4106_/B gf180mcu_as_sc_mcu7t3v3__ao211_2
XPHY_EDGE_ROW_142_1_Right_651 VDD VSS gf180mcu_as_sc_mcu7t3v3__tap_2
X_5085_ VDD VDD VSS VSS _5178_/CLK _5085_/D _5085_/Q gf180mcu_as_sc_mcu7t3v3__dfxtp_2
X_4036_ VDD VDD VSS VSS _4990_/Q _4150_/B _4241_/B _4150_/D _4990_/D gf180mcu_as_sc_mcu7t3v3__ao22_2
XFILLER_112_37 VDD VDD VSS VSS gf180mcu_as_sc_mcu7t3v3__fillcap_4
X_4938_ VDD VDD VSS VSS _5158_/CLK _4938_/D _4938_/Q gf180mcu_as_sc_mcu7t3v3__dfxtp_2
XANTENNA_30 VDD VDD VSS VSS _4692_/B gf180mcu_as_sc_mcu7t3v3__diode_2
XANTENNA_41 VDD VDD VSS VSS _4805_/D gf180mcu_as_sc_mcu7t3v3__diode_2
X_4869_ VDD VDD VSS VSS _5097_/CLK _4869_/D _4869_/Q gf180mcu_as_sc_mcu7t3v3__dfxtp_2
XFILLER_165_323 VDD VDD VSS VSS gf180mcu_as_sc_mcu7t3v3__fill_2
XFILLER_166_868 VDD VDD VSS VSS gf180mcu_as_sc_mcu7t3v3__fillcap_4
XFILLER_177_194 VDD VDD VSS VSS gf180mcu_as_sc_mcu7t3v3__fillcap_4
XFILLER_101_1322 VDD VDD VSS VSS gf180mcu_as_sc_mcu7t3v3__fill_2
XFILLER_192_142 VDD VDD VSS VSS gf180mcu_as_sc_mcu7t3v3__fill_2
XFILLER_10_1227 VDD VDD VSS VSS gf180mcu_as_sc_mcu7t3v3__fillcap_8
XFILLER_21_67 VDD VDD VSS VSS gf180mcu_as_sc_mcu7t3v3__fill_2
XFILLER_137_67 VDD VDD VSS VSS gf180mcu_as_sc_mcu7t3v3__fill_2
XFILLER_97_49 VDD VDD VSS VSS gf180mcu_as_sc_mcu7t3v3__fillcap_4
XTAP_TAPCELL_ROW_8_845 VDD VSS gf180mcu_as_sc_mcu7t3v3__tap_2
XTAP_TAPCELL_ROW_8_834 VDD VSS gf180mcu_as_sc_mcu7t3v3__tap_2
XFILLER_0_745 VDD VDD VSS VSS gf180mcu_as_sc_mcu7t3v3__fill_2
XTAP_TAPCELL_ROW_161_1310 VDD VSS gf180mcu_as_sc_mcu7t3v3__tap_2
XPHY_EDGE_ROW_16_1_Right_525 VDD VSS gf180mcu_as_sc_mcu7t3v3__tap_2
XPHY_EDGE_ROW_77_3_Right_118 VDD VSS gf180mcu_as_sc_mcu7t3v3__tap_2
XFILLER_169_640 VDD VDD VSS VSS gf180mcu_as_sc_mcu7t3v3__fillcap_4
XFILLER_180_1140 VDD VDD VSS VSS gf180mcu_as_sc_mcu7t3v3__fillcap_8
XFILLER_30_104 VDD VDD VSS VSS gf180mcu_as_sc_mcu7t3v3__fill_1
XFILLER_62_41 VDD VDD VSS VSS gf180mcu_as_sc_mcu7t3v3__fill_2
XFILLER_169_673 VDD VDD VSS VSS gf180mcu_as_sc_mcu7t3v3__fillcap_16
XFILLER_180_1173 VDD VDD VSS VSS gf180mcu_as_sc_mcu7t3v3__fillcap_8
XTAP_TAPCELL_ROW_159_1261 VDD VSS gf180mcu_as_sc_mcu7t3v3__tap_2
XFILLER_12_885 VDD VDD VSS VSS gf180mcu_as_sc_mcu7t3v3__fill_2
XFILLER_184_643 VDD VDD VSS VSS gf180mcu_as_sc_mcu7t3v3__fillcap_16
XFILLER_8_845 VDD VDD VSS VSS gf180mcu_as_sc_mcu7t3v3__fillcap_4
XTAP_TAPCELL_ROW_159_1272 VDD VSS gf180mcu_as_sc_mcu7t3v3__tap_2
XFILLER_106_1299 VDD VDD VSS VSS gf180mcu_as_sc_mcu7t3v3__fillcap_4
XFILLER_7_344 VDD VDD VSS VSS gf180mcu_as_sc_mcu7t3v3__fillcap_4
XFILLER_7_69 VDD VDD VSS VSS gf180mcu_as_sc_mcu7t3v3__fill_1
XFILLER_8_889 VDD VDD VSS VSS gf180mcu_as_sc_mcu7t3v3__fillcap_16
XTAP_TAPCELL_ROW_63_3_1974 VDD VSS gf180mcu_as_sc_mcu7t3v3__tap_2
XFILLER_152_562 VDD VDD VSS VSS gf180mcu_as_sc_mcu7t3v3__fillcap_4
XFILLER_180_893 VDD VDD VSS VSS gf180mcu_as_sc_mcu7t3v3__fillcap_16
XFILLER_97_104 VDD VDD VSS VSS gf180mcu_as_sc_mcu7t3v3__fill_1
XFILLER_26_1256 VDD VDD VSS VSS gf180mcu_as_sc_mcu7t3v3__fillcap_4
Xclkbuf_leaf_1_clk_regs VDD VDD VSS VSS clkbuf_leaf_7_clk_regs/A clkload5/A gf180mcu_as_sc_mcu7t3v3__clkbuff_12
XFILLER_21_104 VDD VDD VSS VSS gf180mcu_as_sc_mcu7t3v3__fill_1
X_2984_ VDD VDD VSS VSS _3129_/B _4919_/Q _2987_/C gf180mcu_as_sc_mcu7t3v3__or2_2
XTAP_TAPCELL_ROW_179_1648 VDD VSS gf180mcu_as_sc_mcu7t3v3__tap_2
XFILLER_159_150 VDD VDD VSS VSS gf180mcu_as_sc_mcu7t3v3__fill_2
XFILLER_188_993 VDD VDD VSS VSS gf180mcu_as_sc_mcu7t3v3__fillcap_8
X_4723_ VDD VDD VSS VSS _4723_/B _4723_/A _5262_/D gf180mcu_as_sc_mcu7t3v3__or2_2
XFILLER_187_492 VDD VDD VSS VSS gf180mcu_as_sc_mcu7t3v3__fillcap_8
XFILLER_175_687 VDD VDD VSS VSS gf180mcu_as_sc_mcu7t3v3__fillcap_8
XFILLER_190_613 VDD VDD VSS VSS gf180mcu_as_sc_mcu7t3v3__fill_1
X_4654_ VDD VDD VSS VSS _4659_/B _4654_/B _5237_/Q _5237_/D gf180mcu_as_sc_mcu7t3v3__mux2_2
XFILLER_162_337 VDD VDD VSS VSS gf180mcu_as_sc_mcu7t3v3__fillcap_16
Xinput50 VDD VDD VSS VSS east_in[15] _4055_/A gf180mcu_as_sc_mcu7t3v3__buff_12
Xinput61 VDD VDD VSS VSS east_in[25] _4138_/A gf180mcu_as_sc_mcu7t3v3__buff_12
Xinput72 VDD VDD VSS VSS east_in[4] _3968_/A gf180mcu_as_sc_mcu7t3v3__buff_12
X_4585_ VDD VDD VSS VSS _4588_/C _5001_/Q _4585_/A gf180mcu_as_sc_mcu7t3v3__nand2b_2
X_3605_ VDD VDD VSS VSS _3976_/A _3652_/B _3673_/C _3976_/D _3606_/D gf180mcu_as_sc_mcu7t3v3__ao22_2
XFILLER_190_657 VDD VDD VSS VSS gf180mcu_as_sc_mcu7t3v3__fillcap_8
Xinput83 VDD VDD VSS VSS ne_in[14] _4048_/D gf180mcu_as_sc_mcu7t3v3__buff_12
Xinput94 VDD VDD VSS VSS ne_in[24] _4126_/A gf180mcu_as_sc_mcu7t3v3__buff_12
Xmax_cap553 VDD VDD VSS VSS _4141_/B fanout551/A gf180mcu_as_sc_mcu7t3v3__clkbuff_12
X_3536_ VDD VDD VSS VSS _3790_/C _3932_/B _3537_/A gf180mcu_as_sc_mcu7t3v3__nand2_2
XFILLER_107_37 VDD VDD VSS VSS gf180mcu_as_sc_mcu7t3v3__fillcap_16
XFILLER_157_1175 VDD VDD VSS VSS gf180mcu_as_sc_mcu7t3v3__fill_2
XFILLER_88_104 VDD VDD VSS VSS gf180mcu_as_sc_mcu7t3v3__fill_1
XFILLER_153_1039 VDD VDD VSS VSS gf180mcu_as_sc_mcu7t3v3__fill_2
X_5206_ VDD VDD VSS VSS _5212_/CLK _5206_/D _5206_/Q gf180mcu_as_sc_mcu7t3v3__dfxtp_2
X_3467_ VDD VDD VSS VSS _4118_/A _3467_/B _3504_/B _4119_/A _3468_/D gf180mcu_as_sc_mcu7t3v3__ao22_2
X_3398_ VDD VDD VSS VSS _4048_/A _3453_/B _3398_/C _3398_/D _3399_/B gf180mcu_as_sc_mcu7t3v3__ao211_2
X_2418_ VDD VDD VSS VSS _3236_/A _3254_/A gf180mcu_as_sc_mcu7t3v3__inv_2
XFILLER_131_1326 VDD VDD VSS VSS gf180mcu_as_sc_mcu7t3v3__fillcap_4
X_5137_ VDD VDD VSS VSS _5152_/CLK _5137_/D _5137_/Q gf180mcu_as_sc_mcu7t3v3__dfxtp_2
XPHY_EDGE_ROW_143_1_Right_652 VDD VSS gf180mcu_as_sc_mcu7t3v3__tap_2
X_5068_ VDD VDD VSS VSS _5095_/CLK _5068_/D _5068_/Q gf180mcu_as_sc_mcu7t3v3__dfxtp_2
XFILLER_123_69 VDD VDD VSS VSS gf180mcu_as_sc_mcu7t3v3__fill_1
X_4019_ VDD VDD VSS VSS _4019_/B _4165_/A _4239_/B gf180mcu_as_sc_mcu7t3v3__and2_2
XFILLER_168_1271 VDD VDD VSS VSS gf180mcu_as_sc_mcu7t3v3__fill_2
XPHY_EDGE_ROW_0_Right_0 VDD VSS gf180mcu_as_sc_mcu7t3v3__tap_2
XFILLER_129_1288 VDD VDD VSS VSS gf180mcu_as_sc_mcu7t3v3__fillcap_8
XFILLER_12_104 VDD VDD VSS VSS gf180mcu_as_sc_mcu7t3v3__fill_1
XFILLER_164_1157 VDD VDD VSS VSS gf180mcu_as_sc_mcu7t3v3__fill_2
XFILLER_179_960 VDD VDD VSS VSS gf180mcu_as_sc_mcu7t3v3__fillcap_8
XFILLER_179_982 VDD VDD VSS VSS gf180mcu_as_sc_mcu7t3v3__fillcap_4
XFILLER_165_142 VDD VDD VSS VSS gf180mcu_as_sc_mcu7t3v3__fillcap_8
XFILLER_166_687 VDD VDD VSS VSS gf180mcu_as_sc_mcu7t3v3__fill_2
XFILLER_5_804 VDD VDD VSS VSS gf180mcu_as_sc_mcu7t3v3__fill_1
XFILLER_148_66 VDD VDD VSS VSS gf180mcu_as_sc_mcu7t3v3__fill_2
XFILLER_154_838 VDD VDD VSS VSS gf180mcu_as_sc_mcu7t3v3__fillcap_16
XFILLER_181_624 VDD VDD VSS VSS gf180mcu_as_sc_mcu7t3v3__fillcap_4
XFILLER_32_99 VDD VDD VSS VSS gf180mcu_as_sc_mcu7t3v3__fillcap_4
XFILLER_153_348 VDD VDD VSS VSS gf180mcu_as_sc_mcu7t3v3__fill_2
XTAP_TAPCELL_ROW_154_1180 VDD VSS gf180mcu_as_sc_mcu7t3v3__tap_2
XFILLER_162_893 VDD VDD VSS VSS gf180mcu_as_sc_mcu7t3v3__fillcap_16
XFILLER_164_76 VDD VDD VSS VSS gf180mcu_as_sc_mcu7t3v3__fillcap_16
XTAP_TAPCELL_ROW_151_1_1104 VDD VSS gf180mcu_as_sc_mcu7t3v3__tap_2
XFILLER_0_586 VDD VDD VSS VSS gf180mcu_as_sc_mcu7t3v3__fill_1
XFILLER_180_53 VDD VDD VSS VSS gf180mcu_as_sc_mcu7t3v3__fill_2
XFILLER_169_1046 VDD VDD VSS VSS gf180mcu_as_sc_mcu7t3v3__fillcap_4
XPHY_EDGE_ROW_17_1_Right_526 VDD VSS gf180mcu_as_sc_mcu7t3v3__tap_2
XFILLER_169_1068 VDD VDD VSS VSS gf180mcu_as_sc_mcu7t3v3__fill_2
XPHY_EDGE_ROW_78_3_Right_119 VDD VSS gf180mcu_as_sc_mcu7t3v3__tap_2
XFILLER_169_470 VDD VDD VSS VSS gf180mcu_as_sc_mcu7t3v3__fill_2
XFILLER_188_278 VDD VDD VSS VSS gf180mcu_as_sc_mcu7t3v3__fill_2
XFILLER_12_660 VDD VDD VSS VSS gf180mcu_as_sc_mcu7t3v3__fillcap_4
XFILLER_12_671 VDD VDD VSS VSS gf180mcu_as_sc_mcu7t3v3__fill_2
XFILLER_157_632 VDD VDD VSS VSS gf180mcu_as_sc_mcu7t3v3__fillcap_4
XFILLER_169_492 VDD VDD VSS VSS gf180mcu_as_sc_mcu7t3v3__fill_2
XFILLER_8_653 VDD VDD VSS VSS gf180mcu_as_sc_mcu7t3v3__fill_1
XTAP_TAPCELL_ROW_174_1556 VDD VSS gf180mcu_as_sc_mcu7t3v3__tap_2
XTAP_TAPCELL_ROW_174_1545 VDD VSS gf180mcu_as_sc_mcu7t3v3__tap_2
XFILLER_184_473 VDD VDD VSS VSS gf180mcu_as_sc_mcu7t3v3__fillcap_16
XTAP_TAPCELL_ROW_191_1870 VDD VSS gf180mcu_as_sc_mcu7t3v3__tap_2
XTAP_TAPCELL_ROW_10_872 VDD VSS gf180mcu_as_sc_mcu7t3v3__tap_2
XFILLER_171_156 VDD VDD VSS VSS gf180mcu_as_sc_mcu7t3v3__fill_1
X_4370_ VDD VDD VSS VSS _5161_/D _4370_/C _4378_/D _4370_/A gf180mcu_as_sc_mcu7t3v3__aoi21_2
XTAP_TAPCELL_ROW_191_1881 VDD VSS gf180mcu_as_sc_mcu7t3v3__tap_2
XTAP_TAPCELL_ROW_10_883 VDD VSS gf180mcu_as_sc_mcu7t3v3__tap_2
X_3321_ VDD VDD VSS VSS _3973_/D _3370_/B _3321_/C _3386_/D _3323_/C gf180mcu_as_sc_mcu7t3v3__ao211_2
XFILLER_98_92 VDD VDD VSS VSS gf180mcu_as_sc_mcu7t3v3__fillcap_8
X_3252_ VDD VDD VSS VSS _3255_/C _3787_/A _3818_/C gf180mcu_as_sc_mcu7t3v3__and2_2
XFILLER_152_1072 VDD VDD VSS VSS gf180mcu_as_sc_mcu7t3v3__fillcap_8
X_3183_ VDD VDD VSS VSS _3213_/A _3199_/B _4977_/Q gf180mcu_as_sc_mcu7t3v3__nand2_2
XFILLER_187_1124 VDD VDD VSS VSS gf180mcu_as_sc_mcu7t3v3__fill_1
X_4905__1063 VDD VDD VSS VSS _4905_/D gf180mcu_as_sc_mcu7t3v3__tiel_4
XFILLER_179_212 VDD VDD VSS VSS gf180mcu_as_sc_mcu7t3v3__fillcap_4
XFILLER_74_1327 VDD VDD VSS VSS gf180mcu_as_sc_mcu7t3v3__fill_2
XFILLER_10_608 VDD VDD VSS VSS gf180mcu_as_sc_mcu7t3v3__fillcap_16
XFILLER_167_429 VDD VDD VSS VSS gf180mcu_as_sc_mcu7t3v3__fillcap_16
X_2967_ VDD VDD VSS VSS _3043_/S _3947_/D _3951_/A _2969_/B gf180mcu_as_sc_mcu7t3v3__mux2_2
X_4706_ VDD VDD VSS VSS _4749_/B _4706_/B _4706_/A _4707_/A gf180mcu_as_sc_mcu7t3v3__mux2_2
X_2898_ VDD VDD VSS VSS _4977_/Q _4943_/Q _3542_/A gf180mcu_as_sc_mcu7t3v3__or2_2
XFILLER_159_1204 VDD VDD VSS VSS gf180mcu_as_sc_mcu7t3v3__fill_2
XFILLER_175_484 VDD VDD VSS VSS gf180mcu_as_sc_mcu7t3v3__fillcap_4
X_4637_ VDD VDD VSS VSS _4683_/C _5114_/Q _5228_/Q _5228_/D gf180mcu_as_sc_mcu7t3v3__mux2_2
XPHY_EDGE_ROW_27_1_Left_219 VDD VSS gf180mcu_as_sc_mcu7t3v3__tap_2
XFILLER_162_145 VDD VDD VSS VSS gf180mcu_as_sc_mcu7t3v3__fill_2
XFILLER_2_807 VDD VDD VSS VSS gf180mcu_as_sc_mcu7t3v3__fill_1
X_4568_ VDD VDD VSS VSS _4572_/B _5086_/Q _4570_/S gf180mcu_as_sc_mcu7t3v3__nand2_2
X_4499_ VDD VDD VSS VSS _4502_/C _4991_/Q _4500_/S gf180mcu_as_sc_mcu7t3v3__nand2b_2
X_3519_ VDD VDD VSS VSS _3519_/D _3519_/A _3818_/B _3519_/C _3520_/D gf180mcu_as_sc_mcu7t3v3__ao31_2
XPHY_EDGE_ROW_28_3_Left_400 VDD VSS gf180mcu_as_sc_mcu7t3v3__tap_2
XFILLER_94_39 VDD VDD VSS VSS gf180mcu_as_sc_mcu7t3v3__fill_1
Xmesh_tile_1009 VDD VDD VSS VSS nw_out[15] gf180mcu_as_sc_mcu7t3v3__tiel_4
XTAP_TAPCELL_ROW_115_3_2026 VDD VSS gf180mcu_as_sc_mcu7t3v3__tap_2
XPHY_EDGE_ROW_141_1_Left_333 VDD VSS gf180mcu_as_sc_mcu7t3v3__tap_2
XPHY_EDGE_ROW_144_1_Right_653 VDD VSS gf180mcu_as_sc_mcu7t3v3__tap_2
XFILLER_150_34 VDD VDD VSS VSS gf180mcu_as_sc_mcu7t3v3__fill_1
XFILLER_0_1291 VDD VDD VSS VSS gf180mcu_as_sc_mcu7t3v3__fill_1
XFILLER_9_417 VDD VDD VSS VSS gf180mcu_as_sc_mcu7t3v3__fill_2
XFILLER_182_900 VDD VDD VSS VSS gf180mcu_as_sc_mcu7t3v3__fillcap_8
XFILLER_166_473 VDD VDD VSS VSS gf180mcu_as_sc_mcu7t3v3__fillcap_4
XTAP_TAPCELL_ROW_152_1117 VDD VSS gf180mcu_as_sc_mcu7t3v3__tap_2
XTAP_TAPCELL_ROW_152_1106 VDD VSS gf180mcu_as_sc_mcu7t3v3__tap_2
XFILLER_175_42 VDD VDD VSS VSS gf180mcu_as_sc_mcu7t3v3__fillcap_4
XFILLER_175_53 VDD VDD VSS VSS gf180mcu_as_sc_mcu7t3v3__fillcap_16
XFILLER_177_1348 VDD VDD VSS VSS gf180mcu_as_sc_mcu7t3v3__fillcap_4
XFILLER_181_454 VDD VDD VSS VSS gf180mcu_as_sc_mcu7t3v3__fill_2
XFILLER_182_955 VDD VDD VSS VSS gf180mcu_as_sc_mcu7t3v3__fill_2
XTAP_TAPCELL_ROW_152_1139 VDD VSS gf180mcu_as_sc_mcu7t3v3__tap_2
XTAP_TAPCELL_ROW_152_1128 VDD VSS gf180mcu_as_sc_mcu7t3v3__tap_2
XFILLER_181_487 VDD VDD VSS VSS gf180mcu_as_sc_mcu7t3v3__fill_2
XFILLER_4_177 VDD VDD VSS VSS gf180mcu_as_sc_mcu7t3v3__fill_1
XFILLER_4_37 VDD VDD VSS VSS gf180mcu_as_sc_mcu7t3v3__fillcap_16
XFILLER_108_91 VDD VDD VSS VSS gf180mcu_as_sc_mcu7t3v3__fillcap_8
XFILLER_0_372 VDD VDD VSS VSS gf180mcu_as_sc_mcu7t3v3__fill_2
XPHY_EDGE_ROW_73_1_Left_265 VDD VSS gf180mcu_as_sc_mcu7t3v3__tap_2
XFILLER_62_1264 VDD VDD VSS VSS gf180mcu_as_sc_mcu7t3v3__fillcap_4
Xinput240 VDD VDD VSS VSS south_in[32] _3254_/A gf180mcu_as_sc_mcu7t3v3__buff_12
Xinput251 VDD VDD VSS VSS sw_in[11] _2433_/A gf180mcu_as_sc_mcu7t3v3__buff_12
Xinput262 VDD VDD VSS VSS sw_in[21] _4106_/A gf180mcu_as_sc_mcu7t3v3__buff_12
Xinput273 VDD VDD VSS VSS sw_in[31] _3515_/A gf180mcu_as_sc_mcu7t3v3__buff_12
Xinput284 VDD VDD VSS VSS west_in[10] _4013_/A gf180mcu_as_sc_mcu7t3v3__buff_12
Xinput295 VDD VDD VSS VSS west_in[20] _4093_/D gf180mcu_as_sc_mcu7t3v3__buff_12
XPHY_EDGE_ROW_18_1_Right_527 VDD VSS gf180mcu_as_sc_mcu7t3v3__tap_2
XFILLER_189_521 VDD VDD VSS VSS gf180mcu_as_sc_mcu7t3v3__fill_1
X_3870_ VDD VDD VSS VSS _4914_/D _4339_/B _3870_/A gf180mcu_as_sc_mcu7t3v3__nor2_2
XFILLER_176_226 VDD VDD VSS VSS gf180mcu_as_sc_mcu7t3v3__fillcap_8
X_2821_ VDD VDD VSS VSS _5483_/A _2833_/A _2829_/B gf180mcu_as_sc_mcu7t3v3__and2_2
XFILLER_121_1314 VDD VDD VSS VSS gf180mcu_as_sc_mcu7t3v3__fill_2
XFILLER_9_940 VDD VDD VSS VSS gf180mcu_as_sc_mcu7t3v3__fillcap_16
X_2752_ VDD VDD VSS VSS _2754_/D _4751_/A _5279_/Q gf180mcu_as_sc_mcu7t3v3__nor2b_2
XFILLER_157_484 VDD VDD VSS VSS gf180mcu_as_sc_mcu7t3v3__fillcap_4
XFILLER_158_996 VDD VDD VSS VSS gf180mcu_as_sc_mcu7t3v3__fillcap_4
XFILLER_8_461 VDD VDD VSS VSS gf180mcu_as_sc_mcu7t3v3__fill_2
XFILLER_69_2 VDD VDD VSS VSS gf180mcu_as_sc_mcu7t3v3__fill_2
X_4422_ VDD VDD VSS VSS _5170_/Q _4493_/B _4540_/C _5120_/Q _4423_/B gf180mcu_as_sc_mcu7t3v3__ao22_2
X_2683_ VDD VDD VSS VSS _2734_/S _2683_/B _2683_/A _2684_/C gf180mcu_as_sc_mcu7t3v3__mux2_2
XFILLER_172_465 VDD VDD VSS VSS gf180mcu_as_sc_mcu7t3v3__fill_2
X_4353_ VDD VDD VSS VSS _4357_/C _4573_/A _4353_/A gf180mcu_as_sc_mcu7t3v3__nor2b_2
X_4284_ VDD VDD VSS VSS _4289_/S _4694_/B _5118_/Q _5118_/D gf180mcu_as_sc_mcu7t3v3__mux2_2
X_3304_ VDD VDD VSS VSS _4918_/Q _3369_/B _3369_/C _3959_/A _3306_/C gf180mcu_as_sc_mcu7t3v3__ao22_2
X_3235_ VDD VDD VSS VSS _3236_/D _3235_/B _3517_/A gf180mcu_as_sc_mcu7t3v3__nor2_2
XFILLER_104_27 VDD VDD VSS VSS gf180mcu_as_sc_mcu7t3v3__fillcap_8
XFILLER_41_1326 VDD VDD VSS VSS gf180mcu_as_sc_mcu7t3v3__fill_2
X_3166_ VDD VDD VSS VSS _3241_/B _4147_/A _3172_/C gf180mcu_as_sc_mcu7t3v3__and2_2
X_3097_ VDD VDD VSS VSS _3805_/C _3097_/A _3097_/B _3097_/C _3098_/C gf180mcu_as_sc_mcu7t3v3__ao31_2
XFILLER_120_59 VDD VDD VSS VSS gf180mcu_as_sc_mcu7t3v3__fill_1
XFILLER_168_716 VDD VDD VSS VSS gf180mcu_as_sc_mcu7t3v3__fillcap_16
X_3999_ VDD VDD VSS VSS _3999_/A _4160_/C _4129_/C _4923_/Q _4001_/C gf180mcu_as_sc_mcu7t3v3__ao22_2
XFILLER_164_944 VDD VDD VSS VSS gf180mcu_as_sc_mcu7t3v3__fill_1
XFILLER_11_1130 VDD VDD VSS VSS gf180mcu_as_sc_mcu7t3v3__fill_2
XFILLER_159_1012 VDD VDD VSS VSS gf180mcu_as_sc_mcu7t3v3__fillcap_16
XFILLER_191_752 VDD VDD VSS VSS gf180mcu_as_sc_mcu7t3v3__fill_2
XFILLER_102_1291 VDD VDD VSS VSS gf180mcu_as_sc_mcu7t3v3__fill_1
XFILLER_150_104 VDD VDD VSS VSS gf180mcu_as_sc_mcu7t3v3__fill_1
XFILLER_190_251 VDD VDD VSS VSS gf180mcu_as_sc_mcu7t3v3__fill_2
XFILLER_137_1310 VDD VDD VSS VSS gf180mcu_as_sc_mcu7t3v3__fill_1
XFILLER_137_1321 VDD VDD VSS VSS gf180mcu_as_sc_mcu7t3v3__fill_2
XFILLER_8_6 VDD VDD VSS VSS gf180mcu_as_sc_mcu7t3v3__fill_2
XFILLER_161_33 VDD VDD VSS VSS gf180mcu_as_sc_mcu7t3v3__fill_1
Xhold1150 VDD VDD VSS VSS _4961_/Q hold1150/Y gf180mcu_as_sc_mcu7t3v3__clkbuff_4
XPHY_EDGE_ROW_145_1_Right_654 VDD VSS gf180mcu_as_sc_mcu7t3v3__tap_2
XFILLER_2_1353 VDD VDD VSS VSS gf180mcu_as_sc_mcu7t3v3__fill_2
XFILLER_54_31 VDD VDD VSS VSS gf180mcu_as_sc_mcu7t3v3__fillcap_4
XFILLER_183_1352 VDD VDD VSS VSS gf180mcu_as_sc_mcu7t3v3__fill_2
XFILLER_9_203 VDD VDD VSS VSS gf180mcu_as_sc_mcu7t3v3__fillcap_4
XTAP_TAPCELL_ROW_12_912 VDD VSS gf180mcu_as_sc_mcu7t3v3__tap_2
XFILLER_70_41 VDD VDD VSS VSS gf180mcu_as_sc_mcu7t3v3__fill_2
XTAP_TAPCELL_ROW_12_923 VDD VSS gf180mcu_as_sc_mcu7t3v3__tap_2
XFILLER_186_30 VDD VDD VSS VSS gf180mcu_as_sc_mcu7t3v3__fillcap_4
XFILLER_9_269 VDD VDD VSS VSS gf180mcu_as_sc_mcu7t3v3__fill_1
Xclkload17 VDD VDD VSS VSS clkload17/Y _5212_/CLK gf180mcu_as_sc_mcu7t3v3__inv_4
XTAP_TAPCELL_ROW_171_1504 VDD VSS gf180mcu_as_sc_mcu7t3v3__tap_2
XFILLER_155_955 VDD VDD VSS VSS gf180mcu_as_sc_mcu7t3v3__fillcap_16
XFILLER_186_85 VDD VDD VSS VSS gf180mcu_as_sc_mcu7t3v3__fillcap_16
XFILLER_6_943 VDD VDD VSS VSS gf180mcu_as_sc_mcu7t3v3__fill_2
Xclkload28 VDD VDD VSS VSS clkload28/Y _5280_/CLK gf180mcu_as_sc_mcu7t3v3__inv_2
XFILLER_154_454 VDD VDD VSS VSS gf180mcu_as_sc_mcu7t3v3__fill_1
XFILLER_6_976 VDD VDD VSS VSS gf180mcu_as_sc_mcu7t3v3__fillcap_8
XFILLER_141_104 VDD VDD VSS VSS gf180mcu_as_sc_mcu7t3v3__fill_1
XTAP_TAPCELL_ROW_169_1466 VDD VSS gf180mcu_as_sc_mcu7t3v3__tap_2
XTAP_TAPCELL_ROW_169_1455 VDD VSS gf180mcu_as_sc_mcu7t3v3__tap_2
XFILLER_7_1253 VDD VDD VSS VSS gf180mcu_as_sc_mcu7t3v3__fillcap_4
XFILLER_3_1128 VDD VDD VSS VSS gf180mcu_as_sc_mcu7t3v3__fill_1
X_3020_ VDD VDD VSS VSS _3187_/B _4923_/Q _3021_/D gf180mcu_as_sc_mcu7t3v3__or2_2
XTAP_TAPCELL_ROW_186_1780 VDD VSS gf180mcu_as_sc_mcu7t3v3__tap_2
XTAP_TAPCELL_ROW_182_1699 VDD VSS gf180mcu_as_sc_mcu7t3v3__tap_2
X_4971_ VDD VDD VSS VSS _5164_/CLK _4971_/D _4971_/Q gf180mcu_as_sc_mcu7t3v3__dfxtp_2
XPHY_EDGE_ROW_19_1_Right_528 VDD VSS gf180mcu_as_sc_mcu7t3v3__tap_2
X_3922_ VDD VDD VSS VSS _3922_/A _3922_/B _3922_/C _3927_/B _4156_/S gf180mcu_as_sc_mcu7t3v3__ao211_2
X_3853_ VDD VDD VSS VSS _5153_/Q _5154_/Q _3853_/C _3858_/B gf180mcu_as_sc_mcu7t3v3__nor3_2
X_2804_ VDD VDD VSS VSS _2840_/D _5227_/Q _5226_/Q gf180mcu_as_sc_mcu7t3v3__nand2_2
XFILLER_125_1291 VDD VDD VSS VSS gf180mcu_as_sc_mcu7t3v3__fillcap_8
XFILLER_164_218 VDD VDD VSS VSS gf180mcu_as_sc_mcu7t3v3__fill_2
XFILLER_192_527 VDD VDD VSS VSS gf180mcu_as_sc_mcu7t3v3__fillcap_4
X_3784_ VDD VDD VSS VSS _3794_/S _3784_/B _4164_/A _3785_/B gf180mcu_as_sc_mcu7t3v3__mux2_2
XFILLER_173_752 VDD VDD VSS VSS gf180mcu_as_sc_mcu7t3v3__fill_2
XFILLER_8_280 VDD VDD VSS VSS gf180mcu_as_sc_mcu7t3v3__fill_1
X_2735_ VDD VDD VSS VSS _2735_/A _2735_/B _2735_/C _2735_/D _2737_/C gf180mcu_as_sc_mcu7t3v3__ao211_2
X_2666_ VDD VDD VSS VSS _2666_/A _2666_/B _2666_/C _2666_/D _2667_/C gf180mcu_as_sc_mcu7t3v3__ao22_2
XFILLER_132_104 VDD VDD VSS VSS gf180mcu_as_sc_mcu7t3v3__fill_1
XFILLER_160_413 VDD VDD VSS VSS gf180mcu_as_sc_mcu7t3v3__fill_1
X_4405_ VDD VDD VSS VSS _4405_/D _4502_/A _4405_/B _4405_/C _4406_/B gf180mcu_as_sc_mcu7t3v3__ao31_2
XFILLER_160_457 VDD VDD VSS VSS gf180mcu_as_sc_mcu7t3v3__fillcap_8
X_4336_ VDD VDD VSS VSS _4379_/B _4574_/B _4366_/S gf180mcu_as_sc_mcu7t3v3__nand2_2
X_2597_ VDD VDD VSS VSS _5227_/Q _2597_/B _2597_/C _2597_/D _2598_/B gf180mcu_as_sc_mcu7t3v3__ao22_2
XFILLER_8_1017 VDD VDD VSS VSS gf180mcu_as_sc_mcu7t3v3__fillcap_8
X_4267_ VDD VDD VSS VSS _4273_/S _4692_/B _5101_/Q _5101_/D gf180mcu_as_sc_mcu7t3v3__mux2_2
XFILLER_132_1262 VDD VDD VSS VSS gf180mcu_as_sc_mcu7t3v3__fill_1
XFILLER_189_1049 VDD VDD VSS VSS gf180mcu_as_sc_mcu7t3v3__fill_1
X_4198_ VDD VDD VSS VSS _4198_/Y _4908_/Q _4198_/A gf180mcu_as_sc_mcu7t3v3__nor2b_2
X_3218_ VDD VDD VSS VSS _3219_/B _3218_/C _3218_/B _3803_/A gf180mcu_as_sc_mcu7t3v3__aoi21_2
X_3149_ VDD VDD VSS VSS _4124_/A _3182_/B _3149_/C _4794_/D _3775_/D gf180mcu_as_sc_mcu7t3v3__aoi211_2
XFILLER_131_47 VDD VDD VSS VSS gf180mcu_as_sc_mcu7t3v3__fill_1
XFILLER_165_1060 VDD VDD VSS VSS gf180mcu_as_sc_mcu7t3v3__fill_1
XFILLER_145_6 VDD VDD VSS VSS gf180mcu_as_sc_mcu7t3v3__fillcap_16
XFILLER_24_78 VDD VDD VSS VSS gf180mcu_as_sc_mcu7t3v3__fill_1
XFILLER_11_769 VDD VDD VSS VSS gf180mcu_as_sc_mcu7t3v3__fill_1
XFILLER_13_1203 VDD VDD VSS VSS gf180mcu_as_sc_mcu7t3v3__fillcap_8
XFILLER_7_718 VDD VDD VSS VSS gf180mcu_as_sc_mcu7t3v3__fillcap_8
XFILLER_104_1353 VDD VDD VSS VSS gf180mcu_as_sc_mcu7t3v3__fill_2
XFILLER_156_22 VDD VDD VSS VSS gf180mcu_as_sc_mcu7t3v3__fill_2
XFILLER_3_902 VDD VDD VSS VSS gf180mcu_as_sc_mcu7t3v3__fillcap_8
XFILLER_87_1326 VDD VDD VSS VSS gf180mcu_as_sc_mcu7t3v3__fillcap_4
XFILLER_152_936 VDD VDD VSS VSS gf180mcu_as_sc_mcu7t3v3__fillcap_8
XFILLER_164_796 VDD VDD VSS VSS gf180mcu_as_sc_mcu7t3v3__fill_1
XFILLER_3_924 VDD VDD VSS VSS gf180mcu_as_sc_mcu7t3v3__fill_2
XFILLER_172_1064 VDD VDD VSS VSS gf180mcu_as_sc_mcu7t3v3__fillcap_16
Xfanout760 VDD VDD VSS VSS fanout760/A _3153_/D gf180mcu_as_sc_mcu7t3v3__buff_12
XFILLER_1_27 VDD VDD VSS VSS gf180mcu_as_sc_mcu7t3v3__fillcap_16
Xfanout771 VDD VDD VSS VSS _3127_/B _3044_/B gf180mcu_as_sc_mcu7t3v3__buff_12
XPHY_EDGE_ROW_130_3_Right_171 VDD VSS gf180mcu_as_sc_mcu7t3v3__tap_2
XTAP_TAPCELL_ROW_164_1363 VDD VSS gf180mcu_as_sc_mcu7t3v3__tap_2
XFILLER_2_1161 VDD VDD VSS VSS gf180mcu_as_sc_mcu7t3v3__fill_2
XFILLER_60_102 VDD VDD VSS VSS gf180mcu_as_sc_mcu7t3v3__fill_2
XPHY_EDGE_ROW_146_1_Right_655 VDD VSS gf180mcu_as_sc_mcu7t3v3__tap_2
XFILLER_148_1291 VDD VDD VSS VSS gf180mcu_as_sc_mcu7t3v3__fillcap_4
XFILLER_183_1160 VDD VDD VSS VSS gf180mcu_as_sc_mcu7t3v3__fillcap_4
XFILLER_186_321 VDD VDD VSS VSS gf180mcu_as_sc_mcu7t3v3__fill_2
XFILLER_187_866 VDD VDD VSS VSS gf180mcu_as_sc_mcu7t3v3__fill_1
XFILLER_174_516 VDD VDD VSS VSS gf180mcu_as_sc_mcu7t3v3__fill_2
XFILLER_186_387 VDD VDD VSS VSS gf180mcu_as_sc_mcu7t3v3__fillcap_16
XFILLER_155_752 VDD VDD VSS VSS gf180mcu_as_sc_mcu7t3v3__fill_2
XFILLER_10_791 VDD VDD VSS VSS gf180mcu_as_sc_mcu7t3v3__fill_1
X_2520_ VDD VDD VSS VSS _2797_/A _2545_/B gf180mcu_as_sc_mcu7t3v3__inv_2
X_2451_ VDD VDD VSS VSS _2832_/B _2451_/A gf180mcu_as_sc_mcu7t3v3__inv_2
XFILLER_5_294 VDD VDD VSS VSS gf180mcu_as_sc_mcu7t3v3__fillcap_4
XTAP_TAPCELL_ROW_188_1820 VDD VSS gf180mcu_as_sc_mcu7t3v3__tap_2
XFILLER_155_1262 VDD VDD VSS VSS gf180mcu_as_sc_mcu7t3v3__fillcap_4
XFILLER_190_1142 VDD VDD VSS VSS gf180mcu_as_sc_mcu7t3v3__fillcap_8
XFILLER_9_1348 VDD VDD VSS VSS gf180mcu_as_sc_mcu7t3v3__fillcap_4
X_5170_ VDD VDD VSS VSS _5178_/CLK _5170_/D _5170_/Q gf180mcu_as_sc_mcu7t3v3__dfxtp_2
X_4121_ VDD VDD VSS VSS _4121_/A _4159_/B _4159_/C _4121_/D _4122_/D gf180mcu_as_sc_mcu7t3v3__ao22_2
X_4052_ VDD VDD VSS VSS _4992_/Q _4150_/B _4243_/B _4150_/D _4992_/D gf180mcu_as_sc_mcu7t3v3__ao22_2
XTAP_TAPCELL_ROW_184_1739 VDD VSS gf180mcu_as_sc_mcu7t3v3__tap_2
Xinput4 VDD VDD VSS VSS boot_addr[2] input4/Y gf180mcu_as_sc_mcu7t3v3__buff_12
X_3003_ VDD VDD VSS VSS _3046_/B _4921_/Q _3004_/D gf180mcu_as_sc_mcu7t3v3__or2_2
XFILLER_188_1071 VDD VDD VSS VSS gf180mcu_as_sc_mcu7t3v3__fillcap_8
XTAP_TAPCELL_ROW_53_1_1006 VDD VSS gf180mcu_as_sc_mcu7t3v3__tap_2
XPHY_EDGE_ROW_36_1_Left_228 VDD VSS gf180mcu_as_sc_mcu7t3v3__tap_2
XFILLER_178_811 VDD VDD VSS VSS gf180mcu_as_sc_mcu7t3v3__fill_1
X_4954_ VDD VDD VSS VSS _5097_/CLK _4954_/D _4954_/Q gf180mcu_as_sc_mcu7t3v3__dfxtp_2
XFILLER_178_822 VDD VDD VSS VSS gf180mcu_as_sc_mcu7t3v3__fillcap_4
X_3905_ VDD VDD VSS VSS _3905_/B _5164_/Q _4945_/D gf180mcu_as_sc_mcu7t3v3__and2_2
X_4885_ VDD VDD VSS VSS _4895_/CLK _4885_/D _4885_/Q gf180mcu_as_sc_mcu7t3v3__dfxtp_2
X_3836_ VDD VDD VSS VSS _3838_/B _3843_/B _3845_/A gf180mcu_as_sc_mcu7t3v3__nand2_2
XTAP_TAPCELL_ROW_81_3_1992 VDD VSS gf180mcu_as_sc_mcu7t3v3__tap_2
X_3767_ VDD VDD VSS VSS _3794_/S _3767_/B _4148_/A _3768_/B gf180mcu_as_sc_mcu7t3v3__mux2_2
XFILLER_3_209 VDD VDD VSS VSS gf180mcu_as_sc_mcu7t3v3__fill_1
X_2718_ VDD VDD VSS VSS _2732_/S _4962_/Q _4971_/Q _2720_/A gf180mcu_as_sc_mcu7t3v3__mux2_2
XPHY_EDGE_ROW_150_1_Left_342 VDD VSS gf180mcu_as_sc_mcu7t3v3__tap_2
XFILLER_161_744 VDD VDD VSS VSS gf180mcu_as_sc_mcu7t3v3__fillcap_4
X_3698_ VDD VDD VSS VSS _3699_/C _3698_/C _3783_/B _4073_/A gf180mcu_as_sc_mcu7t3v3__aoi21_2
XFILLER_0_905 VDD VDD VSS VSS gf180mcu_as_sc_mcu7t3v3__fill_2
XFILLER_10_69 VDD VDD VSS VSS gf180mcu_as_sc_mcu7t3v3__fillcap_16
XFILLER_161_755 VDD VDD VSS VSS gf180mcu_as_sc_mcu7t3v3__fillcap_4
Xoutput352 VDD VDD VSS VSS _4842_/Q east_out[3] gf180mcu_as_sc_mcu7t3v3__buff_12
Xoutput341 VDD VDD VSS VSS _4863_/Q east_out[24] gf180mcu_as_sc_mcu7t3v3__buff_12
Xoutput330 VDD VDD VSS VSS _4853_/Q east_out[14] gf180mcu_as_sc_mcu7t3v3__buff_12
X_2649_ VDD VDD VSS VSS _2666_/B _2649_/B _2649_/C _2722_/B _2650_/D gf180mcu_as_sc_mcu7t3v3__ao211_2
XFILLER_126_47 VDD VDD VSS VSS gf180mcu_as_sc_mcu7t3v3__fillcap_8
XFILLER_161_788 VDD VDD VSS VSS gf180mcu_as_sc_mcu7t3v3__fillcap_8
Xoutput396 VDD VDD VSS VSS _4817_/Q south_out[12] gf180mcu_as_sc_mcu7t3v3__buff_12
Xoutput385 VDD VDD VSS VSS _4804_/Q se_out[33] gf180mcu_as_sc_mcu7t3v3__buff_12
Xoutput374 VDD VDD VSS VSS _4794_/Q se_out[23] gf180mcu_as_sc_mcu7t3v3__buff_12
Xoutput363 VDD VDD VSS VSS _4784_/Q se_out[13] gf180mcu_as_sc_mcu7t3v3__buff_12
XFILLER_82_1256 VDD VDD VSS VSS gf180mcu_as_sc_mcu7t3v3__fillcap_16
X_4319_ VDD VDD VSS VSS _4319_/S _5149_/Q _5148_/Q _5148_/D gf180mcu_as_sc_mcu7t3v3__mux2_2
XFILLER_19_56 VDD VDD VSS VSS gf180mcu_as_sc_mcu7t3v3__fill_1
Xclkbuf_leaf_25_clk_regs VDD VDD VSS VSS clkbuf_3_5__f_clk_regs/Y _5277_/CLK gf180mcu_as_sc_mcu7t3v3__clkbuff_12
XTAP_TAPCELL_ROW_3_754 VDD VSS gf180mcu_as_sc_mcu7t3v3__tap_2
XTAP_TAPCELL_ROW_3_743 VDD VSS gf180mcu_as_sc_mcu7t3v3__tap_2
XPHY_EDGE_ROW_155_Right_17 VDD VSS gf180mcu_as_sc_mcu7t3v3__tap_2
XFILLER_167_1122 VDD VDD VSS VSS gf180mcu_as_sc_mcu7t3v3__fill_2
XFILLER_167_1177 VDD VDD VSS VSS gf180mcu_as_sc_mcu7t3v3__fillcap_8
XPHY_EDGE_ROW_48_3_Right_89 VDD VSS gf180mcu_as_sc_mcu7t3v3__tap_2
XFILLER_169_822 VDD VDD VSS VSS gf180mcu_as_sc_mcu7t3v3__fill_2
XFILLER_54_1303 VDD VDD VSS VSS gf180mcu_as_sc_mcu7t3v3__fill_2
XFILLER_141_1317 VDD VDD VSS VSS gf180mcu_as_sc_mcu7t3v3__fillcap_4
XFILLER_184_803 VDD VDD VSS VSS gf180mcu_as_sc_mcu7t3v3__fill_2
XPHY_EDGE_ROW_21_3_Left_393 VDD VSS gf180mcu_as_sc_mcu7t3v3__tap_2
XFILLER_156_527 VDD VDD VSS VSS gf180mcu_as_sc_mcu7t3v3__fillcap_4
XPHY_EDGE_ROW_164_Right_26 VDD VSS gf180mcu_as_sc_mcu7t3v3__tap_2
XFILLER_11_577 VDD VDD VSS VSS gf180mcu_as_sc_mcu7t3v3__fill_2
XFILLER_13_1033 VDD VDD VSS VSS gf180mcu_as_sc_mcu7t3v3__fill_1
XPHY_EDGE_ROW_82_1_Left_274 VDD VSS gf180mcu_as_sc_mcu7t3v3__tap_2
XFILLER_167_65 VDD VDD VSS VSS gf180mcu_as_sc_mcu7t3v3__fillcap_4
Xwire468 VDD VDD VSS VSS _3587_/Y _4841_/D gf180mcu_as_sc_mcu7t3v3__clkbuff_12
XFILLER_174_1115 VDD VDD VSS VSS gf180mcu_as_sc_mcu7t3v3__fill_1
XFILLER_139_1268 VDD VDD VSS VSS gf180mcu_as_sc_mcu7t3v3__fillcap_16
XFILLER_152_766 VDD VDD VSS VSS gf180mcu_as_sc_mcu7t3v3__fillcap_16
XFILLER_152_788 VDD VDD VSS VSS gf180mcu_as_sc_mcu7t3v3__fill_1
XTAP_TAPCELL_ROW_166_1403 VDD VSS gf180mcu_as_sc_mcu7t3v3__tap_2
XPHY_EDGE_ROW_173_Right_35 VDD VSS gf180mcu_as_sc_mcu7t3v3__tap_2
Xfanout590 VDD VDD VSS VSS _4104_/B _4022_/B gf180mcu_as_sc_mcu7t3v3__buff_12
XPHY_EDGE_ROW_131_3_Right_172 VDD VSS gf180mcu_as_sc_mcu7t3v3__tap_2
XPHY_EDGE_ROW_147_1_Right_656 VDD VSS gf180mcu_as_sc_mcu7t3v3__tap_2
XFILLER_178_107 VDD VDD VSS VSS gf180mcu_as_sc_mcu7t3v3__fillcap_8
XFILLER_181_1119 VDD VDD VSS VSS gf180mcu_as_sc_mcu7t3v3__fill_1
XFILLER_92_83 VDD VDD VSS VSS gf180mcu_as_sc_mcu7t3v3__fill_1
XTAP_TAPCELL_ROW_114_1_1067 VDD VSS gf180mcu_as_sc_mcu7t3v3__tap_2
XPHY_EDGE_ROW_182_Right_44 VDD VSS gf180mcu_as_sc_mcu7t3v3__tap_2
XFILLER_187_685 VDD VDD VSS VSS gf180mcu_as_sc_mcu7t3v3__fillcap_8
X_4670_ VDD VDD VSS VSS _5242_/D _5242_/Q _4685_/C _4670_/C gf180mcu_as_sc_mcu7t3v3__ao21_2
XFILLER_175_858 VDD VDD VSS VSS gf180mcu_as_sc_mcu7t3v3__fillcap_16
X_3621_ VDD VDD VSS VSS _3992_/A _3652_/B _3621_/C _3621_/D _3622_/C gf180mcu_as_sc_mcu7t3v3__ao211_2
XFILLER_122_1272 VDD VDD VSS VSS gf180mcu_as_sc_mcu7t3v3__fillcap_16
X_3552_ VDD VDD VSS VSS _3801_/B _3561_/A gf180mcu_as_sc_mcu7t3v3__inv_2
XFILLER_190_839 VDD VDD VSS VSS gf180mcu_as_sc_mcu7t3v3__fillcap_4
XFILLER_51_2 VDD VDD VSS VSS gf180mcu_as_sc_mcu7t3v3__fill_1
X_2503_ VDD VDD VSS VSS _2546_/B _2503_/B _5189_/Q gf180mcu_as_sc_mcu7t3v3__nand2_2
XFILLER_192_1226 VDD VDD VSS VSS gf180mcu_as_sc_mcu7t3v3__fillcap_4
XFILLER_192_1237 VDD VDD VSS VSS gf180mcu_as_sc_mcu7t3v3__fillcap_4
X_3483_ VDD VDD VSS VSS _3505_/S _3483_/B _3483_/A _3484_/B gf180mcu_as_sc_mcu7t3v3__mux2_2
X_5222_ VDD VDD VSS VSS _5226_/CLK _5222_/D _5222_/Q gf180mcu_as_sc_mcu7t3v3__dfxtp_2
X_2434_ VDD VDD VSS VSS _3661_/A _4034_/A gf180mcu_as_sc_mcu7t3v3__inv_2
X_5153_ VDD VDD VSS VSS _5278_/CLK _5153_/D _5153_/Q gf180mcu_as_sc_mcu7t3v3__dfxtp_2
XPHY_EDGE_ROW_97_3_Left_469 VDD VSS gf180mcu_as_sc_mcu7t3v3__tap_2
XPHY_EDGE_ROW_191_Right_53 VDD VSS gf180mcu_as_sc_mcu7t3v3__tap_2
XFILLER_9_1189 VDD VDD VSS VSS gf180mcu_as_sc_mcu7t3v3__fill_1
X_4104_ VDD VDD VSS VSS _4104_/A _4104_/B _4104_/C _4104_/D _4105_/D gf180mcu_as_sc_mcu7t3v3__ao22_2
X_5084_ VDD VDD VSS VSS _5185_/CLK _5084_/D _5084_/Q gf180mcu_as_sc_mcu7t3v3__dfxtp_2
X_4035_ VDD VDD VSS VSS _4035_/B _4165_/A _4241_/B gf180mcu_as_sc_mcu7t3v3__and2_2
XFILLER_178_630 VDD VDD VSS VSS gf180mcu_as_sc_mcu7t3v3__fillcap_8
X_4937_ VDD VDD VSS VSS _5185_/CLK _4937_/D _4937_/Q gf180mcu_as_sc_mcu7t3v3__dfxtp_2
XANTENNA_20 VDD VDD VSS VSS _4107_/B gf180mcu_as_sc_mcu7t3v3__diode_2
XANTENNA_31 VDD VDD VSS VSS _3848_/A gf180mcu_as_sc_mcu7t3v3__diode_2
XFILLER_162_1063 VDD VDD VSS VSS gf180mcu_as_sc_mcu7t3v3__fillcap_16
X_4868_ VDD VDD VSS VSS _5097_/CLK _4868_/D _4868_/Q gf180mcu_as_sc_mcu7t3v3__dfxtp_2
XANTENNA_42 VDD VDD VSS VSS _4855_/D gf180mcu_as_sc_mcu7t3v3__diode_2
XFILLER_192_110 VDD VDD VSS VSS gf180mcu_as_sc_mcu7t3v3__fill_1
X_3819_ VDD VDD VSS VSS _3927_/A _3920_/B _3929_/B _3922_/C _3820_/B gf180mcu_as_sc_mcu7t3v3__nand4_2
X_4799_ VDD VDD VSS VSS _5226_/CLK _4799_/D _4799_/Q gf180mcu_as_sc_mcu7t3v3__dfxtp_2
XFILLER_181_839 VDD VDD VSS VSS gf180mcu_as_sc_mcu7t3v3__fill_1
XFILLER_192_176 VDD VDD VSS VSS gf180mcu_as_sc_mcu7t3v3__fill_2
XTAP_TAPCELL_ROW_8_846 VDD VSS gf180mcu_as_sc_mcu7t3v3__tap_2
XTAP_TAPCELL_ROW_8_835 VDD VSS gf180mcu_as_sc_mcu7t3v3__tap_2
XFILLER_0_779 VDD VDD VSS VSS gf180mcu_as_sc_mcu7t3v3__fill_2
XFILLER_173_1192 VDD VDD VSS VSS gf180mcu_as_sc_mcu7t3v3__fillcap_16
XTAP_TAPCELL_ROW_161_1311 VDD VSS gf180mcu_as_sc_mcu7t3v3__tap_2
XTAP_TAPCELL_ROW_161_1300 VDD VSS gf180mcu_as_sc_mcu7t3v3__tap_2
XFILLER_188_405 VDD VDD VSS VSS gf180mcu_as_sc_mcu7t3v3__fill_2
XFILLER_102_60 VDD VDD VSS VSS gf180mcu_as_sc_mcu7t3v3__fill_2
XFILLER_102_93 VDD VDD VSS VSS gf180mcu_as_sc_mcu7t3v3__fillcap_8
XFILLER_58_1291 VDD VDD VSS VSS gf180mcu_as_sc_mcu7t3v3__fillcap_4
XFILLER_145_1283 VDD VDD VSS VSS gf180mcu_as_sc_mcu7t3v3__fillcap_4
XFILLER_157_825 VDD VDD VSS VSS gf180mcu_as_sc_mcu7t3v3__fillcap_8
XFILLER_178_53 VDD VDD VSS VSS gf180mcu_as_sc_mcu7t3v3__fillcap_16
XFILLER_180_1152 VDD VDD VSS VSS gf180mcu_as_sc_mcu7t3v3__fill_2
XFILLER_62_86 VDD VDD VSS VSS gf180mcu_as_sc_mcu7t3v3__fill_1
XFILLER_8_802 VDD VDD VSS VSS gf180mcu_as_sc_mcu7t3v3__fill_2
XTAP_TAPCELL_ROW_159_1262 VDD VSS gf180mcu_as_sc_mcu7t3v3__tap_2
XPHY_EDGE_ROW_71_1_Right_580 VDD VSS gf180mcu_as_sc_mcu7t3v3__tap_2
XFILLER_106_1256 VDD VDD VSS VSS gf180mcu_as_sc_mcu7t3v3__fillcap_4
XFILLER_11_352 VDD VDD VSS VSS gf180mcu_as_sc_mcu7t3v3__fillcap_4
XFILLER_168_173 VDD VDD VSS VSS gf180mcu_as_sc_mcu7t3v3__fill_2
XFILLER_8_824 VDD VDD VSS VSS gf180mcu_as_sc_mcu7t3v3__fill_2
XTAP_TAPCELL_ROW_159_1273 VDD VSS gf180mcu_as_sc_mcu7t3v3__tap_2
XFILLER_156_368 VDD VDD VSS VSS gf180mcu_as_sc_mcu7t3v3__fillcap_16
XFILLER_183_132 VDD VDD VSS VSS gf180mcu_as_sc_mcu7t3v3__fill_1
XFILLER_183_154 VDD VDD VSS VSS gf180mcu_as_sc_mcu7t3v3__fill_2
XFILLER_171_338 VDD VDD VSS VSS gf180mcu_as_sc_mcu7t3v3__fillcap_8
XFILLER_3_562 VDD VDD VSS VSS gf180mcu_as_sc_mcu7t3v3__fill_2
XTAP_TAPCELL_ROW_133_3_2044 VDD VSS gf180mcu_as_sc_mcu7t3v3__tap_2
XPHY_EDGE_ROW_132_3_Right_173 VDD VSS gf180mcu_as_sc_mcu7t3v3__tap_2
XFILLER_185_1052 VDD VDD VSS VSS gf180mcu_as_sc_mcu7t3v3__fillcap_4
XFILLER_179_438 VDD VDD VSS VSS gf180mcu_as_sc_mcu7t3v3__fillcap_8
XPHY_EDGE_ROW_148_1_Right_657 VDD VSS gf180mcu_as_sc_mcu7t3v3__tap_2
X_2983_ VDD VDD VSS VSS _3043_/S _3965_/D _3968_/A _2986_/B gf180mcu_as_sc_mcu7t3v3__mux2_2
XTAP_TAPCELL_ROW_179_1649 VDD VSS gf180mcu_as_sc_mcu7t3v3__tap_2
XTAP_TAPCELL_ROW_179_1638 VDD VSS gf180mcu_as_sc_mcu7t3v3__tap_2
XFILLER_187_471 VDD VDD VSS VSS gf180mcu_as_sc_mcu7t3v3__fillcap_16
XFILLER_72_1266 VDD VDD VSS VSS gf180mcu_as_sc_mcu7t3v3__fill_1
X_4722_ VDD VDD VSS VSS _5263_/Q _4730_/B _4730_/C _5262_/Q _4723_/B gf180mcu_as_sc_mcu7t3v3__ao22_2
XTAP_TAPCELL_ROW_48_1_1001 VDD VSS gf180mcu_as_sc_mcu7t3v3__tap_2
XFILLER_159_195 VDD VDD VSS VSS gf180mcu_as_sc_mcu7t3v3__fillcap_4
XFILLER_72_1288 VDD VDD VSS VSS gf180mcu_as_sc_mcu7t3v3__fill_1
Xinput40 VDD VDD VSS VSS dft_wdata[5] _2723_/B gf180mcu_as_sc_mcu7t3v3__buff_12
X_4653_ VDD VDD VSS VSS _4653_/B _4657_/B _4654_/B gf180mcu_as_sc_mcu7t3v3__or2_2
XFILLER_175_699 VDD VDD VSS VSS gf180mcu_as_sc_mcu7t3v3__fill_1
Xinput51 VDD VDD VSS VSS east_in[16] _4063_/A gf180mcu_as_sc_mcu7t3v3__buff_12
Xinput62 VDD VDD VSS VSS east_in[26] wire860/A gf180mcu_as_sc_mcu7t3v3__buff_12
Xinput73 VDD VDD VSS VSS east_in[5] _3975_/A gf180mcu_as_sc_mcu7t3v3__buff_12
X_4584_ VDD VDD VSS VSS _4588_/B _5088_/Q _4585_/A gf180mcu_as_sc_mcu7t3v3__nand2_2
X_3604_ VDD VDD VSS VSS _3975_/A _3649_/B _3604_/C _3604_/D _3606_/C gf180mcu_as_sc_mcu7t3v3__ao211_2
XFILLER_171_850 VDD VDD VSS VSS gf180mcu_as_sc_mcu7t3v3__fillcap_4
Xinput84 VDD VDD VSS VSS ne_in[15] _4056_/D gf180mcu_as_sc_mcu7t3v3__buff_12
Xinput95 VDD VDD VSS VSS ne_in[25] _4135_/A gf180mcu_as_sc_mcu7t3v3__buff_12
X_3535_ VDD VDD VSS VSS _3799_/A _3932_/B _3535_/A gf180mcu_as_sc_mcu7t3v3__nand2_2
XFILLER_170_360 VDD VDD VSS VSS gf180mcu_as_sc_mcu7t3v3__fillcap_4
Xmax_cap565 VDD VDD VSS VSS _3561_/Y fanout563/A gf180mcu_as_sc_mcu7t3v3__clkbuff_12
X_4892__1076 VDD VDD VSS VSS _4892_/D gf180mcu_as_sc_mcu7t3v3__tiel_4
X_3466_ VDD VDD VSS VSS _4121_/D _3503_/B _3466_/C _3466_/D _3468_/C gf180mcu_as_sc_mcu7t3v3__ao211_2
X_5205_ VDD VDD VSS VSS _5212_/CLK _5205_/D _5205_/Q gf180mcu_as_sc_mcu7t3v3__dfxtp_2
X_2417_ VDD VDD VSS VSS _3224_/D _3510_/A gf180mcu_as_sc_mcu7t3v3__inv_2
X_3397_ VDD VDD VSS VSS _4048_/D _3452_/S _3453_/C _4049_/A _3398_/D gf180mcu_as_sc_mcu7t3v3__ao22_2
X_5136_ VDD VDD VSS VSS _5152_/CLK _5136_/D _5136_/Q gf180mcu_as_sc_mcu7t3v3__dfxtp_2
X_5067_ VDD VDD VSS VSS _5095_/CLK _5067_/D _5067_/Q gf180mcu_as_sc_mcu7t3v3__dfxtp_2
X_4018_ VDD VDD VSS VSS _4106_/S _4018_/B _4018_/A _4019_/B gf180mcu_as_sc_mcu7t3v3__mux2_2
XFILLER_129_1256 VDD VDD VSS VSS gf180mcu_as_sc_mcu7t3v3__fillcap_16
XFILLER_164_1136 VDD VDD VSS VSS gf180mcu_as_sc_mcu7t3v3__fillcap_16
XFILLER_168_1294 VDD VDD VSS VSS gf180mcu_as_sc_mcu7t3v3__fill_1
XTAP_TAPCELL_ROW_68_3_1979 VDD VSS gf180mcu_as_sc_mcu7t3v3__tap_2
XFILLER_179_972 VDD VDD VSS VSS gf180mcu_as_sc_mcu7t3v3__fill_2
XFILLER_185_419 VDD VDD VSS VSS gf180mcu_as_sc_mcu7t3v3__fill_1
XFILLER_165_154 VDD VDD VSS VSS gf180mcu_as_sc_mcu7t3v3__fill_2
XFILLER_10_1014 VDD VDD VSS VSS gf180mcu_as_sc_mcu7t3v3__fill_1
XFILLER_180_102 VDD VDD VSS VSS gf180mcu_as_sc_mcu7t3v3__fill_2
XFILLER_5_816 VDD VDD VSS VSS gf180mcu_as_sc_mcu7t3v3__fillcap_16
XFILLER_10_1036 VDD VDD VSS VSS gf180mcu_as_sc_mcu7t3v3__fill_2
XFILLER_181_658 VDD VDD VSS VSS gf180mcu_as_sc_mcu7t3v3__fillcap_4
XTAP_TAPCELL_ROW_154_1181 VDD VSS gf180mcu_as_sc_mcu7t3v3__tap_2
XTAP_TAPCELL_ROW_154_1170 VDD VSS gf180mcu_as_sc_mcu7t3v3__tap_2
XFILLER_10_1069 VDD VDD VSS VSS gf180mcu_as_sc_mcu7t3v3__fill_2
XFILLER_162_861 VDD VDD VSS VSS gf180mcu_as_sc_mcu7t3v3__fillcap_8
XFILLER_164_22 VDD VDD VSS VSS gf180mcu_as_sc_mcu7t3v3__fillcap_8
XFILLER_175_1254 VDD VDD VSS VSS gf180mcu_as_sc_mcu7t3v3__fillcap_4
XPHY_EDGE_ROW_113_1_Left_305 VDD VSS gf180mcu_as_sc_mcu7t3v3__tap_2
XFILLER_164_99 VDD VDD VSS VSS gf180mcu_as_sc_mcu7t3v3__fillcap_4
XFILLER_57_31 VDD VDD VSS VSS gf180mcu_as_sc_mcu7t3v3__fill_2
XFILLER_5_1351 VDD VDD VSS VSS gf180mcu_as_sc_mcu7t3v3__fillcap_4
XFILLER_112_1260 VDD VDD VSS VSS gf180mcu_as_sc_mcu7t3v3__fill_2
XFILLER_169_1025 VDD VDD VSS VSS gf180mcu_as_sc_mcu7t3v3__fill_1
XFILLER_180_98 VDD VDD VSS VSS gf180mcu_as_sc_mcu7t3v3__fillcap_4
XFILLER_1_1259 VDD VDD VSS VSS gf180mcu_as_sc_mcu7t3v3__fill_1
XFILLER_147_1323 VDD VDD VSS VSS gf180mcu_as_sc_mcu7t3v3__fill_1
XFILLER_189_30 VDD VDD VSS VSS gf180mcu_as_sc_mcu7t3v3__fill_2
XFILLER_95_1288 VDD VDD VSS VSS gf180mcu_as_sc_mcu7t3v3__fillcap_8
XPHY_EDGE_ROW_72_1_Right_581 VDD VSS gf180mcu_as_sc_mcu7t3v3__tap_2
XTAP_TAPCELL_ROW_174_1557 VDD VSS gf180mcu_as_sc_mcu7t3v3__tap_2
XTAP_TAPCELL_ROW_174_1546 VDD VSS gf180mcu_as_sc_mcu7t3v3__tap_2
XFILLER_7_142 VDD VDD VSS VSS gf180mcu_as_sc_mcu7t3v3__fillcap_8
XTAP_TAPCELL_ROW_191_1871 VDD VSS gf180mcu_as_sc_mcu7t3v3__tap_2
XTAP_TAPCELL_ROW_109_1_1062 VDD VSS gf180mcu_as_sc_mcu7t3v3__tap_2
XFILLER_176_1029 VDD VDD VSS VSS gf180mcu_as_sc_mcu7t3v3__fillcap_8
XTAP_TAPCELL_ROW_191_1882 VDD VSS gf180mcu_as_sc_mcu7t3v3__tap_2
XTAP_TAPCELL_ROW_10_884 VDD VSS gf180mcu_as_sc_mcu7t3v3__tap_2
XTAP_TAPCELL_ROW_10_873 VDD VSS gf180mcu_as_sc_mcu7t3v3__tap_2
XPHY_EDGE_ROW_109_3_Left_481 VDD VSS gf180mcu_as_sc_mcu7t3v3__tap_2
X_3320_ VDD VDD VSS VSS _4920_/Q _3369_/B _3369_/C _3974_/A _3321_/C gf180mcu_as_sc_mcu7t3v3__ao22_2
XPHY_EDGE_ROW_45_1_Left_237 VDD VSS gf180mcu_as_sc_mcu7t3v3__tap_2
X_3251_ VDD VDD VSS VSS _3518_/C _3268_/A _3456_/B gf180mcu_as_sc_mcu7t3v3__nand2b_2
XFILLER_152_1040 VDD VDD VSS VSS gf180mcu_as_sc_mcu7t3v3__fillcap_8
X_3182_ VDD VDD VSS VSS _3775_/A _3182_/B _3182_/C _4798_/D _3775_/D gf180mcu_as_sc_mcu7t3v3__aoi211_2
XPHY_EDGE_ROW_133_3_Right_174 VDD VSS gf180mcu_as_sc_mcu7t3v3__tap_2
XFILLER_167_419 VDD VDD VSS VSS gf180mcu_as_sc_mcu7t3v3__fill_1
XPHY_EDGE_ROW_149_1_Right_658 VDD VSS gf180mcu_as_sc_mcu7t3v3__tap_2
X_2966_ VDD VDD VSS VSS _3948_/A _3042_/B _3042_/C _3947_/A _2972_/B gf180mcu_as_sc_mcu7t3v3__ao22_2
XFILLER_176_986 VDD VDD VSS VSS gf180mcu_as_sc_mcu7t3v3__fill_2
X_4705_ VDD VDD VSS VSS _4705_/D _4705_/A _4705_/B _4705_/C _4706_/B gf180mcu_as_sc_mcu7t3v3__ao31_2
X_2897_ VDD VDD VSS VSS _3914_/A _4977_/Q _4943_/Q gf180mcu_as_sc_mcu7t3v3__nor2_2
XFILLER_163_625 VDD VDD VSS VSS gf180mcu_as_sc_mcu7t3v3__fillcap_4
XFILLER_190_411 VDD VDD VSS VSS gf180mcu_as_sc_mcu7t3v3__fill_1
X_4636_ VDD VDD VSS VSS _4639_/S _5113_/Q _5227_/Q _5227_/D gf180mcu_as_sc_mcu7t3v3__mux2_2
XFILLER_118_48 VDD VDD VSS VSS gf180mcu_as_sc_mcu7t3v3__fillcap_4
XFILLER_2_819 VDD VDD VSS VSS gf180mcu_as_sc_mcu7t3v3__fillcap_16
X_4567_ VDD VDD VSS VSS _4567_/B _4591_/A _4574_/C gf180mcu_as_sc_mcu7t3v3__and2_2
X_4498_ VDD VDD VSS VSS _4502_/B _5078_/Q _4500_/S gf180mcu_as_sc_mcu7t3v3__nand2_2
X_3518_ VDD VDD VSS VSS _3520_/C _3518_/C _3518_/B _3518_/A gf180mcu_as_sc_mcu7t3v3__aoi21_2
X_3449_ VDD VDD VSS VSS _3451_/C _4101_/D _3449_/B _3449_/C gf180mcu_as_sc_mcu7t3v3__ao21_2
XPHY_EDGE_ROW_57_3_Right_98 VDD VSS gf180mcu_as_sc_mcu7t3v3__tap_2
XFILLER_135_1293 VDD VDD VSS VSS gf180mcu_as_sc_mcu7t3v3__fillcap_8
X_5119_ VDD VDD VSS VSS _5181_/CLK _5119_/D _5119_/Q gf180mcu_as_sc_mcu7t3v3__dfxtp_2
XPHY_EDGE_ROW_91_1_Left_283 VDD VSS gf180mcu_as_sc_mcu7t3v3__tap_2
XFILLER_27_56 VDD VDD VSS VSS gf180mcu_as_sc_mcu7t3v3__fill_1
XFILLER_150_68 VDD VDD VSS VSS gf180mcu_as_sc_mcu7t3v3__fillcap_4
XFILLER_43_33 VDD VDD VSS VSS gf180mcu_as_sc_mcu7t3v3__fill_1
XTAP_TAPCELL_ROW_16_3_1927 VDD VSS gf180mcu_as_sc_mcu7t3v3__tap_2
XFILLER_167_942 VDD VDD VSS VSS gf180mcu_as_sc_mcu7t3v3__fillcap_16
XTAP_TAPCELL_ROW_156_1210 VDD VSS gf180mcu_as_sc_mcu7t3v3__tap_2
XFILLER_154_625 VDD VDD VSS VSS gf180mcu_as_sc_mcu7t3v3__fill_2
XFILLER_181_411 VDD VDD VSS VSS gf180mcu_as_sc_mcu7t3v3__fillcap_8
XTAP_TAPCELL_ROW_152_1107 VDD VSS gf180mcu_as_sc_mcu7t3v3__tap_2
XFILLER_181_422 VDD VDD VSS VSS gf180mcu_as_sc_mcu7t3v3__fillcap_16
XTAP_TAPCELL_ROW_152_1129 VDD VSS gf180mcu_as_sc_mcu7t3v3__tap_2
XTAP_TAPCELL_ROW_152_1118 VDD VSS gf180mcu_as_sc_mcu7t3v3__tap_2
XFILLER_153_168 VDD VDD VSS VSS gf180mcu_as_sc_mcu7t3v3__fill_1
XFILLER_162_680 VDD VDD VSS VSS gf180mcu_as_sc_mcu7t3v3__fillcap_16
XFILLER_4_27 VDD VDD VSS VSS gf180mcu_as_sc_mcu7t3v3__fillcap_8
XFILLER_1_874 VDD VDD VSS VSS gf180mcu_as_sc_mcu7t3v3__fillcap_8
Xinput230 VDD VDD VSS VSS south_in[23] _4121_/D gf180mcu_as_sc_mcu7t3v3__buff_12
Xinput241 VDD VDD VSS VSS south_in[33] _3787_/A gf180mcu_as_sc_mcu7t3v3__buff_12
Xinput252 VDD VDD VSS VSS sw_in[12] _4034_/A gf180mcu_as_sc_mcu7t3v3__buff_12
Xinput263 VDD VDD VSS VSS sw_in[22] _2444_/A gf180mcu_as_sc_mcu7t3v3__buff_12
XFILLER_124_80 VDD VDD VSS VSS gf180mcu_as_sc_mcu7t3v3__fillcap_4
Xinput274 VDD VDD VSS VSS sw_in[32] _3524_/A gf180mcu_as_sc_mcu7t3v3__buff_12
Xinput285 VDD VDD VSS VSS west_in[11] _4021_/D gf180mcu_as_sc_mcu7t3v3__buff_12
Xinput296 VDD VDD VSS VSS west_in[21] _4101_/A gf180mcu_as_sc_mcu7t3v3__buff_12
XFILLER_84_62 VDD VDD VSS VSS gf180mcu_as_sc_mcu7t3v3__fillcap_4
XFILLER_186_1191 VDD VDD VSS VSS gf180mcu_as_sc_mcu7t3v3__fillcap_4
XFILLER_13_970 VDD VDD VSS VSS gf180mcu_as_sc_mcu7t3v3__fillcap_16
XFILLER_182_1099 VDD VDD VSS VSS gf180mcu_as_sc_mcu7t3v3__fillcap_8
X_2820_ VDD VDD VSS VSS _4974_/D _2828_/B _4759_/Q _4758_/D gf180mcu_as_sc_mcu7t3v3__mux2_2
XFILLER_157_430 VDD VDD VSS VSS gf180mcu_as_sc_mcu7t3v3__fillcap_4
X_2751_ VDD VDD VSS VSS _4718_/A _2833_/A _2812_/B gf180mcu_as_sc_mcu7t3v3__and2_2
XFILLER_121_1326 VDD VDD VSS VSS gf180mcu_as_sc_mcu7t3v3__fill_2
XFILLER_158_986 VDD VDD VSS VSS gf180mcu_as_sc_mcu7t3v3__fill_1
XFILLER_185_772 VDD VDD VSS VSS gf180mcu_as_sc_mcu7t3v3__fill_2
X_2682_ VDD VDD VSS VSS _5157_/Q _4273_/S _4275_/S _5181_/Q _2683_/B gf180mcu_as_sc_mcu7t3v3__ao22_2
XPHY_EDGE_ROW_73_1_Right_582 VDD VSS gf180mcu_as_sc_mcu7t3v3__tap_2
XFILLER_173_945 VDD VDD VSS VSS gf180mcu_as_sc_mcu7t3v3__fill_2
X_4421_ VDD VDD VSS VSS _4538_/A _4421_/B _4421_/C _4424_/C _4553_/D gf180mcu_as_sc_mcu7t3v3__aoi211_2
X_4352_ VDD VDD VSS VSS _4379_/B _4352_/B _5158_/Q _5158_/D gf180mcu_as_sc_mcu7t3v3__mux2_2
XFILLER_152_190 VDD VDD VSS VSS gf180mcu_as_sc_mcu7t3v3__fillcap_4
XFILLER_154_1157 VDD VDD VSS VSS gf180mcu_as_sc_mcu7t3v3__fill_2
X_4283_ VDD VDD VSS VSS _4289_/S _4692_/B _5117_/Q _5117_/D gf180mcu_as_sc_mcu7t3v3__mux2_2
X_3303_ VDD VDD VSS VSS _3303_/B _3525_/A _4807_/D gf180mcu_as_sc_mcu7t3v3__and2_2
X_3234_ VDD VDD VSS VSS _3542_/A _3249_/B _3236_/B _3234_/D _3238_/A gf180mcu_as_sc_mcu7t3v3__ao22_2
X_3165_ VDD VDD VSS VSS _4141_/A _3182_/B _3165_/C _4796_/D _3775_/D gf180mcu_as_sc_mcu7t3v3__aoi211_2
X_3096_ VDD VDD VSS VSS _3097_/C _3096_/C _3192_/C _4069_/A gf180mcu_as_sc_mcu7t3v3__aoi21_2
XFILLER_120_27 VDD VDD VSS VSS gf180mcu_as_sc_mcu7t3v3__fillcap_8
XPHY_EDGE_ROW_134_3_Right_175 VDD VSS gf180mcu_as_sc_mcu7t3v3__tap_2
XFILLER_161_1128 VDD VDD VSS VSS gf180mcu_as_sc_mcu7t3v3__fill_1
X_3998_ VDD VDD VSS VSS _3998_/A _4162_/B _4086_/C _3998_/D _4002_/A gf180mcu_as_sc_mcu7t3v3__ao211_2
XFILLER_13_47 VDD VDD VSS VSS gf180mcu_as_sc_mcu7t3v3__fillcap_8
X_2949_ VDD VDD VSS VSS _3091_/S _3925_/D _3933_/A _2951_/B gf180mcu_as_sc_mcu7t3v3__mux2_2
XFILLER_129_58 VDD VDD VSS VSS gf180mcu_as_sc_mcu7t3v3__fill_1
XFILLER_163_422 VDD VDD VSS VSS gf180mcu_as_sc_mcu7t3v3__fillcap_16
XFILLER_175_282 VDD VDD VSS VSS gf180mcu_as_sc_mcu7t3v3__fill_1
XFILLER_164_989 VDD VDD VSS VSS gf180mcu_as_sc_mcu7t3v3__fillcap_16
X_4619_ VDD VDD VSS VSS _5213_/Q _4621_/B _4621_/C _5214_/Q _5213_/D gf180mcu_as_sc_mcu7t3v3__ao22_2
XFILLER_145_24 VDD VDD VSS VSS gf180mcu_as_sc_mcu7t3v3__fill_1
XFILLER_145_68 VDD VDD VSS VSS gf180mcu_as_sc_mcu7t3v3__fill_2
Xhold1140 VDD VDD VSS VSS _3906_/B hold1140/Y gf180mcu_as_sc_mcu7t3v3__clkbuff_4
Xhold1151 VDD VDD VSS VSS _4970_/Q hold1151/Y gf180mcu_as_sc_mcu7t3v3__clkbuff_4
XTAP_TAPCELL_ROW_71_1_1024 VDD VSS gf180mcu_as_sc_mcu7t3v3__tap_2
XFILLER_161_89 VDD VDD VSS VSS gf180mcu_as_sc_mcu7t3v3__fillcap_4
XFILLER_166_1017 VDD VDD VSS VSS gf180mcu_as_sc_mcu7t3v3__fillcap_4
XFILLER_96_1350 VDD VDD VSS VSS gf180mcu_as_sc_mcu7t3v3__fillcap_4
XFILLER_57_1323 VDD VDD VSS VSS gf180mcu_as_sc_mcu7t3v3__fill_1
XFILLER_159_706 VDD VDD VSS VSS gf180mcu_as_sc_mcu7t3v3__fill_2
XFILLER_186_547 VDD VDD VSS VSS gf180mcu_as_sc_mcu7t3v3__fill_2
XTAP_TAPCELL_ROW_12_913 VDD VSS gf180mcu_as_sc_mcu7t3v3__tap_2
XFILLER_167_750 VDD VDD VSS VSS gf180mcu_as_sc_mcu7t3v3__fillcap_16
XFILLER_9_226 VDD VDD VSS VSS gf180mcu_as_sc_mcu7t3v3__fill_1
XTAP_TAPCELL_ROW_12_924 VDD VSS gf180mcu_as_sc_mcu7t3v3__tap_2
XFILLER_155_912 VDD VDD VSS VSS gf180mcu_as_sc_mcu7t3v3__fill_2
XFILLER_155_923 VDD VDD VSS VSS gf180mcu_as_sc_mcu7t3v3__fillcap_4
XFILLER_167_772 VDD VDD VSS VSS gf180mcu_as_sc_mcu7t3v3__fillcap_4
XFILLER_182_720 VDD VDD VSS VSS gf180mcu_as_sc_mcu7t3v3__fillcap_8
XFILLER_186_53 VDD VDD VSS VSS gf180mcu_as_sc_mcu7t3v3__fillcap_16
XFILLER_6_911 VDD VDD VSS VSS gf180mcu_as_sc_mcu7t3v3__fill_1
XFILLER_154_433 VDD VDD VSS VSS gf180mcu_as_sc_mcu7t3v3__fillcap_4
Xclkload18 VDD VDD VSS VSS clkload18/Y _5203_/CLK gf180mcu_as_sc_mcu7t3v3__inv_6
Xclkload29 VDD VDD VSS VSS clkload29/Y _5267_/CLK gf180mcu_as_sc_mcu7t3v3__inv_6
XFILLER_177_1157 VDD VDD VSS VSS gf180mcu_as_sc_mcu7t3v3__fillcap_8
XTAP_TAPCELL_ROW_169_1456 VDD VSS gf180mcu_as_sc_mcu7t3v3__tap_2
XFILLER_3_1118 VDD VDD VSS VSS gf180mcu_as_sc_mcu7t3v3__fill_2
XFILLER_7_1287 VDD VDD VSS VSS gf180mcu_as_sc_mcu7t3v3__fillcap_8
XFILLER_95_72 VDD VDD VSS VSS gf180mcu_as_sc_mcu7t3v3__fillcap_4
XTAP_TAPCELL_ROW_186_1781 VDD VSS gf180mcu_as_sc_mcu7t3v3__tap_2
XFILLER_188_1275 VDD VDD VSS VSS gf180mcu_as_sc_mcu7t3v3__fillcap_16
X_4970_ VDD VDD VSS VSS _5164_/CLK _4970_/D _4970_/Q gf180mcu_as_sc_mcu7t3v3__dfxtp_2
XFILLER_189_352 VDD VDD VSS VSS gf180mcu_as_sc_mcu7t3v3__fillcap_8
X_3921_ VDD VDD VSS VSS _3922_/A _3922_/B _3922_/C _3921_/Y _3927_/B gf180mcu_as_sc_mcu7t3v3__aoi211_2
XFILLER_189_396 VDD VDD VSS VSS gf180mcu_as_sc_mcu7t3v3__fill_2
X_3852_ VDD VDD VSS VSS _5152_/Q _5151_/Q _3853_/C gf180mcu_as_sc_mcu7t3v3__or2_2
XFILLER_177_569 VDD VDD VSS VSS gf180mcu_as_sc_mcu7t3v3__fill_1
XFILLER_81_2 VDD VDD VSS VSS gf180mcu_as_sc_mcu7t3v3__fillcap_4
X_2803_ VDD VDD VSS VSS _2806_/B _2803_/B _2806_/D gf180mcu_as_sc_mcu7t3v3__nand2_2
XFILLER_160_1161 VDD VDD VSS VSS gf180mcu_as_sc_mcu7t3v3__fill_2
XFILLER_192_517 VDD VDD VSS VSS gf180mcu_as_sc_mcu7t3v3__fillcap_4
XFILLER_192_539 VDD VDD VSS VSS gf180mcu_as_sc_mcu7t3v3__fill_1
X_3783_ VDD VDD VSS VSS _4163_/A _3783_/B _3783_/C _3783_/D _3784_/B gf180mcu_as_sc_mcu7t3v3__ao211_2
XFILLER_157_282 VDD VDD VSS VSS gf180mcu_as_sc_mcu7t3v3__fill_1
X_2734_ VDD VDD VSS VSS _2734_/S _2734_/B _2734_/A _2735_/C gf180mcu_as_sc_mcu7t3v3__mux2_2
XPHY_EDGE_ROW_74_1_Right_583 VDD VSS gf180mcu_as_sc_mcu7t3v3__tap_2
XFILLER_160_403 VDD VDD VSS VSS gf180mcu_as_sc_mcu7t3v3__fillcap_8
XFILLER_161_904 VDD VDD VSS VSS gf180mcu_as_sc_mcu7t3v3__fillcap_4
X_2665_ VDD VDD VSS VSS _2673_/B _5132_/Q _5196_/Q _2666_/C gf180mcu_as_sc_mcu7t3v3__mux2_2
XFILLER_172_274 VDD VDD VSS VSS gf180mcu_as_sc_mcu7t3v3__fillcap_8
X_4404_ VDD VDD VSS VSS _4405_/D _4404_/B _4502_/A gf180mcu_as_sc_mcu7t3v3__nor2_2
X_2596_ VDD VDD VSS VSS _5126_/Q _5099_/Q _2597_/D gf180mcu_as_sc_mcu7t3v3__xnor2_2
X_4335_ VDD VDD VSS VSS _4574_/B _4366_/S _4378_/D gf180mcu_as_sc_mcu7t3v3__and2_2
XFILLER_5_92 VDD VDD VSS VSS gf180mcu_as_sc_mcu7t3v3__fill_2
X_4266_ VDD VDD VSS VSS _4272_/S _4718_/A _5100_/Q _5100_/D gf180mcu_as_sc_mcu7t3v3__mux2_2
XFILLER_171_1290 VDD VDD VSS VSS gf180mcu_as_sc_mcu7t3v3__fill_1
XFILLER_45_1293 VDD VDD VSS VSS gf180mcu_as_sc_mcu7t3v3__fillcap_4
X_4197_ VDD VDD VSS VSS _4257_/B _4197_/B _4197_/C _5035_/Q _5035_/D gf180mcu_as_sc_mcu7t3v3__ao22_2
X_3217_ VDD VDD VSS VSS _3241_/B _3802_/A _3217_/A _3218_/C gf180mcu_as_sc_mcu7t3v3__mux2_2
X_3148_ VDD VDD VSS VSS _3148_/A _3148_/B _3148_/C _3149_/C gf180mcu_as_sc_mcu7t3v3__nor3_2
X_3079_ VDD VDD VSS VSS _4057_/A _3130_/B _3079_/C _3079_/D _3080_/C gf180mcu_as_sc_mcu7t3v3__ao22_2
XTAP_TAPCELL_ROW_132_1_1085 VDD VSS gf180mcu_as_sc_mcu7t3v3__tap_2
XPHY_EDGE_ROW_135_3_Right_176 VDD VSS gf180mcu_as_sc_mcu7t3v3__tap_2
XPHY_EDGE_ROW_122_1_Left_314 VDD VSS gf180mcu_as_sc_mcu7t3v3__tap_2
XFILLER_11_726 VDD VDD VSS VSS gf180mcu_as_sc_mcu7t3v3__fillcap_16
XFILLER_155_208 VDD VDD VSS VSS gf180mcu_as_sc_mcu7t3v3__fill_2
XFILLER_156_34 VDD VDD VSS VSS gf180mcu_as_sc_mcu7t3v3__fill_1
XFILLER_164_753 VDD VDD VSS VSS gf180mcu_as_sc_mcu7t3v3__fillcap_4
XTAP_TAPCELL_ROW_90_3_2001 VDD VSS gf180mcu_as_sc_mcu7t3v3__tap_2
XFILLER_156_78 VDD VDD VSS VSS gf180mcu_as_sc_mcu7t3v3__fillcap_8
XFILLER_163_274 VDD VDD VSS VSS gf180mcu_as_sc_mcu7t3v3__fillcap_4
XFILLER_191_594 VDD VDD VSS VSS gf180mcu_as_sc_mcu7t3v3__fillcap_16
XFILLER_2_457 VDD VDD VSS VSS gf180mcu_as_sc_mcu7t3v3__fill_2
XFILLER_172_1087 VDD VDD VSS VSS gf180mcu_as_sc_mcu7t3v3__fillcap_16
XFILLER_172_55 VDD VDD VSS VSS gf180mcu_as_sc_mcu7t3v3__fill_1
Xfanout750 VDD VDD VSS VSS _2931_/Y _3236_/C gf180mcu_as_sc_mcu7t3v3__buff_12
XFILLER_111_1303 VDD VDD VSS VSS gf180mcu_as_sc_mcu7t3v3__fillcap_4
Xfanout761 VDD VDD VSS VSS _2902_/Y _3178_/D gf180mcu_as_sc_mcu7t3v3__buff_12
Xfanout772 VDD VDD VSS VSS _2909_/Y _3127_/B gf180mcu_as_sc_mcu7t3v3__buff_12
Xfanout783 VDD VDD VSS VSS _4281_/S _4275_/S gf180mcu_as_sc_mcu7t3v3__buff_12
XTAP_TAPCELL_ROW_6_796 VDD VSS gf180mcu_as_sc_mcu7t3v3__tap_2
XFILLER_45_100 VDD VDD VSS VSS gf180mcu_as_sc_mcu7t3v3__fillcap_4
XFILLER_65_20 VDD VDD VSS VSS gf180mcu_as_sc_mcu7t3v3__fill_2
XTAP_TAPCELL_ROW_164_1353 VDD VSS gf180mcu_as_sc_mcu7t3v3__tap_2
XTAP_TAPCELL_ROW_164_1364 VDD VSS gf180mcu_as_sc_mcu7t3v3__tap_2
XFILLER_148_1270 VDD VDD VSS VSS gf180mcu_as_sc_mcu7t3v3__fill_1
XPHY_EDGE_ROW_54_1_Left_246 VDD VSS gf180mcu_as_sc_mcu7t3v3__tap_2
XPHY_EDGE_ROW_118_3_Left_490 VDD VSS gf180mcu_as_sc_mcu7t3v3__tap_2
XFILLER_187_878 VDD VDD VSS VSS gf180mcu_as_sc_mcu7t3v3__fillcap_4
XFILLER_10_770 VDD VDD VSS VSS gf180mcu_as_sc_mcu7t3v3__fillcap_4
XFILLER_31_1326 VDD VDD VSS VSS gf180mcu_as_sc_mcu7t3v3__fill_2
XFILLER_170_734 VDD VDD VSS VSS gf180mcu_as_sc_mcu7t3v3__fill_1
XFILLER_6_796 VDD VDD VSS VSS gf180mcu_as_sc_mcu7t3v3__fill_1
X_2450_ VDD VDD VSS VSS _3192_/A _4162_/A gf180mcu_as_sc_mcu7t3v3__inv_2
XPHY_EDGE_ROW_137_3_Left_509 VDD VSS gf180mcu_as_sc_mcu7t3v3__tap_2
XTAP_TAPCELL_ROW_188_1821 VDD VSS gf180mcu_as_sc_mcu7t3v3__tap_2
XTAP_TAPCELL_ROW_188_1810 VDD VSS gf180mcu_as_sc_mcu7t3v3__tap_2
XFILLER_155_1241 VDD VDD VSS VSS gf180mcu_as_sc_mcu7t3v3__fill_1
XFILLER_190_1154 VDD VDD VSS VSS gf180mcu_as_sc_mcu7t3v3__fill_1
XFILLER_190_1187 VDD VDD VSS VSS gf180mcu_as_sc_mcu7t3v3__fill_1
X_4120_ VDD VDD VSS VSS _4120_/A _4160_/C _4129_/C _4938_/Q _4122_/C gf180mcu_as_sc_mcu7t3v3__ao22_2
X_4051_ VDD VDD VSS VSS _4051_/B _4165_/A _4243_/B gf180mcu_as_sc_mcu7t3v3__and2_2
Xinput5 VDD VDD VSS VSS boot_addr[3] input5/Y gf180mcu_as_sc_mcu7t3v3__buff_12
X_3002_ VDD VDD VSS VSS _3045_/A _3002_/B _3002_/C _3045_/D _3004_/C gf180mcu_as_sc_mcu7t3v3__ao211_2
XFILLER_188_1083 VDD VDD VSS VSS gf180mcu_as_sc_mcu7t3v3__fill_2
X_4953_ VDD VDD VSS VSS _5267_/CLK _4953_/D _4953_/Q gf180mcu_as_sc_mcu7t3v3__dfxtp_2
X_3904_ VDD VDD VSS VSS _3905_/B _5163_/Q _4944_/D gf180mcu_as_sc_mcu7t3v3__and2_2
XFILLER_178_867 VDD VDD VSS VSS gf180mcu_as_sc_mcu7t3v3__fill_1
X_4884_ VDD VDD VSS VSS _4895_/CLK _4884_/D _4884_/Q gf180mcu_as_sc_mcu7t3v3__dfxtp_2
X_3835_ VDD VDD VSS VSS _3843_/B _3835_/B _4168_/A gf180mcu_as_sc_mcu7t3v3__nand2_2
X_3766_ VDD VDD VSS VSS _3767_/B _4147_/A _3802_/B _3766_/C gf180mcu_as_sc_mcu7t3v3__ao21_2
XFILLER_192_369 VDD VDD VSS VSS gf180mcu_as_sc_mcu7t3v3__fill_1
X_2717_ VDD VDD VSS VSS _2724_/S _5178_/Q _5170_/Q _2721_/B gf180mcu_as_sc_mcu7t3v3__mux2_2
XFILLER_10_37 VDD VDD VSS VSS gf180mcu_as_sc_mcu7t3v3__fillcap_16
X_3697_ VDD VDD VSS VSS _4070_/A _3792_/B _3697_/C _3775_/B _3698_/C gf180mcu_as_sc_mcu7t3v3__ao211_2
XPHY_EDGE_ROW_75_1_Right_584 VDD VSS gf180mcu_as_sc_mcu7t3v3__tap_2
XFILLER_160_244 VDD VDD VSS VSS gf180mcu_as_sc_mcu7t3v3__fill_1
XFILLER_47_1322 VDD VDD VSS VSS gf180mcu_as_sc_mcu7t3v3__fill_2
Xoutput353 VDD VDD VSS VSS _4843_/Q east_out[4] gf180mcu_as_sc_mcu7t3v3__buff_12
Xoutput342 VDD VDD VSS VSS _4864_/Q east_out[25] gf180mcu_as_sc_mcu7t3v3__buff_12
Xoutput331 VDD VDD VSS VSS _4854_/Q east_out[15] gf180mcu_as_sc_mcu7t3v3__buff_12
Xoutput320 VDD VDD VSS VSS _5481_/Y dft_rdata[3] gf180mcu_as_sc_mcu7t3v3__buff_12
X_2648_ VDD VDD VSS VSS _2649_/C _2648_/B _4262_/B gf180mcu_as_sc_mcu7t3v3__nor2_2
XFILLER_0_917 VDD VDD VSS VSS gf180mcu_as_sc_mcu7t3v3__fill_1
XFILLER_126_59 VDD VDD VSS VSS gf180mcu_as_sc_mcu7t3v3__fill_2
XFILLER_160_288 VDD VDD VSS VSS gf180mcu_as_sc_mcu7t3v3__fill_2
XFILLER_173_1352 VDD VDD VSS VSS gf180mcu_as_sc_mcu7t3v3__fill_2
Xoutput386 VDD VDD VSS VSS _4774_/Q se_out[3] gf180mcu_as_sc_mcu7t3v3__buff_12
Xoutput375 VDD VDD VSS VSS _4795_/Q se_out[24] gf180mcu_as_sc_mcu7t3v3__buff_12
Xoutput364 VDD VDD VSS VSS _4785_/Q se_out[14] gf180mcu_as_sc_mcu7t3v3__buff_12
X_2579_ VDD VDD VSS VSS _2666_/D _2674_/C gf180mcu_as_sc_mcu7t3v3__inv_2
XTAP_TAPCELL_ROW_151_3_2062 VDD VSS gf180mcu_as_sc_mcu7t3v3__tap_2
Xoutput397 VDD VDD VSS VSS _4818_/Q south_out[13] gf180mcu_as_sc_mcu7t3v3__buff_12
X_4318_ VDD VDD VSS VSS _4319_/S _5148_/Q _5147_/Q _5147_/D gf180mcu_as_sc_mcu7t3v3__mux2_2
X_4249_ VDD VDD VSS VSS _4257_/S _4249_/B _5085_/Q _5085_/D gf180mcu_as_sc_mcu7t3v3__mux2_2
XFILLER_142_58 VDD VDD VSS VSS gf180mcu_as_sc_mcu7t3v3__fillcap_4
XFILLER_19_68 VDD VDD VSS VSS gf180mcu_as_sc_mcu7t3v3__fill_2
XFILLER_27_100 VDD VDD VSS VSS gf180mcu_as_sc_mcu7t3v3__fillcap_4
XTAP_TAPCELL_ROW_3_755 VDD VSS gf180mcu_as_sc_mcu7t3v3__tap_2
XTAP_TAPCELL_ROW_3_744 VDD VSS gf180mcu_as_sc_mcu7t3v3__tap_2
XFILLER_42_103 VDD VDD VSS VSS gf180mcu_as_sc_mcu7t3v3__fill_2
XFILLER_167_1189 VDD VDD VSS VSS gf180mcu_as_sc_mcu7t3v3__fill_1
XFILLER_169_812 VDD VDD VSS VSS gf180mcu_as_sc_mcu7t3v3__fill_2
XFILLER_169_834 VDD VDD VSS VSS gf180mcu_as_sc_mcu7t3v3__fillcap_4
XFILLER_168_333 VDD VDD VSS VSS gf180mcu_as_sc_mcu7t3v3__fillcap_4
XPHY_EDGE_ROW_136_3_Right_177 VDD VSS gf180mcu_as_sc_mcu7t3v3__tap_2
XFILLER_13_1056 VDD VDD VSS VSS gf180mcu_as_sc_mcu7t3v3__fillcap_8
XFILLER_167_88 VDD VDD VSS VSS gf180mcu_as_sc_mcu7t3v3__fill_2
Xwire469 VDD VDD VSS VSS _3580_/Y _4840_/D gf180mcu_as_sc_mcu7t3v3__clkbuff_12
XFILLER_192_881 VDD VDD VSS VSS gf180mcu_as_sc_mcu7t3v3__fill_2
XFILLER_152_745 VDD VDD VSS VSS gf180mcu_as_sc_mcu7t3v3__fill_2
XFILLER_178_1285 VDD VDD VSS VSS gf180mcu_as_sc_mcu7t3v3__fillcap_4
XFILLER_183_54 VDD VDD VSS VSS gf180mcu_as_sc_mcu7t3v3__fillcap_16
XFILLER_3_799 VDD VDD VSS VSS gf180mcu_as_sc_mcu7t3v3__fillcap_8
XTAP_TAPCELL_ROW_166_1404 VDD VSS gf180mcu_as_sc_mcu7t3v3__tap_2
XFILLER_4_1213 VDD VDD VSS VSS gf180mcu_as_sc_mcu7t3v3__fill_1
Xfanout580 VDD VDD VSS VSS fanout580/A _3132_/B gf180mcu_as_sc_mcu7t3v3__buff_12
Xfanout591 VDD VDD VSS VSS _3919_/Y _4104_/B gf180mcu_as_sc_mcu7t3v3__buff_12
XTAP_TAPCELL_ROW_86_3_1997 VDD VSS gf180mcu_as_sc_mcu7t3v3__tap_2
XFILLER_181_1109 VDD VDD VSS VSS gf180mcu_as_sc_mcu7t3v3__fillcap_8
XFILLER_178_119 VDD VDD VSS VSS gf180mcu_as_sc_mcu7t3v3__fill_2
XFILLER_175_837 VDD VDD VSS VSS gf180mcu_as_sc_mcu7t3v3__fill_2
XFILLER_174_314 VDD VDD VSS VSS gf180mcu_as_sc_mcu7t3v3__fill_1
XFILLER_187_697 VDD VDD VSS VSS gf180mcu_as_sc_mcu7t3v3__fill_2
X_3620_ VDD VDD VSS VSS _3989_/A _3650_/B _3620_/C _3620_/D _3621_/D gf180mcu_as_sc_mcu7t3v3__ao211_2
XFILLER_174_358 VDD VDD VSS VSS gf180mcu_as_sc_mcu7t3v3__fillcap_16
XFILLER_190_807 VDD VDD VSS VSS gf180mcu_as_sc_mcu7t3v3__fillcap_4
X_3551_ VDD VDD VSS VSS _3561_/A _3551_/B _3551_/A gf180mcu_as_sc_mcu7t3v3__nand2_2
Xmax_cap736 VDD VDD VSS VSS fanout735/Y _3178_/A gf180mcu_as_sc_mcu7t3v3__clkbuff_12
X_2502_ VDD VDD VSS VSS _4746_/D _4691_/A _2502_/C _2502_/D _2503_/B gf180mcu_as_sc_mcu7t3v3__ao211_2
XFILLER_157_1325 VDD VDD VSS VSS gf180mcu_as_sc_mcu7t3v3__fillcap_4
Xmax_cap747 VDD VDD VSS VSS _3250_/Y fanout746/A gf180mcu_as_sc_mcu7t3v3__clkbuff_12
X_3482_ VDD VDD VSS VSS _4139_/A _3523_/B _3482_/C _3482_/D _3483_/B gf180mcu_as_sc_mcu7t3v3__ao211_2
XFILLER_170_575 VDD VDD VSS VSS gf180mcu_as_sc_mcu7t3v3__fill_1
X_5221_ VDD VDD VSS VSS _5280_/CLK _5221_/D _5221_/Q gf180mcu_as_sc_mcu7t3v3__dfxtp_2
X_2433_ VDD VDD VSS VSS _4027_/A _2433_/A gf180mcu_as_sc_mcu7t3v3__inv_2
X_5152_ VDD VDD VSS VSS _5152_/CLK _5152_/D _5152_/Q gf180mcu_as_sc_mcu7t3v3__dfxtp_2
X_4103_ VDD VDD VSS VSS _4103_/A _4103_/B _4103_/C _4103_/D _4105_/C gf180mcu_as_sc_mcu7t3v3__ao211_2
X_5083_ VDD VDD VSS VSS _5185_/CLK _5083_/D _5083_/Q gf180mcu_as_sc_mcu7t3v3__dfxtp_2
X_4034_ VDD VDD VSS VSS _4106_/S _4034_/B _4034_/A _4035_/B gf180mcu_as_sc_mcu7t3v3__mux2_2
XFILLER_77_1304 VDD VDD VSS VSS gf180mcu_as_sc_mcu7t3v3__fill_1
XFILLER_77_1326 VDD VDD VSS VSS gf180mcu_as_sc_mcu7t3v3__fillcap_4
XFILLER_24_103 VDD VDD VSS VSS gf180mcu_as_sc_mcu7t3v3__fill_2
X_4936_ VDD VDD VSS VSS _5164_/CLK _4936_/D _4936_/Q gf180mcu_as_sc_mcu7t3v3__dfxtp_2
XANTENNA_10 VDD VDD VSS VSS _2649_/B gf180mcu_as_sc_mcu7t3v3__diode_2
XANTENNA_21 VDD VDD VSS VSS _4107_/B gf180mcu_as_sc_mcu7t3v3__diode_2
XANTENNA_32 VDD VDD VSS VSS _3848_/A gf180mcu_as_sc_mcu7t3v3__diode_2
X_4867_ VDD VDD VSS VSS _5097_/CLK _4867_/D _4867_/Q gf180mcu_as_sc_mcu7t3v3__dfxtp_2
XANTENNA_43 VDD VDD VSS VSS _4124_/A gf180mcu_as_sc_mcu7t3v3__diode_2
XFILLER_165_336 VDD VDD VSS VSS gf180mcu_as_sc_mcu7t3v3__fillcap_8
X_3818_ VDD VDD VSS VSS _3818_/A _3818_/B _3818_/C _3818_/D _3915_/A gf180mcu_as_sc_mcu7t3v3__ao22_2
XFILLER_14_1343 VDD VDD VSS VSS gf180mcu_as_sc_mcu7t3v3__fillcap_8
XFILLER_192_144 VDD VDD VSS VSS gf180mcu_as_sc_mcu7t3v3__fill_1
X_4798_ VDD VDD VSS VSS _5226_/CLK _4798_/D _4798_/Q gf180mcu_as_sc_mcu7t3v3__dfxtp_2
XTAP_TAPCELL_ROW_127_1_1080 VDD VSS gf180mcu_as_sc_mcu7t3v3__tap_2
XFILLER_180_328 VDD VDD VSS VSS gf180mcu_as_sc_mcu7t3v3__fillcap_16
XFILLER_21_69 VDD VDD VSS VSS gf180mcu_as_sc_mcu7t3v3__fill_1
X_3749_ VDD VDD VSS VSS _4130_/A _3771_/B _3749_/C _3749_/D _3751_/C gf180mcu_as_sc_mcu7t3v3__ao211_2
XFILLER_137_69 VDD VDD VSS VSS gf180mcu_as_sc_mcu7t3v3__fill_1
XPHY_EDGE_ROW_76_1_Right_585 VDD VSS gf180mcu_as_sc_mcu7t3v3__tap_2
XTAP_TAPCELL_ROW_8_847 VDD VSS gf180mcu_as_sc_mcu7t3v3__tap_2
XTAP_TAPCELL_ROW_8_836 VDD VSS gf180mcu_as_sc_mcu7t3v3__tap_2
XFILLER_0_747 VDD VDD VSS VSS gf180mcu_as_sc_mcu7t3v3__fill_1
XFILLER_138_1291 VDD VDD VSS VSS gf180mcu_as_sc_mcu7t3v3__fillcap_16
XFILLER_46_33 VDD VDD VSS VSS gf180mcu_as_sc_mcu7t3v3__fill_2
XTAP_TAPCELL_ROW_161_1301 VDD VSS gf180mcu_as_sc_mcu7t3v3__tap_2
XTAP_TAPCELL_ROW_161_1312 VDD VSS gf180mcu_as_sc_mcu7t3v3__tap_2
XFILLER_58_1281 VDD VDD VSS VSS gf180mcu_as_sc_mcu7t3v3__fillcap_8
XFILLER_62_43 VDD VDD VSS VSS gf180mcu_as_sc_mcu7t3v3__fill_1
XFILLER_156_303 VDD VDD VSS VSS gf180mcu_as_sc_mcu7t3v3__fill_2
XFILLER_184_612 VDD VDD VSS VSS gf180mcu_as_sc_mcu7t3v3__fillcap_4
XFILLER_12_887 VDD VDD VSS VSS gf180mcu_as_sc_mcu7t3v3__fill_1
XFILLER_12_898 VDD VDD VSS VSS gf180mcu_as_sc_mcu7t3v3__fillcap_4
XFILLER_156_325 VDD VDD VSS VSS gf180mcu_as_sc_mcu7t3v3__fill_1
XFILLER_156_336 VDD VDD VSS VSS gf180mcu_as_sc_mcu7t3v3__fillcap_16
XFILLER_157_837 VDD VDD VSS VSS gf180mcu_as_sc_mcu7t3v3__fill_2
XFILLER_169_697 VDD VDD VSS VSS gf180mcu_as_sc_mcu7t3v3__fill_2
XFILLER_19_1298 VDD VDD VSS VSS gf180mcu_as_sc_mcu7t3v3__fill_1
XFILLER_7_27 VDD VDD VSS VSS gf180mcu_as_sc_mcu7t3v3__fillcap_4
XTAP_TAPCELL_ROW_159_1274 VDD VSS gf180mcu_as_sc_mcu7t3v3__tap_2
XTAP_TAPCELL_ROW_159_1263 VDD VSS gf180mcu_as_sc_mcu7t3v3__tap_2
XPHY_EDGE_ROW_137_3_Right_178 VDD VSS gf180mcu_as_sc_mcu7t3v3__tap_2
XFILLER_172_807 VDD VDD VSS VSS gf180mcu_as_sc_mcu7t3v3__fillcap_8
XFILLER_184_667 VDD VDD VSS VSS gf180mcu_as_sc_mcu7t3v3__fillcap_4
XFILLER_7_49 VDD VDD VSS VSS gf180mcu_as_sc_mcu7t3v3__fillcap_16
XFILLER_172_829 VDD VDD VSS VSS gf180mcu_as_sc_mcu7t3v3__fillcap_8
XFILLER_152_542 VDD VDD VSS VSS gf180mcu_as_sc_mcu7t3v3__fill_2
XFILLER_180_873 VDD VDD VSS VSS gf180mcu_as_sc_mcu7t3v3__fill_2
XFILLER_152_1211 VDD VDD VSS VSS gf180mcu_as_sc_mcu7t3v3__fillcap_4
XFILLER_117_1353 VDD VDD VSS VSS gf180mcu_as_sc_mcu7t3v3__fill_2
XFILLER_152_1222 VDD VDD VSS VSS gf180mcu_as_sc_mcu7t3v3__fill_2
XFILLER_185_1020 VDD VDD VSS VSS gf180mcu_as_sc_mcu7t3v3__fill_1
XTAP_TAPCELL_ROW_19_1_972 VDD VSS gf180mcu_as_sc_mcu7t3v3__tap_2
XPHY_EDGE_ROW_99_3_Right_140 VDD VSS gf180mcu_as_sc_mcu7t3v3__tap_2
X_2982_ VDD VDD VSS VSS _2989_/B _3047_/B _3969_/A gf180mcu_as_sc_mcu7t3v3__nand2_2
XTAP_TAPCELL_ROW_34_3_1945 VDD VSS gf180mcu_as_sc_mcu7t3v3__tap_2
XTAP_TAPCELL_ROW_179_1639 VDD VSS gf180mcu_as_sc_mcu7t3v3__tap_2
XFILLER_188_962 VDD VDD VSS VSS gf180mcu_as_sc_mcu7t3v3__fillcap_4
XFILLER_72_1256 VDD VDD VSS VSS gf180mcu_as_sc_mcu7t3v3__fillcap_8
X_4721_ VDD VDD VSS VSS _4721_/B _4721_/A _4730_/C gf180mcu_as_sc_mcu7t3v3__and2_2
XFILLER_174_111 VDD VDD VSS VSS gf180mcu_as_sc_mcu7t3v3__fill_2
X_4652_ VDD VDD VSS VSS _4746_/D _5224_/Q _5238_/Q _4733_/A _4653_/B gf180mcu_as_sc_mcu7t3v3__ao22_2
XPHY_EDGE_ROW_17_1_Left_209 VDD VSS gf180mcu_as_sc_mcu7t3v3__tap_2
Xinput30 VDD VDD VSS VSS dft_addr[7] _2668_/A gf180mcu_as_sc_mcu7t3v3__buff_12
X_3603_ VDD VDD VSS VSS _4920_/Q _3648_/B _3648_/C _3974_/A _3604_/D gf180mcu_as_sc_mcu7t3v3__ao22_2
XFILLER_162_306 VDD VDD VSS VSS gf180mcu_as_sc_mcu7t3v3__fillcap_8
XFILLER_162_317 VDD VDD VSS VSS gf180mcu_as_sc_mcu7t3v3__fillcap_8
Xinput41 VDD VDD VSS VSS dft_wdata[6] _2730_/B gf180mcu_as_sc_mcu7t3v3__buff_12
Xinput52 VDD VDD VSS VSS east_in[17] wire865/A gf180mcu_as_sc_mcu7t3v3__buff_12
Xinput63 VDD VDD VSS VSS east_in[27] _4153_/A gf180mcu_as_sc_mcu7t3v3__buff_12
X_4583_ VDD VDD VSS VSS _5187_/Q _4592_/B _4583_/C _4583_/D _5187_/D gf180mcu_as_sc_mcu7t3v3__ao211_2
XFILLER_155_380 VDD VDD VSS VSS gf180mcu_as_sc_mcu7t3v3__fill_2
XFILLER_157_1122 VDD VDD VSS VSS gf180mcu_as_sc_mcu7t3v3__fillcap_4
XFILLER_192_1013 VDD VDD VSS VSS gf180mcu_as_sc_mcu7t3v3__fill_2
XFILLER_7_891 VDD VDD VSS VSS gf180mcu_as_sc_mcu7t3v3__fillcap_16
Xinput74 VDD VDD VSS VSS east_in[6] _3983_/A gf180mcu_as_sc_mcu7t3v3__buff_12
Xinput85 VDD VDD VSS VSS ne_in[16] _4064_/D gf180mcu_as_sc_mcu7t3v3__buff_12
Xinput96 VDD VDD VSS VSS ne_in[26] _4146_/D gf180mcu_as_sc_mcu7t3v3__buff_12
X_3534_ VDD VDD VSS VSS _3818_/A _3534_/A _3932_/B gf180mcu_as_sc_mcu7t3v3__and2_2
X_3465_ VDD VDD VSS VSS _4938_/Q _3493_/B _3501_/B _4120_/A _3466_/D gf180mcu_as_sc_mcu7t3v3__ao22_2
XFILLER_157_1188 VDD VDD VSS VSS gf180mcu_as_sc_mcu7t3v3__fill_2
X_5204_ VDD VDD VSS VSS _5212_/CLK _5204_/D _5204_/Q gf180mcu_as_sc_mcu7t3v3__dfxtp_2
X_2416_ VDD VDD VSS VSS _2695_/A _2732_/S gf180mcu_as_sc_mcu7t3v3__inv_2
X_3396_ VDD VDD VSS VSS _3451_/B _4046_/A _3396_/A _3398_/C gf180mcu_as_sc_mcu7t3v3__mux2_2
X_5135_ VDD VDD VSS VSS _5152_/CLK _5135_/D _5135_/Q gf180mcu_as_sc_mcu7t3v3__dfxtp_2
XPHY_EDGE_ROW_131_1_Left_323 VDD VSS gf180mcu_as_sc_mcu7t3v3__tap_2
X_5066_ VDD VDD VSS VSS _5182_/CLK _5066_/D _5066_/Q gf180mcu_as_sc_mcu7t3v3__dfxtp_2
X_4017_ VDD VDD VSS VSS _4017_/A _4105_/B _4017_/C _4017_/D _4018_/B gf180mcu_as_sc_mcu7t3v3__ao211_2
XFILLER_168_1273 VDD VDD VSS VSS gf180mcu_as_sc_mcu7t3v3__fill_1
XFILLER_13_618 VDD VDD VSS VSS gf180mcu_as_sc_mcu7t3v3__fill_2
XFILLER_164_1159 VDD VDD VSS VSS gf180mcu_as_sc_mcu7t3v3__fill_1
XFILLER_12_139 VDD VDD VSS VSS gf180mcu_as_sc_mcu7t3v3__fillcap_16
X_4919_ VDD VDD VSS VSS clkload1/A _4919_/D _4919_/Q gf180mcu_as_sc_mcu7t3v3__dfxtp_2
XFILLER_154_807 VDD VDD VSS VSS gf180mcu_as_sc_mcu7t3v3__fillcap_4
XFILLER_166_667 VDD VDD VSS VSS gf180mcu_as_sc_mcu7t3v3__fillcap_16
XFILLER_148_68 VDD VDD VSS VSS gf180mcu_as_sc_mcu7t3v3__fill_1
XFILLER_166_689 VDD VDD VSS VSS gf180mcu_as_sc_mcu7t3v3__fill_1
XTAP_TAPCELL_ROW_138_3_2049 VDD VSS gf180mcu_as_sc_mcu7t3v3__tap_2
XFILLER_175_1200 VDD VDD VSS VSS gf180mcu_as_sc_mcu7t3v3__fillcap_4
XTAP_TAPCELL_ROW_154_1171 VDD VSS gf180mcu_as_sc_mcu7t3v3__tap_2
XFILLER_162_873 VDD VDD VSS VSS gf180mcu_as_sc_mcu7t3v3__fill_2
XFILLER_164_34 VDD VDD VSS VSS gf180mcu_as_sc_mcu7t3v3__fill_1
XFILLER_175_1233 VDD VDD VSS VSS gf180mcu_as_sc_mcu7t3v3__fill_2
XFILLER_175_1266 VDD VDD VSS VSS gf180mcu_as_sc_mcu7t3v3__fill_1
XFILLER_175_1277 VDD VDD VSS VSS gf180mcu_as_sc_mcu7t3v3__fillcap_4
XPHY_EDGE_ROW_77_1_Right_586 VDD VSS gf180mcu_as_sc_mcu7t3v3__tap_2
XPHY_EDGE_ROW_63_1_Left_255 VDD VSS gf180mcu_as_sc_mcu7t3v3__tap_2
XFILLER_180_22 VDD VDD VSS VSS gf180mcu_as_sc_mcu7t3v3__fillcap_8
XFILLER_57_76 VDD VDD VSS VSS gf180mcu_as_sc_mcu7t3v3__fill_2
XFILLER_25_1291 VDD VDD VSS VSS gf180mcu_as_sc_mcu7t3v3__fillcap_4
XPHY_EDGE_ROW_11_Left_204 VDD VSS gf180mcu_as_sc_mcu7t3v3__tap_2
XFILLER_73_31 VDD VDD VSS VSS gf180mcu_as_sc_mcu7t3v3__fill_2
XFILLER_188_247 VDD VDD VSS VSS gf180mcu_as_sc_mcu7t3v3__fillcap_4
XPHY_EDGE_ROW_146_3_Left_518 VDD VSS gf180mcu_as_sc_mcu7t3v3__tap_2
XPHY_EDGE_ROW_159_Left_351 VDD VSS gf180mcu_as_sc_mcu7t3v3__tap_2
XFILLER_169_483 VDD VDD VSS VSS gf180mcu_as_sc_mcu7t3v3__fillcap_4
XFILLER_169_494 VDD VDD VSS VSS gf180mcu_as_sc_mcu7t3v3__fill_1
XFILLER_185_932 VDD VDD VSS VSS gf180mcu_as_sc_mcu7t3v3__fill_2
XFILLER_12_695 VDD VDD VSS VSS gf180mcu_as_sc_mcu7t3v3__fill_2
XFILLER_157_667 VDD VDD VSS VSS gf180mcu_as_sc_mcu7t3v3__fill_2
XFILLER_184_453 VDD VDD VSS VSS gf180mcu_as_sc_mcu7t3v3__fill_2
XFILLER_7_121 VDD VDD VSS VSS gf180mcu_as_sc_mcu7t3v3__fillcap_8
XTAP_TAPCELL_ROW_174_1558 VDD VSS gf180mcu_as_sc_mcu7t3v3__tap_2
XTAP_TAPCELL_ROW_174_1547 VDD VSS gf180mcu_as_sc_mcu7t3v3__tap_2
XPHY_EDGE_ROW_138_3_Right_179 VDD VSS gf180mcu_as_sc_mcu7t3v3__tap_2
XFILLER_172_648 VDD VDD VSS VSS gf180mcu_as_sc_mcu7t3v3__fillcap_4
XFILLER_7_176 VDD VDD VSS VSS gf180mcu_as_sc_mcu7t3v3__fillcap_4
XTAP_TAPCELL_ROW_191_1883 VDD VSS gf180mcu_as_sc_mcu7t3v3__tap_2
XTAP_TAPCELL_ROW_191_1872 VDD VSS gf180mcu_as_sc_mcu7t3v3__tap_2
XTAP_TAPCELL_ROW_10_885 VDD VSS gf180mcu_as_sc_mcu7t3v3__tap_2
XTAP_TAPCELL_ROW_10_874 VDD VSS gf180mcu_as_sc_mcu7t3v3__tap_2
XFILLER_152_394 VDD VDD VSS VSS gf180mcu_as_sc_mcu7t3v3__fillcap_8
X_3250_ VDD VDD VSS VSS _3250_/Y _3510_/C _3519_/C gf180mcu_as_sc_mcu7t3v3__nand2_2
XPHY_EDGE_ROW_168_Left_360 VDD VSS gf180mcu_as_sc_mcu7t3v3__tap_2
XFILLER_152_1030 VDD VDD VSS VSS gf180mcu_as_sc_mcu7t3v3__fill_1
XFILLER_152_1052 VDD VDD VSS VSS gf180mcu_as_sc_mcu7t3v3__fill_2
X_3181_ VDD VDD VSS VSS _3182_/B _3181_/B _3181_/C _3182_/C gf180mcu_as_sc_mcu7t3v3__nor3_2
XFILLER_187_1148 VDD VDD VSS VSS gf180mcu_as_sc_mcu7t3v3__fillcap_16
XFILLER_74_1329 VDD VDD VSS VSS gf180mcu_as_sc_mcu7t3v3__fill_1
XFILLER_176_932 VDD VDD VSS VSS gf180mcu_as_sc_mcu7t3v3__fill_2
X_4704_ VDD VDD VSS VSS _4705_/C _4704_/A _4704_/B _5241_/Q gf180mcu_as_sc_mcu7t3v3__ao21_2
X_2965_ VDD VDD VSS VSS _4772_/D _2965_/C _3049_/B _3944_/A gf180mcu_as_sc_mcu7t3v3__aoi21_2
XFILLER_175_442 VDD VDD VSS VSS gf180mcu_as_sc_mcu7t3v3__fill_1
X_2896_ VDD VDD VSS VSS _3134_/S _3227_/S _2948_/B gf180mcu_as_sc_mcu7t3v3__and2_2
XFILLER_159_1206 VDD VDD VSS VSS gf180mcu_as_sc_mcu7t3v3__fill_1
X_4635_ VDD VDD VSS VSS _4683_/C _5112_/Q _5226_/Q _5226_/D gf180mcu_as_sc_mcu7t3v3__mux2_2
XFILLER_118_27 VDD VDD VSS VSS gf180mcu_as_sc_mcu7t3v3__fill_1
XFILLER_191_979 VDD VDD VSS VSS gf180mcu_as_sc_mcu7t3v3__fill_1
X_4566_ VDD VDD VSS VSS _5187_/Q _4590_/B _4590_/C _5105_/Q _4567_/B gf180mcu_as_sc_mcu7t3v3__ao22_2
XFILLER_162_147 VDD VDD VSS VSS gf180mcu_as_sc_mcu7t3v3__fill_1
X_3517_ VDD VDD VSS VSS _3517_/A _3533_/A _3812_/A _3517_/D _3518_/B gf180mcu_as_sc_mcu7t3v3__nand4_2
XFILLER_171_681 VDD VDD VSS VSS gf180mcu_as_sc_mcu7t3v3__fill_2
X_4497_ VDD VDD VSS VSS _4497_/B _4591_/A _4504_/C gf180mcu_as_sc_mcu7t3v3__and2_2
X_3448_ VDD VDD VSS VSS _4936_/Q _3448_/B _3448_/C _4102_/A _3449_/C gf180mcu_as_sc_mcu7t3v3__ao22_2
XFILLER_134_37 VDD VDD VSS VSS gf180mcu_as_sc_mcu7t3v3__fillcap_8
XFILLER_135_1272 VDD VDD VSS VSS gf180mcu_as_sc_mcu7t3v3__fillcap_8
X_3379_ VDD VDD VSS VSS _3449_/B _4031_/A _3379_/A _3380_/D gf180mcu_as_sc_mcu7t3v3__mux2_2
XFILLER_170_1185 VDD VDD VSS VSS gf180mcu_as_sc_mcu7t3v3__fillcap_16
X_5118_ VDD VDD VSS VSS _5188_/CLK _5118_/D _5118_/Q gf180mcu_as_sc_mcu7t3v3__dfxtp_2
XFILLER_27_68 VDD VDD VSS VSS gf180mcu_as_sc_mcu7t3v3__fill_2
X_5049_ VDD VDD VSS VSS clkload8/A _5049_/D _5049_/Q gf180mcu_as_sc_mcu7t3v3__dfxtp_2
XFILLER_13_426 VDD VDD VSS VSS gf180mcu_as_sc_mcu7t3v3__fillcap_4
XFILLER_159_34 VDD VDD VSS VSS gf180mcu_as_sc_mcu7t3v3__fillcap_4
XFILLER_185_228 VDD VDD VSS VSS gf180mcu_as_sc_mcu7t3v3__fillcap_4
XFILLER_9_419 VDD VDD VSS VSS gf180mcu_as_sc_mcu7t3v3__fill_1
XFILLER_166_453 VDD VDD VSS VSS gf180mcu_as_sc_mcu7t3v3__fill_2
XTAP_TAPCELL_ROW_156_1211 VDD VSS gf180mcu_as_sc_mcu7t3v3__tap_2
XFILLER_167_998 VDD VDD VSS VSS gf180mcu_as_sc_mcu7t3v3__fillcap_16
XTAP_TAPCELL_ROW_152_1108 VDD VSS gf180mcu_as_sc_mcu7t3v3__tap_2
Xclkbuf_2_0_0_clk_regs VDD VDD VSS VSS clkbuf_0_clk_regs/Y clkbuf_2_0_0_clk_regs/Y
+ gf180mcu_as_sc_mcu7t3v3__clkbuff_12
XTAP_TAPCELL_ROW_152_1119 VDD VSS gf180mcu_as_sc_mcu7t3v3__tap_2
XFILLER_153_147 VDD VDD VSS VSS gf180mcu_as_sc_mcu7t3v3__fillcap_8
XTAP_TAPCELL_ROW_18_1_971 VDD VSS gf180mcu_as_sc_mcu7t3v3__tap_2
XFILLER_181_489 VDD VDD VSS VSS gf180mcu_as_sc_mcu7t3v3__fill_1
XFILLER_191_10 VDD VDD VSS VSS gf180mcu_as_sc_mcu7t3v3__fillcap_8
XFILLER_1_842 VDD VDD VSS VSS gf180mcu_as_sc_mcu7t3v3__fillcap_16
XPHY_EDGE_ROW_78_1_Right_587 VDD VSS gf180mcu_as_sc_mcu7t3v3__tap_2
XFILLER_1_886 VDD VDD VSS VSS gf180mcu_as_sc_mcu7t3v3__fill_1
Xinput220 VDD VDD VSS VSS south_in[14] _4047_/A gf180mcu_as_sc_mcu7t3v3__buff_12
Xinput231 VDD VDD VSS VSS south_in[24] _4128_/A gf180mcu_as_sc_mcu7t3v3__buff_12
Xinput242 VDD VDD VSS VSS south_in[3] _3958_/A gf180mcu_as_sc_mcu7t3v3__buff_12
Xinput253 VDD VDD VSS VSS sw_in[13] _2435_/A gf180mcu_as_sc_mcu7t3v3__buff_12
Xinput264 VDD VDD VSS VSS sw_in[23] _2445_/A gf180mcu_as_sc_mcu7t3v3__buff_12
Xinput275 VDD VDD VSS VSS sw_in[33] _3817_/A gf180mcu_as_sc_mcu7t3v3__buff_12
Xinput286 VDD VDD VSS VSS west_in[12] _4030_/A gf180mcu_as_sc_mcu7t3v3__buff_12
Xinput297 VDD VDD VSS VSS west_in[22] _4109_/D gf180mcu_as_sc_mcu7t3v3__buff_12
XFILLER_177_729 VDD VDD VSS VSS gf180mcu_as_sc_mcu7t3v3__fillcap_4
XFILLER_182_1045 VDD VDD VSS VSS gf180mcu_as_sc_mcu7t3v3__fill_2
XFILLER_34_1324 VDD VDD VSS VSS gf180mcu_as_sc_mcu7t3v3__fillcap_4
XFILLER_121_1316 VDD VDD VSS VSS gf180mcu_as_sc_mcu7t3v3__fill_1
X_2750_ VDD VDD VSS VSS _2764_/A _2810_/A gf180mcu_as_sc_mcu7t3v3__inv_2
XFILLER_144_103 VDD VDD VSS VSS gf180mcu_as_sc_mcu7t3v3__fill_2
XFILLER_185_762 VDD VDD VSS VSS gf180mcu_as_sc_mcu7t3v3__fillcap_8
XFILLER_8_452 VDD VDD VSS VSS gf180mcu_as_sc_mcu7t3v3__fill_2
XFILLER_8_463 VDD VDD VSS VSS gf180mcu_as_sc_mcu7t3v3__fill_1
XFILLER_9_986 VDD VDD VSS VSS gf180mcu_as_sc_mcu7t3v3__fill_1
XFILLER_9_997 VDD VDD VSS VSS gf180mcu_as_sc_mcu7t3v3__fill_1
X_2681_ VDD VDD VSS VSS _2681_/Y _2724_/S _2699_/A gf180mcu_as_sc_mcu7t3v3__nor2_2
XFILLER_184_294 VDD VDD VSS VSS gf180mcu_as_sc_mcu7t3v3__fillcap_16
X_4420_ VDD VDD VSS VSS _4421_/B _4420_/A gf180mcu_as_sc_mcu7t3v3__inv_2
XTAP_TAPCELL_ROW_29_3_1940 VDD VSS gf180mcu_as_sc_mcu7t3v3__tap_2
XFILLER_173_979 VDD VDD VSS VSS gf180mcu_as_sc_mcu7t3v3__fill_1
X_4351_ VDD VDD VSS VSS _4375_/B _4351_/B _4351_/A _4352_/B gf180mcu_as_sc_mcu7t3v3__mux2_2
XFILLER_154_1136 VDD VDD VSS VSS gf180mcu_as_sc_mcu7t3v3__fill_2
XFILLER_154_1147 VDD VDD VSS VSS gf180mcu_as_sc_mcu7t3v3__fillcap_8
X_4282_ VDD VDD VSS VSS _4289_/S _4718_/A _5116_/Q _5116_/D gf180mcu_as_sc_mcu7t3v3__mux2_2
X_3302_ VDD VDD VSS VSS _3505_/S _3302_/B _3302_/A _3303_/B gf180mcu_as_sc_mcu7t3v3__mux2_2
XFILLER_119_1289 VDD VDD VSS VSS gf180mcu_as_sc_mcu7t3v3__fill_1
X_3233_ VDD VDD VSS VSS _3234_/D _3233_/C _3233_/B _3519_/A gf180mcu_as_sc_mcu7t3v3__aoi21b_2
X_3164_ VDD VDD VSS VSS _3182_/B _3164_/B _3164_/C _3165_/C gf180mcu_as_sc_mcu7t3v3__nor3_2
X_3095_ VDD VDD VSS VSS _4070_/A _3206_/B _3095_/C _3095_/D _3096_/C gf180mcu_as_sc_mcu7t3v3__ao22_2
XFILLER_161_1118 VDD VDD VSS VSS gf180mcu_as_sc_mcu7t3v3__fill_2
X_3997_ VDD VDD VSS VSS _3997_/A _4160_/B _4161_/B _3997_/D _3998_/D gf180mcu_as_sc_mcu7t3v3__ao22_2
X_2948_ VDD VDD VSS VSS _2948_/Y _2948_/B _3201_/C gf180mcu_as_sc_mcu7t3v3__nor2b_2
XFILLER_176_762 VDD VDD VSS VSS gf180mcu_as_sc_mcu7t3v3__fillcap_16
XFILLER_11_1132 VDD VDD VSS VSS gf180mcu_as_sc_mcu7t3v3__fill_1
XFILLER_135_103 VDD VDD VSS VSS gf180mcu_as_sc_mcu7t3v3__fill_2
X_4618_ VDD VDD VSS VSS _5212_/Q _4621_/B _4621_/C _5213_/Q _5212_/D gf180mcu_as_sc_mcu7t3v3__ao22_2
X_2879_ VDD VDD VSS VSS _2880_/B _4719_/B _2879_/B _2879_/A gf180mcu_as_sc_mcu7t3v3__aoi21_2
XFILLER_159_1036 VDD VDD VSS VSS gf180mcu_as_sc_mcu7t3v3__fill_1
XFILLER_163_456 VDD VDD VSS VSS gf180mcu_as_sc_mcu7t3v3__fillcap_4
Xclkbuf_leaf_19_clk_regs VDD VDD VSS VSS clkbuf_3_6__f_clk_regs/Y _5266_/CLK gf180mcu_as_sc_mcu7t3v3__clkbuff_12
XFILLER_137_1323 VDD VDD VSS VSS gf180mcu_as_sc_mcu7t3v3__fill_1
XFILLER_8_8 VDD VDD VSS VSS gf180mcu_as_sc_mcu7t3v3__fill_1
X_4549_ VDD VDD VSS VSS _4559_/S _5084_/Q _4997_/Q _4550_/A gf180mcu_as_sc_mcu7t3v3__mux2_2
XFILLER_145_47 VDD VDD VSS VSS gf180mcu_as_sc_mcu7t3v3__fill_1
XFILLER_172_1269 VDD VDD VSS VSS gf180mcu_as_sc_mcu7t3v3__fillcap_8
Xhold1130 VDD VDD VSS VSS _5273_/Q _4744_/A gf180mcu_as_sc_mcu7t3v3__clkbuff_4
Xhold1141 VDD VDD VSS VSS _2587_/Y hold1141/Y gf180mcu_as_sc_mcu7t3v3__clkbuff_4
XFILLER_161_68 VDD VDD VSS VSS gf180mcu_as_sc_mcu7t3v3__fill_2
Xhold1152 VDD VDD VSS VSS _4959_/Q hold1152/Y gf180mcu_as_sc_mcu7t3v3__clkbuff_4
XFILLER_183_1332 VDD VDD VSS VSS gf180mcu_as_sc_mcu7t3v3__fillcap_16
XFILLER_13_212 VDD VDD VSS VSS gf180mcu_as_sc_mcu7t3v3__fillcap_16
XFILLER_183_1354 VDD VDD VSS VSS gf180mcu_as_sc_mcu7t3v3__fill_1
XFILLER_13_256 VDD VDD VSS VSS gf180mcu_as_sc_mcu7t3v3__fillcap_16
XFILLER_110_94 VDD VDD VSS VSS gf180mcu_as_sc_mcu7t3v3__fillcap_8
XFILLER_13_278 VDD VDD VSS VSS gf180mcu_as_sc_mcu7t3v3__fillcap_16
XFILLER_70_43 VDD VDD VSS VSS gf180mcu_as_sc_mcu7t3v3__fill_1
XTAP_TAPCELL_ROW_12_925 VDD VSS gf180mcu_as_sc_mcu7t3v3__tap_2
XTAP_TAPCELL_ROW_12_914 VDD VSS gf180mcu_as_sc_mcu7t3v3__tap_2
XFILLER_182_732 VDD VDD VSS VSS gf180mcu_as_sc_mcu7t3v3__fill_2
XFILLER_6_923 VDD VDD VSS VSS gf180mcu_as_sc_mcu7t3v3__fillcap_4
Xclkload19 VDD VDD VSS VSS _5277_/CLK clkload19/Y gf180mcu_as_sc_mcu7t3v3__clkbuff_12
XFILLER_181_253 VDD VDD VSS VSS gf180mcu_as_sc_mcu7t3v3__fillcap_16
XFILLER_6_989 VDD VDD VSS VSS gf180mcu_as_sc_mcu7t3v3__fillcap_4
X_4904__1064 VDD VDD VSS VSS _4904_/D gf180mcu_as_sc_mcu7t3v3__tiel_4
XFILLER_163_990 VDD VDD VSS VSS gf180mcu_as_sc_mcu7t3v3__fill_2
XFILLER_151_1309 VDD VDD VSS VSS gf180mcu_as_sc_mcu7t3v3__fillcap_4
XTAP_TAPCELL_ROW_169_1457 VDD VSS gf180mcu_as_sc_mcu7t3v3__tap_2
XPHY_EDGE_ROW_79_1_Right_588 VDD VSS gf180mcu_as_sc_mcu7t3v3__tap_2
XFILLER_135_80 VDD VDD VSS VSS gf180mcu_as_sc_mcu7t3v3__fillcap_4
XFILLER_188_1210 VDD VDD VSS VSS gf180mcu_as_sc_mcu7t3v3__fillcap_8
XTAP_TAPCELL_ROW_186_1782 VDD VSS gf180mcu_as_sc_mcu7t3v3__tap_2
XTAP_TAPCELL_ROW_186_1771 VDD VSS gf180mcu_as_sc_mcu7t3v3__tap_2
XFILLER_188_1243 VDD VDD VSS VSS gf180mcu_as_sc_mcu7t3v3__fillcap_16
XFILLER_63_101 VDD VDD VSS VSS gf180mcu_as_sc_mcu7t3v3__fillcap_4
XPHY_EDGE_ROW_26_1_Left_218 VDD VSS gf180mcu_as_sc_mcu7t3v3__tap_2
X_3920_ VDD VDD VSS VSS _3927_/B _3920_/B _3920_/A gf180mcu_as_sc_mcu7t3v3__nand2b_2
X_3851_ VDD VDD VSS VSS _5132_/Q _5133_/Q _3851_/C _3858_/A gf180mcu_as_sc_mcu7t3v3__nor3_2
X_3782_ VDD VDD VSS VSS _4162_/A _3792_/B _3791_/B _4160_/A _3783_/D gf180mcu_as_sc_mcu7t3v3__ao22_2
X_2802_ VDD VDD VSS VSS _2805_/A _2802_/A _2803_/B gf180mcu_as_sc_mcu7t3v3__or2_2
XFILLER_192_507 VDD VDD VSS VSS gf180mcu_as_sc_mcu7t3v3__fill_2
X_2733_ VDD VDD VSS VSS _5164_/Q _4272_/S _4275_/S _5188_/Q _2734_/B gf180mcu_as_sc_mcu7t3v3__ao22_2
XPHY_EDGE_ROW_4_Left_197 VDD VSS gf180mcu_as_sc_mcu7t3v3__tap_2
XPHY_EDGE_ROW_140_1_Left_332 VDD VSS gf180mcu_as_sc_mcu7t3v3__tap_2
XFILLER_117_103 VDD VDD VSS VSS gf180mcu_as_sc_mcu7t3v3__fill_2
XFILLER_172_220 VDD VDD VSS VSS gf180mcu_as_sc_mcu7t3v3__fill_2
XFILLER_173_754 VDD VDD VSS VSS gf180mcu_as_sc_mcu7t3v3__fill_1
X_2664_ VDD VDD VSS VSS _2664_/Y _2676_/A _2664_/B _2664_/C gf180mcu_as_sc_mcu7t3v3__ao21_2
X_4403_ VDD VDD VSS VSS _4456_/S _5009_/Q _5038_/Q _4404_/B gf180mcu_as_sc_mcu7t3v3__mux2_2
X_2595_ VDD VDD VSS VSS _5125_/Q _2731_/S _2595_/A _2597_/C gf180mcu_as_sc_mcu7t3v3__mux2_2
XTAP_TAPCELL_ROW_76_1_1029 VDD VSS gf180mcu_as_sc_mcu7t3v3__tap_2
X_4334_ VDD VDD VSS VSS _4334_/Y _4334_/B _4590_/B gf180mcu_as_sc_mcu7t3v3__nand2_2
XFILLER_45_1272 VDD VDD VSS VSS gf180mcu_as_sc_mcu7t3v3__fillcap_8
X_4265_ VDD VDD VSS VSS _4742_/C _4265_/B _4265_/C _5099_/D gf180mcu_as_sc_mcu7t3v3__nor3_2
X_4196_ VDD VDD VSS VSS _4256_/B _4197_/B _4197_/C _5034_/Q _5034_/D gf180mcu_as_sc_mcu7t3v3__ao22_2
X_3216_ VDD VDD VSS VSS _3216_/D _3801_/A _3216_/B _3216_/C _3217_/A gf180mcu_as_sc_mcu7t3v3__ao31_2
X_3147_ VDD VDD VSS VSS _4122_/A _3241_/B _3147_/C _3147_/D _3148_/C gf180mcu_as_sc_mcu7t3v3__ao22_2
XFILLER_131_27 VDD VDD VSS VSS gf180mcu_as_sc_mcu7t3v3__fill_1
XFILLER_167_1349 VDD VDD VSS VSS gf180mcu_as_sc_mcu7t3v3__fillcap_4
X_3078_ VDD VDD VSS VSS _3129_/B _4930_/Q _3079_/D gf180mcu_as_sc_mcu7t3v3__or2_2
XPHY_EDGE_ROW_38_3_Right_79 VDD VSS gf180mcu_as_sc_mcu7t3v3__tap_2
XTAP_TAPCELL_ROW_17_1_970 VDD VSS gf180mcu_as_sc_mcu7t3v3__tap_2
XPHY_EDGE_ROW_72_1_Left_264 VDD VSS gf180mcu_as_sc_mcu7t3v3__tap_2
XFILLER_183_529 VDD VDD VSS VSS gf180mcu_as_sc_mcu7t3v3__fillcap_4
XFILLER_108_103 VDD VDD VSS VSS gf180mcu_as_sc_mcu7t3v3__fill_2
XFILLER_156_24 VDD VDD VSS VSS gf180mcu_as_sc_mcu7t3v3__fill_1
XFILLER_163_220 VDD VDD VSS VSS gf180mcu_as_sc_mcu7t3v3__fillcap_4
XFILLER_191_540 VDD VDD VSS VSS gf180mcu_as_sc_mcu7t3v3__fillcap_16
XFILLER_191_562 VDD VDD VSS VSS gf180mcu_as_sc_mcu7t3v3__fillcap_16
XFILLER_3_937 VDD VDD VSS VSS gf180mcu_as_sc_mcu7t3v3__fill_2
XFILLER_176_1191 VDD VDD VSS VSS gf180mcu_as_sc_mcu7t3v3__fill_1
XFILLER_172_34 VDD VDD VSS VSS gf180mcu_as_sc_mcu7t3v3__fill_1
Xfanout740 VDD VDD VSS VSS _3542_/Y _3770_/B gf180mcu_as_sc_mcu7t3v3__buff_12
Xfanout751 VDD VDD VSS VSS _2931_/Y _3177_/C gf180mcu_as_sc_mcu7t3v3__buff_12
XFILLER_172_67 VDD VDD VSS VSS gf180mcu_as_sc_mcu7t3v3__fillcap_4
Xfanout773 VDD VDD VSS VSS _3177_/B _3222_/D gf180mcu_as_sc_mcu7t3v3__buff_12
Xfanout784 VDD VDD VSS VSS _2681_/Y _4281_/S gf180mcu_as_sc_mcu7t3v3__buff_12
XTAP_TAPCELL_ROW_6_797 VDD VSS gf180mcu_as_sc_mcu7t3v3__tap_2
XFILLER_105_72 VDD VDD VSS VSS gf180mcu_as_sc_mcu7t3v3__fillcap_8
XFILLER_111_1326 VDD VDD VSS VSS gf180mcu_as_sc_mcu7t3v3__fillcap_4
XTAP_TAPCELL_ROW_164_1354 VDD VSS gf180mcu_as_sc_mcu7t3v3__tap_2
XTAP_TAPCELL_ROW_164_1365 VDD VSS gf180mcu_as_sc_mcu7t3v3__tap_2
XFILLER_60_104 VDD VDD VSS VSS gf180mcu_as_sc_mcu7t3v3__fill_1
XTAP_TAPCELL_ROW_181_1690 VDD VSS gf180mcu_as_sc_mcu7t3v3__tap_2
XFILLER_148_1282 VDD VDD VSS VSS gf180mcu_as_sc_mcu7t3v3__fillcap_4
XFILLER_186_301 VDD VDD VSS VSS gf180mcu_as_sc_mcu7t3v3__fillcap_8
XFILLER_109_1288 VDD VDD VSS VSS gf180mcu_as_sc_mcu7t3v3__fillcap_16
XFILLER_186_323 VDD VDD VSS VSS gf180mcu_as_sc_mcu7t3v3__fill_1
XFILLER_14_80 VDD VDD VSS VSS gf180mcu_as_sc_mcu7t3v3__fillcap_8
XFILLER_186_367 VDD VDD VSS VSS gf180mcu_as_sc_mcu7t3v3__fill_2
XFILLER_81_97 VDD VDD VSS VSS gf180mcu_as_sc_mcu7t3v3__fillcap_8
XFILLER_155_721 VDD VDD VSS VSS gf180mcu_as_sc_mcu7t3v3__fillcap_4
XFILLER_167_570 VDD VDD VSS VSS gf180mcu_as_sc_mcu7t3v3__fillcap_4
XFILLER_155_754 VDD VDD VSS VSS gf180mcu_as_sc_mcu7t3v3__fill_1
XFILLER_6_753 VDD VDD VSS VSS gf180mcu_as_sc_mcu7t3v3__fillcap_4
XFILLER_6_786 VDD VDD VSS VSS gf180mcu_as_sc_mcu7t3v3__fillcap_8
XFILLER_170_768 VDD VDD VSS VSS gf180mcu_as_sc_mcu7t3v3__fillcap_16
XFILLER_190_1111 VDD VDD VSS VSS gf180mcu_as_sc_mcu7t3v3__fillcap_4
XTAP_TAPCELL_ROW_188_1811 VDD VSS gf180mcu_as_sc_mcu7t3v3__tap_2
XPHY_EDGE_ROW_87_3_Left_459 VDD VSS gf180mcu_as_sc_mcu7t3v3__tap_2
XFILLER_29_1256 VDD VDD VSS VSS gf180mcu_as_sc_mcu7t3v3__fillcap_16
XTAP_TAPCELL_ROW_188_1822 VDD VSS gf180mcu_as_sc_mcu7t3v3__tap_2
X_4050_ VDD VDD VSS VSS _4106_/S _4050_/B _4050_/A _4051_/B gf180mcu_as_sc_mcu7t3v3__mux2_2
Xinput6 VDD VDD VSS VSS boot_addr[4] input6/Y gf180mcu_as_sc_mcu7t3v3__buff_12
X_3001_ VDD VDD VSS VSS _3982_/A _3044_/B _3044_/C _3981_/D _3002_/C gf180mcu_as_sc_mcu7t3v3__ao22_2
X_4952_ VDD VDD VSS VSS _5203_/CLK _4952_/Q _4952_/RN _3795_/A _4952_/D gf180mcu_as_sc_mcu7t3v3__dfsrtp_2
X_4883_ VDD VDD VSS VSS _4895_/CLK _4883_/D _4883_/Q gf180mcu_as_sc_mcu7t3v3__dfxtp_2
X_3903_ VDD VDD VSS VSS _3908_/B _5162_/Q _4943_/D gf180mcu_as_sc_mcu7t3v3__and2_2
XTAP_TAPCELL_ROW_95_3_2006 VDD VSS gf180mcu_as_sc_mcu7t3v3__tap_2
XFILLER_75_1287 VDD VDD VSS VSS gf180mcu_as_sc_mcu7t3v3__fillcap_8
X_3834_ VDD VDD VSS VSS _3835_/B _4168_/A _3845_/A gf180mcu_as_sc_mcu7t3v3__or2_2
X_3765_ VDD VDD VSS VSS _4146_/A _3772_/B _3765_/C _3765_/D _3766_/C gf180mcu_as_sc_mcu7t3v3__ao211_2
X_3696_ VDD VDD VSS VSS _3697_/C _4069_/A _3791_/B _3696_/C gf180mcu_as_sc_mcu7t3v3__ao21_2
X_2716_ VDD VDD VSS VSS _2723_/A _2716_/B _2716_/C _2716_/D _2716_/Y gf180mcu_as_sc_mcu7t3v3__ao22_2
XFILLER_161_702 VDD VDD VSS VSS gf180mcu_as_sc_mcu7t3v3__fillcap_4
XFILLER_173_562 VDD VDD VSS VSS gf180mcu_as_sc_mcu7t3v3__fillcap_16
X_2647_ VDD VDD VSS VSS _2673_/B _5129_/Q _5193_/Q _2648_/B gf180mcu_as_sc_mcu7t3v3__mux2_2
XFILLER_156_1017 VDD VDD VSS VSS gf180mcu_as_sc_mcu7t3v3__fill_2
XFILLER_173_1320 VDD VDD VSS VSS gf180mcu_as_sc_mcu7t3v3__fillcap_8
Xoutput343 VDD VDD VSS VSS _4865_/Q east_out[26] gf180mcu_as_sc_mcu7t3v3__buff_12
Xoutput332 VDD VDD VSS VSS _4855_/Q east_out[16] gf180mcu_as_sc_mcu7t3v3__buff_12
Xoutput321 VDD VDD VSS VSS _5482_/Y dft_rdata[4] gf180mcu_as_sc_mcu7t3v3__buff_12
Xoutput387 VDD VDD VSS VSS _4775_/Q se_out[4] gf180mcu_as_sc_mcu7t3v3__buff_12
Xoutput376 VDD VDD VSS VSS _4796_/Q se_out[25] gf180mcu_as_sc_mcu7t3v3__buff_12
Xoutput365 VDD VDD VSS VSS _4786_/Q se_out[15] gf180mcu_as_sc_mcu7t3v3__buff_12
Xoutput354 VDD VDD VSS VSS _4844_/Q east_out[5] gf180mcu_as_sc_mcu7t3v3__buff_12
X_2578_ VDD VDD VSS VSS _2674_/C _2639_/S _2701_/A gf180mcu_as_sc_mcu7t3v3__nand2_2
Xoutput398 VDD VDD VSS VSS _4819_/Q south_out[14] gf180mcu_as_sc_mcu7t3v3__buff_12
X_4317_ VDD VDD VSS VSS _4319_/S _5147_/Q _5146_/Q _5146_/D gf180mcu_as_sc_mcu7t3v3__mux2_2
X_4248_ VDD VDD VSS VSS _4257_/S _4248_/B _5084_/Q _5084_/D gf180mcu_as_sc_mcu7t3v3__mux2_2
XTAP_TAPCELL_ROW_3_745 VDD VSS gf180mcu_as_sc_mcu7t3v3__tap_2
X_4179_ VDD VDD VSS VSS _4239_/B _4197_/B _4197_/C _5017_/Q _5017_/D gf180mcu_as_sc_mcu7t3v3__ao22_2
XTAP_TAPCELL_ROW_3_756 VDD VSS gf180mcu_as_sc_mcu7t3v3__tap_2
XTAP_TAPCELL_ROW_52_3_1963 VDD VSS gf180mcu_as_sc_mcu7t3v3__tap_2
XFILLER_150_6 VDD VDD VSS VSS gf180mcu_as_sc_mcu7t3v3__fillcap_16
XFILLER_54_1305 VDD VDD VSS VSS gf180mcu_as_sc_mcu7t3v3__fill_1
Xclkbuf_leaf_34_clk_regs VDD VDD VSS VSS clkbuf_3_4__f_clk_regs/Y _5203_/CLK gf180mcu_as_sc_mcu7t3v3__clkbuff_12
XFILLER_11_579 VDD VDD VSS VSS gf180mcu_as_sc_mcu7t3v3__fill_1
XFILLER_13_1046 VDD VDD VSS VSS gf180mcu_as_sc_mcu7t3v3__fillcap_8
XFILLER_13_1068 VDD VDD VSS VSS gf180mcu_as_sc_mcu7t3v3__fill_2
XFILLER_178_1220 VDD VDD VSS VSS gf180mcu_as_sc_mcu7t3v3__fillcap_4
XFILLER_152_724 VDD VDD VSS VSS gf180mcu_as_sc_mcu7t3v3__fillcap_4
XFILLER_174_1128 VDD VDD VSS VSS gf180mcu_as_sc_mcu7t3v3__fillcap_4
XFILLER_178_1297 VDD VDD VSS VSS gf180mcu_as_sc_mcu7t3v3__fill_1
XFILLER_183_22 VDD VDD VSS VSS gf180mcu_as_sc_mcu7t3v3__fillcap_16
XFILLER_183_88 VDD VDD VSS VSS gf180mcu_as_sc_mcu7t3v3__fillcap_4
XTAP_TAPCELL_ROW_166_1405 VDD VSS gf180mcu_as_sc_mcu7t3v3__tap_2
XFILLER_76_31 VDD VDD VSS VSS gf180mcu_as_sc_mcu7t3v3__fillcap_4
Xfanout570 VDD VDD VSS VSS _3286_/Y _3523_/B gf180mcu_as_sc_mcu7t3v3__buff_12
Xfanout592 VDD VDD VSS VSS _3919_/Y _4162_/B gf180mcu_as_sc_mcu7t3v3__buff_12
XTAP_TAPCELL_ROW_183_1730 VDD VSS gf180mcu_as_sc_mcu7t3v3__tap_2
XFILLER_132_81 VDD VDD VSS VSS gf180mcu_as_sc_mcu7t3v3__fill_1
XFILLER_185_1257 VDD VDD VSS VSS gf180mcu_as_sc_mcu7t3v3__fill_2
XFILLER_92_41 VDD VDD VSS VSS gf180mcu_as_sc_mcu7t3v3__fill_2
XFILLER_187_632 VDD VDD VSS VSS gf180mcu_as_sc_mcu7t3v3__fillcap_16
XFILLER_159_356 VDD VDD VSS VSS gf180mcu_as_sc_mcu7t3v3__fill_1
XFILLER_186_131 VDD VDD VSS VSS gf180mcu_as_sc_mcu7t3v3__fillcap_4
XFILLER_186_153 VDD VDD VSS VSS gf180mcu_as_sc_mcu7t3v3__fill_1
XFILLER_35_1260 VDD VDD VSS VSS gf180mcu_as_sc_mcu7t3v3__fill_2
X_3550_ VDD VDD VSS VSS _3562_/B _3562_/A _3550_/Y gf180mcu_as_sc_mcu7t3v3__and2_2
XFILLER_155_562 VDD VDD VSS VSS gf180mcu_as_sc_mcu7t3v3__fillcap_4
XFILLER_155_573 VDD VDD VSS VSS gf180mcu_as_sc_mcu7t3v3__fillcap_8
Xmax_cap726 VDD VDD VSS VSS fanout725/Y fanout722/A gf180mcu_as_sc_mcu7t3v3__clkbuff_12
X_2501_ VDD VDD VSS VSS _4746_/A _4662_/C _5222_/Q _2502_/D gf180mcu_as_sc_mcu7t3v3__mux2_2
XFILLER_192_1217 VDD VDD VSS VSS gf180mcu_as_sc_mcu7t3v3__fill_2
X_5220_ VDD VDD VSS VSS _5220_/CLK _5220_/D _5220_/Q gf180mcu_as_sc_mcu7t3v3__dfxtp_2
X_3481_ VDD VDD VSS VSS _4135_/A _3496_/B _3496_/C _4136_/A _3482_/D gf180mcu_as_sc_mcu7t3v3__ao22_2
X_2432_ VDD VDD VSS VSS _3647_/A _4018_/A gf180mcu_as_sc_mcu7t3v3__inv_2
X_5151_ VDD VDD VSS VSS _5152_/CLK _5151_/D _5151_/Q gf180mcu_as_sc_mcu7t3v3__dfxtp_2
X_5082_ VDD VDD VSS VSS clkload8/A _5082_/D _5082_/Q gf180mcu_as_sc_mcu7t3v3__dfxtp_2
X_4102_ VDD VDD VSS VSS _4102_/A _4102_/B _4102_/C _4936_/Q _4103_/D gf180mcu_as_sc_mcu7t3v3__ao22_2
X_4033_ VDD VDD VSS VSS _4033_/A _4105_/B _4033_/C _4033_/D _4034_/B gf180mcu_as_sc_mcu7t3v3__ao211_2
XFILLER_162_1010 VDD VDD VSS VSS gf180mcu_as_sc_mcu7t3v3__fillcap_4
X_4935_ VDD VDD VSS VSS clkload2/A _4935_/D _4935_/Q gf180mcu_as_sc_mcu7t3v3__dfxtp_2
XANTENNA_11 VDD VDD VSS VSS _2956_/B gf180mcu_as_sc_mcu7t3v3__diode_2
XANTENNA_22 VDD VDD VSS VSS _4153_/A gf180mcu_as_sc_mcu7t3v3__diode_2
XFILLER_177_142 VDD VDD VSS VSS gf180mcu_as_sc_mcu7t3v3__fillcap_4
X_4866_ VDD VDD VSS VSS _5097_/CLK _4866_/D _4866_/Q gf180mcu_as_sc_mcu7t3v3__dfxtp_2
XANTENNA_33 VDD VDD VSS VSS _4061_/A gf180mcu_as_sc_mcu7t3v3__diode_2
XANTENNA_44 VDD VDD VSS VSS _3793_/C gf180mcu_as_sc_mcu7t3v3__diode_2
XFILLER_162_1087 VDD VDD VSS VSS gf180mcu_as_sc_mcu7t3v3__fill_2
XFILLER_165_315 VDD VDD VSS VSS gf180mcu_as_sc_mcu7t3v3__fillcap_8
XFILLER_177_186 VDD VDD VSS VSS gf180mcu_as_sc_mcu7t3v3__fillcap_8
X_4797_ VDD VDD VSS VSS _5226_/CLK _4797_/D _4797_/Q gf180mcu_as_sc_mcu7t3v3__dfxtp_2
X_3817_ VDD VDD VSS VSS _3817_/A _3817_/B _3817_/C _3922_/C gf180mcu_as_sc_mcu7t3v3__nand3_2
XFILLER_165_348 VDD VDD VSS VSS gf180mcu_as_sc_mcu7t3v3__fill_2
X_3748_ VDD VDD VSS VSS _4939_/Q _3770_/B _3748_/C _4129_/A _3749_/D gf180mcu_as_sc_mcu7t3v3__ao22_2
XFILLER_174_871 VDD VDD VSS VSS gf180mcu_as_sc_mcu7t3v3__fillcap_4
XFILLER_174_893 VDD VDD VSS VSS gf180mcu_as_sc_mcu7t3v3__fillcap_16
XFILLER_192_178 VDD VDD VSS VSS gf180mcu_as_sc_mcu7t3v3__fill_1
X_3679_ VDD VDD VSS VSS _3683_/B _3679_/C _3726_/B _4056_/A gf180mcu_as_sc_mcu7t3v3__aoi21_2
XTAP_TAPCELL_ROW_8_837 VDD VSS gf180mcu_as_sc_mcu7t3v3__tap_2
XFILLER_161_587 VDD VDD VSS VSS gf180mcu_as_sc_mcu7t3v3__fillcap_4
XTAP_TAPCELL_ROW_8_848 VDD VSS gf180mcu_as_sc_mcu7t3v3__tap_2
XFILLER_153_47 VDD VDD VSS VSS gf180mcu_as_sc_mcu7t3v3__fill_1
XFILLER_169_1208 VDD VDD VSS VSS gf180mcu_as_sc_mcu7t3v3__fill_2
XFILLER_21_1326 VDD VDD VSS VSS gf180mcu_as_sc_mcu7t3v3__fillcap_4
XTAP_TAPCELL_ROW_161_1302 VDD VSS gf180mcu_as_sc_mcu7t3v3__tap_2
XTAP_TAPCELL_ROW_161_1313 VDD VSS gf180mcu_as_sc_mcu7t3v3__tap_2
XFILLER_15_104 VDD VDD VSS VSS gf180mcu_as_sc_mcu7t3v3__fill_1
XFILLER_102_62 VDD VDD VSS VSS gf180mcu_as_sc_mcu7t3v3__fill_1
XFILLER_188_407 VDD VDD VSS VSS gf180mcu_as_sc_mcu7t3v3__fill_1
XFILLER_169_632 VDD VDD VSS VSS gf180mcu_as_sc_mcu7t3v3__fillcap_8
XFILLER_180_1154 VDD VDD VSS VSS gf180mcu_as_sc_mcu7t3v3__fill_1
XFILLER_8_804 VDD VDD VSS VSS gf180mcu_as_sc_mcu7t3v3__fill_1
XFILLER_12_877 VDD VDD VSS VSS gf180mcu_as_sc_mcu7t3v3__fillcap_8
XFILLER_178_77 VDD VDD VSS VSS gf180mcu_as_sc_mcu7t3v3__fill_2
XFILLER_8_826 VDD VDD VSS VSS gf180mcu_as_sc_mcu7t3v3__fill_1
XFILLER_8_837 VDD VDD VSS VSS gf180mcu_as_sc_mcu7t3v3__fillcap_8
XTAP_TAPCELL_ROW_159_1275 VDD VSS gf180mcu_as_sc_mcu7t3v3__tap_2
XTAP_TAPCELL_ROW_159_1264 VDD VSS gf180mcu_as_sc_mcu7t3v3__tap_2
XFILLER_168_197 VDD VDD VSS VSS gf180mcu_as_sc_mcu7t3v3__fill_2
XFILLER_178_99 VDD VDD VSS VSS gf180mcu_as_sc_mcu7t3v3__fillcap_4
XFILLER_183_156 VDD VDD VSS VSS gf180mcu_as_sc_mcu7t3v3__fill_1
XPHY_EDGE_ROW_35_1_Left_227 VDD VSS gf180mcu_as_sc_mcu7t3v3__tap_2
XFILLER_178_1083 VDD VDD VSS VSS gf180mcu_as_sc_mcu7t3v3__fill_2
XFILLER_65_1264 VDD VDD VSS VSS gf180mcu_as_sc_mcu7t3v3__fillcap_4
XFILLER_87_41 VDD VDD VSS VSS gf180mcu_as_sc_mcu7t3v3__fill_2
XFILLER_152_1256 VDD VDD VSS VSS gf180mcu_as_sc_mcu7t3v3__fill_2
XFILLER_152_1278 VDD VDD VSS VSS gf180mcu_as_sc_mcu7t3v3__fill_1
XFILLER_179_418 VDD VDD VSS VSS gf180mcu_as_sc_mcu7t3v3__fill_2
X_2981_ VDD VDD VSS VSS _3962_/A _3049_/B _2981_/C _2981_/Y _3654_/D gf180mcu_as_sc_mcu7t3v3__aoi211_2
XFILLER_124_1303 VDD VDD VSS VSS gf180mcu_as_sc_mcu7t3v3__fill_1
XFILLER_159_142 VDD VDD VSS VSS gf180mcu_as_sc_mcu7t3v3__fillcap_8
XFILLER_163_1352 VDD VDD VSS VSS gf180mcu_as_sc_mcu7t3v3__fill_2
X_4720_ VDD VDD VSS VSS _4730_/B _4721_/B _4728_/B gf180mcu_as_sc_mcu7t3v3__nor2_2
X_4651_ VDD VDD VSS VSS _4659_/B _4651_/B _5236_/Q _5236_/D gf180mcu_as_sc_mcu7t3v3__mux2_2
XFILLER_175_657 VDD VDD VSS VSS gf180mcu_as_sc_mcu7t3v3__fill_2
Xinput20 VDD VDD VSS VSS boot_mode _4952_/D gf180mcu_as_sc_mcu7t3v3__buff_12
Xinput31 VDD VDD VSS VSS dft_addr[8] _2672_/B gf180mcu_as_sc_mcu7t3v3__buff_12
X_3602_ VDD VDD VSS VSS _3649_/C _3973_/D _3604_/C gf180mcu_as_sc_mcu7t3v3__and2_2
XFILLER_156_860 VDD VDD VSS VSS gf180mcu_as_sc_mcu7t3v3__fillcap_8
Xinput42 VDD VDD VSS VSS dft_wdata[7] _2737_/B gf180mcu_as_sc_mcu7t3v3__buff_12
Xinput53 VDD VDD VSS VSS east_in[18] wire864/A gf180mcu_as_sc_mcu7t3v3__buff_12
Xinput64 VDD VDD VSS VSS east_in[28] wire859/A gf180mcu_as_sc_mcu7t3v3__buff_12
X_4582_ VDD VDD VSS VSS _4583_/D _4582_/B _4582_/A gf180mcu_as_sc_mcu7t3v3__nor2_2
XFILLER_155_392 VDD VDD VSS VSS gf180mcu_as_sc_mcu7t3v3__fill_2
XFILLER_156_893 VDD VDD VSS VSS gf180mcu_as_sc_mcu7t3v3__fillcap_8
XFILLER_157_1112 VDD VDD VSS VSS gf180mcu_as_sc_mcu7t3v3__fillcap_8
Xinput75 VDD VDD VSS VSS east_in[7] _3991_/A gf180mcu_as_sc_mcu7t3v3__buff_12
Xinput86 VDD VDD VSS VSS ne_in[17] _4069_/A gf180mcu_as_sc_mcu7t3v3__buff_12
Xinput97 VDD VDD VSS VSS ne_in[27] _4154_/D gf180mcu_as_sc_mcu7t3v3__buff_12
X_3533_ VDD VDD VSS VSS _3533_/A _3533_/B _3533_/C _3563_/A gf180mcu_as_sc_mcu7t3v3__nand3_2
XTAP_TAPCELL_ROW_104_3_2015 VDD VSS gf180mcu_as_sc_mcu7t3v3__tap_2
X_3464_ VDD VDD VSS VSS _3501_/C _4121_/A _3466_/C gf180mcu_as_sc_mcu7t3v3__and2_2
XPHY_EDGE_ROW_47_3_Right_88 VDD VSS gf180mcu_as_sc_mcu7t3v3__tap_2
XFILLER_170_1301 VDD VDD VSS VSS gf180mcu_as_sc_mcu7t3v3__fill_2
XFILLER_170_384 VDD VDD VSS VSS gf180mcu_as_sc_mcu7t3v3__fill_1
XFILLER_170_395 VDD VDD VSS VSS gf180mcu_as_sc_mcu7t3v3__fill_2
X_5203_ VDD VDD VSS VSS _5203_/CLK _5203_/D _5203_/Q gf180mcu_as_sc_mcu7t3v3__dfxtp_2
X_2415_ VDD VDD VSS VSS _4750_/A _5278_/Q gf180mcu_as_sc_mcu7t3v3__inv_2
X_5134_ VDD VDD VSS VSS _5216_/CLK _5134_/D _5134_/Q gf180mcu_as_sc_mcu7t3v3__dfxtp_2
X_3395_ VDD VDD VSS VSS _4047_/A _3449_/B _3395_/C _3395_/D _3396_/A gf180mcu_as_sc_mcu7t3v3__ao211_2
XPHY_EDGE_ROW_20_3_Left_392 VDD VSS gf180mcu_as_sc_mcu7t3v3__tap_2
X_5065_ VDD VDD VSS VSS _5178_/CLK _5065_/D _5065_/Q gf180mcu_as_sc_mcu7t3v3__dfxtp_2
XPHY_EDGE_ROW_81_1_Left_273 VDD VSS gf180mcu_as_sc_mcu7t3v3__tap_2
X_4016_ VDD VDD VSS VSS _4016_/A _4104_/B _4104_/C _4016_/D _4017_/D gf180mcu_as_sc_mcu7t3v3__ao22_2
XFILLER_168_1241 VDD VDD VSS VSS gf180mcu_as_sc_mcu7t3v3__fill_1
XFILLER_168_1252 VDD VDD VSS VSS gf180mcu_as_sc_mcu7t3v3__fillcap_4
XFILLER_16_48 VDD VDD VSS VSS gf180mcu_as_sc_mcu7t3v3__fillcap_16
XFILLER_12_107 VDD VDD VSS VSS gf180mcu_as_sc_mcu7t3v3__fillcap_16
X_4918_ VDD VDD VSS VSS clkload1/A _4918_/D _4918_/Q gf180mcu_as_sc_mcu7t3v3__dfxtp_2
X_4849_ VDD VDD VSS VSS _5220_/CLK _4849_/D _4849_/Q gf180mcu_as_sc_mcu7t3v3__dfxtp_2
XFILLER_180_104 VDD VDD VSS VSS gf180mcu_as_sc_mcu7t3v3__fill_1
XFILLER_181_616 VDD VDD VSS VSS gf180mcu_as_sc_mcu7t3v3__fillcap_8
XFILLER_113_6 VDD VDD VSS VSS gf180mcu_as_sc_mcu7t3v3__fill_2
XFILLER_88_1264 VDD VDD VSS VSS gf180mcu_as_sc_mcu7t3v3__fillcap_4
XTAP_TAPCELL_ROW_154_1172 VDD VSS gf180mcu_as_sc_mcu7t3v3__tap_2
XFILLER_162_852 VDD VDD VSS VSS gf180mcu_as_sc_mcu7t3v3__fill_2
XFILLER_180_148 VDD VDD VSS VSS gf180mcu_as_sc_mcu7t3v3__fill_2
XFILLER_0_512 VDD VDD VSS VSS gf180mcu_as_sc_mcu7t3v3__fillcap_4
XFILLER_161_384 VDD VDD VSS VSS gf180mcu_as_sc_mcu7t3v3__fillcap_16
XFILLER_57_33 VDD VDD VSS VSS gf180mcu_as_sc_mcu7t3v3__fill_1
XFILLER_169_1005 VDD VDD VSS VSS gf180mcu_as_sc_mcu7t3v3__fillcap_16
XFILLER_180_34 VDD VDD VSS VSS gf180mcu_as_sc_mcu7t3v3__fill_1
XFILLER_169_1038 VDD VDD VSS VSS gf180mcu_as_sc_mcu7t3v3__fillcap_8
XFILLER_113_50 VDD VDD VSS VSS gf180mcu_as_sc_mcu7t3v3__fillcap_8
XFILLER_113_72 VDD VDD VSS VSS gf180mcu_as_sc_mcu7t3v3__fillcap_8
XFILLER_186_1352 VDD VDD VSS VSS gf180mcu_as_sc_mcu7t3v3__fill_2
XFILLER_189_32 VDD VDD VSS VSS gf180mcu_as_sc_mcu7t3v3__fill_1
XPHY_EDGE_ROW_96_3_Left_468 VDD VSS gf180mcu_as_sc_mcu7t3v3__tap_2
XFILLER_12_652 VDD VDD VSS VSS gf180mcu_as_sc_mcu7t3v3__fillcap_8
XFILLER_157_613 VDD VDD VSS VSS gf180mcu_as_sc_mcu7t3v3__fillcap_16
XFILLER_184_432 VDD VDD VSS VSS gf180mcu_as_sc_mcu7t3v3__fill_2
XTAP_TAPCELL_ROW_174_1548 VDD VSS gf180mcu_as_sc_mcu7t3v3__tap_2
XFILLER_11_195 VDD VDD VSS VSS gf180mcu_as_sc_mcu7t3v3__fill_1
XFILLER_8_689 VDD VDD VSS VSS gf180mcu_as_sc_mcu7t3v3__fillcap_4
XTAP_TAPCELL_ROW_174_1559 VDD VSS gf180mcu_as_sc_mcu7t3v3__tap_2
XFILLER_176_1009 VDD VDD VSS VSS gf180mcu_as_sc_mcu7t3v3__fillcap_4
XTAP_TAPCELL_ROW_191_1884 VDD VSS gf180mcu_as_sc_mcu7t3v3__tap_2
XTAP_TAPCELL_ROW_191_1873 VDD VSS gf180mcu_as_sc_mcu7t3v3__tap_2
XTAP_TAPCELL_ROW_10_886 VDD VSS gf180mcu_as_sc_mcu7t3v3__tap_2
XTAP_TAPCELL_ROW_10_875 VDD VSS gf180mcu_as_sc_mcu7t3v3__tap_2
XFILLER_153_852 VDD VDD VSS VSS gf180mcu_as_sc_mcu7t3v3__fillcap_16
XFILLER_154_1329 VDD VDD VSS VSS gf180mcu_as_sc_mcu7t3v3__fill_1
X_3180_ VDD VDD VSS VSS _4155_/A _3241_/B _3180_/C _3180_/D _3181_/C gf180mcu_as_sc_mcu7t3v3__ao22_2
XFILLER_187_1105 VDD VDD VSS VSS gf180mcu_as_sc_mcu7t3v3__fill_2
XPHY_EDGE_ROW_179_Right_41 VDD VSS gf180mcu_as_sc_mcu7t3v3__tap_2
XFILLER_74_1319 VDD VDD VSS VSS gf180mcu_as_sc_mcu7t3v3__fillcap_8
X_2964_ VDD VDD VSS VSS _3580_/D _3097_/A _2964_/B _2964_/C _2965_/C gf180mcu_as_sc_mcu7t3v3__ao31_2
XFILLER_128_1291 VDD VDD VSS VSS gf180mcu_as_sc_mcu7t3v3__fillcap_8
X_4703_ VDD VDD VSS VSS _4703_/A _5221_/Q _5222_/Q _4703_/D _4705_/B gf180mcu_as_sc_mcu7t3v3__ao211_2
X_2895_ VDD VDD VSS VSS _3533_/C _3257_/A _3223_/B gf180mcu_as_sc_mcu7t3v3__and2_2
XFILLER_176_988 VDD VDD VSS VSS gf180mcu_as_sc_mcu7t3v3__fill_1
X_4634_ VDD VDD VSS VSS _4731_/B _5122_/Q _4684_/A _5225_/D gf180mcu_as_sc_mcu7t3v3__mux2_2
X_4565_ VDD VDD VSS VSS _5185_/Q _4565_/B _4565_/C _4565_/D _5185_/D gf180mcu_as_sc_mcu7t3v3__ao211_2
XPHY_EDGE_ROW_188_Right_50 VDD VSS gf180mcu_as_sc_mcu7t3v3__tap_2
X_3516_ VDD VDD VSS VSS _3516_/B _3525_/A _4836_/D gf180mcu_as_sc_mcu7t3v3__and2_2
X_4496_ VDD VDD VSS VSS _5179_/Q _4532_/B _4523_/C _5113_/Q _4497_/B gf180mcu_as_sc_mcu7t3v3__ao22_2
XPHY_EDGE_ROW_4_Right_4 VDD VSS gf180mcu_as_sc_mcu7t3v3__tap_2
X_3447_ VDD VDD VSS VSS _4099_/A _3463_/B _3447_/C _4825_/D _3638_/D gf180mcu_as_sc_mcu7t3v3__aoi211_2
XFILLER_170_1153 VDD VDD VSS VSS gf180mcu_as_sc_mcu7t3v3__fill_2
X_3378_ VDD VDD VSS VSS _4927_/Q _3448_/B _3448_/C _4029_/A _3379_/A gf180mcu_as_sc_mcu7t3v3__ao22_2
X_5117_ VDD VDD VSS VSS _5181_/CLK _5117_/D _5117_/Q gf180mcu_as_sc_mcu7t3v3__dfxtp_2
X_5048_ VDD VDD VSS VSS _5089_/CLK _5048_/D _5048_/Q gf180mcu_as_sc_mcu7t3v3__dfxtp_2
XFILLER_150_37 VDD VDD VSS VSS gf180mcu_as_sc_mcu7t3v3__fill_1
XFILLER_13_405 VDD VDD VSS VSS gf180mcu_as_sc_mcu7t3v3__fill_2
XFILLER_168_1082 VDD VDD VSS VSS gf180mcu_as_sc_mcu7t3v3__fill_2
XFILLER_167_900 VDD VDD VSS VSS gf180mcu_as_sc_mcu7t3v3__fillcap_8
XFILLER_159_57 VDD VDD VSS VSS gf180mcu_as_sc_mcu7t3v3__fillcap_4
XFILLER_166_410 VDD VDD VSS VSS gf180mcu_as_sc_mcu7t3v3__fillcap_16
XFILLER_185_207 VDD VDD VSS VSS gf180mcu_as_sc_mcu7t3v3__fill_2
XTAP_TAPCELL_ROW_156_1201 VDD VSS gf180mcu_as_sc_mcu7t3v3__tap_2
XTAP_TAPCELL_ROW_156_1212 VDD VSS gf180mcu_as_sc_mcu7t3v3__tap_2
XFILLER_142_1288 VDD VDD VSS VSS gf180mcu_as_sc_mcu7t3v3__fill_1
XFILLER_154_627 VDD VDD VSS VSS gf180mcu_as_sc_mcu7t3v3__fill_1
XFILLER_175_34 VDD VDD VSS VSS gf180mcu_as_sc_mcu7t3v3__fillcap_8
XFILLER_182_947 VDD VDD VSS VSS gf180mcu_as_sc_mcu7t3v3__fillcap_8
XFILLER_4_103 VDD VDD VSS VSS gf180mcu_as_sc_mcu7t3v3__fill_2
XTAP_TAPCELL_ROW_94_1_1047 VDD VSS gf180mcu_as_sc_mcu7t3v3__tap_2
XTAP_TAPCELL_ROW_152_1109 VDD VSS gf180mcu_as_sc_mcu7t3v3__tap_2
XFILLER_175_89 VDD VDD VSS VSS gf180mcu_as_sc_mcu7t3v3__fillcap_16
XFILLER_0_342 VDD VDD VSS VSS gf180mcu_as_sc_mcu7t3v3__fill_2
Xinput210 VDD VDD VSS VSS se_in[5] wire876/A gf180mcu_as_sc_mcu7t3v3__buff_12
XFILLER_191_88 VDD VDD VSS VSS gf180mcu_as_sc_mcu7t3v3__fill_2
XFILLER_62_1256 VDD VDD VSS VSS gf180mcu_as_sc_mcu7t3v3__fillcap_8
Xinput221 VDD VDD VSS VSS south_in[15] _4053_/D gf180mcu_as_sc_mcu7t3v3__buff_12
Xinput232 VDD VDD VSS VSS south_in[25] _4138_/D gf180mcu_as_sc_mcu7t3v3__buff_12
Xinput243 VDD VDD VSS VSS south_in[4] _3968_/D gf180mcu_as_sc_mcu7t3v3__buff_12
Xinput254 VDD VDD VSS VSS sw_in[14] _4050_/A gf180mcu_as_sc_mcu7t3v3__buff_12
XFILLER_97_1308 VDD VDD VSS VSS gf180mcu_as_sc_mcu7t3v3__fill_2
Xinput265 VDD VDD VSS VSS sw_in[24] _2446_/A gf180mcu_as_sc_mcu7t3v3__buff_12
Xinput276 VDD VDD VSS VSS sw_in[3] _2426_/A gf180mcu_as_sc_mcu7t3v3__buff_12
Xinput287 VDD VDD VSS VSS west_in[13] _4037_/D gf180mcu_as_sc_mcu7t3v3__buff_12
Xinput298 VDD VDD VSS VSS west_in[23] _4118_/D gf180mcu_as_sc_mcu7t3v3__buff_12
XFILLER_1_1036 VDD VDD VSS VSS gf180mcu_as_sc_mcu7t3v3__fill_1
XFILLER_17_80 VDD VDD VSS VSS gf180mcu_as_sc_mcu7t3v3__fillcap_4
XFILLER_182_1013 VDD VDD VSS VSS gf180mcu_as_sc_mcu7t3v3__fill_2
XFILLER_140_81 VDD VDD VSS VSS gf180mcu_as_sc_mcu7t3v3__fill_1
X_4891__1077 VDD VDD VSS VSS _4891_/D gf180mcu_as_sc_mcu7t3v3__tiel_4
XFILLER_121_1306 VDD VDD VSS VSS gf180mcu_as_sc_mcu7t3v3__fillcap_8
XFILLER_184_251 VDD VDD VSS VSS gf180mcu_as_sc_mcu7t3v3__fill_2
XFILLER_185_774 VDD VDD VSS VSS gf180mcu_as_sc_mcu7t3v3__fill_1
X_2680_ VDD VDD VSS VSS _2732_/S _4957_/Q _4966_/Q _2683_/A gf180mcu_as_sc_mcu7t3v3__mux2_2
XFILLER_160_619 VDD VDD VSS VSS gf180mcu_as_sc_mcu7t3v3__fill_2
XFILLER_172_457 VDD VDD VSS VSS gf180mcu_as_sc_mcu7t3v3__fillcap_8
X_4350_ VDD VDD VSS VSS _4350_/A _4692_/B _4350_/C _4350_/D _4351_/A gf180mcu_as_sc_mcu7t3v3__ao22_2
X_3301_ VDD VDD VSS VSS _3952_/A _3374_/C _3301_/C _3301_/D _3302_/B gf180mcu_as_sc_mcu7t3v3__ao211_2
XFILLER_153_693 VDD VDD VSS VSS gf180mcu_as_sc_mcu7t3v3__fill_1
X_4281_ VDD VDD VSS VSS _4281_/S _5485_/A _5115_/Q _5115_/D gf180mcu_as_sc_mcu7t3v3__mux2_2
X_3232_ VDD VDD VSS VSS _3232_/B _3907_/A _4802_/D gf180mcu_as_sc_mcu7t3v3__and2_2
X_3163_ VDD VDD VSS VSS _4139_/A _3241_/B _3163_/C _3163_/D _3164_/C gf180mcu_as_sc_mcu7t3v3__ao22_2
X_3094_ VDD VDD VSS VSS _3153_/A _3094_/B _3094_/C _3153_/D _3095_/D gf180mcu_as_sc_mcu7t3v3__ao211_2
XFILLER_165_1211 VDD VDD VSS VSS gf180mcu_as_sc_mcu7t3v3__fill_1
XFILLER_165_1244 VDD VDD VSS VSS gf180mcu_as_sc_mcu7t3v3__fillcap_4
XFILLER_39_1258 VDD VDD VSS VSS gf180mcu_as_sc_mcu7t3v3__fillcap_4
XPHY_EDGE_ROW_112_1_Left_304 VDD VSS gf180mcu_as_sc_mcu7t3v3__tap_2
XFILLER_11_909 VDD VDD VSS VSS gf180mcu_as_sc_mcu7t3v3__fill_1
X_3996_ VDD VDD VSS VSS _4985_/Q _4150_/B _4236_/B _4150_/D _4985_/D gf180mcu_as_sc_mcu7t3v3__ao22_2
XFILLER_13_27 VDD VDD VSS VSS gf180mcu_as_sc_mcu7t3v3__fillcap_4
X_2947_ VDD VDD VSS VSS _2947_/Y _2947_/B _2947_/A gf180mcu_as_sc_mcu7t3v3__nor2_2
XFILLER_129_27 VDD VDD VSS VSS gf180mcu_as_sc_mcu7t3v3__fill_2
XFILLER_11_1122 VDD VDD VSS VSS gf180mcu_as_sc_mcu7t3v3__fillcap_8
X_4617_ VDD VDD VSS VSS _5211_/Q _4617_/B _4617_/C _5212_/Q _5211_/D gf180mcu_as_sc_mcu7t3v3__ao22_2
X_2878_ VDD VDD VSS VSS _5265_/Q _5264_/Q _5266_/Q _2879_/B gf180mcu_as_sc_mcu7t3v3__nor3_2
XFILLER_163_446 VDD VDD VSS VSS gf180mcu_as_sc_mcu7t3v3__fill_2
XFILLER_191_766 VDD VDD VSS VSS gf180mcu_as_sc_mcu7t3v3__fillcap_4
XFILLER_172_991 VDD VDD VSS VSS gf180mcu_as_sc_mcu7t3v3__fill_1
X_4548_ VDD VDD VSS VSS _5183_/Q _4548_/B _4548_/C _4548_/D _5183_/D gf180mcu_as_sc_mcu7t3v3__ao211_2
XFILLER_172_1237 VDD VDD VSS VSS gf180mcu_as_sc_mcu7t3v3__fillcap_16
X_4479_ VDD VDD VSS VSS _5177_/Q _4554_/B _4563_/C _5111_/Q _4480_/B gf180mcu_as_sc_mcu7t3v3__ao22_2
XFILLER_180_6 VDD VDD VSS VSS gf180mcu_as_sc_mcu7t3v3__fillcap_16
XPHY_EDGE_ROW_107_1_Left_299 VDD VSS gf180mcu_as_sc_mcu7t3v3__tap_2
Xhold1120 VDD VDD VSS VSS hold1153/Y _4957_/D gf180mcu_as_sc_mcu7t3v3__clkbuff_4
Xhold1131 VDD VDD VSS VSS _5239_/Q _4659_/A gf180mcu_as_sc_mcu7t3v3__clkbuff_4
Xhold1142 VDD VDD VSS VSS hold1142/A hold1142/Y gf180mcu_as_sc_mcu7t3v3__clkbuff_4
Xhold1153 VDD VDD VSS VSS _4958_/Q hold1153/Y gf180mcu_as_sc_mcu7t3v3__clkbuff_4
XPHY_EDGE_ROW_187_Left_379 VDD VSS gf180mcu_as_sc_mcu7t3v3__tap_2
XFILLER_22_1284 VDD VDD VSS VSS gf180mcu_as_sc_mcu7t3v3__fillcap_4
XPHY_EDGE_ROW_108_3_Left_480 VDD VSS gf180mcu_as_sc_mcu7t3v3__tap_2
XPHY_EDGE_ROW_44_1_Left_236 VDD VSS gf180mcu_as_sc_mcu7t3v3__tap_2
XFILLER_110_62 VDD VDD VSS VSS gf180mcu_as_sc_mcu7t3v3__fillcap_16
XFILLER_186_505 VDD VDD VSS VSS gf180mcu_as_sc_mcu7t3v3__fillcap_16
XFILLER_186_527 VDD VDD VSS VSS gf180mcu_as_sc_mcu7t3v3__fillcap_16
XFILLER_9_239 VDD VDD VSS VSS gf180mcu_as_sc_mcu7t3v3__fill_2
XTAP_TAPCELL_ROW_12_926 VDD VSS gf180mcu_as_sc_mcu7t3v3__tap_2
XTAP_TAPCELL_ROW_12_915 VDD VSS gf180mcu_as_sc_mcu7t3v3__tap_2
XFILLER_155_903 VDD VDD VSS VSS gf180mcu_as_sc_mcu7t3v3__fillcap_4
XFILLER_186_22 VDD VDD VSS VSS gf180mcu_as_sc_mcu7t3v3__fillcap_8
XFILLER_126_104 VDD VDD VSS VSS gf180mcu_as_sc_mcu7t3v3__fill_1
XFILLER_166_295 VDD VDD VSS VSS gf180mcu_as_sc_mcu7t3v3__fillcap_8
XFILLER_6_935 VDD VDD VSS VSS gf180mcu_as_sc_mcu7t3v3__fillcap_8
XFILLER_154_457 VDD VDD VSS VSS gf180mcu_as_sc_mcu7t3v3__fillcap_4
XFILLER_119_93 VDD VDD VSS VSS gf180mcu_as_sc_mcu7t3v3__fillcap_8
XFILLER_170_928 VDD VDD VSS VSS gf180mcu_as_sc_mcu7t3v3__fillcap_16
XFILLER_79_53 VDD VDD VSS VSS gf180mcu_as_sc_mcu7t3v3__fill_2
XTAP_TAPCELL_ROW_169_1458 VDD VSS gf180mcu_as_sc_mcu7t3v3__tap_2
XFILLER_188_1200 VDD VDD VSS VSS gf180mcu_as_sc_mcu7t3v3__fill_2
XTAP_TAPCELL_ROW_186_1783 VDD VSS gf180mcu_as_sc_mcu7t3v3__tap_2
XTAP_TAPCELL_ROW_186_1772 VDD VSS gf180mcu_as_sc_mcu7t3v3__tap_2
XFILLER_188_1222 VDD VDD VSS VSS gf180mcu_as_sc_mcu7t3v3__fill_2
XFILLER_95_96 VDD VDD VSS VSS gf180mcu_as_sc_mcu7t3v3__fillcap_8
XTAP_TAPCELL_ROW_70_3_1981 VDD VSS gf180mcu_as_sc_mcu7t3v3__tap_2
XFILLER_189_321 VDD VDD VSS VSS gf180mcu_as_sc_mcu7t3v3__fill_1
X_3850_ VDD VDD VSS VSS _3850_/A _5156_/Q _3850_/C _3851_/C gf180mcu_as_sc_mcu7t3v3__nand3_2
XPHY_EDGE_ROW_56_3_Right_97 VDD VSS gf180mcu_as_sc_mcu7t3v3__tap_2
XFILLER_38_1291 VDD VDD VSS VSS gf180mcu_as_sc_mcu7t3v3__fillcap_8
X_3781_ VDD VDD VSS VSS _3781_/S _3781_/B _3781_/A _3783_/C gf180mcu_as_sc_mcu7t3v3__mux2_2
X_2801_ VDD VDD VSS VSS _2847_/A _5245_/Q _4754_/Q _2805_/A gf180mcu_as_sc_mcu7t3v3__mux2_2
XFILLER_160_1163 VDD VDD VSS VSS gf180mcu_as_sc_mcu7t3v3__fill_1
XFILLER_9_762 VDD VDD VSS VSS gf180mcu_as_sc_mcu7t3v3__fillcap_8
X_2732_ VDD VDD VSS VSS _2732_/S _4964_/Q _4973_/Q _2734_/A gf180mcu_as_sc_mcu7t3v3__mux2_2
XFILLER_158_785 VDD VDD VSS VSS gf180mcu_as_sc_mcu7t3v3__fillcap_4
XFILLER_173_722 VDD VDD VSS VSS gf180mcu_as_sc_mcu7t3v3__fill_1
XFILLER_8_272 VDD VDD VSS VSS gf180mcu_as_sc_mcu7t3v3__fillcap_8
XFILLER_9_795 VDD VDD VSS VSS gf180mcu_as_sc_mcu7t3v3__fillcap_4
XPHY_EDGE_ROW_90_1_Left_282 VDD VSS gf180mcu_as_sc_mcu7t3v3__tap_2
XFILLER_67_2 VDD VDD VSS VSS gf180mcu_as_sc_mcu7t3v3__fill_2
X_2663_ VDD VDD VSS VSS _2663_/A _2722_/B _2663_/C _2664_/C _2736_/C gf180mcu_as_sc_mcu7t3v3__aoi211_2
XFILLER_161_939 VDD VDD VSS VSS gf180mcu_as_sc_mcu7t3v3__fillcap_4
XFILLER_173_799 VDD VDD VSS VSS gf180mcu_as_sc_mcu7t3v3__fillcap_16
X_4402_ VDD VDD VSS VSS _4405_/C _4980_/Q _4456_/S gf180mcu_as_sc_mcu7t3v3__nand2b_2
X_2594_ VDD VDD VSS VSS _2595_/A _2767_/A _2731_/S gf180mcu_as_sc_mcu7t3v3__nand2_2
XFILLER_5_72 VDD VDD VSS VSS gf180mcu_as_sc_mcu7t3v3__fillcap_16
X_4333_ VDD VDD VSS VSS _4334_/B _4590_/B _4333_/Y gf180mcu_as_sc_mcu7t3v3__and2_2
XFILLER_5_94 VDD VDD VSS VSS gf180mcu_as_sc_mcu7t3v3__fill_1
X_4264_ VDD VDD VSS VSS _4265_/C _5099_/Q _4264_/B _4264_/A gf180mcu_as_sc_mcu7t3v3__aoi21_2
X_3215_ VDD VDD VSS VSS _3228_/A _3215_/B _3215_/A _3216_/D gf180mcu_as_sc_mcu7t3v3__mux2_2
X_4195_ VDD VDD VSS VSS _4255_/B _4195_/B _4195_/C _5033_/Q _5033_/D gf180mcu_as_sc_mcu7t3v3__ao22_2
X_3146_ VDD VDD VSS VSS _3179_/B _4938_/Q _3147_/D gf180mcu_as_sc_mcu7t3v3__or2_2
X_3077_ VDD VDD VSS VSS _3128_/A _3077_/B _3077_/C _3128_/D _3079_/C gf180mcu_as_sc_mcu7t3v3__ao211_2
XFILLER_165_1052 VDD VDD VSS VSS gf180mcu_as_sc_mcu7t3v3__fillcap_8
X_3979_ VDD VDD VSS VSS _3979_/B _4165_/A _4234_/B gf180mcu_as_sc_mcu7t3v3__and2_2
XFILLER_164_733 VDD VDD VSS VSS gf180mcu_as_sc_mcu7t3v3__fill_2
XFILLER_176_593 VDD VDD VSS VSS gf180mcu_as_sc_mcu7t3v3__fill_2
XFILLER_52_1288 VDD VDD VSS VSS gf180mcu_as_sc_mcu7t3v3__fill_1
XFILLER_152_906 VDD VDD VSS VSS gf180mcu_as_sc_mcu7t3v3__fillcap_4
XFILLER_164_766 VDD VDD VSS VSS gf180mcu_as_sc_mcu7t3v3__fillcap_16
XFILLER_156_69 VDD VDD VSS VSS gf180mcu_as_sc_mcu7t3v3__fill_2
XFILLER_163_298 VDD VDD VSS VSS gf180mcu_as_sc_mcu7t3v3__fill_1
XFILLER_172_1012 VDD VDD VSS VSS gf180mcu_as_sc_mcu7t3v3__fill_2
XFILLER_160_961 VDD VDD VSS VSS gf180mcu_as_sc_mcu7t3v3__fillcap_8
XFILLER_2_459 VDD VDD VSS VSS gf180mcu_as_sc_mcu7t3v3__fill_1
Xfanout730 VDD VDD VSS VSS wire731/Y _3493_/C gf180mcu_as_sc_mcu7t3v3__buff_12
Xfanout741 VDD VDD VSS VSS _3736_/B _3704_/B gf180mcu_as_sc_mcu7t3v3__buff_12
Xfanout752 VDD VDD VSS VSS _3129_/B _3046_/B gf180mcu_as_sc_mcu7t3v3__buff_12
Xfanout763 VDD VDD VSS VSS _4749_/B _4721_/A gf180mcu_as_sc_mcu7t3v3__buff_12
Xfanout774 VDD VDD VSS VSS _3177_/B _3233_/B gf180mcu_as_sc_mcu7t3v3__buff_12
Xfanout785 VDD VDD VSS VSS _2591_/Y _4974_/D gf180mcu_as_sc_mcu7t3v3__buff_12
XTAP_TAPCELL_ROW_89_1_1042 VDD VSS gf180mcu_as_sc_mcu7t3v3__tap_2
XTAP_TAPCELL_ROW_103_1_1056 VDD VSS gf180mcu_as_sc_mcu7t3v3__tap_2
XFILLER_105_84 VDD VDD VSS VSS gf180mcu_as_sc_mcu7t3v3__fill_1
XTAP_TAPCELL_ROW_6_798 VDD VSS gf180mcu_as_sc_mcu7t3v3__tap_2
XTAP_TAPCELL_ROW_164_1366 VDD VSS gf180mcu_as_sc_mcu7t3v3__tap_2
XTAP_TAPCELL_ROW_164_1355 VDD VSS gf180mcu_as_sc_mcu7t3v3__tap_2
XTAP_TAPCELL_ROW_181_1691 VDD VSS gf180mcu_as_sc_mcu7t3v3__tap_2
XTAP_TAPCELL_ROW_181_1680 VDD VSS gf180mcu_as_sc_mcu7t3v3__tap_2
XFILLER_183_1130 VDD VDD VSS VSS gf180mcu_as_sc_mcu7t3v3__fill_1
XFILLER_121_72 VDD VDD VSS VSS gf180mcu_as_sc_mcu7t3v3__fill_2
XFILLER_183_1152 VDD VDD VSS VSS gf180mcu_as_sc_mcu7t3v3__fillcap_8
XFILLER_109_1256 VDD VDD VSS VSS gf180mcu_as_sc_mcu7t3v3__fillcap_16
XFILLER_186_313 VDD VDD VSS VSS gf180mcu_as_sc_mcu7t3v3__fill_2
XFILLER_14_92 VDD VDD VSS VSS gf180mcu_as_sc_mcu7t3v3__fill_1
XFILLER_155_766 VDD VDD VSS VSS gf180mcu_as_sc_mcu7t3v3__fillcap_4
XFILLER_155_1210 VDD VDD VSS VSS gf180mcu_as_sc_mcu7t3v3__fillcap_4
XTAP_TAPCELL_ROW_188_1812 VDD VSS gf180mcu_as_sc_mcu7t3v3__tap_2
XFILLER_68_1295 VDD VDD VSS VSS gf180mcu_as_sc_mcu7t3v3__fill_1
XTAP_TAPCELL_ROW_188_1823 VDD VSS gf180mcu_as_sc_mcu7t3v3__tap_2
XFILLER_1_492 VDD VDD VSS VSS gf180mcu_as_sc_mcu7t3v3__fillcap_16
Xclkbuf_leaf_4_clk_regs VDD VDD VSS VSS clkbuf_leaf_9_clk_regs/A clkload8/A gf180mcu_as_sc_mcu7t3v3__clkbuff_12
Xinput7 VDD VDD VSS VSS boot_addr[5] input7/Y gf180mcu_as_sc_mcu7t3v3__buff_12
X_3000_ VDD VDD VSS VSS _3043_/S _3981_/A _3983_/A _3002_/B gf180mcu_as_sc_mcu7t3v3__mux2_2
X_4951_ VDD VDD VSS VSS _5158_/CLK _4951_/D _4951_/Q gf180mcu_as_sc_mcu7t3v3__dfxtp_2
XFILLER_178_814 VDD VDD VSS VSS gf180mcu_as_sc_mcu7t3v3__fillcap_8
X_4882_ VDD VDD VSS VSS _4895_/CLK _4882_/D _4882_/Q gf180mcu_as_sc_mcu7t3v3__dfxtp_2
X_3902_ VDD VDD VSS VSS _3908_/B _5160_/Q _4942_/D gf180mcu_as_sc_mcu7t3v3__and2_2
XFILLER_177_313 VDD VDD VSS VSS gf180mcu_as_sc_mcu7t3v3__fillcap_4
XFILLER_177_346 VDD VDD VSS VSS gf180mcu_as_sc_mcu7t3v3__fillcap_4
X_3833_ VDD VDD VSS VSS _4910_/D _4753_/B _4753_/A gf180mcu_as_sc_mcu7t3v3__nor2_2
XFILLER_177_379 VDD VDD VSS VSS gf180mcu_as_sc_mcu7t3v3__fillcap_16
XFILLER_192_338 VDD VDD VSS VSS gf180mcu_as_sc_mcu7t3v3__fill_2
X_3764_ VDD VDD VSS VSS _4143_/A _3773_/B _3764_/C _3764_/D _3765_/D gf180mcu_as_sc_mcu7t3v3__ao211_2
X_3695_ VDD VDD VSS VSS _4069_/D _3781_/S _3695_/C _3695_/D _3696_/C gf180mcu_as_sc_mcu7t3v3__ao211_2
X_2715_ VDD VDD VSS VSS _2716_/D _2832_/S _2722_/B _2715_/A gf180mcu_as_sc_mcu7t3v3__aoi21b_2
X_2646_ VDD VDD VSS VSS _2831_/A _2646_/B _5264_/Q _2649_/B gf180mcu_as_sc_mcu7t3v3__mux2_2
XFILLER_161_736 VDD VDD VSS VSS gf180mcu_as_sc_mcu7t3v3__fillcap_8
Xoutput344 VDD VDD VSS VSS _4866_/Q east_out[27] gf180mcu_as_sc_mcu7t3v3__buff_12
Xoutput333 VDD VDD VSS VSS _4856_/Q east_out[17] gf180mcu_as_sc_mcu7t3v3__buff_12
Xoutput322 VDD VDD VSS VSS _5483_/Y dft_rdata[5] gf180mcu_as_sc_mcu7t3v3__buff_12
XFILLER_173_1332 VDD VDD VSS VSS gf180mcu_as_sc_mcu7t3v3__fillcap_16
XFILLER_173_1354 VDD VDD VSS VSS gf180mcu_as_sc_mcu7t3v3__fill_1
Xoutput377 VDD VDD VSS VSS _4797_/Q se_out[26] gf180mcu_as_sc_mcu7t3v3__buff_12
Xoutput366 VDD VDD VSS VSS _4787_/Q se_out[16] gf180mcu_as_sc_mcu7t3v3__buff_12
Xoutput355 VDD VDD VSS VSS _4845_/Q east_out[6] gf180mcu_as_sc_mcu7t3v3__buff_12
X_2577_ VDD VDD VSS VSS _2599_/A _2601_/D _2699_/D gf180mcu_as_sc_mcu7t3v3__or2_2
Xoutput399 VDD VDD VSS VSS _4820_/Q south_out[15] gf180mcu_as_sc_mcu7t3v3__buff_12
Xoutput388 VDD VDD VSS VSS _4776_/Q se_out[5] gf180mcu_as_sc_mcu7t3v3__buff_12
X_4316_ VDD VDD VSS VSS _4319_/S _5146_/Q _5145_/Q _5145_/D gf180mcu_as_sc_mcu7t3v3__mux2_2
X_4247_ VDD VDD VSS VSS _4257_/S _4247_/B _5083_/Q _5083_/D gf180mcu_as_sc_mcu7t3v3__mux2_2
X_4178_ VDD VDD VSS VSS _4238_/B _4197_/B _4197_/C _5016_/Q _5016_/D gf180mcu_as_sc_mcu7t3v3__ao22_2
XTAP_TAPCELL_ROW_3_746 VDD VSS gf180mcu_as_sc_mcu7t3v3__tap_2
XTAP_TAPCELL_ROW_3_757 VDD VSS gf180mcu_as_sc_mcu7t3v3__tap_2
XFILLER_167_1136 VDD VDD VSS VSS gf180mcu_as_sc_mcu7t3v3__fillcap_16
X_3129_ VDD VDD VSS VSS _3129_/B _4936_/Q _3130_/D gf180mcu_as_sc_mcu7t3v3__or2_2
XFILLER_169_814 VDD VDD VSS VSS gf180mcu_as_sc_mcu7t3v3__fill_1
XFILLER_35_69 VDD VDD VSS VSS gf180mcu_as_sc_mcu7t3v3__fill_1
XFILLER_169_858 VDD VDD VSS VSS gf180mcu_as_sc_mcu7t3v3__fillcap_16
XFILLER_168_379 VDD VDD VSS VSS gf180mcu_as_sc_mcu7t3v3__fillcap_4
XFILLER_183_349 VDD VDD VSS VSS gf180mcu_as_sc_mcu7t3v3__fill_1
XTAP_TAPCELL_ROW_122_3_2033 VDD VSS gf180mcu_as_sc_mcu7t3v3__tap_2
XFILLER_192_883 VDD VDD VSS VSS gf180mcu_as_sc_mcu7t3v3__fill_1
XFILLER_152_747 VDD VDD VSS VSS gf180mcu_as_sc_mcu7t3v3__fill_1
XFILLER_3_757 VDD VDD VSS VSS gf180mcu_as_sc_mcu7t3v3__fill_2
XFILLER_116_94 VDD VDD VSS VSS gf180mcu_as_sc_mcu7t3v3__fillcap_8
Xfanout560 VDD VDD VSS VSS _3726_/B _3652_/B gf180mcu_as_sc_mcu7t3v3__buff_12
XTAP_TAPCELL_ROW_166_1406 VDD VSS gf180mcu_as_sc_mcu7t3v3__tap_2
Xfanout571 VDD VDD VSS VSS _3453_/B _3374_/B gf180mcu_as_sc_mcu7t3v3__buff_12
Xfanout582 VDD VDD VSS VSS _2945_/Y _3148_/A gf180mcu_as_sc_mcu7t3v3__buff_12
Xfanout593 VDD VDD VSS VSS _3919_/Y _4154_/B gf180mcu_as_sc_mcu7t3v3__buff_12
XTAP_TAPCELL_ROW_183_1731 VDD VSS gf180mcu_as_sc_mcu7t3v3__tap_2
XTAP_TAPCELL_ROW_183_1720 VDD VSS gf180mcu_as_sc_mcu7t3v3__tap_2
XFILLER_92_31 VDD VDD VSS VSS gf180mcu_as_sc_mcu7t3v3__fillcap_4
XFILLER_98_1299 VDD VDD VSS VSS gf180mcu_as_sc_mcu7t3v3__fill_1
XFILLER_187_600 VDD VDD VSS VSS gf180mcu_as_sc_mcu7t3v3__fillcap_16
XFILLER_159_346 VDD VDD VSS VSS gf180mcu_as_sc_mcu7t3v3__fillcap_4
XFILLER_159_368 VDD VDD VSS VSS gf180mcu_as_sc_mcu7t3v3__fillcap_16
XFILLER_175_817 VDD VDD VSS VSS gf180mcu_as_sc_mcu7t3v3__fillcap_16
XFILLER_175_839 VDD VDD VSS VSS gf180mcu_as_sc_mcu7t3v3__fill_1
XFILLER_187_699 VDD VDD VSS VSS gf180mcu_as_sc_mcu7t3v3__fill_1
XFILLER_10_591 VDD VDD VSS VSS gf180mcu_as_sc_mcu7t3v3__fillcap_4
X_3480_ VDD VDD VSS VSS _4135_/D _3495_/B _3480_/C _3480_/D _3482_/C gf180mcu_as_sc_mcu7t3v3__ao211_2
X_2500_ VDD VDD VSS VSS _2525_/A _5229_/Q _2502_/C gf180mcu_as_sc_mcu7t3v3__and2_2
XFILLER_170_522 VDD VDD VSS VSS gf180mcu_as_sc_mcu7t3v3__fill_2
XFILLER_192_1207 VDD VDD VSS VSS gf180mcu_as_sc_mcu7t3v3__fillcap_4
X_2431_ VDD VDD VSS VSS _3639_/A _4010_/A gf180mcu_as_sc_mcu7t3v3__inv_2
XFILLER_9_1126 VDD VDD VSS VSS gf180mcu_as_sc_mcu7t3v3__fill_1
X_5150_ VDD VDD VSS VSS _5150_/CLK _5150_/D _5150_/Q gf180mcu_as_sc_mcu7t3v3__dfxtp_2
XPHY_EDGE_ROW_121_1_Left_313 VDD VSS gf180mcu_as_sc_mcu7t3v3__tap_2
X_5081_ VDD VDD VSS VSS _5089_/CLK _5081_/D _5081_/Q gf180mcu_as_sc_mcu7t3v3__dfxtp_2
X_4101_ VDD VDD VSS VSS _4101_/A _4101_/B _4101_/C _4101_/D _4103_/C gf180mcu_as_sc_mcu7t3v3__ao22_2
XTAP_TAPCELL_ROW_57_3_1968 VDD VSS gf180mcu_as_sc_mcu7t3v3__tap_2
X_4032_ VDD VDD VSS VSS _4032_/A _4104_/B _4104_/C _4032_/D _4033_/D gf180mcu_as_sc_mcu7t3v3__ao22_2
XPHY_EDGE_ROW_160_Right_22 VDD VSS gf180mcu_as_sc_mcu7t3v3__tap_2
X_4934_ VDD VDD VSS VSS _5185_/CLK _4934_/D _4934_/Q gf180mcu_as_sc_mcu7t3v3__dfxtp_2
XANTENNA_12 VDD VDD VSS VSS _2956_/B gf180mcu_as_sc_mcu7t3v3__diode_2
XANTENNA_23 VDD VDD VSS VSS _4153_/A gf180mcu_as_sc_mcu7t3v3__diode_2
X_4865_ VDD VDD VSS VSS _5097_/CLK _4865_/D _4865_/Q gf180mcu_as_sc_mcu7t3v3__dfxtp_2
XANTENNA_34 VDD VDD VSS VSS _3995_/B gf180mcu_as_sc_mcu7t3v3__diode_2
XANTENNA_45 VDD VDD VSS VSS _4048_/A gf180mcu_as_sc_mcu7t3v3__diode_2
X_4796_ VDD VDD VSS VSS _5226_/CLK _4796_/D _4796_/Q gf180mcu_as_sc_mcu7t3v3__dfxtp_2
X_3816_ VDD VDD VSS VSS _3928_/A _3818_/B _3818_/A gf180mcu_as_sc_mcu7t3v3__nand2_2
X_3747_ VDD VDD VSS VSS _3769_/B _4128_/A _3749_/C gf180mcu_as_sc_mcu7t3v3__and2_2
XFILLER_101_1326 VDD VDD VSS VSS gf180mcu_as_sc_mcu7t3v3__fillcap_4
XFILLER_173_360 VDD VDD VSS VSS gf180mcu_as_sc_mcu7t3v3__fill_2
X_3678_ VDD VDD VSS VSS _3679_/C _4053_/A _3725_/B _3678_/C gf180mcu_as_sc_mcu7t3v3__ao21_2
X_2629_ VDD VDD VSS VSS _2676_/A _2629_/B _2629_/A _2629_/Y gf180mcu_as_sc_mcu7t3v3__mux2_2
XTAP_TAPCELL_ROW_8_838 VDD VSS gf180mcu_as_sc_mcu7t3v3__tap_2
XPHY_EDGE_ROW_53_1_Left_245 VDD VSS gf180mcu_as_sc_mcu7t3v3__tap_2
XTAP_TAPCELL_ROW_8_849 VDD VSS gf180mcu_as_sc_mcu7t3v3__tap_2
X_5279_ VDD VDD VSS VSS _5280_/CLK _5279_/D _5279_/Q gf180mcu_as_sc_mcu7t3v3__dfxtp_2
XTAP_TAPCELL_ROW_161_1314 VDD VSS gf180mcu_as_sc_mcu7t3v3__tap_2
XTAP_TAPCELL_ROW_161_1303 VDD VSS gf180mcu_as_sc_mcu7t3v3__tap_2
XPHY_EDGE_ROW_136_3_Left_508 VDD VSS gf180mcu_as_sc_mcu7t3v3__tap_2
XFILLER_102_74 VDD VDD VSS VSS gf180mcu_as_sc_mcu7t3v3__fillcap_4
XFILLER_12_801 VDD VDD VSS VSS gf180mcu_as_sc_mcu7t3v3__fillcap_4
XFILLER_169_644 VDD VDD VSS VSS gf180mcu_as_sc_mcu7t3v3__fill_2
XFILLER_62_34 VDD VDD VSS VSS gf180mcu_as_sc_mcu7t3v3__fill_1
XFILLER_11_322 VDD VDD VSS VSS gf180mcu_as_sc_mcu7t3v3__fillcap_16
XFILLER_145_1275 VDD VDD VSS VSS gf180mcu_as_sc_mcu7t3v3__fill_1
XFILLER_178_34 VDD VDD VSS VSS gf180mcu_as_sc_mcu7t3v3__fill_1
XFILLER_12_867 VDD VDD VSS VSS gf180mcu_as_sc_mcu7t3v3__fillcap_8
XFILLER_157_839 VDD VDD VSS VSS gf180mcu_as_sc_mcu7t3v3__fill_1
XFILLER_168_165 VDD VDD VSS VSS gf180mcu_as_sc_mcu7t3v3__fillcap_8
XFILLER_169_699 VDD VDD VSS VSS gf180mcu_as_sc_mcu7t3v3__fill_1
XFILLER_7_315 VDD VDD VSS VSS gf180mcu_as_sc_mcu7t3v3__fillcap_4
XTAP_TAPCELL_ROW_159_1276 VDD VSS gf180mcu_as_sc_mcu7t3v3__tap_2
XTAP_TAPCELL_ROW_159_1265 VDD VSS gf180mcu_as_sc_mcu7t3v3__tap_2
XFILLER_7_348 VDD VDD VSS VSS gf180mcu_as_sc_mcu7t3v3__fill_2
XFILLER_8_849 VDD VDD VSS VSS gf180mcu_as_sc_mcu7t3v3__fill_2
XTAP_TAPCELL_ROW_176_1590 VDD VSS gf180mcu_as_sc_mcu7t3v3__tap_2
XFILLER_178_1051 VDD VDD VSS VSS gf180mcu_as_sc_mcu7t3v3__fillcap_4
XFILLER_180_820 VDD VDD VSS VSS gf180mcu_as_sc_mcu7t3v3__fillcap_4
XFILLER_3_576 VDD VDD VSS VSS gf180mcu_as_sc_mcu7t3v3__fillcap_4
XFILLER_87_97 VDD VDD VSS VSS gf180mcu_as_sc_mcu7t3v3__fillcap_8
XPHY_EDGE_ROW_91_1_Right_600 VDD VSS gf180mcu_as_sc_mcu7t3v3__tap_2
XFILLER_185_1033 VDD VDD VSS VSS gf180mcu_as_sc_mcu7t3v3__fillcap_16
X_2980_ VDD VDD VSS VSS _3049_/B _2980_/B _2980_/C _2981_/C gf180mcu_as_sc_mcu7t3v3__nor3_2
XFILLER_187_430 VDD VDD VSS VSS gf180mcu_as_sc_mcu7t3v3__fill_1
XFILLER_159_187 VDD VDD VSS VSS gf180mcu_as_sc_mcu7t3v3__fillcap_8
X_4650_ VDD VDD VSS VSS _4651_/B _4733_/A _5237_/Q _4657_/B gf180mcu_as_sc_mcu7t3v3__ao21_2
XFILLER_174_113 VDD VDD VSS VSS gf180mcu_as_sc_mcu7t3v3__fill_1
Xinput10 VDD VDD VSS VSS boot_addr[8] _2671_/A gf180mcu_as_sc_mcu7t3v3__buff_12
Xinput21 VDD VDD VSS VSS boot_wen _2831_/B gf180mcu_as_sc_mcu7t3v3__buff_12
X_3601_ VDD VDD VSS VSS _3971_/A _3723_/B _3601_/C _3601_/Y _3699_/D gf180mcu_as_sc_mcu7t3v3__aoi211_2
XFILLER_156_872 VDD VDD VSS VSS gf180mcu_as_sc_mcu7t3v3__fill_2
XFILLER_174_157 VDD VDD VSS VSS gf180mcu_as_sc_mcu7t3v3__fillcap_4
Xinput32 VDD VDD VSS VSS dft_addr[9] _2676_/B gf180mcu_as_sc_mcu7t3v3__buff_12
Xinput43 VDD VDD VSS VSS dft_we _2451_/A gf180mcu_as_sc_mcu7t3v3__buff_12
Xinput54 VDD VDD VSS VSS east_in[19] wire863/A gf180mcu_as_sc_mcu7t3v3__buff_12
X_4581_ VDD VDD VSS VSS _4581_/D _4581_/A _4581_/B _4581_/C _4582_/B gf180mcu_as_sc_mcu7t3v3__ao31_2
XFILLER_171_842 VDD VDD VSS VSS gf180mcu_as_sc_mcu7t3v3__fillcap_8
Xinput65 VDD VDD VSS VSS east_in[29] wire858/A gf180mcu_as_sc_mcu7t3v3__buff_12
Xinput76 VDD VDD VSS VSS east_in[8] wire853/A gf180mcu_as_sc_mcu7t3v3__buff_12
Xinput87 VDD VDD VSS VSS ne_in[18] _4077_/A gf180mcu_as_sc_mcu7t3v3__buff_12
Xinput98 VDD VDD VSS VSS ne_in[28] _4160_/A gf180mcu_as_sc_mcu7t3v3__buff_12
X_3532_ VDD VDD VSS VSS _3736_/B _3551_/A gf180mcu_as_sc_mcu7t3v3__inv_2
XFILLER_192_1015 VDD VDD VSS VSS gf180mcu_as_sc_mcu7t3v3__fill_1
XFILLER_83_1310 VDD VDD VSS VSS gf180mcu_as_sc_mcu7t3v3__fillcap_8
Xmax_cap568 VDD VDD VSS VSS _3390_/C _3453_/C gf180mcu_as_sc_mcu7t3v3__clkbuff_12
X_3463_ VDD VDD VSS VSS _4115_/A _3463_/B _3463_/C _4827_/D _3615_/D gf180mcu_as_sc_mcu7t3v3__aoi211_2
X_5202_ VDD VDD VSS VSS _5203_/CLK _5202_/D _5202_/Q gf180mcu_as_sc_mcu7t3v3__dfxtp_2
X_2414_ VDD VDD VSS VSS _3850_/A _5155_/Q gf180mcu_as_sc_mcu7t3v3__inv_2
X_5133_ VDD VDD VSS VSS _5216_/CLK _5133_/D _5133_/Q gf180mcu_as_sc_mcu7t3v3__dfxtp_2
X_3394_ VDD VDD VSS VSS _3450_/B _4046_/D _3395_/D gf180mcu_as_sc_mcu7t3v3__and2_2
X_5064_ VDD VDD VSS VSS _5185_/CLK _5064_/D _5064_/Q gf180mcu_as_sc_mcu7t3v3__dfxtp_2
X_4015_ VDD VDD VSS VSS _4015_/A _4103_/B _4015_/C _4015_/D _4017_/C gf180mcu_as_sc_mcu7t3v3__ao211_2
XFILLER_16_27 VDD VDD VSS VSS gf180mcu_as_sc_mcu7t3v3__fillcap_8
XFILLER_168_1297 VDD VDD VSS VSS gf180mcu_as_sc_mcu7t3v3__fillcap_8
XFILLER_178_452 VDD VDD VSS VSS gf180mcu_as_sc_mcu7t3v3__fill_2
X_4917_ VDD VDD VSS VSS clkload1/A _4917_/D _4917_/Q gf180mcu_as_sc_mcu7t3v3__dfxtp_2
XFILLER_178_485 VDD VDD VSS VSS gf180mcu_as_sc_mcu7t3v3__fillcap_4
XFILLER_179_986 VDD VDD VSS VSS gf180mcu_as_sc_mcu7t3v3__fill_1
X_4848_ VDD VDD VSS VSS _5220_/CLK _4848_/D _4848_/Q gf180mcu_as_sc_mcu7t3v3__dfxtp_2
XFILLER_148_26 VDD VDD VSS VSS gf180mcu_as_sc_mcu7t3v3__fill_2
XFILLER_181_628 VDD VDD VSS VSS gf180mcu_as_sc_mcu7t3v3__fill_2
X_4779_ VDD VDD VSS VSS _5275_/CLK _4779_/D _4779_/Q gf180mcu_as_sc_mcu7t3v3__dfxtp_2
XFILLER_10_1017 VDD VDD VSS VSS gf180mcu_as_sc_mcu7t3v3__fillcap_8
XTAP_TAPCELL_ROW_154_1173 VDD VSS gf180mcu_as_sc_mcu7t3v3__tap_2
XFILLER_161_352 VDD VDD VSS VSS gf180mcu_as_sc_mcu7t3v3__fillcap_16
XFILLER_175_1235 VDD VDD VSS VSS gf180mcu_as_sc_mcu7t3v3__fill_1
XFILLER_0_546 VDD VDD VSS VSS gf180mcu_as_sc_mcu7t3v3__fillcap_4
XFILLER_5_1343 VDD VDD VSS VSS gf180mcu_as_sc_mcu7t3v3__fillcap_8
XFILLER_147_1326 VDD VDD VSS VSS gf180mcu_as_sc_mcu7t3v3__fillcap_4
XFILLER_189_22 VDD VDD VSS VSS gf180mcu_as_sc_mcu7t3v3__fillcap_8
XFILLER_73_33 VDD VDD VSS VSS gf180mcu_as_sc_mcu7t3v3__fill_1
XFILLER_182_1239 VDD VDD VSS VSS gf180mcu_as_sc_mcu7t3v3__fill_2
XFILLER_189_66 VDD VDD VSS VSS gf180mcu_as_sc_mcu7t3v3__fillcap_4
XTAP_TAPCELL_ROW_178_1630 VDD VSS gf180mcu_as_sc_mcu7t3v3__tap_2
XPHY_EDGE_ROW_130_1_Right_639 VDD VSS gf180mcu_as_sc_mcu7t3v3__tap_2
XFILLER_12_664 VDD VDD VSS VSS gf180mcu_as_sc_mcu7t3v3__fill_1
XFILLER_185_912 VDD VDD VSS VSS gf180mcu_as_sc_mcu7t3v3__fillcap_16
XFILLER_8_613 VDD VDD VSS VSS gf180mcu_as_sc_mcu7t3v3__fillcap_4
XFILLER_12_697 VDD VDD VSS VSS gf180mcu_as_sc_mcu7t3v3__fill_1
XFILLER_157_647 VDD VDD VSS VSS gf180mcu_as_sc_mcu7t3v3__fillcap_16
XFILLER_185_967 VDD VDD VSS VSS gf180mcu_as_sc_mcu7t3v3__fill_1
XTAP_TAPCELL_ROW_174_1549 VDD VSS gf180mcu_as_sc_mcu7t3v3__tap_2
XFILLER_171_138 VDD VDD VSS VSS gf180mcu_as_sc_mcu7t3v3__fill_2
XTAP_TAPCELL_ROW_191_1874 VDD VSS gf180mcu_as_sc_mcu7t3v3__tap_2
XTAP_TAPCELL_ROW_10_887 VDD VSS gf180mcu_as_sc_mcu7t3v3__tap_2
XTAP_TAPCELL_ROW_10_876 VDD VSS gf180mcu_as_sc_mcu7t3v3__tap_2
XFILLER_154_1308 VDD VDD VSS VSS gf180mcu_as_sc_mcu7t3v3__fill_2
XFILLER_4_885 VDD VDD VSS VSS gf180mcu_as_sc_mcu7t3v3__fillcap_4
XFILLER_93_100 VDD VDD VSS VSS gf180mcu_as_sc_mcu7t3v3__fillcap_4
XPHY_EDGE_ROW_92_1_Right_601 VDD VSS gf180mcu_as_sc_mcu7t3v3__tap_2
XFILLER_179_216 VDD VDD VSS VSS gf180mcu_as_sc_mcu7t3v3__fill_2
XFILLER_176_901 VDD VDD VSS VSS gf180mcu_as_sc_mcu7t3v3__fillcap_4
X_2963_ VDD VDD VSS VSS _2964_/C _2963_/C _3042_/C _3938_/A gf180mcu_as_sc_mcu7t3v3__aoi21_2
XFILLER_147_102 VDD VDD VSS VSS gf180mcu_as_sc_mcu7t3v3__fill_2
X_4702_ VDD VDD VSS VSS _4705_/D _4705_/A _5250_/Q gf180mcu_as_sc_mcu7t3v3__nor2b_2
XFILLER_175_422 VDD VDD VSS VSS gf180mcu_as_sc_mcu7t3v3__fillcap_16
X_2894_ VDD VDD VSS VSS _2894_/Y _3533_/C _3257_/A gf180mcu_as_sc_mcu7t3v3__nand2_2
XFILLER_176_978 VDD VDD VSS VSS gf180mcu_as_sc_mcu7t3v3__fillcap_8
XFILLER_190_403 VDD VDD VSS VSS gf180mcu_as_sc_mcu7t3v3__fillcap_8
X_4633_ VDD VDD VSS VSS _4731_/B _5121_/Q _5224_/Q _5224_/D gf180mcu_as_sc_mcu7t3v3__mux2_2
XFILLER_156_691 VDD VDD VSS VSS gf180mcu_as_sc_mcu7t3v3__fill_2
XFILLER_175_488 VDD VDD VSS VSS gf180mcu_as_sc_mcu7t3v3__fill_2
X_4564_ VDD VDD VSS VSS _4564_/B _4591_/A _4565_/D gf180mcu_as_sc_mcu7t3v3__and2_2
X_3515_ VDD VDD VSS VSS _3515_/D _3515_/A _3817_/A _3524_/C _3516_/B gf180mcu_as_sc_mcu7t3v3__ao31_2
XTAP_TAPCELL_ROW_60_1_1013 VDD VSS gf180mcu_as_sc_mcu7t3v3__tap_2
XFILLER_171_683 VDD VDD VSS VSS gf180mcu_as_sc_mcu7t3v3__fill_1
X_4495_ VDD VDD VSS VSS _5177_/Q _4574_/B _4495_/C _4495_/D _5177_/D gf180mcu_as_sc_mcu7t3v3__ao211_2
XFILLER_170_193 VDD VDD VSS VSS gf180mcu_as_sc_mcu7t3v3__fill_2
XFILLER_48_1260 VDD VDD VSS VSS gf180mcu_as_sc_mcu7t3v3__fill_2
X_3446_ VDD VDD VSS VSS _3462_/A _3446_/B _3446_/C _3447_/C gf180mcu_as_sc_mcu7t3v3__nor3_2
X_3377_ VDD VDD VSS VSS _3450_/B _4030_/D _3380_/C gf180mcu_as_sc_mcu7t3v3__and2_2
X_5116_ VDD VDD VSS VSS _5181_/CLK _5116_/D _5116_/Q gf180mcu_as_sc_mcu7t3v3__dfxtp_2
X_5047_ VDD VDD VSS VSS clkload2/A _5047_/D _5047_/Q gf180mcu_as_sc_mcu7t3v3__dfxtp_2
XFILLER_0_1251 VDD VDD VSS VSS gf180mcu_as_sc_mcu7t3v3__fillcap_4
XFILLER_159_14 VDD VDD VSS VSS gf180mcu_as_sc_mcu7t3v3__fillcap_4
XFILLER_94_1291 VDD VDD VSS VSS gf180mcu_as_sc_mcu7t3v3__fill_1
XFILLER_55_1264 VDD VDD VSS VSS gf180mcu_as_sc_mcu7t3v3__fill_2
XFILLER_142_1256 VDD VDD VSS VSS gf180mcu_as_sc_mcu7t3v3__fillcap_16
XFILLER_166_433 VDD VDD VSS VSS gf180mcu_as_sc_mcu7t3v3__fillcap_16
XTAP_TAPCELL_ROW_156_1213 VDD VSS gf180mcu_as_sc_mcu7t3v3__tap_2
XTAP_TAPCELL_ROW_156_1202 VDD VSS gf180mcu_as_sc_mcu7t3v3__tap_2
XFILLER_166_477 VDD VDD VSS VSS gf180mcu_as_sc_mcu7t3v3__fill_2
XFILLER_167_978 VDD VDD VSS VSS gf180mcu_as_sc_mcu7t3v3__fill_2
XFILLER_182_915 VDD VDD VSS VSS gf180mcu_as_sc_mcu7t3v3__fillcap_16
XFILLER_162_661 VDD VDD VSS VSS gf180mcu_as_sc_mcu7t3v3__fillcap_4
Xinput200 VDD VDD VSS VSS se_in[27] _4155_/A gf180mcu_as_sc_mcu7t3v3__buff_12
Xinput211 VDD VDD VSS VSS se_in[6] wire875/A gf180mcu_as_sc_mcu7t3v3__buff_12
XFILLER_62_1268 VDD VDD VSS VSS gf180mcu_as_sc_mcu7t3v3__fill_1
Xinput222 VDD VDD VSS VSS south_in[16] _4062_/A gf180mcu_as_sc_mcu7t3v3__buff_12
Xinput233 VDD VDD VSS VSS south_in[26] _4143_/D gf180mcu_as_sc_mcu7t3v3__buff_12
Xinput244 VDD VDD VSS VSS south_in[5] _3973_/D gf180mcu_as_sc_mcu7t3v3__buff_12
XPHY_EDGE_ROW_16_1_Left_208 VDD VSS gf180mcu_as_sc_mcu7t3v3__tap_2
XFILLER_5_1151 VDD VDD VSS VSS gf180mcu_as_sc_mcu7t3v3__fill_2
Xinput255 VDD VDD VSS VSS sw_in[15] _4058_/A gf180mcu_as_sc_mcu7t3v3__buff_12
Xinput266 VDD VDD VSS VSS sw_in[25] _3483_/A gf180mcu_as_sc_mcu7t3v3__buff_12
Xinput277 VDD VDD VSS VSS sw_in[4] _2427_/A gf180mcu_as_sc_mcu7t3v3__buff_12
Xinput288 VDD VDD VSS VSS west_in[14] _4046_/A gf180mcu_as_sc_mcu7t3v3__buff_12
Xinput299 VDD VDD VSS VSS west_in[24] _4126_/D gf180mcu_as_sc_mcu7t3v3__buff_12
XFILLER_186_1183 VDD VDD VSS VSS gf180mcu_as_sc_mcu7t3v3__fillcap_8
XFILLER_129_102 VDD VDD VSS VSS gf180mcu_as_sc_mcu7t3v3__fill_2
XFILLER_12_461 VDD VDD VSS VSS gf180mcu_as_sc_mcu7t3v3__fill_1
XFILLER_157_422 VDD VDD VSS VSS gf180mcu_as_sc_mcu7t3v3__fillcap_8
XFILLER_169_282 VDD VDD VSS VSS gf180mcu_as_sc_mcu7t3v3__fillcap_16
XPHY_EDGE_ROW_130_1_Left_322 VDD VSS gf180mcu_as_sc_mcu7t3v3__tap_2
XFILLER_8_454 VDD VDD VSS VSS gf180mcu_as_sc_mcu7t3v3__fill_1
XFILLER_157_488 VDD VDD VSS VSS gf180mcu_as_sc_mcu7t3v3__fill_2
XFILLER_173_937 VDD VDD VSS VSS gf180mcu_as_sc_mcu7t3v3__fillcap_8
X_3300_ VDD VDD VSS VSS _3947_/A _3373_/S _3374_/B _3948_/A _3301_/D gf180mcu_as_sc_mcu7t3v3__ao22_2
XFILLER_152_182 VDD VDD VSS VSS gf180mcu_as_sc_mcu7t3v3__fillcap_8
X_4280_ VDD VDD VSS VSS _4281_/S _4706_/A _5114_/Q _5114_/D gf180mcu_as_sc_mcu7t3v3__mux2_2
X_3231_ VDD VDD VSS VSS _3232_/B _3515_/A _3241_/C _3231_/C gf180mcu_as_sc_mcu7t3v3__ao21_2
XTAP_TAPCELL_ROW_121_1_1074 VDD VSS gf180mcu_as_sc_mcu7t3v3__tap_2
X_3162_ VDD VDD VSS VSS _3179_/B _4940_/Q _3163_/D gf180mcu_as_sc_mcu7t3v3__or2_2
X_3093_ VDD VDD VSS VSS _4071_/A _3222_/D _3236_/C _4072_/D _3094_/C gf180mcu_as_sc_mcu7t3v3__ao22_2
XPHY_EDGE_ROW_28_3_Right_69 VDD VSS gf180mcu_as_sc_mcu7t3v3__tap_2
XPHY_EDGE_ROW_93_1_Right_602 VDD VSS gf180mcu_as_sc_mcu7t3v3__tap_2
X_3995_ VDD VDD VSS VSS _3995_/B _4165_/A _4236_/B gf180mcu_as_sc_mcu7t3v3__and2_2
XPHY_EDGE_ROW_62_1_Left_254 VDD VSS gf180mcu_as_sc_mcu7t3v3__tap_2
X_2946_ VDD VDD VSS VSS _3194_/S _3218_/B _3283_/A gf180mcu_as_sc_mcu7t3v3__nand2_2
X_2877_ VDD VDD VSS VSS _2879_/A _5262_/Q _5263_/Q gf180mcu_as_sc_mcu7t3v3__nor2_2
XFILLER_175_263 VDD VDD VSS VSS gf180mcu_as_sc_mcu7t3v3__fillcap_16
XFILLER_176_786 VDD VDD VSS VSS gf180mcu_as_sc_mcu7t3v3__fillcap_4
XFILLER_176_797 VDD VDD VSS VSS gf180mcu_as_sc_mcu7t3v3__fillcap_8
X_4616_ VDD VDD VSS VSS _5210_/Q _4617_/B _4617_/C _5211_/Q _5210_/D gf180mcu_as_sc_mcu7t3v3__ao22_2
XFILLER_11_1156 VDD VDD VSS VSS gf180mcu_as_sc_mcu7t3v3__fill_2
XFILLER_159_1049 VDD VDD VSS VSS gf180mcu_as_sc_mcu7t3v3__fill_1
X_4547_ VDD VDD VSS VSS _4548_/D _4547_/B _4582_/A gf180mcu_as_sc_mcu7t3v3__nor2_2
X_4478_ VDD VDD VSS VSS _5175_/Q _4548_/B _4478_/C _4478_/D _5175_/D gf180mcu_as_sc_mcu7t3v3__ao211_2
XPHY_EDGE_ROW_145_3_Left_517 VDD VSS gf180mcu_as_sc_mcu7t3v3__tap_2
X_3429_ VDD VDD VSS VSS _3502_/B _4077_/A _3429_/A _3431_/B gf180mcu_as_sc_mcu7t3v3__mux2_2
Xhold1110 VDD VDD VSS VSS _2588_/Y hold1110/Y gf180mcu_as_sc_mcu7t3v3__clkbuff_4
Xhold1121 VDD VDD VSS VSS hold1154/Y _4959_/D gf180mcu_as_sc_mcu7t3v3__clkbuff_4
Xhold1132 VDD VDD VSS VSS _5096_/Q _4258_/C gf180mcu_as_sc_mcu7t3v3__clkbuff_4
XFILLER_161_48 VDD VDD VSS VSS gf180mcu_as_sc_mcu7t3v3__fillcap_16
Xclkbuf_leaf_28_clk_regs VDD VDD VSS VSS clkbuf_3_5__f_clk_regs/Y _5278_/CLK gf180mcu_as_sc_mcu7t3v3__clkbuff_12
Xhold1143 VDD VDD VSS VSS _4952_/Q hold1143/Y gf180mcu_as_sc_mcu7t3v3__clkbuff_4
Xhold1154 VDD VDD VSS VSS _4960_/Q hold1154/Y gf180mcu_as_sc_mcu7t3v3__clkbuff_4
XFILLER_173_6 VDD VDD VSS VSS gf180mcu_as_sc_mcu7t3v3__fillcap_16
XFILLER_96_1342 VDD VDD VSS VSS gf180mcu_as_sc_mcu7t3v3__fillcap_8
XFILLER_57_1326 VDD VDD VSS VSS gf180mcu_as_sc_mcu7t3v3__fillcap_4
XFILLER_144_1307 VDD VDD VSS VSS gf180mcu_as_sc_mcu7t3v3__fillcap_16
XFILLER_13_236 VDD VDD VSS VSS gf180mcu_as_sc_mcu7t3v3__fill_2
XFILLER_9_207 VDD VDD VSS VSS gf180mcu_as_sc_mcu7t3v3__fill_2
XFILLER_181_1080 VDD VDD VSS VSS gf180mcu_as_sc_mcu7t3v3__fill_1
XTAP_TAPCELL_ROW_12_927 VDD VSS gf180mcu_as_sc_mcu7t3v3__tap_2
XTAP_TAPCELL_ROW_12_916 VDD VSS gf180mcu_as_sc_mcu7t3v3__tap_2
XFILLER_166_230 VDD VDD VSS VSS gf180mcu_as_sc_mcu7t3v3__fillcap_4
XFILLER_182_701 VDD VDD VSS VSS gf180mcu_as_sc_mcu7t3v3__fillcap_4
XFILLER_186_34 VDD VDD VSS VSS gf180mcu_as_sc_mcu7t3v3__fill_1
XFILLER_154_414 VDD VDD VSS VSS gf180mcu_as_sc_mcu7t3v3__fill_2
XFILLER_182_734 VDD VDD VSS VSS gf180mcu_as_sc_mcu7t3v3__fill_1
XFILLER_182_745 VDD VDD VSS VSS gf180mcu_as_sc_mcu7t3v3__fillcap_4
XFILLER_182_778 VDD VDD VSS VSS gf180mcu_as_sc_mcu7t3v3__fillcap_16
XFILLER_181_277 VDD VDD VSS VSS gf180mcu_as_sc_mcu7t3v3__fill_2
XPHY_EDGE_ROW_77_3_Left_449 VDD VSS gf180mcu_as_sc_mcu7t3v3__tap_2
XFILLER_163_992 VDD VDD VSS VSS gf180mcu_as_sc_mcu7t3v3__fill_1
XTAP_TAPCELL_ROW_169_1448 VDD VSS gf180mcu_as_sc_mcu7t3v3__tap_2
XFILLER_95_31 VDD VDD VSS VSS gf180mcu_as_sc_mcu7t3v3__fillcap_16
XTAP_TAPCELL_ROW_169_1459 VDD VSS gf180mcu_as_sc_mcu7t3v3__tap_2
XFILLER_118_1291 VDD VDD VSS VSS gf180mcu_as_sc_mcu7t3v3__fill_1
XFILLER_7_1257 VDD VDD VSS VSS gf180mcu_as_sc_mcu7t3v3__fill_2
XTAP_TAPCELL_ROW_186_1784 VDD VSS gf180mcu_as_sc_mcu7t3v3__tap_2
XTAP_TAPCELL_ROW_186_1773 VDD VSS gf180mcu_as_sc_mcu7t3v3__tap_2
X_3780_ VDD VDD VSS VSS _3781_/B _3780_/A _3811_/A _3780_/C gf180mcu_as_sc_mcu7t3v3__ao21_2
X_2800_ VDD VDD VSS VSS _2800_/B _2800_/A _4973_/D gf180mcu_as_sc_mcu7t3v3__and2_2
XFILLER_13_781 VDD VDD VSS VSS gf180mcu_as_sc_mcu7t3v3__fill_1
XFILLER_13_792 VDD VDD VSS VSS gf180mcu_as_sc_mcu7t3v3__fill_2
XFILLER_158_753 VDD VDD VSS VSS gf180mcu_as_sc_mcu7t3v3__fillcap_16
XFILLER_192_509 VDD VDD VSS VSS gf180mcu_as_sc_mcu7t3v3__fill_1
XFILLER_9_730 VDD VDD VSS VSS gf180mcu_as_sc_mcu7t3v3__fillcap_4
X_2731_ VDD VDD VSS VSS _2731_/S _5180_/Q _5172_/Q _2735_/B gf180mcu_as_sc_mcu7t3v3__mux2_2
XFILLER_160_1186 VDD VDD VSS VSS gf180mcu_as_sc_mcu7t3v3__fillcap_16
XTAP_TAPCELL_ROW_140_3_2051 VDD VSS gf180mcu_as_sc_mcu7t3v3__tap_2
XFILLER_172_222 VDD VDD VSS VSS gf180mcu_as_sc_mcu7t3v3__fill_1
XFILLER_173_767 VDD VDD VSS VSS gf180mcu_as_sc_mcu7t3v3__fill_2
X_4401_ VDD VDD VSS VSS _4405_/B _5067_/Q _4456_/S gf180mcu_as_sc_mcu7t3v3__nand2_2
X_2662_ VDD VDD VSS VSS _2662_/D _2701_/A _2666_/B _2662_/C _2663_/C gf180mcu_as_sc_mcu7t3v3__ao31_2
X_2593_ VDD VDD VSS VSS _2731_/S _5099_/Q _2597_/B gf180mcu_as_sc_mcu7t3v3__or2_2
XFILLER_158_1060 VDD VDD VSS VSS gf180mcu_as_sc_mcu7t3v3__fillcap_8
X_4332_ VDD VDD VSS VSS _4332_/D _5270_/Q _5125_/Q _4332_/C _4334_/B gf180mcu_as_sc_mcu7t3v3__ao31_2
X_4263_ VDD VDD VSS VSS _4263_/B _4748_/A _5098_/D gf180mcu_as_sc_mcu7t3v3__and2_2
X_3214_ VDD VDD VSS VSS _3227_/S _3800_/A _3796_/A _3215_/A gf180mcu_as_sc_mcu7t3v3__mux2_2
X_4194_ VDD VDD VSS VSS _4254_/B _4195_/B _4195_/C _5032_/Q _5032_/D gf180mcu_as_sc_mcu7t3v3__ao22_2
X_3145_ VDD VDD VSS VSS _3153_/A _3145_/B _3145_/C _3153_/D _3147_/C gf180mcu_as_sc_mcu7t3v3__ao211_2
XFILLER_132_1299 VDD VDD VSS VSS gf180mcu_as_sc_mcu7t3v3__fillcap_4
XFILLER_54_103 VDD VDD VSS VSS gf180mcu_as_sc_mcu7t3v3__fill_2
X_3076_ VDD VDD VSS VSS _4054_/A _3127_/B _3127_/C _4053_/D _3077_/C gf180mcu_as_sc_mcu7t3v3__ao22_2
XPHY_EDGE_ROW_94_1_Right_603 VDD VSS gf180mcu_as_sc_mcu7t3v3__tap_2
XFILLER_24_27 VDD VDD VSS VSS gf180mcu_as_sc_mcu7t3v3__fillcap_8
X_3978_ VDD VDD VSS VSS _4106_/S _3978_/B _3978_/A _3979_/B gf180mcu_as_sc_mcu7t3v3__mux2_2
XFILLER_10_228 VDD VDD VSS VSS gf180mcu_as_sc_mcu7t3v3__fillcap_16
X_2929_ VDD VDD VSS VSS _3134_/S _3236_/B _3201_/C _3204_/C gf180mcu_as_sc_mcu7t3v3__nand3_2
XFILLER_104_1335 VDD VDD VSS VSS gf180mcu_as_sc_mcu7t3v3__fillcap_4
XFILLER_40_37 VDD VDD VSS VSS gf180mcu_as_sc_mcu7t3v3__fillcap_4
XFILLER_156_37 VDD VDD VSS VSS gf180mcu_as_sc_mcu7t3v3__fillcap_16
XFILLER_3_939 VDD VDD VSS VSS gf180mcu_as_sc_mcu7t3v3__fill_1
XTAP_TAPCELL_ROW_75_3_1986 VDD VSS gf180mcu_as_sc_mcu7t3v3__tap_2
XFILLER_24_1303 VDD VDD VSS VSS gf180mcu_as_sc_mcu7t3v3__fill_2
XFILLER_105_41 VDD VDD VSS VSS gf180mcu_as_sc_mcu7t3v3__fillcap_16
Xfanout753 VDD VDD VSS VSS _2903_/Y _3062_/B gf180mcu_as_sc_mcu7t3v3__buff_12
Xfanout764 VDD VDD VSS VSS _2858_/Y _4749_/B gf180mcu_as_sc_mcu7t3v3__buff_12
Xfanout775 VDD VDD VSS VSS _2909_/Y _3177_/B gf180mcu_as_sc_mcu7t3v3__buff_12
Xfanout786 VDD VDD VSS VSS _2591_/Y _2818_/S gf180mcu_as_sc_mcu7t3v3__buff_12
XTAP_TAPCELL_ROW_6_799 VDD VSS gf180mcu_as_sc_mcu7t3v3__tap_2
XTAP_TAPCELL_ROW_164_1367 VDD VSS gf180mcu_as_sc_mcu7t3v3__tap_2
XTAP_TAPCELL_ROW_164_1356 VDD VSS gf180mcu_as_sc_mcu7t3v3__tap_2
XFILLER_2_1154 VDD VDD VSS VSS gf180mcu_as_sc_mcu7t3v3__fill_1
XTAP_TAPCELL_ROW_181_1681 VDD VSS gf180mcu_as_sc_mcu7t3v3__tap_2
XTAP_TAPCELL_ROW_181_1692 VDD VSS gf180mcu_as_sc_mcu7t3v3__tap_2
XFILLER_121_95 VDD VDD VSS VSS gf180mcu_as_sc_mcu7t3v3__fillcap_8
XFILLER_148_1295 VDD VDD VSS VSS gf180mcu_as_sc_mcu7t3v3__fill_2
XFILLER_183_1164 VDD VDD VSS VSS gf180mcu_as_sc_mcu7t3v3__fill_2
XFILLER_183_1186 VDD VDD VSS VSS gf180mcu_as_sc_mcu7t3v3__fillcap_4
XFILLER_167_550 VDD VDD VSS VSS gf180mcu_as_sc_mcu7t3v3__fill_2
XFILLER_170_726 VDD VDD VSS VSS gf180mcu_as_sc_mcu7t3v3__fillcap_8
XFILLER_182_564 VDD VDD VSS VSS gf180mcu_as_sc_mcu7t3v3__fillcap_4
XFILLER_170_737 VDD VDD VSS VSS gf180mcu_as_sc_mcu7t3v3__fillcap_4
XFILLER_182_597 VDD VDD VSS VSS gf180mcu_as_sc_mcu7t3v3__fillcap_16
XFILLER_5_298 VDD VDD VSS VSS gf180mcu_as_sc_mcu7t3v3__fill_2
XTAP_TAPCELL_ROW_188_1824 VDD VSS gf180mcu_as_sc_mcu7t3v3__tap_2
XTAP_TAPCELL_ROW_188_1813 VDD VSS gf180mcu_as_sc_mcu7t3v3__tap_2
XFILLER_155_1266 VDD VDD VSS VSS gf180mcu_as_sc_mcu7t3v3__fill_2
XFILLER_190_1157 VDD VDD VSS VSS gf180mcu_as_sc_mcu7t3v3__fillcap_16
Xinput8 VDD VDD VSS VSS boot_addr[6] input8/Y gf180mcu_as_sc_mcu7t3v3__buff_12
XFILLER_188_1042 VDD VDD VSS VSS gf180mcu_as_sc_mcu7t3v3__fill_2
X_4950_ VDD VDD VSS VSS _5158_/CLK _4950_/D _4950_/Q gf180mcu_as_sc_mcu7t3v3__dfxtp_2
XFILLER_178_804 VDD VDD VSS VSS gf180mcu_as_sc_mcu7t3v3__fill_1
XFILLER_178_826 VDD VDD VSS VSS gf180mcu_as_sc_mcu7t3v3__fill_2
XFILLER_75_1256 VDD VDD VSS VSS gf180mcu_as_sc_mcu7t3v3__fillcap_4
X_4881_ VDD VDD VSS VSS _4895_/CLK _4881_/D _4881_/Q gf180mcu_as_sc_mcu7t3v3__dfxtp_2
X_3901_ VDD VDD VSS VSS _3905_/B _5159_/Q _4941_/D gf180mcu_as_sc_mcu7t3v3__and2_2
X_3832_ VDD VDD VSS VSS _4752_/C _4910_/Q _4753_/B gf180mcu_as_sc_mcu7t3v3__xnor2_2
X_3763_ VDD VDD VSS VSS _4145_/A _3771_/B _3769_/B _4143_/D _3764_/D gf180mcu_as_sc_mcu7t3v3__ao22_2
XFILLER_158_594 VDD VDD VSS VSS gf180mcu_as_sc_mcu7t3v3__fill_1
X_3694_ VDD VDD VSS VSS _4072_/A _3779_/B _3778_/B _4072_/D _3695_/D gf180mcu_as_sc_mcu7t3v3__ao22_2
X_2714_ VDD VDD VSS VSS _2735_/A _2714_/B _2714_/C _2735_/D _2716_/C gf180mcu_as_sc_mcu7t3v3__ao211_2
XFILLER_173_553 VDD VDD VSS VSS gf180mcu_as_sc_mcu7t3v3__fillcap_4
X_2645_ VDD VDD VSS VSS _4974_/D _5259_/Q _5247_/Q _2646_/B gf180mcu_as_sc_mcu7t3v3__mux2_2
Xoutput334 VDD VDD VSS VSS _4857_/Q east_out[18] gf180mcu_as_sc_mcu7t3v3__buff_12
Xoutput323 VDD VDD VSS VSS _5484_/Y dft_rdata[6] gf180mcu_as_sc_mcu7t3v3__buff_12
XFILLER_160_258 VDD VDD VSS VSS gf180mcu_as_sc_mcu7t3v3__fillcap_4
Xoutput378 VDD VDD VSS VSS _4798_/Q se_out[27] gf180mcu_as_sc_mcu7t3v3__buff_12
Xoutput367 VDD VDD VSS VSS _4788_/Q se_out[17] gf180mcu_as_sc_mcu7t3v3__buff_12
Xoutput356 VDD VDD VSS VSS _4846_/Q east_out[7] gf180mcu_as_sc_mcu7t3v3__buff_12
Xoutput345 VDD VDD VSS VSS _4867_/Q east_out[28] gf180mcu_as_sc_mcu7t3v3__buff_12
X_4315_ VDD VDD VSS VSS _4319_/S _5145_/Q _5144_/Q _5144_/D gf180mcu_as_sc_mcu7t3v3__mux2_2
X_2576_ VDD VDD VSS VSS _2576_/Y _2599_/A _2601_/D gf180mcu_as_sc_mcu7t3v3__nor2_2
Xoutput389 VDD VDD VSS VSS _4777_/Q se_out[6] gf180mcu_as_sc_mcu7t3v3__buff_12
XFILLER_19_38 VDD VDD VSS VSS gf180mcu_as_sc_mcu7t3v3__fill_1
X_4246_ VDD VDD VSS VSS _4246_/S _4246_/B _5082_/Q _5082_/D gf180mcu_as_sc_mcu7t3v3__mux2_2
X_4177_ VDD VDD VSS VSS _4237_/B _4186_/B _4186_/C _5015_/Q _5015_/D gf180mcu_as_sc_mcu7t3v3__ao22_2
X_3128_ VDD VDD VSS VSS _3128_/A _3128_/B _3128_/C _3128_/D _3130_/C gf180mcu_as_sc_mcu7t3v3__ao211_2
XTAP_TAPCELL_ROW_3_747 VDD VSS gf180mcu_as_sc_mcu7t3v3__tap_2
XFILLER_167_1115 VDD VDD VSS VSS gf180mcu_as_sc_mcu7t3v3__fillcap_4
X_4903__1065 VDD VDD VSS VSS _4903_/D gf180mcu_as_sc_mcu7t3v3__tiel_4
X_3059_ VDD VDD VSS VSS _3059_/S _4037_/D _4040_/A _3061_/B gf180mcu_as_sc_mcu7t3v3__mux2_2
XFILLER_169_804 VDD VDD VSS VSS gf180mcu_as_sc_mcu7t3v3__fillcap_8
XFILLER_169_826 VDD VDD VSS VSS gf180mcu_as_sc_mcu7t3v3__fillcap_8
XPHY_EDGE_ROW_95_1_Right_604 VDD VSS gf180mcu_as_sc_mcu7t3v3__tap_2
XFILLER_13_1004 VDD VDD VSS VSS gf180mcu_as_sc_mcu7t3v3__fill_2
XFILLER_164_520 VDD VDD VSS VSS gf180mcu_as_sc_mcu7t3v3__fillcap_4
XFILLER_164_531 VDD VDD VSS VSS gf180mcu_as_sc_mcu7t3v3__fill_2
XFILLER_167_69 VDD VDD VSS VSS gf180mcu_as_sc_mcu7t3v3__fill_1
XFILLER_176_380 VDD VDD VSS VSS gf180mcu_as_sc_mcu7t3v3__fillcap_4
XPHY_EDGE_ROW_25_1_Left_217 VDD VSS gf180mcu_as_sc_mcu7t3v3__tap_2
XFILLER_191_361 VDD VDD VSS VSS gf180mcu_as_sc_mcu7t3v3__fill_2
XFILLER_164_597 VDD VDD VSS VSS gf180mcu_as_sc_mcu7t3v3__fillcap_8
XFILLER_191_383 VDD VDD VSS VSS gf180mcu_as_sc_mcu7t3v3__fillcap_16
Xfanout550 VDD VDD VSS VSS _4127_/C _4086_/C gf180mcu_as_sc_mcu7t3v3__buff_12
XTAP_TAPCELL_ROW_166_1407 VDD VSS gf180mcu_as_sc_mcu7t3v3__tap_2
XFILLER_28_1291 VDD VDD VSS VSS gf180mcu_as_sc_mcu7t3v3__fill_1
Xfanout561 VDD VDD VSS VSS fanout563/A _3664_/B gf180mcu_as_sc_mcu7t3v3__buff_12
Xfanout572 VDD VDD VSS VSS _3278_/Y _3453_/B gf180mcu_as_sc_mcu7t3v3__buff_12
XTAP_TAPCELL_ROW_23_3_1934 VDD VSS gf180mcu_as_sc_mcu7t3v3__tap_2
XTAP_TAPCELL_ROW_183_1732 VDD VSS gf180mcu_as_sc_mcu7t3v3__tap_2
XTAP_TAPCELL_ROW_183_1721 VDD VSS gf180mcu_as_sc_mcu7t3v3__tap_2
XFILLER_115_1272 VDD VDD VSS VSS gf180mcu_as_sc_mcu7t3v3__fillcap_16
XFILLER_4_1227 VDD VDD VSS VSS gf180mcu_as_sc_mcu7t3v3__fillcap_8
Xfanout594 VDD VDD VSS VSS wire597/A _4099_/D gf180mcu_as_sc_mcu7t3v3__buff_12
XFILLER_98_1256 VDD VDD VSS VSS gf180mcu_as_sc_mcu7t3v3__fillcap_4
XFILLER_185_1259 VDD VDD VSS VSS gf180mcu_as_sc_mcu7t3v3__fill_1
XFILLER_92_43 VDD VDD VSS VSS gf180mcu_as_sc_mcu7t3v3__fill_1
XFILLER_159_314 VDD VDD VSS VSS gf180mcu_as_sc_mcu7t3v3__fillcap_16
XFILLER_187_656 VDD VDD VSS VSS gf180mcu_as_sc_mcu7t3v3__fill_2
XFILLER_174_306 VDD VDD VSS VSS gf180mcu_as_sc_mcu7t3v3__fillcap_8
XFILLER_174_317 VDD VDD VSS VSS gf180mcu_as_sc_mcu7t3v3__fillcap_8
XFILLER_186_177 VDD VDD VSS VSS gf180mcu_as_sc_mcu7t3v3__fillcap_16
XFILLER_35_1262 VDD VDD VSS VSS gf180mcu_as_sc_mcu7t3v3__fill_1
XFILLER_157_1317 VDD VDD VSS VSS gf180mcu_as_sc_mcu7t3v3__fillcap_8
XFILLER_192_1219 VDD VDD VSS VSS gf180mcu_as_sc_mcu7t3v3__fill_1
X_2430_ VDD VDD VSS VSS _4003_/A _2430_/A gf180mcu_as_sc_mcu7t3v3__inv_2
XPHY_EDGE_ROW_37_3_Right_78 VDD VSS gf180mcu_as_sc_mcu7t3v3__tap_2
XFILLER_170_567 VDD VDD VSS VSS gf180mcu_as_sc_mcu7t3v3__fillcap_8
X_5080_ VDD VDD VSS VSS _5086_/CLK _5080_/D _5080_/Q gf180mcu_as_sc_mcu7t3v3__dfxtp_2
X_4100_ VDD VDD VSS VSS _4998_/Q _4166_/B _4249_/B _4166_/D _4998_/D gf180mcu_as_sc_mcu7t3v3__ao22_2
XPHY_EDGE_ROW_71_1_Left_263 VDD VSS gf180mcu_as_sc_mcu7t3v3__tap_2
X_4031_ VDD VDD VSS VSS _4031_/A _4101_/C _4031_/C _4031_/D _4033_/C gf180mcu_as_sc_mcu7t3v3__ao211_2
XFILLER_178_601 VDD VDD VSS VSS gf180mcu_as_sc_mcu7t3v3__fill_2
X_4933_ VDD VDD VSS VSS clkload2/A _4933_/D _4933_/Q gf180mcu_as_sc_mcu7t3v3__dfxtp_2
XTAP_TAPCELL_ROW_127_3_2038 VDD VSS gf180mcu_as_sc_mcu7t3v3__tap_2
XANTENNA_13 VDD VDD VSS VSS _3470_/C gf180mcu_as_sc_mcu7t3v3__diode_2
XFILLER_178_678 VDD VDD VSS VSS gf180mcu_as_sc_mcu7t3v3__fillcap_16
X_4864_ VDD VDD VSS VSS _5097_/CLK _4864_/D _4864_/Q gf180mcu_as_sc_mcu7t3v3__dfxtp_2
XANTENNA_24 VDD VDD VSS VSS _4056_/A gf180mcu_as_sc_mcu7t3v3__diode_2
XANTENNA_35 VDD VDD VSS VSS _4059_/B gf180mcu_as_sc_mcu7t3v3__diode_2
XANTENNA_46 VDD VDD VSS VSS _4109_/D gf180mcu_as_sc_mcu7t3v3__diode_2
X_4795_ VDD VDD VSS VSS _5226_/CLK _4795_/D _4795_/Q gf180mcu_as_sc_mcu7t3v3__dfxtp_2
X_3815_ VDD VDD VSS VSS _3929_/B _3914_/B _3914_/A gf180mcu_as_sc_mcu7t3v3__nand2_2
X_3746_ VDD VDD VSS VSS _4124_/A _3803_/B _3746_/C _4862_/D _3775_/D gf180mcu_as_sc_mcu7t3v3__aoi211_2
XFILLER_12_1070 VDD VDD VSS VSS gf180mcu_as_sc_mcu7t3v3__fill_2
X_3677_ VDD VDD VSS VSS _4055_/A _3724_/B _3724_/C _4054_/A _3678_/C gf180mcu_as_sc_mcu7t3v3__ao22_2
X_2628_ VDD VDD VSS VSS _2701_/A _2628_/B input4/Y _2629_/A gf180mcu_as_sc_mcu7t3v3__mux2_2
X_2559_ VDD VDD VSS VSS _2559_/B _4328_/A _4956_/D gf180mcu_as_sc_mcu7t3v3__and2_2
XTAP_TAPCELL_ROW_8_839 VDD VSS gf180mcu_as_sc_mcu7t3v3__tap_2
XFILLER_138_1283 VDD VDD VSS VSS gf180mcu_as_sc_mcu7t3v3__fillcap_4
XFILLER_173_1185 VDD VDD VSS VSS gf180mcu_as_sc_mcu7t3v3__fillcap_4
XFILLER_60_1300 VDD VDD VSS VSS gf180mcu_as_sc_mcu7t3v3__fill_1
X_5278_ VDD VDD VSS VSS _5278_/CLK _5278_/D _5278_/Q gf180mcu_as_sc_mcu7t3v3__dfxtp_2
X_4229_ VDD VDD VSS VSS _4246_/S _4229_/B _5065_/Q _5065_/D gf180mcu_as_sc_mcu7t3v3__mux2_2
XTAP_TAPCELL_ROW_161_1304 VDD VSS gf180mcu_as_sc_mcu7t3v3__tap_2
XPHY_EDGE_ROW_86_3_Left_458 VDD VSS gf180mcu_as_sc_mcu7t3v3__tap_2
XPHY_EDGE_ROW_80_3_Right_121 VDD VSS gf180mcu_as_sc_mcu7t3v3__tap_2
XFILLER_169_623 VDD VDD VSS VSS gf180mcu_as_sc_mcu7t3v3__fillcap_4
XFILLER_168_133 VDD VDD VSS VSS gf180mcu_as_sc_mcu7t3v3__fillcap_16
XFILLER_19_1268 VDD VDD VSS VSS gf180mcu_as_sc_mcu7t3v3__fill_2
XFILLER_58_1295 VDD VDD VSS VSS gf180mcu_as_sc_mcu7t3v3__fill_2
XPHY_EDGE_ROW_96_1_Right_605 VDD VSS gf180mcu_as_sc_mcu7t3v3__tap_2
XFILLER_11_356 VDD VDD VSS VSS gf180mcu_as_sc_mcu7t3v3__fill_1
XFILLER_156_317 VDD VDD VSS VSS gf180mcu_as_sc_mcu7t3v3__fillcap_8
XFILLER_168_177 VDD VDD VSS VSS gf180mcu_as_sc_mcu7t3v3__fillcap_16
XFILLER_169_689 VDD VDD VSS VSS gf180mcu_as_sc_mcu7t3v3__fillcap_8
XFILLER_178_79 VDD VDD VSS VSS gf180mcu_as_sc_mcu7t3v3__fill_1
XFILLER_184_604 VDD VDD VSS VSS gf180mcu_as_sc_mcu7t3v3__fillcap_8
XTAP_TAPCELL_ROW_159_1266 VDD VSS gf180mcu_as_sc_mcu7t3v3__tap_2
XFILLER_168_199 VDD VDD VSS VSS gf180mcu_as_sc_mcu7t3v3__fill_1
XFILLER_184_659 VDD VDD VSS VSS gf180mcu_as_sc_mcu7t3v3__fillcap_4
XTAP_TAPCELL_ROW_176_1591 VDD VSS gf180mcu_as_sc_mcu7t3v3__tap_2
XFILLER_152_534 VDD VDD VSS VSS gf180mcu_as_sc_mcu7t3v3__fillcap_8
XFILLER_164_394 VDD VDD VSS VSS gf180mcu_as_sc_mcu7t3v3__fillcap_8
XFILLER_180_865 VDD VDD VSS VSS gf180mcu_as_sc_mcu7t3v3__fillcap_8
XFILLER_127_72 VDD VDD VSS VSS gf180mcu_as_sc_mcu7t3v3__fill_2
XFILLER_152_1203 VDD VDD VSS VSS gf180mcu_as_sc_mcu7t3v3__fillcap_8
XFILLER_152_1236 VDD VDD VSS VSS gf180mcu_as_sc_mcu7t3v3__fillcap_16
XFILLER_87_65 VDD VDD VSS VSS gf180mcu_as_sc_mcu7t3v3__fillcap_4
XFILLER_189_1192 VDD VDD VSS VSS gf180mcu_as_sc_mcu7t3v3__fill_1
XFILLER_185_1056 VDD VDD VSS VSS gf180mcu_as_sc_mcu7t3v3__fill_1
XFILLER_163_1332 VDD VDD VSS VSS gf180mcu_as_sc_mcu7t3v3__fillcap_16
XFILLER_159_122 VDD VDD VSS VSS gf180mcu_as_sc_mcu7t3v3__fill_2
XFILLER_163_1354 VDD VDD VSS VSS gf180mcu_as_sc_mcu7t3v3__fill_1
XFILLER_187_442 VDD VDD VSS VSS gf180mcu_as_sc_mcu7t3v3__fill_2
XFILLER_159_199 VDD VDD VSS VSS gf180mcu_as_sc_mcu7t3v3__fill_1
XFILLER_175_659 VDD VDD VSS VSS gf180mcu_as_sc_mcu7t3v3__fill_1
Xinput11 VDD VDD VSS VSS boot_addr[9] _2675_/A gf180mcu_as_sc_mcu7t3v3__buff_12
Xinput22 VDD VDD VSS VSS dft_addr[0] _2604_/B gf180mcu_as_sc_mcu7t3v3__buff_12
X_4580_ VDD VDD VSS VSS _4581_/D _4580_/B _4581_/A gf180mcu_as_sc_mcu7t3v3__nor2_2
X_3600_ VDD VDD VSS VSS _3601_/C _3600_/C _3667_/B _3969_/A gf180mcu_as_sc_mcu7t3v3__aoi21_2
XFILLER_7_850 VDD VDD VSS VSS gf180mcu_as_sc_mcu7t3v3__fill_2
Xinput33 VDD VDD VSS VSS dft_ce _2586_/B gf180mcu_as_sc_mcu7t3v3__buff_12
Xinput44 VDD VDD VSS VSS east_in[0] wire866/A gf180mcu_as_sc_mcu7t3v3__buff_12
Xinput55 VDD VDD VSS VSS east_in[1] _3942_/A gf180mcu_as_sc_mcu7t3v3__buff_12
X_3531_ VDD VDD VSS VSS _3551_/A _3807_/B _3531_/A gf180mcu_as_sc_mcu7t3v3__nand2_2
XFILLER_171_810 VDD VDD VSS VSS gf180mcu_as_sc_mcu7t3v3__fill_1
Xinput66 VDD VDD VSS VSS east_in[2] _3951_/A gf180mcu_as_sc_mcu7t3v3__buff_12
Xinput77 VDD VDD VSS VSS east_in[9] _4006_/D gf180mcu_as_sc_mcu7t3v3__buff_12
Xinput88 VDD VDD VSS VSS ne_in[19] _4085_/A gf180mcu_as_sc_mcu7t3v3__buff_12
XFILLER_155_394 VDD VDD VSS VSS gf180mcu_as_sc_mcu7t3v3__fill_1
XFILLER_157_1136 VDD VDD VSS VSS gf180mcu_as_sc_mcu7t3v3__fill_2
Xinput99 VDD VDD VSS VSS ne_in[29] _3791_/A gf180mcu_as_sc_mcu7t3v3__buff_12
Xmax_cap547 VDD VDD VSS VSS _4156_/S _4164_/S gf180mcu_as_sc_mcu7t3v3__clkbuff_12
X_3462_ VDD VDD VSS VSS _3462_/A _3462_/B _3462_/C _3463_/C gf180mcu_as_sc_mcu7t3v3__nor3_2
XFILLER_170_364 VDD VDD VSS VSS gf180mcu_as_sc_mcu7t3v3__fill_1
XFILLER_83_1322 VDD VDD VSS VSS gf180mcu_as_sc_mcu7t3v3__fill_2
X_5201_ VDD VDD VSS VSS _5203_/CLK _5201_/D _5201_/Q gf180mcu_as_sc_mcu7t3v3__dfxtp_2
X_3393_ VDD VDD VSS VSS _4929_/Q _3448_/B _3448_/C _4045_/A _3395_/C gf180mcu_as_sc_mcu7t3v3__ao22_2
X_2413_ VDD VDD VSS VSS _2844_/C _5126_/Q gf180mcu_as_sc_mcu7t3v3__inv_2
X_5132_ VDD VDD VSS VSS _5220_/CLK _5132_/D _5132_/Q gf180mcu_as_sc_mcu7t3v3__dfxtp_2
Xclkbuf_1_0__f_clk VDD VDD VSS VSS clkbuf_0_clk/Y clkbuf_1_0__f_clk/Y gf180mcu_as_sc_mcu7t3v3__clkbuff_12
X_5063_ VDD VDD VSS VSS _5175_/CLK _5063_/D _5063_/Q gf180mcu_as_sc_mcu7t3v3__dfxtp_2
X_4014_ VDD VDD VSS VSS _4014_/A _4102_/B _4102_/C _4925_/Q _4015_/D gf180mcu_as_sc_mcu7t3v3__ao22_2
XPHY_EDGE_ROW_9_Left_202 VDD VSS gf180mcu_as_sc_mcu7t3v3__tap_2
X_4916_ VDD VDD VSS VSS clkload1/A _4916_/D _4916_/Q gf180mcu_as_sc_mcu7t3v3__dfxtp_2
XFILLER_32_27 VDD VDD VSS VSS gf180mcu_as_sc_mcu7t3v3__fillcap_8
X_4847_ VDD VDD VSS VSS _5150_/CLK _4847_/D _4847_/Q gf180mcu_as_sc_mcu7t3v3__dfxtp_2
XFILLER_32_49 VDD VDD VSS VSS gf180mcu_as_sc_mcu7t3v3__fill_2
X_4778_ VDD VDD VSS VSS _5216_/CLK _4778_/D _4778_/Q gf180mcu_as_sc_mcu7t3v3__dfxtp_2
XFILLER_113_8 VDD VDD VSS VSS gf180mcu_as_sc_mcu7t3v3__fill_1
X_3729_ VDD VDD VSS VSS _3730_/C _3729_/C _3729_/B _4105_/A gf180mcu_as_sc_mcu7t3v3__aoi21_2
XTAP_TAPCELL_ROW_154_1174 VDD VSS gf180mcu_as_sc_mcu7t3v3__tap_2
XTAP_TAPCELL_ROW_154_1163 VDD VSS gf180mcu_as_sc_mcu7t3v3__tap_2
XFILLER_88_1288 VDD VDD VSS VSS gf180mcu_as_sc_mcu7t3v3__fill_1
XFILLER_164_37 VDD VDD VSS VSS gf180mcu_as_sc_mcu7t3v3__fillcap_16
XFILLER_175_1258 VDD VDD VSS VSS gf180mcu_as_sc_mcu7t3v3__fill_2
XFILLER_186_1354 VDD VDD VSS VSS gf180mcu_as_sc_mcu7t3v3__fill_1
XFILLER_189_729 VDD VDD VSS VSS gf180mcu_as_sc_mcu7t3v3__fillcap_4
XPHY_EDGE_ROW_81_3_Right_122 VDD VSS gf180mcu_as_sc_mcu7t3v3__tap_2
XTAP_TAPCELL_ROW_178_1631 VDD VSS gf180mcu_as_sc_mcu7t3v3__tap_2
XTAP_TAPCELL_ROW_178_1620 VDD VSS gf180mcu_as_sc_mcu7t3v3__tap_2
XPHY_EDGE_ROW_97_1_Right_606 VDD VSS gf180mcu_as_sc_mcu7t3v3__tap_2
XFILLER_11_142 VDD VDD VSS VSS gf180mcu_as_sc_mcu7t3v3__fill_1
XFILLER_12_687 VDD VDD VSS VSS gf180mcu_as_sc_mcu7t3v3__fillcap_8
XFILLER_184_434 VDD VDD VSS VSS gf180mcu_as_sc_mcu7t3v3__fill_1
XFILLER_184_445 VDD VDD VSS VSS gf180mcu_as_sc_mcu7t3v3__fillcap_8
XFILLER_22_60 VDD VDD VSS VSS gf180mcu_as_sc_mcu7t3v3__fill_2
XFILLER_8_669 VDD VDD VSS VSS gf180mcu_as_sc_mcu7t3v3__fill_1
XFILLER_184_489 VDD VDD VSS VSS gf180mcu_as_sc_mcu7t3v3__fill_2
XTAP_TAPCELL_ROW_191_1875 VDD VSS gf180mcu_as_sc_mcu7t3v3__tap_2
XTAP_TAPCELL_ROW_10_877 VDD VSS gf180mcu_as_sc_mcu7t3v3__tap_2
XFILLER_152_342 VDD VDD VSS VSS gf180mcu_as_sc_mcu7t3v3__fillcap_16
XFILLER_98_31 VDD VDD VSS VSS gf180mcu_as_sc_mcu7t3v3__fillcap_4
XFILLER_98_53 VDD VDD VSS VSS gf180mcu_as_sc_mcu7t3v3__fillcap_4
XTAP_TAPCELL_ROW_10_888 VDD VSS gf180mcu_as_sc_mcu7t3v3__tap_2
XFILLER_3_352 VDD VDD VSS VSS gf180mcu_as_sc_mcu7t3v3__fillcap_4
XFILLER_152_1022 VDD VDD VSS VSS gf180mcu_as_sc_mcu7t3v3__fillcap_8
XFILLER_152_1099 VDD VDD VSS VSS gf180mcu_as_sc_mcu7t3v3__fillcap_16
XFILLER_187_1107 VDD VDD VSS VSS gf180mcu_as_sc_mcu7t3v3__fill_1
X_2962_ VDD VDD VSS VSS _3939_/A _3042_/B _2962_/C _2962_/D _2963_/C gf180mcu_as_sc_mcu7t3v3__ao22_2
XFILLER_128_1282 VDD VDD VSS VSS gf180mcu_as_sc_mcu7t3v3__fillcap_4
X_4701_ VDD VDD VSS VSS _4707_/S _5255_/Q _4701_/A _5255_/D gf180mcu_as_sc_mcu7t3v3__mux2_2
XFILLER_187_294 VDD VDD VSS VSS gf180mcu_as_sc_mcu7t3v3__fill_1
X_4632_ VDD VDD VSS VSS _4683_/C _5120_/Q _4703_/A _5223_/D gf180mcu_as_sc_mcu7t3v3__mux2_2
X_2893_ VDD VDD VSS VSS _3789_/A _3797_/A _3533_/C gf180mcu_as_sc_mcu7t3v3__or2_2
XFILLER_191_905 VDD VDD VSS VSS gf180mcu_as_sc_mcu7t3v3__fillcap_4
XFILLER_163_629 VDD VDD VSS VSS gf180mcu_as_sc_mcu7t3v3__fill_1
X_4563_ VDD VDD VSS VSS _5186_/Q _4590_/B _4563_/C _5104_/Q _4564_/B gf180mcu_as_sc_mcu7t3v3__ao22_2
X_4494_ VDD VDD VSS VSS _4494_/B _4541_/A _4495_/D gf180mcu_as_sc_mcu7t3v3__and2_2
X_3514_ VDD VDD VSS VSS _3515_/D _3514_/C _3523_/B _3514_/A gf180mcu_as_sc_mcu7t3v3__aoi21b_2
X_3445_ VDD VDD VSS VSS _4094_/A _3504_/B _3513_/C _4097_/A _3446_/C gf180mcu_as_sc_mcu7t3v3__ao22_2
X_3376_ VDD VDD VSS VSS _4027_/A _3424_/B _3376_/C _4816_/D _3580_/D gf180mcu_as_sc_mcu7t3v3__aoi211_2
X_5115_ VDD VDD VSS VSS _5188_/CLK _5115_/D _5115_/Q gf180mcu_as_sc_mcu7t3v3__dfxtp_2
X_5046_ VDD VDD VSS VSS _5075_/CLK _5046_/D _5046_/Q gf180mcu_as_sc_mcu7t3v3__dfxtp_2
XPHY_EDGE_ROW_34_1_Left_226 VDD VSS gf180mcu_as_sc_mcu7t3v3__tap_2
XFILLER_13_407 VDD VDD VSS VSS gf180mcu_as_sc_mcu7t3v3__fill_1
XFILLER_168_1084 VDD VDD VSS VSS gf180mcu_as_sc_mcu7t3v3__fill_1
XFILLER_0_1285 VDD VDD VSS VSS gf180mcu_as_sc_mcu7t3v3__fillcap_4
XFILLER_179_740 VDD VDD VSS VSS gf180mcu_as_sc_mcu7t3v3__fill_1
XFILLER_159_26 VDD VDD VSS VSS gf180mcu_as_sc_mcu7t3v3__fill_1
XFILLER_181_1262 VDD VDD VSS VSS gf180mcu_as_sc_mcu7t3v3__fillcap_16
XFILLER_185_209 VDD VDD VSS VSS gf180mcu_as_sc_mcu7t3v3__fill_1
XTAP_TAPCELL_ROW_156_1214 VDD VSS gf180mcu_as_sc_mcu7t3v3__tap_2
XTAP_TAPCELL_ROW_156_1203 VDD VSS gf180mcu_as_sc_mcu7t3v3__tap_2
XFILLER_153_128 VDD VDD VSS VSS gf180mcu_as_sc_mcu7t3v3__fillcap_4
XFILLER_153_139 VDD VDD VSS VSS gf180mcu_as_sc_mcu7t3v3__fill_1
XFILLER_175_1022 VDD VDD VSS VSS gf180mcu_as_sc_mcu7t3v3__fill_2
XFILLER_175_69 VDD VDD VSS VSS gf180mcu_as_sc_mcu7t3v3__fill_1
XFILLER_161_172 VDD VDD VSS VSS gf180mcu_as_sc_mcu7t3v3__fillcap_4
XFILLER_175_1077 VDD VDD VSS VSS gf180mcu_as_sc_mcu7t3v3__fill_2
XFILLER_1_834 VDD VDD VSS VSS gf180mcu_as_sc_mcu7t3v3__fillcap_4
XFILLER_68_34 VDD VDD VSS VSS gf180mcu_as_sc_mcu7t3v3__fill_1
XFILLER_0_344 VDD VDD VSS VSS gf180mcu_as_sc_mcu7t3v3__fill_1
XFILLER_153_1342 VDD VDD VSS VSS gf180mcu_as_sc_mcu7t3v3__fillcap_4
Xinput201 VDD VDD VSS VSS se_in[28] _4163_/A gf180mcu_as_sc_mcu7t3v3__buff_12
XFILLER_191_68 VDD VDD VSS VSS gf180mcu_as_sc_mcu7t3v3__fill_2
Xinput212 VDD VDD VSS VSS se_in[7] wire874/A gf180mcu_as_sc_mcu7t3v3__buff_12
Xinput223 VDD VDD VSS VSS south_in[17] _4072_/D gf180mcu_as_sc_mcu7t3v3__buff_12
Xinput234 VDD VDD VSS VSS south_in[27] _4151_/D gf180mcu_as_sc_mcu7t3v3__buff_12
Xinput245 VDD VDD VSS VSS south_in[6] _3981_/D gf180mcu_as_sc_mcu7t3v3__buff_12
XFILLER_124_51 VDD VDD VSS VSS gf180mcu_as_sc_mcu7t3v3__fillcap_16
Xinput256 VDD VDD VSS VSS sw_in[16] _2438_/A gf180mcu_as_sc_mcu7t3v3__buff_12
Xinput267 VDD VDD VSS VSS sw_in[26] _4148_/A gf180mcu_as_sc_mcu7t3v3__buff_12
Xinput278 VDD VDD VSS VSS sw_in[5] _3978_/A gf180mcu_as_sc_mcu7t3v3__buff_12
XFILLER_124_84 VDD VDD VSS VSS gf180mcu_as_sc_mcu7t3v3__fill_2
Xinput289 VDD VDD VSS VSS west_in[15] _4053_/A gf180mcu_as_sc_mcu7t3v3__buff_12
XFILLER_84_66 VDD VDD VSS VSS gf180mcu_as_sc_mcu7t3v3__fill_1
XPHY_EDGE_ROW_21_1_Right_530 VDD VSS gf180mcu_as_sc_mcu7t3v3__tap_2
XFILLER_140_61 VDD VDD VSS VSS gf180mcu_as_sc_mcu7t3v3__fill_1
XPHY_EDGE_ROW_46_3_Right_87 VDD VSS gf180mcu_as_sc_mcu7t3v3__tap_2
XFILLER_186_1195 VDD VDD VSS VSS gf180mcu_as_sc_mcu7t3v3__fill_2
XFILLER_9_912 VDD VDD VSS VSS gf180mcu_as_sc_mcu7t3v3__fillcap_16
XTAP_TAPCELL_ROW_65_1_1018 VDD VSS gf180mcu_as_sc_mcu7t3v3__tap_2
XPHY_EDGE_ROW_82_3_Right_123 VDD VSS gf180mcu_as_sc_mcu7t3v3__tap_2
XFILLER_12_473 VDD VDD VSS VSS gf180mcu_as_sc_mcu7t3v3__fill_2
XFILLER_9_956 VDD VDD VSS VSS gf180mcu_as_sc_mcu7t3v3__fillcap_16
XPHY_EDGE_ROW_98_1_Right_607 VDD VSS gf180mcu_as_sc_mcu7t3v3__tap_2
XPHY_EDGE_ROW_80_1_Left_272 VDD VSS gf180mcu_as_sc_mcu7t3v3__tap_2
XFILLER_181_982 VDD VDD VSS VSS gf180mcu_as_sc_mcu7t3v3__fill_1
XFILLER_158_1297 VDD VDD VSS VSS gf180mcu_as_sc_mcu7t3v3__fillcap_8
X_3230_ VDD VDD VSS VSS _3241_/B _3514_/A _3230_/A _3231_/C gf180mcu_as_sc_mcu7t3v3__mux2_2
X_3161_ VDD VDD VSS VSS _3178_/A _3161_/B _3161_/C _3178_/D _3163_/C gf180mcu_as_sc_mcu7t3v3__ao211_2
X_3092_ VDD VDD VSS VSS _3187_/B _4932_/Q _3095_/C gf180mcu_as_sc_mcu7t3v3__or2_2
X_3994_ VDD VDD VSS VSS _4106_/S _3994_/B _3994_/A _3995_/B gf180mcu_as_sc_mcu7t3v3__mux2_2
X_2945_ VDD VDD VSS VSS _3218_/B _3283_/A _2945_/Y gf180mcu_as_sc_mcu7t3v3__and2_2
XFILLER_175_231 VDD VDD VSS VSS gf180mcu_as_sc_mcu7t3v3__fillcap_4
X_2876_ VDD VDD VSS VSS _4719_/B _3871_/A _2876_/B _4691_/C gf180mcu_as_sc_mcu7t3v3__ao21_2
XFILLER_15_1260 VDD VDD VSS VSS gf180mcu_as_sc_mcu7t3v3__fill_1
XFILLER_163_404 VDD VDD VSS VSS gf180mcu_as_sc_mcu7t3v3__fillcap_4
X_4615_ VDD VDD VSS VSS _5209_/Q _4617_/B _4617_/C _5210_/Q _5209_/D gf180mcu_as_sc_mcu7t3v3__ao22_2
XFILLER_159_1028 VDD VDD VSS VSS gf180mcu_as_sc_mcu7t3v3__fillcap_8
XFILLER_163_448 VDD VDD VSS VSS gf180mcu_as_sc_mcu7t3v3__fill_1
X_4546_ VDD VDD VSS VSS _4546_/D _4560_/A _4546_/B _4546_/C _4547_/B gf180mcu_as_sc_mcu7t3v3__ao31_2
XFILLER_137_1326 VDD VDD VSS VSS gf180mcu_as_sc_mcu7t3v3__fillcap_4
XFILLER_145_39 VDD VDD VSS VSS gf180mcu_as_sc_mcu7t3v3__fillcap_8
XFILLER_171_492 VDD VDD VSS VSS gf180mcu_as_sc_mcu7t3v3__fill_2
X_4477_ VDD VDD VSS VSS _4478_/D _4477_/B _4589_/A gf180mcu_as_sc_mcu7t3v3__nor2_2
X_3428_ VDD VDD VSS VSS _4077_/D _3500_/B _3428_/C _3428_/D _3429_/A gf180mcu_as_sc_mcu7t3v3__ao211_2
XPHY_EDGE_ROW_95_3_Left_467 VDD VSS gf180mcu_as_sc_mcu7t3v3__tap_2
XPHY_EDGE_ROW_60_1_Right_569 VDD VSS gf180mcu_as_sc_mcu7t3v3__tap_2
X_3359_ VDD VDD VSS VSS _3463_/B _3359_/B _3359_/C _3360_/C gf180mcu_as_sc_mcu7t3v3__nor3_2
XFILLER_38_37 VDD VDD VSS VSS gf180mcu_as_sc_mcu7t3v3__fillcap_4
Xhold1111 VDD VDD VSS VSS hold1144/Y _4964_/D gf180mcu_as_sc_mcu7t3v3__clkbuff_4
Xhold1122 VDD VDD VSS VSS hold1157/Y _4972_/D gf180mcu_as_sc_mcu7t3v3__clkbuff_4
Xhold1133 VDD VDD VSS VSS _5274_/Q _4745_/A gf180mcu_as_sc_mcu7t3v3__clkbuff_4
Xhold1144 VDD VDD VSS VSS _4965_/Q hold1144/Y gf180mcu_as_sc_mcu7t3v3__clkbuff_4
Xhold1155 VDD VDD VSS VSS _4968_/Q hold1155/Y gf180mcu_as_sc_mcu7t3v3__clkbuff_4
X_5029_ VDD VDD VSS VSS clkload9/A _5029_/D _5029_/Q gf180mcu_as_sc_mcu7t3v3__dfxtp_2
XFILLER_166_6 VDD VDD VSS VSS gf180mcu_as_sc_mcu7t3v3__fill_2
XFILLER_96_1354 VDD VDD VSS VSS gf180mcu_as_sc_mcu7t3v3__fill_1
XFILLER_10_900 VDD VDD VSS VSS gf180mcu_as_sc_mcu7t3v3__fillcap_8
XTAP_TAPCELL_ROW_12_928 VDD VSS gf180mcu_as_sc_mcu7t3v3__tap_2
XTAP_TAPCELL_ROW_12_917 VDD VSS gf180mcu_as_sc_mcu7t3v3__tap_2
XFILLER_167_776 VDD VDD VSS VSS gf180mcu_as_sc_mcu7t3v3__fill_2
XFILLER_155_927 VDD VDD VSS VSS gf180mcu_as_sc_mcu7t3v3__fill_1
XTAP_TAPCELL_ROW_126_1_1079 VDD VSS gf180mcu_as_sc_mcu7t3v3__tap_2
XFILLER_163_982 VDD VDD VSS VSS gf180mcu_as_sc_mcu7t3v3__fillcap_8
XFILLER_79_55 VDD VDD VSS VSS gf180mcu_as_sc_mcu7t3v3__fill_1
XFILLER_135_72 VDD VDD VSS VSS gf180mcu_as_sc_mcu7t3v3__fillcap_8
XTAP_TAPCELL_ROW_169_1449 VDD VSS gf180mcu_as_sc_mcu7t3v3__tap_2
XFILLER_188_1202 VDD VDD VSS VSS gf180mcu_as_sc_mcu7t3v3__fill_1
XTAP_TAPCELL_ROW_186_1785 VDD VSS gf180mcu_as_sc_mcu7t3v3__tap_2
XTAP_TAPCELL_ROW_186_1774 VDD VSS gf180mcu_as_sc_mcu7t3v3__tap_2
XFILLER_188_1224 VDD VDD VSS VSS gf180mcu_as_sc_mcu7t3v3__fill_1
XFILLER_40_1331 VDD VDD VSS VSS gf180mcu_as_sc_mcu7t3v3__fillcap_16
XFILLER_28_70 VDD VDD VSS VSS gf180mcu_as_sc_mcu7t3v3__fill_2
XPHY_EDGE_ROW_22_1_Right_531 VDD VSS gf180mcu_as_sc_mcu7t3v3__tap_2
XPHY_EDGE_ROW_83_3_Right_124 VDD VSS gf180mcu_as_sc_mcu7t3v3__tap_2
XFILLER_185_551 VDD VDD VSS VSS gf180mcu_as_sc_mcu7t3v3__fillcap_8
XFILLER_81_6 VDD VDD VSS VSS gf180mcu_as_sc_mcu7t3v3__fill_1
X_2730_ VDD VDD VSS VSS _2730_/A _2730_/B _2730_/C _2730_/D _2730_/Y gf180mcu_as_sc_mcu7t3v3__ao22_2
XFILLER_173_702 VDD VDD VSS VSS gf180mcu_as_sc_mcu7t3v3__fillcap_16
XFILLER_185_562 VDD VDD VSS VSS gf180mcu_as_sc_mcu7t3v3__fillcap_16
X_2661_ VDD VDD VSS VSS _2662_/D _2661_/B _2674_/C gf180mcu_as_sc_mcu7t3v3__nor2_2
XPHY_EDGE_ROW_99_1_Right_608 VDD VSS gf180mcu_as_sc_mcu7t3v3__tap_2
XFILLER_161_908 VDD VDD VSS VSS gf180mcu_as_sc_mcu7t3v3__fill_2
XFILLER_67_4 VDD VDD VSS VSS gf180mcu_as_sc_mcu7t3v3__fill_1
X_4400_ VDD VDD VSS VSS _4400_/B _4541_/A _4407_/C gf180mcu_as_sc_mcu7t3v3__and2_2
X_2592_ VDD VDD VSS VSS _2852_/B _3871_/A _2598_/A gf180mcu_as_sc_mcu7t3v3__and2_2
XFILLER_153_492 VDD VDD VSS VSS gf180mcu_as_sc_mcu7t3v3__fill_2
XFILLER_158_1072 VDD VDD VSS VSS gf180mcu_as_sc_mcu7t3v3__fill_1
X_4331_ VDD VDD VSS VSS _5271_/Q _5126_/Q _4708_/C _4331_/D _4332_/D gf180mcu_as_sc_mcu7t3v3__ao211_2
X_4262_ VDD VDD VSS VSS _4262_/B _4264_/A _4263_/B gf180mcu_as_sc_mcu7t3v3__xnor2_2
XFILLER_84_1291 VDD VDD VSS VSS gf180mcu_as_sc_mcu7t3v3__fillcap_8
X_3213_ VDD VDD VSS VSS _3213_/D _3213_/A _3213_/B _3213_/C _3215_/B gf180mcu_as_sc_mcu7t3v3__ao31_2
XTAP_TAPCELL_ROW_41_3_1952 VDD VSS gf180mcu_as_sc_mcu7t3v3__tap_2
XFILLER_45_1297 VDD VDD VSS VSS gf180mcu_as_sc_mcu7t3v3__fill_2
X_4193_ VDD VDD VSS VSS _4253_/B _4195_/B _4195_/C _5031_/Q _5031_/D gf180mcu_as_sc_mcu7t3v3__ao22_2
XFILLER_132_1256 VDD VDD VSS VSS gf180mcu_as_sc_mcu7t3v3__fillcap_4
X_3144_ VDD VDD VSS VSS _4120_/A _3177_/B _3177_/C _4121_/D _3145_/C gf180mcu_as_sc_mcu7t3v3__ao22_2
X_3075_ VDD VDD VSS VSS _3126_/S _4053_/A _4055_/A _3077_/B gf180mcu_as_sc_mcu7t3v3__mux2_2
X_3977_ VDD VDD VSS VSS _3977_/A _4025_/B _3977_/C _3977_/D _3978_/B gf180mcu_as_sc_mcu7t3v3__ao211_2
X_2928_ VDD VDD VSS VSS _3216_/C _3216_/B _2928_/Y gf180mcu_as_sc_mcu7t3v3__and2_2
XFILLER_164_702 VDD VDD VSS VSS gf180mcu_as_sc_mcu7t3v3__fillcap_8
XFILLER_40_27 VDD VDD VSS VSS gf180mcu_as_sc_mcu7t3v3__fillcap_8
XFILLER_163_212 VDD VDD VSS VSS gf180mcu_as_sc_mcu7t3v3__fillcap_8
XFILLER_164_757 VDD VDD VSS VSS gf180mcu_as_sc_mcu7t3v3__fill_2
X_2859_ VDD VDD VSS VSS _4749_/B _4747_/D _2861_/B gf180mcu_as_sc_mcu7t3v3__and2_2
XFILLER_163_278 VDD VDD VSS VSS gf180mcu_as_sc_mcu7t3v3__fill_2
X_4529_ VDD VDD VSS VSS _4529_/D _4588_/A _4529_/B _4529_/C _4530_/B gf180mcu_as_sc_mcu7t3v3__ao31_2
XFILLER_172_1014 VDD VDD VSS VSS gf180mcu_as_sc_mcu7t3v3__fill_1
XFILLER_160_996 VDD VDD VSS VSS gf180mcu_as_sc_mcu7t3v3__fill_2
XFILLER_172_37 VDD VDD VSS VSS gf180mcu_as_sc_mcu7t3v3__fillcap_16
Xfanout710 VDD VDD VSS VSS _3929_/Y _4152_/C gf180mcu_as_sc_mcu7t3v3__buff_12
Xfanout721 VDD VDD VSS VSS fanout722/A _3386_/D gf180mcu_as_sc_mcu7t3v3__buff_12
Xfanout732 VDD VDD VSS VSS _3128_/A _3045_/A gf180mcu_as_sc_mcu7t3v3__buff_12
X_4890__1078 VDD VDD VSS VSS _4890_/D gf180mcu_as_sc_mcu7t3v3__tiel_4
Xfanout743 VDD VDD VSS VSS _3448_/B _3369_/B gf180mcu_as_sc_mcu7t3v3__buff_12
Xfanout765 VDD VDD VSS VSS _4700_/S _4731_/B gf180mcu_as_sc_mcu7t3v3__buff_12
Xfanout776 VDD VDD VSS VSS _3059_/S _3043_/S gf180mcu_as_sc_mcu7t3v3__buff_12
XFILLER_111_1307 VDD VDD VSS VSS gf180mcu_as_sc_mcu7t3v3__fill_1
Xfanout787 VDD VDD VSS VSS _2852_/B _2673_/B gf180mcu_as_sc_mcu7t3v3__buff_12
Xfanout798 VDD VDD VSS VSS _4273_/S _4272_/S gf180mcu_as_sc_mcu7t3v3__buff_12
XFILLER_45_104 VDD VDD VSS VSS gf180mcu_as_sc_mcu7t3v3__fill_1
XFILLER_6_1291 VDD VDD VSS VSS gf180mcu_as_sc_mcu7t3v3__fillcap_4
XPHY_EDGE_ROW_0_Left_193 VDD VSS gf180mcu_as_sc_mcu7t3v3__tap_2
XTAP_TAPCELL_ROW_164_1368 VDD VSS gf180mcu_as_sc_mcu7t3v3__tap_2
XTAP_TAPCELL_ROW_164_1357 VDD VSS gf180mcu_as_sc_mcu7t3v3__tap_2
XTAP_TAPCELL_ROW_181_1682 VDD VSS gf180mcu_as_sc_mcu7t3v3__tap_2
XTAP_TAPCELL_ROW_145_3_2056 VDD VSS gf180mcu_as_sc_mcu7t3v3__tap_2
XTAP_TAPCELL_ROW_181_1693 VDD VSS gf180mcu_as_sc_mcu7t3v3__tap_2
XFILLER_121_74 VDD VDD VSS VSS gf180mcu_as_sc_mcu7t3v3__fill_1
XFILLER_155_702 VDD VDD VSS VSS gf180mcu_as_sc_mcu7t3v3__fillcap_8
XFILLER_167_562 VDD VDD VSS VSS gf180mcu_as_sc_mcu7t3v3__fillcap_8
XFILLER_10_785 VDD VDD VSS VSS gf180mcu_as_sc_mcu7t3v3__fillcap_4
XFILLER_154_234 VDD VDD VSS VSS gf180mcu_as_sc_mcu7t3v3__fill_1
XFILLER_167_595 VDD VDD VSS VSS gf180mcu_as_sc_mcu7t3v3__fillcap_8
XFILLER_190_1103 VDD VDD VSS VSS gf180mcu_as_sc_mcu7t3v3__fillcap_8
XFILLER_68_1286 VDD VDD VSS VSS gf180mcu_as_sc_mcu7t3v3__fill_2
XPHY_EDGE_ROW_111_1_Left_303 VDD VSS gf180mcu_as_sc_mcu7t3v3__tap_2
XTAP_TAPCELL_ROW_188_1825 VDD VSS gf180mcu_as_sc_mcu7t3v3__tap_2
XTAP_TAPCELL_ROW_188_1814 VDD VSS gf180mcu_as_sc_mcu7t3v3__tap_2
XFILLER_155_1256 VDD VDD VSS VSS gf180mcu_as_sc_mcu7t3v3__fillcap_4
XFILLER_155_1278 VDD VDD VSS VSS gf180mcu_as_sc_mcu7t3v3__fillcap_16
XFILLER_7_1077 VDD VDD VSS VSS gf180mcu_as_sc_mcu7t3v3__fill_2
XFILLER_162_92 VDD VDD VSS VSS gf180mcu_as_sc_mcu7t3v3__fillcap_4
Xinput9 VDD VDD VSS VSS boot_addr[7] input9/Y gf180mcu_as_sc_mcu7t3v3__buff_12
XFILLER_188_1087 VDD VDD VSS VSS gf180mcu_as_sc_mcu7t3v3__fillcap_16
XFILLER_189_142 VDD VDD VSS VSS gf180mcu_as_sc_mcu7t3v3__fillcap_4
X_4880_ VDD VDD VSS VSS _4895_/CLK _4880_/D _4880_/Q gf180mcu_as_sc_mcu7t3v3__dfxtp_2
X_3900_ VDD VDD VSS VSS _3905_/B _5158_/Q _4940_/D gf180mcu_as_sc_mcu7t3v3__and2_2
XPHY_EDGE_ROW_23_1_Right_532 VDD VSS gf180mcu_as_sc_mcu7t3v3__tap_2
XFILLER_162_1227 VDD VDD VSS VSS gf180mcu_as_sc_mcu7t3v3__fillcap_16
X_3831_ VDD VDD VSS VSS _4753_/A _4752_/B _4752_/C _4909_/D gf180mcu_as_sc_mcu7t3v3__nor3_2
X_3762_ VDD VDD VSS VSS _4941_/Q _3770_/B _3770_/C _4144_/A _3764_/C gf180mcu_as_sc_mcu7t3v3__ao22_2
XFILLER_72_2 VDD VDD VSS VSS gf180mcu_as_sc_mcu7t3v3__fillcap_8
XPHY_EDGE_ROW_106_1_Left_298 VDD VSS gf180mcu_as_sc_mcu7t3v3__tap_2
XPHY_EDGE_ROW_84_3_Right_125 VDD VSS gf180mcu_as_sc_mcu7t3v3__tap_2
X_3693_ VDD VDD VSS VSS _4932_/Q _3799_/B _3748_/C _4071_/A _3695_/C gf180mcu_as_sc_mcu7t3v3__ao22_2
X_2713_ VDD VDD VSS VSS _2734_/S _2713_/B _2713_/A _2714_/C gf180mcu_as_sc_mcu7t3v3__mux2_2
X_2644_ VDD VDD VSS VSS _2666_/B _2644_/C _2644_/B _2831_/A gf180mcu_as_sc_mcu7t3v3__aoi21b_2
XFILLER_160_226 VDD VDD VSS VSS gf180mcu_as_sc_mcu7t3v3__fillcap_4
Xoutput335 VDD VDD VSS VSS _4858_/Q east_out[19] gf180mcu_as_sc_mcu7t3v3__buff_12
Xoutput324 VDD VDD VSS VSS _5485_/Y dft_rdata[7] gf180mcu_as_sc_mcu7t3v3__buff_12
X_2575_ VDD VDD VSS VSS _2599_/A _2852_/B _2575_/B _5097_/Q gf180mcu_as_sc_mcu7t3v3__ao21_2
XPHY_EDGE_ROW_43_1_Left_235 VDD VSS gf180mcu_as_sc_mcu7t3v3__tap_2
XFILLER_47_1326 VDD VDD VSS VSS gf180mcu_as_sc_mcu7t3v3__fillcap_4
Xoutput368 VDD VDD VSS VSS _4789_/Q se_out[18] gf180mcu_as_sc_mcu7t3v3__buff_12
Xoutput357 VDD VDD VSS VSS _4847_/Q east_out[8] gf180mcu_as_sc_mcu7t3v3__buff_12
Xoutput346 VDD VDD VSS VSS _4868_/Q east_out[29] gf180mcu_as_sc_mcu7t3v3__buff_12
X_4314_ VDD VDD VSS VSS _4314_/S _5144_/Q _5143_/Q _5143_/D gf180mcu_as_sc_mcu7t3v3__mux2_2
XFILLER_134_1307 VDD VDD VSS VSS gf180mcu_as_sc_mcu7t3v3__fill_2
Xoutput379 VDD VDD VSS VSS _4799_/Q se_out[28] gf180mcu_as_sc_mcu7t3v3__buff_12
X_4245_ VDD VDD VSS VSS _4254_/S _4245_/B _5081_/Q _5081_/D gf180mcu_as_sc_mcu7t3v3__mux2_2
X_4176_ VDD VDD VSS VSS _4236_/B _4197_/B _4197_/C _5014_/Q _5014_/D gf180mcu_as_sc_mcu7t3v3__ao22_2
XFILLER_27_104 VDD VDD VSS VSS gf180mcu_as_sc_mcu7t3v3__fill_1
X_3127_ VDD VDD VSS VSS _4102_/A _3127_/B _3127_/C _4101_/D _3128_/C gf180mcu_as_sc_mcu7t3v3__ao22_2
XTAP_TAPCELL_ROW_3_748 VDD VSS gf180mcu_as_sc_mcu7t3v3__tap_2
X_3058_ VDD VDD VSS VSS _4038_/A _3058_/B _3058_/C _4037_/A _3064_/B gf180mcu_as_sc_mcu7t3v3__ao22_2
XFILLER_169_838 VDD VDD VSS VSS gf180mcu_as_sc_mcu7t3v3__fill_2
XFILLER_168_337 VDD VDD VSS VSS gf180mcu_as_sc_mcu7t3v3__fill_2
XFILLER_184_819 VDD VDD VSS VSS gf180mcu_as_sc_mcu7t3v3__fillcap_16
XFILLER_108_1291 VDD VDD VSS VSS gf180mcu_as_sc_mcu7t3v3__fillcap_8
XFILLER_178_1212 VDD VDD VSS VSS gf180mcu_as_sc_mcu7t3v3__fillcap_8
XFILLER_152_716 VDD VDD VSS VSS gf180mcu_as_sc_mcu7t3v3__fillcap_8
XFILLER_178_1289 VDD VDD VSS VSS gf180mcu_as_sc_mcu7t3v3__fill_2
XFILLER_2_247 VDD VDD VSS VSS gf180mcu_as_sc_mcu7t3v3__fillcap_4
XFILLER_3_759 VDD VDD VSS VSS gf180mcu_as_sc_mcu7t3v3__fill_1
XFILLER_160_771 VDD VDD VSS VSS gf180mcu_as_sc_mcu7t3v3__fillcap_4
XPHY_EDGE_ROW_55_3_Right_96 VDD VSS gf180mcu_as_sc_mcu7t3v3__tap_2
Xfanout540 VDD VDD VSS VSS _4333_/Y _4592_/B gf180mcu_as_sc_mcu7t3v3__buff_12
Xfanout551 VDD VDD VSS VSS fanout551/A _4127_/C gf180mcu_as_sc_mcu7t3v3__buff_12
XTAP_TAPCELL_ROW_166_1408 VDD VSS gf180mcu_as_sc_mcu7t3v3__tap_2
Xfanout573 VDD VDD VSS VSS _3278_/Y _3504_/B gf180mcu_as_sc_mcu7t3v3__buff_12
Xfanout584 VDD VDD VSS VSS _2945_/Y _3182_/B gf180mcu_as_sc_mcu7t3v3__buff_12
XTAP_TAPCELL_ROW_183_1722 VDD VSS gf180mcu_as_sc_mcu7t3v3__tap_2
XFILLER_189_1352 VDD VDD VSS VSS gf180mcu_as_sc_mcu7t3v3__fill_2
Xfanout595 VDD VDD VSS VSS wire597/A _4141_/D gf180mcu_as_sc_mcu7t3v3__buff_12
Xclkbuf_leaf_12_clk_regs VDD VDD VSS VSS clkbuf_3_3__f_clk_regs/Y _5158_/CLK gf180mcu_as_sc_mcu7t3v3__clkbuff_12
XFILLER_92_55 VDD VDD VSS VSS gf180mcu_as_sc_mcu7t3v3__fillcap_16
XFILLER_186_101 VDD VDD VSS VSS gf180mcu_as_sc_mcu7t3v3__fillcap_4
XFILLER_187_624 VDD VDD VSS VSS gf180mcu_as_sc_mcu7t3v3__fillcap_4
XFILLER_92_99 VDD VDD VSS VSS gf180mcu_as_sc_mcu7t3v3__fillcap_4
XFILLER_186_123 VDD VDD VSS VSS gf180mcu_as_sc_mcu7t3v3__fillcap_8
XFILLER_186_145 VDD VDD VSS VSS gf180mcu_as_sc_mcu7t3v3__fillcap_8
XFILLER_25_93 VDD VDD VSS VSS gf180mcu_as_sc_mcu7t3v3__fillcap_8
XFILLER_155_532 VDD VDD VSS VSS gf180mcu_as_sc_mcu7t3v3__fill_2
XFILLER_122_1288 VDD VDD VSS VSS gf180mcu_as_sc_mcu7t3v3__fill_1
XFILLER_6_531 VDD VDD VSS VSS gf180mcu_as_sc_mcu7t3v3__fill_2
XFILLER_157_1329 VDD VDD VSS VSS gf180mcu_as_sc_mcu7t3v3__fill_1
XFILLER_170_524 VDD VDD VSS VSS gf180mcu_as_sc_mcu7t3v3__fill_1
XFILLER_6_597 VDD VDD VSS VSS gf180mcu_as_sc_mcu7t3v3__fill_1
XFILLER_9_1117 VDD VDD VSS VSS gf180mcu_as_sc_mcu7t3v3__fill_2
XFILLER_2_781 VDD VDD VSS VSS gf180mcu_as_sc_mcu7t3v3__fill_2
XFILLER_9_1139 VDD VDD VSS VSS gf180mcu_as_sc_mcu7t3v3__fill_2
XFILLER_2_53 VDD VDD VSS VSS gf180mcu_as_sc_mcu7t3v3__fill_1
XPHY_EDGE_ROW_10_Right_10 VDD VSS gf180mcu_as_sc_mcu7t3v3__tap_2
X_4030_ VDD VDD VSS VSS _4030_/A _4101_/B _4103_/B _4030_/D _4031_/D gf180mcu_as_sc_mcu7t3v3__ao22_2
XFILLER_42_1256 VDD VDD VSS VSS gf180mcu_as_sc_mcu7t3v3__fillcap_4
XFILLER_77_1319 VDD VDD VSS VSS gf180mcu_as_sc_mcu7t3v3__fillcap_4
X_4932_ VDD VDD VSS VSS clkload2/A _4932_/D _4932_/Q gf180mcu_as_sc_mcu7t3v3__dfxtp_2
XFILLER_162_1002 VDD VDD VSS VSS gf180mcu_as_sc_mcu7t3v3__fillcap_8
XANTENNA_14 VDD VDD VSS VSS _3505_/B gf180mcu_as_sc_mcu7t3v3__diode_2
X_4863_ VDD VDD VSS VSS _5097_/CLK _4863_/D _4863_/Q gf180mcu_as_sc_mcu7t3v3__dfxtp_2
XPHY_EDGE_ROW_24_1_Right_533 VDD VSS gf180mcu_as_sc_mcu7t3v3__tap_2
XANTENNA_25 VDD VDD VSS VSS _4118_/D gf180mcu_as_sc_mcu7t3v3__diode_2
XANTENNA_36 VDD VDD VSS VSS _4059_/B gf180mcu_as_sc_mcu7t3v3__diode_2
XANTENNA_47 VDD VDD VSS VSS _4151_/A gf180mcu_as_sc_mcu7t3v3__diode_2
XFILLER_162_1079 VDD VDD VSS VSS gf180mcu_as_sc_mcu7t3v3__fillcap_4
XFILLER_192_104 VDD VDD VSS VSS gf180mcu_as_sc_mcu7t3v3__fillcap_4
X_4794_ VDD VDD VSS VSS _5226_/CLK _4794_/D _4794_/Q gf180mcu_as_sc_mcu7t3v3__dfxtp_2
X_3814_ VDD VDD VSS VSS _3814_/B _3814_/A _3920_/B gf180mcu_as_sc_mcu7t3v3__or2_2
X_3745_ VDD VDD VSS VSS _3746_/C _3745_/C _3745_/B _4122_/A gf180mcu_as_sc_mcu7t3v3__aoi21_2
XPHY_EDGE_ROW_85_3_Right_126 VDD VSS gf180mcu_as_sc_mcu7t3v3__tap_2
XFILLER_173_362 VDD VDD VSS VSS gf180mcu_as_sc_mcu7t3v3__fill_1
X_3676_ VDD VDD VSS VSS _3676_/A _3731_/B _3676_/C _4853_/D _3676_/D gf180mcu_as_sc_mcu7t3v3__aoi211_2
XTAP_TAPCELL_ROW_28_3_1939 VDD VSS gf180mcu_as_sc_mcu7t3v3__tap_2
X_2627_ VDD VDD VSS VSS _2627_/D _4262_/B _2627_/B _2627_/C _2628_/B gf180mcu_as_sc_mcu7t3v3__ao31_2
X_2558_ VDD VDD VSS VSS _2558_/D _2558_/A _2558_/B _2558_/C _2559_/B gf180mcu_as_sc_mcu7t3v3__ao31_2
XFILLER_153_39 VDD VDD VSS VSS gf180mcu_as_sc_mcu7t3v3__fillcap_8
X_5277_ VDD VDD VSS VSS _5277_/CLK _5277_/D _5277_/Q gf180mcu_as_sc_mcu7t3v3__dfxtp_2
X_2489_ VDD VDD VSS VSS _4594_/A _4329_/A _4719_/A gf180mcu_as_sc_mcu7t3v3__nand2_2
X_4228_ VDD VDD VSS VSS _4257_/B _4228_/B _4228_/C _5064_/Q _5064_/D gf180mcu_as_sc_mcu7t3v3__ao22_2
XFILLER_46_48 VDD VDD VSS VSS gf180mcu_as_sc_mcu7t3v3__fillcap_4
X_4159_ VDD VDD VSS VSS _4159_/A _4159_/B _4159_/C _4159_/D _4161_/C gf180mcu_as_sc_mcu7t3v3__ao22_2
XTAP_TAPCELL_ROW_161_1305 VDD VSS gf180mcu_as_sc_mcu7t3v3__tap_2
XFILLER_102_32 VDD VDD VSS VSS gf180mcu_as_sc_mcu7t3v3__fill_2
XFILLER_169_646 VDD VDD VSS VSS gf180mcu_as_sc_mcu7t3v3__fill_1
XFILLER_11_346 VDD VDD VSS VSS gf180mcu_as_sc_mcu7t3v3__fillcap_4
XFILLER_178_69 VDD VDD VSS VSS gf180mcu_as_sc_mcu7t3v3__fillcap_8
XFILLER_180_1157 VDD VDD VSS VSS gf180mcu_as_sc_mcu7t3v3__fillcap_16
XFILLER_8_807 VDD VDD VSS VSS gf180mcu_as_sc_mcu7t3v3__fillcap_4
XTAP_TAPCELL_ROW_159_1267 VDD VSS gf180mcu_as_sc_mcu7t3v3__tap_2
XFILLER_11_368 VDD VDD VSS VSS gf180mcu_as_sc_mcu7t3v3__fill_2
XTAP_TAPCELL_ROW_176_1581 VDD VSS gf180mcu_as_sc_mcu7t3v3__tap_2
XFILLER_164_340 VDD VDD VSS VSS gf180mcu_as_sc_mcu7t3v3__fillcap_8
XFILLER_165_874 VDD VDD VSS VSS gf180mcu_as_sc_mcu7t3v3__fill_2
XTAP_TAPCELL_ROW_176_1592 VDD VSS gf180mcu_as_sc_mcu7t3v3__tap_2
XFILLER_164_373 VDD VDD VSS VSS gf180mcu_as_sc_mcu7t3v3__fill_1
XFILLER_180_811 VDD VDD VSS VSS gf180mcu_as_sc_mcu7t3v3__fill_2
XFILLER_180_833 VDD VDD VSS VSS gf180mcu_as_sc_mcu7t3v3__fillcap_16
XFILLER_192_671 VDD VDD VSS VSS gf180mcu_as_sc_mcu7t3v3__fill_2
XFILLER_192_682 VDD VDD VSS VSS gf180mcu_as_sc_mcu7t3v3__fillcap_4
XFILLER_152_546 VDD VDD VSS VSS gf180mcu_as_sc_mcu7t3v3__fillcap_16
XFILLER_3_523 VDD VDD VSS VSS gf180mcu_as_sc_mcu7t3v3__fillcap_4
XFILLER_11_95 VDD VDD VSS VSS gf180mcu_as_sc_mcu7t3v3__fillcap_4
XFILLER_127_62 VDD VDD VSS VSS gf180mcu_as_sc_mcu7t3v3__fill_1
XFILLER_180_877 VDD VDD VSS VSS gf180mcu_as_sc_mcu7t3v3__fillcap_16
XFILLER_191_1242 VDD VDD VSS VSS gf180mcu_as_sc_mcu7t3v3__fillcap_16
XFILLER_2_2 VDD VDD VSS VSS gf180mcu_as_sc_mcu7t3v3__fillcap_16
XFILLER_152_1226 VDD VDD VSS VSS gf180mcu_as_sc_mcu7t3v3__fill_2
XFILLER_160_590 VDD VDD VSS VSS gf180mcu_as_sc_mcu7t3v3__fillcap_4
XFILLER_65_1256 VDD VDD VSS VSS gf180mcu_as_sc_mcu7t3v3__fillcap_8
XFILLER_143_72 VDD VDD VSS VSS gf180mcu_as_sc_mcu7t3v3__fill_2
XFILLER_188_922 VDD VDD VSS VSS gf180mcu_as_sc_mcu7t3v3__fillcap_4
XPHY_EDGE_ROW_151_1_Right_660 VDD VSS gf180mcu_as_sc_mcu7t3v3__tap_2
XFILLER_188_944 VDD VDD VSS VSS gf180mcu_as_sc_mcu7t3v3__fill_1
XFILLER_187_487 VDD VDD VSS VSS gf180mcu_as_sc_mcu7t3v3__fill_2
XFILLER_174_104 VDD VDD VSS VSS gf180mcu_as_sc_mcu7t3v3__fill_1
Xinput12 VDD VDD VSS VSS boot_data[0] _2685_/A gf180mcu_as_sc_mcu7t3v3__buff_12
XFILLER_11_880 VDD VDD VSS VSS gf180mcu_as_sc_mcu7t3v3__fillcap_4
XFILLER_156_874 VDD VDD VSS VSS gf180mcu_as_sc_mcu7t3v3__fill_1
XFILLER_161_1090 VDD VDD VSS VSS gf180mcu_as_sc_mcu7t3v3__fill_2
Xinput23 VDD VDD VSS VSS dft_addr[10] _2583_/B gf180mcu_as_sc_mcu7t3v3__buff_12
Xinput34 VDD VDD VSS VSS dft_mode _2565_/A gf180mcu_as_sc_mcu7t3v3__buff_12
Xinput45 VDD VDD VSS VSS east_in[10] _4015_/A gf180mcu_as_sc_mcu7t3v3__buff_12
X_3530_ VDD VDD VSS VSS _3530_/B _3530_/A _3807_/B gf180mcu_as_sc_mcu7t3v3__and2_2
Xinput56 VDD VDD VSS VSS east_in[20] wire862/A gf180mcu_as_sc_mcu7t3v3__buff_12
Xinput67 VDD VDD VSS VSS east_in[30] wire857/A gf180mcu_as_sc_mcu7t3v3__buff_12
Xinput78 VDD VDD VSS VSS ne_in[0] _3925_/A gf180mcu_as_sc_mcu7t3v3__buff_12
Xinput89 VDD VDD VSS VSS ne_in[1] wire851/A gf180mcu_as_sc_mcu7t3v3__buff_12
Xwire793 VDD VDD VSS VSS _5484_/A _4706_/A gf180mcu_as_sc_mcu7t3v3__clkbuff_12
XFILLER_157_1126 VDD VDD VSS VSS gf180mcu_as_sc_mcu7t3v3__fill_2
X_3461_ VDD VDD VSS VSS _4110_/A _3504_/B _3513_/C _4114_/A _3462_/C gf180mcu_as_sc_mcu7t3v3__ao22_2
XFILLER_170_376 VDD VDD VSS VSS gf180mcu_as_sc_mcu7t3v3__fillcap_8
X_5200_ VDD VDD VSS VSS _5203_/CLK _5200_/D _5200_/Q gf180mcu_as_sc_mcu7t3v3__dfxtp_2
X_3392_ VDD VDD VSS VSS _4043_/A _3424_/B _3392_/C _4818_/D _3580_/D gf180mcu_as_sc_mcu7t3v3__aoi211_2
X_2412_ VDD VDD VSS VSS _2511_/C _5257_/Q gf180mcu_as_sc_mcu7t3v3__inv_2
XFILLER_170_387 VDD VDD VSS VSS gf180mcu_as_sc_mcu7t3v3__fillcap_8
XFILLER_35_2 VDD VDD VSS VSS gf180mcu_as_sc_mcu7t3v3__fillcap_4
X_5131_ VDD VDD VSS VSS _5216_/CLK _5131_/D _5131_/Q gf180mcu_as_sc_mcu7t3v3__dfxtp_2
X_5062_ VDD VDD VSS VSS _5175_/CLK _5062_/D _5062_/Q gf180mcu_as_sc_mcu7t3v3__dfxtp_2
X_4013_ VDD VDD VSS VSS _4013_/A _4101_/B _4101_/C _4013_/D _4015_/C gf180mcu_as_sc_mcu7t3v3__ao22_2
XFILLER_168_1200 VDD VDD VSS VSS gf180mcu_as_sc_mcu7t3v3__fillcap_8
XFILLER_168_1288 VDD VDD VSS VSS gf180mcu_as_sc_mcu7t3v3__fillcap_4
XTAP_TAPCELL_ROW_83_1_1036 VDD VSS gf180mcu_as_sc_mcu7t3v3__tap_2
XFILLER_179_944 VDD VDD VSS VSS gf180mcu_as_sc_mcu7t3v3__fillcap_16
X_4915_ VDD VDD VSS VSS clkload1/A _4915_/D _4915_/Q gf180mcu_as_sc_mcu7t3v3__dfxtp_2
XFILLER_166_616 VDD VDD VSS VSS gf180mcu_as_sc_mcu7t3v3__fill_2
XFILLER_178_454 VDD VDD VSS VSS gf180mcu_as_sc_mcu7t3v3__fill_1
X_4846_ VDD VDD VSS VSS _5220_/CLK _4846_/D _4846_/Q gf180mcu_as_sc_mcu7t3v3__dfxtp_2
XPHY_EDGE_ROW_25_1_Right_534 VDD VSS gf180mcu_as_sc_mcu7t3v3__tap_2
X_4777_ VDD VDD VSS VSS _5220_/CLK _4777_/D _4777_/Q gf180mcu_as_sc_mcu7t3v3__dfxtp_2
XFILLER_162_800 VDD VDD VSS VSS gf180mcu_as_sc_mcu7t3v3__fillcap_4
XFILLER_174_671 VDD VDD VSS VSS gf180mcu_as_sc_mcu7t3v3__fill_2
XFILLER_175_1204 VDD VDD VSS VSS gf180mcu_as_sc_mcu7t3v3__fill_2
XFILLER_180_107 VDD VDD VSS VSS gf180mcu_as_sc_mcu7t3v3__fillcap_4
XFILLER_88_1256 VDD VDD VSS VSS gf180mcu_as_sc_mcu7t3v3__fillcap_8
X_3728_ VDD VDD VSS VSS _3728_/D _4104_/D _3728_/B _3728_/C _3729_/C gf180mcu_as_sc_mcu7t3v3__ao31_2
XTAP_TAPCELL_ROW_154_1164 VDD VSS gf180mcu_as_sc_mcu7t3v3__tap_2
XPHY_EDGE_ROW_86_3_Right_127 VDD VSS gf180mcu_as_sc_mcu7t3v3__tap_2
XFILLER_161_343 VDD VDD VSS VSS gf180mcu_as_sc_mcu7t3v3__fillcap_4
XFILLER_162_844 VDD VDD VSS VSS gf180mcu_as_sc_mcu7t3v3__fillcap_8
X_3659_ VDD VDD VSS VSS _4032_/A _3726_/B _3659_/C _3731_/B _3660_/C gf180mcu_as_sc_mcu7t3v3__ao211_2
XTAP_TAPCELL_ROW_154_1175 VDD VSS gf180mcu_as_sc_mcu7t3v3__tap_2
XFILLER_162_877 VDD VDD VSS VSS gf180mcu_as_sc_mcu7t3v3__fillcap_16
XFILLER_180_37 VDD VDD VSS VSS gf180mcu_as_sc_mcu7t3v3__fillcap_16
XFILLER_5_1323 VDD VDD VSS VSS gf180mcu_as_sc_mcu7t3v3__fillcap_4
XFILLER_25_1295 VDD VDD VSS VSS gf180mcu_as_sc_mcu7t3v3__fill_2
XFILLER_147_1317 VDD VDD VSS VSS gf180mcu_as_sc_mcu7t3v3__fillcap_4
XFILLER_188_218 VDD VDD VSS VSS gf180mcu_as_sc_mcu7t3v3__fill_2
XTAP_TAPCELL_ROW_178_1632 VDD VSS gf180mcu_as_sc_mcu7t3v3__tap_2
XTAP_TAPCELL_ROW_178_1621 VDD VSS gf180mcu_as_sc_mcu7t3v3__tap_2
XPHY_EDGE_ROW_120_1_Left_312 VDD VSS gf180mcu_as_sc_mcu7t3v3__tap_2
XFILLER_169_454 VDD VDD VSS VSS gf180mcu_as_sc_mcu7t3v3__fillcap_16
XFILLER_169_487 VDD VDD VSS VSS gf180mcu_as_sc_mcu7t3v3__fill_2
XFILLER_11_187 VDD VDD VSS VSS gf180mcu_as_sc_mcu7t3v3__fillcap_8
XFILLER_172_608 VDD VDD VSS VSS gf180mcu_as_sc_mcu7t3v3__fill_2
XFILLER_184_457 VDD VDD VSS VSS gf180mcu_as_sc_mcu7t3v3__fillcap_16
XTAP_TAPCELL_ROW_191_1876 VDD VSS gf180mcu_as_sc_mcu7t3v3__tap_2
XTAP_TAPCELL_ROW_10_878 VDD VSS gf180mcu_as_sc_mcu7t3v3__tap_2
XTAP_TAPCELL_ROW_10_889 VDD VSS gf180mcu_as_sc_mcu7t3v3__tap_2
XFILLER_152_376 VDD VDD VSS VSS gf180mcu_as_sc_mcu7t3v3__fillcap_4
XFILLER_153_899 VDD VDD VSS VSS gf180mcu_as_sc_mcu7t3v3__fillcap_8
XFILLER_152_1056 VDD VDD VSS VSS gf180mcu_as_sc_mcu7t3v3__fillcap_16
XPHY_EDGE_ROW_18_3_Right_59 VDD VSS gf180mcu_as_sc_mcu7t3v3__tap_2
XFILLER_170_81 VDD VDD VSS VSS gf180mcu_as_sc_mcu7t3v3__fillcap_8
XFILLER_179_218 VDD VDD VSS VSS gf180mcu_as_sc_mcu7t3v3__fill_1
XPHY_EDGE_ROW_52_1_Left_244 VDD VSS gf180mcu_as_sc_mcu7t3v3__tap_2
XFILLER_188_741 VDD VDD VSS VSS gf180mcu_as_sc_mcu7t3v3__fill_2
X_2961_ VDD VDD VSS VSS _3045_/A _2961_/B _2961_/C _3045_/D _2962_/D gf180mcu_as_sc_mcu7t3v3__ao211_2
X_4700_ VDD VDD VSS VSS _4700_/S _5483_/A _5256_/Q _4701_/A gf180mcu_as_sc_mcu7t3v3__mux2_2
XFILLER_147_104 VDD VDD VSS VSS gf180mcu_as_sc_mcu7t3v3__fill_1
XFILLER_163_1185 VDD VDD VSS VSS gf180mcu_as_sc_mcu7t3v3__fillcap_4
XFILLER_176_947 VDD VDD VSS VSS gf180mcu_as_sc_mcu7t3v3__fillcap_4
X_4631_ VDD VDD VSS VSS _4683_/C _5119_/Q _5222_/Q _5222_/D gf180mcu_as_sc_mcu7t3v3__mux2_2
X_2892_ VDD VDD VSS VSS _3812_/A _3789_/A _3797_/A gf180mcu_as_sc_mcu7t3v3__nor2_2
XFILLER_175_468 VDD VDD VSS VSS gf180mcu_as_sc_mcu7t3v3__fillcap_16
XTAP_TAPCELL_ROW_144_1_1097 VDD VSS gf180mcu_as_sc_mcu7t3v3__tap_2
XFILLER_11_1328 VDD VDD VSS VSS gf180mcu_as_sc_mcu7t3v3__fill_2
XFILLER_162_107 VDD VDD VSS VSS gf180mcu_as_sc_mcu7t3v3__fill_2
X_4562_ VDD VDD VSS VSS _4565_/C _4562_/B _4582_/A gf180mcu_as_sc_mcu7t3v3__nor2_2
X_4493_ VDD VDD VSS VSS _5178_/Q _4493_/B _4523_/C _5112_/Q _4494_/B gf180mcu_as_sc_mcu7t3v3__ao22_2
X_3513_ VDD VDD VSS VSS _3513_/A _3522_/B _3513_/C _3514_/C _3513_/D gf180mcu_as_sc_mcu7t3v3__aoi211_2
XPHY_EDGE_ROW_135_3_Left_507 VDD VSS gf180mcu_as_sc_mcu7t3v3__tap_2
X_3444_ VDD VDD VSS VSS _3467_/B _4093_/A _3444_/A _3446_/B gf180mcu_as_sc_mcu7t3v3__mux2_2
XFILLER_171_696 VDD VDD VSS VSS gf180mcu_as_sc_mcu7t3v3__fillcap_4
XFILLER_170_195 VDD VDD VSS VSS gf180mcu_as_sc_mcu7t3v3__fill_1
XFILLER_174_1292 VDD VDD VSS VSS gf180mcu_as_sc_mcu7t3v3__fill_2
X_3375_ VDD VDD VSS VSS _3432_/B _3375_/B _3375_/C _3376_/C gf180mcu_as_sc_mcu7t3v3__nor3_2
XFILLER_170_1145 VDD VDD VSS VSS gf180mcu_as_sc_mcu7t3v3__fillcap_8
X_5114_ VDD VDD VSS VSS _5188_/CLK _5114_/D _5114_/Q gf180mcu_as_sc_mcu7t3v3__dfxtp_2
X_5045_ VDD VDD VSS VSS clkload9/A _5045_/D _5045_/Q gf180mcu_as_sc_mcu7t3v3__dfxtp_2
XFILLER_43_27 VDD VDD VSS VSS gf180mcu_as_sc_mcu7t3v3__fillcap_4
XFILLER_179_752 VDD VDD VSS VSS gf180mcu_as_sc_mcu7t3v3__fill_1
XFILLER_159_49 VDD VDD VSS VSS gf180mcu_as_sc_mcu7t3v3__fillcap_8
XFILLER_167_958 VDD VDD VSS VSS gf180mcu_as_sc_mcu7t3v3__fill_1
XFILLER_178_273 VDD VDD VSS VSS gf180mcu_as_sc_mcu7t3v3__fillcap_16
XTAP_TAPCELL_ROW_156_1215 VDD VSS gf180mcu_as_sc_mcu7t3v3__tap_2
XTAP_TAPCELL_ROW_156_1204 VDD VSS gf180mcu_as_sc_mcu7t3v3__tap_2
XFILLER_166_457 VDD VDD VSS VSS gf180mcu_as_sc_mcu7t3v3__fillcap_4
X_4829_ VDD VDD VSS VSS clkload7/A _4829_/D _4829_/Q gf180mcu_as_sc_mcu7t3v3__dfxtp_2
XPHY_EDGE_ROW_26_1_Right_535 VDD VSS gf180mcu_as_sc_mcu7t3v3__tap_2
XTAP_TAPCELL_ROW_173_1540 VDD VSS gf180mcu_as_sc_mcu7t3v3__tap_2
XPHY_EDGE_ROW_67_3_Left_439 VDD VSS gf180mcu_as_sc_mcu7t3v3__tap_2
XFILLER_181_438 VDD VDD VSS VSS gf180mcu_as_sc_mcu7t3v3__fillcap_16
XPHY_EDGE_ROW_87_3_Right_128 VDD VSS gf180mcu_as_sc_mcu7t3v3__tap_2
XFILLER_108_31 VDD VDD VSS VSS gf180mcu_as_sc_mcu7t3v3__fillcap_4
XFILLER_108_53 VDD VDD VSS VSS gf180mcu_as_sc_mcu7t3v3__fillcap_4
XFILLER_179_1192 VDD VDD VSS VSS gf180mcu_as_sc_mcu7t3v3__fill_1
XFILLER_1_802 VDD VDD VSS VSS gf180mcu_as_sc_mcu7t3v3__fillcap_16
XFILLER_0_312 VDD VDD VSS VSS gf180mcu_as_sc_mcu7t3v3__fill_2
XFILLER_162_696 VDD VDD VSS VSS gf180mcu_as_sc_mcu7t3v3__fillcap_8
XFILLER_153_1332 VDD VDD VSS VSS gf180mcu_as_sc_mcu7t3v3__fill_2
XFILLER_161_195 VDD VDD VSS VSS gf180mcu_as_sc_mcu7t3v3__fillcap_4
Xinput202 VDD VDD VSS VSS se_in[29] _3793_/A gf180mcu_as_sc_mcu7t3v3__buff_12
Xinput213 VDD VDD VSS VSS se_in[8] _4001_/A gf180mcu_as_sc_mcu7t3v3__buff_12
Xinput224 VDD VDD VSS VSS south_in[18] _4080_/D gf180mcu_as_sc_mcu7t3v3__buff_12
Xinput235 VDD VDD VSS VSS south_in[28] _4159_/D gf180mcu_as_sc_mcu7t3v3__buff_12
Xinput246 VDD VDD VSS VSS south_in[7] _3989_/D gf180mcu_as_sc_mcu7t3v3__buff_12
Xinput257 VDD VDD VSS VSS sw_in[17] _2439_/A gf180mcu_as_sc_mcu7t3v3__buff_12
Xinput268 VDD VDD VSS VSS sw_in[27] _4156_/A gf180mcu_as_sc_mcu7t3v3__buff_12
Xinput279 VDD VDD VSS VSS sw_in[6] _3986_/A gf180mcu_as_sc_mcu7t3v3__buff_12
XFILLER_17_72 VDD VDD VSS VSS gf180mcu_as_sc_mcu7t3v3__fillcap_8
XFILLER_13_920 VDD VDD VSS VSS gf180mcu_as_sc_mcu7t3v3__fillcap_16
XFILLER_158_914 VDD VDD VSS VSS gf180mcu_as_sc_mcu7t3v3__fillcap_4
XFILLER_129_104 VDD VDD VSS VSS gf180mcu_as_sc_mcu7t3v3__fill_1
XFILLER_157_413 VDD VDD VSS VSS gf180mcu_as_sc_mcu7t3v3__fillcap_4
XFILLER_169_273 VDD VDD VSS VSS gf180mcu_as_sc_mcu7t3v3__fillcap_4
XFILLER_34_1328 VDD VDD VSS VSS gf180mcu_as_sc_mcu7t3v3__fill_2
XFILLER_184_243 VDD VDD VSS VSS gf180mcu_as_sc_mcu7t3v3__fill_2
XFILLER_181_950 VDD VDD VSS VSS gf180mcu_as_sc_mcu7t3v3__fill_2
XFILLER_158_1265 VDD VDD VSS VSS gf180mcu_as_sc_mcu7t3v3__fill_2
XFILLER_153_685 VDD VDD VSS VSS gf180mcu_as_sc_mcu7t3v3__fillcap_8
XFILLER_153_696 VDD VDD VSS VSS gf180mcu_as_sc_mcu7t3v3__fillcap_4
XFILLER_154_1107 VDD VDD VSS VSS gf180mcu_as_sc_mcu7t3v3__fill_2
XFILLER_165_92 VDD VDD VSS VSS gf180mcu_as_sc_mcu7t3v3__fill_1
X_3160_ VDD VDD VSS VSS _4137_/A _3177_/B _3177_/C _4138_/D _3161_/C gf180mcu_as_sc_mcu7t3v3__ao22_2
X_3091_ VDD VDD VSS VSS _3091_/S _4069_/D _4072_/A _3094_/B gf180mcu_as_sc_mcu7t3v3__mux2_2
XFILLER_165_1203 VDD VDD VSS VSS gf180mcu_as_sc_mcu7t3v3__fillcap_8
XPHY_EDGE_ROW_8_Right_8 VDD VSS gf180mcu_as_sc_mcu7t3v3__tap_2
X_3993_ VDD VDD VSS VSS _3993_/A _4025_/B _3993_/C _3993_/D _3994_/B gf180mcu_as_sc_mcu7t3v3__ao211_2
XFILLER_176_733 VDD VDD VSS VSS gf180mcu_as_sc_mcu7t3v3__fill_2
X_2944_ VDD VDD VSS VSS _3526_/B _3243_/A _3218_/B gf180mcu_as_sc_mcu7t3v3__and2_2
X_2875_ VDD VDD VSS VSS _2875_/B _4630_/A _4691_/C gf180mcu_as_sc_mcu7t3v3__and2_2
XFILLER_11_1103 VDD VDD VSS VSS gf180mcu_as_sc_mcu7t3v3__fillcap_4
XFILLER_141_1280 VDD VDD VSS VSS gf180mcu_as_sc_mcu7t3v3__fillcap_4
XFILLER_164_928 VDD VDD VSS VSS gf180mcu_as_sc_mcu7t3v3__fillcap_4
X_4614_ VDD VDD VSS VSS _5208_/Q _4617_/B _4617_/C _5209_/Q _5208_/D gf180mcu_as_sc_mcu7t3v3__ao22_2
XFILLER_163_438 VDD VDD VSS VSS gf180mcu_as_sc_mcu7t3v3__fillcap_8
X_4545_ VDD VDD VSS VSS _4546_/D _4545_/B _4560_/A gf180mcu_as_sc_mcu7t3v3__nor2_2
XTAP_TAPCELL_ROW_78_1_1031 VDD VSS gf180mcu_as_sc_mcu7t3v3__tap_2
XFILLER_11_1158 VDD VDD VSS VSS gf180mcu_as_sc_mcu7t3v3__fill_1
X_4476_ VDD VDD VSS VSS _4476_/D _4528_/A _4476_/B _4476_/C _4477_/B gf180mcu_as_sc_mcu7t3v3__ao31_2
X_3427_ VDD VDD VSS VSS _3501_/C _4080_/A _3428_/D gf180mcu_as_sc_mcu7t3v3__and2_2
XFILLER_38_27 VDD VDD VSS VSS gf180mcu_as_sc_mcu7t3v3__fillcap_8
X_3358_ VDD VDD VSS VSS _4008_/A _3374_/B _3374_/C _4009_/A _3359_/C gf180mcu_as_sc_mcu7t3v3__ao22_2
Xhold1112 VDD VDD VSS VSS hold1145/Y _4966_/D gf180mcu_as_sc_mcu7t3v3__clkbuff_4
Xhold1123 VDD VDD VSS VSS hold1155/Y _4967_/D gf180mcu_as_sc_mcu7t3v3__clkbuff_4
Xhold1134 VDD VDD VSS VSS _4762_/Q _4741_/C gf180mcu_as_sc_mcu7t3v3__clkbuff_4
Xhold1145 VDD VDD VSS VSS _4967_/Q hold1145/Y gf180mcu_as_sc_mcu7t3v3__clkbuff_4
Xhold1156 VDD VDD VSS VSS _4969_/Q hold1156/Y gf180mcu_as_sc_mcu7t3v3__clkbuff_4
X_3289_ VDD VDD VSS VSS _3936_/A _3462_/A _3289_/C _4805_/D _3805_/C gf180mcu_as_sc_mcu7t3v3__aoi211_2
X_5028_ VDD VDD VSS VSS _5089_/CLK _5028_/D _5028_/Q gf180mcu_as_sc_mcu7t3v3__dfxtp_2
XFILLER_54_37 VDD VDD VSS VSS gf180mcu_as_sc_mcu7t3v3__fillcap_4
XFILLER_57_1306 VDD VDD VSS VSS gf180mcu_as_sc_mcu7t3v3__fillcap_4
XFILLER_159_6 VDD VDD VSS VSS gf180mcu_as_sc_mcu7t3v3__fillcap_8
XPHY_EDGE_ROW_156_Left_348 VDD VSS gf180mcu_as_sc_mcu7t3v3__tap_2
XFILLER_10_912 VDD VDD VSS VSS gf180mcu_as_sc_mcu7t3v3__fill_1
XFILLER_9_209 VDD VDD VSS VSS gf180mcu_as_sc_mcu7t3v3__fill_1
XTAP_TAPCELL_ROW_12_918 VDD VSS gf180mcu_as_sc_mcu7t3v3__tap_2
XFILLER_167_766 VDD VDD VSS VSS gf180mcu_as_sc_mcu7t3v3__fillcap_4
XFILLER_181_1093 VDD VDD VSS VSS gf180mcu_as_sc_mcu7t3v3__fillcap_16
XFILLER_70_69 VDD VDD VSS VSS gf180mcu_as_sc_mcu7t3v3__fillcap_8
XFILLER_181_202 VDD VDD VSS VSS gf180mcu_as_sc_mcu7t3v3__fillcap_8
XFILLER_186_69 VDD VDD VSS VSS gf180mcu_as_sc_mcu7t3v3__fillcap_16
XFILLER_6_927 VDD VDD VSS VSS gf180mcu_as_sc_mcu7t3v3__fill_1
Xclkbuf_leaf_37_clk_regs VDD VDD VSS VSS clkbuf_leaf_6_clk_regs/A clkload3/A gf180mcu_as_sc_mcu7t3v3__clkbuff_12
XPHY_EDGE_ROW_27_1_Right_536 VDD VSS gf180mcu_as_sc_mcu7t3v3__tap_2
XFILLER_102_2 VDD VDD VSS VSS gf180mcu_as_sc_mcu7t3v3__fillcap_4
XFILLER_181_279 VDD VDD VSS VSS gf180mcu_as_sc_mcu7t3v3__fill_1
XPHY_EDGE_ROW_88_3_Right_129 VDD VSS gf180mcu_as_sc_mcu7t3v3__tap_2
XPHY_EDGE_ROW_165_Left_357 VDD VSS gf180mcu_as_sc_mcu7t3v3__tap_2
XFILLER_1_643 VDD VDD VSS VSS gf180mcu_as_sc_mcu7t3v3__fill_2
XFILLER_0_142 VDD VDD VSS VSS gf180mcu_as_sc_mcu7t3v3__fill_2
XFILLER_0_197 VDD VDD VSS VSS gf180mcu_as_sc_mcu7t3v3__fillcap_4
XFILLER_135_95 VDD VDD VSS VSS gf180mcu_as_sc_mcu7t3v3__fillcap_8
XFILLER_7_1259 VDD VDD VSS VSS gf180mcu_as_sc_mcu7t3v3__fill_1
XFILLER_95_55 VDD VDD VSS VSS gf180mcu_as_sc_mcu7t3v3__fillcap_4
XTAP_TAPCELL_ROW_186_1786 VDD VSS gf180mcu_as_sc_mcu7t3v3__tap_2
XTAP_TAPCELL_ROW_186_1775 VDD VSS gf180mcu_as_sc_mcu7t3v3__tap_2
XFILLER_151_72 VDD VDD VSS VSS gf180mcu_as_sc_mcu7t3v3__fillcap_8
XPHY_EDGE_ROW_174_Left_366 VDD VSS gf180mcu_as_sc_mcu7t3v3__tap_2
XFILLER_177_519 VDD VDD VSS VSS gf180mcu_as_sc_mcu7t3v3__fillcap_4
XFILLER_13_750 VDD VDD VSS VSS gf180mcu_as_sc_mcu7t3v3__fillcap_16
XFILLER_158_733 VDD VDD VSS VSS gf180mcu_as_sc_mcu7t3v3__fill_2
XFILLER_164_1280 VDD VDD VSS VSS gf180mcu_as_sc_mcu7t3v3__fill_1
XFILLER_125_1264 VDD VDD VSS VSS gf180mcu_as_sc_mcu7t3v3__fillcap_4
XFILLER_125_1275 VDD VDD VSS VSS gf180mcu_as_sc_mcu7t3v3__fillcap_16
XFILLER_8_242 VDD VDD VSS VSS gf180mcu_as_sc_mcu7t3v3__fill_2
X_2660_ VDD VDD VSS VSS _2673_/B _5131_/Q _5195_/Q _2661_/B gf180mcu_as_sc_mcu7t3v3__mux2_2
XFILLER_173_769 VDD VDD VSS VSS gf180mcu_as_sc_mcu7t3v3__fill_1
X_2591_ VDD VDD VSS VSS _2882_/A _4767_/Q _4764_/Q _2591_/Y gf180mcu_as_sc_mcu7t3v3__nor3_2
XPHY_EDGE_ROW_183_Left_375 VDD VSS gf180mcu_as_sc_mcu7t3v3__tap_2
XFILLER_181_780 VDD VDD VSS VSS gf180mcu_as_sc_mcu7t3v3__fillcap_4
XFILLER_5_64 VDD VDD VSS VSS gf180mcu_as_sc_mcu7t3v3__fillcap_4
X_4330_ VDD VDD VSS VSS _5126_/Q _4739_/A _4332_/C gf180mcu_as_sc_mcu7t3v3__or2_2
X_4261_ VDD VDD VSS VSS _4265_/B _4747_/D _5097_/D gf180mcu_as_sc_mcu7t3v3__and2_2
XTAP_TAPCELL_ROW_139_1_1092 VDD VSS gf180mcu_as_sc_mcu7t3v3__tap_2
XFILLER_84_1281 VDD VDD VSS VSS gf180mcu_as_sc_mcu7t3v3__fill_1
X_3212_ VDD VDD VSS VSS _3212_/D _3797_/A _3223_/B _3223_/C _3213_/C gf180mcu_as_sc_mcu7t3v3__ao31_2
XFILLER_171_1262 VDD VDD VSS VSS gf180mcu_as_sc_mcu7t3v3__fillcap_16
X_4192_ VDD VDD VSS VSS _4252_/B _4195_/B _4195_/C _5030_/Q _5030_/D gf180mcu_as_sc_mcu7t3v3__ao22_2
X_3143_ VDD VDD VSS VSS _3176_/S _4118_/D _4121_/A _3145_/B gf180mcu_as_sc_mcu7t3v3__mux2_2
X_3074_ VDD VDD VSS VSS _4056_/A _3125_/B _3125_/C _4056_/D _3080_/B gf180mcu_as_sc_mcu7t3v3__ao22_2
XPHY_EDGE_ROW_192_Left_384 VDD VSS gf180mcu_as_sc_mcu7t3v3__tap_2
XTAP_TAPCELL_ROW_111_3_2022 VDD VSS gf180mcu_as_sc_mcu7t3v3__tap_2
XFILLER_165_1044 VDD VDD VSS VSS gf180mcu_as_sc_mcu7t3v3__fillcap_4
X_3976_ VDD VDD VSS VSS _3976_/A _4022_/B _4021_/B _3976_/D _3977_/D gf180mcu_as_sc_mcu7t3v3__ao22_2
X_2927_ VDD VDD VSS VSS _3216_/C _2932_/C _2930_/A gf180mcu_as_sc_mcu7t3v3__nor2_2
XPHY_EDGE_ROW_15_1_Left_207 VDD VSS gf180mcu_as_sc_mcu7t3v3__tap_2
XFILLER_176_563 VDD VDD VSS VSS gf180mcu_as_sc_mcu7t3v3__fill_1
X_2858_ VDD VDD VSS VSS _2858_/Y _2858_/B _5097_/Q gf180mcu_as_sc_mcu7t3v3__nand2_2
X_2789_ VDD VDD VSS VSS _5125_/Q _2789_/B _2789_/A _2791_/A gf180mcu_as_sc_mcu7t3v3__mux2_2
X_4528_ VDD VDD VSS VSS _4529_/D _4528_/B _4528_/A gf180mcu_as_sc_mcu7t3v3__nor2_2
XFILLER_172_1004 VDD VDD VSS VSS gf180mcu_as_sc_mcu7t3v3__fillcap_8
X_4459_ VDD VDD VSS VSS _4460_/D _4459_/B _4553_/D gf180mcu_as_sc_mcu7t3v3__nor2_2
Xfanout711 VDD VDD VSS VSS _4102_/B _4023_/B gf180mcu_as_sc_mcu7t3v3__buff_12
Xfanout722 VDD VDD VSS VSS fanout722/A _3450_/B gf180mcu_as_sc_mcu7t3v3__buff_12
Xfanout733 VDD VDD VSS VSS _3178_/A _3128_/A gf180mcu_as_sc_mcu7t3v3__buff_12
Xfanout744 VDD VDD VSS VSS fanout746/A _3448_/B gf180mcu_as_sc_mcu7t3v3__buff_12
Xfanout755 VDD VDD VSS VSS _3187_/B _3236_/B gf180mcu_as_sc_mcu7t3v3__buff_12
Xfanout766 VDD VDD VSS VSS _4728_/B _4700_/S gf180mcu_as_sc_mcu7t3v3__buff_12
XFILLER_105_65 VDD VDD VSS VSS gf180mcu_as_sc_mcu7t3v3__fillcap_4
XFILLER_111_1319 VDD VDD VSS VSS gf180mcu_as_sc_mcu7t3v3__fillcap_4
Xfanout777 VDD VDD VSS VSS _2894_/Y _3059_/S gf180mcu_as_sc_mcu7t3v3__buff_12
Xfanout799 VDD VDD VSS VSS _2677_/Y _4273_/S gf180mcu_as_sc_mcu7t3v3__buff_12
XTAP_TAPCELL_ROW_164_1369 VDD VSS gf180mcu_as_sc_mcu7t3v3__tap_2
XTAP_TAPCELL_ROW_164_1358 VDD VSS gf180mcu_as_sc_mcu7t3v3__tap_2
XFILLER_183_1122 VDD VDD VSS VSS gf180mcu_as_sc_mcu7t3v3__fillcap_8
XTAP_TAPCELL_ROW_181_1694 VDD VSS gf180mcu_as_sc_mcu7t3v3__tap_2
XTAP_TAPCELL_ROW_181_1683 VDD VSS gf180mcu_as_sc_mcu7t3v3__tap_2
XFILLER_121_64 VDD VDD VSS VSS gf180mcu_as_sc_mcu7t3v3__fillcap_4
XFILLER_148_1264 VDD VDD VSS VSS gf180mcu_as_sc_mcu7t3v3__fillcap_4
XFILLER_148_1286 VDD VDD VSS VSS gf180mcu_as_sc_mcu7t3v3__fill_2
XFILLER_159_508 VDD VDD VSS VSS gf180mcu_as_sc_mcu7t3v3__fill_1
XFILLER_183_1166 VDD VDD VSS VSS gf180mcu_as_sc_mcu7t3v3__fill_1
XFILLER_187_828 VDD VDD VSS VSS gf180mcu_as_sc_mcu7t3v3__fill_1
XFILLER_70_1303 VDD VDD VSS VSS gf180mcu_as_sc_mcu7t3v3__fill_2
XFILLER_155_725 VDD VDD VSS VSS gf180mcu_as_sc_mcu7t3v3__fill_1
XFILLER_167_552 VDD VDD VSS VSS gf180mcu_as_sc_mcu7t3v3__fill_1
XFILLER_167_574 VDD VDD VSS VSS gf180mcu_as_sc_mcu7t3v3__fill_2
XFILLER_5_212 VDD VDD VSS VSS gf180mcu_as_sc_mcu7t3v3__fillcap_4
XTAP_TAPCELL_ROW_46_3_1957 VDD VSS gf180mcu_as_sc_mcu7t3v3__tap_2
XPHY_EDGE_ROW_27_3_Right_68 VDD VSS gf180mcu_as_sc_mcu7t3v3__tap_2
XFILLER_6_757 VDD VDD VSS VSS gf180mcu_as_sc_mcu7t3v3__fill_2
XPHY_EDGE_ROW_28_1_Right_537 VDD VSS gf180mcu_as_sc_mcu7t3v3__tap_2
XFILLER_155_1202 VDD VDD VSS VSS gf180mcu_as_sc_mcu7t3v3__fillcap_8
XFILLER_162_290 VDD VDD VSS VSS gf180mcu_as_sc_mcu7t3v3__fillcap_16
XFILLER_2_930 VDD VDD VSS VSS gf180mcu_as_sc_mcu7t3v3__fill_1
XTAP_TAPCELL_ROW_188_1826 VDD VSS gf180mcu_as_sc_mcu7t3v3__tap_2
XTAP_TAPCELL_ROW_188_1815 VDD VSS gf180mcu_as_sc_mcu7t3v3__tap_2
XPHY_EDGE_ROW_61_1_Left_253 VDD VSS gf180mcu_as_sc_mcu7t3v3__tap_2
XTAP_TAPCELL_ROW_5_790 VDD VSS gf180mcu_as_sc_mcu7t3v3__tap_2
XFILLER_127_1326 VDD VDD VSS VSS gf180mcu_as_sc_mcu7t3v3__fillcap_4
XFILLER_166_1353 VDD VDD VSS VSS gf180mcu_as_sc_mcu7t3v3__fill_2
XPHY_EDGE_ROW_144_3_Left_516 VDD VSS gf180mcu_as_sc_mcu7t3v3__tap_2
XFILLER_162_1217 VDD VDD VSS VSS gf180mcu_as_sc_mcu7t3v3__fillcap_8
XFILLER_178_839 VDD VDD VSS VSS gf180mcu_as_sc_mcu7t3v3__fill_2
X_3830_ VDD VDD VSS VSS _3835_/B _4909_/Q _4752_/C gf180mcu_as_sc_mcu7t3v3__and2_2
X_3761_ VDD VDD VSS VSS _3791_/B _4146_/D _3765_/C gf180mcu_as_sc_mcu7t3v3__and2_2
XFILLER_192_308 VDD VDD VSS VSS gf180mcu_as_sc_mcu7t3v3__fillcap_4
XFILLER_9_562 VDD VDD VSS VSS gf180mcu_as_sc_mcu7t3v3__fillcap_16
X_2712_ VDD VDD VSS VSS _5161_/Q _4272_/S _4275_/S _5185_/Q _2713_/B gf180mcu_as_sc_mcu7t3v3__ao22_2
XFILLER_12_1231 VDD VDD VSS VSS gf180mcu_as_sc_mcu7t3v3__fill_2
XFILLER_173_533 VDD VDD VSS VSS gf180mcu_as_sc_mcu7t3v3__fill_2
X_3692_ VDD VDD VSS VSS _4855_/D _3692_/C _3731_/B _4067_/A gf180mcu_as_sc_mcu7t3v3__aoi21_2
XFILLER_161_706 VDD VDD VSS VSS gf180mcu_as_sc_mcu7t3v3__fill_2
XFILLER_65_2 VDD VDD VSS VSS gf180mcu_as_sc_mcu7t3v3__fill_2
X_2643_ VDD VDD VSS VSS _4264_/B _2818_/S _2831_/A _2643_/C _2644_/C gf180mcu_as_sc_mcu7t3v3__ao31_2
Xoutput325 VDD VDD VSS VSS _4839_/Q east_out[0] gf180mcu_as_sc_mcu7t3v3__buff_12
X_2574_ VDD VDD VSS VSS _2575_/B _4350_/A _2849_/A gf180mcu_as_sc_mcu7t3v3__nand2_2
Xoutput369 VDD VDD VSS VSS _4790_/Q se_out[19] gf180mcu_as_sc_mcu7t3v3__buff_12
Xoutput358 VDD VDD VSS VSS _4848_/Q east_out[9] gf180mcu_as_sc_mcu7t3v3__buff_12
Xoutput347 VDD VDD VSS VSS _4841_/Q east_out[2] gf180mcu_as_sc_mcu7t3v3__buff_12
Xoutput336 VDD VDD VSS VSS _4840_/Q east_out[1] gf180mcu_as_sc_mcu7t3v3__buff_12
X_4313_ VDD VDD VSS VSS _4314_/S _5143_/Q _5142_/Q _5142_/D gf180mcu_as_sc_mcu7t3v3__mux2_2
X_4244_ VDD VDD VSS VSS _4254_/S _4244_/B _5080_/Q _5080_/D gf180mcu_as_sc_mcu7t3v3__mux2_2
X_4175_ VDD VDD VSS VSS _4235_/B _4197_/B _4197_/C _5013_/Q _5013_/D gf180mcu_as_sc_mcu7t3v3__ao22_2
X_3126_ VDD VDD VSS VSS _3126_/S _4101_/A _4103_/A _3128_/B gf180mcu_as_sc_mcu7t3v3__mux2_2
XTAP_TAPCELL_ROW_3_749 VDD VSS gf180mcu_as_sc_mcu7t3v3__tap_2
X_3057_ VDD VDD VSS VSS _3661_/A _3131_/A _3057_/C _4783_/D _3676_/D gf180mcu_as_sc_mcu7t3v3__aoi211_2
XPHY_EDGE_ROW_76_3_Left_448 VDD VSS gf180mcu_as_sc_mcu7t3v3__tap_2
XFILLER_11_517 VDD VDD VSS VSS gf180mcu_as_sc_mcu7t3v3__fill_2
X_3959_ VDD VDD VSS VSS _3959_/A _4023_/B _4023_/C _4918_/Q _3960_/D gf180mcu_as_sc_mcu7t3v3__ao22_2
XFILLER_167_49 VDD VDD VSS VSS gf180mcu_as_sc_mcu7t3v3__fillcap_16
XFILLER_178_1224 VDD VDD VSS VSS gf180mcu_as_sc_mcu7t3v3__fill_1
XFILLER_178_1235 VDD VDD VSS VSS gf180mcu_as_sc_mcu7t3v3__fillcap_4
XFILLER_191_352 VDD VDD VSS VSS gf180mcu_as_sc_mcu7t3v3__fill_1
XFILLER_152_728 VDD VDD VSS VSS gf180mcu_as_sc_mcu7t3v3__fill_2
Xfanout530 VDD VDD VSS VSS _4563_/C _4523_/C gf180mcu_as_sc_mcu7t3v3__buff_12
Xfanout541 VDD VDD VSS VSS _4105_/B _4025_/B gf180mcu_as_sc_mcu7t3v3__buff_12
XTAP_TAPCELL_ROW_166_1409 VDD VSS gf180mcu_as_sc_mcu7t3v3__tap_2
XFILLER_4_1207 VDD VDD VSS VSS gf180mcu_as_sc_mcu7t3v3__fillcap_4
Xfanout552 VDD VDD VSS VSS _3921_/Y _4141_/B gf180mcu_as_sc_mcu7t3v3__buff_12
Xfanout563 VDD VDD VSS VSS fanout563/A _3792_/B gf180mcu_as_sc_mcu7t3v3__buff_12
Xfanout574 VDD VDD VSS VSS _3278_/Y _3496_/C gf180mcu_as_sc_mcu7t3v3__buff_12
XTAP_TAPCELL_ROW_183_1723 VDD VSS gf180mcu_as_sc_mcu7t3v3__tap_2
Xfanout596 VDD VDD VSS VSS _3909_/Y wire597/A gf180mcu_as_sc_mcu7t3v3__buff_12
XFILLER_74_1291 VDD VDD VSS VSS gf180mcu_as_sc_mcu7t3v3__fill_1
XFILLER_122_1256 VDD VDD VSS VSS gf180mcu_as_sc_mcu7t3v3__fillcap_16
XFILLER_155_511 VDD VDD VSS VSS gf180mcu_as_sc_mcu7t3v3__fillcap_8
XFILLER_183_842 VDD VDD VSS VSS gf180mcu_as_sc_mcu7t3v3__fillcap_4
XFILLER_183_853 VDD VDD VSS VSS gf180mcu_as_sc_mcu7t3v3__fillcap_4
Xmax_cap719 VDD VDD VSS VSS _3770_/C fanout717/A gf180mcu_as_sc_mcu7t3v3__clkbuff_12
XFILLER_170_503 VDD VDD VSS VSS gf180mcu_as_sc_mcu7t3v3__fillcap_4
XPHY_EDGE_ROW_29_1_Right_538 VDD VSS gf180mcu_as_sc_mcu7t3v3__tap_2
XFILLER_170_558 VDD VDD VSS VSS gf180mcu_as_sc_mcu7t3v3__fill_2
XFILLER_110_102 VDD VDD VSS VSS gf180mcu_as_sc_mcu7t3v3__fill_2
X_4931_ VDD VDD VSS VSS _5158_/CLK _4931_/D _4931_/Q gf180mcu_as_sc_mcu7t3v3__dfxtp_2
XFILLER_162_1014 VDD VDD VSS VSS gf180mcu_as_sc_mcu7t3v3__fill_1
X_4862_ VDD VDD VSS VSS _5278_/CLK _4862_/D _4862_/Q gf180mcu_as_sc_mcu7t3v3__dfxtp_2
XFILLER_162_1036 VDD VDD VSS VSS gf180mcu_as_sc_mcu7t3v3__fill_2
X_3813_ VDD VDD VSS VSS _3917_/A _3931_/A _3924_/A gf180mcu_as_sc_mcu7t3v3__nor2b_2
XANTENNA_15 VDD VDD VSS VSS _3516_/B gf180mcu_as_sc_mcu7t3v3__diode_2
XANTENNA_26 VDD VDD VSS VSS _3730_/A gf180mcu_as_sc_mcu7t3v3__diode_2
XANTENNA_37 VDD VDD VSS VSS _3976_/D gf180mcu_as_sc_mcu7t3v3__diode_2
XANTENNA_48 VDD VDD VSS VSS _4151_/A gf180mcu_as_sc_mcu7t3v3__diode_2
XFILLER_140_1301 VDD VDD VSS VSS gf180mcu_as_sc_mcu7t3v3__fill_2
XFILLER_177_146 VDD VDD VSS VSS gf180mcu_as_sc_mcu7t3v3__fill_1
X_4793_ VDD VDD VSS VSS _5267_/CLK _4793_/D _4793_/Q gf180mcu_as_sc_mcu7t3v3__dfxtp_2
XFILLER_158_382 VDD VDD VSS VSS gf180mcu_as_sc_mcu7t3v3__fill_2
XFILLER_159_894 VDD VDD VSS VSS gf180mcu_as_sc_mcu7t3v3__fillcap_4
XFILLER_192_138 VDD VDD VSS VSS gf180mcu_as_sc_mcu7t3v3__fillcap_4
X_3744_ VDD VDD VSS VSS _4119_/A _3772_/B _3744_/C _3803_/B _3745_/C gf180mcu_as_sc_mcu7t3v3__ao211_2
X_3675_ VDD VDD VSS VSS _4049_/A _3729_/B _3731_/B _3676_/C _3675_/D gf180mcu_as_sc_mcu7t3v3__aoi211_2
XFILLER_173_352 VDD VDD VSS VSS gf180mcu_as_sc_mcu7t3v3__fillcap_8
X_2626_ VDD VDD VSS VSS _2626_/B _2639_/S _2627_/D gf180mcu_as_sc_mcu7t3v3__and2_2
X_2557_ VDD VDD VSS VSS _2558_/C _2557_/A _4294_/B gf180mcu_as_sc_mcu7t3v3__and2_2
XFILLER_153_29 VDD VDD VSS VSS gf180mcu_as_sc_mcu7t3v3__fill_2
XFILLER_173_1165 VDD VDD VSS VSS gf180mcu_as_sc_mcu7t3v3__fillcap_4
X_5276_ VDD VDD VSS VSS _5277_/CLK _5276_/D _5276_/Q gf180mcu_as_sc_mcu7t3v3__dfxtp_2
X_2488_ VDD VDD VSS VSS _4329_/A _2534_/B _2534_/A gf180mcu_as_sc_mcu7t3v3__nand2_2
X_4227_ VDD VDD VSS VSS _4256_/B _4227_/B _4227_/C _5063_/Q _5063_/D gf180mcu_as_sc_mcu7t3v3__ao22_2
X_4158_ VDD VDD VSS VSS _5005_/Q _4158_/B _4256_/B _4158_/D _5005_/D gf180mcu_as_sc_mcu7t3v3__ao22_2
XTAP_TAPCELL_ROW_161_1306 VDD VSS gf180mcu_as_sc_mcu7t3v3__tap_2
X_4089_ VDD VDD VSS VSS _4089_/A _4163_/B _4089_/C _4089_/D _4090_/B gf180mcu_as_sc_mcu7t3v3__ao211_2
X_3109_ VDD VDD VSS VSS _3134_/S _4085_/D _4088_/A _3112_/B gf180mcu_as_sc_mcu7t3v3__mux2_2
XFILLER_102_44 VDD VDD VSS VSS gf180mcu_as_sc_mcu7t3v3__fillcap_16
XFILLER_180_1103 VDD VDD VSS VSS gf180mcu_as_sc_mcu7t3v3__fillcap_16
XFILLER_12_815 VDD VDD VSS VSS gf180mcu_as_sc_mcu7t3v3__fillcap_4
XFILLER_145_1256 VDD VDD VSS VSS gf180mcu_as_sc_mcu7t3v3__fill_1
XFILLER_145_1267 VDD VDD VSS VSS gf180mcu_as_sc_mcu7t3v3__fillcap_8
XFILLER_178_37 VDD VDD VSS VSS gf180mcu_as_sc_mcu7t3v3__fillcap_16
XFILLER_58_1297 VDD VDD VSS VSS gf180mcu_as_sc_mcu7t3v3__fill_1
XFILLER_157_809 VDD VDD VSS VSS gf180mcu_as_sc_mcu7t3v3__fillcap_16
XTAP_TAPCELL_ROW_159_1268 VDD VSS gf180mcu_as_sc_mcu7t3v3__tap_2
XPHY_EDGE_ROW_140_3_Right_181 VDD VSS gf180mcu_as_sc_mcu7t3v3__tap_2
XFILLER_165_842 VDD VDD VSS VSS gf180mcu_as_sc_mcu7t3v3__fillcap_4
XFILLER_178_1021 VDD VDD VSS VSS gf180mcu_as_sc_mcu7t3v3__fill_2
XTAP_TAPCELL_ROW_176_1593 VDD VSS gf180mcu_as_sc_mcu7t3v3__tap_2
XTAP_TAPCELL_ROW_176_1582 VDD VSS gf180mcu_as_sc_mcu7t3v3__tap_2
XFILLER_164_352 VDD VDD VSS VSS gf180mcu_as_sc_mcu7t3v3__fill_2
XFILLER_192_661 VDD VDD VSS VSS gf180mcu_as_sc_mcu7t3v3__fill_2
XFILLER_127_74 VDD VDD VSS VSS gf180mcu_as_sc_mcu7t3v3__fill_1
XFILLER_65_1268 VDD VDD VSS VSS gf180mcu_as_sc_mcu7t3v3__fill_1
XTAP_TAPCELL_ROW_7_830 VDD VSS gf180mcu_as_sc_mcu7t3v3__tap_2
XFILLER_36_71 VDD VDD VSS VSS gf180mcu_as_sc_mcu7t3v3__fill_2
XFILLER_37_1315 VDD VDD VSS VSS gf180mcu_as_sc_mcu7t3v3__fill_2
XFILLER_37_1326 VDD VDD VSS VSS gf180mcu_as_sc_mcu7t3v3__fill_2
XFILLER_159_124 VDD VDD VSS VSS gf180mcu_as_sc_mcu7t3v3__fill_1
XFILLER_187_422 VDD VDD VSS VSS gf180mcu_as_sc_mcu7t3v3__fillcap_8
XFILLER_175_617 VDD VDD VSS VSS gf180mcu_as_sc_mcu7t3v3__fill_2
XFILLER_187_455 VDD VDD VSS VSS gf180mcu_as_sc_mcu7t3v3__fillcap_16
XFILLER_156_831 VDD VDD VSS VSS gf180mcu_as_sc_mcu7t3v3__fill_2
XFILLER_168_691 VDD VDD VSS VSS gf180mcu_as_sc_mcu7t3v3__fill_2
Xinput13 VDD VDD VSS VSS boot_data[1] _2692_/A gf180mcu_as_sc_mcu7t3v3__buff_12
XFILLER_7_852 VDD VDD VSS VSS gf180mcu_as_sc_mcu7t3v3__fill_1
Xinput24 VDD VDD VSS VSS dft_addr[1] _2610_/B gf180mcu_as_sc_mcu7t3v3__buff_12
Xinput35 VDD VDD VSS VSS dft_wdata[0] _2686_/B gf180mcu_as_sc_mcu7t3v3__buff_12
Xinput46 VDD VDD VSS VSS east_in[11] _4024_/A gf180mcu_as_sc_mcu7t3v3__buff_12
XFILLER_155_352 VDD VDD VSS VSS gf180mcu_as_sc_mcu7t3v3__fillcap_4
Xinput57 VDD VDD VSS VSS east_in[21] _4103_/A gf180mcu_as_sc_mcu7t3v3__buff_12
Xinput68 VDD VDD VSS VSS east_in[31] wire856/A gf180mcu_as_sc_mcu7t3v3__buff_12
Xinput79 VDD VDD VSS VSS ne_in[10] _4016_/D gf180mcu_as_sc_mcu7t3v3__buff_12
Xmax_cap516 VDD VDD VSS VSS _3745_/B _3783_/B gf180mcu_as_sc_mcu7t3v3__clkbuff_12
Xmax_cap527 VDD VDD VSS VSS _3469_/D _3462_/A gf180mcu_as_sc_mcu7t3v3__clkbuff_12
X_4902__1066 VDD VDD VSS VSS _4902_/D gf180mcu_as_sc_mcu7t3v3__tiel_4
X_3460_ VDD VDD VSS VSS _3467_/B _4109_/A _3460_/A _3462_/B gf180mcu_as_sc_mcu7t3v3__mux2_2
XFILLER_170_344 VDD VDD VSS VSS gf180mcu_as_sc_mcu7t3v3__fillcap_16
XFILLER_171_889 VDD VDD VSS VSS gf180mcu_as_sc_mcu7t3v3__fill_2
X_3391_ VDD VDD VSS VSS _3391_/A _3391_/B _3391_/C _3392_/C gf180mcu_as_sc_mcu7t3v3__nor3_2
X_2411_ VDD VDD VSS VSS _2538_/A _5162_/Q gf180mcu_as_sc_mcu7t3v3__inv_2
X_5130_ VDD VDD VSS VSS _5216_/CLK _5130_/D _5130_/Q gf180mcu_as_sc_mcu7t3v3__dfxtp_2
X_5061_ VDD VDD VSS VSS _5175_/CLK _5061_/D _5061_/Q gf180mcu_as_sc_mcu7t3v3__dfxtp_2
X_4012_ VDD VDD VSS VSS _4987_/Q _4150_/B _4238_/B _4150_/D _4987_/D gf180mcu_as_sc_mcu7t3v3__ao22_2
XPHY_EDGE_ROW_24_1_Left_216 VDD VSS gf180mcu_as_sc_mcu7t3v3__tap_2
XFILLER_168_1212 VDD VDD VSS VSS gf180mcu_as_sc_mcu7t3v3__fill_2
XFILLER_168_1267 VDD VDD VSS VSS gf180mcu_as_sc_mcu7t3v3__fillcap_4
XPHY_EDGE_ROW_149_1_Left_341 VDD VSS gf180mcu_as_sc_mcu7t3v3__tap_2
XFILLER_179_912 VDD VDD VSS VSS gf180mcu_as_sc_mcu7t3v3__fillcap_16
X_4914_ VDD VDD VSS VSS _5185_/CLK _4914_/D _4914_/Q gf180mcu_as_sc_mcu7t3v3__dfxtp_2
XFILLER_179_978 VDD VDD VSS VSS gf180mcu_as_sc_mcu7t3v3__fill_2
X_4845_ VDD VDD VSS VSS _5220_/CLK _4845_/D _4845_/Q gf180mcu_as_sc_mcu7t3v3__dfxtp_2
XFILLER_148_18 VDD VDD VSS VSS gf180mcu_as_sc_mcu7t3v3__fillcap_8
X_4776_ VDD VDD VSS VSS _5220_/CLK _4776_/D _4776_/Q gf180mcu_as_sc_mcu7t3v3__dfxtp_2
X_3727_ VDD VDD VSS VSS _4936_/Q _3727_/B _3727_/C _4101_/D _3728_/D gf180mcu_as_sc_mcu7t3v3__ao22_2
XFILLER_179_1352 VDD VDD VSS VSS gf180mcu_as_sc_mcu7t3v3__fill_2
XTAP_TAPCELL_ROW_154_1165 VDD VSS gf180mcu_as_sc_mcu7t3v3__tap_2
XFILLER_88_1268 VDD VDD VSS VSS gf180mcu_as_sc_mcu7t3v3__fill_2
X_3658_ VDD VDD VSS VSS _3659_/C _4032_/D _3673_/C _3658_/C gf180mcu_as_sc_mcu7t3v3__ao21_2
XTAP_TAPCELL_ROW_154_1176 VDD VSS gf180mcu_as_sc_mcu7t3v3__tap_2
X_3589_ VDD VDD VSS VSS _4918_/Q _3648_/B _3648_/C _3959_/A _3590_/D gf180mcu_as_sc_mcu7t3v3__ao22_2
X_2609_ VDD VDD VSS VSS _2701_/A _2609_/B input3/Y _2610_/A gf180mcu_as_sc_mcu7t3v3__mux2_2
XTAP_TAPCELL_ROW_171_1490 VDD VSS gf180mcu_as_sc_mcu7t3v3__tap_2
XFILLER_0_516 VDD VDD VSS VSS gf180mcu_as_sc_mcu7t3v3__fill_2
X_5259_ VDD VDD VSS VSS _5265_/CLK _5259_/D _5259_/Q gf180mcu_as_sc_mcu7t3v3__dfxtp_2
XFILLER_113_21 VDD VDD VSS VSS gf180mcu_as_sc_mcu7t3v3__fillcap_4
XFILLER_189_6 VDD VDD VSS VSS gf180mcu_as_sc_mcu7t3v3__fillcap_16
XPHY_EDGE_ROW_36_3_Right_77 VDD VSS gf180mcu_as_sc_mcu7t3v3__tap_2
XFILLER_169_422 VDD VDD VSS VSS gf180mcu_as_sc_mcu7t3v3__fillcap_16
XFILLER_189_58 VDD VDD VSS VSS gf180mcu_as_sc_mcu7t3v3__fillcap_8
XTAP_TAPCELL_ROW_178_1633 VDD VSS gf180mcu_as_sc_mcu7t3v3__tap_2
XTAP_TAPCELL_ROW_178_1622 VDD VSS gf180mcu_as_sc_mcu7t3v3__tap_2
XPHY_EDGE_ROW_70_1_Left_262 VDD VSS gf180mcu_as_sc_mcu7t3v3__tap_2
XFILLER_12_667 VDD VDD VSS VSS gf180mcu_as_sc_mcu7t3v3__fillcap_4
XFILLER_132_2 VDD VDD VSS VSS gf180mcu_as_sc_mcu7t3v3__fill_2
XFILLER_184_403 VDD VDD VSS VSS gf180mcu_as_sc_mcu7t3v3__fill_2
XFILLER_185_959 VDD VDD VSS VSS gf180mcu_as_sc_mcu7t3v3__fillcap_8
XFILLER_32_1256 VDD VDD VSS VSS gf180mcu_as_sc_mcu7t3v3__fill_2
XPHY_EDGE_ROW_141_3_Right_182 VDD VSS gf180mcu_as_sc_mcu7t3v3__tap_2
XFILLER_153_823 VDD VDD VSS VSS gf180mcu_as_sc_mcu7t3v3__fillcap_16
XFILLER_22_62 VDD VDD VSS VSS gf180mcu_as_sc_mcu7t3v3__fill_1
XTAP_TAPCELL_ROW_191_1877 VDD VSS gf180mcu_as_sc_mcu7t3v3__tap_2
XTAP_TAPCELL_ROW_191_1866 VDD VSS gf180mcu_as_sc_mcu7t3v3__tap_2
XTAP_TAPCELL_ROW_110_1_1063 VDD VSS gf180mcu_as_sc_mcu7t3v3__tap_2
XFILLER_164_171 VDD VDD VSS VSS gf180mcu_as_sc_mcu7t3v3__fillcap_4
XFILLER_164_193 VDD VDD VSS VSS gf180mcu_as_sc_mcu7t3v3__fillcap_8
XFILLER_192_491 VDD VDD VSS VSS gf180mcu_as_sc_mcu7t3v3__fill_2
XTAP_TAPCELL_ROW_10_879 VDD VSS gf180mcu_as_sc_mcu7t3v3__tap_2
XFILLER_4_877 VDD VDD VSS VSS gf180mcu_as_sc_mcu7t3v3__fillcap_8
XFILLER_98_77 VDD VDD VSS VSS gf180mcu_as_sc_mcu7t3v3__fill_1
XFILLER_180_686 VDD VDD VSS VSS gf180mcu_as_sc_mcu7t3v3__fillcap_16
XFILLER_154_61 VDD VDD VSS VSS gf180mcu_as_sc_mcu7t3v3__fill_1
XFILLER_156_1182 VDD VDD VSS VSS gf180mcu_as_sc_mcu7t3v3__fillcap_16
XFILLER_170_93 VDD VDD VSS VSS gf180mcu_as_sc_mcu7t3v3__fill_2
XFILLER_179_208 VDD VDD VSS VSS gf180mcu_as_sc_mcu7t3v3__fill_2
X_2960_ VDD VDD VSS VSS _3940_/A _3044_/B _3044_/C _3941_/A _2961_/C gf180mcu_as_sc_mcu7t3v3__ao22_2
XFILLER_163_1164 VDD VDD VSS VSS gf180mcu_as_sc_mcu7t3v3__fill_2
X_2891_ VDD VDD VSS VSS _3257_/A _3533_/B _3533_/A gf180mcu_as_sc_mcu7t3v3__nor2b_2
XFILLER_175_403 VDD VDD VSS VSS gf180mcu_as_sc_mcu7t3v3__fill_2
XFILLER_187_274 VDD VDD VSS VSS gf180mcu_as_sc_mcu7t3v3__fillcap_4
X_4630_ VDD VDD VSS VSS _4700_/S _5118_/Q _4630_/A _5221_/D gf180mcu_as_sc_mcu7t3v3__mux2_2
XFILLER_163_609 VDD VDD VSS VSS gf180mcu_as_sc_mcu7t3v3__fillcap_16
XFILLER_8_64 VDD VDD VSS VSS gf180mcu_as_sc_mcu7t3v3__fill_2
XFILLER_156_661 VDD VDD VSS VSS gf180mcu_as_sc_mcu7t3v3__fillcap_4
X_4561_ VDD VDD VSS VSS _4561_/D _4561_/A _4561_/B _4561_/C _4562_/B gf180mcu_as_sc_mcu7t3v3__ao31_2
XFILLER_190_439 VDD VDD VSS VSS gf180mcu_as_sc_mcu7t3v3__fillcap_16
X_4492_ VDD VDD VSS VSS _4495_/C _4492_/B _4573_/A gf180mcu_as_sc_mcu7t3v3__nor2_2
X_3512_ VDD VDD VSS VSS _3513_/D _3512_/A _3521_/B _3512_/C gf180mcu_as_sc_mcu7t3v3__ao21_2
XFILLER_171_653 VDD VDD VSS VSS gf180mcu_as_sc_mcu7t3v3__fill_1
XFILLER_6_181 VDD VDD VSS VSS gf180mcu_as_sc_mcu7t3v3__fill_2
X_3443_ VDD VDD VSS VSS _4093_/D _3500_/B _3443_/C _3443_/D _3444_/A gf180mcu_as_sc_mcu7t3v3__ao22_2
XPHY_EDGE_ROW_85_3_Left_457 VDD VSS gf180mcu_as_sc_mcu7t3v3__tap_2
X_5113_ VDD VDD VSS VSS _5266_/CLK _5113_/D _5113_/Q gf180mcu_as_sc_mcu7t3v3__dfxtp_2
X_3374_ VDD VDD VSS VSS _4022_/A _3374_/B _3374_/C _4025_/A _3375_/C gf180mcu_as_sc_mcu7t3v3__ao22_2
XFILLER_170_1157 VDD VDD VSS VSS gf180mcu_as_sc_mcu7t3v3__fillcap_16
X_5044_ VDD VDD VSS VSS clkload8/A _5044_/D _5044_/Q gf180mcu_as_sc_mcu7t3v3__dfxtp_2
XFILLER_0_1221 VDD VDD VSS VSS gf180mcu_as_sc_mcu7t3v3__fill_2
XFILLER_168_1053 VDD VDD VSS VSS gf180mcu_as_sc_mcu7t3v3__fill_2
XFILLER_181_1253 VDD VDD VSS VSS gf180mcu_as_sc_mcu7t3v3__fillcap_4
XFILLER_55_1256 VDD VDD VSS VSS gf180mcu_as_sc_mcu7t3v3__fillcap_8
XFILLER_167_926 VDD VDD VSS VSS gf180mcu_as_sc_mcu7t3v3__fillcap_16
X_4828_ VDD VDD VSS VSS clkload7/A _4828_/D _4828_/Q gf180mcu_as_sc_mcu7t3v3__dfxtp_2
XTAP_TAPCELL_ROW_156_1216 VDD VSS gf180mcu_as_sc_mcu7t3v3__tap_2
XTAP_TAPCELL_ROW_156_1205 VDD VSS gf180mcu_as_sc_mcu7t3v3__tap_2
X_4759_ VDD VDD VSS VSS _5285_/CLK _4759_/D _4759_/Q gf180mcu_as_sc_mcu7t3v3__dfxtp_2
XTAP_TAPCELL_ROW_173_1541 VDD VSS gf180mcu_as_sc_mcu7t3v3__tap_2
XTAP_TAPCELL_ROW_173_1530 VDD VSS gf180mcu_as_sc_mcu7t3v3__tap_2
XFILLER_4_107 VDD VDD VSS VSS gf180mcu_as_sc_mcu7t3v3__fillcap_4
XFILLER_175_1024 VDD VDD VSS VSS gf180mcu_as_sc_mcu7t3v3__fill_1
XFILLER_190_962 VDD VDD VSS VSS gf180mcu_as_sc_mcu7t3v3__fill_1
XFILLER_175_1079 VDD VDD VSS VSS gf180mcu_as_sc_mcu7t3v3__fill_1
Xmax_cap880 VDD VDD VSS VSS _4952_/D _3872_/A gf180mcu_as_sc_mcu7t3v3__clkbuff_12
XFILLER_1_858 VDD VDD VSS VSS gf180mcu_as_sc_mcu7t3v3__fillcap_16
XPHY_EDGE_ROW_81_1_Right_590 VDD VSS gf180mcu_as_sc_mcu7t3v3__tap_2
Xinput203 VDD VDD VSS VSS se_in[2] wire879/A gf180mcu_as_sc_mcu7t3v3__buff_12
Xinput214 VDD VDD VSS VSS se_in[9] wire873/A gf180mcu_as_sc_mcu7t3v3__buff_12
Xinput225 VDD VDD VSS VSS south_in[19] _4088_/D gf180mcu_as_sc_mcu7t3v3__buff_12
Xinput236 VDD VDD VSS VSS south_in[29] _3788_/D gf180mcu_as_sc_mcu7t3v3__buff_12
Xinput247 VDD VDD VSS VSS south_in[8] _4000_/D gf180mcu_as_sc_mcu7t3v3__buff_12
Xinput258 VDD VDD VSS VSS sw_in[18] _2440_/A gf180mcu_as_sc_mcu7t3v3__buff_12
Xinput269 VDD VDD VSS VSS sw_in[28] _4164_/A gf180mcu_as_sc_mcu7t3v3__buff_12
XFILLER_124_97 VDD VDD VSS VSS gf180mcu_as_sc_mcu7t3v3__fillcap_8
XFILLER_84_79 VDD VDD VSS VSS gf180mcu_as_sc_mcu7t3v3__fill_1
XFILLER_186_1153 VDD VDD VSS VSS gf180mcu_as_sc_mcu7t3v3__fill_2
XFILLER_13_954 VDD VDD VSS VSS gf180mcu_as_sc_mcu7t3v3__fillcap_16
XFILLER_160_1304 VDD VDD VSS VSS gf180mcu_as_sc_mcu7t3v3__fill_1
XFILLER_173_907 VDD VDD VSS VSS gf180mcu_as_sc_mcu7t3v3__fill_2
XFILLER_149_72 VDD VDD VSS VSS gf180mcu_as_sc_mcu7t3v3__fill_2
XFILLER_172_406 VDD VDD VSS VSS gf180mcu_as_sc_mcu7t3v3__fill_1
XFILLER_8_457 VDD VDD VSS VSS gf180mcu_as_sc_mcu7t3v3__fillcap_4
XPHY_EDGE_ROW_142_3_Right_183 VDD VSS gf180mcu_as_sc_mcu7t3v3__tap_2
XFILLER_181_973 VDD VDD VSS VSS gf180mcu_as_sc_mcu7t3v3__fillcap_4
XFILLER_181_995 VDD VDD VSS VSS gf180mcu_as_sc_mcu7t3v3__fillcap_4
X_3090_ VDD VDD VSS VSS _3097_/B _3207_/S _4073_/A gf180mcu_as_sc_mcu7t3v3__nand2_2
Xclkbuf_leaf_7_clk_regs VDD VDD VSS VSS clkbuf_leaf_7_clk_regs/A _5185_/CLK gf180mcu_as_sc_mcu7t3v3__clkbuff_12
X_3992_ VDD VDD VSS VSS _3992_/A _4022_/B _4021_/B _3992_/D _3993_/D gf180mcu_as_sc_mcu7t3v3__ao22_2
X_2943_ VDD VDD VSS VSS _3243_/B _3526_/B _3283_/A gf180mcu_as_sc_mcu7t3v3__nand2_2
XFILLER_164_907 VDD VDD VSS VSS gf180mcu_as_sc_mcu7t3v3__fill_2
X_2874_ VDD VDD VSS VSS _4768_/D _4742_/C _4749_/B _4733_/B gf180mcu_as_sc_mcu7t3v3__aoi21_2
XTAP_TAPCELL_ROW_64_3_1975 VDD VSS gf180mcu_as_sc_mcu7t3v3__tap_2
XFILLER_176_778 VDD VDD VSS VSS gf180mcu_as_sc_mcu7t3v3__fillcap_8
X_4613_ VDD VDD VSS VSS _5207_/Q _4617_/B _4617_/C _5208_/Q _5207_/D gf180mcu_as_sc_mcu7t3v3__ao22_2
X_4544_ VDD VDD VSS VSS _4559_/S _5025_/Q _5054_/Q _4545_/B gf180mcu_as_sc_mcu7t3v3__mux2_2
XFILLER_102_1287 VDD VDD VSS VSS gf180mcu_as_sc_mcu7t3v3__fill_2
XFILLER_190_247 VDD VDD VSS VSS gf180mcu_as_sc_mcu7t3v3__fillcap_4
X_4475_ VDD VDD VSS VSS _4476_/D _4475_/B _4528_/A gf180mcu_as_sc_mcu7t3v3__nor2_2
X_3426_ VDD VDD VSS VSS _3428_/C _4080_/D _3503_/B _3426_/C gf180mcu_as_sc_mcu7t3v3__ao21_2
X_3357_ VDD VDD VSS VSS _3373_/S _4008_/D _3357_/A _3359_/B gf180mcu_as_sc_mcu7t3v3__mux2_2
XFILLER_161_29 VDD VDD VSS VSS gf180mcu_as_sc_mcu7t3v3__fillcap_4
XFILLER_57_103 VDD VDD VSS VSS gf180mcu_as_sc_mcu7t3v3__fill_2
Xhold1102 VDD VDD VSS VSS _5199_/Q _2581_/A gf180mcu_as_sc_mcu7t3v3__clkbuff_4
Xhold1113 VDD VDD VSS VSS hold1146/Y _4971_/D gf180mcu_as_sc_mcu7t3v3__clkbuff_4
Xhold1124 VDD VDD VSS VSS hold1156/Y _4968_/D gf180mcu_as_sc_mcu7t3v3__clkbuff_4
X_5027_ VDD VDD VSS VSS _5185_/CLK _5027_/D _5027_/Q gf180mcu_as_sc_mcu7t3v3__dfxtp_2
Xhold1135 VDD VDD VSS VSS _5267_/Q _4732_/A gf180mcu_as_sc_mcu7t3v3__clkbuff_4
Xhold1146 VDD VDD VSS VSS _4972_/Q hold1146/Y gf180mcu_as_sc_mcu7t3v3__clkbuff_4
Xhold1157 VDD VDD VSS VSS _4973_/Q hold1157/Y gf180mcu_as_sc_mcu7t3v3__clkbuff_4
X_3288_ VDD VDD VSS VSS _3288_/A _3462_/A _3288_/C _3289_/C gf180mcu_as_sc_mcu7t3v3__nor3_2
XFILLER_61_1293 VDD VDD VSS VSS gf180mcu_as_sc_mcu7t3v3__fill_1
XTAP_TAPCELL_ROW_29_1_982 VDD VSS gf180mcu_as_sc_mcu7t3v3__tap_2
XFILLER_22_1288 VDD VDD VSS VSS gf180mcu_as_sc_mcu7t3v3__fill_1
XFILLER_2_1349 VDD VDD VSS VSS gf180mcu_as_sc_mcu7t3v3__fillcap_4
XFILLER_13_206 VDD VDD VSS VSS gf180mcu_as_sc_mcu7t3v3__fill_2
XFILLER_183_1348 VDD VDD VSS VSS gf180mcu_as_sc_mcu7t3v3__fillcap_4
XFILLER_13_228 VDD VDD VSS VSS gf180mcu_as_sc_mcu7t3v3__fillcap_8
XTAP_TAPCELL_ROW_12_919 VDD VSS gf180mcu_as_sc_mcu7t3v3__tap_2
XFILLER_155_907 VDD VDD VSS VSS gf180mcu_as_sc_mcu7t3v3__fill_2
XFILLER_166_222 VDD VDD VSS VSS gf180mcu_as_sc_mcu7t3v3__fillcap_8
XFILLER_167_734 VDD VDD VSS VSS gf180mcu_as_sc_mcu7t3v3__fillcap_16
XFILLER_179_594 VDD VDD VSS VSS gf180mcu_as_sc_mcu7t3v3__fillcap_16
XFILLER_70_37 VDD VDD VSS VSS gf180mcu_as_sc_mcu7t3v3__fillcap_4
XFILLER_186_37 VDD VDD VSS VSS gf180mcu_as_sc_mcu7t3v3__fillcap_16
XFILLER_163_940 VDD VDD VSS VSS gf180mcu_as_sc_mcu7t3v3__fill_2
XFILLER_177_1119 VDD VDD VSS VSS gf180mcu_as_sc_mcu7t3v3__fill_1
XFILLER_182_737 VDD VDD VSS VSS gf180mcu_as_sc_mcu7t3v3__fillcap_8
XPHY_EDGE_ROW_167_Right_29 VDD VSS gf180mcu_as_sc_mcu7t3v3__tap_2
XFILLER_163_962 VDD VDD VSS VSS gf180mcu_as_sc_mcu7t3v3__fill_2
XFILLER_181_269 VDD VDD VSS VSS gf180mcu_as_sc_mcu7t3v3__fillcap_8
XFILLER_162_483 VDD VDD VSS VSS gf180mcu_as_sc_mcu7t3v3__fillcap_4
XFILLER_79_79 VDD VDD VSS VSS gf180mcu_as_sc_mcu7t3v3__fill_1
XFILLER_118_1272 VDD VDD VSS VSS gf180mcu_as_sc_mcu7t3v3__fill_2
XPHY_EDGE_ROW_82_1_Right_591 VDD VSS gf180mcu_as_sc_mcu7t3v3__tap_2
XFILLER_1_699 VDD VDD VSS VSS gf180mcu_as_sc_mcu7t3v3__fill_1
XTAP_TAPCELL_ROW_186_1776 VDD VSS gf180mcu_as_sc_mcu7t3v3__tap_2
XTAP_TAPCELL_ROW_186_1787 VDD VSS gf180mcu_as_sc_mcu7t3v3__tap_2
XPHY_EDGE_ROW_176_Right_38 VDD VSS gf180mcu_as_sc_mcu7t3v3__tap_2
XFILLER_188_1259 VDD VDD VSS VSS gf180mcu_as_sc_mcu7t3v3__fillcap_16
XFILLER_160_1101 VDD VDD VSS VSS gf180mcu_as_sc_mcu7t3v3__fill_2
XPHY_EDGE_ROW_185_Right_47 VDD VSS gf180mcu_as_sc_mcu7t3v3__tap_2
XFILLER_173_748 VDD VDD VSS VSS gf180mcu_as_sc_mcu7t3v3__fillcap_4
XFILLER_185_586 VDD VDD VSS VSS gf180mcu_as_sc_mcu7t3v3__fillcap_4
XPHY_EDGE_ROW_33_1_Left_225 VDD VSS gf180mcu_as_sc_mcu7t3v3__tap_2
XFILLER_5_10 VDD VDD VSS VSS gf180mcu_as_sc_mcu7t3v3__fill_2
X_2590_ VDD VDD VSS VSS _4949_/D _2590_/B _3907_/A gf180mcu_as_sc_mcu7t3v3__nand2_2
XPHY_EDGE_ROW_143_3_Right_184 VDD VSS gf180mcu_as_sc_mcu7t3v3__tap_2
XFILLER_5_994 VDD VDD VSS VSS gf180mcu_as_sc_mcu7t3v3__fill_2
X_4260_ VDD VDD VSS VSS _5096_/D _4260_/B _4260_/A gf180mcu_as_sc_mcu7t3v3__nor2_2
X_4191_ VDD VDD VSS VSS _4251_/B _4197_/B _4197_/C _5029_/Q _5029_/D gf180mcu_as_sc_mcu7t3v3__ao22_2
X_3211_ VDD VDD VSS VSS _3222_/D _3796_/D _3787_/A _3255_/B _3212_/D gf180mcu_as_sc_mcu7t3v3__ao31_2
X_3142_ VDD VDD VSS VSS _4119_/A _3240_/B _3239_/A _4118_/A _3148_/B gf180mcu_as_sc_mcu7t3v3__ao22_2
X_3073_ VDD VDD VSS VSS _3676_/A _3131_/A _3073_/C _4785_/D _3676_/D gf180mcu_as_sc_mcu7t3v3__aoi211_2
XFILLER_169_1192 VDD VDD VSS VSS gf180mcu_as_sc_mcu7t3v3__fillcap_16
X_3975_ VDD VDD VSS VSS _3975_/A _4024_/B _3975_/C _3975_/D _3977_/C gf180mcu_as_sc_mcu7t3v3__ao211_2
X_2926_ VDD VDD VSS VSS _3216_/B _3266_/B _3531_/A gf180mcu_as_sc_mcu7t3v3__nand2_2
X_2857_ VDD VDD VSS VSS _2858_/B _5097_/Q _2857_/Y gf180mcu_as_sc_mcu7t3v3__and2_2
XFILLER_163_203 VDD VDD VSS VSS gf180mcu_as_sc_mcu7t3v3__fillcap_4
XFILLER_164_737 VDD VDD VSS VSS gf180mcu_as_sc_mcu7t3v3__fillcap_16
XFILLER_176_597 VDD VDD VSS VSS gf180mcu_as_sc_mcu7t3v3__fill_1
XFILLER_191_556 VDD VDD VSS VSS gf180mcu_as_sc_mcu7t3v3__fillcap_4
XFILLER_191_578 VDD VDD VSS VSS gf180mcu_as_sc_mcu7t3v3__fillcap_16
X_2788_ VDD VDD VSS VSS _5126_/Q _5181_/Q _5165_/Q _2789_/A gf180mcu_as_sc_mcu7t3v3__mux2_2
XFILLER_172_770 VDD VDD VSS VSS gf180mcu_as_sc_mcu7t3v3__fill_1
X_4527_ VDD VDD VSS VSS _4585_/A _5023_/Q _5052_/Q _4528_/B gf180mcu_as_sc_mcu7t3v3__mux2_2
XPHY_EDGE_ROW_45_3_Right_86 VDD VSS gf180mcu_as_sc_mcu7t3v3__tap_2
XFILLER_160_943 VDD VDD VSS VSS gf180mcu_as_sc_mcu7t3v3__fill_2
X_4458_ VDD VDD VSS VSS _4458_/D _4502_/A _4458_/B _4458_/C _4459_/B gf180mcu_as_sc_mcu7t3v3__ao31_2
Xfanout701 VDD VDD VSS VSS _4674_/B _4685_/C gf180mcu_as_sc_mcu7t3v3__buff_12
Xfanout712 VDD VDD VSS VSS _3928_/Y _4102_/B gf180mcu_as_sc_mcu7t3v3__buff_12
Xfanout723 VDD VDD VSS VSS fanout725/Y _3501_/C gf180mcu_as_sc_mcu7t3v3__buff_12
X_3409_ VDD VDD VSS VSS _4931_/Q _3448_/B _3448_/C _4061_/A _3410_/C gf180mcu_as_sc_mcu7t3v3__ao22_2
Xfanout734 VDD VDD VSS VSS fanout735/Y _3153_/A gf180mcu_as_sc_mcu7t3v3__buff_12
Xfanout745 VDD VDD VSS VSS _3250_/Y _3456_/B gf180mcu_as_sc_mcu7t3v3__buff_12
Xfanout756 VDD VDD VSS VSS _3179_/B _3187_/B gf180mcu_as_sc_mcu7t3v3__buff_12
Xfanout767 VDD VDD VSS VSS _4733_/C _4728_/B gf180mcu_as_sc_mcu7t3v3__buff_12
X_4389_ VDD VDD VSS VSS _5165_/Q _4565_/B _4389_/C _4389_/D _5165_/D gf180mcu_as_sc_mcu7t3v3__ao211_2
XTAP_TAPCELL_ROW_168_1440 VDD VSS gf180mcu_as_sc_mcu7t3v3__tap_2
Xfanout789 VDD VDD VSS VSS _4167_/Y _4186_/B gf180mcu_as_sc_mcu7t3v3__buff_12
XFILLER_105_99 VDD VDD VSS VSS gf180mcu_as_sc_mcu7t3v3__fillcap_4
XTAP_TAPCELL_ROW_164_1359 VDD VSS gf180mcu_as_sc_mcu7t3v3__tap_2
XFILLER_171_6 VDD VDD VSS VSS gf180mcu_as_sc_mcu7t3v3__fillcap_16
XFILLER_2_1157 VDD VDD VSS VSS gf180mcu_as_sc_mcu7t3v3__fillcap_4
XTAP_TAPCELL_ROW_181_1684 VDD VSS gf180mcu_as_sc_mcu7t3v3__tap_2
XFILLER_183_1178 VDD VDD VSS VSS gf180mcu_as_sc_mcu7t3v3__fillcap_8
XFILLER_186_317 VDD VDD VSS VSS gf180mcu_as_sc_mcu7t3v3__fillcap_4
XFILLER_14_52 VDD VDD VSS VSS gf180mcu_as_sc_mcu7t3v3__fill_2
XFILLER_155_748 VDD VDD VSS VSS gf180mcu_as_sc_mcu7t3v3__fillcap_4
XTAP_TAPCELL_ROW_14_1_1924 VDD VSS gf180mcu_as_sc_mcu7t3v3__tap_2
XFILLER_154_247 VDD VDD VSS VSS gf180mcu_as_sc_mcu7t3v3__fill_2
XFILLER_159_1350 VDD VDD VSS VSS gf180mcu_as_sc_mcu7t3v3__fillcap_4
XFILLER_155_1214 VDD VDD VSS VSS gf180mcu_as_sc_mcu7t3v3__fill_2
XFILLER_68_1288 VDD VDD VSS VSS gf180mcu_as_sc_mcu7t3v3__fill_1
XTAP_TAPCELL_ROW_188_1827 VDD VSS gf180mcu_as_sc_mcu7t3v3__tap_2
XTAP_TAPCELL_ROW_188_1816 VDD VSS gf180mcu_as_sc_mcu7t3v3__tap_2
XTAP_TAPCELL_ROW_116_3_2027 VDD VSS gf180mcu_as_sc_mcu7t3v3__tap_2
XPHY_EDGE_ROW_83_1_Right_592 VDD VSS gf180mcu_as_sc_mcu7t3v3__tap_2
XFILLER_7_1079 VDD VDD VSS VSS gf180mcu_as_sc_mcu7t3v3__fill_1
XTAP_TAPCELL_ROW_5_791 VDD VSS gf180mcu_as_sc_mcu7t3v3__tap_2
XTAP_TAPCELL_ROW_5_780 VDD VSS gf180mcu_as_sc_mcu7t3v3__tap_2
XFILLER_131_1291 VDD VDD VSS VSS gf180mcu_as_sc_mcu7t3v3__fill_1
XFILLER_178_807 VDD VDD VSS VSS gf180mcu_as_sc_mcu7t3v3__fillcap_4
XFILLER_177_317 VDD VDD VSS VSS gf180mcu_as_sc_mcu7t3v3__fill_2
XPHY_EDGE_ROW_94_3_Left_466 VDD VSS gf180mcu_as_sc_mcu7t3v3__tap_2
XFILLER_158_531 VDD VDD VSS VSS gf180mcu_as_sc_mcu7t3v3__fill_2
X_3760_ VDD VDD VSS VSS _4141_/A _3803_/B _3760_/C _3760_/Y _3805_/C gf180mcu_as_sc_mcu7t3v3__aoi211_2
XFILLER_186_873 VDD VDD VSS VSS gf180mcu_as_sc_mcu7t3v3__fill_2
XFILLER_9_530 VDD VDD VSS VSS gf180mcu_as_sc_mcu7t3v3__fillcap_4
X_2711_ VDD VDD VSS VSS _2732_/S _4961_/Q _4970_/Q _2713_/A gf180mcu_as_sc_mcu7t3v3__mux2_2
XFILLER_158_586 VDD VDD VSS VSS gf180mcu_as_sc_mcu7t3v3__fillcap_8
XFILLER_158_597 VDD VDD VSS VSS gf180mcu_as_sc_mcu7t3v3__fillcap_16
X_3691_ VDD VDD VSS VSS _3730_/D _3730_/A _3691_/B _3691_/C _3692_/C gf180mcu_as_sc_mcu7t3v3__ao31_2
XFILLER_173_545 VDD VDD VSS VSS gf180mcu_as_sc_mcu7t3v3__fillcap_8
X_2642_ VDD VDD VSS VSS _2650_/C _2736_/C _2722_/B input6/Y gf180mcu_as_sc_mcu7t3v3__aoi21_2
XFILLER_173_578 VDD VDD VSS VSS gf180mcu_as_sc_mcu7t3v3__fill_2
XFILLER_58_2 VDD VDD VSS VSS gf180mcu_as_sc_mcu7t3v3__fill_2
Xoutput326 VDD VDD VSS VSS _4849_/Q east_out[10] gf180mcu_as_sc_mcu7t3v3__buff_12
X_2573_ VDD VDD VSS VSS _5156_/Q _5155_/Q _4338_/A gf180mcu_as_sc_mcu7t3v3__or2_2
XTAP_TAPCELL_ROW_28_1_981 VDD VSS gf180mcu_as_sc_mcu7t3v3__tap_2
XPHY_EDGE_ROW_144_3_Right_185 VDD VSS gf180mcu_as_sc_mcu7t3v3__tap_2
Xoutput359 VDD VDD VSS VSS _4771_/Q se_out[0] gf180mcu_as_sc_mcu7t3v3__buff_12
Xoutput348 VDD VDD VSS VSS _4869_/Q east_out[30] gf180mcu_as_sc_mcu7t3v3__buff_12
Xoutput337 VDD VDD VSS VSS _4859_/Q east_out[20] gf180mcu_as_sc_mcu7t3v3__buff_12
X_4312_ VDD VDD VSS VSS _4314_/S _5142_/Q _5141_/Q _5141_/D gf180mcu_as_sc_mcu7t3v3__mux2_2
X_4243_ VDD VDD VSS VSS _4256_/S _4243_/B _5079_/Q _5079_/D gf180mcu_as_sc_mcu7t3v3__mux2_2
XTAP_TAPCELL_ROW_59_3_1970 VDD VSS gf180mcu_as_sc_mcu7t3v3__tap_2
X_4174_ VDD VDD VSS VSS _4234_/B _4189_/B _4189_/C _5012_/Q _5012_/D gf180mcu_as_sc_mcu7t3v3__ao22_2
X_3125_ VDD VDD VSS VSS _4104_/A _3125_/B _3125_/C _4104_/D _3131_/B gf180mcu_as_sc_mcu7t3v3__ao22_2
XTAP_TAPCELL_ROW_3_739 VDD VSS gf180mcu_as_sc_mcu7t3v3__tap_2
X_3056_ VDD VDD VSS VSS _3131_/A _3056_/B _3056_/C _3057_/C gf180mcu_as_sc_mcu7t3v3__nor3_2
XFILLER_93_1326 VDD VDD VSS VSS gf180mcu_as_sc_mcu7t3v3__fill_2
XFILLER_168_317 VDD VDD VSS VSS gf180mcu_as_sc_mcu7t3v3__fillcap_16
XFILLER_168_339 VDD VDD VSS VSS gf180mcu_as_sc_mcu7t3v3__fill_1
X_3958_ VDD VDD VSS VSS _4024_/C _3958_/A _3960_/C gf180mcu_as_sc_mcu7t3v3__and2_2
XFILLER_13_1018 VDD VDD VSS VSS gf180mcu_as_sc_mcu7t3v3__fill_2
X_3889_ VDD VDD VSS VSS _3908_/B _5179_/Q _4929_/D gf180mcu_as_sc_mcu7t3v3__and2_2
X_2909_ VDD VDD VSS VSS _3202_/B _3537_/A _2909_/Y gf180mcu_as_sc_mcu7t3v3__and2_2
XFILLER_192_843 VDD VDD VSS VSS gf180mcu_as_sc_mcu7t3v3__fillcap_4
XFILLER_178_1269 VDD VDD VSS VSS gf180mcu_as_sc_mcu7t3v3__fillcap_16
XFILLER_183_38 VDD VDD VSS VSS gf180mcu_as_sc_mcu7t3v3__fillcap_16
XFILLER_28_1272 VDD VDD VSS VSS gf180mcu_as_sc_mcu7t3v3__fill_2
Xfanout520 VDD VDD VSS VSS _3432_/B _3424_/B gf180mcu_as_sc_mcu7t3v3__buff_12
Xfanout531 VDD VDD VSS VSS _4590_/C _4563_/C gf180mcu_as_sc_mcu7t3v3__buff_12
Xfanout542 VDD VDD VSS VSS _3927_/Y _4041_/B gf180mcu_as_sc_mcu7t3v3__buff_12
Xfanout564 VDD VDD VSS VSS _3561_/Y _3772_/B gf180mcu_as_sc_mcu7t3v3__buff_12
Xfanout575 VDD VDD VSS VSS _3194_/S _3115_/A gf180mcu_as_sc_mcu7t3v3__buff_12
XTAP_TAPCELL_ROW_183_1724 VDD VSS gf180mcu_as_sc_mcu7t3v3__tap_2
XFILLER_189_1332 VDD VDD VSS VSS gf180mcu_as_sc_mcu7t3v3__fillcap_16
Xfanout586 VDD VDD VSS VSS _4168_/Y _4186_/C gf180mcu_as_sc_mcu7t3v3__buff_12
XFILLER_189_1354 VDD VDD VSS VSS gf180mcu_as_sc_mcu7t3v3__fill_1
Xmesh_tile_990 VDD VDD VSS VSS north_out[30] gf180mcu_as_sc_mcu7t3v3__tiel_4
XFILLER_185_1229 VDD VDD VSS VSS gf180mcu_as_sc_mcu7t3v3__fill_1
XFILLER_187_648 VDD VDD VSS VSS gf180mcu_as_sc_mcu7t3v3__fillcap_8
XFILLER_74_1270 VDD VDD VSS VSS gf180mcu_as_sc_mcu7t3v3__fill_1
XFILLER_161_1262 VDD VDD VSS VSS gf180mcu_as_sc_mcu7t3v3__fillcap_16
Xwire910 VDD VDD VSS VSS wire910/A _3947_/A gf180mcu_as_sc_mcu7t3v3__clkbuff_12
XFILLER_155_523 VDD VDD VSS VSS gf180mcu_as_sc_mcu7t3v3__fill_2
XFILLER_168_884 VDD VDD VSS VSS gf180mcu_as_sc_mcu7t3v3__fillcap_16
XFILLER_183_832 VDD VDD VSS VSS gf180mcu_as_sc_mcu7t3v3__fillcap_8
XFILLER_155_534 VDD VDD VSS VSS gf180mcu_as_sc_mcu7t3v3__fill_1
Xclkbuf_leaf_21_clk_regs VDD VDD VSS VSS clkload0/A _5280_/CLK gf180mcu_as_sc_mcu7t3v3__clkbuff_12
XFILLER_182_397 VDD VDD VSS VSS gf180mcu_as_sc_mcu7t3v3__fillcap_8
XFILLER_9_1119 VDD VDD VSS VSS gf180mcu_as_sc_mcu7t3v3__fill_1
XFILLER_2_783 VDD VDD VSS VSS gf180mcu_as_sc_mcu7t3v3__fill_1
XFILLER_81_1296 VDD VDD VSS VSS gf180mcu_as_sc_mcu7t3v3__fill_1
XPHY_EDGE_ROW_84_1_Right_593 VDD VSS gf180mcu_as_sc_mcu7t3v3__tap_2
XFILLER_2_99 VDD VDD VSS VSS gf180mcu_as_sc_mcu7t3v3__fill_2
XTAP_TAPCELL_ROW_147_1_1100 VDD VSS gf180mcu_as_sc_mcu7t3v3__tap_2
X_4930_ VDD VDD VSS VSS _5158_/CLK _4930_/D _4930_/Q gf180mcu_as_sc_mcu7t3v3__dfxtp_2
XFILLER_166_1173 VDD VDD VSS VSS gf180mcu_as_sc_mcu7t3v3__fillcap_16
X_4861_ VDD VDD VSS VSS _5278_/CLK _4861_/D _4861_/Q gf180mcu_as_sc_mcu7t3v3__dfxtp_2
X_3812_ VDD VDD VSS VSS _3812_/B _3812_/A _3931_/A gf180mcu_as_sc_mcu7t3v3__and2_2
XANTENNA_16 VDD VDD VSS VSS _3516_/B gf180mcu_as_sc_mcu7t3v3__diode_2
XANTENNA_27 VDD VDD VSS VSS _3728_/C gf180mcu_as_sc_mcu7t3v3__diode_2
XANTENNA_38 VDD VDD VSS VSS _4793_/D gf180mcu_as_sc_mcu7t3v3__diode_2
X_4792_ VDD VDD VSS VSS _5212_/CLK _4792_/D _4792_/Q gf180mcu_as_sc_mcu7t3v3__dfxtp_2
XANTENNA_49 VDD VDD VSS VSS _3791_/B gf180mcu_as_sc_mcu7t3v3__diode_2
X_3743_ VDD VDD VSS VSS _3744_/C _4118_/A _3791_/B _3743_/C gf180mcu_as_sc_mcu7t3v3__ao21_2
X_3674_ VDD VDD VSS VSS _4046_/A _3725_/B _3674_/C _3674_/D _3675_/D gf180mcu_as_sc_mcu7t3v3__ao211_2
X_2625_ VDD VDD VSS VSS _2673_/B _5127_/Q _5191_/Q _2626_/B gf180mcu_as_sc_mcu7t3v3__mux2_2
XFILLER_12_1084 VDD VDD VSS VSS gf180mcu_as_sc_mcu7t3v3__fill_1
XFILLER_161_548 VDD VDD VSS VSS gf180mcu_as_sc_mcu7t3v3__fill_2
XFILLER_138_1264 VDD VDD VSS VSS gf180mcu_as_sc_mcu7t3v3__fill_2
X_2556_ VDD VDD VSS VSS _4956_/Q _4754_/Q _2556_/B _4705_/A _2558_/C gf180mcu_as_sc_mcu7t3v3__ao31_2
XPHY_EDGE_ROW_145_3_Right_186 VDD VSS gf180mcu_as_sc_mcu7t3v3__tap_2
XFILLER_173_1177 VDD VDD VSS VSS gf180mcu_as_sc_mcu7t3v3__fillcap_8
X_5275_ VDD VDD VSS VSS _5275_/CLK _5275_/D _5275_/Q gf180mcu_as_sc_mcu7t3v3__dfxtp_2
X_2487_ VDD VDD VSS VSS _2558_/A _2747_/B _2840_/A _2806_/D _2534_/B gf180mcu_as_sc_mcu7t3v3__ao31_2
X_4226_ VDD VDD VSS VSS _4255_/B _4227_/B _4227_/C _5062_/Q _5062_/D gf180mcu_as_sc_mcu7t3v3__ao22_2
X_4157_ VDD VDD VSS VSS _4157_/B _4157_/A _4256_/B gf180mcu_as_sc_mcu7t3v3__and2_2
X_3108_ VDD VDD VSS VSS _3115_/B _3207_/S _4089_/A gf180mcu_as_sc_mcu7t3v3__nand2_2
XTAP_TAPCELL_ROW_161_1307 VDD VSS gf180mcu_as_sc_mcu7t3v3__tap_2
X_4088_ VDD VDD VSS VSS _4088_/A _4159_/B _4159_/C _4088_/D _4089_/D gf180mcu_as_sc_mcu7t3v3__ao22_2
XFILLER_102_34 VDD VDD VSS VSS gf180mcu_as_sc_mcu7t3v3__fill_1
X_3039_ VDD VDD VSS VSS _3040_/C _3039_/C _3125_/C _4016_/D gf180mcu_as_sc_mcu7t3v3__aoi21_2
XFILLER_184_1251 VDD VDD VSS VSS gf180mcu_as_sc_mcu7t3v3__fill_1
XPHY_EDGE_ROW_110_1_Left_302 VDD VSS gf180mcu_as_sc_mcu7t3v3__tap_2
XFILLER_180_1148 VDD VDD VSS VSS gf180mcu_as_sc_mcu7t3v3__fillcap_4
XTAP_TAPCELL_ROW_159_1269 VDD VSS gf180mcu_as_sc_mcu7t3v3__tap_2
XTAP_TAPCELL_ROW_159_1258 VDD VSS gf180mcu_as_sc_mcu7t3v3__tap_2
XTAP_TAPCELL_ROW_176_1594 VDD VSS gf180mcu_as_sc_mcu7t3v3__tap_2
XTAP_TAPCELL_ROW_176_1583 VDD VSS gf180mcu_as_sc_mcu7t3v3__tap_2
XFILLER_178_1055 VDD VDD VSS VSS gf180mcu_as_sc_mcu7t3v3__fill_2
XFILLER_180_824 VDD VDD VSS VSS gf180mcu_as_sc_mcu7t3v3__fill_2
XFILLER_178_1099 VDD VDD VSS VSS gf180mcu_as_sc_mcu7t3v3__fillcap_8
XTAP_TAPCELL_ROW_7_831 VDD VSS gf180mcu_as_sc_mcu7t3v3__tap_2
XTAP_TAPCELL_ROW_7_820 VDD VSS gf180mcu_as_sc_mcu7t3v3__tap_2
XFILLER_152_1228 VDD VDD VSS VSS gf180mcu_as_sc_mcu7t3v3__fill_1
XPHY_EDGE_ROW_105_1_Left_297 VDD VSS gf180mcu_as_sc_mcu7t3v3__tap_2
XFILLER_143_74 VDD VDD VSS VSS gf180mcu_as_sc_mcu7t3v3__fill_1
XFILLER_41_1291 VDD VDD VSS VSS gf180mcu_as_sc_mcu7t3v3__fillcap_8
XTAP_TAPCELL_ROW_27_1_980 VDD VSS gf180mcu_as_sc_mcu7t3v3__tap_2
XPHY_EDGE_ROW_42_1_Left_234 VDD VSS gf180mcu_as_sc_mcu7t3v3__tap_2
XFILLER_159_136 VDD VDD VSS VSS gf180mcu_as_sc_mcu7t3v3__fillcap_4
XFILLER_187_489 VDD VDD VSS VSS gf180mcu_as_sc_mcu7t3v3__fill_1
XFILLER_161_1092 VDD VDD VSS VSS gf180mcu_as_sc_mcu7t3v3__fill_1
XFILLER_7_842 VDD VDD VSS VSS gf180mcu_as_sc_mcu7t3v3__fillcap_8
Xinput14 VDD VDD VSS VSS boot_data[2] _2700_/A gf180mcu_as_sc_mcu7t3v3__buff_12
Xinput25 VDD VDD VSS VSS dft_addr[2] _2629_/B gf180mcu_as_sc_mcu7t3v3__buff_12
Xinput36 VDD VDD VSS VSS dft_wdata[1] _2693_/B gf180mcu_as_sc_mcu7t3v3__buff_12
XFILLER_7_875 VDD VDD VSS VSS gf180mcu_as_sc_mcu7t3v3__fillcap_4
Xinput47 VDD VDD VSS VSS east_in[12] _4030_/D gf180mcu_as_sc_mcu7t3v3__buff_12
Xinput58 VDD VDD VSS VSS east_in[22] wire861/A gf180mcu_as_sc_mcu7t3v3__buff_12
Xinput69 VDD VDD VSS VSS east_in[32] wire855/A gf180mcu_as_sc_mcu7t3v3__buff_12
XFILLER_157_1128 VDD VDD VSS VSS gf180mcu_as_sc_mcu7t3v3__fill_1
Xmax_cap528 VDD VDD VSS VSS _3284_/Y _3476_/D gf180mcu_as_sc_mcu7t3v3__clkbuff_12
X_2410_ VDD VDD VSS VSS _4370_/A _5161_/Q gf180mcu_as_sc_mcu7t3v3__inv_2
X_3390_ VDD VDD VSS VSS _4038_/A _3453_/B _3390_/C _4041_/A _3391_/C gf180mcu_as_sc_mcu7t3v3__ao22_2
XFILLER_96_101 VDD VDD VSS VSS gf180mcu_as_sc_mcu7t3v3__fillcap_4
X_5060_ VDD VDD VSS VSS _5089_/CLK _5060_/D _5060_/Q gf180mcu_as_sc_mcu7t3v3__dfxtp_2
X_4011_ VDD VDD VSS VSS _4011_/B _4165_/A _4238_/B gf180mcu_as_sc_mcu7t3v3__and2_2
XFILLER_168_1235 VDD VDD VSS VSS gf180mcu_as_sc_mcu7t3v3__fillcap_4
XPHY_EDGE_ROW_85_1_Right_594 VDD VSS gf180mcu_as_sc_mcu7t3v3__tap_2
X_4913_ VDD VDD VSS VSS clkload1/A _4913_/D _4913_/Q gf180mcu_as_sc_mcu7t3v3__dfxtp_2
XPHY_EDGE_ROW_99_1_Left_291 VDD VSS gf180mcu_as_sc_mcu7t3v3__tap_2
XPHY_EDGE_ROW_54_3_Right_95 VDD VSS gf180mcu_as_sc_mcu7t3v3__tap_2
XFILLER_179_968 VDD VDD VSS VSS gf180mcu_as_sc_mcu7t3v3__fillcap_4
XFILLER_20_101 VDD VDD VSS VSS gf180mcu_as_sc_mcu7t3v3__fillcap_4
X_4844_ VDD VDD VSS VSS _5216_/CLK _4844_/D _4844_/Q gf180mcu_as_sc_mcu7t3v3__dfxtp_2
X_4775_ VDD VDD VSS VSS _5278_/CLK _4775_/D _4775_/Q gf180mcu_as_sc_mcu7t3v3__dfxtp_2
XFILLER_165_139 VDD VDD VSS VSS gf180mcu_as_sc_mcu7t3v3__fill_1
X_3726_ VDD VDD VSS VSS _3730_/B _3726_/C _3726_/B _4104_/A gf180mcu_as_sc_mcu7t3v3__aoi21_2
XPHY_EDGE_ROW_57_3_Left_429 VDD VSS gf180mcu_as_sc_mcu7t3v3__tap_2
XFILLER_174_673 VDD VDD VSS VSS gf180mcu_as_sc_mcu7t3v3__fill_1
X_3657_ VDD VDD VSS VSS _4030_/A _3725_/B _3657_/C _3657_/D _3658_/C gf180mcu_as_sc_mcu7t3v3__ao211_2
XTAP_TAPCELL_ROW_154_1177 VDD VSS gf180mcu_as_sc_mcu7t3v3__tap_2
XTAP_TAPCELL_ROW_154_1166 VDD VSS gf180mcu_as_sc_mcu7t3v3__tap_2
X_3588_ VDD VDD VSS VSS _3649_/C _3958_/A _3590_/C gf180mcu_as_sc_mcu7t3v3__and2_2
X_2608_ VDD VDD VSS VSS _4262_/B _2608_/B _5099_/Q _2609_/B gf180mcu_as_sc_mcu7t3v3__mux2_2
XTAP_TAPCELL_ROW_171_1491 VDD VSS gf180mcu_as_sc_mcu7t3v3__tap_2
X_2539_ VDD VDD VSS VSS _4366_/S _2539_/B _2539_/A _4372_/D gf180mcu_as_sc_mcu7t3v3__mux2_2
XPHY_EDGE_ROW_146_3_Right_187 VDD VSS gf180mcu_as_sc_mcu7t3v3__tap_2
XFILLER_64_1291 VDD VDD VSS VSS gf180mcu_as_sc_mcu7t3v3__fillcap_8
X_5258_ VDD VDD VSS VSS _5265_/CLK _5258_/D _5258_/Q gf180mcu_as_sc_mcu7t3v3__dfxtp_2
X_5189_ VDD VDD VSS VSS _5220_/CLK _5189_/D _5189_/Q gf180mcu_as_sc_mcu7t3v3__dfxtp_2
X_4209_ VDD VDD VSS VSS _4238_/B _4228_/B _4228_/C _5045_/Q _5045_/D gf180mcu_as_sc_mcu7t3v3__ao22_2
XTAP_TAPCELL_ROW_54_1_1007 VDD VSS gf180mcu_as_sc_mcu7t3v3__tap_2
XFILLER_112_1256 VDD VDD VSS VSS gf180mcu_as_sc_mcu7t3v3__fillcap_4
XTAP_TAPCELL_ROW_178_1623 VDD VSS gf180mcu_as_sc_mcu7t3v3__tap_2
XTAP_TAPCELL_ROW_178_1634 VDD VSS gf180mcu_as_sc_mcu7t3v3__tap_2
XFILLER_157_629 VDD VDD VSS VSS gf180mcu_as_sc_mcu7t3v3__fill_1
XFILLER_169_489 VDD VDD VSS VSS gf180mcu_as_sc_mcu7t3v3__fill_1
XFILLER_8_617 VDD VDD VSS VSS gf180mcu_as_sc_mcu7t3v3__fill_1
XTAP_TAPCELL_ROW_82_3_1993 VDD VSS gf180mcu_as_sc_mcu7t3v3__tap_2
XFILLER_22_74 VDD VDD VSS VSS gf180mcu_as_sc_mcu7t3v3__fillcap_4
XTAP_TAPCELL_ROW_191_1867 VDD VSS gf180mcu_as_sc_mcu7t3v3__tap_2
XFILLER_22_96 VDD VDD VSS VSS gf180mcu_as_sc_mcu7t3v3__fillcap_4
XFILLER_4_834 VDD VDD VSS VSS gf180mcu_as_sc_mcu7t3v3__fill_2
XTAP_TAPCELL_ROW_191_1878 VDD VSS gf180mcu_as_sc_mcu7t3v3__tap_2
XFILLER_153_868 VDD VDD VSS VSS gf180mcu_as_sc_mcu7t3v3__fillcap_8
XFILLER_4_889 VDD VDD VSS VSS gf180mcu_as_sc_mcu7t3v3__fill_1
XFILLER_191_1085 VDD VDD VSS VSS gf180mcu_as_sc_mcu7t3v3__fillcap_16
XFILLER_93_104 VDD VDD VSS VSS gf180mcu_as_sc_mcu7t3v3__fill_1
XFILLER_188_732 VDD VDD VSS VSS gf180mcu_as_sc_mcu7t3v3__fill_2
XFILLER_128_1274 VDD VDD VSS VSS gf180mcu_as_sc_mcu7t3v3__fillcap_8
X_2890_ VDD VDD VSS VSS _3533_/B _3508_/A _3517_/A gf180mcu_as_sc_mcu7t3v3__nor2_2
XFILLER_8_32 VDD VDD VSS VSS gf180mcu_as_sc_mcu7t3v3__fill_2
X_4560_ VDD VDD VSS VSS _4561_/D _4560_/B _4560_/A gf180mcu_as_sc_mcu7t3v3__nor2_2
XFILLER_155_172 VDD VDD VSS VSS gf180mcu_as_sc_mcu7t3v3__fillcap_16
XFILLER_171_632 VDD VDD VSS VSS gf180mcu_as_sc_mcu7t3v3__fillcap_16
XFILLER_183_492 VDD VDD VSS VSS gf180mcu_as_sc_mcu7t3v3__fillcap_8
XFILLER_7_672 VDD VDD VSS VSS gf180mcu_as_sc_mcu7t3v3__fill_2
X_4491_ VDD VDD VSS VSS _4491_/D _4572_/A _4491_/B _4491_/C _4492_/B gf180mcu_as_sc_mcu7t3v3__ao31_2
X_3511_ VDD VDD VSS VSS _3511_/A _3520_/B _3511_/C _3511_/D _3512_/C gf180mcu_as_sc_mcu7t3v3__ao211_2
X_3442_ VDD VDD VSS VSS _3442_/B _4096_/A _3443_/D gf180mcu_as_sc_mcu7t3v3__or2_2
XFILLER_87_1280 VDD VDD VSS VSS gf180mcu_as_sc_mcu7t3v3__fill_1
X_3373_ VDD VDD VSS VSS _3373_/S _4021_/A _3373_/A _3375_/B gf180mcu_as_sc_mcu7t3v3__mux2_2
XFILLER_152_890 VDD VDD VSS VSS gf180mcu_as_sc_mcu7t3v3__fill_1
XFILLER_174_1294 VDD VDD VSS VSS gf180mcu_as_sc_mcu7t3v3__fill_1
X_5112_ VDD VDD VSS VSS _5181_/CLK _5112_/D _5112_/Q gf180mcu_as_sc_mcu7t3v3__dfxtp_2
XFILLER_135_1256 VDD VDD VSS VSS gf180mcu_as_sc_mcu7t3v3__fillcap_16
X_5043_ VDD VDD VSS VSS _5178_/CLK _5043_/D _5043_/Q gf180mcu_as_sc_mcu7t3v3__dfxtp_2
XPHY_EDGE_ROW_86_1_Right_595 VDD VSS gf180mcu_as_sc_mcu7t3v3__tap_2
XTAP_TAPCELL_ROW_115_1_1068 VDD VSS gf180mcu_as_sc_mcu7t3v3__tap_2
XFILLER_0_1255 VDD VDD VSS VSS gf180mcu_as_sc_mcu7t3v3__fill_2
XFILLER_168_1087 VDD VDD VSS VSS gf180mcu_as_sc_mcu7t3v3__fill_1
XFILLER_159_18 VDD VDD VSS VSS gf180mcu_as_sc_mcu7t3v3__fill_1
XFILLER_179_765 VDD VDD VSS VSS gf180mcu_as_sc_mcu7t3v3__fillcap_4
X_4827_ VDD VDD VSS VSS clkload7/A _4827_/D _4827_/Q gf180mcu_as_sc_mcu7t3v3__dfxtp_2
XTAP_TAPCELL_ROW_156_1206 VDD VSS gf180mcu_as_sc_mcu7t3v3__tap_2
XFILLER_178_297 VDD VDD VSS VSS gf180mcu_as_sc_mcu7t3v3__fill_2
XTAP_TAPCELL_ROW_156_1217 VDD VSS gf180mcu_as_sc_mcu7t3v3__tap_2
XFILLER_175_982 VDD VDD VSS VSS gf180mcu_as_sc_mcu7t3v3__fillcap_16
X_4758_ VDD VDD VSS VSS _5285_/CLK _4758_/D _4758_/Q gf180mcu_as_sc_mcu7t3v3__dfxtp_2
XTAP_TAPCELL_ROW_173_1542 VDD VSS gf180mcu_as_sc_mcu7t3v3__tap_2
XTAP_TAPCELL_ROW_173_1531 VDD VSS gf180mcu_as_sc_mcu7t3v3__tap_2
XFILLER_179_1161 VDD VDD VSS VSS gf180mcu_as_sc_mcu7t3v3__fillcap_4
X_4689_ VDD VDD VSS VSS _4723_/A _4719_/A _4703_/D _4721_/A _4690_/C gf180mcu_as_sc_mcu7t3v3__ao31_2
X_3709_ VDD VDD VSS VSS _3710_/C _4085_/D _3781_/S _3709_/C gf180mcu_as_sc_mcu7t3v3__ao21_2
XFILLER_161_142 VDD VDD VSS VSS gf180mcu_as_sc_mcu7t3v3__fillcap_8
XFILLER_175_1014 VDD VDD VSS VSS gf180mcu_as_sc_mcu7t3v3__fillcap_8
XFILLER_153_1301 VDD VDD VSS VSS gf180mcu_as_sc_mcu7t3v3__fillcap_8
XFILLER_161_164 VDD VDD VSS VSS gf180mcu_as_sc_mcu7t3v3__fillcap_8
XFILLER_0_314 VDD VDD VSS VSS gf180mcu_as_sc_mcu7t3v3__fill_1
XFILLER_108_99 VDD VDD VSS VSS gf180mcu_as_sc_mcu7t3v3__fillcap_4
XFILLER_153_1334 VDD VDD VSS VSS gf180mcu_as_sc_mcu7t3v3__fill_1
XFILLER_27_1326 VDD VDD VSS VSS gf180mcu_as_sc_mcu7t3v3__fill_2
XFILLER_68_48 VDD VDD VSS VSS gf180mcu_as_sc_mcu7t3v3__fill_2
Xinput204 VDD VDD VSS VSS se_in[30] _3802_/A gf180mcu_as_sc_mcu7t3v3__buff_12
Xinput215 VDD VDD VSS VSS south_in[0] _3933_/D gf180mcu_as_sc_mcu7t3v3__buff_12
Xinput226 VDD VDD VSS VSS south_in[1] _3941_/A gf180mcu_as_sc_mcu7t3v3__buff_12
XPHY_EDGE_ROW_147_3_Right_188 VDD VSS gf180mcu_as_sc_mcu7t3v3__tap_2
Xinput237 VDD VDD VSS VSS south_in[2] _3949_/A gf180mcu_as_sc_mcu7t3v3__buff_12
Xinput248 VDD VDD VSS VSS south_in[9] _4007_/A gf180mcu_as_sc_mcu7t3v3__buff_12
Xinput259 VDD VDD VSS VSS sw_in[19] _2441_/A gf180mcu_as_sc_mcu7t3v3__buff_12
XFILLER_140_53 VDD VDD VSS VSS gf180mcu_as_sc_mcu7t3v3__fillcap_8
XFILLER_182_1029 VDD VDD VSS VSS gf180mcu_as_sc_mcu7t3v3__fillcap_16
XFILLER_169_220 VDD VDD VSS VSS gf180mcu_as_sc_mcu7t3v3__fill_2
XFILLER_185_702 VDD VDD VSS VSS gf180mcu_as_sc_mcu7t3v3__fill_2
XFILLER_9_904 VDD VDD VSS VSS gf180mcu_as_sc_mcu7t3v3__fillcap_4
XFILLER_13_988 VDD VDD VSS VSS gf180mcu_as_sc_mcu7t3v3__fillcap_16
XFILLER_33_62 VDD VDD VSS VSS gf180mcu_as_sc_mcu7t3v3__fillcap_8
XTAP_TAPCELL_ROW_30_3_1941 VDD VSS gf180mcu_as_sc_mcu7t3v3__tap_2
XFILLER_153_632 VDD VDD VSS VSS gf180mcu_as_sc_mcu7t3v3__fill_2
XFILLER_166_993 VDD VDD VSS VSS gf180mcu_as_sc_mcu7t3v3__fillcap_4
XFILLER_165_492 VDD VDD VSS VSS gf180mcu_as_sc_mcu7t3v3__fill_1
XFILLER_181_952 VDD VDD VSS VSS gf180mcu_as_sc_mcu7t3v3__fill_1
XFILLER_158_1278 VDD VDD VSS VSS gf180mcu_as_sc_mcu7t3v3__fill_2
XFILLER_165_72 VDD VDD VSS VSS gf180mcu_as_sc_mcu7t3v3__fillcap_16
XFILLER_180_473 VDD VDD VSS VSS gf180mcu_as_sc_mcu7t3v3__fillcap_16
XFILLER_0_881 VDD VDD VSS VSS gf180mcu_as_sc_mcu7t3v3__fill_2
XPHY_EDGE_ROW_109_3_Right_150 VDD VSS gf180mcu_as_sc_mcu7t3v3__tap_2
X_3991_ VDD VDD VSS VSS _3991_/A _4024_/B _3991_/C _3991_/D _3993_/C gf180mcu_as_sc_mcu7t3v3__ao211_2
X_2942_ VDD VDD VSS VSS _3526_/B _3817_/C _3817_/A gf180mcu_as_sc_mcu7t3v3__nor2b_2
XFILLER_175_223 VDD VDD VSS VSS gf180mcu_as_sc_mcu7t3v3__fillcap_8
XFILLER_88_2 VDD VDD VSS VSS gf180mcu_as_sc_mcu7t3v3__fill_2
X_2873_ VDD VDD VSS VSS _4748_/A _4742_/A _2873_/C _2873_/D _4767_/D gf180mcu_as_sc_mcu7t3v3__ao22_2
X_4612_ VDD VDD VSS VSS _5206_/Q _4617_/B _4617_/C _5207_/Q _5206_/D gf180mcu_as_sc_mcu7t3v3__ao22_2
XFILLER_172_930 VDD VDD VSS VSS gf180mcu_as_sc_mcu7t3v3__fillcap_8
XFILLER_176_1301 VDD VDD VSS VSS gf180mcu_as_sc_mcu7t3v3__fill_2
X_4543_ VDD VDD VSS VSS _4546_/C _4996_/Q _4559_/S gf180mcu_as_sc_mcu7t3v3__nand2b_2
XFILLER_171_462 VDD VDD VSS VSS gf180mcu_as_sc_mcu7t3v3__fill_1
XFILLER_172_1209 VDD VDD VSS VSS gf180mcu_as_sc_mcu7t3v3__fillcap_16
X_4474_ VDD VDD VSS VSS _4586_/S _5017_/Q _5046_/Q _4475_/B gf180mcu_as_sc_mcu7t3v3__mux2_2
X_3425_ VDD VDD VSS VSS _4933_/Q _3456_/B _3501_/B _4079_/A _3426_/C gf180mcu_as_sc_mcu7t3v3__ao22_2
Xsram2048.u_bank0 _2672_/Y _2668_/Y _2664_/Y _2657_/Y _2650_/Y _2641_/Y _2629_/Y _2610_/Y
+ _2604_/Y hold1110/Y clkbuf_1_0__f_clk/Y _2737_/Y _2730_/Y _2723_/Y _2716_/Y _2709_/Y
+ _2702_/Y _2693_/Y _2686_/Y _2832_/Y _2744_/A _2743_/A _2742_/A _2741_/A _2740_/A
+ _2739_/A _2738_/A _2478_/A VDD VSS sram2048.u_bank0/WEN[7] sram2048.u_bank0/WEN[6]
+ sram2048.u_bank0/WEN[5] sram2048.u_bank0/WEN[4] sram2048.u_bank0/WEN[3] sram2048.u_bank0/WEN[2]
+ sram2048.u_bank0/WEN[1] sram2048.u_bank0/WEN[0] _2676_/Y gf180mcu_ocd_ip_sram__sram1024x8m8wm1
X_3356_ VDD VDD VSS VSS _4006_/A _3372_/B _3356_/C _3356_/D _3357_/A gf180mcu_as_sc_mcu7t3v3__ao211_2
XTAP_TAPCELL_ROW_134_3_2045 VDD VSS gf180mcu_as_sc_mcu7t3v3__tap_2
Xhold1103 VDD VDD VSS VSS hold1138/Y hold1139/A gf180mcu_as_sc_mcu7t3v3__clkbuff_4
Xhold1114 VDD VDD VSS VSS hold1149/Y _4962_/D gf180mcu_as_sc_mcu7t3v3__clkbuff_4
X_3287_ VDD VDD VSS VSS _3926_/A _3504_/B _3513_/C _3934_/A _3288_/C gf180mcu_as_sc_mcu7t3v3__ao22_2
X_5026_ VDD VDD VSS VSS _5185_/CLK _5026_/D _5026_/Q gf180mcu_as_sc_mcu7t3v3__dfxtp_2
Xhold1125 VDD VDD VSS VSS hold1158/Y _4963_/D gf180mcu_as_sc_mcu7t3v3__clkbuff_4
Xhold1136 VDD VDD VSS VSS _5135_/Q _2580_/A gf180mcu_as_sc_mcu7t3v3__clkbuff_4
Xhold1147 VDD VDD VSS VSS _4971_/Q hold1147/Y gf180mcu_as_sc_mcu7t3v3__clkbuff_4
Xhold1158 VDD VDD VSS VSS _4964_/Q hold1158/Y gf180mcu_as_sc_mcu7t3v3__clkbuff_4
XFILLER_183_1327 VDD VDD VSS VSS gf180mcu_as_sc_mcu7t3v3__fill_2
XPHY_EDGE_ROW_87_1_Right_596 VDD VSS gf180mcu_as_sc_mcu7t3v3__tap_2
XFILLER_167_702 VDD VDD VSS VSS gf180mcu_as_sc_mcu7t3v3__fillcap_16
XFILLER_179_562 VDD VDD VSS VSS gf180mcu_as_sc_mcu7t3v3__fillcap_16
XTAP_TAPCELL_ROW_49_1_1002 VDD VSS gf180mcu_as_sc_mcu7t3v3__tap_2
XFILLER_10_925 VDD VDD VSS VSS gf180mcu_as_sc_mcu7t3v3__fill_2
XFILLER_110_78 VDD VDD VSS VSS gf180mcu_as_sc_mcu7t3v3__fillcap_16
XFILLER_10_947 VDD VDD VSS VSS gf180mcu_as_sc_mcu7t3v3__fillcap_4
XFILLER_10_958 VDD VDD VSS VSS gf180mcu_as_sc_mcu7t3v3__fill_1
XFILLER_182_705 VDD VDD VSS VSS gf180mcu_as_sc_mcu7t3v3__fill_2
XFILLER_6_907 VDD VDD VSS VSS gf180mcu_as_sc_mcu7t3v3__fillcap_4
XPHY_EDGE_ROW_17_3_Right_58 VDD VSS gf180mcu_as_sc_mcu7t3v3__tap_2
XFILLER_182_749 VDD VDD VSS VSS gf180mcu_as_sc_mcu7t3v3__fill_2
XFILLER_181_237 VDD VDD VSS VSS gf180mcu_as_sc_mcu7t3v3__fillcap_16
XPHY_EDGE_ROW_51_1_Left_243 VDD VSS gf180mcu_as_sc_mcu7t3v3__tap_2
XFILLER_0_144 VDD VDD VSS VSS gf180mcu_as_sc_mcu7t3v3__fill_1
XFILLER_135_42 VDD VDD VSS VSS gf180mcu_as_sc_mcu7t3v3__fill_2
XFILLER_153_1186 VDD VDD VSS VSS gf180mcu_as_sc_mcu7t3v3__fillcap_4
XTAP_TAPCELL_ROW_186_1777 VDD VSS gf180mcu_as_sc_mcu7t3v3__tap_2
XPHY_EDGE_ROW_148_3_Right_189 VDD VSS gf180mcu_as_sc_mcu7t3v3__tap_2
XFILLER_188_1227 VDD VDD VSS VSS gf180mcu_as_sc_mcu7t3v3__fillcap_16
XTAP_TAPCELL_ROW_186_1788 VDD VSS gf180mcu_as_sc_mcu7t3v3__tap_2
XFILLER_151_63 VDD VDD VSS VSS gf180mcu_as_sc_mcu7t3v3__fillcap_4
XPHY_EDGE_ROW_134_3_Left_506 VDD VSS gf180mcu_as_sc_mcu7t3v3__tap_2
XFILLER_189_315 VDD VDD VSS VSS gf180mcu_as_sc_mcu7t3v3__fillcap_4
XFILLER_158_713 VDD VDD VSS VSS gf180mcu_as_sc_mcu7t3v3__fillcap_16
XFILLER_38_1274 VDD VDD VSS VSS gf180mcu_as_sc_mcu7t3v3__fill_1
XFILLER_157_201 VDD VDD VSS VSS gf180mcu_as_sc_mcu7t3v3__fillcap_8
XFILLER_157_212 VDD VDD VSS VSS gf180mcu_as_sc_mcu7t3v3__fillcap_16
XFILLER_9_745 VDD VDD VSS VSS gf180mcu_as_sc_mcu7t3v3__fillcap_4
XFILLER_125_1299 VDD VDD VSS VSS gf180mcu_as_sc_mcu7t3v3__fillcap_4
XFILLER_12_295 VDD VDD VSS VSS gf180mcu_as_sc_mcu7t3v3__fillcap_4
XFILLER_160_1157 VDD VDD VSS VSS gf180mcu_as_sc_mcu7t3v3__fillcap_4
XFILLER_8_244 VDD VDD VSS VSS gf180mcu_as_sc_mcu7t3v3__fill_1
X_4878__1090 VDD VDD VSS VSS _4878_/D gf180mcu_as_sc_mcu7t3v3__tiel_4
XFILLER_10_1193 VDD VDD VSS VSS gf180mcu_as_sc_mcu7t3v3__fillcap_4
XFILLER_180_281 VDD VDD VSS VSS gf180mcu_as_sc_mcu7t3v3__fill_2
XFILLER_5_88 VDD VDD VSS VSS gf180mcu_as_sc_mcu7t3v3__fillcap_4
XFILLER_192_70 VDD VDD VSS VSS gf180mcu_as_sc_mcu7t3v3__fillcap_4
X_4190_ VDD VDD VSS VSS _4250_/B _4195_/B _4195_/C _5028_/Q _5028_/D gf180mcu_as_sc_mcu7t3v3__ao22_2
X_3210_ VDD VDD VSS VSS _3210_/B _3535_/A _3213_/B gf180mcu_as_sc_mcu7t3v3__or2_2
XFILLER_45_1256 VDD VDD VSS VSS gf180mcu_as_sc_mcu7t3v3__fillcap_16
X_3141_ VDD VDD VSS VSS _4793_/D _3141_/C _3141_/B _4115_/A gf180mcu_as_sc_mcu7t3v3__aoi21_2
XFILLER_171_1286 VDD VDD VSS VSS gf180mcu_as_sc_mcu7t3v3__fillcap_4
X_3072_ VDD VDD VSS VSS _3131_/A _3072_/B _3072_/C _3073_/C gf180mcu_as_sc_mcu7t3v3__nor3_2
XPHY_EDGE_ROW_66_3_Left_438 VDD VSS gf180mcu_as_sc_mcu7t3v3__tap_2
XFILLER_143_1300 VDD VDD VSS VSS gf180mcu_as_sc_mcu7t3v3__fill_1
X_3974_ VDD VDD VSS VSS _3974_/A _4023_/B _4023_/C _4920_/Q _3975_/D gf180mcu_as_sc_mcu7t3v3__ao22_2
X_2925_ VDD VDD VSS VSS _3266_/B _3530_/B _3530_/A gf180mcu_as_sc_mcu7t3v3__nor2b_2
XFILLER_104_1339 VDD VDD VSS VSS gf180mcu_as_sc_mcu7t3v3__fill_2
X_2856_ VDD VDD VSS VSS _4733_/B _2856_/A _2856_/B _4746_/C gf180mcu_as_sc_mcu7t3v3__ao21_2
XFILLER_191_524 VDD VDD VSS VSS gf180mcu_as_sc_mcu7t3v3__fillcap_16
X_2787_ VDD VDD VSS VSS _5126_/Q _5157_/Q _5173_/Q _2789_/B gf180mcu_as_sc_mcu7t3v3__mux2_2
XFILLER_172_782 VDD VDD VSS VSS gf180mcu_as_sc_mcu7t3v3__fill_1
XFILLER_176_1142 VDD VDD VSS VSS gf180mcu_as_sc_mcu7t3v3__fill_2
X_4526_ VDD VDD VSS VSS _4529_/C _4994_/Q _4585_/A gf180mcu_as_sc_mcu7t3v3__nand2b_2
XFILLER_160_933 VDD VDD VSS VSS gf180mcu_as_sc_mcu7t3v3__fill_2
XFILLER_176_1175 VDD VDD VSS VSS gf180mcu_as_sc_mcu7t3v3__fillcap_16
X_4457_ VDD VDD VSS VSS _4458_/D _4457_/B _4502_/A gf180mcu_as_sc_mcu7t3v3__nor2_2
XFILLER_172_18 VDD VDD VSS VSS gf180mcu_as_sc_mcu7t3v3__fillcap_16
Xfanout702 VDD VDD VSS VSS _4101_/C _4024_/C gf180mcu_as_sc_mcu7t3v3__buff_12
Xfanout713 VDD VDD VSS VSS _3928_/Y _4160_/C gf180mcu_as_sc_mcu7t3v3__buff_12
Xfanout724 VDD VDD VSS VSS fanout725/Y _3494_/B gf180mcu_as_sc_mcu7t3v3__buff_12
X_3408_ VDD VDD VSS VSS _3684_/A _3454_/A _3408_/C _4820_/D _3730_/D gf180mcu_as_sc_mcu7t3v3__aoi211_2
XFILLER_150_1315 VDD VDD VSS VSS gf180mcu_as_sc_mcu7t3v3__fillcap_4
Xfanout735 VDD VDD VSS VSS _2948_/Y fanout735/Y gf180mcu_as_sc_mcu7t3v3__buff_12
Xfanout746 VDD VDD VSS VSS fanout746/A _3493_/B gf180mcu_as_sc_mcu7t3v3__buff_12
Xfanout757 VDD VDD VSS VSS _2903_/Y _3179_/B gf180mcu_as_sc_mcu7t3v3__buff_12
X_4388_ VDD VDD VSS VSS _4388_/B _4541_/A _4389_/D gf180mcu_as_sc_mcu7t3v3__and2_2
XTAP_TAPCELL_ROW_168_1441 VDD VSS gf180mcu_as_sc_mcu7t3v3__tap_2
XTAP_TAPCELL_ROW_168_1430 VDD VSS gf180mcu_as_sc_mcu7t3v3__tap_2
Xfanout768 VDD VDD VSS VSS _4639_/S _4683_/C gf180mcu_as_sc_mcu7t3v3__buff_12
Xfanout779 VDD VDD VSS VSS _2894_/Y _3091_/S gf180mcu_as_sc_mcu7t3v3__buff_12
X_3339_ VDD VDD VSS VSS _3340_/A _3989_/A _3372_/B _3339_/C gf180mcu_as_sc_mcu7t3v3__ao21_2
XFILLER_65_49 VDD VDD VSS VSS gf180mcu_as_sc_mcu7t3v3__fill_2
X_5009_ VDD VDD VSS VSS _5095_/CLK _5009_/D _5009_/Q gf180mcu_as_sc_mcu7t3v3__dfxtp_2
XFILLER_164_6 VDD VDD VSS VSS gf180mcu_as_sc_mcu7t3v3__fillcap_16
XTAP_TAPCELL_ROW_181_1685 VDD VSS gf180mcu_as_sc_mcu7t3v3__tap_2
XPHY_EDGE_ROW_88_1_Right_597 VDD VSS gf180mcu_as_sc_mcu7t3v3__tap_2
XFILLER_148_1288 VDD VDD VSS VSS gf180mcu_as_sc_mcu7t3v3__fill_1
XFILLER_14_64 VDD VDD VSS VSS gf180mcu_as_sc_mcu7t3v3__fill_2
XFILLER_6_737 VDD VDD VSS VSS gf180mcu_as_sc_mcu7t3v3__fillcap_16
XFILLER_30_63 VDD VDD VSS VSS gf180mcu_as_sc_mcu7t3v3__fillcap_4
XFILLER_68_1256 VDD VDD VSS VSS gf180mcu_as_sc_mcu7t3v3__fillcap_8
XFILLER_2_921 VDD VDD VSS VSS gf180mcu_as_sc_mcu7t3v3__fill_2
XFILLER_68_1278 VDD VDD VSS VSS gf180mcu_as_sc_mcu7t3v3__fillcap_8
XTAP_TAPCELL_ROW_188_1817 VDD VSS gf180mcu_as_sc_mcu7t3v3__tap_2
XFILLER_146_85 VDD VDD VSS VSS gf180mcu_as_sc_mcu7t3v3__fillcap_16
XTAP_TAPCELL_ROW_5_792 VDD VSS gf180mcu_as_sc_mcu7t3v3__tap_2
XTAP_TAPCELL_ROW_5_781 VDD VSS gf180mcu_as_sc_mcu7t3v3__tap_2
XFILLER_188_1079 VDD VDD VSS VSS gf180mcu_as_sc_mcu7t3v3__fillcap_4
XTAP_TAPCELL_ROW_17_3_1928 VDD VSS gf180mcu_as_sc_mcu7t3v3__tap_2
XFILLER_158_543 VDD VDD VSS VSS gf180mcu_as_sc_mcu7t3v3__fillcap_16
X_2710_ VDD VDD VSS VSS _2724_/S _5177_/Q _5169_/Q _2714_/B gf180mcu_as_sc_mcu7t3v3__mux2_2
XFILLER_186_885 VDD VDD VSS VSS gf180mcu_as_sc_mcu7t3v3__fillcap_4
XFILLER_186_896 VDD VDD VSS VSS gf180mcu_as_sc_mcu7t3v3__fillcap_4
XFILLER_51_1260 VDD VDD VSS VSS gf180mcu_as_sc_mcu7t3v3__fill_1
X_3690_ VDD VDD VSS VSS _3691_/C _3690_/C _3729_/B _4066_/A gf180mcu_as_sc_mcu7t3v3__aoi21_2
XFILLER_161_708 VDD VDD VSS VSS gf180mcu_as_sc_mcu7t3v3__fill_1
XFILLER_173_557 VDD VDD VSS VSS gf180mcu_as_sc_mcu7t3v3__fill_2
XFILLER_65_4 VDD VDD VSS VSS gf180mcu_as_sc_mcu7t3v3__fill_1
X_2641_ VDD VDD VSS VSS _2676_/A _2641_/B _2641_/A _2641_/Y gf180mcu_as_sc_mcu7t3v3__mux2_2
X_2572_ VDD VDD VSS VSS _4350_/A _5156_/Q _5155_/Q gf180mcu_as_sc_mcu7t3v3__nor2_2
XFILLER_153_270 VDD VDD VSS VSS gf180mcu_as_sc_mcu7t3v3__fillcap_8
Xoutput349 VDD VDD VSS VSS _4870_/Q east_out[31] gf180mcu_as_sc_mcu7t3v3__buff_12
Xoutput338 VDD VDD VSS VSS _4860_/Q east_out[21] gf180mcu_as_sc_mcu7t3v3__buff_12
Xoutput327 VDD VDD VSS VSS _4850_/Q east_out[11] gf180mcu_as_sc_mcu7t3v3__buff_12
X_4311_ VDD VDD VSS VSS _4314_/S _5141_/Q _5140_/Q _5140_/D gf180mcu_as_sc_mcu7t3v3__mux2_2
XFILLER_173_1348 VDD VDD VSS VSS gf180mcu_as_sc_mcu7t3v3__fillcap_4
X_4242_ VDD VDD VSS VSS _4246_/S _4242_/B _5078_/Q _5078_/D gf180mcu_as_sc_mcu7t3v3__mux2_2
X_4173_ VDD VDD VSS VSS _4233_/B _4186_/B _4186_/C _5011_/Q _5011_/D gf180mcu_as_sc_mcu7t3v3__ao22_2
X_3124_ VDD VDD VSS VSS _4099_/A _3141_/B _3124_/C _4791_/D _3870_/A gf180mcu_as_sc_mcu7t3v3__aoi211_2
XFILLER_167_1119 VDD VDD VSS VSS gf180mcu_as_sc_mcu7t3v3__fill_1
X_3055_ VDD VDD VSS VSS _4033_/A _3130_/B _3055_/C _3055_/D _3056_/C gf180mcu_as_sc_mcu7t3v3__ao22_2
XFILLER_110_1343 VDD VDD VSS VSS gf180mcu_as_sc_mcu7t3v3__fill_2
XTAP_TAPCELL_ROW_129_3_2040 VDD VSS gf180mcu_as_sc_mcu7t3v3__tap_2
XFILLER_168_307 VDD VDD VSS VSS gf180mcu_as_sc_mcu7t3v3__fillcap_8
X_3957_ VDD VDD VSS VSS _3957_/A _4022_/B _4027_/B _3962_/C _3957_/D gf180mcu_as_sc_mcu7t3v3__aoi211_2
XFILLER_108_1272 VDD VDD VSS VSS gf180mcu_as_sc_mcu7t3v3__fillcap_4
Xclkbuf_0_clk_regs VDD VDD VSS VSS clkbuf_regs_0_clk/Y clkbuf_0_clk_regs/Y gf180mcu_as_sc_mcu7t3v3__clkbuff_12
X_2908_ VDD VDD VSS VSS _3245_/C _3534_/A _3202_/B gf180mcu_as_sc_mcu7t3v3__and2_2
XFILLER_164_524 VDD VDD VSS VSS gf180mcu_as_sc_mcu7t3v3__fill_1
XFILLER_176_384 VDD VDD VSS VSS gf180mcu_as_sc_mcu7t3v3__fill_1
X_3888_ VDD VDD VSS VSS _3895_/B _5178_/Q _4928_/D gf180mcu_as_sc_mcu7t3v3__and2_2
X_2839_ VDD VDD VSS VSS _2842_/B _2839_/B _2842_/D gf180mcu_as_sc_mcu7t3v3__nor2_2
XFILLER_192_877 VDD VDD VSS VSS gf180mcu_as_sc_mcu7t3v3__fillcap_4
XFILLER_2_228 VDD VDD VSS VSS gf180mcu_as_sc_mcu7t3v3__fill_2
X_4509_ VDD VDD VSS VSS _4570_/S _5021_/Q _5050_/Q _4510_/B gf180mcu_as_sc_mcu7t3v3__mux2_2
XFILLER_160_763 VDD VDD VSS VSS gf180mcu_as_sc_mcu7t3v3__fillcap_8
XFILLER_8_1301 VDD VDD VSS VSS gf180mcu_as_sc_mcu7t3v3__fill_2
Xfanout510 VDD VDD VSS VSS _3739_/B _3775_/B gf180mcu_as_sc_mcu7t3v3__buff_12
Xfanout521 VDD VDD VSS VSS _3463_/B _3432_/B gf180mcu_as_sc_mcu7t3v3__buff_12
Xfanout532 VDD VDD VSS VSS _4338_/Y _4590_/C gf180mcu_as_sc_mcu7t3v3__buff_12
XFILLER_76_37 VDD VDD VSS VSS gf180mcu_as_sc_mcu7t3v3__fillcap_4
Xfanout554 VDD VDD VSS VSS _4157_/A _4165_/A gf180mcu_as_sc_mcu7t3v3__buff_12
XTAP_TAPCELL_ROW_183_1714 VDD VSS gf180mcu_as_sc_mcu7t3v3__tap_2
Xfanout587 VDD VDD VSS VSS _4168_/Y _4189_/C gf180mcu_as_sc_mcu7t3v3__buff_12
Xfanout598 VDD VDD VSS VSS _3895_/B _4946_/D gf180mcu_as_sc_mcu7t3v3__buff_12
XTAP_TAPCELL_ROW_183_1725 VDD VSS gf180mcu_as_sc_mcu7t3v3__tap_2
Xmesh_tile_980 VDD VDD VSS VSS north_out[20] gf180mcu_as_sc_mcu7t3v3__tiel_4
Xmesh_tile_991 VDD VDD VSS VSS north_out[31] gf180mcu_as_sc_mcu7t3v3__tiel_4
XFILLER_155_2 VDD VDD VSS VSS gf180mcu_as_sc_mcu7t3v3__fillcap_16
XFILLER_187_616 VDD VDD VSS VSS gf180mcu_as_sc_mcu7t3v3__fillcap_8
XPHY_EDGE_ROW_89_1_Right_598 VDD VSS gf180mcu_as_sc_mcu7t3v3__tap_2
XFILLER_161_1230 VDD VDD VSS VSS gf180mcu_as_sc_mcu7t3v3__fillcap_16
XFILLER_168_863 VDD VDD VSS VSS gf180mcu_as_sc_mcu7t3v3__fill_1
Xwire900 VDD VDD VSS VSS wire900/A _4104_/A gf180mcu_as_sc_mcu7t3v3__clkbuff_12
XFILLER_182_321 VDD VDD VSS VSS gf180mcu_as_sc_mcu7t3v3__fill_2
XFILLER_170_527 VDD VDD VSS VSS gf180mcu_as_sc_mcu7t3v3__fillcap_4
XFILLER_159_1192 VDD VDD VSS VSS gf180mcu_as_sc_mcu7t3v3__fillcap_8
XFILLER_110_104 VDD VDD VSS VSS gf180mcu_as_sc_mcu7t3v3__fill_1
XFILLER_173_72 VDD VDD VSS VSS gf180mcu_as_sc_mcu7t3v3__fillcap_16
XFILLER_2_34 VDD VDD VSS VSS gf180mcu_as_sc_mcu7t3v3__fill_1
XFILLER_81_1264 VDD VDD VSS VSS gf180mcu_as_sc_mcu7t3v3__fillcap_4
XTAP_TAPCELL_ROW_72_1_1025 VDD VSS gf180mcu_as_sc_mcu7t3v3__tap_2
XPHY_EDGE_ROW_139_1_Left_331 VDD VSS gf180mcu_as_sc_mcu7t3v3__tap_2
X_4860_ VDD VDD VSS VSS _5212_/CLK _4860_/D _4860_/Q gf180mcu_as_sc_mcu7t3v3__dfxtp_2
XFILLER_178_638 VDD VDD VSS VSS gf180mcu_as_sc_mcu7t3v3__fill_2
X_3811_ VDD VDD VSS VSS _3924_/A _3811_/B _3811_/A gf180mcu_as_sc_mcu7t3v3__nand2_2
XANTENNA_17 VDD VDD VSS VSS _3995_/B gf180mcu_as_sc_mcu7t3v3__diode_2
XANTENNA_28 VDD VDD VSS VSS _3728_/B gf180mcu_as_sc_mcu7t3v3__diode_2
XANTENNA_39 VDD VDD VSS VSS _4796_/D gf180mcu_as_sc_mcu7t3v3__diode_2
XFILLER_140_1303 VDD VDD VSS VSS gf180mcu_as_sc_mcu7t3v3__fill_1
X_4791_ VDD VDD VSS VSS _5267_/CLK _4791_/D _4791_/Q gf180mcu_as_sc_mcu7t3v3__dfxtp_2
XFILLER_140_1314 VDD VDD VSS VSS gf180mcu_as_sc_mcu7t3v3__fillcap_16
XFILLER_70_2 VDD VDD VSS VSS gf180mcu_as_sc_mcu7t3v3__fill_2
X_3742_ VDD VDD VSS VSS _4118_/D _3781_/S _3742_/C _3742_/D _3743_/C gf180mcu_as_sc_mcu7t3v3__ao211_2
XFILLER_158_384 VDD VDD VSS VSS gf180mcu_as_sc_mcu7t3v3__fill_1
XFILLER_174_855 VDD VDD VSS VSS gf180mcu_as_sc_mcu7t3v3__fillcap_16
XFILLER_9_372 VDD VDD VSS VSS gf180mcu_as_sc_mcu7t3v3__fill_2
X_3673_ VDD VDD VSS VSS _4048_/A _3726_/B _3673_/C _4048_/D _3674_/D gf180mcu_as_sc_mcu7t3v3__ao22_2
XFILLER_174_877 VDD VDD VSS VSS gf180mcu_as_sc_mcu7t3v3__fillcap_16
X_2624_ VDD VDD VSS VSS _2631_/C _2624_/B _2624_/C _2831_/A _2627_/C gf180mcu_as_sc_mcu7t3v3__ao211_2
XFILLER_12_1096 VDD VDD VSS VSS gf180mcu_as_sc_mcu7t3v3__fillcap_8
XFILLER_173_387 VDD VDD VSS VSS gf180mcu_as_sc_mcu7t3v3__fillcap_8
X_2555_ VDD VDD VSS VSS _2558_/B _2558_/A _4294_/A gf180mcu_as_sc_mcu7t3v3__and2_2
XFILLER_101_104 VDD VDD VSS VSS gf180mcu_as_sc_mcu7t3v3__fill_1
XFILLER_138_1287 VDD VDD VSS VSS gf180mcu_as_sc_mcu7t3v3__fill_2
X_5274_ VDD VDD VSS VSS _5275_/CLK _5274_/D _5274_/Q gf180mcu_as_sc_mcu7t3v3__dfxtp_2
X_2486_ VDD VDD VSS VSS _2790_/C _2806_/D gf180mcu_as_sc_mcu7t3v3__inv_2
XPHY_EDGE_ROW_189_Left_381 VDD VSS gf180mcu_as_sc_mcu7t3v3__tap_2
XFILLER_173_1189 VDD VDD VSS VSS gf180mcu_as_sc_mcu7t3v3__fill_1
X_4225_ VDD VDD VSS VSS _4254_/B _4227_/B _4227_/C _5061_/Q _5061_/D gf180mcu_as_sc_mcu7t3v3__ao22_2
X_4156_ VDD VDD VSS VSS _4156_/S _4156_/B _4156_/A _4157_/B gf180mcu_as_sc_mcu7t3v3__mux2_2
X_3107_ VDD VDD VSS VSS _4789_/D _3107_/C _3141_/B _4083_/A gf180mcu_as_sc_mcu7t3v3__aoi21_2
XTAP_TAPCELL_ROW_161_1308 VDD VSS gf180mcu_as_sc_mcu7t3v3__tap_2
XPHY_EDGE_ROW_26_3_Right_67 VDD VSS gf180mcu_as_sc_mcu7t3v3__tap_2
X_4087_ VDD VDD VSS VSS _4087_/A _4160_/C _4129_/C _4934_/Q _4089_/C gf180mcu_as_sc_mcu7t3v3__ao22_2
X_3038_ VDD VDD VSS VSS _4016_/A _3042_/B _3038_/C _3038_/D _3039_/C gf180mcu_as_sc_mcu7t3v3__ao22_2
XFILLER_168_104 VDD VDD VSS VSS gf180mcu_as_sc_mcu7t3v3__fill_1
XFILLER_169_627 VDD VDD VSS VSS gf180mcu_as_sc_mcu7t3v3__fill_2
XFILLER_180_1127 VDD VDD VSS VSS gf180mcu_as_sc_mcu7t3v3__fill_2
XPHY_EDGE_ROW_60_1_Left_252 VDD VSS gf180mcu_as_sc_mcu7t3v3__tap_2
XFILLER_11_338 VDD VDD VSS VSS gf180mcu_as_sc_mcu7t3v3__fillcap_8
X_4989_ VDD VDD VSS VSS clkload2/A _4989_/D _4989_/Q gf180mcu_as_sc_mcu7t3v3__dfxtp_2
XTAP_TAPCELL_ROW_159_1259 VDD VSS gf180mcu_as_sc_mcu7t3v3__tap_2
XFILLER_176_192 VDD VDD VSS VSS gf180mcu_as_sc_mcu7t3v3__fillcap_4
XFILLER_178_1023 VDD VDD VSS VSS gf180mcu_as_sc_mcu7t3v3__fill_1
XFILLER_192_641 VDD VDD VSS VSS gf180mcu_as_sc_mcu7t3v3__fill_1
XTAP_TAPCELL_ROW_176_1595 VDD VSS gf180mcu_as_sc_mcu7t3v3__tap_2
XTAP_TAPCELL_ROW_176_1584 VDD VSS gf180mcu_as_sc_mcu7t3v3__tap_2
XFILLER_164_365 VDD VDD VSS VSS gf180mcu_as_sc_mcu7t3v3__fillcap_8
XFILLER_192_652 VDD VDD VSS VSS gf180mcu_as_sc_mcu7t3v3__fill_1
XFILLER_127_54 VDD VDD VSS VSS gf180mcu_as_sc_mcu7t3v3__fillcap_8
XFILLER_191_1212 VDD VDD VSS VSS gf180mcu_as_sc_mcu7t3v3__fill_2
XPHY_EDGE_ROW_143_3_Left_515 VDD VSS gf180mcu_as_sc_mcu7t3v3__tap_2
Xdelaybuf_1_clk VDD VDD VSS VSS delaybuf_1_clk/A delaybuf_2_clk/A gf180mcu_as_sc_mcu7t3v3__clkbuff_12
XTAP_TAPCELL_ROW_7_832 VDD VSS gf180mcu_as_sc_mcu7t3v3__tap_2
XTAP_TAPCELL_ROW_7_821 VDD VSS gf180mcu_as_sc_mcu7t3v3__tap_2
XFILLER_87_69 VDD VDD VSS VSS gf180mcu_as_sc_mcu7t3v3__fill_1
XFILLER_189_1130 VDD VDD VSS VSS gf180mcu_as_sc_mcu7t3v3__fillcap_4
XFILLER_4_1017 VDD VDD VSS VSS gf180mcu_as_sc_mcu7t3v3__fillcap_4
XFILLER_185_1049 VDD VDD VSS VSS gf180mcu_as_sc_mcu7t3v3__fill_1
XTAP_TAPCELL_ROW_133_1_1086 VDD VSS gf180mcu_as_sc_mcu7t3v3__tap_2
XFILLER_163_1314 VDD VDD VSS VSS gf180mcu_as_sc_mcu7t3v3__fillcap_4
XFILLER_188_947 VDD VDD VSS VSS gf180mcu_as_sc_mcu7t3v3__fillcap_4
XFILLER_174_107 VDD VDD VSS VSS gf180mcu_as_sc_mcu7t3v3__fillcap_4
XFILLER_11_872 VDD VDD VSS VSS gf180mcu_as_sc_mcu7t3v3__fillcap_8
XFILLER_156_844 VDD VDD VSS VSS gf180mcu_as_sc_mcu7t3v3__fillcap_16
Xinput15 VDD VDD VSS VSS boot_data[3] _2708_/A gf180mcu_as_sc_mcu7t3v3__buff_12
Xinput26 VDD VDD VSS VSS dft_addr[3] _2641_/B gf180mcu_as_sc_mcu7t3v3__buff_12
Xinput37 VDD VDD VSS VSS dft_wdata[2] _2702_/B gf180mcu_as_sc_mcu7t3v3__buff_12
XFILLER_156_877 VDD VDD VSS VSS gf180mcu_as_sc_mcu7t3v3__fillcap_16
Xinput48 VDD VDD VSS VSS east_in[13] _4040_/A gf180mcu_as_sc_mcu7t3v3__buff_12
Xinput59 VDD VDD VSS VSS east_in[23] _4121_/A gf180mcu_as_sc_mcu7t3v3__buff_12
XTAP_TAPCELL_ROW_91_3_2002 VDD VSS gf180mcu_as_sc_mcu7t3v3__tap_2
XFILLER_155_376 VDD VDD VSS VSS gf180mcu_as_sc_mcu7t3v3__fillcap_4
XFILLER_170_313 VDD VDD VSS VSS gf180mcu_as_sc_mcu7t3v3__fill_2
Xwire796 VDD VDD VSS VSS _5480_/A _4694_/B gf180mcu_as_sc_mcu7t3v3__clkbuff_12
XPHY_EDGE_ROW_75_3_Left_447 VDD VSS gf180mcu_as_sc_mcu7t3v3__tap_2
XFILLER_83_1326 VDD VDD VSS VSS gf180mcu_as_sc_mcu7t3v3__fill_2
X_4010_ VDD VDD VSS VSS _4106_/S _4010_/B _4010_/A _4011_/B gf180mcu_as_sc_mcu7t3v3__mux2_2
XFILLER_168_1214 VDD VDD VSS VSS gf180mcu_as_sc_mcu7t3v3__fill_1
XFILLER_179_903 VDD VDD VSS VSS gf180mcu_as_sc_mcu7t3v3__fillcap_4
X_4912_ VDD VDD VSS VSS _5095_/CLK _4912_/D _4912_/Q gf180mcu_as_sc_mcu7t3v3__dfxtp_2
XFILLER_178_457 VDD VDD VSS VSS gf180mcu_as_sc_mcu7t3v3__fill_1
X_4843_ VDD VDD VSS VSS _5150_/CLK _4843_/D _4843_/Q gf180mcu_as_sc_mcu7t3v3__dfxtp_2
X_4774_ VDD VDD VSS VSS _5152_/CLK _4774_/D _4774_/Q gf180mcu_as_sc_mcu7t3v3__dfxtp_2
XFILLER_144_1291 VDD VDD VSS VSS gf180mcu_as_sc_mcu7t3v3__fillcap_16
X_3725_ VDD VDD VSS VSS _3726_/C _4101_/A _3725_/B _3725_/C gf180mcu_as_sc_mcu7t3v3__ao21_2
XFILLER_179_1332 VDD VDD VSS VSS gf180mcu_as_sc_mcu7t3v3__fillcap_16
XFILLER_179_1354 VDD VDD VSS VSS gf180mcu_as_sc_mcu7t3v3__fill_1
XFILLER_9_180 VDD VDD VSS VSS gf180mcu_as_sc_mcu7t3v3__fill_2
X_3656_ VDD VDD VSS VSS _4030_/D _3724_/B _3727_/C _4031_/A _3657_/D gf180mcu_as_sc_mcu7t3v3__ao22_2
XTAP_TAPCELL_ROW_154_1178 VDD VSS gf180mcu_as_sc_mcu7t3v3__tap_2
XTAP_TAPCELL_ROW_154_1167 VDD VSS gf180mcu_as_sc_mcu7t3v3__tap_2
XFILLER_162_869 VDD VDD VSS VSS gf180mcu_as_sc_mcu7t3v3__fillcap_4
X_3587_ VDD VDD VSS VSS _3953_/A _3652_/D _3587_/C _3587_/Y _3654_/D gf180mcu_as_sc_mcu7t3v3__aoi211_2
X_2607_ VDD VDD VSS VSS _2734_/S _2699_/A _2735_/A gf180mcu_as_sc_mcu7t3v3__and2_2
XTAP_TAPCELL_ROW_171_1492 VDD VSS gf180mcu_as_sc_mcu7t3v3__tap_2
XFILLER_0_518 VDD VDD VSS VSS gf180mcu_as_sc_mcu7t3v3__fill_1
XFILLER_161_368 VDD VDD VSS VSS gf180mcu_as_sc_mcu7t3v3__fillcap_16
X_2538_ VDD VDD VSS VSS _4365_/A _2538_/A _2539_/A gf180mcu_as_sc_mcu7t3v3__xnor2_2
X_5257_ VDD VDD VSS VSS _5280_/CLK _5257_/D _5257_/Q gf180mcu_as_sc_mcu7t3v3__dfxtp_2
X_4208_ VDD VDD VSS VSS _4237_/B _4217_/B _4218_/C _5044_/Q _5044_/D gf180mcu_as_sc_mcu7t3v3__ao22_2
X_2469_ VDD VDD VSS VSS _2472_/C _2469_/C _5063_/Q _4341_/S gf180mcu_as_sc_mcu7t3v3__aoi21b_2
X_5188_ VDD VDD VSS VSS _5188_/CLK _5188_/D _5188_/Q gf180mcu_as_sc_mcu7t3v3__dfxtp_2
X_4139_ VDD VDD VSS VSS _4139_/A _4155_/B _4139_/C _4139_/D _4140_/B gf180mcu_as_sc_mcu7t3v3__ao211_2
XFILLER_147_1309 VDD VDD VSS VSS gf180mcu_as_sc_mcu7t3v3__fillcap_8
XFILLER_73_27 VDD VDD VSS VSS gf180mcu_as_sc_mcu7t3v3__fillcap_4
XTAP_TAPCELL_ROW_178_1624 VDD VSS gf180mcu_as_sc_mcu7t3v3__tap_2
XTAP_TAPCELL_ROW_178_1635 VDD VSS gf180mcu_as_sc_mcu7t3v3__tap_2
XFILLER_132_4 VDD VDD VSS VSS gf180mcu_as_sc_mcu7t3v3__fill_1
XFILLER_185_928 VDD VDD VSS VSS gf180mcu_as_sc_mcu7t3v3__fillcap_4
XFILLER_36_1350 VDD VDD VSS VSS gf180mcu_as_sc_mcu7t3v3__fillcap_4
XTAP_TAPCELL_ROW_191_1868 VDD VSS gf180mcu_as_sc_mcu7t3v3__tap_2
XFILLER_138_53 VDD VDD VSS VSS gf180mcu_as_sc_mcu7t3v3__fillcap_4
XFILLER_138_86 VDD VDD VSS VSS gf180mcu_as_sc_mcu7t3v3__fill_1
XFILLER_152_324 VDD VDD VSS VSS gf180mcu_as_sc_mcu7t3v3__fillcap_16
XFILLER_165_685 VDD VDD VSS VSS gf180mcu_as_sc_mcu7t3v3__fillcap_4
XFILLER_192_471 VDD VDD VSS VSS gf180mcu_as_sc_mcu7t3v3__fill_1
XFILLER_192_482 VDD VDD VSS VSS gf180mcu_as_sc_mcu7t3v3__fill_1
XTAP_TAPCELL_ROW_191_1879 VDD VSS gf180mcu_as_sc_mcu7t3v3__tap_2
XFILLER_98_57 VDD VDD VSS VSS gf180mcu_as_sc_mcu7t3v3__fill_1
XFILLER_152_1004 VDD VDD VSS VSS gf180mcu_as_sc_mcu7t3v3__fillcap_4
XFILLER_152_1048 VDD VDD VSS VSS gf180mcu_as_sc_mcu7t3v3__fillcap_4
XFILLER_47_72 VDD VDD VSS VSS gf180mcu_as_sc_mcu7t3v3__fillcap_4
XFILLER_163_1122 VDD VDD VSS VSS gf180mcu_as_sc_mcu7t3v3__fill_2
XFILLER_188_711 VDD VDD VSS VSS gf180mcu_as_sc_mcu7t3v3__fill_1
XTAP_TAPCELL_ROW_67_1_1020 VDD VSS gf180mcu_as_sc_mcu7t3v3__tap_2
XFILLER_128_1264 VDD VDD VSS VSS gf180mcu_as_sc_mcu7t3v3__fill_2
XFILLER_128_1286 VDD VDD VSS VSS gf180mcu_as_sc_mcu7t3v3__fill_2
XFILLER_175_405 VDD VDD VSS VSS gf180mcu_as_sc_mcu7t3v3__fill_1
XFILLER_175_438 VDD VDD VSS VSS gf180mcu_as_sc_mcu7t3v3__fillcap_4
XFILLER_191_909 VDD VDD VSS VSS gf180mcu_as_sc_mcu7t3v3__fill_1
XFILLER_8_66 VDD VDD VSS VSS gf180mcu_as_sc_mcu7t3v3__fill_1
XFILLER_8_77 VDD VDD VSS VSS gf180mcu_as_sc_mcu7t3v3__fill_1
X_3510_ VDD VDD VSS VSS _3510_/D _3510_/A _3818_/B _3510_/C _3511_/D gf180mcu_as_sc_mcu7t3v3__ao31_2
XFILLER_7_684 VDD VDD VSS VSS gf180mcu_as_sc_mcu7t3v3__fillcap_16
X_4490_ VDD VDD VSS VSS _4491_/D _4490_/B _4572_/A gf180mcu_as_sc_mcu7t3v3__nor2_2
X_3441_ VDD VDD VSS VSS _4096_/D _3503_/B _3441_/C _3501_/C _3443_/C gf180mcu_as_sc_mcu7t3v3__ao211_2
X_3372_ VDD VDD VSS VSS _4021_/D _3372_/B _3372_/C _3372_/D _3373_/A gf180mcu_as_sc_mcu7t3v3__ao22_2
X_5111_ VDD VDD VSS VSS _5188_/CLK _5111_/D _5111_/Q gf180mcu_as_sc_mcu7t3v3__dfxtp_2
X_5042_ VDD VDD VSS VSS clkload9/A _5042_/D _5042_/Q gf180mcu_as_sc_mcu7t3v3__dfxtp_2
XFILLER_168_1033 VDD VDD VSS VSS gf180mcu_as_sc_mcu7t3v3__fillcap_16
XTAP_TAPCELL_ROW_87_3_1998 VDD VSS gf180mcu_as_sc_mcu7t3v3__tap_2
XFILLER_0_1223 VDD VDD VSS VSS gf180mcu_as_sc_mcu7t3v3__fill_1
XFILLER_168_1055 VDD VDD VSS VSS gf180mcu_as_sc_mcu7t3v3__fill_1
XFILLER_168_1066 VDD VDD VSS VSS gf180mcu_as_sc_mcu7t3v3__fillcap_16
XFILLER_168_1099 VDD VDD VSS VSS gf180mcu_as_sc_mcu7t3v3__fillcap_16
XFILLER_0_1289 VDD VDD VSS VSS gf180mcu_as_sc_mcu7t3v3__fill_2
XFILLER_178_243 VDD VDD VSS VSS gf180mcu_as_sc_mcu7t3v3__fill_2
XFILLER_107_1326 VDD VDD VSS VSS gf180mcu_as_sc_mcu7t3v3__fillcap_4
X_4826_ VDD VDD VSS VSS clkload6/A _4826_/D _4826_/Q gf180mcu_as_sc_mcu7t3v3__dfxtp_2
XTAP_TAPCELL_ROW_156_1207 VDD VSS gf180mcu_as_sc_mcu7t3v3__tap_2
XFILLER_166_449 VDD VDD VSS VSS gf180mcu_as_sc_mcu7t3v3__fillcap_4
XTAP_TAPCELL_ROW_156_1218 VDD VSS gf180mcu_as_sc_mcu7t3v3__tap_2
XFILLER_181_419 VDD VDD VSS VSS gf180mcu_as_sc_mcu7t3v3__fill_1
X_4757_ VDD VDD VSS VSS _5285_/CLK _4757_/D _4757_/Q gf180mcu_as_sc_mcu7t3v3__dfxtp_2
XTAP_TAPCELL_ROW_173_1532 VDD VSS gf180mcu_as_sc_mcu7t3v3__tap_2
XFILLER_175_18 VDD VDD VSS VSS gf180mcu_as_sc_mcu7t3v3__fillcap_16
X_4688_ VDD VDD VSS VSS _4731_/B _5123_/Q _4723_/A gf180mcu_as_sc_mcu7t3v3__and2_2
X_3708_ VDD VDD VSS VSS _4088_/A _3779_/B _3748_/C _4087_/A _3709_/C gf180mcu_as_sc_mcu7t3v3__ao22_2
XFILLER_174_493 VDD VDD VSS VSS gf180mcu_as_sc_mcu7t3v3__fillcap_8
X_3639_ VDD VDD VSS VSS _4848_/D _3639_/C _3654_/B _3639_/A gf180mcu_as_sc_mcu7t3v3__aoi21_2
XFILLER_161_176 VDD VDD VSS VSS gf180mcu_as_sc_mcu7t3v3__fill_2
XFILLER_1_838 VDD VDD VSS VSS gf180mcu_as_sc_mcu7t3v3__fill_2
Xinput205 VDD VDD VSS VSS se_in[31] _3514_/A gf180mcu_as_sc_mcu7t3v3__buff_12
Xinput216 VDD VDD VSS VSS south_in[10] _4013_/D gf180mcu_as_sc_mcu7t3v3__buff_12
Xinput227 VDD VDD VSS VSS south_in[20] _4096_/D gf180mcu_as_sc_mcu7t3v3__buff_12
Xinput238 VDD VDD VSS VSS south_in[30] _3796_/D gf180mcu_as_sc_mcu7t3v3__buff_12
Xinput249 VDD VDD VSS VSS sw_in[0] _2955_/A gf180mcu_as_sc_mcu7t3v3__buff_12
XFILLER_186_1133 VDD VDD VSS VSS gf180mcu_as_sc_mcu7t3v3__fillcap_16
XFILLER_189_519 VDD VDD VSS VSS gf180mcu_as_sc_mcu7t3v3__fill_2
X_4901__1067 VDD VDD VSS VSS _4901_/D gf180mcu_as_sc_mcu7t3v3__tiel_4
XFILLER_169_298 VDD VDD VSS VSS gf180mcu_as_sc_mcu7t3v3__fillcap_16
XTAP_TAPCELL_ROW_128_1_1081 VDD VSS gf180mcu_as_sc_mcu7t3v3__tap_2
XFILLER_149_74 VDD VDD VSS VSS gf180mcu_as_sc_mcu7t3v3__fill_1
XFILLER_173_909 VDD VDD VSS VSS gf180mcu_as_sc_mcu7t3v3__fill_1
XPHY_EDGE_ROW_23_1_Left_215 VDD VSS gf180mcu_as_sc_mcu7t3v3__tap_2
XFILLER_180_441 VDD VDD VSS VSS gf180mcu_as_sc_mcu7t3v3__fillcap_4
XPHY_EDGE_ROW_148_1_Left_340 VDD VSS gf180mcu_as_sc_mcu7t3v3__tap_2
XFILLER_152_154 VDD VDD VSS VSS gf180mcu_as_sc_mcu7t3v3__fillcap_16
XFILLER_158_1257 VDD VDD VSS VSS gf180mcu_as_sc_mcu7t3v3__fillcap_8
XFILLER_3_142 VDD VDD VSS VSS gf180mcu_as_sc_mcu7t3v3__fillcap_4
XFILLER_152_198 VDD VDD VSS VSS gf180mcu_as_sc_mcu7t3v3__fillcap_4
XFILLER_3_186 VDD VDD VSS VSS gf180mcu_as_sc_mcu7t3v3__fill_1
XTAP_TAPCELL_ROW_100_3_2011 VDD VSS gf180mcu_as_sc_mcu7t3v3__tap_2
XFILLER_181_72 VDD VDD VSS VSS gf180mcu_as_sc_mcu7t3v3__fillcap_16
X_3990_ VDD VDD VSS VSS _3990_/A _4023_/B _4023_/C _4922_/Q _3991_/D gf180mcu_as_sc_mcu7t3v3__ao22_2
X_2941_ VDD VDD VSS VSS _3817_/C _3515_/A _3524_/A gf180mcu_as_sc_mcu7t3v3__nor2_2
XFILLER_175_235 VDD VDD VSS VSS gf180mcu_as_sc_mcu7t3v3__fill_1
X_4611_ VDD VDD VSS VSS _5205_/Q _4611_/B _4611_/C _5206_/Q _5205_/D gf180mcu_as_sc_mcu7t3v3__ao22_2
X_2872_ VDD VDD VSS VSS _4767_/Q _2882_/A _2873_/D gf180mcu_as_sc_mcu7t3v3__xnor2_2
XPHY_EDGE_ROW_19_3_Left_391 VDD VSS gf180mcu_as_sc_mcu7t3v3__tap_2
XFILLER_141_1272 VDD VDD VSS VSS gf180mcu_as_sc_mcu7t3v3__fillcap_8
XFILLER_175_279 VDD VDD VSS VSS gf180mcu_as_sc_mcu7t3v3__fill_1
X_4542_ VDD VDD VSS VSS _4546_/B _5083_/Q _4559_/S gf180mcu_as_sc_mcu7t3v3__nand2_2
XFILLER_102_1256 VDD VDD VSS VSS gf180mcu_as_sc_mcu7t3v3__fillcap_4
XFILLER_171_430 VDD VDD VSS VSS gf180mcu_as_sc_mcu7t3v3__fill_1
XFILLER_172_942 VDD VDD VSS VSS gf180mcu_as_sc_mcu7t3v3__fill_2
XFILLER_183_290 VDD VDD VSS VSS gf180mcu_as_sc_mcu7t3v3__fillcap_4
X_4473_ VDD VDD VSS VSS _4476_/C _4988_/Q _4473_/A gf180mcu_as_sc_mcu7t3v3__nand2b_2
XPHY_EDGE_ROW_35_3_Right_76 VDD VSS gf180mcu_as_sc_mcu7t3v3__tap_2
X_3424_ VDD VDD VSS VSS _4075_/A _3424_/B _3424_/C _4822_/D _3580_/D gf180mcu_as_sc_mcu7t3v3__aoi211_2
Xsram2048.u_bank1 _2672_/Y _2668_/Y _2664_/Y _2657_/Y _2650_/Y _2641_/Y _2629_/Y _2610_/Y
+ _2604_/Y hold1142/Y clkbuf_1_1__f_clk/Y _2737_/Y _2730_/Y _2723_/Y _2716_/Y _2709_/Y
+ _2702_/Y _2693_/Y _2686_/Y _2832_/Y _2744_/B _2743_/B _2742_/B _2741_/B _2740_/B
+ _2739_/B _2738_/B _2478_/B VDD VSS sram2048.u_bank1/WEN[7] sram2048.u_bank1/WEN[6]
+ sram2048.u_bank1/WEN[5] sram2048.u_bank1/WEN[4] sram2048.u_bank1/WEN[3] sram2048.u_bank1/WEN[2]
+ sram2048.u_bank1/WEN[1] sram2048.u_bank1/WEN[0] _2676_/Y gf180mcu_ocd_ip_sram__sram1024x8m8wm1
X_3355_ VDD VDD VSS VSS _3386_/D _4006_/D _3356_/D gf180mcu_as_sc_mcu7t3v3__and2_2
Xhold1104 VDD VDD VSS VSS hold1140/Y _2588_/A gf180mcu_as_sc_mcu7t3v3__clkbuff_4
Xhold1115 VDD VDD VSS VSS hold1148/Y _4961_/D gf180mcu_as_sc_mcu7t3v3__clkbuff_4
X_3286_ VDD VDD VSS VSS _3286_/Y _3286_/B _3526_/C gf180mcu_as_sc_mcu7t3v3__nor2_2
X_5025_ VDD VDD VSS VSS _5182_/CLK _5025_/D _5025_/Q gf180mcu_as_sc_mcu7t3v3__dfxtp_2
Xhold1126 VDD VDD VSS VSS _4950_/Q _2589_/C gf180mcu_as_sc_mcu7t3v3__clkbuff_4
Xhold1137 VDD VDD VSS VSS _2580_/Y _2581_/D gf180mcu_as_sc_mcu7t3v3__clkbuff_4
Xhold1148 VDD VDD VSS VSS _4962_/Q hold1148/Y gf180mcu_as_sc_mcu7t3v3__clkbuff_4
XFILLER_22_1268 VDD VDD VSS VSS gf180mcu_as_sc_mcu7t3v3__fillcap_4
XTAP_TAPCELL_ROW_166_1391 VDD VSS gf180mcu_as_sc_mcu7t3v3__tap_2
XFILLER_0_1053 VDD VDD VSS VSS gf180mcu_as_sc_mcu7t3v3__fill_1
XTAP_TAPCELL_ROW_35_3_1946 VDD VSS gf180mcu_as_sc_mcu7t3v3__tap_2
XFILLER_155_909 VDD VDD VSS VSS gf180mcu_as_sc_mcu7t3v3__fill_1
X_4809_ VDD VDD VSS VSS clkload3/A _4809_/D _4809_/Q gf180mcu_as_sc_mcu7t3v3__dfxtp_2
XFILLER_120_1323 VDD VDD VSS VSS gf180mcu_as_sc_mcu7t3v3__fillcap_4
XFILLER_175_780 VDD VDD VSS VSS gf180mcu_as_sc_mcu7t3v3__fill_1
XFILLER_182_728 VDD VDD VSS VSS gf180mcu_as_sc_mcu7t3v3__fillcap_4
XFILLER_192_1181 VDD VDD VSS VSS gf180mcu_as_sc_mcu7t3v3__fill_2
XFILLER_192_1192 VDD VDD VSS VSS gf180mcu_as_sc_mcu7t3v3__fill_1
XFILLER_118_1274 VDD VDD VSS VSS gf180mcu_as_sc_mcu7t3v3__fill_1
XFILLER_95_47 VDD VDD VSS VSS gf180mcu_as_sc_mcu7t3v3__fillcap_8
XTAP_TAPCELL_ROW_186_1789 VDD VSS gf180mcu_as_sc_mcu7t3v3__tap_2
XTAP_TAPCELL_ROW_186_1778 VDD VSS gf180mcu_as_sc_mcu7t3v3__tap_2
XFILLER_185_2 VDD VDD VSS VSS gf180mcu_as_sc_mcu7t3v3__fillcap_16
XFILLER_151_53 VDD VDD VSS VSS gf180mcu_as_sc_mcu7t3v3__fill_2
Xclkbuf_leaf_15_clk_regs VDD VDD VSS VSS clkbuf_3_6__f_clk_regs/Y _5181_/CLK gf180mcu_as_sc_mcu7t3v3__clkbuff_12
XPHY_EDGE_ROW_84_3_Left_456 VDD VSS gf180mcu_as_sc_mcu7t3v3__tap_2
XFILLER_189_349 VDD VDD VSS VSS gf180mcu_as_sc_mcu7t3v3__fill_1
XTAP_TAPCELL_ROW_0_690 VDD VSS gf180mcu_as_sc_mcu7t3v3__tap_2
XFILLER_160_1103 VDD VDD VSS VSS gf180mcu_as_sc_mcu7t3v3__fill_1
XFILLER_164_1261 VDD VDD VSS VSS gf180mcu_as_sc_mcu7t3v3__fillcap_8
XFILLER_38_1264 VDD VDD VSS VSS gf180mcu_as_sc_mcu7t3v3__fill_2
XFILLER_125_1256 VDD VDD VSS VSS gf180mcu_as_sc_mcu7t3v3__fillcap_8
XFILLER_12_263 VDD VDD VSS VSS gf180mcu_as_sc_mcu7t3v3__fillcap_16
XFILLER_9_713 VDD VDD VSS VSS gf180mcu_as_sc_mcu7t3v3__fillcap_4
XFILLER_158_769 VDD VDD VSS VSS gf180mcu_as_sc_mcu7t3v3__fillcap_16
XFILLER_9_779 VDD VDD VSS VSS gf180mcu_as_sc_mcu7t3v3__fillcap_16
XFILLER_154_942 VDD VDD VSS VSS gf180mcu_as_sc_mcu7t3v3__fill_2
XFILLER_176_61 VDD VDD VSS VSS gf180mcu_as_sc_mcu7t3v3__fillcap_4
XFILLER_5_12 VDD VDD VSS VSS gf180mcu_as_sc_mcu7t3v3__fill_1
XFILLER_181_772 VDD VDD VSS VSS gf180mcu_as_sc_mcu7t3v3__fillcap_8
XFILLER_5_974 VDD VDD VSS VSS gf180mcu_as_sc_mcu7t3v3__fillcap_4
XFILLER_158_1087 VDD VDD VSS VSS gf180mcu_as_sc_mcu7t3v3__fill_1
XFILLER_4_484 VDD VDD VSS VSS gf180mcu_as_sc_mcu7t3v3__fill_2
XFILLER_5_56 VDD VDD VSS VSS gf180mcu_as_sc_mcu7t3v3__fillcap_8
XFILLER_5_996 VDD VDD VSS VSS gf180mcu_as_sc_mcu7t3v3__fill_1
XPHY_EDGE_ROW_152_Left_344 VDD VSS gf180mcu_as_sc_mcu7t3v3__tap_2
XFILLER_171_1254 VDD VDD VSS VSS gf180mcu_as_sc_mcu7t3v3__fillcap_4
X_3140_ VDD VDD VSS VSS _3738_/D _3194_/S _3140_/B _3140_/C _3141_/C gf180mcu_as_sc_mcu7t3v3__ao31_2
X_3071_ VDD VDD VSS VSS _4049_/A _3130_/B _3071_/C _3071_/D _3072_/C gf180mcu_as_sc_mcu7t3v3__ao22_2
XFILLER_165_1036 VDD VDD VSS VSS gf180mcu_as_sc_mcu7t3v3__fillcap_8
XPHY_EDGE_ROW_161_Left_353 VDD VSS gf180mcu_as_sc_mcu7t3v3__tap_2
X_3973_ VDD VDD VSS VSS _3973_/A _4021_/C _4024_/C _3973_/D _3975_/C gf180mcu_as_sc_mcu7t3v3__ao22_2
XFILLER_17_1326 VDD VDD VSS VSS gf180mcu_as_sc_mcu7t3v3__fill_2
XFILLER_188_382 VDD VDD VSS VSS gf180mcu_as_sc_mcu7t3v3__fill_2
X_2924_ VDD VDD VSS VSS _3530_/B _3512_/A _3521_/A gf180mcu_as_sc_mcu7t3v3__nor2_2
X_2855_ VDD VDD VSS VSS _2856_/B _2875_/B _2855_/A gf180mcu_as_sc_mcu7t3v3__nand2_2
X_4525_ VDD VDD VSS VSS _4529_/B _5081_/Q _4525_/A gf180mcu_as_sc_mcu7t3v3__nand2_2
X_2786_ VDD VDD VSS VSS _4649_/B _2786_/B _2786_/C _2786_/D _2806_/A gf180mcu_as_sc_mcu7t3v3__ao211_2
XFILLER_131_102 VDD VDD VSS VSS gf180mcu_as_sc_mcu7t3v3__fill_2
XFILLER_171_271 VDD VDD VSS VSS gf180mcu_as_sc_mcu7t3v3__fillcap_8
XFILLER_171_282 VDD VDD VSS VSS gf180mcu_as_sc_mcu7t3v3__fill_2
X_4456_ VDD VDD VSS VSS _4456_/S _5015_/Q _5044_/Q _4457_/B gf180mcu_as_sc_mcu7t3v3__mux2_2
XPHY_EDGE_ROW_170_Left_362 VDD VSS gf180mcu_as_sc_mcu7t3v3__tap_2
XFILLER_172_1029 VDD VDD VSS VSS gf180mcu_as_sc_mcu7t3v3__fillcap_8
Xfanout703 VDD VDD VSS VSS _3932_/Y _4101_/C gf180mcu_as_sc_mcu7t3v3__buff_12
Xfanout714 VDD VDD VSS VSS _3928_/Y _4152_/B gf180mcu_as_sc_mcu7t3v3__buff_12
X_4387_ VDD VDD VSS VSS _5166_/Q _4493_/B _4540_/C _5116_/Q _4388_/B gf180mcu_as_sc_mcu7t3v3__ao22_2
X_3407_ VDD VDD VSS VSS _3454_/A _3407_/B _3407_/C _3408_/C gf180mcu_as_sc_mcu7t3v3__nor3_2
XFILLER_105_24 VDD VDD VSS VSS gf180mcu_as_sc_mcu7t3v3__fillcap_4
Xfanout725 VDD VDD VSS VSS _3270_/Y fanout725/Y gf180mcu_as_sc_mcu7t3v3__buff_12
Xfanout758 VDD VDD VSS VSS _3128_/D _3045_/D gf180mcu_as_sc_mcu7t3v3__buff_12
X_3338_ VDD VDD VSS VSS _3419_/B _3338_/B _3991_/A _3339_/C gf180mcu_as_sc_mcu7t3v3__mux2_2
XTAP_TAPCELL_ROW_90_1_1043 VDD VSS gf180mcu_as_sc_mcu7t3v3__tap_2
XTAP_TAPCELL_ROW_168_1442 VDD VSS gf180mcu_as_sc_mcu7t3v3__tap_2
XTAP_TAPCELL_ROW_168_1431 VDD VSS gf180mcu_as_sc_mcu7t3v3__tap_2
XFILLER_105_57 VDD VDD VSS VSS gf180mcu_as_sc_mcu7t3v3__fillcap_8
Xfanout769 VDD VDD VSS VSS _4733_/C _4639_/S gf180mcu_as_sc_mcu7t3v3__buff_12
X_3269_ VDD VDD VSS VSS _4915_/Q _3456_/B _3501_/B _3930_/A _3274_/C gf180mcu_as_sc_mcu7t3v3__ao22_2
XFILLER_2_1137 VDD VDD VSS VSS gf180mcu_as_sc_mcu7t3v3__fill_2
X_5008_ VDD VDD VSS VSS _5182_/CLK _5008_/D _5008_/Q gf180mcu_as_sc_mcu7t3v3__dfxtp_2
XTAP_TAPCELL_ROW_181_1686 VDD VSS gf180mcu_as_sc_mcu7t3v3__tap_2
XFILLER_148_1256 VDD VDD VSS VSS gf180mcu_as_sc_mcu7t3v3__fillcap_8
XFILLER_157_6 VDD VDD VSS VSS gf180mcu_as_sc_mcu7t3v3__fillcap_8
XFILLER_179_360 VDD VDD VSS VSS gf180mcu_as_sc_mcu7t3v3__fill_1
XFILLER_10_712 VDD VDD VSS VSS gf180mcu_as_sc_mcu7t3v3__fill_2
XFILLER_10_734 VDD VDD VSS VSS gf180mcu_as_sc_mcu7t3v3__fill_1
XFILLER_10_756 VDD VDD VSS VSS gf180mcu_as_sc_mcu7t3v3__fill_2
XFILLER_6_727 VDD VDD VSS VSS gf180mcu_as_sc_mcu7t3v3__fillcap_8
XFILLER_10_789 VDD VDD VSS VSS gf180mcu_as_sc_mcu7t3v3__fill_2
XFILLER_163_750 VDD VDD VSS VSS gf180mcu_as_sc_mcu7t3v3__fillcap_16
XFILLER_163_772 VDD VDD VSS VSS gf180mcu_as_sc_mcu7t3v3__fillcap_16
XFILLER_146_53 VDD VDD VSS VSS gf180mcu_as_sc_mcu7t3v3__fillcap_16
XTAP_TAPCELL_ROW_188_1818 VDD VSS gf180mcu_as_sc_mcu7t3v3__tap_2
XFILLER_162_30 VDD VDD VSS VSS gf180mcu_as_sc_mcu7t3v3__fillcap_4
XFILLER_162_52 VDD VDD VSS VSS gf180mcu_as_sc_mcu7t3v3__fillcap_4
XTAP_TAPCELL_ROW_5_793 VDD VSS gf180mcu_as_sc_mcu7t3v3__tap_2
XTAP_TAPCELL_ROW_5_782 VDD VSS gf180mcu_as_sc_mcu7t3v3__tap_2
XFILLER_131_1260 VDD VDD VSS VSS gf180mcu_as_sc_mcu7t3v3__fill_2
XFILLER_162_96 VDD VDD VSS VSS gf180mcu_as_sc_mcu7t3v3__fill_2
XFILLER_79_1320 VDD VDD VSS VSS gf180mcu_as_sc_mcu7t3v3__fillcap_4
XFILLER_166_1301 VDD VDD VSS VSS gf180mcu_as_sc_mcu7t3v3__fill_2
XFILLER_189_146 VDD VDD VSS VSS gf180mcu_as_sc_mcu7t3v3__fill_1
XFILLER_13_550 VDD VDD VSS VSS gf180mcu_as_sc_mcu7t3v3__fill_2
XFILLER_173_503 VDD VDD VSS VSS gf180mcu_as_sc_mcu7t3v3__fillcap_4
XFILLER_185_352 VDD VDD VSS VSS gf180mcu_as_sc_mcu7t3v3__fillcap_16
X_2640_ VDD VDD VSS VSS _2701_/A _2640_/B input5/Y _2641_/A gf180mcu_as_sc_mcu7t3v3__mux2_2
XFILLER_58_4 VDD VDD VSS VSS gf180mcu_as_sc_mcu7t3v3__fill_1
Xoutput317 VDD VDD VSS VSS _5478_/Y dft_rdata[0] gf180mcu_as_sc_mcu7t3v3__buff_12
X_2571_ VDD VDD VSS VSS _2849_/A _2571_/B _2855_/A gf180mcu_as_sc_mcu7t3v3__nor2_2
XFILLER_153_282 VDD VDD VSS VSS gf180mcu_as_sc_mcu7t3v3__fillcap_16
Xoutput339 VDD VDD VSS VSS _4861_/Q east_out[22] gf180mcu_as_sc_mcu7t3v3__buff_12
Xoutput328 VDD VDD VSS VSS _4851_/Q east_out[12] gf180mcu_as_sc_mcu7t3v3__buff_12
X_4310_ VDD VDD VSS VSS _4314_/S _5140_/Q _5139_/Q _5139_/D gf180mcu_as_sc_mcu7t3v3__mux2_2
X_4241_ VDD VDD VSS VSS _4256_/S _4241_/B _5077_/Q _5077_/D gf180mcu_as_sc_mcu7t3v3__mux2_2
X_4172_ VDD VDD VSS VSS _4232_/B _4186_/B _4186_/C _5010_/Q _5010_/D gf180mcu_as_sc_mcu7t3v3__ao22_2
X_3123_ VDD VDD VSS VSS _3141_/B _3123_/B _3123_/C _3124_/C gf180mcu_as_sc_mcu7t3v3__nor3_2
X_3054_ VDD VDD VSS VSS _3129_/B _4927_/Q _3055_/D gf180mcu_as_sc_mcu7t3v3__or2_2
XTAP_TAPCELL_ROW_163_1350 VDD VSS gf180mcu_as_sc_mcu7t3v3__tap_2
XFILLER_1_1192 VDD VDD VSS VSS gf180mcu_as_sc_mcu7t3v3__fillcap_8
X_3956_ VDD VDD VSS VSS _3956_/A _4021_/B _4021_/C _3956_/D _3957_/D gf180mcu_as_sc_mcu7t3v3__ao22_2
XFILLER_177_842 VDD VDD VSS VSS gf180mcu_as_sc_mcu7t3v3__fill_1
X_2907_ VDD VDD VSS VSS _3510_/A _3519_/A _3245_/C gf180mcu_as_sc_mcu7t3v3__or2_2
X_3887_ VDD VDD VSS VSS _3908_/B _5177_/Q _4927_/D gf180mcu_as_sc_mcu7t3v3__and2_2
XFILLER_164_558 VDD VDD VSS VSS gf180mcu_as_sc_mcu7t3v3__fill_1
XFILLER_178_1227 VDD VDD VSS VSS gf180mcu_as_sc_mcu7t3v3__fillcap_8
X_2838_ VDD VDD VSS VSS _2839_/B _2838_/B _5124_/Q gf180mcu_as_sc_mcu7t3v3__nor2_2
X_2769_ VDD VDD VSS VSS _5124_/Q _2838_/B _2845_/B _2770_/D gf180mcu_as_sc_mcu7t3v3__nand3_2
XFILLER_104_102 VDD VDD VSS VSS gf180mcu_as_sc_mcu7t3v3__fill_2
XFILLER_160_731 VDD VDD VSS VSS gf180mcu_as_sc_mcu7t3v3__fillcap_4
XFILLER_191_399 VDD VDD VSS VSS gf180mcu_as_sc_mcu7t3v3__fillcap_16
X_4508_ VDD VDD VSS VSS _4511_/C _4992_/Q _4570_/S gf180mcu_as_sc_mcu7t3v3__nand2b_2
X_4439_ VDD VDD VSS VSS _4440_/D _4439_/B _4581_/A gf180mcu_as_sc_mcu7t3v3__nor2_2
XFILLER_160_786 VDD VDD VSS VSS gf180mcu_as_sc_mcu7t3v3__fill_2
Xfanout500 VDD VDD VSS VSS fanout502/Y _4150_/D gf180mcu_as_sc_mcu7t3v3__buff_12
Xfanout522 VDD VDD VSS VSS _3391_/A _3463_/B gf180mcu_as_sc_mcu7t3v3__buff_12
Xfanout533 VDD VDD VSS VSS _4515_/A _4541_/A gf180mcu_as_sc_mcu7t3v3__buff_12
XFILLER_116_78 VDD VDD VSS VSS gf180mcu_as_sc_mcu7t3v3__fillcap_16
XFILLER_154_1282 VDD VDD VSS VSS gf180mcu_as_sc_mcu7t3v3__fill_1
XFILLER_154_1293 VDD VDD VSS VSS gf180mcu_as_sc_mcu7t3v3__fill_2
Xfanout544 VDD VDD VSS VSS _3927_/Y _4163_/B gf180mcu_as_sc_mcu7t3v3__buff_12
Xfanout555 VDD VDD VSS VSS fanout559/Y _4246_/S gf180mcu_as_sc_mcu7t3v3__buff_12
Xfanout566 VDD VDD VSS VSS _3453_/C _3374_/C gf180mcu_as_sc_mcu7t3v3__buff_12
XTAP_TAPCELL_ROW_183_1715 VDD VSS gf180mcu_as_sc_mcu7t3v3__tap_2
Xfanout577 VDD VDD VSS VSS _3065_/B _3049_/B gf180mcu_as_sc_mcu7t3v3__buff_12
Xfanout588 VDD VDD VSS VSS _4197_/C _4195_/C gf180mcu_as_sc_mcu7t3v3__buff_12
Xfanout599 VDD VDD VSS VSS _3897_/B _3895_/B gf180mcu_as_sc_mcu7t3v3__buff_12
XTAP_TAPCELL_ROW_183_1726 VDD VSS gf180mcu_as_sc_mcu7t3v3__tap_2
XFILLER_115_1288 VDD VDD VSS VSS gf180mcu_as_sc_mcu7t3v3__fillcap_16
XFILLER_132_33 VDD VDD VSS VSS gf180mcu_as_sc_mcu7t3v3__fill_2
XFILLER_132_44 VDD VDD VSS VSS gf180mcu_as_sc_mcu7t3v3__fillcap_4
Xmesh_tile_981 VDD VDD VSS VSS north_out[21] gf180mcu_as_sc_mcu7t3v3__tiel_4
Xmesh_tile_970 VDD VDD VSS VSS north_out[10] gf180mcu_as_sc_mcu7t3v3__tiel_4
XTAP_TAPCELL_ROW_2_730 VDD VSS gf180mcu_as_sc_mcu7t3v3__tap_2
XPHY_EDGE_ROW_32_1_Left_224 VDD VSS gf180mcu_as_sc_mcu7t3v3__tap_2
Xmesh_tile_992 VDD VDD VSS VSS north_out[32] gf180mcu_as_sc_mcu7t3v3__tiel_4
XFILLER_92_37 VDD VDD VSS VSS gf180mcu_as_sc_mcu7t3v3__fillcap_4
XFILLER_148_2 VDD VDD VSS VSS gf180mcu_as_sc_mcu7t3v3__fillcap_16
XFILLER_168_831 VDD VDD VSS VSS gf180mcu_as_sc_mcu7t3v3__fillcap_16
XFILLER_187_628 VDD VDD VSS VSS gf180mcu_as_sc_mcu7t3v3__fill_2
XFILLER_35_1256 VDD VDD VSS VSS gf180mcu_as_sc_mcu7t3v3__fillcap_4
Xwire901 VDD VDD VSS VSS wire901/A _4102_/A gf180mcu_as_sc_mcu7t3v3__clkbuff_12
XFILLER_167_352 VDD VDD VSS VSS gf180mcu_as_sc_mcu7t3v3__fillcap_4
XFILLER_161_1297 VDD VDD VSS VSS gf180mcu_as_sc_mcu7t3v3__fillcap_8
XFILLER_159_1171 VDD VDD VSS VSS gf180mcu_as_sc_mcu7t3v3__fillcap_4
XFILLER_182_377 VDD VDD VSS VSS gf180mcu_as_sc_mcu7t3v3__fill_1
XFILLER_173_40 VDD VDD VSS VSS gf180mcu_as_sc_mcu7t3v3__fill_1
Xclkbuf_leaf_30_clk_regs VDD VDD VSS VSS clkbuf_3_4__f_clk_regs/Y _5152_/CLK gf180mcu_as_sc_mcu7t3v3__clkbuff_12
XPHY_EDGE_ROW_89_1_Left_281 VDD VSS gf180mcu_as_sc_mcu7t3v3__tap_2
XFILLER_166_1131 VDD VDD VSS VSS gf180mcu_as_sc_mcu7t3v3__fillcap_16
XPHY_EDGE_ROW_44_3_Right_85 VDD VSS gf180mcu_as_sc_mcu7t3v3__tap_2
XFILLER_162_1028 VDD VDD VSS VSS gf180mcu_as_sc_mcu7t3v3__fillcap_8
X_4790_ VDD VDD VSS VSS _5267_/CLK _4790_/D _4790_/Q gf180mcu_as_sc_mcu7t3v3__dfxtp_2
X_3810_ VDD VDD VSS VSS _3927_/A _3922_/B _3922_/A gf180mcu_as_sc_mcu7t3v3__nand2_2
XANTENNA_18 VDD VDD VSS VSS _4011_/B gf180mcu_as_sc_mcu7t3v3__diode_2
XANTENNA_29 VDD VDD VSS VSS _4692_/B gf180mcu_as_sc_mcu7t3v3__diode_2
XFILLER_159_842 VDD VDD VSS VSS gf180mcu_as_sc_mcu7t3v3__fillcap_16
X_3741_ VDD VDD VSS VSS _4121_/A _3779_/B _3778_/B _4121_/D _3742_/D gf180mcu_as_sc_mcu7t3v3__ao22_2
XPHY_EDGE_ROW_47_3_Left_419 VDD VSS gf180mcu_as_sc_mcu7t3v3__tap_2
XFILLER_158_374 VDD VDD VSS VSS gf180mcu_as_sc_mcu7t3v3__fillcap_8
XFILLER_174_823 VDD VDD VSS VSS gf180mcu_as_sc_mcu7t3v3__fillcap_4
XFILLER_186_661 VDD VDD VSS VSS gf180mcu_as_sc_mcu7t3v3__fillcap_4
XFILLER_192_108 VDD VDD VSS VSS gf180mcu_as_sc_mcu7t3v3__fill_2
XFILLER_186_694 VDD VDD VSS VSS gf180mcu_as_sc_mcu7t3v3__fillcap_16
X_3672_ VDD VDD VSS VSS _4046_/D _3724_/B _3672_/C _3672_/D _3674_/C gf180mcu_as_sc_mcu7t3v3__ao211_2
XFILLER_63_2 VDD VDD VSS VSS gf180mcu_as_sc_mcu7t3v3__fillcap_4
X_2623_ VDD VDD VSS VSS _2624_/C _2644_/B _5262_/Q gf180mcu_as_sc_mcu7t3v3__nor2_2
XFILLER_173_1102 VDD VDD VSS VSS gf180mcu_as_sc_mcu7t3v3__fillcap_16
X_2554_ VDD VDD VSS VSS _2845_/D _2838_/B _2554_/C _2558_/B _2765_/B gf180mcu_as_sc_mcu7t3v3__aoi31_2
X_5273_ VDD VDD VSS VSS _5275_/CLK _5273_/D _5273_/Q gf180mcu_as_sc_mcu7t3v3__dfxtp_2
X_2485_ VDD VDD VSS VSS _5227_/Q _5226_/Q _2806_/D gf180mcu_as_sc_mcu7t3v3__or2_2
X_4224_ VDD VDD VSS VSS _4253_/B _4228_/B _4228_/C _5060_/Q _5060_/D gf180mcu_as_sc_mcu7t3v3__ao22_2
X_4155_ VDD VDD VSS VSS _4155_/A _4155_/B _4155_/C _4155_/D _4156_/B gf180mcu_as_sc_mcu7t3v3__ao211_2
X_3106_ VDD VDD VSS VSS _3870_/A _3115_/A _3106_/B _3106_/C _3107_/C gf180mcu_as_sc_mcu7t3v3__ao31_2
XFILLER_3_1254 VDD VDD VSS VSS gf180mcu_as_sc_mcu7t3v3__fill_2
X_4086_ VDD VDD VSS VSS _4086_/A _4162_/B _4086_/C _4086_/D _4090_/A gf180mcu_as_sc_mcu7t3v3__ao211_2
XTAP_TAPCELL_ROW_161_1309 VDD VSS gf180mcu_as_sc_mcu7t3v3__tap_2
XFILLER_184_1220 VDD VDD VSS VSS gf180mcu_as_sc_mcu7t3v3__fillcap_4
X_3037_ VDD VDD VSS VSS _3128_/A _3037_/B _3037_/C _3128_/D _3038_/D gf180mcu_as_sc_mcu7t3v3__ao211_2
XFILLER_12_807 VDD VDD VSS VSS gf180mcu_as_sc_mcu7t3v3__fillcap_8
XFILLER_178_18 VDD VDD VSS VSS gf180mcu_as_sc_mcu7t3v3__fillcap_16
XFILLER_184_1297 VDD VDD VSS VSS gf180mcu_as_sc_mcu7t3v3__fillcap_4
XFILLER_168_149 VDD VDD VSS VSS gf180mcu_as_sc_mcu7t3v3__fillcap_16
X_4988_ VDD VDD VSS VSS _5075_/CLK _4988_/D _4988_/Q gf180mcu_as_sc_mcu7t3v3__dfxtp_2
X_3939_ VDD VDD VSS VSS _3939_/A _4022_/B _4027_/B _3944_/C _3939_/D gf180mcu_as_sc_mcu7t3v3__aoi211_2
XFILLER_192_631 VDD VDD VSS VSS gf180mcu_as_sc_mcu7t3v3__fill_2
XTAP_TAPCELL_ROW_176_1596 VDD VSS gf180mcu_as_sc_mcu7t3v3__tap_2
XTAP_TAPCELL_ROW_176_1585 VDD VSS gf180mcu_as_sc_mcu7t3v3__tap_2
XFILLER_121_1292 VDD VDD VSS VSS gf180mcu_as_sc_mcu7t3v3__fillcap_4
XFILLER_178_1057 VDD VDD VSS VSS gf180mcu_as_sc_mcu7t3v3__fill_1
XFILLER_192_686 VDD VDD VSS VSS gf180mcu_as_sc_mcu7t3v3__fill_2
XFILLER_3_527 VDD VDD VSS VSS gf180mcu_as_sc_mcu7t3v3__fill_1
XFILLER_11_99 VDD VDD VSS VSS gf180mcu_as_sc_mcu7t3v3__fill_2
XFILLER_160_561 VDD VDD VSS VSS gf180mcu_as_sc_mcu7t3v3__fillcap_4
XFILLER_87_37 VDD VDD VSS VSS gf180mcu_as_sc_mcu7t3v3__fillcap_4
XTAP_TAPCELL_ROW_7_833 VDD VSS gf180mcu_as_sc_mcu7t3v3__tap_2
XTAP_TAPCELL_ROW_7_822 VDD VSS gf180mcu_as_sc_mcu7t3v3__tap_2
XPHY_EDGE_ROW_93_3_Left_465 VDD VSS gf180mcu_as_sc_mcu7t3v3__tap_2
XFILLER_160_594 VDD VDD VSS VSS gf180mcu_as_sc_mcu7t3v3__fill_1
XFILLER_8_1154 VDD VDD VSS VSS gf180mcu_as_sc_mcu7t3v3__fill_1
XFILLER_143_87 VDD VDD VSS VSS gf180mcu_as_sc_mcu7t3v3__fillcap_16
XPHY_EDGE_ROW_14_1_Right_661 VDD VSS gf180mcu_as_sc_mcu7t3v3__tap_2
XFILLER_36_41 VDD VDD VSS VSS gf180mcu_as_sc_mcu7t3v3__fill_1
XFILLER_163_1348 VDD VDD VSS VSS gf180mcu_as_sc_mcu7t3v3__fillcap_4
XFILLER_187_403 VDD VDD VSS VSS gf180mcu_as_sc_mcu7t3v3__fillcap_16
XFILLER_175_609 VDD VDD VSS VSS gf180mcu_as_sc_mcu7t3v3__fillcap_8
XFILLER_11_884 VDD VDD VSS VSS gf180mcu_as_sc_mcu7t3v3__fill_1
XFILLER_156_823 VDD VDD VSS VSS gf180mcu_as_sc_mcu7t3v3__fillcap_8
XFILLER_168_62 VDD VDD VSS VSS gf180mcu_as_sc_mcu7t3v3__fillcap_16
XFILLER_168_683 VDD VDD VSS VSS gf180mcu_as_sc_mcu7t3v3__fillcap_8
Xinput16 VDD VDD VSS VSS boot_data[4] _2715_/A gf180mcu_as_sc_mcu7t3v3__buff_12
Xinput27 VDD VDD VSS VSS dft_addr[4] _2420_/A gf180mcu_as_sc_mcu7t3v3__buff_12
Xwire720 VDD VDD VSS VSS _3442_/B _3419_/B gf180mcu_as_sc_mcu7t3v3__clkbuff_12
Xwire731 VDD VDD VSS VSS _3268_/Y wire731/Y gf180mcu_as_sc_mcu7t3v3__clkbuff_12
Xwire742 VDD VDD VSS VSS _3704_/B _3728_/B gf180mcu_as_sc_mcu7t3v3__clkbuff_12
XFILLER_171_804 VDD VDD VSS VSS gf180mcu_as_sc_mcu7t3v3__fillcap_4
Xinput38 VDD VDD VSS VSS dft_wdata[3] _2709_/B gf180mcu_as_sc_mcu7t3v3__buff_12
Xinput49 VDD VDD VSS VSS east_in[14] _4046_/D gf180mcu_as_sc_mcu7t3v3__buff_12
Xmax_cap508 VDD VDD VSS VSS fanout507/Y _3731_/B gf180mcu_as_sc_mcu7t3v3__clkbuff_12
XFILLER_171_837 VDD VDD VSS VSS gf180mcu_as_sc_mcu7t3v3__fill_2
XFILLER_182_174 VDD VDD VSS VSS gf180mcu_as_sc_mcu7t3v3__fill_1
Xwire797 VDD VDD VSS VSS _5479_/A _4692_/B gf180mcu_as_sc_mcu7t3v3__clkbuff_12
XFILLER_100_1354 VDD VDD VSS VSS gf180mcu_as_sc_mcu7t3v3__fill_1
XFILLER_35_6 VDD VDD VSS VSS gf180mcu_as_sc_mcu7t3v3__fill_2
XFILLER_93_80 VDD VDD VSS VSS gf180mcu_as_sc_mcu7t3v3__fillcap_4
X_4911_ VDD VDD VSS VSS _5095_/CLK _4911_/D _4911_/Q gf180mcu_as_sc_mcu7t3v3__dfxtp_2
XFILLER_178_403 VDD VDD VSS VSS gf180mcu_as_sc_mcu7t3v3__fillcap_4
X_4842_ VDD VDD VSS VSS _5220_/CLK _4842_/D _4842_/Q gf180mcu_as_sc_mcu7t3v3__dfxtp_2
XFILLER_178_469 VDD VDD VSS VSS gf180mcu_as_sc_mcu7t3v3__fillcap_16
X_4773_ VDD VDD VSS VSS _5150_/CLK _4773_/D _4773_/Q gf180mcu_as_sc_mcu7t3v3__dfxtp_2
XFILLER_144_1281 VDD VDD VSS VSS gf180mcu_as_sc_mcu7t3v3__fillcap_8
XFILLER_159_683 VDD VDD VSS VSS gf180mcu_as_sc_mcu7t3v3__fillcap_16
X_3724_ VDD VDD VSS VSS _4103_/A _3724_/B _3724_/C _4102_/A _3725_/C gf180mcu_as_sc_mcu7t3v3__ao22_2
XFILLER_158_193 VDD VDD VSS VSS gf180mcu_as_sc_mcu7t3v3__fillcap_4
XFILLER_162_804 VDD VDD VSS VSS gf180mcu_as_sc_mcu7t3v3__fill_1
XFILLER_162_815 VDD VDD VSS VSS gf180mcu_as_sc_mcu7t3v3__fill_2
XFILLER_174_664 VDD VDD VSS VSS gf180mcu_as_sc_mcu7t3v3__fill_1
X_3655_ VDD VDD VSS VSS _4927_/Q _3727_/B _3724_/C _4029_/A _3657_/C gf180mcu_as_sc_mcu7t3v3__ao22_2
X_2606_ VDD VDD VSS VSS _2606_/B _4766_/Q _2608_/B gf180mcu_as_sc_mcu7t3v3__xnor2_2
XTAP_TAPCELL_ROW_154_1179 VDD VSS gf180mcu_as_sc_mcu7t3v3__tap_2
XTAP_TAPCELL_ROW_154_1168 VDD VSS gf180mcu_as_sc_mcu7t3v3__tap_2
XFILLER_161_347 VDD VDD VSS VSS gf180mcu_as_sc_mcu7t3v3__fill_2
XFILLER_173_196 VDD VDD VSS VSS gf180mcu_as_sc_mcu7t3v3__fill_2
X_3586_ VDD VDD VSS VSS _3587_/C _3586_/C _3653_/B _3952_/A gf180mcu_as_sc_mcu7t3v3__aoi21_2
XTAP_TAPCELL_ROW_171_1493 VDD VSS gf180mcu_as_sc_mcu7t3v3__tap_2
X_2537_ VDD VDD VSS VSS _4364_/A _4370_/A _4364_/B _4365_/A gf180mcu_as_sc_mcu7t3v3__nand3_2
X_5256_ VDD VDD VSS VSS _5280_/CLK _5256_/D _5256_/Q gf180mcu_as_sc_mcu7t3v3__dfxtp_2
X_2468_ VDD VDD VSS VSS _2469_/C _4341_/S _5034_/Q _4588_/A gf180mcu_as_sc_mcu7t3v3__ao21_2
X_4207_ VDD VDD VSS VSS _4236_/B _4228_/B _4228_/C _5043_/Q _5043_/D gf180mcu_as_sc_mcu7t3v3__ao22_2
XFILLER_5_1327 VDD VDD VSS VSS gf180mcu_as_sc_mcu7t3v3__fill_2
XFILLER_99_1323 VDD VDD VSS VSS gf180mcu_as_sc_mcu7t3v3__fill_1
X_5187_ VDD VDD VSS VSS _5188_/CLK _5187_/D _5187_/Q gf180mcu_as_sc_mcu7t3v3__dfxtp_2
X_2399_ VDD VDD VSS VSS _2802_/A _5227_/Q gf180mcu_as_sc_mcu7t3v3__inv_2
XFILLER_151_1285 VDD VDD VSS VSS gf180mcu_as_sc_mcu7t3v3__fillcap_16
X_4138_ VDD VDD VSS VSS _4138_/A _4153_/B _4151_/C _4138_/D _4139_/D gf180mcu_as_sc_mcu7t3v3__ao22_2
X_4069_ VDD VDD VSS VSS _4069_/A _4160_/B _4161_/B _4069_/D _4070_/D gf180mcu_as_sc_mcu7t3v3__ao22_2
XTAP_TAPCELL_ROW_96_3_2007 VDD VSS gf180mcu_as_sc_mcu7t3v3__tap_2
XFILLER_185_907 VDD VDD VSS VSS gf180mcu_as_sc_mcu7t3v3__fill_2
XTAP_TAPCELL_ROW_178_1636 VDD VSS gf180mcu_as_sc_mcu7t3v3__tap_2
XTAP_TAPCELL_ROW_178_1625 VDD VSS gf180mcu_as_sc_mcu7t3v3__tap_2
XFILLER_178_970 VDD VDD VSS VSS gf180mcu_as_sc_mcu7t3v3__fill_1
XFILLER_71_1264 VDD VDD VSS VSS gf180mcu_as_sc_mcu7t3v3__fillcap_4
XFILLER_71_1297 VDD VDD VSS VSS gf180mcu_as_sc_mcu7t3v3__fill_2
XFILLER_192_461 VDD VDD VSS VSS gf180mcu_as_sc_mcu7t3v3__fill_2
XTAP_TAPCELL_ROW_191_1869 VDD VSS gf180mcu_as_sc_mcu7t3v3__tap_2
XFILLER_152_358 VDD VDD VSS VSS gf180mcu_as_sc_mcu7t3v3__fillcap_16
XFILLER_180_667 VDD VDD VSS VSS gf180mcu_as_sc_mcu7t3v3__fill_2
XFILLER_4_836 VDD VDD VSS VSS gf180mcu_as_sc_mcu7t3v3__fill_1
XFILLER_191_1032 VDD VDD VSS VSS gf180mcu_as_sc_mcu7t3v3__fill_2
XFILLER_98_69 VDD VDD VSS VSS gf180mcu_as_sc_mcu7t3v3__fillcap_8
XFILLER_154_53 VDD VDD VSS VSS gf180mcu_as_sc_mcu7t3v3__fillcap_8
XFILLER_170_30 VDD VDD VSS VSS gf180mcu_as_sc_mcu7t3v3__fillcap_4
XTAP_TAPCELL_ROW_53_3_1964 VDD VSS gf180mcu_as_sc_mcu7t3v3__tap_2
XFILLER_163_1112 VDD VDD VSS VSS gf180mcu_as_sc_mcu7t3v3__fillcap_8
XFILLER_188_734 VDD VDD VSS VSS gf180mcu_as_sc_mcu7t3v3__fill_1
XFILLER_63_72 VDD VDD VSS VSS gf180mcu_as_sc_mcu7t3v3__fillcap_4
XFILLER_163_1189 VDD VDD VSS VSS gf180mcu_as_sc_mcu7t3v3__fill_1
XFILLER_179_72 VDD VDD VSS VSS gf180mcu_as_sc_mcu7t3v3__fillcap_4
XFILLER_8_34 VDD VDD VSS VSS gf180mcu_as_sc_mcu7t3v3__fill_1
XFILLER_183_450 VDD VDD VSS VSS gf180mcu_as_sc_mcu7t3v3__fillcap_4
XFILLER_8_89 VDD VDD VSS VSS gf180mcu_as_sc_mcu7t3v3__fillcap_16
XFILLER_155_163 VDD VDD VSS VSS gf180mcu_as_sc_mcu7t3v3__fill_2
XFILLER_183_461 VDD VDD VSS VSS gf180mcu_as_sc_mcu7t3v3__fillcap_4
X_3440_ VDD VDD VSS VSS _4935_/Q _3456_/B _3501_/B _4095_/A _3441_/C gf180mcu_as_sc_mcu7t3v3__ao22_2
X_3371_ VDD VDD VSS VSS _3419_/B _4024_/A _3372_/D gf180mcu_as_sc_mcu7t3v3__or2_2
XFILLER_170_177 VDD VDD VSS VSS gf180mcu_as_sc_mcu7t3v3__fillcap_16
X_5110_ VDD VDD VSS VSS _5266_/CLK _5110_/D _5110_/Q gf180mcu_as_sc_mcu7t3v3__dfxtp_2
X_5041_ VDD VDD VSS VSS _5178_/CLK _5041_/D _5041_/Q gf180mcu_as_sc_mcu7t3v3__dfxtp_2
XFILLER_168_1012 VDD VDD VSS VSS gf180mcu_as_sc_mcu7t3v3__fill_2
XFILLER_0_1257 VDD VDD VSS VSS gf180mcu_as_sc_mcu7t3v3__fill_1
XFILLER_179_734 VDD VDD VSS VSS gf180mcu_as_sc_mcu7t3v3__fillcap_4
XFILLER_181_1278 VDD VDD VSS VSS gf180mcu_as_sc_mcu7t3v3__fill_2
X_4825_ VDD VDD VSS VSS clkload7/A _4825_/D _4825_/Q gf180mcu_as_sc_mcu7t3v3__dfxtp_2
XFILLER_178_299 VDD VDD VSS VSS gf180mcu_as_sc_mcu7t3v3__fill_1
XPHY_EDGE_ROW_104_1_Left_296 VDD VSS gf180mcu_as_sc_mcu7t3v3__tap_2
XTAP_TAPCELL_ROW_156_1219 VDD VSS gf180mcu_as_sc_mcu7t3v3__tap_2
XTAP_TAPCELL_ROW_156_1208 VDD VSS gf180mcu_as_sc_mcu7t3v3__tap_2
XFILLER_179_1130 VDD VDD VSS VSS gf180mcu_as_sc_mcu7t3v3__fillcap_4
X_4756_ VDD VDD VSS VSS _5280_/CLK _4756_/D _4756_/Q gf180mcu_as_sc_mcu7t3v3__dfxtp_2
XTAP_TAPCELL_ROW_173_1533 VDD VSS gf180mcu_as_sc_mcu7t3v3__tap_2
X_4687_ VDD VDD VSS VSS _4721_/A _4708_/C _4691_/D gf180mcu_as_sc_mcu7t3v3__and2_2
X_3707_ VDD VDD VSS VSS _4857_/D _3707_/C _3723_/B _4083_/A gf180mcu_as_sc_mcu7t3v3__aoi21_2
XFILLER_161_133 VDD VDD VSS VSS gf180mcu_as_sc_mcu7t3v3__fillcap_4
XFILLER_162_645 VDD VDD VSS VSS gf180mcu_as_sc_mcu7t3v3__fillcap_16
XFILLER_190_943 VDD VDD VSS VSS gf180mcu_as_sc_mcu7t3v3__fill_2
XFILLER_190_954 VDD VDD VSS VSS gf180mcu_as_sc_mcu7t3v3__fillcap_8
X_3638_ VDD VDD VSS VSS _3638_/D _3730_/A _3638_/B _3638_/C _3639_/C gf180mcu_as_sc_mcu7t3v3__ao31_2
XPHY_EDGE_ROW_41_1_Left_233 VDD VSS gf180mcu_as_sc_mcu7t3v3__tap_2
XFILLER_108_57 VDD VDD VSS VSS gf180mcu_as_sc_mcu7t3v3__fill_2
XFILLER_162_667 VDD VDD VSS VSS gf180mcu_as_sc_mcu7t3v3__fill_2
Xmax_cap850 VDD VDD VSS VSS fanout849/Y _3848_/A gf180mcu_as_sc_mcu7t3v3__clkbuff_12
X_3569_ VDD VDD VSS VSS _3728_/C _3728_/B _3772_/C gf180mcu_as_sc_mcu7t3v3__and2_2
XFILLER_161_199 VDD VDD VSS VSS gf180mcu_as_sc_mcu7t3v3__fill_1
Xinput206 VDD VDD VSS VSS se_in[32] _3523_/A gf180mcu_as_sc_mcu7t3v3__buff_12
Xinput217 VDD VDD VSS VSS south_in[11] _4024_/D gf180mcu_as_sc_mcu7t3v3__buff_12
X_5239_ VDD VDD VSS VSS _5267_/CLK _5239_/D _5239_/Q gf180mcu_as_sc_mcu7t3v3__dfxtp_2
Xinput228 VDD VDD VSS VSS south_in[21] _4101_/D gf180mcu_as_sc_mcu7t3v3__buff_12
Xinput239 VDD VDD VSS VSS south_in[31] _3253_/A gf180mcu_as_sc_mcu7t3v3__buff_12
XFILLER_124_67 VDD VDD VSS VSS gf180mcu_as_sc_mcu7t3v3__fill_2
XFILLER_187_6 VDD VDD VSS VSS gf180mcu_as_sc_mcu7t3v3__fillcap_16
XFILLER_186_1101 VDD VDD VSS VSS gf180mcu_as_sc_mcu7t3v3__fillcap_4
XFILLER_13_902 VDD VDD VSS VSS gf180mcu_as_sc_mcu7t3v3__fillcap_16
XFILLER_182_1009 VDD VDD VSS VSS gf180mcu_as_sc_mcu7t3v3__fillcap_4
XFILLER_140_77 VDD VDD VSS VSS gf180mcu_as_sc_mcu7t3v3__fillcap_4
XFILLER_169_222 VDD VDD VSS VSS gf180mcu_as_sc_mcu7t3v3__fill_1
XFILLER_158_918 VDD VDD VSS VSS gf180mcu_as_sc_mcu7t3v3__fill_2
XFILLER_185_715 VDD VDD VSS VSS gf180mcu_as_sc_mcu7t3v3__fill_1
XFILLER_149_53 VDD VDD VSS VSS gf180mcu_as_sc_mcu7t3v3__fillcap_16
XFILLER_157_417 VDD VDD VSS VSS gf180mcu_as_sc_mcu7t3v3__fill_2
XFILLER_169_277 VDD VDD VSS VSS gf180mcu_as_sc_mcu7t3v3__fill_2
XFILLER_184_225 VDD VDD VSS VSS gf180mcu_as_sc_mcu7t3v3__fill_2
XFILLER_9_928 VDD VDD VSS VSS gf180mcu_as_sc_mcu7t3v3__fill_1
XFILLER_184_247 VDD VDD VSS VSS gf180mcu_as_sc_mcu7t3v3__fillcap_4
XFILLER_152_133 VDD VDD VSS VSS gf180mcu_as_sc_mcu7t3v3__fill_2
XFILLER_158_1214 VDD VDD VSS VSS gf180mcu_as_sc_mcu7t3v3__fill_1
XFILLER_181_965 VDD VDD VSS VSS gf180mcu_as_sc_mcu7t3v3__fillcap_8
XFILLER_192_280 VDD VDD VSS VSS gf180mcu_as_sc_mcu7t3v3__fill_1
XFILLER_165_41 VDD VDD VSS VSS gf180mcu_as_sc_mcu7t3v3__fill_1
XPHY_EDGE_ROW_98_1_Left_290 VDD VSS gf180mcu_as_sc_mcu7t3v3__tap_2
XPHY_EDGE_ROW_53_3_Right_94 VDD VSS gf180mcu_as_sc_mcu7t3v3__tap_2
XFILLER_0_883 VDD VDD VSS VSS gf180mcu_as_sc_mcu7t3v3__fill_1
XFILLER_0_894 VDD VDD VSS VSS gf180mcu_as_sc_mcu7t3v3__fill_1
XFILLER_134_1291 VDD VDD VSS VSS gf180mcu_as_sc_mcu7t3v3__fillcap_16
XPHY_EDGE_ROW_56_3_Left_428 VDD VSS gf180mcu_as_sc_mcu7t3v3__tap_2
XPHY_EDGE_ROW_101_1_Right_610 VDD VSS gf180mcu_as_sc_mcu7t3v3__tap_2
XFILLER_169_1354 VDD VDD VSS VSS gf180mcu_as_sc_mcu7t3v3__fill_1
X_2940_ VDD VDD VSS VSS _3794_/A _3803_/A _3283_/A gf180mcu_as_sc_mcu7t3v3__or2_2
X_2871_ VDD VDD VSS VSS _4742_/A _2871_/B _2871_/C _4766_/D gf180mcu_as_sc_mcu7t3v3__nor3_2
XFILLER_188_597 VDD VDD VSS VSS gf180mcu_as_sc_mcu7t3v3__fillcap_16
XFILLER_88_4 VDD VDD VSS VSS gf180mcu_as_sc_mcu7t3v3__fill_1
X_4610_ VDD VDD VSS VSS _5204_/Q _4611_/B _4611_/C _5205_/Q _5204_/D gf180mcu_as_sc_mcu7t3v3__ao22_2
XFILLER_54_1281 VDD VDD VSS VSS gf180mcu_as_sc_mcu7t3v3__fillcap_8
XFILLER_11_1107 VDD VDD VSS VSS gf180mcu_as_sc_mcu7t3v3__fill_2
XFILLER_141_1284 VDD VDD VSS VSS gf180mcu_as_sc_mcu7t3v3__fill_2
XFILLER_157_973 VDD VDD VSS VSS gf180mcu_as_sc_mcu7t3v3__fillcap_4
X_4541_ VDD VDD VSS VSS _4541_/B _4541_/A _4548_/C gf180mcu_as_sc_mcu7t3v3__and2_2
X_4472_ VDD VDD VSS VSS _4476_/B _5075_/Q _4473_/A gf180mcu_as_sc_mcu7t3v3__nand2_2
X_3423_ VDD VDD VSS VSS _3462_/A _3423_/B _3423_/C _3424_/C gf180mcu_as_sc_mcu7t3v3__nor3_2
X_3354_ VDD VDD VSS VSS _3356_/C _4007_/A _3370_/B _3354_/C gf180mcu_as_sc_mcu7t3v3__ao21_2
Xhold1105 VDD VDD VSS VSS hold1141/Y hold1142/A gf180mcu_as_sc_mcu7t3v3__clkbuff_4
X_3285_ VDD VDD VSS VSS _3285_/Y _3524_/C _3526_/B gf180mcu_as_sc_mcu7t3v3__nand2_2
X_5024_ VDD VDD VSS VSS clkload2/A _5024_/D _5024_/Q gf180mcu_as_sc_mcu7t3v3__dfxtp_2
Xhold1116 VDD VDD VSS VSS hold1147/Y _4970_/D gf180mcu_as_sc_mcu7t3v3__clkbuff_4
Xhold1127 VDD VDD VSS VSS _2589_/Y _2590_/B gf180mcu_as_sc_mcu7t3v3__clkbuff_4
Xhold1138 VDD VDD VSS VSS _2581_/Y hold1138/Y gf180mcu_as_sc_mcu7t3v3__clkbuff_4
Xhold1149 VDD VDD VSS VSS _4963_/Q hold1149/Y gf180mcu_as_sc_mcu7t3v3__clkbuff_4
XTAP_TAPCELL_ROW_166_1392 VDD VSS gf180mcu_as_sc_mcu7t3v3__tap_2
XFILLER_183_1329 VDD VDD VSS VSS gf180mcu_as_sc_mcu7t3v3__fill_1
XFILLER_179_531 VDD VDD VSS VSS gf180mcu_as_sc_mcu7t3v3__fill_1
XFILLER_181_1042 VDD VDD VSS VSS gf180mcu_as_sc_mcu7t3v3__fill_1
XFILLER_181_1064 VDD VDD VSS VSS gf180mcu_as_sc_mcu7t3v3__fillcap_16
XFILLER_166_247 VDD VDD VSS VSS gf180mcu_as_sc_mcu7t3v3__fill_2
XFILLER_182_707 VDD VDD VSS VSS gf180mcu_as_sc_mcu7t3v3__fill_1
X_4808_ VDD VDD VSS VSS clkload3/A _4808_/D _4808_/Q gf180mcu_as_sc_mcu7t3v3__dfxtp_2
XTAP_TAPCELL_ROW_192_1920 VDD VSS gf180mcu_as_sc_mcu7t3v3__tap_2
X_4739_ VDD VDD VSS VSS _4739_/B _4739_/A _4740_/B gf180mcu_as_sc_mcu7t3v3__or2_2
XTAP_TAPCELL_ROW_105_3_2016 VDD VSS gf180mcu_as_sc_mcu7t3v3__tap_2
XFILLER_134_100 VDD VDD VSS VSS gf180mcu_as_sc_mcu7t3v3__fillcap_4
XFILLER_102_6 VDD VDD VSS VSS gf180mcu_as_sc_mcu7t3v3__fill_2
XFILLER_163_976 VDD VDD VSS VSS gf180mcu_as_sc_mcu7t3v3__fillcap_4
XPHY_EDGE_ROW_140_1_Right_649 VDD VSS gf180mcu_as_sc_mcu7t3v3__tap_2
XFILLER_135_44 VDD VDD VSS VSS gf180mcu_as_sc_mcu7t3v3__fill_1
XFILLER_192_1171 VDD VDD VSS VSS gf180mcu_as_sc_mcu7t3v3__fill_2
XFILLER_153_1199 VDD VDD VSS VSS gf180mcu_as_sc_mcu7t3v3__fillcap_4
XFILLER_188_1218 VDD VDD VSS VSS gf180mcu_as_sc_mcu7t3v3__fillcap_4
XFILLER_95_59 VDD VDD VSS VSS gf180mcu_as_sc_mcu7t3v3__fill_1
XTAP_TAPCELL_ROW_186_1779 VDD VSS gf180mcu_as_sc_mcu7t3v3__tap_2
XFILLER_40_1347 VDD VDD VSS VSS gf180mcu_as_sc_mcu7t3v3__fillcap_8
XFILLER_178_2 VDD VDD VSS VSS gf180mcu_as_sc_mcu7t3v3__fillcap_16
XTAP_TAPCELL_ROW_0_691 VDD VSS gf180mcu_as_sc_mcu7t3v3__tap_2
XTAP_TAPCELL_ROW_0_680 VDD VSS gf180mcu_as_sc_mcu7t3v3__tap_2
XFILLER_12_231 VDD VDD VSS VSS gf180mcu_as_sc_mcu7t3v3__fillcap_8
XFILLER_158_737 VDD VDD VSS VSS gf180mcu_as_sc_mcu7t3v3__fillcap_16
XFILLER_164_1273 VDD VDD VSS VSS gf180mcu_as_sc_mcu7t3v3__fill_2
XFILLER_38_1287 VDD VDD VSS VSS gf180mcu_as_sc_mcu7t3v3__fill_2
XTAP_TAPCELL_ROW_11_900 VDD VSS gf180mcu_as_sc_mcu7t3v3__tap_2
XFILLER_173_718 VDD VDD VSS VSS gf180mcu_as_sc_mcu7t3v3__fillcap_4
XFILLER_185_578 VDD VDD VSS VSS gf180mcu_as_sc_mcu7t3v3__fillcap_8
XFILLER_158_1000 VDD VDD VSS VSS gf180mcu_as_sc_mcu7t3v3__fill_1
XFILLER_166_792 VDD VDD VSS VSS gf180mcu_as_sc_mcu7t3v3__fillcap_4
XFILLER_67_9 VDD VDD VSS VSS gf180mcu_as_sc_mcu7t3v3__fill_1
XFILLER_158_1033 VDD VDD VSS VSS gf180mcu_as_sc_mcu7t3v3__fill_2
XPHY_EDGE_ROW_154_Right_16 VDD VSS gf180mcu_as_sc_mcu7t3v3__tap_2
XFILLER_180_283 VDD VDD VSS VSS gf180mcu_as_sc_mcu7t3v3__fill_1
XFILLER_181_784 VDD VDD VSS VSS gf180mcu_as_sc_mcu7t3v3__fill_2
XFILLER_5_68 VDD VDD VSS VSS gf180mcu_as_sc_mcu7t3v3__fill_2
X_3070_ VDD VDD VSS VSS _3129_/B _4929_/Q _3071_/D gf180mcu_as_sc_mcu7t3v3__or2_2
XFILLER_169_1151 VDD VDD VSS VSS gf180mcu_as_sc_mcu7t3v3__fillcap_4
XFILLER_85_92 VDD VDD VSS VSS gf180mcu_as_sc_mcu7t3v3__fill_2
XPHY_EDGE_ROW_163_Right_25 VDD VSS gf180mcu_as_sc_mcu7t3v3__tap_2
XPHY_EDGE_ROW_102_1_Right_611 VDD VSS gf180mcu_as_sc_mcu7t3v3__tap_2
XFILLER_165_1048 VDD VDD VSS VSS gf180mcu_as_sc_mcu7t3v3__fill_2
X_3972_ VDD VDD VSS VSS _4982_/Q _4076_/B _4233_/B _4076_/D _4982_/D gf180mcu_as_sc_mcu7t3v3__ao22_2
XFILLER_176_512 VDD VDD VSS VSS gf180mcu_as_sc_mcu7t3v3__fill_1
X_2923_ VDD VDD VSS VSS _3791_/A _3800_/A _3531_/A gf180mcu_as_sc_mcu7t3v3__or2_2
X_2854_ VDD VDD VSS VSS _4742_/A _4748_/B _2854_/B _2854_/C gf180mcu_as_sc_mcu7t3v3__ao21_2
XFILLER_176_589 VDD VDD VSS VSS gf180mcu_as_sc_mcu7t3v3__fillcap_4
X_2785_ VDD VDD VSS VSS _5236_/Q _4649_/A _4643_/A _5096_/Q _2786_/B gf180mcu_as_sc_mcu7t3v3__ao22_2
XFILLER_157_792 VDD VDD VSS VSS gf180mcu_as_sc_mcu7t3v3__fill_2
X_4524_ VDD VDD VSS VSS _4524_/B _4524_/A _4531_/C gf180mcu_as_sc_mcu7t3v3__and2_2
XPHY_EDGE_ROW_172_Right_34 VDD VSS gf180mcu_as_sc_mcu7t3v3__tap_2
XFILLER_160_935 VDD VDD VSS VSS gf180mcu_as_sc_mcu7t3v3__fill_1
XFILLER_172_795 VDD VDD VSS VSS gf180mcu_as_sc_mcu7t3v3__fillcap_8
X_4455_ VDD VDD VSS VSS _4458_/C _4986_/Q _4456_/S gf180mcu_as_sc_mcu7t3v3__nand2b_2
Xfanout704 VDD VDD VSS VSS fanout705/A _4159_/C gf180mcu_as_sc_mcu7t3v3__buff_12
Xfanout715 VDD VDD VSS VSS _3724_/C _3648_/C gf180mcu_as_sc_mcu7t3v3__buff_12
X_4386_ VDD VDD VSS VSS _4389_/C _4386_/B _4553_/D gf180mcu_as_sc_mcu7t3v3__nor2_2
X_3406_ VDD VDD VSS VSS _4056_/A _3453_/B _3453_/C _4057_/A _3407_/C gf180mcu_as_sc_mcu7t3v3__ao22_2
Xfanout737 VDD VDD VSS VSS _3727_/B _3648_/B gf180mcu_as_sc_mcu7t3v3__buff_12
Xfanout748 VDD VDD VSS VSS _3127_/C _3044_/C gf180mcu_as_sc_mcu7t3v3__buff_12
X_3337_ VDD VDD VSS VSS _3338_/B _3989_/D _3370_/B _3337_/C gf180mcu_as_sc_mcu7t3v3__ao21_2
XTAP_TAPCELL_ROW_168_1443 VDD VSS gf180mcu_as_sc_mcu7t3v3__tap_2
XTAP_TAPCELL_ROW_168_1432 VDD VSS gf180mcu_as_sc_mcu7t3v3__tap_2
Xfanout759 VDD VDD VSS VSS fanout760/A _3128_/D gf180mcu_as_sc_mcu7t3v3__buff_12
XFILLER_105_69 VDD VDD VSS VSS gf180mcu_as_sc_mcu7t3v3__fill_1
XFILLER_6_1252 VDD VDD VSS VSS gf180mcu_as_sc_mcu7t3v3__fill_1
X_3268_ VDD VDD VSS VSS _3268_/Y _3456_/B _3268_/A gf180mcu_as_sc_mcu7t3v3__nor2_2
XPHY_EDGE_ROW_181_Right_43 VDD VSS gf180mcu_as_sc_mcu7t3v3__tap_2
XFILLER_187_1240 VDD VDD VSS VSS gf180mcu_as_sc_mcu7t3v3__fillcap_4
X_5007_ VDD VDD VSS VSS _5182_/CLK _5007_/D _5007_/Q gf180mcu_as_sc_mcu7t3v3__dfxtp_2
X_3199_ VDD VDD VSS VSS _3199_/B _4943_/Q _3213_/D gf180mcu_as_sc_mcu7t3v3__and2_2
XFILLER_183_1104 VDD VDD VSS VSS gf180mcu_as_sc_mcu7t3v3__fill_2
XFILLER_187_1262 VDD VDD VSS VSS gf180mcu_as_sc_mcu7t3v3__fillcap_16
XTAP_TAPCELL_ROW_181_1687 VDD VSS gf180mcu_as_sc_mcu7t3v3__tap_2
XTAP_TAPCELL_ROW_181_1676 VDD VSS gf180mcu_as_sc_mcu7t3v3__tap_2
XFILLER_121_68 VDD VDD VSS VSS gf180mcu_as_sc_mcu7t3v3__fill_2
XFILLER_148_1268 VDD VDD VSS VSS gf180mcu_as_sc_mcu7t3v3__fill_2
XFILLER_186_309 VDD VDD VSS VSS gf180mcu_as_sc_mcu7t3v3__fillcap_4
XFILLER_14_88 VDD VDD VSS VSS gf180mcu_as_sc_mcu7t3v3__fillcap_4
XPHY_EDGE_ROW_190_Right_52 VDD VSS gf180mcu_as_sc_mcu7t3v3__tap_2
XFILLER_5_216 VDD VDD VSS VSS gf180mcu_as_sc_mcu7t3v3__fill_2
XFILLER_2_923 VDD VDD VSS VSS gf180mcu_as_sc_mcu7t3v3__fill_1
XTAP_TAPCELL_ROW_188_1819 VDD VSS gf180mcu_as_sc_mcu7t3v3__tap_2
XFILLER_1_422 VDD VDD VSS VSS gf180mcu_as_sc_mcu7t3v3__fillcap_8
XFILLER_7_1049 VDD VDD VSS VSS gf180mcu_as_sc_mcu7t3v3__fill_1
XFILLER_44_1291 VDD VDD VSS VSS gf180mcu_as_sc_mcu7t3v3__fillcap_8
XTAP_TAPCELL_ROW_5_783 VDD VSS gf180mcu_as_sc_mcu7t3v3__tap_2
XPHY_EDGE_ROW_129_1_Left_321 VDD VSS gf180mcu_as_sc_mcu7t3v3__tap_2
XTAP_TAPCELL_ROW_5_794 VDD VSS gf180mcu_as_sc_mcu7t3v3__tap_2
XFILLER_13_584 VDD VDD VSS VSS gf180mcu_as_sc_mcu7t3v3__fill_2
XFILLER_71_72 VDD VDD VSS VSS gf180mcu_as_sc_mcu7t3v3__fillcap_4
XFILLER_187_72 VDD VDD VSS VSS gf180mcu_as_sc_mcu7t3v3__fillcap_16
XFILLER_173_559 VDD VDD VSS VSS gf180mcu_as_sc_mcu7t3v3__fill_1
XTAP_TAPCELL_ROW_95_1_1048 VDD VSS gf180mcu_as_sc_mcu7t3v3__tap_2
X_2570_ VDD VDD VSS VSS _5277_/Q _4708_/C _2875_/B _2571_/B gf180mcu_as_sc_mcu7t3v3__nand3_2
XFILLER_4_260 VDD VDD VSS VSS gf180mcu_as_sc_mcu7t3v3__fillcap_4
XFILLER_5_772 VDD VDD VSS VSS gf180mcu_as_sc_mcu7t3v3__fillcap_16
Xoutput329 VDD VDD VSS VSS _4852_/Q east_out[13] gf180mcu_as_sc_mcu7t3v3__buff_12
Xoutput318 VDD VDD VSS VSS _5479_/Y dft_rdata[1] gf180mcu_as_sc_mcu7t3v3__buff_12
XFILLER_173_1328 VDD VDD VSS VSS gf180mcu_as_sc_mcu7t3v3__fill_2
X_4240_ VDD VDD VSS VSS _4246_/S _4240_/B _5076_/Q _5076_/D gf180mcu_as_sc_mcu7t3v3__mux2_2
XFILLER_171_1030 VDD VDD VSS VSS gf180mcu_as_sc_mcu7t3v3__fillcap_4
X_4171_ VDD VDD VSS VSS _4231_/B _4186_/B _4186_/C _5009_/Q _5009_/D gf180mcu_as_sc_mcu7t3v3__ao22_2
XFILLER_171_1052 VDD VDD VSS VSS gf180mcu_as_sc_mcu7t3v3__fillcap_16
X_3122_ VDD VDD VSS VSS _4097_/A _3207_/S _3122_/C _3122_/D _3123_/C gf180mcu_as_sc_mcu7t3v3__ao22_2
XFILLER_171_1096 VDD VDD VSS VSS gf180mcu_as_sc_mcu7t3v3__fillcap_16
XPHY_EDGE_ROW_16_3_Right_57 VDD VSS gf180mcu_as_sc_mcu7t3v3__tap_2
X_3053_ VDD VDD VSS VSS _3128_/A _3053_/B _3053_/C _3128_/D _3055_/C gf180mcu_as_sc_mcu7t3v3__ao211_2
XTAP_TAPCELL_ROW_163_1340 VDD VSS gf180mcu_as_sc_mcu7t3v3__tap_2
XFILLER_110_1345 VDD VDD VSS VSS gf180mcu_as_sc_mcu7t3v3__fill_1
XTAP_TAPCELL_ROW_163_1351 VDD VSS gf180mcu_as_sc_mcu7t3v3__tap_2
XPHY_EDGE_ROW_103_1_Right_612 VDD VSS gf180mcu_as_sc_mcu7t3v3__tap_2
XPHY_EDGE_ROW_50_1_Left_242 VDD VSS gf180mcu_as_sc_mcu7t3v3__tap_2
X_3955_ VDD VDD VSS VSS _4980_/Q _4076_/B _4231_/B _4076_/D _4980_/D gf180mcu_as_sc_mcu7t3v3__ao22_2
X_2906_ VDD VDD VSS VSS _3818_/A _3510_/A _3519_/A gf180mcu_as_sc_mcu7t3v3__nor2_2
XFILLER_176_353 VDD VDD VSS VSS gf180mcu_as_sc_mcu7t3v3__fill_2
X_3886_ VDD VDD VSS VSS _3895_/B _5176_/Q _4926_/D gf180mcu_as_sc_mcu7t3v3__and2_2
Xclkbuf_leaf_0_clk_regs VDD VDD VSS VSS clkbuf_leaf_6_clk_regs/A _4895_/CLK gf180mcu_as_sc_mcu7t3v3__clkbuff_12
X_2837_ VDD VDD VSS VSS _4746_/C _4748_/B gf180mcu_as_sc_mcu7t3v3__inv_2
XFILLER_191_367 VDD VDD VSS VSS gf180mcu_as_sc_mcu7t3v3__fillcap_16
X_2768_ VDD VDD VSS VSS _2792_/A _5227_/Q _2845_/B gf180mcu_as_sc_mcu7t3v3__and2_2
XPHY_EDGE_ROW_133_3_Left_505 VDD VSS gf180mcu_as_sc_mcu7t3v3__tap_2
X_4507_ VDD VDD VSS VSS _4511_/B _5079_/Q _4570_/S gf180mcu_as_sc_mcu7t3v3__nand2_2
X_2699_ VDD VDD VSS VSS _2699_/A _2699_/B _2699_/C _2699_/D _2701_/C gf180mcu_as_sc_mcu7t3v3__ao211_2
X_4438_ VDD VDD VSS VSS _4473_/A _5013_/Q _5042_/Q _4439_/B gf180mcu_as_sc_mcu7t3v3__mux2_2
Xfanout501 VDD VDD VSS VSS fanout502/Y _4158_/D gf180mcu_as_sc_mcu7t3v3__buff_12
Xfanout512 VDD VDD VSS VSS _3729_/B _3653_/B gf180mcu_as_sc_mcu7t3v3__buff_12
Xfanout523 VDD VDD VSS VSS _3477_/B _3454_/A gf180mcu_as_sc_mcu7t3v3__buff_12
XFILLER_28_1286 VDD VDD VSS VSS gf180mcu_as_sc_mcu7t3v3__fill_2
Xfanout534 VDD VDD VSS VSS _4515_/A _4524_/A gf180mcu_as_sc_mcu7t3v3__buff_12
Xfanout545 VDD VDD VSS VSS _3927_/Y _4155_/B gf180mcu_as_sc_mcu7t3v3__buff_12
Xfanout556 VDD VDD VSS VSS fanout559/Y _4257_/S gf180mcu_as_sc_mcu7t3v3__buff_12
X_4369_ VDD VDD VSS VSS _4370_/C _4369_/C _4369_/B _4573_/A gf180mcu_as_sc_mcu7t3v3__aoi21b_2
XFILLER_115_1256 VDD VDD VSS VSS gf180mcu_as_sc_mcu7t3v3__fillcap_16
Xfanout567 VDD VDD VSS VSS _3286_/Y _3390_/C gf180mcu_as_sc_mcu7t3v3__buff_12
Xfanout578 VDD VDD VSS VSS _3041_/B _3065_/B gf180mcu_as_sc_mcu7t3v3__buff_12
Xfanout589 VDD VDD VSS VSS _4168_/Y _4197_/C gf180mcu_as_sc_mcu7t3v3__buff_12
XTAP_TAPCELL_ROW_183_1727 VDD VSS gf180mcu_as_sc_mcu7t3v3__tap_2
XTAP_TAPCELL_ROW_183_1716 VDD VSS gf180mcu_as_sc_mcu7t3v3__tap_2
Xmesh_tile_971 VDD VDD VSS VSS north_out[11] gf180mcu_as_sc_mcu7t3v3__tiel_4
Xmesh_tile_960 VDD VDD VSS VSS north_out[0] gf180mcu_as_sc_mcu7t3v3__tiel_4
XTAP_TAPCELL_ROW_2_731 VDD VSS gf180mcu_as_sc_mcu7t3v3__tap_2
XTAP_TAPCELL_ROW_2_720 VDD VSS gf180mcu_as_sc_mcu7t3v3__tap_2
Xmesh_tile_993 VDD VDD VSS VSS north_out[33] gf180mcu_as_sc_mcu7t3v3__tiel_4
Xmesh_tile_982 VDD VDD VSS VSS north_out[22] gf180mcu_as_sc_mcu7t3v3__tiel_4
XFILLER_187_1070 VDD VDD VSS VSS gf180mcu_as_sc_mcu7t3v3__fillcap_8
X_4877__1091 VDD VDD VSS VSS _4877_/D gf180mcu_as_sc_mcu7t3v3__tiel_4
XFILLER_41_31 VDD VDD VSS VSS gf180mcu_as_sc_mcu7t3v3__fill_2
Xwire902 VDD VDD VSS VSS wire902/A _4061_/A gf180mcu_as_sc_mcu7t3v3__clkbuff_12
XFILLER_157_20 VDD VDD VSS VSS gf180mcu_as_sc_mcu7t3v3__fill_1
XFILLER_183_857 VDD VDD VSS VSS gf180mcu_as_sc_mcu7t3v3__fill_1
XPHY_EDGE_ROW_65_3_Left_437 VDD VSS gf180mcu_as_sc_mcu7t3v3__tap_2
XFILLER_170_507 VDD VDD VSS VSS gf180mcu_as_sc_mcu7t3v3__fill_1
XFILLER_170_518 VDD VDD VSS VSS gf180mcu_as_sc_mcu7t3v3__fillcap_4
XFILLER_155_1036 VDD VDD VSS VSS gf180mcu_as_sc_mcu7t3v3__fill_2
XFILLER_2_720 VDD VDD VSS VSS gf180mcu_as_sc_mcu7t3v3__fill_1
XFILLER_81_1288 VDD VDD VSS VSS gf180mcu_as_sc_mcu7t3v3__fillcap_8
XANTENNA_19 VDD VDD VSS VSS _4011_/B gf180mcu_as_sc_mcu7t3v3__diode_2
X_3740_ VDD VDD VSS VSS _4938_/Q _3770_/B _3748_/C _4120_/A _3742_/C gf180mcu_as_sc_mcu7t3v3__ao22_2
XFILLER_158_353 VDD VDD VSS VSS gf180mcu_as_sc_mcu7t3v3__fill_2
XFILLER_185_150 VDD VDD VSS VSS gf180mcu_as_sc_mcu7t3v3__fill_2
XFILLER_9_352 VDD VDD VSS VSS gf180mcu_as_sc_mcu7t3v3__fillcap_4
X_3671_ VDD VDD VSS VSS _4929_/Q _3727_/B _3724_/C _4045_/A _3672_/D gf180mcu_as_sc_mcu7t3v3__ao22_2
XFILLER_12_1054 VDD VDD VSS VSS gf180mcu_as_sc_mcu7t3v3__fillcap_16
X_2622_ VDD VDD VSS VSS _2644_/B _4655_/B _2695_/A gf180mcu_as_sc_mcu7t3v3__nand2_2
X_2553_ VDD VDD VSS VSS _5222_/Q _4630_/A _2554_/C gf180mcu_as_sc_mcu7t3v3__xnor2_2
XFILLER_138_1256 VDD VDD VSS VSS gf180mcu_as_sc_mcu7t3v3__fillcap_8
XFILLER_173_1169 VDD VDD VSS VSS gf180mcu_as_sc_mcu7t3v3__fill_1
X_5272_ VDD VDD VSS VSS _5275_/CLK _5272_/D _5272_/Q gf180mcu_as_sc_mcu7t3v3__dfxtp_2
X_2484_ VDD VDD VSS VSS _2840_/A _2847_/A _5227_/Q gf180mcu_as_sc_mcu7t3v3__nand2_2
X_4223_ VDD VDD VSS VSS _4252_/B _4227_/B _4227_/C _5059_/Q _5059_/D gf180mcu_as_sc_mcu7t3v3__ao22_2
XFILLER_60_1328 VDD VDD VSS VSS gf180mcu_as_sc_mcu7t3v3__fill_2
X_4154_ VDD VDD VSS VSS _4154_/A _4154_/B _4154_/C _4154_/D _4155_/D gf180mcu_as_sc_mcu7t3v3__ao22_2
X_4085_ VDD VDD VSS VSS _4085_/A _4160_/B _4161_/B _4085_/D _4086_/D gf180mcu_as_sc_mcu7t3v3__ao22_2
X_3105_ VDD VDD VSS VSS _3106_/C _3105_/C _3192_/C _4077_/A gf180mcu_as_sc_mcu7t3v3__aoi21_2
X_3036_ VDD VDD VSS VSS _4014_/A _3127_/B _3127_/C _4013_/D _3037_/C gf180mcu_as_sc_mcu7t3v3__ao22_2
XTAP_TAPCELL_ROW_71_3_1982 VDD VSS gf180mcu_as_sc_mcu7t3v3__tap_2
XFILLER_12_819 VDD VDD VSS VSS gf180mcu_as_sc_mcu7t3v3__fill_1
XFILLER_169_629 VDD VDD VSS VSS gf180mcu_as_sc_mcu7t3v3__fill_1
XFILLER_180_1129 VDD VDD VSS VSS gf180mcu_as_sc_mcu7t3v3__fill_1
XPHY_EDGE_ROW_104_1_Right_613 VDD VSS gf180mcu_as_sc_mcu7t3v3__tap_2
X_4987_ VDD VDD VSS VSS clkload9/A _4987_/D _4987_/Q gf180mcu_as_sc_mcu7t3v3__dfxtp_2
X_3938_ VDD VDD VSS VSS _3938_/A _4021_/B _4021_/C _3938_/D _3939_/D gf180mcu_as_sc_mcu7t3v3__ao22_2
XFILLER_165_846 VDD VDD VSS VSS gf180mcu_as_sc_mcu7t3v3__fill_1
XFILLER_178_1014 VDD VDD VSS VSS gf180mcu_as_sc_mcu7t3v3__fill_1
X_3869_ VDD VDD VSS VSS _3869_/A _3869_/B _3869_/C _3869_/D _4339_/B gf180mcu_as_sc_mcu7t3v3__nand4_2
XTAP_TAPCELL_ROW_176_1597 VDD VSS gf180mcu_as_sc_mcu7t3v3__tap_2
XTAP_TAPCELL_ROW_176_1586 VDD VSS gf180mcu_as_sc_mcu7t3v3__tap_2
XFILLER_191_142 VDD VDD VSS VSS gf180mcu_as_sc_mcu7t3v3__fillcap_4
XFILLER_180_849 VDD VDD VSS VSS gf180mcu_as_sc_mcu7t3v3__fillcap_16
XFILLER_191_1258 VDD VDD VSS VSS gf180mcu_as_sc_mcu7t3v3__fill_2
XTAP_TAPCELL_ROW_7_823 VDD VSS gf180mcu_as_sc_mcu7t3v3__tap_2
XFILLER_143_55 VDD VDD VSS VSS gf180mcu_as_sc_mcu7t3v3__fillcap_4
XFILLER_185_1018 VDD VDD VSS VSS gf180mcu_as_sc_mcu7t3v3__fill_2
XFILLER_159_106 VDD VDD VSS VSS gf180mcu_as_sc_mcu7t3v3__fillcap_16
XFILLER_168_662 VDD VDD VSS VSS gf180mcu_as_sc_mcu7t3v3__fill_2
XFILLER_183_632 VDD VDD VSS VSS gf180mcu_as_sc_mcu7t3v3__fill_1
Xinput17 VDD VDD VSS VSS boot_data[5] _2722_/A gf180mcu_as_sc_mcu7t3v3__buff_12
Xinput28 VDD VDD VSS VSS dft_addr[5] _2421_/A gf180mcu_as_sc_mcu7t3v3__buff_12
XFILLER_10_384 VDD VDD VSS VSS gf180mcu_as_sc_mcu7t3v3__fill_1
XFILLER_155_334 VDD VDD VSS VSS gf180mcu_as_sc_mcu7t3v3__fillcap_16
XFILLER_155_356 VDD VDD VSS VSS gf180mcu_as_sc_mcu7t3v3__fill_2
XFILLER_156_868 VDD VDD VSS VSS gf180mcu_as_sc_mcu7t3v3__fillcap_4
XFILLER_6_333 VDD VDD VSS VSS gf180mcu_as_sc_mcu7t3v3__fill_2
XFILLER_7_867 VDD VDD VSS VSS gf180mcu_as_sc_mcu7t3v3__fillcap_8
Xinput39 VDD VDD VSS VSS dft_wdata[4] _2716_/B gf180mcu_as_sc_mcu7t3v3__buff_12
Xwire754 VDD VDD VSS VSS _3062_/B _3129_/B gf180mcu_as_sc_mcu7t3v3__clkbuff_12
XFILLER_6_399 VDD VDD VSS VSS gf180mcu_as_sc_mcu7t3v3__fillcap_4
XFILLER_172_1180 VDD VDD VSS VSS gf180mcu_as_sc_mcu7t3v3__fill_1
XTAP_TAPCELL_ROW_104_1_1057 VDD VSS gf180mcu_as_sc_mcu7t3v3__tap_2
XFILLER_168_1227 VDD VDD VSS VSS gf180mcu_as_sc_mcu7t3v3__fillcap_8
X_4910_ VDD VDD VSS VSS _5095_/CLK _4910_/D _4910_/Q gf180mcu_as_sc_mcu7t3v3__dfxtp_2
X_4841_ VDD VDD VSS VSS _5152_/CLK _4841_/D _4841_/Q gf180mcu_as_sc_mcu7t3v3__dfxtp_2
XFILLER_178_448 VDD VDD VSS VSS gf180mcu_as_sc_mcu7t3v3__fillcap_4
XFILLER_187_982 VDD VDD VSS VSS gf180mcu_as_sc_mcu7t3v3__fillcap_16
X_4772_ VDD VDD VSS VSS _5216_/CLK _4772_/D _4772_/Q gf180mcu_as_sc_mcu7t3v3__dfxtp_2
X_3723_ VDD VDD VSS VSS _4859_/D _3723_/C _3723_/B _4099_/A gf180mcu_as_sc_mcu7t3v3__aoi21_2
XTAP_TAPCELL_ROW_158_1250 VDD VSS gf180mcu_as_sc_mcu7t3v3__tap_2
XFILLER_173_131 VDD VDD VSS VSS gf180mcu_as_sc_mcu7t3v3__fill_2
X_3654_ VDD VDD VSS VSS _4027_/A _3654_/B _3654_/C _3654_/Y _3654_/D gf180mcu_as_sc_mcu7t3v3__aoi211_2
X_2605_ VDD VDD VSS VSS _4764_/Q _4765_/Q _2605_/C _2606_/B gf180mcu_as_sc_mcu7t3v3__nor3_2
XTAP_TAPCELL_ROW_154_1169 VDD VSS gf180mcu_as_sc_mcu7t3v3__tap_2
X_3585_ VDD VDD VSS VSS _3948_/A _3652_/B _3585_/C _3652_/D _3586_/C gf180mcu_as_sc_mcu7t3v3__ao211_2
X_2536_ VDD VDD VSS VSS _5159_/Q _5157_/Q _5158_/Q _4364_/B gf180mcu_as_sc_mcu7t3v3__nor3_2
XTAP_TAPCELL_ROW_171_1494 VDD VSS gf180mcu_as_sc_mcu7t3v3__tap_2
XFILLER_170_893 VDD VDD VSS VSS gf180mcu_as_sc_mcu7t3v3__fillcap_8
X_5255_ VDD VDD VSS VSS _5285_/CLK _5255_/D _5255_/Q gf180mcu_as_sc_mcu7t3v3__dfxtp_2
X_2467_ VDD VDD VSS VSS _4369_/B _2467_/C _2467_/B _4581_/A gf180mcu_as_sc_mcu7t3v3__aoi21_2
X_4206_ VDD VDD VSS VSS _4235_/B _4228_/B _4228_/C _5042_/Q _5042_/D gf180mcu_as_sc_mcu7t3v3__ao22_2
XFILLER_25_1256 VDD VDD VSS VSS gf180mcu_as_sc_mcu7t3v3__fill_2
X_5186_ VDD VDD VSS VSS _5188_/CLK _5186_/D _5186_/Q gf180mcu_as_sc_mcu7t3v3__dfxtp_2
X_2398_ VDD VDD VSS VSS _2767_/A _5226_/Q gf180mcu_as_sc_mcu7t3v3__inv_2
X_4137_ VDD VDD VSS VSS _4137_/A _4152_/B _4152_/C _4940_/Q _4139_/C gf180mcu_as_sc_mcu7t3v3__ao22_2
XFILLER_113_58 VDD VDD VSS VSS gf180mcu_as_sc_mcu7t3v3__fill_1
X_4068_ VDD VDD VSS VSS _4994_/Q _4158_/B _4245_/B _4158_/D _4994_/D gf180mcu_as_sc_mcu7t3v3__ao22_2
X_3019_ VDD VDD VSS VSS _3153_/A _3019_/B _3019_/C _3153_/D _3021_/C gf180mcu_as_sc_mcu7t3v3__ao211_2
XFILLER_169_415 VDD VDD VSS VSS gf180mcu_as_sc_mcu7t3v3__fillcap_4
XFILLER_12_616 VDD VDD VSS VSS gf180mcu_as_sc_mcu7t3v3__fill_1
XPHY_EDGE_ROW_105_1_Right_614 VDD VSS gf180mcu_as_sc_mcu7t3v3__tap_2
XTAP_TAPCELL_ROW_178_1637 VDD VSS gf180mcu_as_sc_mcu7t3v3__tap_2
XTAP_TAPCELL_ROW_178_1626 VDD VSS gf180mcu_as_sc_mcu7t3v3__tap_2
XFILLER_11_115 VDD VDD VSS VSS gf180mcu_as_sc_mcu7t3v3__fillcap_4
XFILLER_11_137 VDD VDD VSS VSS gf180mcu_as_sc_mcu7t3v3__fill_2
XFILLER_165_632 VDD VDD VSS VSS gf180mcu_as_sc_mcu7t3v3__fillcap_16
XPHY_EDGE_ROW_138_1_Left_330 VDD VSS gf180mcu_as_sc_mcu7t3v3__tap_2
XFILLER_180_613 VDD VDD VSS VSS gf180mcu_as_sc_mcu7t3v3__fill_2
XFILLER_22_88 VDD VDD VSS VSS gf180mcu_as_sc_mcu7t3v3__fillcap_8
XFILLER_4_859 VDD VDD VSS VSS gf180mcu_as_sc_mcu7t3v3__fillcap_16
XFILLER_98_37 VDD VDD VSS VSS gf180mcu_as_sc_mcu7t3v3__fillcap_16
XFILLER_154_10 VDD VDD VSS VSS gf180mcu_as_sc_mcu7t3v3__fill_2
XFILLER_154_87 VDD VDD VSS VSS gf180mcu_as_sc_mcu7t3v3__fill_1
XFILLER_103_80 VDD VDD VSS VSS gf180mcu_as_sc_mcu7t3v3__fillcap_4
XFILLER_188_724 VDD VDD VSS VSS gf180mcu_as_sc_mcu7t3v3__fillcap_8
XFILLER_128_1266 VDD VDD VSS VSS gf180mcu_as_sc_mcu7t3v3__fill_1
XFILLER_128_1288 VDD VDD VSS VSS gf180mcu_as_sc_mcu7t3v3__fill_1
XFILLER_128_1299 VDD VDD VSS VSS gf180mcu_as_sc_mcu7t3v3__fill_1
XFILLER_179_62 VDD VDD VSS VSS gf180mcu_as_sc_mcu7t3v3__fill_1
XFILLER_11_660 VDD VDD VSS VSS gf180mcu_as_sc_mcu7t3v3__fill_2
XFILLER_187_278 VDD VDD VSS VSS gf180mcu_as_sc_mcu7t3v3__fill_2
XFILLER_11_693 VDD VDD VSS VSS gf180mcu_as_sc_mcu7t3v3__fillcap_4
XFILLER_156_632 VDD VDD VSS VSS gf180mcu_as_sc_mcu7t3v3__fill_1
XTAP_TAPCELL_ROW_123_3_2034 VDD VSS gf180mcu_as_sc_mcu7t3v3__tap_2
XPHY_EDGE_ROW_25_3_Right_66 VDD VSS gf180mcu_as_sc_mcu7t3v3__tap_2
XFILLER_156_687 VDD VDD VSS VSS gf180mcu_as_sc_mcu7t3v3__fillcap_4
XFILLER_171_602 VDD VDD VSS VSS gf180mcu_as_sc_mcu7t3v3__fill_2
Xwire562 VDD VDD VSS VSS _3664_/B _3726_/B gf180mcu_as_sc_mcu7t3v3__clkbuff_12
XFILLER_87_1272 VDD VDD VSS VSS gf180mcu_as_sc_mcu7t3v3__fillcap_8
X_3370_ VDD VDD VSS VSS _4024_/D _3370_/B _3370_/C _3386_/D _3372_/C gf180mcu_as_sc_mcu7t3v3__ao211_2
XFILLER_152_882 VDD VDD VSS VSS gf180mcu_as_sc_mcu7t3v3__fill_2
XFILLER_3_870 VDD VDD VSS VSS gf180mcu_as_sc_mcu7t3v3__fillcap_16
XFILLER_48_1256 VDD VDD VSS VSS gf180mcu_as_sc_mcu7t3v3__fillcap_4
XFILLER_174_1297 VDD VDD VSS VSS gf180mcu_as_sc_mcu7t3v3__fillcap_4
XFILLER_2_380 VDD VDD VSS VSS gf180mcu_as_sc_mcu7t3v3__fillcap_4
X_5040_ VDD VDD VSS VSS clkload8/A _5040_/D _5040_/Q gf180mcu_as_sc_mcu7t3v3__dfxtp_2
XFILLER_179_702 VDD VDD VSS VSS gf180mcu_as_sc_mcu7t3v3__fillcap_16
XPHY_EDGE_ROW_142_3_Left_514 VDD VSS gf180mcu_as_sc_mcu7t3v3__tap_2
XFILLER_167_908 VDD VDD VSS VSS gf180mcu_as_sc_mcu7t3v3__fill_2
XFILLER_181_1257 VDD VDD VSS VSS gf180mcu_as_sc_mcu7t3v3__fill_2
X_4824_ VDD VDD VSS VSS clkload7/A _4824_/D _4824_/Q gf180mcu_as_sc_mcu7t3v3__dfxtp_2
XFILLER_178_289 VDD VDD VSS VSS gf180mcu_as_sc_mcu7t3v3__fillcap_8
X_4755_ VDD VDD VSS VSS _5226_/CLK _4755_/D _4755_/Q gf180mcu_as_sc_mcu7t3v3__dfxtp_2
XTAP_TAPCELL_ROW_156_1209 VDD VSS gf180mcu_as_sc_mcu7t3v3__tap_2
XFILLER_159_492 VDD VDD VSS VSS gf180mcu_as_sc_mcu7t3v3__fillcap_16
X_3706_ VDD VDD VSS VSS _3738_/D _3706_/A _3706_/B _3706_/C _3707_/C gf180mcu_as_sc_mcu7t3v3__ao31_2
XTAP_TAPCELL_ROW_173_1534 VDD VSS gf180mcu_as_sc_mcu7t3v3__tap_2
XFILLER_162_613 VDD VDD VSS VSS gf180mcu_as_sc_mcu7t3v3__fillcap_16
X_4686_ VDD VDD VSS VSS _4686_/D _4686_/A _4686_/B _4686_/C _5249_/D gf180mcu_as_sc_mcu7t3v3__ao31_2
X_3637_ VDD VDD VSS VSS _3638_/C _3637_/C _3653_/B _4009_/A gf180mcu_as_sc_mcu7t3v3__aoi21_2
XPHY_EDGE_ROW_90_3_Right_131 VDD VSS gf180mcu_as_sc_mcu7t3v3__tap_2
XFILLER_1_818 VDD VDD VSS VSS gf180mcu_as_sc_mcu7t3v3__fillcap_16
X_3568_ VDD VDD VSS VSS _3933_/A _3779_/B _3568_/C _3568_/D _3571_/C gf180mcu_as_sc_mcu7t3v3__ao211_2
X_2519_ VDD VDD VSS VSS _4704_/B _2845_/D _2545_/B gf180mcu_as_sc_mcu7t3v3__or2_2
XTAP_TAPCELL_ROW_58_3_1969 VDD VSS gf180mcu_as_sc_mcu7t3v3__tap_2
Xinput207 VDD VDD VSS VSS se_in[33] _3528_/A gf180mcu_as_sc_mcu7t3v3__buff_12
Xinput218 VDD VDD VSS VSS south_in[12] _4031_/A gf180mcu_as_sc_mcu7t3v3__buff_12
X_3499_ VDD VDD VSS VSS _3499_/B _3525_/A _4832_/D gf180mcu_as_sc_mcu7t3v3__and2_2
X_5238_ VDD VDD VSS VSS _5267_/CLK _5238_/D _5238_/Q gf180mcu_as_sc_mcu7t3v3__dfxtp_2
Xinput229 VDD VDD VSS VSS south_in[22] _4111_/A gf180mcu_as_sc_mcu7t3v3__buff_12
XFILLER_5_1147 VDD VDD VSS VSS gf180mcu_as_sc_mcu7t3v3__fillcap_4
X_5169_ VDD VDD VSS VSS _5182_/CLK _5169_/D _5169_/Q gf180mcu_as_sc_mcu7t3v3__dfxtp_2
XFILLER_140_34 VDD VDD VSS VSS gf180mcu_as_sc_mcu7t3v3__fill_1
XFILLER_186_1157 VDD VDD VSS VSS gf180mcu_as_sc_mcu7t3v3__fillcap_16
XPHY_EDGE_ROW_74_3_Left_446 VDD VSS gf180mcu_as_sc_mcu7t3v3__tap_2
XFILLER_13_936 VDD VDD VSS VSS gf180mcu_as_sc_mcu7t3v3__fillcap_16
XFILLER_140_89 VDD VDD VSS VSS gf180mcu_as_sc_mcu7t3v3__fillcap_16
XFILLER_169_212 VDD VDD VSS VSS gf180mcu_as_sc_mcu7t3v3__fillcap_8
XFILLER_12_457 VDD VDD VSS VSS gf180mcu_as_sc_mcu7t3v3__fillcap_4
XPHY_EDGE_ROW_106_1_Right_615 VDD VSS gf180mcu_as_sc_mcu7t3v3__tap_2
XFILLER_166_985 VDD VDD VSS VSS gf180mcu_as_sc_mcu7t3v3__fillcap_8
XFILLER_4_601 VDD VDD VSS VSS gf180mcu_as_sc_mcu7t3v3__fill_2
XFILLER_158_1237 VDD VDD VSS VSS gf180mcu_as_sc_mcu7t3v3__fillcap_16
XFILLER_181_977 VDD VDD VSS VSS gf180mcu_as_sc_mcu7t3v3__fill_2
XFILLER_181_96 VDD VDD VSS VSS gf180mcu_as_sc_mcu7t3v3__fillcap_4
XFILLER_188_521 VDD VDD VSS VSS gf180mcu_as_sc_mcu7t3v3__fillcap_4
X_2870_ VDD VDD VSS VSS _2870_/B _4766_/Q _2871_/C gf180mcu_as_sc_mcu7t3v3__xnor2_2
XFILLER_156_451 VDD VDD VSS VSS gf180mcu_as_sc_mcu7t3v3__fillcap_4
X_4540_ VDD VDD VSS VSS _5184_/Q _4554_/B _4540_/C _5102_/Q _4541_/B gf180mcu_as_sc_mcu7t3v3__ao22_2
XFILLER_172_944 VDD VDD VSS VSS gf180mcu_as_sc_mcu7t3v3__fill_1
X_4471_ VDD VDD VSS VSS _4471_/B _4541_/A _4478_/C gf180mcu_as_sc_mcu7t3v3__and2_2
X_3422_ VDD VDD VSS VSS _4070_/A _3504_/B _3513_/C _4073_/A _3423_/C gf180mcu_as_sc_mcu7t3v3__ao22_2
XFILLER_174_1083 VDD VDD VSS VSS gf180mcu_as_sc_mcu7t3v3__fill_2
X_3353_ VDD VDD VSS VSS _4924_/Q _3369_/B _3369_/C _4005_/A _3354_/C gf180mcu_as_sc_mcu7t3v3__ao22_2
Xhold1106 VDD VDD VSS VSS hold1143/Y _2584_/B gf180mcu_as_sc_mcu7t3v3__clkbuff_4
X_3284_ VDD VDD VSS VSS _3524_/C _3526_/B _3284_/Y gf180mcu_as_sc_mcu7t3v3__and2_2
X_5023_ VDD VDD VSS VSS _5086_/CLK _5023_/D _5023_/Q gf180mcu_as_sc_mcu7t3v3__dfxtp_2
Xhold1117 VDD VDD VSS VSS hold1151/Y _4969_/D gf180mcu_as_sc_mcu7t3v3__clkbuff_4
Xhold1128 VDD VDD VSS VSS _4768_/Q _2835_/A gf180mcu_as_sc_mcu7t3v3__clkbuff_4
Xhold1139 VDD VDD VSS VSS hold1139/A _2583_/C gf180mcu_as_sc_mcu7t3v3__clkbuff_4
XTAP_TAPCELL_ROW_166_1393 VDD VSS gf180mcu_as_sc_mcu7t3v3__tap_2
XFILLER_183_1319 VDD VDD VSS VSS gf180mcu_as_sc_mcu7t3v3__fillcap_8
XFILLER_110_48 VDD VDD VSS VSS gf180mcu_as_sc_mcu7t3v3__fillcap_4
X_4807_ VDD VDD VSS VSS clkload3/A _4807_/D _4807_/Q gf180mcu_as_sc_mcu7t3v3__dfxtp_2
XPHY_EDGE_ROW_3_Right_3 VDD VSS gf180mcu_as_sc_mcu7t3v3__tap_2
X_2999_ VDD VDD VSS VSS _3984_/A _3042_/B _3042_/C _3984_/D _3005_/B gf180mcu_as_sc_mcu7t3v3__ao22_2
XTAP_TAPCELL_ROW_192_1921 VDD VSS gf180mcu_as_sc_mcu7t3v3__tap_2
XTAP_TAPCELL_ROW_192_1910 VDD VSS gf180mcu_as_sc_mcu7t3v3__tap_2
XFILLER_163_900 VDD VDD VSS VSS gf180mcu_as_sc_mcu7t3v3__fillcap_8
X_4738_ VDD VDD VSS VSS _4747_/D _4749_/A _4750_/B gf180mcu_as_sc_mcu7t3v3__and2_2
X_4669_ VDD VDD VSS VSS _5112_/Q _4700_/S _4681_/C _5243_/Q _4670_/C gf180mcu_as_sc_mcu7t3v3__ao22_2
XPHY_EDGE_ROW_91_3_Right_132 VDD VSS gf180mcu_as_sc_mcu7t3v3__tap_2
XFILLER_162_487 VDD VDD VSS VSS gf180mcu_as_sc_mcu7t3v3__fill_2
XFILLER_135_34 VDD VDD VSS VSS gf180mcu_as_sc_mcu7t3v3__fillcap_8
Xclkbuf_1_1__f_clk VDD VDD VSS VSS clkbuf_0_clk/Y clkbuf_1_1__f_clk/Y gf180mcu_as_sc_mcu7t3v3__clkbuff_12
XFILLER_9_1091 VDD VDD VSS VSS gf180mcu_as_sc_mcu7t3v3__fill_1
XFILLER_151_22 VDD VDD VSS VSS gf180mcu_as_sc_mcu7t3v3__fillcap_16
XFILLER_151_55 VDD VDD VSS VSS gf180mcu_as_sc_mcu7t3v3__fill_1
XFILLER_13_711 VDD VDD VSS VSS gf180mcu_as_sc_mcu7t3v3__fill_2
XTAP_TAPCELL_ROW_0_692 VDD VSS gf180mcu_as_sc_mcu7t3v3__tap_2
XTAP_TAPCELL_ROW_0_681 VDD VSS gf180mcu_as_sc_mcu7t3v3__tap_2
XTAP_TAPCELL_ROW_0_670 VDD VSS gf180mcu_as_sc_mcu7t3v3__tap_2
XFILLER_38_1266 VDD VDD VSS VSS gf180mcu_as_sc_mcu7t3v3__fill_1
Xsram2048.u_bank1_920 VDD VDD VSS VSS sram2048.u_bank1/WEN[1] gf180mcu_as_sc_mcu7t3v3__tiel_4
XFILLER_12_243 VDD VDD VSS VSS gf180mcu_as_sc_mcu7t3v3__fill_2
XFILLER_13_766 VDD VDD VSS VSS gf180mcu_as_sc_mcu7t3v3__fill_2
XFILLER_38_1299 VDD VDD VSS VSS gf180mcu_as_sc_mcu7t3v3__fill_1
XFILLER_185_535 VDD VDD VSS VSS gf180mcu_as_sc_mcu7t3v3__fillcap_16
XPHY_EDGE_ROW_107_1_Right_616 VDD VSS gf180mcu_as_sc_mcu7t3v3__tap_2
XTAP_TAPCELL_ROW_11_901 VDD VSS gf180mcu_as_sc_mcu7t3v3__tap_2
XFILLER_176_30 VDD VDD VSS VSS gf180mcu_as_sc_mcu7t3v3__fillcap_4
XFILLER_8_247 VDD VDD VSS VSS gf180mcu_as_sc_mcu7t3v3__fill_1
XFILLER_154_944 VDD VDD VSS VSS gf180mcu_as_sc_mcu7t3v3__fill_1
XFILLER_154_955 VDD VDD VSS VSS gf180mcu_as_sc_mcu7t3v3__fill_1
XFILLER_158_1012 VDD VDD VSS VSS gf180mcu_as_sc_mcu7t3v3__fill_2
Xclkbuf_leaf_24_clk_regs VDD VDD VSS VSS clkbuf_3_6__f_clk_regs/Y _5232_/CLK gf180mcu_as_sc_mcu7t3v3__clkbuff_12
XFILLER_158_1045 VDD VDD VSS VSS gf180mcu_as_sc_mcu7t3v3__fillcap_4
XFILLER_180_240 VDD VDD VSS VSS gf180mcu_as_sc_mcu7t3v3__fillcap_4
XFILLER_4_486 VDD VDD VSS VSS gf180mcu_as_sc_mcu7t3v3__fill_1
XFILLER_192_40 VDD VDD VSS VSS gf180mcu_as_sc_mcu7t3v3__fill_2
XFILLER_171_1278 VDD VDD VSS VSS gf180mcu_as_sc_mcu7t3v3__fillcap_8
XFILLER_169_1185 VDD VDD VSS VSS gf180mcu_as_sc_mcu7t3v3__fillcap_4
X_3971_ VDD VDD VSS VSS _3971_/A _4067_/B _3971_/C _4233_/B _4067_/D gf180mcu_as_sc_mcu7t3v3__aoi211_2
XFILLER_182_1352 VDD VDD VSS VSS gf180mcu_as_sc_mcu7t3v3__fill_2
X_2922_ VDD VDD VSS VSS _3807_/A _3791_/A _3800_/A gf180mcu_as_sc_mcu7t3v3__nor2_2
XFILLER_188_384 VDD VDD VSS VSS gf180mcu_as_sc_mcu7t3v3__fill_1
XFILLER_86_2 VDD VDD VSS VSS gf180mcu_as_sc_mcu7t3v3__fillcap_8
X_2853_ VDD VDD VSS VSS _2854_/C _4377_/B _2853_/A gf180mcu_as_sc_mcu7t3v3__nand2_2
XFILLER_157_760 VDD VDD VSS VSS gf180mcu_as_sc_mcu7t3v3__fillcap_8
XFILLER_163_207 VDD VDD VSS VSS gf180mcu_as_sc_mcu7t3v3__fill_2
X_2784_ VDD VDD VSS VSS _4647_/A _5234_/Q _2786_/C gf180mcu_as_sc_mcu7t3v3__and2_2
X_4523_ VDD VDD VSS VSS _5182_/Q _4532_/B _4523_/C _5100_/Q _4524_/B gf180mcu_as_sc_mcu7t3v3__ao22_2
XFILLER_131_104 VDD VDD VSS VSS gf180mcu_as_sc_mcu7t3v3__fill_1
XFILLER_160_925 VDD VDD VSS VSS gf180mcu_as_sc_mcu7t3v3__fillcap_8
XFILLER_160_947 VDD VDD VSS VSS gf180mcu_as_sc_mcu7t3v3__fill_2
X_4454_ VDD VDD VSS VSS _4458_/B _5073_/Q _4456_/S gf180mcu_as_sc_mcu7t3v3__nand2_2
XFILLER_160_969 VDD VDD VSS VSS gf180mcu_as_sc_mcu7t3v3__fill_2
XFILLER_63_1326 VDD VDD VSS VSS gf180mcu_as_sc_mcu7t3v3__fill_2
Xfanout705 VDD VDD VSS VSS fanout705/A _4151_/C gf180mcu_as_sc_mcu7t3v3__buff_12
X_4900__1068 VDD VDD VSS VSS _4900_/D gf180mcu_as_sc_mcu7t3v3__tiel_4
X_4385_ VDD VDD VSS VSS _4385_/D _4560_/A _4385_/B _4385_/C _4386_/B gf180mcu_as_sc_mcu7t3v3__ao31_2
X_3405_ VDD VDD VSS VSS _3452_/S _4056_/D _3405_/A _3407_/B gf180mcu_as_sc_mcu7t3v3__mux2_2
XFILLER_150_1307 VDD VDD VSS VSS gf180mcu_as_sc_mcu7t3v3__fillcap_8
Xfanout716 VDD VDD VSS VSS fanout717/A _3724_/C gf180mcu_as_sc_mcu7t3v3__buff_12
Xfanout727 VDD VDD VSS VSS _3448_/C _3369_/C gf180mcu_as_sc_mcu7t3v3__buff_12
Xfanout738 VDD VDD VSS VSS _3542_/Y _3727_/B gf180mcu_as_sc_mcu7t3v3__buff_12
Xfanout749 VDD VDD VSS VSS _2931_/Y _3127_/C gf180mcu_as_sc_mcu7t3v3__buff_12
X_3336_ VDD VDD VSS VSS _4922_/Q _3369_/B _3369_/C _3990_/A _3337_/C gf180mcu_as_sc_mcu7t3v3__ao22_2
XTAP_TAPCELL_ROW_168_1444 VDD VSS gf180mcu_as_sc_mcu7t3v3__tap_2
XTAP_TAPCELL_ROW_168_1433 VDD VSS gf180mcu_as_sc_mcu7t3v3__tap_2
XFILLER_6_1220 VDD VDD VSS VSS gf180mcu_as_sc_mcu7t3v3__fillcap_4
X_5006_ VDD VDD VSS VSS _5185_/CLK _5006_/D _5006_/Q gf180mcu_as_sc_mcu7t3v3__dfxtp_2
X_3267_ VDD VDD VSS VSS _3267_/Y _3275_/B _3275_/A gf180mcu_as_sc_mcu7t3v3__nor2b_2
XPHY_EDGE_ROW_22_1_Left_214 VDD VSS gf180mcu_as_sc_mcu7t3v3__tap_2
XFILLER_2_1139 VDD VDD VSS VSS gf180mcu_as_sc_mcu7t3v3__fill_1
XFILLER_6_1297 VDD VDD VSS VSS gf180mcu_as_sc_mcu7t3v3__fillcap_4
X_3198_ VDD VDD VSS VSS _3198_/B _3204_/C _3206_/C gf180mcu_as_sc_mcu7t3v3__or2_2
XTAP_TAPCELL_ROW_181_1688 VDD VSS gf180mcu_as_sc_mcu7t3v3__tap_2
XTAP_TAPCELL_ROW_181_1677 VDD VSS gf180mcu_as_sc_mcu7t3v3__tap_2
XFILLER_179_340 VDD VDD VSS VSS gf180mcu_as_sc_mcu7t3v3__fillcap_8
XFILLER_10_714 VDD VDD VSS VSS gf180mcu_as_sc_mcu7t3v3__fill_1
XFILLER_167_546 VDD VDD VSS VSS gf180mcu_as_sc_mcu7t3v3__fillcap_4
XFILLER_124_1291 VDD VDD VSS VSS gf180mcu_as_sc_mcu7t3v3__fillcap_8
XFILLER_159_1354 VDD VDD VSS VSS gf180mcu_as_sc_mcu7t3v3__fill_1
XTAP_TAPCELL_ROW_61_1_1014 VDD VSS gf180mcu_as_sc_mcu7t3v3__tap_2
XPHY_EDGE_ROW_31_1_Right_540 VDD VSS gf180mcu_as_sc_mcu7t3v3__tap_2
XFILLER_122_104 VDD VDD VSS VSS gf180mcu_as_sc_mcu7t3v3__fill_1
XFILLER_146_33 VDD VDD VSS VSS gf180mcu_as_sc_mcu7t3v3__fill_2
XFILLER_2_913 VDD VDD VSS VSS gf180mcu_as_sc_mcu7t3v3__fillcap_8
XTAP_TAPCELL_ROW_188_1809 VDD VSS gf180mcu_as_sc_mcu7t3v3__tap_2
XPHY_EDGE_ROW_92_3_Right_133 VDD VSS gf180mcu_as_sc_mcu7t3v3__tap_2
XFILLER_190_2 VDD VDD VSS VSS gf180mcu_as_sc_mcu7t3v3__fill_1
XPHY_EDGE_ROW_18_3_Left_390 VDD VSS gf180mcu_as_sc_mcu7t3v3__tap_2
XFILLER_39_97 VDD VDD VSS VSS gf180mcu_as_sc_mcu7t3v3__fillcap_8
XTAP_TAPCELL_ROW_5_784 VDD VSS gf180mcu_as_sc_mcu7t3v3__tap_2
XTAP_TAPCELL_ROW_5_795 VDD VSS gf180mcu_as_sc_mcu7t3v3__tap_2
XPHY_EDGE_ROW_79_1_Left_271 VDD VSS gf180mcu_as_sc_mcu7t3v3__tap_2
XPHY_EDGE_ROW_34_3_Right_75 VDD VSS gf180mcu_as_sc_mcu7t3v3__tap_2
XFILLER_189_137 VDD VDD VSS VSS gf180mcu_as_sc_mcu7t3v3__fill_2
XFILLER_13_541 VDD VDD VSS VSS gf180mcu_as_sc_mcu7t3v3__fill_2
XFILLER_13_552 VDD VDD VSS VSS gf180mcu_as_sc_mcu7t3v3__fill_1
XPHY_EDGE_ROW_37_3_Left_409 VDD VSS gf180mcu_as_sc_mcu7t3v3__tap_2
XFILLER_9_534 VDD VDD VSS VSS gf180mcu_as_sc_mcu7t3v3__fill_1
XFILLER_185_343 VDD VDD VSS VSS gf180mcu_as_sc_mcu7t3v3__fillcap_4
XFILLER_185_376 VDD VDD VSS VSS gf180mcu_as_sc_mcu7t3v3__fillcap_4
XFILLER_186_877 VDD VDD VSS VSS gf180mcu_as_sc_mcu7t3v3__fillcap_8
XFILLER_9_578 VDD VDD VSS VSS gf180mcu_as_sc_mcu7t3v3__fill_1
XPHY_EDGE_ROW_108_1_Right_617 VDD VSS gf180mcu_as_sc_mcu7t3v3__tap_2
XFILLER_185_387 VDD VDD VSS VSS gf180mcu_as_sc_mcu7t3v3__fillcap_16
Xoutput319 VDD VDD VSS VSS _5480_/Y dft_rdata[2] gf180mcu_as_sc_mcu7t3v3__buff_12
XPHY_EDGE_ROW_151_3_Left_523 VDD VSS gf180mcu_as_sc_mcu7t3v3__tap_2
X_4170_ VDD VDD VSS VSS _4230_/B _4186_/B _4186_/C _5008_/Q _5008_/D gf180mcu_as_sc_mcu7t3v3__ao22_2
X_3121_ VDD VDD VSS VSS _3187_/B _4935_/Q _3122_/D gf180mcu_as_sc_mcu7t3v3__or2_2
X_3052_ VDD VDD VSS VSS _4029_/A _3127_/B _3127_/C _4031_/A _3053_/C gf180mcu_as_sc_mcu7t3v3__ao22_2
XTAP_TAPCELL_ROW_163_1352 VDD VSS gf180mcu_as_sc_mcu7t3v3__tap_2
XTAP_TAPCELL_ROW_163_1341 VDD VSS gf180mcu_as_sc_mcu7t3v3__tap_2
X_3954_ VDD VDD VSS VSS _4231_/B _3954_/B _4099_/D gf180mcu_as_sc_mcu7t3v3__nor2_2
XPHY_EDGE_ROW_70_1_Right_579 VDD VSS gf180mcu_as_sc_mcu7t3v3__tap_2
XFILLER_177_833 VDD VDD VSS VSS gf180mcu_as_sc_mcu7t3v3__fillcap_4
XFILLER_182_1171 VDD VDD VSS VSS gf180mcu_as_sc_mcu7t3v3__fill_1
XFILLER_182_1182 VDD VDD VSS VSS gf180mcu_as_sc_mcu7t3v3__fillcap_16
XFILLER_188_181 VDD VDD VSS VSS gf180mcu_as_sc_mcu7t3v3__fill_1
X_3885_ VDD VDD VSS VSS _3885_/B _5175_/Q _4925_/D gf180mcu_as_sc_mcu7t3v3__and2_2
X_2905_ VDD VDD VSS VSS _3790_/A _3535_/A _3537_/A gf180mcu_as_sc_mcu7t3v3__or2_2
X_2836_ VDD VDD VSS VSS _4748_/B _4749_/A _4329_/A gf180mcu_as_sc_mcu7t3v3__nor2_2
XFILLER_164_527 VDD VDD VSS VSS gf180mcu_as_sc_mcu7t3v3__fillcap_4
XFILLER_192_847 VDD VDD VSS VSS gf180mcu_as_sc_mcu7t3v3__fill_2
X_2767_ VDD VDD VSS VSS _2767_/A _2847_/A _2840_/B _2840_/C _2770_/C gf180mcu_as_sc_mcu7t3v3__nand4_2
XFILLER_104_104 VDD VDD VSS VSS gf180mcu_as_sc_mcu7t3v3__fill_1
XFILLER_172_582 VDD VDD VSS VSS gf180mcu_as_sc_mcu7t3v3__fill_2
X_4506_ VDD VDD VSS VSS _4506_/B _4591_/A _4513_/C gf180mcu_as_sc_mcu7t3v3__and2_2
X_2698_ VDD VDD VSS VSS _5159_/Q _4272_/S _4275_/S _5183_/Q _2699_/C gf180mcu_as_sc_mcu7t3v3__ao22_2
XPHY_EDGE_ROW_83_3_Left_455 VDD VSS gf180mcu_as_sc_mcu7t3v3__tap_2
X_4437_ VDD VDD VSS VSS _4440_/C _4984_/Q _4473_/A gf180mcu_as_sc_mcu7t3v3__nand2b_2
XFILLER_160_788 VDD VDD VSS VSS gf180mcu_as_sc_mcu7t3v3__fill_1
Xfanout502 VDD VDD VSS VSS _3912_/Y fanout502/Y gf180mcu_as_sc_mcu7t3v3__buff_12
Xfanout513 VDD VDD VSS VSS wire518/Y _3667_/B gf180mcu_as_sc_mcu7t3v3__buff_12
Xfanout524 VDD VDD VSS VSS _3391_/A _3477_/B gf180mcu_as_sc_mcu7t3v3__buff_12
XTAP_TAPCELL_ROW_122_1_1075 VDD VSS gf180mcu_as_sc_mcu7t3v3__tap_2
Xfanout535 VDD VDD VSS VSS _4515_/A _4591_/A gf180mcu_as_sc_mcu7t3v3__buff_12
Xfanout546 VDD VDD VSS VSS _4164_/S _4106_/S gf180mcu_as_sc_mcu7t3v3__buff_12
Xfanout557 VDD VDD VSS VSS fanout559/Y _4256_/S gf180mcu_as_sc_mcu7t3v3__buff_12
X_4368_ VDD VDD VSS VSS _4698_/B _4563_/C _4368_/C _4378_/D _4369_/C gf180mcu_as_sc_mcu7t3v3__ao211_2
Xfanout579 VDD VDD VSS VSS _3132_/B _3131_/A gf180mcu_as_sc_mcu7t3v3__buff_12
X_4299_ VDD VDD VSS VSS _4326_/S _5129_/Q _5128_/Q _5128_/D gf180mcu_as_sc_mcu7t3v3__mux2_2
X_3319_ VDD VDD VSS VSS _3971_/A _3424_/B _3319_/C _4809_/D _3580_/D gf180mcu_as_sc_mcu7t3v3__aoi211_2
XTAP_TAPCELL_ROW_183_1728 VDD VSS gf180mcu_as_sc_mcu7t3v3__tap_2
XTAP_TAPCELL_ROW_183_1717 VDD VSS gf180mcu_as_sc_mcu7t3v3__tap_2
Xmesh_tile_972 VDD VDD VSS VSS north_out[12] gf180mcu_as_sc_mcu7t3v3__tiel_4
Xmesh_tile_961 VDD VDD VSS VSS north_out[1] gf180mcu_as_sc_mcu7t3v3__tiel_4
Xmesh_tile_950 VDD VDD VSS VSS ne_out[24] gf180mcu_as_sc_mcu7t3v3__tiel_4
XTAP_TAPCELL_ROW_2_732 VDD VSS gf180mcu_as_sc_mcu7t3v3__tap_2
XTAP_TAPCELL_ROW_2_721 VDD VSS gf180mcu_as_sc_mcu7t3v3__tap_2
Xmesh_tile_994 VDD VDD VSS VSS nw_out[0] gf180mcu_as_sc_mcu7t3v3__tiel_4
Xmesh_tile_983 VDD VDD VSS VSS north_out[23] gf180mcu_as_sc_mcu7t3v3__tiel_4
XFILLER_162_6 VDD VDD VSS VSS gf180mcu_as_sc_mcu7t3v3__fillcap_16
XFILLER_187_1060 VDD VDD VSS VSS gf180mcu_as_sc_mcu7t3v3__fill_2
XFILLER_161_1200 VDD VDD VSS VSS gf180mcu_as_sc_mcu7t3v3__fillcap_4
XFILLER_186_107 VDD VDD VSS VSS gf180mcu_as_sc_mcu7t3v3__fillcap_16
XFILLER_74_1285 VDD VDD VSS VSS gf180mcu_as_sc_mcu7t3v3__fillcap_4
XFILLER_10_522 VDD VDD VSS VSS gf180mcu_as_sc_mcu7t3v3__fill_2
Xwire903 VDD VDD VSS VSS wire903/A _4054_/A gf180mcu_as_sc_mcu7t3v3__clkbuff_12
XFILLER_182_313 VDD VDD VSS VSS gf180mcu_as_sc_mcu7t3v3__fill_2
XPHY_EDGE_ROW_32_1_Right_541 VDD VSS gf180mcu_as_sc_mcu7t3v3__tap_2
XFILLER_163_593 VDD VDD VSS VSS gf180mcu_as_sc_mcu7t3v3__fillcap_16
XFILLER_2_743 VDD VDD VSS VSS gf180mcu_as_sc_mcu7t3v3__fillcap_16
XPHY_EDGE_ROW_93_3_Right_134 VDD VSS gf180mcu_as_sc_mcu7t3v3__tap_2
XFILLER_1_253 VDD VDD VSS VSS gf180mcu_as_sc_mcu7t3v3__fill_2
XFILLER_2_798 VDD VDD VSS VSS gf180mcu_as_sc_mcu7t3v3__fillcap_4
XFILLER_81_1256 VDD VDD VSS VSS gf180mcu_as_sc_mcu7t3v3__fillcap_8
XFILLER_2_37 VDD VDD VSS VSS gf180mcu_as_sc_mcu7t3v3__fillcap_16
XFILLER_12_1011 VDD VDD VSS VSS gf180mcu_as_sc_mcu7t3v3__fillcap_4
XFILLER_158_387 VDD VDD VSS VSS gf180mcu_as_sc_mcu7t3v3__fillcap_4
X_3670_ VDD VDD VSS VSS _3727_/C _4047_/A _3672_/C gf180mcu_as_sc_mcu7t3v3__and2_2
XPHY_EDGE_ROW_109_1_Right_618 VDD VSS gf180mcu_as_sc_mcu7t3v3__tap_2
X_2621_ VDD VDD VSS VSS _2621_/B _4643_/B _2624_/B gf180mcu_as_sc_mcu7t3v3__or2_2
XFILLER_177_1240 VDD VDD VSS VSS gf180mcu_as_sc_mcu7t3v3__fill_2
X_2552_ VDD VDD VSS VSS _4649_/A _5272_/Q _2838_/B gf180mcu_as_sc_mcu7t3v3__and2_2
XFILLER_177_1262 VDD VDD VSS VSS gf180mcu_as_sc_mcu7t3v3__fillcap_4
XFILLER_49_2 VDD VDD VSS VSS gf180mcu_as_sc_mcu7t3v3__fill_1
XPHY_EDGE_ROW_10_Left_203 VDD VSS gf180mcu_as_sc_mcu7t3v3__tap_2
X_5271_ VDD VDD VSS VSS _5277_/CLK _5271_/D _5271_/Q gf180mcu_as_sc_mcu7t3v3__dfxtp_2
X_4222_ VDD VDD VSS VSS _4251_/B _4228_/B _4228_/C _5058_/Q _5058_/D gf180mcu_as_sc_mcu7t3v3__ao22_2
X_2483_ VDD VDD VSS VSS _2747_/B _4630_/A _2795_/A gf180mcu_as_sc_mcu7t3v3__nor2_2
X_4153_ VDD VDD VSS VSS _4153_/A _4153_/B _4153_/C _4153_/D _4155_/C gf180mcu_as_sc_mcu7t3v3__ao211_2
X_4084_ VDD VDD VSS VSS _4996_/Q _4166_/B _4247_/B _4166_/D _4996_/D gf180mcu_as_sc_mcu7t3v3__ao22_2
X_3104_ VDD VDD VSS VSS _4078_/A _3206_/B _3104_/C _3104_/D _3105_/C gf180mcu_as_sc_mcu7t3v3__ao22_2
XPHY_EDGE_ROW_158_Left_350 VDD VSS gf180mcu_as_sc_mcu7t3v3__tap_2
X_3035_ VDD VDD VSS VSS _3046_/B _4925_/Q _3038_/C gf180mcu_as_sc_mcu7t3v3__or2_2
XFILLER_97_1296 VDD VDD VSS VSS gf180mcu_as_sc_mcu7t3v3__fillcap_8
XFILLER_168_107 VDD VDD VSS VSS gf180mcu_as_sc_mcu7t3v3__fill_1
XFILLER_180_1119 VDD VDD VSS VSS gf180mcu_as_sc_mcu7t3v3__fillcap_8
X_4986_ VDD VDD VSS VSS clkload8/A _4986_/D _4986_/Q gf180mcu_as_sc_mcu7t3v3__dfxtp_2
X_3937_ VDD VDD VSS VSS _4978_/Q _4076_/B _4229_/B _4166_/D _4978_/D gf180mcu_as_sc_mcu7t3v3__ao22_2
XTAP_TAPCELL_ROW_141_3_2052 VDD VSS gf180mcu_as_sc_mcu7t3v3__tap_2
XFILLER_164_313 VDD VDD VSS VSS gf180mcu_as_sc_mcu7t3v3__fill_2
XFILLER_164_324 VDD VDD VSS VSS gf180mcu_as_sc_mcu7t3v3__fillcap_16
XFILLER_165_825 VDD VDD VSS VSS gf180mcu_as_sc_mcu7t3v3__fill_2
XFILLER_176_184 VDD VDD VSS VSS gf180mcu_as_sc_mcu7t3v3__fillcap_8
XFILLER_177_696 VDD VDD VSS VSS gf180mcu_as_sc_mcu7t3v3__fillcap_4
XFILLER_192_611 VDD VDD VSS VSS gf180mcu_as_sc_mcu7t3v3__fill_1
XFILLER_192_622 VDD VDD VSS VSS gf180mcu_as_sc_mcu7t3v3__fill_1
X_3868_ VDD VDD VSS VSS _3869_/D _3868_/A _3868_/B _3868_/C gf180mcu_as_sc_mcu7t3v3__ao21_2
XTAP_TAPCELL_ROW_176_1587 VDD VSS gf180mcu_as_sc_mcu7t3v3__tap_2
XFILLER_34_1291 VDD VDD VSS VSS gf180mcu_as_sc_mcu7t3v3__fillcap_8
X_3799_ VDD VDD VSS VSS _3799_/A _3799_/B _3799_/C _3800_/D _3799_/D gf180mcu_as_sc_mcu7t3v3__oai211_2
X_2819_ VDD VDD VSS VSS _4698_/B _2833_/A _2828_/B gf180mcu_as_sc_mcu7t3v3__and2_2
XTAP_TAPCELL_ROW_176_1598 VDD VSS gf180mcu_as_sc_mcu7t3v3__tap_2
XFILLER_11_57 VDD VDD VSS VSS gf180mcu_as_sc_mcu7t3v3__fill_2
XFILLER_192_677 VDD VDD VSS VSS gf180mcu_as_sc_mcu7t3v3__fill_2
XFILLER_192_688 VDD VDD VSS VSS gf180mcu_as_sc_mcu7t3v3__fill_1
XFILLER_69_1321 VDD VDD VSS VSS gf180mcu_as_sc_mcu7t3v3__fill_2
XFILLER_11_79 VDD VDD VSS VSS gf180mcu_as_sc_mcu7t3v3__fillcap_16
XFILLER_127_35 VDD VDD VSS VSS gf180mcu_as_sc_mcu7t3v3__fill_2
XFILLER_191_1226 VDD VDD VSS VSS gf180mcu_as_sc_mcu7t3v3__fillcap_16
XTAP_TAPCELL_ROW_7_824 VDD VSS gf180mcu_as_sc_mcu7t3v3__tap_2
XFILLER_8_1123 VDD VDD VSS VSS gf180mcu_as_sc_mcu7t3v3__fillcap_4
XFILLER_143_34 VDD VDD VSS VSS gf180mcu_as_sc_mcu7t3v3__fill_2
XFILLER_189_1122 VDD VDD VSS VSS gf180mcu_as_sc_mcu7t3v3__fillcap_8
XFILLER_189_1188 VDD VDD VSS VSS gf180mcu_as_sc_mcu7t3v3__fill_2
XFILLER_187_438 VDD VDD VSS VSS gf180mcu_as_sc_mcu7t3v3__fillcap_4
XFILLER_52_31 VDD VDD VSS VSS gf180mcu_as_sc_mcu7t3v3__fillcap_4
XFILLER_11_842 VDD VDD VSS VSS gf180mcu_as_sc_mcu7t3v3__fillcap_4
Xwire700 VDD VDD VSS VSS _3272_/Y wire700/Y gf180mcu_as_sc_mcu7t3v3__clkbuff_12
XFILLER_168_53 VDD VDD VSS VSS gf180mcu_as_sc_mcu7t3v3__fill_2
Xinput18 VDD VDD VSS VSS boot_data[6] _2729_/A gf180mcu_as_sc_mcu7t3v3__buff_12
XFILLER_10_363 VDD VDD VSS VSS gf180mcu_as_sc_mcu7t3v3__fill_2
XFILLER_168_86 VDD VDD VSS VSS gf180mcu_as_sc_mcu7t3v3__fillcap_4
Xinput29 VDD VDD VSS VSS dft_addr[6] _2664_/B gf180mcu_as_sc_mcu7t3v3__buff_12
XFILLER_155_368 VDD VDD VSS VSS gf180mcu_as_sc_mcu7t3v3__fillcap_8
XFILLER_171_828 VDD VDD VSS VSS gf180mcu_as_sc_mcu7t3v3__fill_2
XFILLER_171_839 VDD VDD VSS VSS gf180mcu_as_sc_mcu7t3v3__fill_1
XFILLER_183_699 VDD VDD VSS VSS gf180mcu_as_sc_mcu7t3v3__fill_1
XFILLER_7_879 VDD VDD VSS VSS gf180mcu_as_sc_mcu7t3v3__fill_2
XFILLER_164_891 VDD VDD VSS VSS gf180mcu_as_sc_mcu7t3v3__fillcap_16
XFILLER_184_30 VDD VDD VSS VSS gf180mcu_as_sc_mcu7t3v3__fillcap_4
XFILLER_184_85 VDD VDD VSS VSS gf180mcu_as_sc_mcu7t3v3__fillcap_16
XFILLER_83_1318 VDD VDD VSS VSS gf180mcu_as_sc_mcu7t3v3__fillcap_4
XTAP_TAPCELL_ROW_76_3_1987 VDD VSS gf180mcu_as_sc_mcu7t3v3__tap_2
XPHY_EDGE_ROW_33_1_Right_542 VDD VSS gf180mcu_as_sc_mcu7t3v3__tap_2
XFILLER_77_72 VDD VDD VSS VSS gf180mcu_as_sc_mcu7t3v3__fillcap_8
XPHY_EDGE_ROW_94_3_Right_135 VDD VSS gf180mcu_as_sc_mcu7t3v3__tap_2
XFILLER_20_1302 VDD VDD VSS VSS gf180mcu_as_sc_mcu7t3v3__fill_1
XFILLER_168_1239 VDD VDD VSS VSS gf180mcu_as_sc_mcu7t3v3__fill_2
XFILLER_179_928 VDD VDD VSS VSS gf180mcu_as_sc_mcu7t3v3__fillcap_16
X_4840_ VDD VDD VSS VSS _5216_/CLK _4840_/D _4840_/Q gf180mcu_as_sc_mcu7t3v3__dfxtp_2
XFILLER_159_652 VDD VDD VSS VSS gf180mcu_as_sc_mcu7t3v3__fill_2
X_4771_ VDD VDD VSS VSS _5275_/CLK _4771_/D _4771_/Q gf180mcu_as_sc_mcu7t3v3__dfxtp_2
XFILLER_105_1256 VDD VDD VSS VSS gf180mcu_as_sc_mcu7t3v3__fillcap_8
X_3722_ VDD VDD VSS VSS _3738_/D _3794_/S _3722_/B _3722_/C _3723_/C gf180mcu_as_sc_mcu7t3v3__ao31_2
XTAP_TAPCELL_ROW_158_1251 VDD VSS gf180mcu_as_sc_mcu7t3v3__tap_2
XTAP_TAPCELL_ROW_158_1240 VDD VSS gf180mcu_as_sc_mcu7t3v3__tap_2
X_3653_ VDD VDD VSS VSS _3654_/C _3653_/C _3653_/B _4025_/A gf180mcu_as_sc_mcu7t3v3__aoi21_2
XPHY_EDGE_ROW_31_1_Left_223 VDD VSS gf180mcu_as_sc_mcu7t3v3__tap_2
XFILLER_162_828 VDD VDD VSS VSS gf180mcu_as_sc_mcu7t3v3__fillcap_16
XFILLER_174_699 VDD VDD VSS VSS gf180mcu_as_sc_mcu7t3v3__fillcap_16
X_2604_ VDD VDD VSS VSS _2676_/A _2604_/B _2604_/A _2604_/Y gf180mcu_as_sc_mcu7t3v3__mux2_2
XFILLER_161_327 VDD VDD VSS VSS gf180mcu_as_sc_mcu7t3v3__fillcap_16
XFILLER_161_349 VDD VDD VSS VSS gf180mcu_as_sc_mcu7t3v3__fill_1
XFILLER_173_198 VDD VDD VSS VSS gf180mcu_as_sc_mcu7t3v3__fill_1
X_3584_ VDD VDD VSS VSS _3585_/C _3947_/A _3673_/C _3584_/C gf180mcu_as_sc_mcu7t3v3__ao21_2
X_2535_ VDD VDD VSS VSS _5158_/Q _5157_/Q _4354_/B gf180mcu_as_sc_mcu7t3v3__or2_2
XTAP_TAPCELL_ROW_171_1495 VDD VSS gf180mcu_as_sc_mcu7t3v3__tap_2
X_5254_ VDD VDD VSS VSS _5266_/CLK _5254_/D _5254_/Q gf180mcu_as_sc_mcu7t3v3__dfxtp_2
X_2466_ VDD VDD VSS VSS _2467_/B _2466_/A gf180mcu_as_sc_mcu7t3v3__inv_2
XFILLER_190_1281 VDD VDD VSS VSS gf180mcu_as_sc_mcu7t3v3__fillcap_8
XFILLER_64_1284 VDD VDD VSS VSS gf180mcu_as_sc_mcu7t3v3__fillcap_4
X_5185_ VDD VDD VSS VSS _5185_/CLK _5185_/D _5185_/Q gf180mcu_as_sc_mcu7t3v3__dfxtp_2
X_4205_ VDD VDD VSS VSS _4234_/B _4220_/B _4220_/C _5041_/Q _5041_/D gf180mcu_as_sc_mcu7t3v3__ao22_2
XFILLER_3_80 VDD VDD VSS VSS gf180mcu_as_sc_mcu7t3v3__fillcap_4
XFILLER_5_1329 VDD VDD VSS VSS gf180mcu_as_sc_mcu7t3v3__fill_1
X_4136_ VDD VDD VSS VSS _4136_/A _4154_/B _4141_/B _4136_/D _4140_/A gf180mcu_as_sc_mcu7t3v3__ao211_2
X_2397_ VDD VDD VSS VSS _2558_/A _2747_/A gf180mcu_as_sc_mcu7t3v3__inv_2
X_4067_ VDD VDD VSS VSS _4067_/A _4067_/B _4067_/C _4245_/B _4067_/D gf180mcu_as_sc_mcu7t3v3__aoi211_2
XTAP_TAPCELL_ROW_117_1_1070 VDD VSS gf180mcu_as_sc_mcu7t3v3__tap_2
X_3018_ VDD VDD VSS VSS _3999_/A _3222_/D _3236_/C _4000_/D _3019_/C gf180mcu_as_sc_mcu7t3v3__ao22_2
XFILLER_169_438 VDD VDD VSS VSS gf180mcu_as_sc_mcu7t3v3__fillcap_16
XTAP_TAPCELL_ROW_178_1627 VDD VSS gf180mcu_as_sc_mcu7t3v3__tap_2
XFILLER_185_909 VDD VDD VSS VSS gf180mcu_as_sc_mcu7t3v3__fill_1
X_4969_ VDD VDD VSS VSS _5164_/CLK _4969_/D _4969_/Q gf180mcu_as_sc_mcu7t3v3__dfxtp_2
XFILLER_7_109 VDD VDD VSS VSS gf180mcu_as_sc_mcu7t3v3__fill_1
XFILLER_192_441 VDD VDD VSS VSS gf180mcu_as_sc_mcu7t3v3__fill_1
XFILLER_153_839 VDD VDD VSS VSS gf180mcu_as_sc_mcu7t3v3__fill_1
XFILLER_192_452 VDD VDD VSS VSS gf180mcu_as_sc_mcu7t3v3__fill_1
XPHY_EDGE_ROW_88_1_Left_280 VDD VSS gf180mcu_as_sc_mcu7t3v3__tap_2
XPHY_EDGE_ROW_43_3_Right_84 VDD VSS gf180mcu_as_sc_mcu7t3v3__tap_2
XFILLER_152_1018 VDD VDD VSS VSS gf180mcu_as_sc_mcu7t3v3__fill_2
XFILLER_160_371 VDD VDD VSS VSS gf180mcu_as_sc_mcu7t3v3__fill_2
XFILLER_191_1034 VDD VDD VSS VSS gf180mcu_as_sc_mcu7t3v3__fill_1
XFILLER_156_1198 VDD VDD VSS VSS gf180mcu_as_sc_mcu7t3v3__fillcap_16
XPHY_EDGE_ROW_46_3_Left_418 VDD VSS gf180mcu_as_sc_mcu7t3v3__tap_2
XFILLER_47_31 VDD VDD VSS VSS gf180mcu_as_sc_mcu7t3v3__fill_2
XFILLER_128_1256 VDD VDD VSS VSS gf180mcu_as_sc_mcu7t3v3__fillcap_8
XFILLER_169_972 VDD VDD VSS VSS gf180mcu_as_sc_mcu7t3v3__fillcap_8
XFILLER_7_632 VDD VDD VSS VSS gf180mcu_as_sc_mcu7t3v3__fillcap_4
XFILLER_13_1150 VDD VDD VSS VSS gf180mcu_as_sc_mcu7t3v3__fill_1
XFILLER_170_102 VDD VDD VSS VSS gf180mcu_as_sc_mcu7t3v3__fill_2
XFILLER_174_1276 VDD VDD VSS VSS gf180mcu_as_sc_mcu7t3v3__fillcap_16
XFILLER_88_71 VDD VDD VSS VSS gf180mcu_as_sc_mcu7t3v3__fill_1
XPHY_EDGE_ROW_34_1_Right_543 VDD VSS gf180mcu_as_sc_mcu7t3v3__tap_2
XFILLER_170_1129 VDD VDD VSS VSS gf180mcu_as_sc_mcu7t3v3__fillcap_16
XTAP_TAPCELL_ROW_24_3_1935 VDD VSS gf180mcu_as_sc_mcu7t3v3__tap_2
XPHY_EDGE_ROW_95_3_Right_136 VDD VSS gf180mcu_as_sc_mcu7t3v3__tap_2
XFILLER_168_1014 VDD VDD VSS VSS gf180mcu_as_sc_mcu7t3v3__fill_1
XFILLER_94_1288 VDD VDD VSS VSS gf180mcu_as_sc_mcu7t3v3__fill_1
XPHY_EDGE_ROW_92_3_Left_464 VDD VSS gf180mcu_as_sc_mcu7t3v3__tap_2
XFILLER_179_769 VDD VDD VSS VSS gf180mcu_as_sc_mcu7t3v3__fill_1
X_4823_ VDD VDD VSS VSS clkload3/A _4823_/D _4823_/Q gf180mcu_as_sc_mcu7t3v3__dfxtp_2
XFILLER_159_460 VDD VDD VSS VSS gf180mcu_as_sc_mcu7t3v3__fill_1
XFILLER_159_471 VDD VDD VSS VSS gf180mcu_as_sc_mcu7t3v3__fillcap_4
X_4754_ VDD VDD VSS VSS _5226_/CLK _4754_/D _4754_/Q gf180mcu_as_sc_mcu7t3v3__dfxtp_2
X_3705_ VDD VDD VSS VSS _3706_/C _3705_/C _3783_/B _4081_/A gf180mcu_as_sc_mcu7t3v3__aoi21_2
XTAP_TAPCELL_ROW_173_1535 VDD VSS gf180mcu_as_sc_mcu7t3v3__tap_2
XTAP_TAPCELL_ROW_173_1524 VDD VSS gf180mcu_as_sc_mcu7t3v3__tap_2
XFILLER_174_452 VDD VDD VSS VSS gf180mcu_as_sc_mcu7t3v3__fill_2
X_4685_ VDD VDD VSS VSS _5103_/Q _4700_/S _4685_/C _5249_/Q _4686_/D gf180mcu_as_sc_mcu7t3v3__ao22_2
X_3636_ VDD VDD VSS VSS _3636_/D _4008_/D _3728_/B _3728_/C _3637_/C gf180mcu_as_sc_mcu7t3v3__ao31_2
XTAP_TAPCELL_ROW_190_1860 VDD VSS gf180mcu_as_sc_mcu7t3v3__tap_2
XFILLER_108_37 VDD VDD VSS VSS gf180mcu_as_sc_mcu7t3v3__fillcap_16
X_3567_ VDD VDD VSS VSS _4915_/Q _3799_/B _3748_/C _3930_/A _3568_/D gf180mcu_as_sc_mcu7t3v3__ao22_2
X_2518_ VDD VDD VSS VSS _4704_/B _4630_/A _4703_/A gf180mcu_as_sc_mcu7t3v3__nand2_2
X_5237_ VDD VDD VSS VSS _5277_/CLK _5237_/D _5237_/Q gf180mcu_as_sc_mcu7t3v3__dfxtp_2
Xinput208 VDD VDD VSS VSS se_in[3] wire878/A gf180mcu_as_sc_mcu7t3v3__buff_12
X_3498_ VDD VDD VSS VSS _3505_/S _3498_/B _4156_/A _3499_/B gf180mcu_as_sc_mcu7t3v3__mux2_2
XFILLER_5_1115 VDD VDD VSS VSS gf180mcu_as_sc_mcu7t3v3__fillcap_4
XFILLER_9_1262 VDD VDD VSS VSS gf180mcu_as_sc_mcu7t3v3__fillcap_4
Xinput219 VDD VDD VSS VSS south_in[13] _4040_/D gf180mcu_as_sc_mcu7t3v3__buff_12
X_2449_ VDD VDD VSS VSS _3192_/D _4160_/A gf180mcu_as_sc_mcu7t3v3__inv_2
X_5168_ VDD VDD VSS VSS _5178_/CLK _5168_/D _5168_/Q gf180mcu_as_sc_mcu7t3v3__dfxtp_2
X_5099_ VDD VDD VSS VSS _5275_/CLK _5099_/D _5099_/Q gf180mcu_as_sc_mcu7t3v3__dfxtp_2
X_4119_ VDD VDD VSS VSS _4119_/A _4162_/B _4127_/C _4119_/D _4123_/A gf180mcu_as_sc_mcu7t3v3__ao211_2
XPHY_EDGE_ROW_3_Left_196 VDD VSS gf180mcu_as_sc_mcu7t3v3__tap_2
XTAP_TAPCELL_ROW_128_3_2039 VDD VSS gf180mcu_as_sc_mcu7t3v3__tap_2
XFILLER_9_908 VDD VDD VSS VSS gf180mcu_as_sc_mcu7t3v3__fill_2
XFILLER_149_22 VDD VDD VSS VSS gf180mcu_as_sc_mcu7t3v3__fillcap_4
XFILLER_157_419 VDD VDD VSS VSS gf180mcu_as_sc_mcu7t3v3__fill_1
XFILLER_169_279 VDD VDD VSS VSS gf180mcu_as_sc_mcu7t3v3__fill_1
XFILLER_166_931 VDD VDD VSS VSS gf180mcu_as_sc_mcu7t3v3__fillcap_8
XFILLER_166_997 VDD VDD VSS VSS gf180mcu_as_sc_mcu7t3v3__fill_1
XFILLER_181_912 VDD VDD VSS VSS gf180mcu_as_sc_mcu7t3v3__fillcap_4
XFILLER_165_10 VDD VDD VSS VSS gf180mcu_as_sc_mcu7t3v3__fill_2
XFILLER_152_135 VDD VDD VSS VSS gf180mcu_as_sc_mcu7t3v3__fill_1
XFILLER_0_852 VDD VDD VSS VSS gf180mcu_as_sc_mcu7t3v3__fill_1
XFILLER_0_863 VDD VDD VSS VSS gf180mcu_as_sc_mcu7t3v3__fill_2
XFILLER_134_1260 VDD VDD VSS VSS gf180mcu_as_sc_mcu7t3v3__fill_1
XFILLER_58_85 VDD VDD VSS VSS gf180mcu_as_sc_mcu7t3v3__fillcap_4
XFILLER_188_566 VDD VDD VSS VSS gf180mcu_as_sc_mcu7t3v3__fill_2
XFILLER_15_1256 VDD VDD VSS VSS gf180mcu_as_sc_mcu7t3v3__fillcap_4
XFILLER_8_941 VDD VDD VSS VSS gf180mcu_as_sc_mcu7t3v3__fillcap_4
XFILLER_11_1109 VDD VDD VSS VSS gf180mcu_as_sc_mcu7t3v3__fill_1
XFILLER_141_1286 VDD VDD VSS VSS gf180mcu_as_sc_mcu7t3v3__fill_1
XFILLER_8_963 VDD VDD VSS VSS gf180mcu_as_sc_mcu7t3v3__fillcap_16
XFILLER_171_422 VDD VDD VSS VSS gf180mcu_as_sc_mcu7t3v3__fillcap_8
XFILLER_183_282 VDD VDD VSS VSS gf180mcu_as_sc_mcu7t3v3__fillcap_8
X_4470_ VDD VDD VSS VSS _5176_/Q _4554_/B _4563_/C _5110_/Q _4471_/B gf180mcu_as_sc_mcu7t3v3__ao22_2
X_3421_ VDD VDD VSS VSS _3502_/B _4069_/A _3421_/A _3423_/B gf180mcu_as_sc_mcu7t3v3__mux2_2
X_3352_ VDD VDD VSS VSS _4003_/A _3424_/B _3352_/C _4813_/D _3580_/D gf180mcu_as_sc_mcu7t3v3__aoi211_2
X_3283_ VDD VDD VSS VSS _3283_/A _3526_/C _3526_/D _3524_/C gf180mcu_as_sc_mcu7t3v3__nor3_2
XPHY_EDGE_ROW_35_1_Right_544 VDD VSS gf180mcu_as_sc_mcu7t3v3__tap_2
X_5022_ VDD VDD VSS VSS _5086_/CLK _5022_/D _5022_/Q gf180mcu_as_sc_mcu7t3v3__dfxtp_2
Xhold1107 VDD VDD VSS VSS _2584_/Y _2585_/B gf180mcu_as_sc_mcu7t3v3__clkbuff_4
Xhold1118 VDD VDD VSS VSS hold1150/Y _4960_/D gf180mcu_as_sc_mcu7t3v3__clkbuff_4
Xhold1129 VDD VDD VSS VSS _4951_/Q _2477_/B gf180mcu_as_sc_mcu7t3v3__clkbuff_4
XPHY_EDGE_ROW_96_3_Right_137 VDD VSS gf180mcu_as_sc_mcu7t3v3__tap_2
XTAP_TAPCELL_ROW_166_1394 VDD VSS gf180mcu_as_sc_mcu7t3v3__tap_2
XFILLER_0_70 VDD VDD VSS VSS gf180mcu_as_sc_mcu7t3v3__fillcap_4
XFILLER_110_27 VDD VDD VSS VSS gf180mcu_as_sc_mcu7t3v3__fillcap_8
X_4806_ VDD VDD VSS VSS clkload3/A _4806_/D _4806_/Q gf180mcu_as_sc_mcu7t3v3__dfxtp_2
XTAP_TAPCELL_ROW_192_1900 VDD VSS gf180mcu_as_sc_mcu7t3v3__tap_2
X_2998_ VDD VDD VSS VSS _3608_/A _3049_/B _2998_/C _2998_/Y _3638_/D gf180mcu_as_sc_mcu7t3v3__aoi211_2
XTAP_TAPCELL_ROW_192_1922 VDD VSS gf180mcu_as_sc_mcu7t3v3__tap_2
XTAP_TAPCELL_ROW_192_1911 VDD VSS gf180mcu_as_sc_mcu7t3v3__tap_2
XFILLER_163_912 VDD VDD VSS VSS gf180mcu_as_sc_mcu7t3v3__fillcap_16
XFILLER_175_772 VDD VDD VSS VSS gf180mcu_as_sc_mcu7t3v3__fillcap_8
X_4737_ VDD VDD VSS VSS _4739_/B _4742_/C _4737_/C _5270_/D gf180mcu_as_sc_mcu7t3v3__nor3_2
X_4668_ VDD VDD VSS VSS _5241_/D _5241_/Q _4685_/C _4668_/C gf180mcu_as_sc_mcu7t3v3__ao21_2
XFILLER_102_8 VDD VDD VSS VSS gf180mcu_as_sc_mcu7t3v3__fill_1
XFILLER_190_764 VDD VDD VSS VSS gf180mcu_as_sc_mcu7t3v3__fill_2
X_3619_ VDD VDD VSS VSS _3991_/A _3649_/B _3649_/C _3989_/D _3620_/D gf180mcu_as_sc_mcu7t3v3__ao22_2
Xmax_cap660 VDD VDD VSS VSS _3262_/Y fanout658/A gf180mcu_as_sc_mcu7t3v3__clkbuff_12
X_4599_ VDD VDD VSS VSS _5193_/Q _4617_/B _4617_/C _5194_/Q _5193_/D gf180mcu_as_sc_mcu7t3v3__ao22_2
XFILLER_0_104 VDD VDD VSS VSS gf180mcu_as_sc_mcu7t3v3__fill_2
XFILLER_192_1151 VDD VDD VSS VSS gf180mcu_as_sc_mcu7t3v3__fill_1
XFILLER_192_1162 VDD VDD VSS VSS gf180mcu_as_sc_mcu7t3v3__fill_1
XFILLER_153_1157 VDD VDD VSS VSS gf180mcu_as_sc_mcu7t3v3__fillcap_4
XPHY_EDGE_ROW_119_1_Left_311 VDD VSS gf180mcu_as_sc_mcu7t3v3__tap_2
XFILLER_192_6 VDD VDD VSS VSS gf180mcu_as_sc_mcu7t3v3__fill_2
XFILLER_151_45 VDD VDD VSS VSS gf180mcu_as_sc_mcu7t3v3__fillcap_8
XFILLER_151_67 VDD VDD VSS VSS gf180mcu_as_sc_mcu7t3v3__fill_2
XFILLER_164_1220 VDD VDD VSS VSS gf180mcu_as_sc_mcu7t3v3__fillcap_4
XFILLER_189_319 VDD VDD VSS VSS gf180mcu_as_sc_mcu7t3v3__fill_2
XFILLER_77_1272 VDD VDD VSS VSS gf180mcu_as_sc_mcu7t3v3__fill_2
XTAP_TAPCELL_ROW_0_682 VDD VSS gf180mcu_as_sc_mcu7t3v3__tap_2
XTAP_TAPCELL_ROW_0_671 VDD VSS gf180mcu_as_sc_mcu7t3v3__tap_2
XFILLER_38_1256 VDD VDD VSS VSS gf180mcu_as_sc_mcu7t3v3__fillcap_8
Xsram2048.u_bank1_921 VDD VDD VSS VSS sram2048.u_bank1/WEN[2] gf180mcu_as_sc_mcu7t3v3__tiel_4
XTAP_TAPCELL_ROW_0_693 VDD VSS gf180mcu_as_sc_mcu7t3v3__tap_2
XFILLER_13_745 VDD VDD VSS VSS gf180mcu_as_sc_mcu7t3v3__fill_2
XFILLER_164_1275 VDD VDD VSS VSS gf180mcu_as_sc_mcu7t3v3__fill_1
XFILLER_164_1297 VDD VDD VSS VSS gf180mcu_as_sc_mcu7t3v3__fillcap_4
XFILLER_100_71 VDD VDD VSS VSS gf180mcu_as_sc_mcu7t3v3__fillcap_16
XFILLER_9_749 VDD VDD VSS VSS gf180mcu_as_sc_mcu7t3v3__fill_2
XTAP_TAPCELL_ROW_11_902 VDD VSS gf180mcu_as_sc_mcu7t3v3__tap_2
XFILLER_153_422 VDD VDD VSS VSS gf180mcu_as_sc_mcu7t3v3__fillcap_4
XFILLER_176_53 VDD VDD VSS VSS gf180mcu_as_sc_mcu7t3v3__fillcap_8
XFILLER_153_455 VDD VDD VSS VSS gf180mcu_as_sc_mcu7t3v3__fillcap_16
XFILLER_158_1035 VDD VDD VSS VSS gf180mcu_as_sc_mcu7t3v3__fill_1
XFILLER_5_944 VDD VDD VSS VSS gf180mcu_as_sc_mcu7t3v3__fillcap_4
XFILLER_101_1281 VDD VDD VSS VSS gf180mcu_as_sc_mcu7t3v3__fill_2
XFILLER_10_1164 VDD VDD VSS VSS gf180mcu_as_sc_mcu7t3v3__fill_2
XFILLER_158_1068 VDD VDD VSS VSS gf180mcu_as_sc_mcu7t3v3__fillcap_4
XTAP_TAPCELL_ROW_140_1_1093 VDD VSS gf180mcu_as_sc_mcu7t3v3__tap_2
XFILLER_10_1197 VDD VDD VSS VSS gf180mcu_as_sc_mcu7t3v3__fill_2
XFILLER_192_74 VDD VDD VSS VSS gf180mcu_as_sc_mcu7t3v3__fill_2
XPHY_EDGE_ROW_103_1_Left_295 VDD VSS gf180mcu_as_sc_mcu7t3v3__tap_2
XPHY_EDGE_ROW_13_Right_13 VDD VSS gf180mcu_as_sc_mcu7t3v3__tap_2
XFILLER_85_72 VDD VDD VSS VSS gf180mcu_as_sc_mcu7t3v3__fillcap_4
XFILLER_85_94 VDD VDD VSS VSS gf180mcu_as_sc_mcu7t3v3__fill_1
XPHY_EDGE_ROW_40_1_Left_232 VDD VSS gf180mcu_as_sc_mcu7t3v3__tap_2
XFILLER_165_1028 VDD VDD VSS VSS gf180mcu_as_sc_mcu7t3v3__fill_1
XFILLER_1_1354 VDD VDD VSS VSS gf180mcu_as_sc_mcu7t3v3__fill_1
X_3970_ VDD VDD VSS VSS _3971_/C _3970_/B _3970_/A gf180mcu_as_sc_mcu7t3v3__nor2_2
XTAP_TAPCELL_ROW_19_3_1930 VDD VSS gf180mcu_as_sc_mcu7t3v3__tap_2
XFILLER_189_842 VDD VDD VSS VSS gf180mcu_as_sc_mcu7t3v3__fillcap_4
X_2921_ VDD VDD VSS VSS _3553_/A _3554_/A _3814_/A _2932_/C gf180mcu_as_sc_mcu7t3v3__nand3_2
XFILLER_143_1326 VDD VDD VSS VSS gf180mcu_as_sc_mcu7t3v3__fillcap_4
X_2852_ VDD VDD VSS VSS _2852_/Y _3874_/A _2852_/B _5097_/Q gf180mcu_as_sc_mcu7t3v3__aoi21_2
X_2783_ VDD VDD VSS VSS _2783_/B _2783_/A _4647_/A gf180mcu_as_sc_mcu7t3v3__and2_2
XFILLER_116_102 VDD VDD VSS VSS gf180mcu_as_sc_mcu7t3v3__fill_2
XFILLER_157_772 VDD VDD VSS VSS gf180mcu_as_sc_mcu7t3v3__fillcap_16
XFILLER_157_794 VDD VDD VSS VSS gf180mcu_as_sc_mcu7t3v3__fill_1
XFILLER_184_580 VDD VDD VSS VSS gf180mcu_as_sc_mcu7t3v3__fill_1
XFILLER_8_771 VDD VDD VSS VSS gf180mcu_as_sc_mcu7t3v3__fill_1
XFILLER_8_782 VDD VDD VSS VSS gf180mcu_as_sc_mcu7t3v3__fillcap_16
X_4522_ VDD VDD VSS VSS _5180_/Q _4574_/B _4522_/C _4522_/D _5180_/D gf180mcu_as_sc_mcu7t3v3__ao211_2
XFILLER_172_764 VDD VDD VSS VSS gf180mcu_as_sc_mcu7t3v3__fillcap_4
X_4453_ VDD VDD VSS VSS _4453_/B _4524_/A _4460_/C gf180mcu_as_sc_mcu7t3v3__and2_2
XFILLER_176_1157 VDD VDD VSS VSS gf180mcu_as_sc_mcu7t3v3__fill_2
X_3404_ VDD VDD VSS VSS _4053_/A _3451_/B _3404_/C _3404_/D _3405_/A gf180mcu_as_sc_mcu7t3v3__ao211_2
X_4384_ VDD VDD VSS VSS _4385_/D _4384_/B _4560_/A gf180mcu_as_sc_mcu7t3v3__nor2_2
Xfanout717 VDD VDD VSS VSS fanout717/A _3748_/C gf180mcu_as_sc_mcu7t3v3__buff_12
Xfanout728 VDD VDD VSS VSS wire731/Y _3448_/C gf180mcu_as_sc_mcu7t3v3__buff_12
Xfanout739 VDD VDD VSS VSS _3542_/Y _3799_/B gf180mcu_as_sc_mcu7t3v3__buff_12
X_3335_ VDD VDD VSS VSS _3616_/A _3463_/B _3335_/C _4811_/D _3615_/D gf180mcu_as_sc_mcu7t3v3__aoi211_2
XTAP_TAPCELL_ROW_168_1434 VDD VSS gf180mcu_as_sc_mcu7t3v3__tap_2
XFILLER_150_1319 VDD VDD VSS VSS gf180mcu_as_sc_mcu7t3v3__fill_2
X_3266_ VDD VDD VSS VSS _3275_/B _3266_/B _3807_/A gf180mcu_as_sc_mcu7t3v3__nand2_2
XTAP_TAPCELL_ROW_168_1445 VDD VSS gf180mcu_as_sc_mcu7t3v3__tap_2
XPHY_EDGE_ROW_36_1_Right_545 VDD VSS gf180mcu_as_sc_mcu7t3v3__tap_2
X_5005_ VDD VDD VSS VSS _5175_/CLK _5005_/D _5005_/Q gf180mcu_as_sc_mcu7t3v3__dfxtp_2
XTAP_TAPCELL_ROW_185_1770 VDD VSS gf180mcu_as_sc_mcu7t3v3__tap_2
X_3197_ VDD VDD VSS VSS _3227_/S _3197_/B _3788_/A _3198_/B gf180mcu_as_sc_mcu7t3v3__mux2_2
XPHY_EDGE_ROW_97_3_Right_138 VDD VSS gf180mcu_as_sc_mcu7t3v3__tap_2
XTAP_TAPCELL_ROW_181_1689 VDD VSS gf180mcu_as_sc_mcu7t3v3__tap_2
XTAP_TAPCELL_ROW_181_1678 VDD VSS gf180mcu_as_sc_mcu7t3v3__tap_2
XFILLER_121_37 VDD VDD VSS VSS gf180mcu_as_sc_mcu7t3v3__fillcap_4
XFILLER_121_48 VDD VDD VSS VSS gf180mcu_as_sc_mcu7t3v3__fillcap_16
XFILLER_183_1106 VDD VDD VSS VSS gf180mcu_as_sc_mcu7t3v3__fill_1
XPHY_EDGE_ROW_52_3_Right_93 VDD VSS gf180mcu_as_sc_mcu7t3v3__tap_2
XFILLER_179_352 VDD VDD VSS VSS gf180mcu_as_sc_mcu7t3v3__fillcap_8
XFILLER_10_726 VDD VDD VSS VSS gf180mcu_as_sc_mcu7t3v3__fillcap_8
XFILLER_10_748 VDD VDD VSS VSS gf180mcu_as_sc_mcu7t3v3__fillcap_8
XPHY_EDGE_ROW_55_3_Left_427 VDD VSS gf180mcu_as_sc_mcu7t3v3__tap_2
XFILLER_5_218 VDD VDD VSS VSS gf180mcu_as_sc_mcu7t3v3__fill_1
XFILLER_30_34 VDD VDD VSS VSS gf180mcu_as_sc_mcu7t3v3__fill_1
XFILLER_30_67 VDD VDD VSS VSS gf180mcu_as_sc_mcu7t3v3__fill_1
XFILLER_1_457 VDD VDD VSS VSS gf180mcu_as_sc_mcu7t3v3__fill_2
XFILLER_162_22 VDD VDD VSS VSS gf180mcu_as_sc_mcu7t3v3__fillcap_8
XFILLER_162_44 VDD VDD VSS VSS gf180mcu_as_sc_mcu7t3v3__fillcap_8
XFILLER_39_43 VDD VDD VSS VSS gf180mcu_as_sc_mcu7t3v3__fill_2
XFILLER_44_1260 VDD VDD VSS VSS gf180mcu_as_sc_mcu7t3v3__fill_2
XFILLER_79_1301 VDD VDD VSS VSS gf180mcu_as_sc_mcu7t3v3__fill_1
XTAP_TAPCELL_ROW_5_785 VDD VSS gf180mcu_as_sc_mcu7t3v3__tap_2
XFILLER_55_97 VDD VDD VSS VSS gf180mcu_as_sc_mcu7t3v3__fillcap_8
XFILLER_186_801 VDD VDD VSS VSS gf180mcu_as_sc_mcu7t3v3__fillcap_4
XFILLER_13_586 VDD VDD VSS VSS gf180mcu_as_sc_mcu7t3v3__fill_1
XFILLER_185_322 VDD VDD VSS VSS gf180mcu_as_sc_mcu7t3v3__fill_2
XFILLER_186_845 VDD VDD VSS VSS gf180mcu_as_sc_mcu7t3v3__fillcap_4
XFILLER_90_1291 VDD VDD VSS VSS gf180mcu_as_sc_mcu7t3v3__fillcap_8
XPHY_EDGE_ROW_59_3_Right_100 VDD VSS gf180mcu_as_sc_mcu7t3v3__tap_2
XFILLER_154_753 VDD VDD VSS VSS gf180mcu_as_sc_mcu7t3v3__fillcap_4
XFILLER_5_763 VDD VDD VSS VSS gf180mcu_as_sc_mcu7t3v3__fillcap_4
X_3120_ VDD VDD VSS VSS _3153_/A _3120_/B _3120_/C _3153_/D _3122_/C gf180mcu_as_sc_mcu7t3v3__ao211_2
X_3051_ VDD VDD VSS VSS _3126_/S _4030_/A _4030_/D _3053_/B gf180mcu_as_sc_mcu7t3v3__mux2_2
XTAP_TAPCELL_ROW_163_1342 VDD VSS gf180mcu_as_sc_mcu7t3v3__tap_2
XFILLER_1_1184 VDD VDD VSS VSS gf180mcu_as_sc_mcu7t3v3__fillcap_4
XFILLER_177_823 VDD VDD VSS VSS gf180mcu_as_sc_mcu7t3v3__fill_2
X_3953_ VDD VDD VSS VSS _3953_/A _4027_/B _3953_/C _3953_/D _3954_/B gf180mcu_as_sc_mcu7t3v3__ao22_2
XTAP_TAPCELL_ROW_66_1_1019 VDD VSS gf180mcu_as_sc_mcu7t3v3__tap_2
XFILLER_189_683 VDD VDD VSS VSS gf180mcu_as_sc_mcu7t3v3__fillcap_4
X_3884_ VDD VDD VSS VSS _4946_/D _5174_/Q _4924_/D gf180mcu_as_sc_mcu7t3v3__and2_2
X_2904_ VDD VDD VSS VSS _3932_/A _3790_/A _3535_/A gf180mcu_as_sc_mcu7t3v3__nor2_2
XFILLER_108_1276 VDD VDD VSS VSS gf180mcu_as_sc_mcu7t3v3__fill_1
XFILLER_176_355 VDD VDD VSS VSS gf180mcu_as_sc_mcu7t3v3__fill_1
X_2835_ VDD VDD VSS VSS _4747_/D _2835_/A _4762_/D gf180mcu_as_sc_mcu7t3v3__and2_2
XFILLER_157_580 VDD VDD VSS VSS gf180mcu_as_sc_mcu7t3v3__fillcap_8
X_2766_ VDD VDD VSS VSS _4691_/A _2766_/B _2766_/C _4754_/Q _2840_/C gf180mcu_as_sc_mcu7t3v3__ao211_2
X_5485_ VDD VDD VSS VSS _5485_/A _5485_/Y gf180mcu_as_sc_mcu7t3v3__buff_2
X_4505_ VDD VDD VSS VSS _5180_/Q _4590_/B _4523_/C _5114_/Q _4506_/B gf180mcu_as_sc_mcu7t3v3__ao22_2
X_2697_ VDD VDD VSS VSS _2724_/S _5175_/Q _5167_/Q _2699_/B gf180mcu_as_sc_mcu7t3v3__mux2_2
XFILLER_172_594 VDD VDD VSS VSS gf180mcu_as_sc_mcu7t3v3__fill_1
XFILLER_6_80 VDD VDD VSS VSS gf180mcu_as_sc_mcu7t3v3__fillcap_16
X_4436_ VDD VDD VSS VSS _4440_/B _5071_/Q _4473_/A gf180mcu_as_sc_mcu7t3v3__nand2_2
XFILLER_116_48 VDD VDD VSS VSS gf180mcu_as_sc_mcu7t3v3__fillcap_8
XFILLER_154_1241 VDD VDD VSS VSS gf180mcu_as_sc_mcu7t3v3__fill_1
Xfanout503 VDD VDD VSS VSS _3654_/B _3652_/D gf180mcu_as_sc_mcu7t3v3__buff_12
X_4367_ VDD VDD VSS VSS _4367_/B _4590_/B _4368_/C gf180mcu_as_sc_mcu7t3v3__and2_2
Xfanout525 VDD VDD VSS VSS _3476_/D _3391_/A gf180mcu_as_sc_mcu7t3v3__buff_12
Xfanout536 VDD VDD VSS VSS _4334_/Y _4515_/A gf180mcu_as_sc_mcu7t3v3__buff_12
X_3318_ VDD VDD VSS VSS _3391_/A _3318_/B _3318_/C _3319_/C gf180mcu_as_sc_mcu7t3v3__nor3_2
XFILLER_189_1304 VDD VDD VSS VSS gf180mcu_as_sc_mcu7t3v3__fill_1
XFILLER_28_1288 VDD VDD VSS VSS gf180mcu_as_sc_mcu7t3v3__fill_1
Xfanout558 VDD VDD VSS VSS fanout559/Y _4254_/S gf180mcu_as_sc_mcu7t3v3__buff_12
Xfanout569 VDD VDD VSS VSS _3523_/B _3513_/C gf180mcu_as_sc_mcu7t3v3__buff_12
X_4298_ VDD VDD VSS VSS _4326_/S _5128_/Q _5127_/Q _5127_/D gf180mcu_as_sc_mcu7t3v3__mux2_2
XTAP_TAPCELL_ROW_183_1729 VDD VSS gf180mcu_as_sc_mcu7t3v3__tap_2
XTAP_TAPCELL_ROW_183_1718 VDD VSS gf180mcu_as_sc_mcu7t3v3__tap_2
XFILLER_189_1348 VDD VDD VSS VSS gf180mcu_as_sc_mcu7t3v3__fillcap_4
Xmesh_tile_962 VDD VDD VSS VSS north_out[2] gf180mcu_as_sc_mcu7t3v3__tiel_4
Xmesh_tile_951 VDD VDD VSS VSS ne_out[25] gf180mcu_as_sc_mcu7t3v3__tiel_4
Xmesh_tile_940 VDD VDD VSS VSS ne_out[14] gf180mcu_as_sc_mcu7t3v3__tiel_4
X_3249_ VDD VDD VSS VSS _3510_/C _3249_/B _3914_/A gf180mcu_as_sc_mcu7t3v3__nand2_2
XTAP_TAPCELL_ROW_2_733 VDD VSS gf180mcu_as_sc_mcu7t3v3__tap_2
XTAP_TAPCELL_ROW_2_722 VDD VSS gf180mcu_as_sc_mcu7t3v3__tap_2
XPHY_EDGE_ROW_37_1_Right_546 VDD VSS gf180mcu_as_sc_mcu7t3v3__tap_2
XFILLER_6_1084 VDD VDD VSS VSS gf180mcu_as_sc_mcu7t3v3__fill_1
Xmesh_tile_995 VDD VDD VSS VSS nw_out[1] gf180mcu_as_sc_mcu7t3v3__tiel_4
Xmesh_tile_984 VDD VDD VSS VSS north_out[24] gf180mcu_as_sc_mcu7t3v3__tiel_4
Xmesh_tile_973 VDD VDD VSS VSS north_out[13] gf180mcu_as_sc_mcu7t3v3__tiel_4
XPHY_EDGE_ROW_98_3_Right_139 VDD VSS gf180mcu_as_sc_mcu7t3v3__tap_2
XFILLER_74_1264 VDD VDD VSS VSS gf180mcu_as_sc_mcu7t3v3__fillcap_4
XFILLER_161_1278 VDD VDD VSS VSS gf180mcu_as_sc_mcu7t3v3__fill_2
Xwire904 VDD VDD VSS VSS wire904/A _4045_/A gf180mcu_as_sc_mcu7t3v3__clkbuff_12
XFILLER_41_33 VDD VDD VSS VSS gf180mcu_as_sc_mcu7t3v3__fill_1
XFILLER_6_527 VDD VDD VSS VSS gf180mcu_as_sc_mcu7t3v3__fillcap_4
XFILLER_157_55 VDD VDD VSS VSS gf180mcu_as_sc_mcu7t3v3__fillcap_8
XFILLER_159_1130 VDD VDD VSS VSS gf180mcu_as_sc_mcu7t3v3__fill_1
XFILLER_159_1163 VDD VDD VSS VSS gf180mcu_as_sc_mcu7t3v3__fillcap_8
XFILLER_46_1322 VDD VDD VSS VSS gf180mcu_as_sc_mcu7t3v3__fillcap_4
XFILLER_133_1314 VDD VDD VSS VSS gf180mcu_as_sc_mcu7t3v3__fill_2
XFILLER_173_65 VDD VDD VSS VSS gf180mcu_as_sc_mcu7t3v3__fillcap_4
XFILLER_2_777 VDD VDD VSS VSS gf180mcu_as_sc_mcu7t3v3__fillcap_4
XFILLER_81_1268 VDD VDD VSS VSS gf180mcu_as_sc_mcu7t3v3__fill_2
XFILLER_66_41 VDD VDD VSS VSS gf180mcu_as_sc_mcu7t3v3__fill_2
XTAP_TAPCELL_ROW_39_1_992 VDD VSS gf180mcu_as_sc_mcu7t3v3__tap_2
XFILLER_32_103 VDD VDD VSS VSS gf180mcu_as_sc_mcu7t3v3__fill_2
XFILLER_82_62 VDD VDD VSS VSS gf180mcu_as_sc_mcu7t3v3__fill_1
XFILLER_92_1353 VDD VDD VSS VSS gf180mcu_as_sc_mcu7t3v3__fill_2
XFILLER_159_823 VDD VDD VSS VSS gf180mcu_as_sc_mcu7t3v3__fill_2
XFILLER_53_1326 VDD VDD VSS VSS gf180mcu_as_sc_mcu7t3v3__fillcap_4
XFILLER_9_310 VDD VDD VSS VSS gf180mcu_as_sc_mcu7t3v3__fillcap_16
XFILLER_158_333 VDD VDD VSS VSS gf180mcu_as_sc_mcu7t3v3__fillcap_16
XFILLER_158_355 VDD VDD VSS VSS gf180mcu_as_sc_mcu7t3v3__fill_1
XFILLER_185_163 VDD VDD VSS VSS gf180mcu_as_sc_mcu7t3v3__fill_1
X_2620_ VDD VDD VSS VSS _5245_/Q _4974_/D _2831_/A _2627_/B _2620_/D gf180mcu_as_sc_mcu7t3v3__oai211_2
XFILLER_154_561 VDD VDD VSS VSS gf180mcu_as_sc_mcu7t3v3__fillcap_16
X_2551_ VDD VDD VSS VSS _2558_/D _2557_/A gf180mcu_as_sc_mcu7t3v3__inv_2
XFILLER_99_103 VDD VDD VSS VSS gf180mcu_as_sc_mcu7t3v3__fill_2
X_5270_ VDD VDD VSS VSS _5277_/CLK _5270_/D _5270_/Q gf180mcu_as_sc_mcu7t3v3__dfxtp_2
X_2482_ VDD VDD VSS VSS _2482_/B _4291_/A _4719_/A gf180mcu_as_sc_mcu7t3v3__or2_2
XFILLER_173_1149 VDD VDD VSS VSS gf180mcu_as_sc_mcu7t3v3__fillcap_16
X_4221_ VDD VDD VSS VSS _4250_/B _4227_/B _4227_/C _5057_/Q _5057_/D gf180mcu_as_sc_mcu7t3v3__ao22_2
X_4152_ VDD VDD VSS VSS _4152_/A _4152_/B _4152_/C _4942_/Q _4153_/D gf180mcu_as_sc_mcu7t3v3__ao22_2
X_4083_ VDD VDD VSS VSS _4083_/A _4086_/C _4083_/C _4247_/B _4099_/D gf180mcu_as_sc_mcu7t3v3__aoi211_2
X_3103_ VDD VDD VSS VSS _3153_/A _3103_/B _3103_/C _3153_/D _3104_/D gf180mcu_as_sc_mcu7t3v3__ao211_2
XFILLER_114_1291 VDD VDD VSS VSS gf180mcu_as_sc_mcu7t3v3__fillcap_8
X_3034_ VDD VDD VSS VSS _3126_/S _4013_/A _4015_/A _3037_/B gf180mcu_as_sc_mcu7t3v3__mux2_2
X_4985_ VDD VDD VSS VSS _5178_/CLK _4985_/D _4985_/Q gf180mcu_as_sc_mcu7t3v3__dfxtp_2
X_3936_ VDD VDD VSS VSS _3936_/A _4086_/C _3936_/C _4229_/B _4099_/D gf180mcu_as_sc_mcu7t3v3__aoi211_2
XPHY_EDGE_ROW_169_Right_31 VDD VSS gf180mcu_as_sc_mcu7t3v3__tap_2
XFILLER_192_601 VDD VDD VSS VSS gf180mcu_as_sc_mcu7t3v3__fill_2
X_3867_ VDD VDD VSS VSS _3873_/B _3868_/B _3868_/A gf180mcu_as_sc_mcu7t3v3__nand2_2
XTAP_TAPCELL_ROW_176_1588 VDD VSS gf180mcu_as_sc_mcu7t3v3__tap_2
XPHY_EDGE_ROW_128_1_Left_320 VDD VSS gf180mcu_as_sc_mcu7t3v3__tap_2
XFILLER_176_196 VDD VDD VSS VSS gf180mcu_as_sc_mcu7t3v3__fill_2
XFILLER_180_807 VDD VDD VSS VSS gf180mcu_as_sc_mcu7t3v3__fillcap_4
X_3798_ VDD VDD VSS VSS _3799_/C _3798_/B _3798_/A gf180mcu_as_sc_mcu7t3v3__nand2_2
X_2818_ VDD VDD VSS VSS _2818_/S _2827_/B _4758_/Q _4757_/D gf180mcu_as_sc_mcu7t3v3__mux2_2
XTAP_TAPCELL_ROW_176_1599 VDD VSS gf180mcu_as_sc_mcu7t3v3__tap_2
XFILLER_121_1284 VDD VDD VSS VSS gf180mcu_as_sc_mcu7t3v3__fillcap_8
XFILLER_192_667 VDD VDD VSS VSS gf180mcu_as_sc_mcu7t3v3__fillcap_4
X_2749_ VDD VDD VSS VSS _4953_/Q _2765_/D _2810_/A gf180mcu_as_sc_mcu7t3v3__xnor2_2
XFILLER_173_881 VDD VDD VSS VSS gf180mcu_as_sc_mcu7t3v3__fill_1
XTAP_TAPCELL_ROW_7_825 VDD VSS gf180mcu_as_sc_mcu7t3v3__tap_2
XPHY_EDGE_ROW_178_Right_40 VDD VSS gf180mcu_as_sc_mcu7t3v3__tap_2
XFILLER_160_597 VDD VDD VSS VSS gf180mcu_as_sc_mcu7t3v3__fillcap_4
X_4419_ VDD VDD VSS VSS _4500_/S _5069_/Q _4982_/Q _4420_/A gf180mcu_as_sc_mcu7t3v3__mux2_2
XTAP_TAPCELL_ROW_42_3_1953 VDD VSS gf180mcu_as_sc_mcu7t3v3__tap_2
XFILLER_189_1134 VDD VDD VSS VSS gf180mcu_as_sc_mcu7t3v3__fill_2
XPHY_EDGE_ROW_38_1_Right_547 VDD VSS gf180mcu_as_sc_mcu7t3v3__tap_2
XFILLER_156_804 VDD VDD VSS VSS gf180mcu_as_sc_mcu7t3v3__fill_1
XFILLER_161_1020 VDD VDD VSS VSS gf180mcu_as_sc_mcu7t3v3__fillcap_4
XFILLER_168_664 VDD VDD VSS VSS gf180mcu_as_sc_mcu7t3v3__fill_1
XFILLER_161_1064 VDD VDD VSS VSS gf180mcu_as_sc_mcu7t3v3__fillcap_16
XFILLER_7_814 VDD VDD VSS VSS gf180mcu_as_sc_mcu7t3v3__fill_1
Xinput19 VDD VDD VSS VSS boot_data[7] _2736_/A gf180mcu_as_sc_mcu7t3v3__buff_12
XPHY_EDGE_ROW_15_3_Right_56 VDD VSS gf180mcu_as_sc_mcu7t3v3__tap_2
XFILLER_182_166 VDD VDD VSS VSS gf180mcu_as_sc_mcu7t3v3__fillcap_8
XFILLER_163_380 VDD VDD VSS VSS gf180mcu_as_sc_mcu7t3v3__fillcap_16
XFILLER_184_53 VDD VDD VSS VSS gf180mcu_as_sc_mcu7t3v3__fillcap_16
Xload_slew706 VDD VDD VSS VSS _3932_/Y fanout705/A gf180mcu_as_sc_mcu7t3v3__clkbuff_12
XFILLER_137_1291 VDD VDD VSS VSS gf180mcu_as_sc_mcu7t3v3__fill_1
XFILLER_172_1193 VDD VDD VSS VSS gf180mcu_as_sc_mcu7t3v3__fillcap_16
XTAP_TAPCELL_ROW_146_3_2057 VDD VSS gf180mcu_as_sc_mcu7t3v3__tap_2
XPHY_EDGE_ROW_132_3_Left_504 VDD VSS gf180mcu_as_sc_mcu7t3v3__tap_2
XFILLER_93_72 VDD VDD VSS VSS gf180mcu_as_sc_mcu7t3v3__fillcap_8
XFILLER_179_907 VDD VDD VSS VSS gf180mcu_as_sc_mcu7t3v3__fill_2
X_4770_ VDD VDD VSS VSS _5275_/CLK _4770_/D _4770_/Q gf180mcu_as_sc_mcu7t3v3__dfxtp_2
X_3721_ VDD VDD VSS VSS _3722_/C _3721_/C _3783_/B _4097_/A gf180mcu_as_sc_mcu7t3v3__aoi21_2
XTAP_TAPCELL_ROW_158_1252 VDD VSS gf180mcu_as_sc_mcu7t3v3__tap_2
XTAP_TAPCELL_ROW_158_1241 VDD VSS gf180mcu_as_sc_mcu7t3v3__tap_2
XFILLER_158_174 VDD VDD VSS VSS gf180mcu_as_sc_mcu7t3v3__fill_1
X_3652_ VDD VDD VSS VSS _4022_/A _3652_/B _3652_/C _3652_/D _3653_/C gf180mcu_as_sc_mcu7t3v3__ao211_2
XFILLER_162_807 VDD VDD VSS VSS gf180mcu_as_sc_mcu7t3v3__fillcap_8
XFILLER_174_667 VDD VDD VSS VSS gf180mcu_as_sc_mcu7t3v3__fillcap_4
X_3583_ VDD VDD VSS VSS _3947_/D _3650_/B _3583_/C _3583_/D _3584_/C gf180mcu_as_sc_mcu7t3v3__ao211_2
X_2603_ VDD VDD VSS VSS _2701_/A _2603_/B input1/Y _2604_/A gf180mcu_as_sc_mcu7t3v3__mux2_2
XFILLER_173_188 VDD VDD VSS VSS gf180mcu_as_sc_mcu7t3v3__fillcap_8
X_2534_ VDD VDD VSS VSS _4371_/B _2534_/A _2534_/B _2534_/C _4366_/S gf180mcu_as_sc_mcu7t3v3__ao31_2
XFILLER_170_862 VDD VDD VSS VSS gf180mcu_as_sc_mcu7t3v3__fill_2
XTAP_TAPCELL_ROW_171_1496 VDD VSS gf180mcu_as_sc_mcu7t3v3__tap_2
X_5253_ VDD VDD VSS VSS _5266_/CLK _5253_/D _5253_/Q gf180mcu_as_sc_mcu7t3v3__dfxtp_2
X_4876__1092 VDD VDD VSS VSS _4876_/D gf180mcu_as_sc_mcu7t3v3__tiel_4
X_2465_ VDD VDD VSS VSS _4559_/S _5093_/Q _5006_/Q _2466_/A gf180mcu_as_sc_mcu7t3v3__mux2_2
XPHY_EDGE_ROW_127_3_Left_499 VDD VSS gf180mcu_as_sc_mcu7t3v3__tap_2
X_5184_ VDD VDD VSS VSS clkload9/A _5184_/D _5184_/Q gf180mcu_as_sc_mcu7t3v3__dfxtp_2
X_4204_ VDD VDD VSS VSS _4233_/B _4217_/B _4218_/C _5040_/Q _5040_/D gf180mcu_as_sc_mcu7t3v3__ao22_2
X_2396_ VDD VDD VSS VSS _4746_/D _2795_/A gf180mcu_as_sc_mcu7t3v3__inv_2
XFILLER_25_1258 VDD VDD VSS VSS gf180mcu_as_sc_mcu7t3v3__fill_1
X_4135_ VDD VDD VSS VSS _4135_/A _4154_/C _4151_/B _4135_/D _4136_/D gf180mcu_as_sc_mcu7t3v3__ao22_2
XFILLER_99_1326 VDD VDD VSS VSS gf180mcu_as_sc_mcu7t3v3__fill_2
XPHY_EDGE_ROW_64_3_Left_436 VDD VSS gf180mcu_as_sc_mcu7t3v3__tap_2
X_4066_ VDD VDD VSS VSS _4066_/A _4105_/B _4066_/C _4067_/C _4067_/B gf180mcu_as_sc_mcu7t3v3__aoi211_2
X_3017_ VDD VDD VSS VSS _3091_/S _3997_/D _4000_/A _3019_/B gf180mcu_as_sc_mcu7t3v3__mux2_2
XTAP_TAPCELL_ROW_178_1628 VDD VSS gf180mcu_as_sc_mcu7t3v3__tap_2
XFILLER_36_1354 VDD VDD VSS VSS gf180mcu_as_sc_mcu7t3v3__fill_1
X_4968_ VDD VDD VSS VSS _5265_/CLK _4968_/D _4968_/Q gf180mcu_as_sc_mcu7t3v3__dfxtp_2
XFILLER_11_139 VDD VDD VSS VSS gf180mcu_as_sc_mcu7t3v3__fill_1
XFILLER_71_1256 VDD VDD VSS VSS gf180mcu_as_sc_mcu7t3v3__fillcap_8
X_4899_ VDD VDD VSS VSS clkload5/A _4899_/D _4899_/Q gf180mcu_as_sc_mcu7t3v3__dfxtp_2
X_3919_ VDD VDD VSS VSS _3919_/Y _3920_/A _3920_/B gf180mcu_as_sc_mcu7t3v3__nor2_2
XFILLER_164_111 VDD VDD VSS VSS gf180mcu_as_sc_mcu7t3v3__fill_2
XFILLER_192_431 VDD VDD VSS VSS gf180mcu_as_sc_mcu7t3v3__fill_2
XFILLER_138_57 VDD VDD VSS VSS gf180mcu_as_sc_mcu7t3v3__fill_1
XFILLER_153_807 VDD VDD VSS VSS gf180mcu_as_sc_mcu7t3v3__fillcap_16
XFILLER_164_155 VDD VDD VSS VSS gf180mcu_as_sc_mcu7t3v3__fillcap_16
XTAP_TAPCELL_ROW_38_1_991 VDD VSS gf180mcu_as_sc_mcu7t3v3__tap_2
XFILLER_164_177 VDD VDD VSS VSS gf180mcu_as_sc_mcu7t3v3__fillcap_16
XFILLER_192_497 VDD VDD VSS VSS gf180mcu_as_sc_mcu7t3v3__fillcap_4
XFILLER_152_1008 VDD VDD VSS VSS gf180mcu_as_sc_mcu7t3v3__fill_1
XFILLER_154_34 VDD VDD VSS VSS gf180mcu_as_sc_mcu7t3v3__fill_1
XFILLER_170_22 VDD VDD VSS VSS gf180mcu_as_sc_mcu7t3v3__fillcap_8
XFILLER_47_76 VDD VDD VSS VSS gf180mcu_as_sc_mcu7t3v3__fill_2
XPHY_EDGE_ROW_39_1_Right_548 VDD VSS gf180mcu_as_sc_mcu7t3v3__tap_2
XFILLER_167_1262 VDD VDD VSS VSS gf180mcu_as_sc_mcu7t3v3__fillcap_16
XPHY_EDGE_ROW_177_Left_369 VDD VSS gf180mcu_as_sc_mcu7t3v3__tap_2
XFILLER_188_737 VDD VDD VSS VSS gf180mcu_as_sc_mcu7t3v3__fillcap_4
Xclkbuf_leaf_18_clk_regs VDD VDD VSS VSS clkbuf_3_6__f_clk_regs/Y _5265_/CLK gf180mcu_as_sc_mcu7t3v3__clkbuff_12
XFILLER_163_1148 VDD VDD VSS VSS gf180mcu_as_sc_mcu7t3v3__fillcap_16
XFILLER_187_258 VDD VDD VSS VSS gf180mcu_as_sc_mcu7t3v3__fillcap_16
XFILLER_11_640 VDD VDD VSS VSS gf180mcu_as_sc_mcu7t3v3__fill_1
XFILLER_168_450 VDD VDD VSS VSS gf180mcu_as_sc_mcu7t3v3__fillcap_4
XFILLER_179_97 VDD VDD VSS VSS gf180mcu_as_sc_mcu7t3v3__fillcap_4
XFILLER_8_48 VDD VDD VSS VSS gf180mcu_as_sc_mcu7t3v3__fillcap_16
XFILLER_11_662 VDD VDD VSS VSS gf180mcu_as_sc_mcu7t3v3__fill_1
XFILLER_156_645 VDD VDD VSS VSS gf180mcu_as_sc_mcu7t3v3__fillcap_16
XFILLER_7_611 VDD VDD VSS VSS gf180mcu_as_sc_mcu7t3v3__fill_1
XFILLER_156_667 VDD VDD VSS VSS gf180mcu_as_sc_mcu7t3v3__fill_1
XFILLER_171_604 VDD VDD VSS VSS gf180mcu_as_sc_mcu7t3v3__fill_1
XFILLER_155_188 VDD VDD VSS VSS gf180mcu_as_sc_mcu7t3v3__fillcap_16
XFILLER_171_648 VDD VDD VSS VSS gf180mcu_as_sc_mcu7t3v3__fill_1
Xwire597 VDD VDD VSS VSS wire597/A _4067_/D gf180mcu_as_sc_mcu7t3v3__clkbuff_12
XTAP_TAPCELL_ROW_153_1160 VDD VSS gf180mcu_as_sc_mcu7t3v3__tap_2
XFILLER_174_1222 VDD VDD VSS VSS gf180mcu_as_sc_mcu7t3v3__fill_2
XPHY_EDGE_ROW_186_Left_378 VDD VSS gf180mcu_as_sc_mcu7t3v3__tap_2
XFILLER_87_1296 VDD VDD VSS VSS gf180mcu_as_sc_mcu7t3v3__fill_2
XFILLER_168_1004 VDD VDD VSS VSS gf180mcu_as_sc_mcu7t3v3__fillcap_8
XFILLER_24_1291 VDD VDD VSS VSS gf180mcu_as_sc_mcu7t3v3__fillcap_8
XFILLER_178_258 VDD VDD VSS VSS gf180mcu_as_sc_mcu7t3v3__fill_1
XFILLER_181_1259 VDD VDD VSS VSS gf180mcu_as_sc_mcu7t3v3__fill_1
X_4822_ VDD VDD VSS VSS clkload3/A _4822_/D _4822_/Q gf180mcu_as_sc_mcu7t3v3__dfxtp_2
XFILLER_175_921 VDD VDD VSS VSS gf180mcu_as_sc_mcu7t3v3__fillcap_16
X_4753_ VDD VDD VSS VSS _5095_/D _4753_/B _4753_/A gf180mcu_as_sc_mcu7t3v3__nor2_2
X_3704_ VDD VDD VSS VSS _3704_/D _4077_/A _3704_/B _3800_/C _3705_/C gf180mcu_as_sc_mcu7t3v3__ao31_2
XTAP_TAPCELL_ROW_173_1536 VDD VSS gf180mcu_as_sc_mcu7t3v3__tap_2
XTAP_TAPCELL_ROW_173_1525 VDD VSS gf180mcu_as_sc_mcu7t3v3__tap_2
XFILLER_179_1122 VDD VDD VSS VSS gf180mcu_as_sc_mcu7t3v3__fillcap_8
XFILLER_190_902 VDD VDD VSS VSS gf180mcu_as_sc_mcu7t3v3__fillcap_4
X_4684_ VDD VDD VSS VSS _5257_/Q _4684_/A _4686_/C gf180mcu_as_sc_mcu7t3v3__or2_2
XFILLER_175_998 VDD VDD VSS VSS gf180mcu_as_sc_mcu7t3v3__fillcap_16
XFILLER_190_935 VDD VDD VSS VSS gf180mcu_as_sc_mcu7t3v3__fillcap_8
XFILLER_31_1284 VDD VDD VSS VSS gf180mcu_as_sc_mcu7t3v3__fillcap_4
X_3635_ VDD VDD VSS VSS _4924_/Q _3648_/B _3649_/C _4007_/A _3636_/D gf180mcu_as_sc_mcu7t3v3__ao22_2
XTAP_TAPCELL_ROW_190_1861 VDD VSS gf180mcu_as_sc_mcu7t3v3__tap_2
XTAP_TAPCELL_ROW_190_1850 VDD VSS gf180mcu_as_sc_mcu7t3v3__tap_2
XFILLER_192_1300 VDD VDD VSS VSS gf180mcu_as_sc_mcu7t3v3__fill_1
XFILLER_66_1303 VDD VDD VSS VSS gf180mcu_as_sc_mcu7t3v3__fill_2
X_3566_ VDD VDD VSS VSS _3566_/Y _3799_/B _3790_/C gf180mcu_as_sc_mcu7t3v3__nor2_2
XFILLER_0_308 VDD VDD VSS VSS gf180mcu_as_sc_mcu7t3v3__fillcap_4
Xmax_cap897 VDD VDD VSS VSS _2851_/A _3775_/D gf180mcu_as_sc_mcu7t3v3__clkbuff_12
X_3497_ VDD VDD VSS VSS _4155_/A _3523_/B _3497_/C _3497_/D _3498_/B gf180mcu_as_sc_mcu7t3v3__ao211_2
X_2517_ VDD VDD VSS VSS _2517_/D _4749_/A _2517_/B _2517_/C _2765_/B gf180mcu_as_sc_mcu7t3v3__ao31_2
XFILLER_170_692 VDD VDD VSS VSS gf180mcu_as_sc_mcu7t3v3__fillcap_4
X_5236_ VDD VDD VSS VSS _5277_/CLK _5236_/D _5236_/Q gf180mcu_as_sc_mcu7t3v3__dfxtp_2
Xinput209 VDD VDD VSS VSS se_in[4] wire877/A gf180mcu_as_sc_mcu7t3v3__buff_12
X_2448_ VDD VDD VSS VSS _3775_/A _4156_/A gf180mcu_as_sc_mcu7t3v3__inv_2
XPHY_EDGE_ROW_150_3_Right_191 VDD VSS gf180mcu_as_sc_mcu7t3v3__tap_2
X_5167_ VDD VDD VSS VSS _5182_/CLK _5167_/D _5167_/Q gf180mcu_as_sc_mcu7t3v3__dfxtp_2
X_5098_ VDD VDD VSS VSS _5278_/CLK _5098_/D _5098_/Q gf180mcu_as_sc_mcu7t3v3__dfxtp_2
X_4118_ VDD VDD VSS VSS _4118_/A _4160_/B _4161_/B _4118_/D _4119_/D gf180mcu_as_sc_mcu7t3v3__ao22_2
X_4049_ VDD VDD VSS VSS _4049_/A _4105_/B _4049_/C _4049_/D _4050_/B gf180mcu_as_sc_mcu7t3v3__ao211_2
XFILLER_140_69 VDD VDD VSS VSS gf180mcu_as_sc_mcu7t3v3__fill_1
XFILLER_137_100 VDD VDD VSS VSS gf180mcu_as_sc_mcu7t3v3__fillcap_4
XFILLER_166_943 VDD VDD VSS VSS gf180mcu_as_sc_mcu7t3v3__fill_2
XFILLER_184_239 VDD VDD VSS VSS gf180mcu_as_sc_mcu7t3v3__fillcap_4
XFILLER_153_615 VDD VDD VSS VSS gf180mcu_as_sc_mcu7t3v3__fillcap_4
XFILLER_158_1206 VDD VDD VSS VSS gf180mcu_as_sc_mcu7t3v3__fillcap_8
XFILLER_181_946 VDD VDD VSS VSS gf180mcu_as_sc_mcu7t3v3__fillcap_4
XFILLER_180_445 VDD VDD VSS VSS gf180mcu_as_sc_mcu7t3v3__fill_2
XFILLER_181_979 VDD VDD VSS VSS gf180mcu_as_sc_mcu7t3v3__fill_1
XFILLER_3_113 VDD VDD VSS VSS gf180mcu_as_sc_mcu7t3v3__fill_2
XFILLER_165_88 VDD VDD VSS VSS gf180mcu_as_sc_mcu7t3v3__fillcap_4
XFILLER_180_489 VDD VDD VSS VSS gf180mcu_as_sc_mcu7t3v3__fillcap_16
XFILLER_3_146 VDD VDD VSS VSS gf180mcu_as_sc_mcu7t3v3__fill_2
XFILLER_161_681 VDD VDD VSS VSS gf180mcu_as_sc_mcu7t3v3__fillcap_16
XFILLER_0_875 VDD VDD VSS VSS gf180mcu_as_sc_mcu7t3v3__fill_2
XFILLER_134_1283 VDD VDD VSS VSS gf180mcu_as_sc_mcu7t3v3__fillcap_4
XFILLER_181_54 VDD VDD VSS VSS gf180mcu_as_sc_mcu7t3v3__fillcap_16
XFILLER_169_1346 VDD VDD VSS VSS gf180mcu_as_sc_mcu7t3v3__fillcap_8
XFILLER_74_41 VDD VDD VSS VSS gf180mcu_as_sc_mcu7t3v3__fill_2
XFILLER_188_501 VDD VDD VSS VSS gf180mcu_as_sc_mcu7t3v3__fillcap_4
XFILLER_90_51 VDD VDD VSS VSS gf180mcu_as_sc_mcu7t3v3__fillcap_16
XTAP_TAPCELL_ROW_155_1200 VDD VSS gf180mcu_as_sc_mcu7t3v3__tap_2
XFILLER_168_291 VDD VDD VSS VSS gf180mcu_as_sc_mcu7t3v3__fillcap_16
XFILLER_143_103 VDD VDD VSS VSS gf180mcu_as_sc_mcu7t3v3__fill_2
XFILLER_171_412 VDD VDD VSS VSS gf180mcu_as_sc_mcu7t3v3__fillcap_8
XFILLER_183_294 VDD VDD VSS VSS gf180mcu_as_sc_mcu7t3v3__fill_2
X_3420_ VDD VDD VSS VSS _4069_/D _3500_/B _3420_/C _3420_/D _3421_/A gf180mcu_as_sc_mcu7t3v3__ao22_2
X_3351_ VDD VDD VSS VSS _3462_/A _3351_/B _3351_/C _3352_/C gf180mcu_as_sc_mcu7t3v3__nor3_2
X_3282_ VDD VDD VSS VSS _3526_/D _3286_/B gf180mcu_as_sc_mcu7t3v3__inv_2
X_5021_ VDD VDD VSS VSS _5086_/CLK _5021_/D _5021_/Q gf180mcu_as_sc_mcu7t3v3__dfxtp_2
Xhold1108 VDD VDD VSS VSS _2585_/Y _2586_/A gf180mcu_as_sc_mcu7t3v3__clkbuff_4
Xhold1119 VDD VDD VSS VSS hold1152/Y _4958_/D gf180mcu_as_sc_mcu7t3v3__clkbuff_4
XFILLER_96_1307 VDD VDD VSS VSS gf180mcu_as_sc_mcu7t3v3__fill_1
XTAP_TAPCELL_ROW_166_1395 VDD VSS gf180mcu_as_sc_mcu7t3v3__tap_2
XFILLER_0_1013 VDD VDD VSS VSS gf180mcu_as_sc_mcu7t3v3__fill_1
XTAP_TAPCELL_ROW_37_1_990 VDD VSS gf180mcu_as_sc_mcu7t3v3__tap_2
XFILLER_185_1192 VDD VDD VSS VSS gf180mcu_as_sc_mcu7t3v3__fill_2
XFILLER_10_908 VDD VDD VSS VSS gf180mcu_as_sc_mcu7t3v3__fillcap_4
XFILLER_167_718 VDD VDD VSS VSS gf180mcu_as_sc_mcu7t3v3__fillcap_16
XFILLER_179_578 VDD VDD VSS VSS gf180mcu_as_sc_mcu7t3v3__fillcap_16
X_4805_ VDD VDD VSS VSS clkload3/A _4805_/D _4805_/Q gf180mcu_as_sc_mcu7t3v3__dfxtp_2
X_2997_ VDD VDD VSS VSS _3049_/B _2997_/B _2997_/C _2998_/C gf180mcu_as_sc_mcu7t3v3__nor3_2
XTAP_TAPCELL_ROW_192_1923 VDD VSS gf180mcu_as_sc_mcu7t3v3__tap_2
XTAP_TAPCELL_ROW_192_1912 VDD VSS gf180mcu_as_sc_mcu7t3v3__tap_2
XTAP_TAPCELL_ROW_192_1901 VDD VSS gf180mcu_as_sc_mcu7t3v3__tap_2
XFILLER_120_1327 VDD VDD VSS VSS gf180mcu_as_sc_mcu7t3v3__fill_2
X_4736_ VDD VDD VSS VSS _4737_/C _4736_/B _5270_/Q gf180mcu_as_sc_mcu7t3v3__nor2_2
XFILLER_163_946 VDD VDD VSS VSS gf180mcu_as_sc_mcu7t3v3__fillcap_16
X_4667_ VDD VDD VSS VSS _5104_/Q _4683_/C _4681_/C _5242_/Q _4668_/C gf180mcu_as_sc_mcu7t3v3__ao22_2
X_3618_ VDD VDD VSS VSS _4922_/Q _3648_/B _3648_/C _3990_/A _3620_/C gf180mcu_as_sc_mcu7t3v3__ao22_2
XFILLER_162_467 VDD VDD VSS VSS gf180mcu_as_sc_mcu7t3v3__fillcap_16
XFILLER_192_1141 VDD VDD VSS VSS gf180mcu_as_sc_mcu7t3v3__fill_2
XFILLER_1_617 VDD VDD VSS VSS gf180mcu_as_sc_mcu7t3v3__fill_1
X_4598_ VDD VDD VSS VSS _5192_/Q _4617_/B _4617_/C _5193_/Q _5192_/D gf180mcu_as_sc_mcu7t3v3__ao22_2
XFILLER_153_1114 VDD VDD VSS VSS gf180mcu_as_sc_mcu7t3v3__fillcap_4
XFILLER_171_990 VDD VDD VSS VSS gf180mcu_as_sc_mcu7t3v3__fillcap_4
X_3549_ VDD VDD VSS VSS _3562_/B _3811_/B _3776_/B gf180mcu_as_sc_mcu7t3v3__nand2_2
XFILLER_0_138 VDD VDD VSS VSS gf180mcu_as_sc_mcu7t3v3__fillcap_4
XFILLER_118_1256 VDD VDD VSS VSS gf180mcu_as_sc_mcu7t3v3__fillcap_16
XFILLER_9_1071 VDD VDD VSS VSS gf180mcu_as_sc_mcu7t3v3__fill_2
X_5219_ VDD VDD VSS VSS _5220_/CLK _5219_/D _5219_/Q gf180mcu_as_sc_mcu7t3v3__dfxtp_2
XPHY_EDGE_ROW_69_1_Left_261 VDD VSS gf180mcu_as_sc_mcu7t3v3__tap_2
XPHY_EDGE_ROW_151_3_Right_192 VDD VSS gf180mcu_as_sc_mcu7t3v3__tap_2
XFILLER_28_34 VDD VDD VSS VSS gf180mcu_as_sc_mcu7t3v3__fill_1
XPHY_EDGE_ROW_24_3_Right_65 VDD VSS gf180mcu_as_sc_mcu7t3v3__tap_2
XTAP_TAPCELL_ROW_84_1_1037 VDD VSS gf180mcu_as_sc_mcu7t3v3__tap_2
XTAP_TAPCELL_ROW_0_683 VDD VSS gf180mcu_as_sc_mcu7t3v3__tap_2
XTAP_TAPCELL_ROW_0_672 VDD VSS gf180mcu_as_sc_mcu7t3v3__tap_2
XFILLER_13_713 VDD VDD VSS VSS gf180mcu_as_sc_mcu7t3v3__fill_1
XTAP_TAPCELL_ROW_0_694 VDD VSS gf180mcu_as_sc_mcu7t3v3__tap_2
XFILLER_13_768 VDD VDD VSS VSS gf180mcu_as_sc_mcu7t3v3__fill_1
XFILLER_158_729 VDD VDD VSS VSS gf180mcu_as_sc_mcu7t3v3__fillcap_4
XFILLER_9_717 VDD VDD VSS VSS gf180mcu_as_sc_mcu7t3v3__fill_2
Xsram2048.u_bank1_922 VDD VDD VSS VSS sram2048.u_bank1/WEN[3] gf180mcu_as_sc_mcu7t3v3__tiel_4
XFILLER_157_228 VDD VDD VSS VSS gf180mcu_as_sc_mcu7t3v3__fill_2
XFILLER_160_1129 VDD VDD VSS VSS gf180mcu_as_sc_mcu7t3v3__fill_1
XFILLER_8_216 VDD VDD VSS VSS gf180mcu_as_sc_mcu7t3v3__fill_1
XTAP_TAPCELL_ROW_11_903 VDD VSS gf180mcu_as_sc_mcu7t3v3__tap_2
XFILLER_185_559 VDD VDD VSS VSS gf180mcu_as_sc_mcu7t3v3__fill_1
XFILLER_125_103 VDD VDD VSS VSS gf180mcu_as_sc_mcu7t3v3__fill_2
XFILLER_176_65 VDD VDD VSS VSS gf180mcu_as_sc_mcu7t3v3__fill_1
XFILLER_5_912 VDD VDD VSS VSS gf180mcu_as_sc_mcu7t3v3__fillcap_16
XFILLER_60_98 VDD VDD VSS VSS gf180mcu_as_sc_mcu7t3v3__fillcap_4
XFILLER_10_1143 VDD VDD VSS VSS gf180mcu_as_sc_mcu7t3v3__fill_1
XFILLER_158_1014 VDD VDD VSS VSS gf180mcu_as_sc_mcu7t3v3__fill_1
XFILLER_181_754 VDD VDD VSS VSS gf180mcu_as_sc_mcu7t3v3__fillcap_16
XFILLER_5_978 VDD VDD VSS VSS gf180mcu_as_sc_mcu7t3v3__fill_2
XPHY_EDGE_ROW_141_3_Left_513 VDD VSS gf180mcu_as_sc_mcu7t3v3__tap_2
XFILLER_192_42 VDD VDD VSS VSS gf180mcu_as_sc_mcu7t3v3__fill_1
XFILLER_84_1299 VDD VDD VSS VSS gf180mcu_as_sc_mcu7t3v3__fillcap_4
XFILLER_0_650 VDD VDD VSS VSS gf180mcu_as_sc_mcu7t3v3__fill_1
XFILLER_171_1258 VDD VDD VSS VSS gf180mcu_as_sc_mcu7t3v3__fill_2
Xclkbuf_leaf_33_clk_regs VDD VDD VSS VSS clkbuf_3_4__f_clk_regs/Y _5212_/CLK gf180mcu_as_sc_mcu7t3v3__clkbuff_12
XFILLER_21_1272 VDD VDD VSS VSS gf180mcu_as_sc_mcu7t3v3__fill_2
XFILLER_62_101 VDD VDD VSS VSS gf180mcu_as_sc_mcu7t3v3__fillcap_4
X_2920_ VDD VDD VSS VSS _3513_/A _3522_/A _3814_/A gf180mcu_as_sc_mcu7t3v3__or2_2
XFILLER_182_1354 VDD VDD VSS VSS gf180mcu_as_sc_mcu7t3v3__fill_1
XFILLER_188_397 VDD VDD VSS VSS gf180mcu_as_sc_mcu7t3v3__fillcap_8
X_2851_ VDD VDD VSS VSS _3874_/A _2851_/B _2851_/A gf180mcu_as_sc_mcu7t3v3__nor2_2
X_2782_ VDD VDD VSS VSS _4649_/A _5275_/Q _2783_/B gf180mcu_as_sc_mcu7t3v3__and2_2
XFILLER_163_209 VDD VDD VSS VSS gf180mcu_as_sc_mcu7t3v3__fill_1
X_4521_ VDD VDD VSS VSS _4522_/D _4521_/B _4573_/A gf180mcu_as_sc_mcu7t3v3__nor2_2
XFILLER_176_1103 VDD VDD VSS VSS gf180mcu_as_sc_mcu7t3v3__fill_1
XFILLER_7_282 VDD VDD VSS VSS gf180mcu_as_sc_mcu7t3v3__fillcap_8
X_4452_ VDD VDD VSS VSS _5174_/Q _4493_/B _4540_/C _5108_/Q _4453_/B gf180mcu_as_sc_mcu7t3v3__ao22_2
XPHY_EDGE_ROW_73_3_Left_445 VDD VSS gf180mcu_as_sc_mcu7t3v3__tap_2
X_3403_ VDD VDD VSS VSS _3449_/B _4053_/D _3403_/A _3404_/D gf180mcu_as_sc_mcu7t3v3__mux2_2
X_4383_ VDD VDD VSS VSS _4559_/S _5007_/Q _5036_/Q _4384_/B gf180mcu_as_sc_mcu7t3v3__mux2_2
Xfanout707 VDD VDD VSS VSS _4102_/C _4023_/C gf180mcu_as_sc_mcu7t3v3__buff_12
Xfanout718 VDD VDD VSS VSS _3566_/Y _3770_/C gf180mcu_as_sc_mcu7t3v3__buff_12
Xfanout729 VDD VDD VSS VSS wire731/Y _3501_/B gf180mcu_as_sc_mcu7t3v3__buff_12
X_3334_ VDD VDD VSS VSS _3463_/B _3334_/B _3334_/C _3335_/C gf180mcu_as_sc_mcu7t3v3__nor3_2
XTAP_TAPCELL_ROW_168_1435 VDD VSS gf180mcu_as_sc_mcu7t3v3__tap_2
XFILLER_105_28 VDD VDD VSS VSS gf180mcu_as_sc_mcu7t3v3__fill_2
X_3265_ VDD VDD VSS VSS _3265_/B _3275_/A _3521_/B gf180mcu_as_sc_mcu7t3v3__and2_2
XTAP_TAPCELL_ROW_168_1446 VDD VSS gf180mcu_as_sc_mcu7t3v3__tap_2
X_5004_ VDD VDD VSS VSS _5175_/CLK _5004_/D _5004_/Q gf180mcu_as_sc_mcu7t3v3__dfxtp_2
XTAP_TAPCELL_ROW_185_1760 VDD VSS gf180mcu_as_sc_mcu7t3v3__tap_2
X_3196_ VDD VDD VSS VSS _3216_/B _3791_/A _3197_/B gf180mcu_as_sc_mcu7t3v3__or2_2
XFILLER_53_101 VDD VDD VSS VSS gf180mcu_as_sc_mcu7t3v3__fillcap_4
XTAP_TAPCELL_ROW_181_1679 VDD VSS gf180mcu_as_sc_mcu7t3v3__tap_2
XFILLER_179_386 VDD VDD VSS VSS gf180mcu_as_sc_mcu7t3v3__fillcap_16
XTAP_TAPCELL_ROW_145_1_1098 VDD VSS gf180mcu_as_sc_mcu7t3v3__tap_2
XFILLER_124_1260 VDD VDD VSS VSS gf180mcu_as_sc_mcu7t3v3__fill_2
X_4719_ VDD VDD VSS VSS _4721_/B _4719_/B _4719_/A gf180mcu_as_sc_mcu7t3v3__nand2_2
XFILLER_162_34 VDD VDD VSS VSS gf180mcu_as_sc_mcu7t3v3__fill_1
XFILLER_162_56 VDD VDD VSS VSS gf180mcu_as_sc_mcu7t3v3__fill_1
XTAP_TAPCELL_ROW_5_786 VDD VSS gf180mcu_as_sc_mcu7t3v3__tap_2
XFILLER_55_32 VDD VDD VSS VSS gf180mcu_as_sc_mcu7t3v3__fill_2
XFILLER_166_1349 VDD VDD VSS VSS gf180mcu_as_sc_mcu7t3v3__fillcap_4
XFILLER_189_139 VDD VDD VSS VSS gf180mcu_as_sc_mcu7t3v3__fill_1
XFILLER_13_543 VDD VDD VSS VSS gf180mcu_as_sc_mcu7t3v3__fill_1
XFILLER_164_1095 VDD VDD VSS VSS gf180mcu_as_sc_mcu7t3v3__fill_2
XFILLER_158_559 VDD VDD VSS VSS gf180mcu_as_sc_mcu7t3v3__fill_2
XFILLER_173_507 VDD VDD VSS VSS gf180mcu_as_sc_mcu7t3v3__fill_1
XFILLER_12_1227 VDD VDD VSS VSS gf180mcu_as_sc_mcu7t3v3__fillcap_4
XFILLER_51_1298 VDD VDD VSS VSS gf180mcu_as_sc_mcu7t3v3__fill_1
XFILLER_154_787 VDD VDD VSS VSS gf180mcu_as_sc_mcu7t3v3__fill_2
XFILLER_181_573 VDD VDD VSS VSS gf180mcu_as_sc_mcu7t3v3__fill_2
XTAP_TAPCELL_ROW_60_3_1971 VDD VSS gf180mcu_as_sc_mcu7t3v3__tap_2
XFILLER_171_1022 VDD VDD VSS VSS gf180mcu_as_sc_mcu7t3v3__fillcap_8
X_3050_ VDD VDD VSS VSS _4032_/A _3125_/B _3125_/C _4032_/D _3056_/B gf180mcu_as_sc_mcu7t3v3__ao22_2
XTAP_TAPCELL_ROW_163_1343 VDD VSS gf180mcu_as_sc_mcu7t3v3__tap_2
X_3952_ VDD VDD VSS VSS _3953_/D _3952_/C _4025_/B _3952_/A gf180mcu_as_sc_mcu7t3v3__aoi21_2
X_3883_ VDD VDD VSS VSS _4946_/D _5173_/Q _4923_/D gf180mcu_as_sc_mcu7t3v3__and2_2
X_2903_ VDD VDD VSS VSS _2903_/Y _3199_/B _3542_/A gf180mcu_as_sc_mcu7t3v3__nand2_2
XFILLER_108_1288 VDD VDD VSS VSS gf180mcu_as_sc_mcu7t3v3__fill_1
XFILLER_108_1299 VDD VDD VSS VSS gf180mcu_as_sc_mcu7t3v3__fillcap_4
X_2834_ VDD VDD VSS VSS _4751_/B _4974_/D _4761_/D gf180mcu_as_sc_mcu7t3v3__and2_2
XFILLER_176_367 VDD VDD VSS VSS gf180mcu_as_sc_mcu7t3v3__fill_1
XFILLER_192_849 VDD VDD VSS VSS gf180mcu_as_sc_mcu7t3v3__fill_1
XFILLER_191_348 VDD VDD VSS VSS gf180mcu_as_sc_mcu7t3v3__fill_2
X_4504_ VDD VDD VSS VSS _5178_/Q _4548_/B _4504_/C _4504_/D _5178_/D gf180mcu_as_sc_mcu7t3v3__ao211_2
X_2765_ VDD VDD VSS VSS _4691_/A _2765_/B _2765_/C _2765_/D _2840_/B gf180mcu_as_sc_mcu7t3v3__ao211_2
XFILLER_172_562 VDD VDD VSS VSS gf180mcu_as_sc_mcu7t3v3__fillcap_4
X_5484_ VDD VDD VSS VSS _5484_/A _5484_/Y gf180mcu_as_sc_mcu7t3v3__buff_2
X_2696_ VDD VDD VSS VSS _2724_/S _2699_/A _4289_/S gf180mcu_as_sc_mcu7t3v3__and2_2
X_4435_ VDD VDD VSS VSS _4435_/B _4591_/A _4442_/C gf180mcu_as_sc_mcu7t3v3__and2_2
XFILLER_116_27 VDD VDD VSS VSS gf180mcu_as_sc_mcu7t3v3__fill_1
XFILLER_67_1272 VDD VDD VSS VSS gf180mcu_as_sc_mcu7t3v3__fill_2
XFILLER_67_1294 VDD VDD VSS VSS gf180mcu_as_sc_mcu7t3v3__fill_2
Xfanout504 VDD VDD VSS VSS _3723_/B _3654_/B gf180mcu_as_sc_mcu7t3v3__buff_12
Xfanout515 VDD VDD VSS VSS wire518/Y _3745_/B gf180mcu_as_sc_mcu7t3v3__buff_12
X_4366_ VDD VDD VSS VSS _4366_/S _5162_/Q _4366_/A _4367_/B gf180mcu_as_sc_mcu7t3v3__mux2_2
XTAP_TAPCELL_ROW_187_1800 VDD VSS gf180mcu_as_sc_mcu7t3v3__tap_2
XFILLER_154_1253 VDD VDD VSS VSS gf180mcu_as_sc_mcu7t3v3__fillcap_4
XFILLER_28_1256 VDD VDD VSS VSS gf180mcu_as_sc_mcu7t3v3__fillcap_16
Xfanout526 VDD VDD VSS VSS _3284_/Y _3469_/D gf180mcu_as_sc_mcu7t3v3__buff_12
Xfanout537 VDD VDD VSS VSS _4592_/B _4565_/B gf180mcu_as_sc_mcu7t3v3__buff_12
Xfanout548 VDD VDD VSS VSS _4067_/B _4027_/B gf180mcu_as_sc_mcu7t3v3__buff_12
X_3317_ VDD VDD VSS VSS _3966_/A _3374_/B _3374_/C _3969_/A _3318_/C gf180mcu_as_sc_mcu7t3v3__ao22_2
Xfanout559 VDD VDD VSS VSS _3825_/Y fanout559/Y gf180mcu_as_sc_mcu7t3v3__buff_12
X_4297_ VDD VDD VSS VSS _4297_/S _5126_/Q _4297_/A _5126_/D gf180mcu_as_sc_mcu7t3v3__mux2_2
XTAP_TAPCELL_ROW_183_1719 VDD VSS gf180mcu_as_sc_mcu7t3v3__tap_2
Xmesh_tile_963 VDD VDD VSS VSS north_out[3] gf180mcu_as_sc_mcu7t3v3__tiel_4
Xmesh_tile_952 VDD VDD VSS VSS ne_out[26] gf180mcu_as_sc_mcu7t3v3__tiel_4
Xmesh_tile_941 VDD VDD VSS VSS ne_out[15] gf180mcu_as_sc_mcu7t3v3__tiel_4
Xmesh_tile_930 VDD VDD VSS VSS ne_out[4] gf180mcu_as_sc_mcu7t3v3__tiel_4
X_3248_ VDD VDD VSS VSS _3249_/B _3914_/A _3519_/D gf180mcu_as_sc_mcu7t3v3__and2_2
XTAP_TAPCELL_ROW_2_723 VDD VSS gf180mcu_as_sc_mcu7t3v3__tap_2
XFILLER_132_48 VDD VDD VSS VSS gf180mcu_as_sc_mcu7t3v3__fill_1
Xmesh_tile_996 VDD VDD VSS VSS nw_out[2] gf180mcu_as_sc_mcu7t3v3__tiel_4
Xmesh_tile_985 VDD VDD VSS VSS north_out[25] gf180mcu_as_sc_mcu7t3v3__tiel_4
Xmesh_tile_974 VDD VDD VSS VSS north_out[14] gf180mcu_as_sc_mcu7t3v3__tiel_4
X_3179_ VDD VDD VSS VSS _3179_/B _4942_/Q _3180_/D gf180mcu_as_sc_mcu7t3v3__or2_2
XTAP_TAPCELL_ROW_2_734 VDD VSS gf180mcu_as_sc_mcu7t3v3__tap_2
XFILLER_187_1062 VDD VDD VSS VSS gf180mcu_as_sc_mcu7t3v3__fill_1
XFILLER_41_104 VDD VDD VSS VSS gf180mcu_as_sc_mcu7t3v3__fill_1
XFILLER_10_524 VDD VDD VSS VSS gf180mcu_as_sc_mcu7t3v3__fill_1
XFILLER_167_356 VDD VDD VSS VSS gf180mcu_as_sc_mcu7t3v3__fill_2
Xwire905 VDD VDD VSS VSS wire905/A _4029_/A gf180mcu_as_sc_mcu7t3v3__clkbuff_12
XFILLER_183_816 VDD VDD VSS VSS gf180mcu_as_sc_mcu7t3v3__fillcap_16
XTAP_TAPCELL_ROW_79_1_1032 VDD VSS gf180mcu_as_sc_mcu7t3v3__tap_2
XFILLER_163_562 VDD VDD VSS VSS gf180mcu_as_sc_mcu7t3v3__fillcap_4
XFILLER_159_1175 VDD VDD VSS VSS gf180mcu_as_sc_mcu7t3v3__fill_1
XFILLER_159_1186 VDD VDD VSS VSS gf180mcu_as_sc_mcu7t3v3__fillcap_4
XTAP_TAPCELL_ROW_16_1_969 VDD VSS gf180mcu_as_sc_mcu7t3v3__tap_2
XFILLER_173_22 VDD VDD VSS VSS gf180mcu_as_sc_mcu7t3v3__fillcap_16
XFILLER_2_767 VDD VDD VSS VSS gf180mcu_as_sc_mcu7t3v3__fill_2
XFILLER_133_1326 VDD VDD VSS VSS gf180mcu_as_sc_mcu7t3v3__fill_2
XFILLER_173_88 VDD VDD VSS VSS gf180mcu_as_sc_mcu7t3v3__fillcap_16
XFILLER_166_1157 VDD VDD VSS VSS gf180mcu_as_sc_mcu7t3v3__fillcap_16
XFILLER_13_384 VDD VDD VSS VSS gf180mcu_as_sc_mcu7t3v3__fill_2
XFILLER_174_827 VDD VDD VSS VSS gf180mcu_as_sc_mcu7t3v3__fill_1
XFILLER_185_142 VDD VDD VSS VSS gf180mcu_as_sc_mcu7t3v3__fillcap_8
XPHY_EDGE_ROW_21_1_Left_213 VDD VSS gf180mcu_as_sc_mcu7t3v3__tap_2
XFILLER_173_348 VDD VDD VSS VSS gf180mcu_as_sc_mcu7t3v3__fill_2
XFILLER_63_6 VDD VDD VSS VSS gf180mcu_as_sc_mcu7t3v3__fill_2
X_2550_ VDD VDD VSS VSS _4754_/Q _4956_/Q _2556_/B _4705_/A _2557_/A gf180mcu_as_sc_mcu7t3v3__nand4_2
XFILLER_177_1253 VDD VDD VSS VSS gf180mcu_as_sc_mcu7t3v3__fillcap_4
X_2481_ VDD VDD VSS VSS _4708_/C _2482_/B _4291_/A gf180mcu_as_sc_mcu7t3v3__nor2_2
X_4220_ VDD VDD VSS VSS _4249_/B _4220_/B _4220_/C _5056_/Q _5056_/D gf180mcu_as_sc_mcu7t3v3__ao22_2
X_4151_ VDD VDD VSS VSS _4151_/A _4151_/B _4151_/C _4151_/D _4153_/C gf180mcu_as_sc_mcu7t3v3__ao22_2
X_4082_ VDD VDD VSS VSS _4083_/C _4082_/B _4082_/A gf180mcu_as_sc_mcu7t3v3__nor2_2
X_3102_ VDD VDD VSS VSS _4079_/A _3222_/D _3236_/C _4080_/D _3103_/C gf180mcu_as_sc_mcu7t3v3__ao22_2
X_3033_ VDD VDD VSS VSS _3040_/B _3130_/B _4017_/A gf180mcu_as_sc_mcu7t3v3__nand2_2
XFILLER_184_1224 VDD VDD VSS VSS gf180mcu_as_sc_mcu7t3v3__fill_1
XFILLER_184_1279 VDD VDD VSS VSS gf180mcu_as_sc_mcu7t3v3__fillcap_16
X_4984_ VDD VDD VSS VSS clkload9/A _4984_/D _4984_/Q gf180mcu_as_sc_mcu7t3v3__dfxtp_2
X_3935_ VDD VDD VSS VSS _3936_/C _3935_/B _3935_/A gf180mcu_as_sc_mcu7t3v3__nor2_2
XFILLER_189_492 VDD VDD VSS VSS gf180mcu_as_sc_mcu7t3v3__fillcap_4
XFILLER_165_827 VDD VDD VSS VSS gf180mcu_as_sc_mcu7t3v3__fill_1
XFILLER_34_1260 VDD VDD VSS VSS gf180mcu_as_sc_mcu7t3v3__fill_2
X_3866_ VDD VDD VSS VSS _5137_/Q _5138_/Q _3866_/C _3868_/B gf180mcu_as_sc_mcu7t3v3__nor3_2
XFILLER_164_348 VDD VDD VSS VSS gf180mcu_as_sc_mcu7t3v3__fillcap_4
XFILLER_178_1017 VDD VDD VSS VSS gf180mcu_as_sc_mcu7t3v3__fillcap_4
XFILLER_192_657 VDD VDD VSS VSS gf180mcu_as_sc_mcu7t3v3__fillcap_4
XFILLER_69_1301 VDD VDD VSS VSS gf180mcu_as_sc_mcu7t3v3__fill_2
X_3797_ VDD VDD VSS VSS _3797_/D _3797_/A _3812_/B _3797_/C _3798_/B gf180mcu_as_sc_mcu7t3v3__ao31_2
X_2817_ VDD VDD VSS VSS _4696_/B _2833_/A _2827_/B gf180mcu_as_sc_mcu7t3v3__and2_2
XTAP_TAPCELL_ROW_176_1589 VDD VSS gf180mcu_as_sc_mcu7t3v3__tap_2
XPHY_EDGE_ROW_78_1_Left_270 VDD VSS gf180mcu_as_sc_mcu7t3v3__tap_2
XFILLER_173_871 VDD VDD VSS VSS gf180mcu_as_sc_mcu7t3v3__fill_1
XFILLER_192_679 VDD VDD VSS VSS gf180mcu_as_sc_mcu7t3v3__fill_1
XFILLER_69_1323 VDD VDD VSS VSS gf180mcu_as_sc_mcu7t3v3__fill_1
X_2748_ VDD VDD VSS VSS _4953_/Q _4754_/Q _2810_/D gf180mcu_as_sc_mcu7t3v3__and2_2
XPHY_EDGE_ROW_33_3_Right_74 VDD VSS gf180mcu_as_sc_mcu7t3v3__tap_2
XFILLER_121_1296 VDD VDD VSS VSS gf180mcu_as_sc_mcu7t3v3__fill_2
X_4418_ VDD VDD VSS VSS _4421_/C _4418_/C _5040_/Q _4500_/S gf180mcu_as_sc_mcu7t3v3__aoi21b_2
X_2679_ VDD VDD VSS VSS _2724_/S _5173_/Q _5165_/Q _2684_/B gf180mcu_as_sc_mcu7t3v3__mux2_2
XTAP_TAPCELL_ROW_7_815 VDD VSS gf180mcu_as_sc_mcu7t3v3__tap_2
XTAP_TAPCELL_ROW_7_826 VDD VSS gf180mcu_as_sc_mcu7t3v3__tap_2
XPHY_EDGE_ROW_36_3_Left_408 VDD VSS gf180mcu_as_sc_mcu7t3v3__tap_2
XFILLER_154_1083 VDD VDD VSS VSS gf180mcu_as_sc_mcu7t3v3__fill_2
X_4349_ VDD VDD VSS VSS _4366_/S _5159_/Q _4349_/A _4351_/B gf180mcu_as_sc_mcu7t3v3__mux2_2
XFILLER_143_47 VDD VDD VSS VSS gf180mcu_as_sc_mcu7t3v3__fillcap_8
XFILLER_80_1291 VDD VDD VSS VSS gf180mcu_as_sc_mcu7t3v3__fillcap_8
XFILLER_36_34 VDD VDD VSS VSS gf180mcu_as_sc_mcu7t3v3__fill_1
XFILLER_14_104 VDD VDD VSS VSS gf180mcu_as_sc_mcu7t3v3__fill_1
XFILLER_36_67 VDD VDD VSS VSS gf180mcu_as_sc_mcu7t3v3__fillcap_4
XTAP_TAPCELL_ROW_112_3_2023 VDD VSS gf180mcu_as_sc_mcu7t3v3__tap_2
XPHY_EDGE_ROW_150_3_Left_522 VDD VSS gf180mcu_as_sc_mcu7t3v3__tap_2
XFILLER_11_833 VDD VDD VSS VSS gf180mcu_as_sc_mcu7t3v3__fillcap_4
XFILLER_167_142 VDD VDD VSS VSS gf180mcu_as_sc_mcu7t3v3__fillcap_4
XFILLER_10_376 VDD VDD VSS VSS gf180mcu_as_sc_mcu7t3v3__fillcap_8
XFILLER_182_101 VDD VDD VSS VSS gf180mcu_as_sc_mcu7t3v3__fillcap_4
XFILLER_10_387 VDD VDD VSS VSS gf180mcu_as_sc_mcu7t3v3__fill_1
XFILLER_171_808 VDD VDD VSS VSS gf180mcu_as_sc_mcu7t3v3__fill_2
XFILLER_168_1208 VDD VDD VSS VSS gf180mcu_as_sc_mcu7t3v3__fillcap_4
Xfanout890 VDD VDD VSS VSS wire899/A _2563_/A gf180mcu_as_sc_mcu7t3v3__buff_12
XFILLER_93_84 VDD VDD VSS VSS gf180mcu_as_sc_mcu7t3v3__fill_2
XPHY_EDGE_ROW_82_3_Left_454 VDD VSS gf180mcu_as_sc_mcu7t3v3__tap_2
XFILLER_178_407 VDD VDD VSS VSS gf180mcu_as_sc_mcu7t3v3__fill_2
XFILLER_187_930 VDD VDD VSS VSS gf180mcu_as_sc_mcu7t3v3__fill_2
XFILLER_159_632 VDD VDD VSS VSS gf180mcu_as_sc_mcu7t3v3__fillcap_16
X_3720_ VDD VDD VSS VSS _3720_/D _4093_/A _3736_/B _3800_/C _3721_/C gf180mcu_as_sc_mcu7t3v3__ao31_2
XFILLER_174_613 VDD VDD VSS VSS gf180mcu_as_sc_mcu7t3v3__fill_2
XFILLER_186_473 VDD VDD VSS VSS gf180mcu_as_sc_mcu7t3v3__fillcap_16
XFILLER_187_974 VDD VDD VSS VSS gf180mcu_as_sc_mcu7t3v3__fillcap_4
XTAP_TAPCELL_ROW_158_1253 VDD VSS gf180mcu_as_sc_mcu7t3v3__tap_2
XTAP_TAPCELL_ROW_158_1242 VDD VSS gf180mcu_as_sc_mcu7t3v3__tap_2
XFILLER_158_197 VDD VDD VSS VSS gf180mcu_as_sc_mcu7t3v3__fill_2
X_3651_ VDD VDD VSS VSS _3652_/C _4021_/A _3673_/C _3651_/C gf180mcu_as_sc_mcu7t3v3__ao21_2
XTAP_TAPCELL_ROW_47_3_1958 VDD VSS gf180mcu_as_sc_mcu7t3v3__tap_2
XFILLER_179_1348 VDD VDD VSS VSS gf180mcu_as_sc_mcu7t3v3__fillcap_4
X_3582_ VDD VDD VSS VSS _3951_/A _3649_/B _3649_/C _3949_/A _3583_/D gf180mcu_as_sc_mcu7t3v3__ao22_2
X_2602_ VDD VDD VSS VSS _4262_/B _2602_/B _4264_/A _2603_/B gf180mcu_as_sc_mcu7t3v3__mux2_2
X_2533_ VDD VDD VSS VSS _4372_/B _4329_/A _2534_/C gf180mcu_as_sc_mcu7t3v3__nor2b_2
XTAP_TAPCELL_ROW_171_1497 VDD VSS gf180mcu_as_sc_mcu7t3v3__tap_2
XTAP_TAPCELL_ROW_171_1486 VDD VSS gf180mcu_as_sc_mcu7t3v3__tap_2
XFILLER_29_1351 VDD VDD VSS VSS gf180mcu_as_sc_mcu7t3v3__fillcap_4
X_5252_ VDD VDD VSS VSS _5266_/CLK _5252_/D _5252_/Q gf180mcu_as_sc_mcu7t3v3__dfxtp_2
X_2464_ VDD VDD VSS VSS _2467_/C _2464_/C _5064_/Q _4579_/S gf180mcu_as_sc_mcu7t3v3__aoi21b_2
X_5183_ VDD VDD VSS VSS clkload9/A _5183_/D _5183_/Q gf180mcu_as_sc_mcu7t3v3__dfxtp_2
X_4203_ VDD VDD VSS VSS _4232_/B _4217_/B _4218_/C _5039_/Q _5039_/D gf180mcu_as_sc_mcu7t3v3__ao22_2
X_2395_ VDD VDD VSS VSS _4733_/A _5268_/Q gf180mcu_as_sc_mcu7t3v3__inv_2
X_4134_ VDD VDD VSS VSS _5002_/Q _4158_/B _4253_/B _4158_/D _5002_/D gf180mcu_as_sc_mcu7t3v3__ao22_2
XFILLER_3_1011 VDD VDD VSS VSS gf180mcu_as_sc_mcu7t3v3__fill_1
X_4065_ VDD VDD VSS VSS _4065_/A _4101_/B _4065_/C _4065_/D _4066_/C gf180mcu_as_sc_mcu7t3v3__ao211_2
XFILLER_184_1021 VDD VDD VSS VSS gf180mcu_as_sc_mcu7t3v3__fill_2
X_3016_ VDD VDD VSS VSS _3998_/A _3206_/B _3192_/C _3997_/A _3022_/B gf180mcu_as_sc_mcu7t3v3__ao22_2
XFILLER_12_608 VDD VDD VSS VSS gf180mcu_as_sc_mcu7t3v3__fillcap_8
XTAP_TAPCELL_ROW_178_1629 VDD VSS gf180mcu_as_sc_mcu7t3v3__tap_2
XTAP_TAPCELL_ROW_15_1_968 VDD VSS gf180mcu_as_sc_mcu7t3v3__tap_2
XFILLER_11_129 VDD VDD VSS VSS gf180mcu_as_sc_mcu7t3v3__fillcap_8
X_4967_ VDD VDD VSS VSS _5232_/CLK _4967_/D _4967_/Q gf180mcu_as_sc_mcu7t3v3__dfxtp_2
XFILLER_71_1268 VDD VDD VSS VSS gf180mcu_as_sc_mcu7t3v3__fill_2
X_4898_ VDD VDD VSS VSS clkload5/A _4898_/D _4898_/Q gf180mcu_as_sc_mcu7t3v3__dfxtp_2
X_3918_ VDD VDD VSS VSS _3920_/A _3923_/B _3918_/A gf180mcu_as_sc_mcu7t3v3__nand2_2
XFILLER_192_410 VDD VDD VSS VSS gf180mcu_as_sc_mcu7t3v3__fill_2
XFILLER_192_421 VDD VDD VSS VSS gf180mcu_as_sc_mcu7t3v3__fill_2
X_3849_ VDD VDD VSS VSS _3850_/C _5134_/Q _5131_/Q gf180mcu_as_sc_mcu7t3v3__nor2_2
XFILLER_192_487 VDD VDD VSS VSS gf180mcu_as_sc_mcu7t3v3__fillcap_4
XFILLER_4_818 VDD VDD VSS VSS gf180mcu_as_sc_mcu7t3v3__fillcap_16
XFILLER_191_1047 VDD VDD VSS VSS gf180mcu_as_sc_mcu7t3v3__fill_2
Xoutput460 VDD VDD VSS VSS _4882_/Q west_out[9] gf180mcu_as_sc_mcu7t3v3__buff_12
XFILLER_160_373 VDD VDD VSS VSS gf180mcu_as_sc_mcu7t3v3__fill_1
XFILLER_160_395 VDD VDD VSS VSS gf180mcu_as_sc_mcu7t3v3__fill_1
XFILLER_43_1326 VDD VDD VSS VSS gf180mcu_as_sc_mcu7t3v3__fill_2
XFILLER_47_33 VDD VDD VSS VSS gf180mcu_as_sc_mcu7t3v3__fill_1
XFILLER_170_34 VDD VDD VSS VSS gf180mcu_as_sc_mcu7t3v3__fill_1
XFILLER_170_89 VDD VDD VSS VSS gf180mcu_as_sc_mcu7t3v3__fillcap_4
XFILLER_103_72 VDD VDD VSS VSS gf180mcu_as_sc_mcu7t3v3__fillcap_8
XFILLER_179_54 VDD VDD VSS VSS gf180mcu_as_sc_mcu7t3v3__fillcap_8
XFILLER_10_140 VDD VDD VSS VSS gf180mcu_as_sc_mcu7t3v3__fill_1
XFILLER_11_652 VDD VDD VSS VSS gf180mcu_as_sc_mcu7t3v3__fillcap_8
XFILLER_156_624 VDD VDD VSS VSS gf180mcu_as_sc_mcu7t3v3__fillcap_8
XFILLER_168_473 VDD VDD VSS VSS gf180mcu_as_sc_mcu7t3v3__fillcap_16
XFILLER_156_679 VDD VDD VSS VSS gf180mcu_as_sc_mcu7t3v3__fillcap_8
XFILLER_183_465 VDD VDD VSS VSS gf180mcu_as_sc_mcu7t3v3__fill_2
XFILLER_184_966 VDD VDD VSS VSS gf180mcu_as_sc_mcu7t3v3__fill_2
Xwire543 VDD VDD VSS VSS _4041_/B _4105_/B gf180mcu_as_sc_mcu7t3v3__clkbuff_12
Xwire576 VDD VDD VSS VSS _3115_/A _3097_/A gf180mcu_as_sc_mcu7t3v3__clkbuff_12
XFILLER_104_1291 VDD VDD VSS VSS gf180mcu_as_sc_mcu7t3v3__fillcap_4
XFILLER_12_80 VDD VDD VSS VSS gf180mcu_as_sc_mcu7t3v3__fillcap_16
XFILLER_13_1174 VDD VDD VSS VSS gf180mcu_as_sc_mcu7t3v3__fillcap_16
XFILLER_170_104 VDD VDD VSS VSS gf180mcu_as_sc_mcu7t3v3__fill_1
XFILLER_183_487 VDD VDD VSS VSS gf180mcu_as_sc_mcu7t3v3__fill_2
XFILLER_6_177 VDD VDD VSS VSS gf180mcu_as_sc_mcu7t3v3__fillcap_4
XTAP_TAPCELL_ROW_153_1150 VDD VSS gf180mcu_as_sc_mcu7t3v3__tap_2
XTAP_TAPCELL_ROW_153_1161 VDD VSS gf180mcu_as_sc_mcu7t3v3__tap_2
XFILLER_0_1217 VDD VDD VSS VSS gf180mcu_as_sc_mcu7t3v3__fillcap_4
XFILLER_168_1049 VDD VDD VSS VSS gf180mcu_as_sc_mcu7t3v3__fillcap_4
XFILLER_111_1295 VDD VDD VSS VSS gf180mcu_as_sc_mcu7t3v3__fillcap_8
XFILLER_185_1352 VDD VDD VSS VSS gf180mcu_as_sc_mcu7t3v3__fill_2
XFILLER_179_738 VDD VDD VSS VSS gf180mcu_as_sc_mcu7t3v3__fill_2
X_4821_ VDD VDD VSS VSS clkload7/A _4821_/D _4821_/Q gf180mcu_as_sc_mcu7t3v3__dfxtp_2
X_4752_ VDD VDD VSS VSS _4753_/A _4752_/B _4752_/C _5094_/D gf180mcu_as_sc_mcu7t3v3__nor3_2
XFILLER_146_101 VDD VDD VSS VSS gf180mcu_as_sc_mcu7t3v3__fillcap_4
XFILLER_174_421 VDD VDD VSS VSS gf180mcu_as_sc_mcu7t3v3__fillcap_16
X_4683_ VDD VDD VSS VSS _4686_/B _4683_/C _4684_/A _4703_/D gf180mcu_as_sc_mcu7t3v3__aoi21b_2
X_3703_ VDD VDD VSS VSS _4933_/Q _3799_/B _3778_/B _4080_/D _3704_/D gf180mcu_as_sc_mcu7t3v3__ao22_2
XTAP_TAPCELL_ROW_173_1526 VDD VSS gf180mcu_as_sc_mcu7t3v3__tap_2
XFILLER_174_454 VDD VDD VSS VSS gf180mcu_as_sc_mcu7t3v3__fill_1
XFILLER_174_465 VDD VDD VSS VSS gf180mcu_as_sc_mcu7t3v3__fill_2
XFILLER_179_1145 VDD VDD VSS VSS gf180mcu_as_sc_mcu7t3v3__fillcap_16
X_3634_ VDD VDD VSS VSS _3638_/B _3634_/C _3652_/B _4008_/A gf180mcu_as_sc_mcu7t3v3__aoi21_2
XTAP_TAPCELL_ROW_173_1537 VDD VSS gf180mcu_as_sc_mcu7t3v3__tap_2
XTAP_TAPCELL_ROW_190_1862 VDD VSS gf180mcu_as_sc_mcu7t3v3__tap_2
XTAP_TAPCELL_ROW_190_1851 VDD VSS gf180mcu_as_sc_mcu7t3v3__tap_2
XFILLER_161_137 VDD VDD VSS VSS gf180mcu_as_sc_mcu7t3v3__fill_2
X_3565_ VDD VDD VSS VSS _3778_/B _3933_/D _3568_/C gf180mcu_as_sc_mcu7t3v3__and2_2
X_3496_ VDD VDD VSS VSS _4154_/D _3496_/B _3496_/C _4154_/A _3497_/D gf180mcu_as_sc_mcu7t3v3__ao22_2
X_2516_ VDD VDD VSS VSS _4749_/A _2517_/B _2517_/C _2766_/B _2517_/D gf180mcu_as_sc_mcu7t3v3__aoi31_2
XPHY_EDGE_ROW_109_1_Left_301 VDD VSS gf180mcu_as_sc_mcu7t3v3__tap_2
X_5235_ VDD VDD VSS VSS _5277_/CLK _5235_/D _5235_/Q gf180mcu_as_sc_mcu7t3v3__dfxtp_2
X_2447_ VDD VDD VSS VSS _4141_/A _3483_/A gf180mcu_as_sc_mcu7t3v3__inv_2
X_5166_ VDD VDD VSS VSS _5182_/CLK _5166_/D _5166_/Q gf180mcu_as_sc_mcu7t3v3__dfxtp_2
XFILLER_186_1105 VDD VDD VSS VSS gf180mcu_as_sc_mcu7t3v3__fill_2
X_5097_ VDD VDD VSS VSS _5097_/CLK _5097_/D _5097_/Q gf180mcu_as_sc_mcu7t3v3__dfxtp_2
X_4117_ VDD VDD VSS VSS _5000_/Q _4150_/B _4251_/B _4150_/D _5000_/D gf180mcu_as_sc_mcu7t3v3__ao22_2
XFILLER_17_36 VDD VDD VSS VSS gf180mcu_as_sc_mcu7t3v3__fill_1
XFILLER_186_1149 VDD VDD VSS VSS gf180mcu_as_sc_mcu7t3v3__fillcap_4
X_4048_ VDD VDD VSS VSS _4048_/A _4104_/B _4104_/C _4048_/D _4049_/D gf180mcu_as_sc_mcu7t3v3__ao22_2
XFILLER_140_37 VDD VDD VSS VSS gf180mcu_as_sc_mcu7t3v3__fillcap_16
XFILLER_17_69 VDD VDD VSS VSS gf180mcu_as_sc_mcu7t3v3__fill_1
XFILLER_192_240 VDD VDD VSS VSS gf180mcu_as_sc_mcu7t3v3__fillcap_4
XFILLER_180_413 VDD VDD VSS VSS gf180mcu_as_sc_mcu7t3v3__fillcap_4
XFILLER_180_457 VDD VDD VSS VSS gf180mcu_as_sc_mcu7t3v3__fillcap_16
XFILLER_181_22 VDD VDD VSS VSS gf180mcu_as_sc_mcu7t3v3__fillcap_16
XFILLER_47_1281 VDD VDD VSS VSS gf180mcu_as_sc_mcu7t3v3__fillcap_4
XFILLER_58_32 VDD VDD VSS VSS gf180mcu_as_sc_mcu7t3v3__fill_2
XFILLER_181_88 VDD VDD VSS VSS gf180mcu_as_sc_mcu7t3v3__fillcap_8
XPHY_EDGE_ROW_30_1_Left_222 VDD VSS gf180mcu_as_sc_mcu7t3v3__tap_2
XFILLER_188_513 VDD VDD VSS VSS gf180mcu_as_sc_mcu7t3v3__fillcap_8
XFILLER_157_900 VDD VDD VSS VSS gf180mcu_as_sc_mcu7t3v3__fill_2
XFILLER_8_921 VDD VDD VSS VSS gf180mcu_as_sc_mcu7t3v3__fillcap_8
XFILLER_157_977 VDD VDD VSS VSS gf180mcu_as_sc_mcu7t3v3__fill_2
XFILLER_89_1326 VDD VDD VSS VSS gf180mcu_as_sc_mcu7t3v3__fill_2
XFILLER_156_465 VDD VDD VSS VSS gf180mcu_as_sc_mcu7t3v3__fillcap_4
XFILLER_172_947 VDD VDD VSS VSS gf180mcu_as_sc_mcu7t3v3__fill_1
XFILLER_99_72 VDD VDD VSS VSS gf180mcu_as_sc_mcu7t3v3__fill_1
X_3350_ VDD VDD VSS VSS _3998_/A _3504_/B _3513_/C _4001_/A _3351_/C gf180mcu_as_sc_mcu7t3v3__ao22_2
XFILLER_152_671 VDD VDD VSS VSS gf180mcu_as_sc_mcu7t3v3__fillcap_8
XFILLER_174_1075 VDD VDD VSS VSS gf180mcu_as_sc_mcu7t3v3__fillcap_8
XFILLER_3_670 VDD VDD VSS VSS gf180mcu_as_sc_mcu7t3v3__fill_2
X_5020_ VDD VDD VSS VSS _5095_/CLK _5020_/D _5020_/Q gf180mcu_as_sc_mcu7t3v3__dfxtp_2
X_3281_ VDD VDD VSS VSS _3286_/B _3281_/B _3922_/A gf180mcu_as_sc_mcu7t3v3__nand2_2
Xhold1109 VDD VDD VSS VSS _3906_/S _2588_/B gf180mcu_as_sc_mcu7t3v3__clkbuff_4
XTAP_TAPCELL_ROW_166_1396 VDD VSS gf180mcu_as_sc_mcu7t3v3__tap_2
XPHY_EDGE_ROW_42_3_Right_83 VDD VSS gf180mcu_as_sc_mcu7t3v3__tap_2
XFILLER_179_557 VDD VDD VSS VSS gf180mcu_as_sc_mcu7t3v3__fill_2
XTAP_TAPCELL_ROW_50_1_1003 VDD VSS gf180mcu_as_sc_mcu7t3v3__tap_2
X_4804_ VDD VDD VSS VSS _5226_/CLK _4804_/D _4804_/Q gf180mcu_as_sc_mcu7t3v3__dfxtp_2
XPHY_EDGE_ROW_45_3_Left_417 VDD VSS gf180mcu_as_sc_mcu7t3v3__tap_2
XFILLER_119_101 VDD VDD VSS VSS gf180mcu_as_sc_mcu7t3v3__fillcap_4
X_4735_ VDD VDD VSS VSS _5269_/D _4735_/B _4736_/B gf180mcu_as_sc_mcu7t3v3__nor2_2
X_2996_ VDD VDD VSS VSS _3977_/A _3047_/B _2996_/C _2996_/D _2997_/C gf180mcu_as_sc_mcu7t3v3__ao22_2
XTAP_TAPCELL_ROW_192_1913 VDD VSS gf180mcu_as_sc_mcu7t3v3__tap_2
XTAP_TAPCELL_ROW_192_1902 VDD VSS gf180mcu_as_sc_mcu7t3v3__tap_2
XFILLER_119_27 VDD VDD VSS VSS gf180mcu_as_sc_mcu7t3v3__fillcap_4
XFILLER_175_763 VDD VDD VSS VSS gf180mcu_as_sc_mcu7t3v3__fillcap_4
XFILLER_187_590 VDD VDD VSS VSS gf180mcu_as_sc_mcu7t3v3__fill_2
XFILLER_134_104 VDD VDD VSS VSS gf180mcu_as_sc_mcu7t3v3__fill_1
XFILLER_163_936 VDD VDD VSS VSS gf180mcu_as_sc_mcu7t3v3__fillcap_4
X_4666_ VDD VDD VSS VSS _4666_/B _4721_/A _4681_/C gf180mcu_as_sc_mcu7t3v3__and2_2
Xclkbuf_leaf_3_clk_regs VDD VDD VSS VSS clkbuf_leaf_9_clk_regs/A _5095_/CLK gf180mcu_as_sc_mcu7t3v3__clkbuff_12
X_4597_ VDD VDD VSS VSS _5191_/Q _4629_/B _4629_/C _5192_/Q _5191_/D gf180mcu_as_sc_mcu7t3v3__ao22_2
X_3617_ VDD VDD VSS VSS _3673_/C _3992_/D _3621_/C gf180mcu_as_sc_mcu7t3v3__and2_2
Xmax_cap651 VDD VDD VSS VSS _3389_/S _3452_/S gf180mcu_as_sc_mcu7t3v3__clkbuff_12
X_3548_ VDD VDD VSS VSS _3780_/A _3548_/A _3811_/B gf180mcu_as_sc_mcu7t3v3__and2_2
XFILLER_0_106 VDD VDD VSS VSS gf180mcu_as_sc_mcu7t3v3__fill_1
XFILLER_192_1197 VDD VDD VSS VSS gf180mcu_as_sc_mcu7t3v3__fillcap_4
X_3479_ VDD VDD VSS VSS _4940_/Q _3493_/B _3494_/B _4138_/A _3480_/D gf180mcu_as_sc_mcu7t3v3__ao22_2
XFILLER_192_8 VDD VDD VSS VSS gf180mcu_as_sc_mcu7t3v3__fill_1
X_5218_ VDD VDD VSS VSS _5220_/CLK _5218_/D _5218_/Q gf180mcu_as_sc_mcu7t3v3__dfxtp_2
X_5149_ VDD VDD VSS VSS _5150_/CLK _5149_/D _5149_/Q gf180mcu_as_sc_mcu7t3v3__dfxtp_2
XFILLER_151_69 VDD VDD VSS VSS gf180mcu_as_sc_mcu7t3v3__fill_1
XTAP_TAPCELL_ROW_0_673 VDD VSS gf180mcu_as_sc_mcu7t3v3__tap_2
XTAP_TAPCELL_ROW_0_662 VDD VSS gf180mcu_as_sc_mcu7t3v3__tap_2
XFILLER_13_703 VDD VDD VSS VSS gf180mcu_as_sc_mcu7t3v3__fillcap_8
XFILLER_77_1274 VDD VDD VSS VSS gf180mcu_as_sc_mcu7t3v3__fill_1
XTAP_TAPCELL_ROW_0_695 VDD VSS gf180mcu_as_sc_mcu7t3v3__tap_2
XTAP_TAPCELL_ROW_0_684 VDD VSS gf180mcu_as_sc_mcu7t3v3__tap_2
XFILLER_13_747 VDD VDD VSS VSS gf180mcu_as_sc_mcu7t3v3__fill_1
Xsram2048.u_bank1_923 VDD VDD VSS VSS sram2048.u_bank1/WEN[4] gf180mcu_as_sc_mcu7t3v3__tiel_4
XFILLER_12_279 VDD VDD VSS VSS gf180mcu_as_sc_mcu7t3v3__fillcap_16
XTAP_TAPCELL_ROW_11_904 VDD VSS gf180mcu_as_sc_mcu7t3v3__tap_2
XFILLER_166_752 VDD VDD VSS VSS gf180mcu_as_sc_mcu7t3v3__fill_2
XFILLER_176_22 VDD VDD VSS VSS gf180mcu_as_sc_mcu7t3v3__fillcap_8
XFILLER_166_796 VDD VDD VSS VSS gf180mcu_as_sc_mcu7t3v3__fill_2
XFILLER_154_947 VDD VDD VSS VSS gf180mcu_as_sc_mcu7t3v3__fillcap_8
XFILLER_180_232 VDD VDD VSS VSS gf180mcu_as_sc_mcu7t3v3__fillcap_8
XFILLER_4_401 VDD VDD VSS VSS gf180mcu_as_sc_mcu7t3v3__fillcap_4
XFILLER_180_265 VDD VDD VSS VSS gf180mcu_as_sc_mcu7t3v3__fillcap_16
XFILLER_49_1321 VDD VDD VSS VSS gf180mcu_as_sc_mcu7t3v3__fill_2
XFILLER_69_31 VDD VDD VSS VSS gf180mcu_as_sc_mcu7t3v3__fill_2
XFILLER_10_1199 VDD VDD VSS VSS gf180mcu_as_sc_mcu7t3v3__fill_1
XPHY_EDGE_ROW_91_3_Left_463 VDD VSS gf180mcu_as_sc_mcu7t3v3__tap_2
XFILLER_192_76 VDD VDD VSS VSS gf180mcu_as_sc_mcu7t3v3__fill_1
XFILLER_69_97 VDD VDD VSS VSS gf180mcu_as_sc_mcu7t3v3__fillcap_8
XFILLER_169_1111 VDD VDD VSS VSS gf180mcu_as_sc_mcu7t3v3__fillcap_8
XFILLER_169_1122 VDD VDD VSS VSS gf180mcu_as_sc_mcu7t3v3__fill_1
XFILLER_169_1155 VDD VDD VSS VSS gf180mcu_as_sc_mcu7t3v3__fill_2
XFILLER_182_1322 VDD VDD VSS VSS gf180mcu_as_sc_mcu7t3v3__fill_1
XFILLER_188_365 VDD VDD VSS VSS gf180mcu_as_sc_mcu7t3v3__fillcap_4
X_2850_ VDD VDD VSS VSS _3869_/B _2851_/B gf180mcu_as_sc_mcu7t3v3__inv_2
XFILLER_176_527 VDD VDD VSS VSS gf180mcu_as_sc_mcu7t3v3__fill_1
XFILLER_169_590 VDD VDD VSS VSS gf180mcu_as_sc_mcu7t3v3__fill_1
XFILLER_191_508 VDD VDD VSS VSS gf180mcu_as_sc_mcu7t3v3__fillcap_16
X_2781_ VDD VDD VSS VSS _2781_/D _2783_/A _2781_/B _4734_/B _2786_/D gf180mcu_as_sc_mcu7t3v3__ao31_2
XTAP_TAPCELL_ROW_97_1_1050 VDD VSS gf180mcu_as_sc_mcu7t3v3__tap_2
XTAP_TAPCELL_ROW_111_1_1064 VDD VSS gf180mcu_as_sc_mcu7t3v3__tap_2
XFILLER_116_104 VDD VDD VSS VSS gf180mcu_as_sc_mcu7t3v3__fill_1
X_4520_ VDD VDD VSS VSS _4520_/D _4572_/A _4520_/B _4520_/C _4521_/B gf180mcu_as_sc_mcu7t3v3__ao31_2
XFILLER_156_295 VDD VDD VSS VSS gf180mcu_as_sc_mcu7t3v3__fillcap_8
XFILLER_172_733 VDD VDD VSS VSS gf180mcu_as_sc_mcu7t3v3__fill_2
XFILLER_184_593 VDD VDD VSS VSS gf180mcu_as_sc_mcu7t3v3__fill_2
XFILLER_7_272 VDD VDD VSS VSS gf180mcu_as_sc_mcu7t3v3__fillcap_8
X_4451_ VDD VDD VSS VSS _5172_/Q _4574_/B _4451_/C _4451_/D _5172_/D gf180mcu_as_sc_mcu7t3v3__ao211_2
XFILLER_171_232 VDD VDD VSS VSS gf180mcu_as_sc_mcu7t3v3__fill_2
X_3402_ VDD VDD VSS VSS _4930_/Q _3448_/B _3448_/C _4054_/A _3403_/A gf180mcu_as_sc_mcu7t3v3__ao22_2
X_4382_ VDD VDD VSS VSS _4385_/C _4978_/Q _4557_/A gf180mcu_as_sc_mcu7t3v3__nand2b_2
Xfanout708 VDD VDD VSS VSS _4152_/C _4102_/C gf180mcu_as_sc_mcu7t3v3__buff_12
X_3333_ VDD VDD VSS VSS _3984_/A _3374_/B _3374_/C _3985_/A _3334_/C gf180mcu_as_sc_mcu7t3v3__ao22_2
X_3264_ VDD VDD VSS VSS _3807_/A _3530_/A _3265_/B gf180mcu_as_sc_mcu7t3v3__and2_2
XTAP_TAPCELL_ROW_168_1447 VDD VSS gf180mcu_as_sc_mcu7t3v3__tap_2
XTAP_TAPCELL_ROW_168_1436 VDD VSS gf180mcu_as_sc_mcu7t3v3__tap_2
XPHY_EDGE_ROW_7_Right_7 VDD VSS gf180mcu_as_sc_mcu7t3v3__tap_2
X_5003_ VDD VDD VSS VSS _5089_/CLK _5003_/D _5003_/Q gf180mcu_as_sc_mcu7t3v3__dfxtp_2
XTAP_TAPCELL_ROW_185_1761 VDD VSS gf180mcu_as_sc_mcu7t3v3__tap_2
X_3195_ VDD VDD VSS VSS _3195_/B _3907_/A _4799_/D gf180mcu_as_sc_mcu7t3v3__and2_2
XFILLER_187_1244 VDD VDD VSS VSS gf180mcu_as_sc_mcu7t3v3__fill_2
XFILLER_183_1119 VDD VDD VSS VSS gf180mcu_as_sc_mcu7t3v3__fill_1
XFILLER_179_321 VDD VDD VSS VSS gf180mcu_as_sc_mcu7t3v3__fillcap_8
XFILLER_14_48 VDD VDD VSS VSS gf180mcu_as_sc_mcu7t3v3__fillcap_4
X_2979_ VDD VDD VSS VSS _3961_/A _3047_/B _2979_/C _2979_/D _2980_/C gf180mcu_as_sc_mcu7t3v3__ao22_2
XFILLER_159_1302 VDD VDD VSS VSS gf180mcu_as_sc_mcu7t3v3__fillcap_16
X_4718_ VDD VDD VSS VSS _4721_/A _4718_/B _4718_/A _5261_/D gf180mcu_as_sc_mcu7t3v3__mux2_2
XFILLER_107_104 VDD VDD VSS VSS gf180mcu_as_sc_mcu7t3v3__fill_1
XFILLER_162_221 VDD VDD VSS VSS gf180mcu_as_sc_mcu7t3v3__fill_2
XFILLER_175_593 VDD VDD VSS VSS gf180mcu_as_sc_mcu7t3v3__fillcap_16
X_4649_ VDD VDD VSS VSS _4659_/B _4649_/A _4649_/B _4649_/C gf180mcu_as_sc_mcu7t3v3__ao21_2
XFILLER_163_766 VDD VDD VSS VSS gf180mcu_as_sc_mcu7t3v3__fillcap_4
XFILLER_163_788 VDD VDD VSS VSS gf180mcu_as_sc_mcu7t3v3__fillcap_16
XFILLER_146_69 VDD VDD VSS VSS gf180mcu_as_sc_mcu7t3v3__fillcap_16
XFILLER_157_1070 VDD VDD VSS VSS gf180mcu_as_sc_mcu7t3v3__fill_2
XTAP_TAPCELL_ROW_5_787 VDD VSS gf180mcu_as_sc_mcu7t3v3__tap_2
XFILLER_111_72 VDD VDD VSS VSS gf180mcu_as_sc_mcu7t3v3__fillcap_8
XFILLER_158_527 VDD VDD VSS VSS gf180mcu_as_sc_mcu7t3v3__fillcap_4
XFILLER_185_335 VDD VDD VSS VSS gf180mcu_as_sc_mcu7t3v3__fillcap_8
XFILLER_186_869 VDD VDD VSS VSS gf180mcu_as_sc_mcu7t3v3__fillcap_4
XFILLER_187_54 VDD VDD VSS VSS gf180mcu_as_sc_mcu7t3v3__fillcap_16
XFILLER_71_76 VDD VDD VSS VSS gf180mcu_as_sc_mcu7t3v3__fill_2
XFILLER_185_368 VDD VDD VSS VSS gf180mcu_as_sc_mcu7t3v3__fillcap_8
XFILLER_154_733 VDD VDD VSS VSS gf180mcu_as_sc_mcu7t3v3__fill_2
XFILLER_153_232 VDD VDD VSS VSS gf180mcu_as_sc_mcu7t3v3__fill_2
XFILLER_153_298 VDD VDD VSS VSS gf180mcu_as_sc_mcu7t3v3__fillcap_4
XFILLER_4_264 VDD VDD VSS VSS gf180mcu_as_sc_mcu7t3v3__fill_1
XPHY_EDGE_ROW_119_3_Right_160 VDD VSS gf180mcu_as_sc_mcu7t3v3__tap_2
XFILLER_175_1192 VDD VDD VSS VSS gf180mcu_as_sc_mcu7t3v3__fillcap_8
XFILLER_171_1034 VDD VDD VSS VSS gf180mcu_as_sc_mcu7t3v3__fill_1
XFILLER_35_102 VDD VDD VSS VSS gf180mcu_as_sc_mcu7t3v3__fill_2
XTAP_TAPCELL_ROW_163_1344 VDD VSS gf180mcu_as_sc_mcu7t3v3__tap_2
XTAP_TAPCELL_ROW_130_3_2041 VDD VSS gf180mcu_as_sc_mcu7t3v3__tap_2
X_3951_ VDD VDD VSS VSS _3951_/A _4024_/B _3951_/C _3951_/D _3952_/C gf180mcu_as_sc_mcu7t3v3__ao211_2
X_2902_ VDD VDD VSS VSS _3199_/B _3542_/A _2902_/Y gf180mcu_as_sc_mcu7t3v3__and2_2
XFILLER_108_1256 VDD VDD VSS VSS gf180mcu_as_sc_mcu7t3v3__fillcap_16
XFILLER_177_825 VDD VDD VSS VSS gf180mcu_as_sc_mcu7t3v3__fill_1
X_3882_ VDD VDD VSS VSS _4946_/D _5172_/Q _4922_/D gf180mcu_as_sc_mcu7t3v3__and2_2
XPHY_EDGE_ROW_118_1_Left_310 VDD VSS gf180mcu_as_sc_mcu7t3v3__tap_2
X_2833_ VDD VDD VSS VSS _5485_/A _2833_/A _4751_/B gf180mcu_as_sc_mcu7t3v3__and2_2
X_2764_ VDD VDD VSS VSS _2764_/B _2764_/A _2842_/A gf180mcu_as_sc_mcu7t3v3__xnor2_2
XFILLER_30_1328 VDD VDD VSS VSS gf180mcu_as_sc_mcu7t3v3__fill_2
X_4503_ VDD VDD VSS VSS _4504_/D _4503_/B _4553_/D gf180mcu_as_sc_mcu7t3v3__nor2_2
X_5483_ VDD VDD VSS VSS _5483_/A _5483_/Y gf180mcu_as_sc_mcu7t3v3__buff_2
X_2695_ VDD VDD VSS VSS _2695_/A _4968_/Q _2734_/S _2695_/D _2701_/B gf180mcu_as_sc_mcu7t3v3__ao211_2
XFILLER_172_574 VDD VDD VSS VSS gf180mcu_as_sc_mcu7t3v3__fillcap_8
X_4434_ VDD VDD VSS VSS _5172_/Q _4590_/B _4523_/C _5122_/Q _4435_/B gf180mcu_as_sc_mcu7t3v3__ao22_2
Xfanout505 VDD VDD VSS VSS fanout507/Y _3715_/B gf180mcu_as_sc_mcu7t3v3__buff_12
X_4365_ VDD VDD VSS VSS _4366_/A _4365_/B _4365_/A gf180mcu_as_sc_mcu7t3v3__nand2_2
XTAP_TAPCELL_ROW_187_1801 VDD VSS gf180mcu_as_sc_mcu7t3v3__tap_2
XFILLER_154_1265 VDD VDD VSS VSS gf180mcu_as_sc_mcu7t3v3__fill_2
Xfanout538 VDD VDD VSS VSS _4592_/B _4548_/B gf180mcu_as_sc_mcu7t3v3__buff_12
X_3316_ VDD VDD VSS VSS _3373_/S _3965_/A _3316_/A _3318_/B gf180mcu_as_sc_mcu7t3v3__mux2_2
Xfanout549 VDD VDD VSS VSS fanout551/A _4067_/B gf180mcu_as_sc_mcu7t3v3__buff_12
X_4296_ VDD VDD VSS VSS _4297_/A _5127_/Q _4329_/A _4328_/B gf180mcu_as_sc_mcu7t3v3__ao21_2
Xmesh_tile_953 VDD VDD VSS VSS ne_out[27] gf180mcu_as_sc_mcu7t3v3__tiel_4
Xmesh_tile_942 VDD VDD VSS VSS ne_out[16] gf180mcu_as_sc_mcu7t3v3__tiel_4
Xmesh_tile_931 VDD VDD VSS VSS ne_out[5] gf180mcu_as_sc_mcu7t3v3__tiel_4
X_3247_ VDD VDD VSS VSS _3247_/B _3542_/A _3519_/C gf180mcu_as_sc_mcu7t3v3__or2_2
XTAP_TAPCELL_ROW_2_724 VDD VSS gf180mcu_as_sc_mcu7t3v3__tap_2
Xmesh_tile_986 VDD VDD VSS VSS north_out[26] gf180mcu_as_sc_mcu7t3v3__tiel_4
Xmesh_tile_975 VDD VDD VSS VSS north_out[15] gf180mcu_as_sc_mcu7t3v3__tiel_4
Xmesh_tile_964 VDD VDD VSS VSS north_out[4] gf180mcu_as_sc_mcu7t3v3__tiel_4
X_3178_ VDD VDD VSS VSS _3178_/A _3178_/B _3178_/C _3178_/D _3180_/C gf180mcu_as_sc_mcu7t3v3__ao211_2
XTAP_TAPCELL_ROW_2_735 VDD VSS gf180mcu_as_sc_mcu7t3v3__tap_2
XFILLER_187_1052 VDD VDD VSS VSS gf180mcu_as_sc_mcu7t3v3__fillcap_8
Xmesh_tile_997 VDD VDD VSS VSS nw_out[3] gf180mcu_as_sc_mcu7t3v3__tiel_4
XFILLER_165_1350 VDD VDD VSS VSS gf180mcu_as_sc_mcu7t3v3__fillcap_4
XFILLER_168_803 VDD VDD VSS VSS gf180mcu_as_sc_mcu7t3v3__fill_2
XFILLER_161_1214 VDD VDD VSS VSS gf180mcu_as_sc_mcu7t3v3__fillcap_16
XFILLER_168_847 VDD VDD VSS VSS gf180mcu_as_sc_mcu7t3v3__fillcap_16
XPHY_EDGE_ROW_102_1_Left_294 VDD VSS gf180mcu_as_sc_mcu7t3v3__tap_2
Xwire906 VDD VDD VSS VSS wire906/A _4008_/D gf180mcu_as_sc_mcu7t3v3__clkbuff_12
XTAP_TAPCELL_ROW_65_3_1976 VDD VSS gf180mcu_as_sc_mcu7t3v3__tap_2
XFILLER_10_558 VDD VDD VSS VSS gf180mcu_as_sc_mcu7t3v3__fill_1
XFILLER_155_519 VDD VDD VSS VSS gf180mcu_as_sc_mcu7t3v3__fillcap_4
XFILLER_11_1250 VDD VDD VSS VSS gf180mcu_as_sc_mcu7t3v3__fillcap_8
XFILLER_157_79 VDD VDD VSS VSS gf180mcu_as_sc_mcu7t3v3__fillcap_16
XFILLER_1_212 VDD VDD VSS VSS gf180mcu_as_sc_mcu7t3v3__fillcap_4
XPHY_EDGE_ROW_8_Left_201 VDD VSS gf180mcu_as_sc_mcu7t3v3__tap_2
XFILLER_133_1316 VDD VDD VSS VSS gf180mcu_as_sc_mcu7t3v3__fill_1
XFILLER_2_18 VDD VDD VSS VSS gf180mcu_as_sc_mcu7t3v3__fillcap_16
XFILLER_66_32 VDD VDD VSS VSS gf180mcu_as_sc_mcu7t3v3__fill_2
XFILLER_66_43 VDD VDD VSS VSS gf180mcu_as_sc_mcu7t3v3__fill_1
XFILLER_122_60 VDD VDD VSS VSS gf180mcu_as_sc_mcu7t3v3__fillcap_16
XFILLER_166_1147 VDD VDD VSS VSS gf180mcu_as_sc_mcu7t3v3__fillcap_8
XFILLER_158_313 VDD VDD VSS VSS gf180mcu_as_sc_mcu7t3v3__fill_2
XFILLER_159_825 VDD VDD VSS VSS gf180mcu_as_sc_mcu7t3v3__fill_1
XFILLER_159_858 VDD VDD VSS VSS gf180mcu_as_sc_mcu7t3v3__fill_2
XFILLER_185_110 VDD VDD VSS VSS gf180mcu_as_sc_mcu7t3v3__fill_1
XFILLER_174_839 VDD VDD VSS VSS gf180mcu_as_sc_mcu7t3v3__fillcap_16
XFILLER_177_1276 VDD VDD VSS VSS gf180mcu_as_sc_mcu7t3v3__fillcap_8
XFILLER_181_360 VDD VDD VSS VSS gf180mcu_as_sc_mcu7t3v3__fillcap_4
XFILLER_5_562 VDD VDD VSS VSS gf180mcu_as_sc_mcu7t3v3__fill_1
X_2480_ VDD VDD VSS VSS _5274_/Q _5275_/Q _2482_/B gf180mcu_as_sc_mcu7t3v3__or2_2
XFILLER_147_90 VDD VDD VSS VSS gf180mcu_as_sc_mcu7t3v3__fillcap_8
XFILLER_173_1118 VDD VDD VSS VSS gf180mcu_as_sc_mcu7t3v3__fill_2
XPHY_EDGE_ROW_51_3_Right_92 VDD VSS gf180mcu_as_sc_mcu7t3v3__tap_2
XPHY_EDGE_ROW_117_3_Left_489 VDD VSS gf180mcu_as_sc_mcu7t3v3__tap_2
X_4150_ VDD VDD VSS VSS _5004_/Q _4150_/B _4255_/B _4150_/D _5004_/D gf180mcu_as_sc_mcu7t3v3__ao22_2
X_3101_ VDD VDD VSS VSS _3236_/B _4933_/Q _3104_/C gf180mcu_as_sc_mcu7t3v3__or2_2
X_4081_ VDD VDD VSS VSS _4081_/A _4163_/B _4081_/C _4081_/D _4082_/B gf180mcu_as_sc_mcu7t3v3__ao211_2
XPHY_EDGE_ROW_54_3_Left_426 VDD VSS gf180mcu_as_sc_mcu7t3v3__tap_2
Xinput190 VDD VDD VSS VSS se_in[18] _4081_/A gf180mcu_as_sc_mcu7t3v3__buff_12
X_3032_ VDD VDD VSS VSS _4780_/D _3032_/C _3065_/B _3639_/A gf180mcu_as_sc_mcu7t3v3__aoi21_2
XFILLER_184_1247 VDD VDD VSS VSS gf180mcu_as_sc_mcu7t3v3__fillcap_4
X_4983_ VDD VDD VSS VSS _5178_/CLK _4983_/D _4983_/Q gf180mcu_as_sc_mcu7t3v3__dfxtp_2
X_3934_ VDD VDD VSS VSS _3934_/A _4163_/B _3934_/C _3934_/D _3935_/B gf180mcu_as_sc_mcu7t3v3__ao211_2
X_3865_ VDD VDD VSS VSS _5136_/Q _5135_/Q _3866_/C gf180mcu_as_sc_mcu7t3v3__or2_2
XFILLER_177_688 VDD VDD VSS VSS gf180mcu_as_sc_mcu7t3v3__fillcap_8
X_2816_ VDD VDD VSS VSS _2818_/S _2826_/B _4757_/Q _4756_/D gf180mcu_as_sc_mcu7t3v3__mux2_2
XFILLER_160_1280 VDD VDD VSS VSS gf180mcu_as_sc_mcu7t3v3__fillcap_8
XFILLER_176_198 VDD VDD VSS VSS gf180mcu_as_sc_mcu7t3v3__fill_1
X_3796_ VDD VDD VSS VSS _3796_/A _3796_/B _3796_/C _3796_/D _3797_/D gf180mcu_as_sc_mcu7t3v3__ao22_2
XFILLER_11_49 VDD VDD VSS VSS gf180mcu_as_sc_mcu7t3v3__fillcap_8
XFILLER_191_146 VDD VDD VSS VSS gf180mcu_as_sc_mcu7t3v3__fill_2
X_2747_ VDD VDD VSS VSS _2747_/B _2747_/A _2845_/A gf180mcu_as_sc_mcu7t3v3__and2_2
XFILLER_127_27 VDD VDD VSS VSS gf180mcu_as_sc_mcu7t3v3__fillcap_8
X_2678_ VDD VDD VSS VSS _4273_/S _4264_/B _4265_/B gf180mcu_as_sc_mcu7t3v3__and2_2
X_4417_ VDD VDD VSS VSS _4418_/C _4536_/S _5011_/Q _4538_/A gf180mcu_as_sc_mcu7t3v3__ao21_2
XTAP_TAPCELL_ROW_7_816 VDD VSS gf180mcu_as_sc_mcu7t3v3__tap_2
XTAP_TAPCELL_ROW_7_827 VDD VSS gf180mcu_as_sc_mcu7t3v3__tap_2
X_4348_ VDD VDD VSS VSS _5158_/Q _5157_/Q _4349_/A gf180mcu_as_sc_mcu7t3v3__xnor2_2
XFILLER_143_59 VDD VDD VSS VSS gf180mcu_as_sc_mcu7t3v3__fill_1
X_4279_ VDD VDD VSS VSS _4281_/S _5483_/A _5113_/Q _5113_/D gf180mcu_as_sc_mcu7t3v3__mux2_2
XFILLER_189_1136 VDD VDD VSS VSS gf180mcu_as_sc_mcu7t3v3__fill_1
XFILLER_160_6 VDD VDD VSS VSS gf180mcu_as_sc_mcu7t3v3__fillcap_16
XFILLER_187_419 VDD VDD VSS VSS gf180mcu_as_sc_mcu7t3v3__fill_1
XFILLER_167_154 VDD VDD VSS VSS gf180mcu_as_sc_mcu7t3v3__fill_2
XFILLER_168_34 VDD VDD VSS VSS gf180mcu_as_sc_mcu7t3v3__fill_1
XFILLER_168_78 VDD VDD VSS VSS gf180mcu_as_sc_mcu7t3v3__fillcap_8
XFILLER_184_22 VDD VDD VSS VSS gf180mcu_as_sc_mcu7t3v3__fillcap_8
XFILLER_11_1091 VDD VDD VSS VSS gf180mcu_as_sc_mcu7t3v3__fill_1
XFILLER_2_510 VDD VDD VSS VSS gf180mcu_as_sc_mcu7t3v3__fillcap_8
XFILLER_137_1260 VDD VDD VSS VSS gf180mcu_as_sc_mcu7t3v3__fill_2
XFILLER_172_1151 VDD VDD VSS VSS gf180mcu_as_sc_mcu7t3v3__fillcap_4
Xfanout891 VDD VDD VSS VSS _4199_/A _4753_/A gf180mcu_as_sc_mcu7t3v3__buff_12
XFILLER_93_63 VDD VDD VSS VSS gf180mcu_as_sc_mcu7t3v3__fillcap_4
XFILLER_179_909 VDD VDD VSS VSS gf180mcu_as_sc_mcu7t3v3__fill_1
XFILLER_187_920 VDD VDD VSS VSS gf180mcu_as_sc_mcu7t3v3__fill_2
XFILLER_18_1256 VDD VDD VSS VSS gf180mcu_as_sc_mcu7t3v3__fill_1
XFILLER_9_142 VDD VDD VSS VSS gf180mcu_as_sc_mcu7t3v3__fill_2
XTAP_TAPCELL_ROW_158_1254 VDD VSS gf180mcu_as_sc_mcu7t3v3__tap_2
XTAP_TAPCELL_ROW_158_1243 VDD VSS gf180mcu_as_sc_mcu7t3v3__tap_2
XFILLER_159_699 VDD VDD VSS VSS gf180mcu_as_sc_mcu7t3v3__fill_1
X_3650_ VDD VDD VSS VSS _4021_/D _3650_/B _3650_/C _3650_/D _3651_/C gf180mcu_as_sc_mcu7t3v3__ao211_2
X_3581_ VDD VDD VSS VSS _4917_/Q _3648_/B _3648_/C _3950_/A _3583_/C gf180mcu_as_sc_mcu7t3v3__ao22_2
X_2601_ VDD VDD VSS VSS _2602_/B _4765_/Q _2605_/C _2601_/C _2601_/D gf180mcu_as_sc_mcu7t3v3__aoi22_2
XFILLER_154_360 VDD VDD VSS VSS gf180mcu_as_sc_mcu7t3v3__fillcap_4
XFILLER_161_308 VDD VDD VSS VSS gf180mcu_as_sc_mcu7t3v3__fillcap_8
X_2532_ VDD VDD VSS VSS _4749_/A _2792_/A _2534_/C gf180mcu_as_sc_mcu7t3v3__or2_2
XFILLER_154_382 VDD VDD VSS VSS gf180mcu_as_sc_mcu7t3v3__fill_2
XFILLER_6_893 VDD VDD VSS VSS gf180mcu_as_sc_mcu7t3v3__fill_2
X_5251_ VDD VDD VSS VSS _5266_/CLK _5251_/D _5251_/Q gf180mcu_as_sc_mcu7t3v3__dfxtp_2
XTAP_TAPCELL_ROW_171_1498 VDD VSS gf180mcu_as_sc_mcu7t3v3__tap_2
XTAP_TAPCELL_ROW_171_1487 VDD VSS gf180mcu_as_sc_mcu7t3v3__tap_2
X_4202_ VDD VDD VSS VSS _4231_/B _4217_/B _4218_/C _5038_/Q _5038_/D gf180mcu_as_sc_mcu7t3v3__ao22_2
X_2463_ VDD VDD VSS VSS _2464_/C _4579_/S _5035_/Q _4581_/A gf180mcu_as_sc_mcu7t3v3__ao21_2
XFILLER_116_1311 VDD VDD VSS VSS gf180mcu_as_sc_mcu7t3v3__fillcap_16
X_5182_ VDD VDD VSS VSS _5182_/CLK _5182_/D _5182_/Q gf180mcu_as_sc_mcu7t3v3__dfxtp_2
X_2394_ VDD VDD VSS VSS _2394_/Y _3676_/D gf180mcu_as_sc_mcu7t3v3__inv_2
XTAP_TAPCELL_ROW_117_3_2028 VDD VSS gf180mcu_as_sc_mcu7t3v3__tap_2
XFILLER_3_72 VDD VDD VSS VSS gf180mcu_as_sc_mcu7t3v3__fillcap_8
X_4133_ VDD VDD VSS VSS _4253_/B _4133_/B _4141_/D gf180mcu_as_sc_mcu7t3v3__nor2_2
X_4064_ VDD VDD VSS VSS _4064_/A _4104_/B _4104_/C _4064_/D _4065_/D gf180mcu_as_sc_mcu7t3v3__ao22_2
X_3015_ VDD VDD VSS VSS _3015_/B _3795_/A _4778_/D gf180mcu_as_sc_mcu7t3v3__and2_2
XFILLER_169_419 VDD VDD VSS VSS gf180mcu_as_sc_mcu7t3v3__fill_1
XFILLER_184_1077 VDD VDD VSS VSS gf180mcu_as_sc_mcu7t3v3__fillcap_8
XTAP_TAPCELL_ROW_178_1619 VDD VSS gf180mcu_as_sc_mcu7t3v3__tap_2
XFILLER_177_430 VDD VDD VSS VSS gf180mcu_as_sc_mcu7t3v3__fill_2
XFILLER_184_1099 VDD VDD VSS VSS gf180mcu_as_sc_mcu7t3v3__fill_2
XFILLER_36_1334 VDD VDD VSS VSS gf180mcu_as_sc_mcu7t3v3__fillcap_16
X_4966_ VDD VDD VSS VSS _5265_/CLK _4966_/D _4966_/Q gf180mcu_as_sc_mcu7t3v3__dfxtp_2
X_4897_ VDD VDD VSS VSS clkload5/A _4897_/D _4897_/Q gf180mcu_as_sc_mcu7t3v3__dfxtp_2
X_3917_ VDD VDD VSS VSS _3931_/B _3917_/A _3923_/B gf180mcu_as_sc_mcu7t3v3__and2_2
XFILLER_164_113 VDD VDD VSS VSS gf180mcu_as_sc_mcu7t3v3__fill_1
XFILLER_22_48 VDD VDD VSS VSS gf180mcu_as_sc_mcu7t3v3__fill_1
X_3848_ VDD VDD VSS VSS _3848_/B _3848_/A _4913_/D gf180mcu_as_sc_mcu7t3v3__and2_2
XFILLER_138_37 VDD VDD VSS VSS gf180mcu_as_sc_mcu7t3v3__fillcap_16
X_3779_ VDD VDD VSS VSS _4159_/A _3779_/B _3779_/C _3779_/D _3781_/A gf180mcu_as_sc_mcu7t3v3__ao211_2
XFILLER_152_308 VDD VDD VSS VSS gf180mcu_as_sc_mcu7t3v3__fillcap_16
Xoutput450 VDD VDD VSS VSS _4903_/Q west_out[30] gf180mcu_as_sc_mcu7t3v3__buff_12
XFILLER_103_84 VDD VDD VSS VSS gf180mcu_as_sc_mcu7t3v3__fill_2
XFILLER_179_22 VDD VDD VSS VSS gf180mcu_as_sc_mcu7t3v3__fillcap_16
XFILLER_10_130 VDD VDD VSS VSS gf180mcu_as_sc_mcu7t3v3__fillcap_8
Xwire511 VDD VDD VSS VSS _3559_/Y _3739_/B gf180mcu_as_sc_mcu7t3v3__clkbuff_12
XFILLER_10_174 VDD VDD VSS VSS gf180mcu_as_sc_mcu7t3v3__fill_1
XFILLER_10_185 VDD VDD VSS VSS gf180mcu_as_sc_mcu7t3v3__fillcap_4
XFILLER_11_697 VDD VDD VSS VSS gf180mcu_as_sc_mcu7t3v3__fill_2
XFILLER_139_1300 VDD VDD VSS VSS gf180mcu_as_sc_mcu7t3v3__fillcap_8
XTAP_TAPCELL_ROW_153_1151 VDD VSS gf180mcu_as_sc_mcu7t3v3__tap_2
XFILLER_174_1224 VDD VDD VSS VSS gf180mcu_as_sc_mcu7t3v3__fill_1
Xclkbuf_leaf_27_clk_regs VDD VDD VSS VSS clkbuf_3_5__f_clk_regs/Y _5097_/CLK gf180mcu_as_sc_mcu7t3v3__clkbuff_12
XTAP_TAPCELL_ROW_153_1162 VDD VSS gf180mcu_as_sc_mcu7t3v3__tap_2
XFILLER_152_886 VDD VDD VSS VSS gf180mcu_as_sc_mcu7t3v3__fillcap_4
XFILLER_174_1235 VDD VDD VSS VSS gf180mcu_as_sc_mcu7t3v3__fillcap_4
XFILLER_87_1298 VDD VDD VSS VSS gf180mcu_as_sc_mcu7t3v3__fill_1
XFILLER_88_41 VDD VDD VSS VSS gf180mcu_as_sc_mcu7t3v3__fill_2
XFILLER_2_384 VDD VDD VSS VSS gf180mcu_as_sc_mcu7t3v3__fill_1
XFILLER_24_1260 VDD VDD VSS VSS gf180mcu_as_sc_mcu7t3v3__fillcap_4
XFILLER_168_1017 VDD VDD VSS VSS gf180mcu_as_sc_mcu7t3v3__fillcap_16
X_4820_ VDD VDD VSS VSS clkload6/A _4820_/D _4820_/Q gf180mcu_as_sc_mcu7t3v3__dfxtp_2
XFILLER_175_912 VDD VDD VSS VSS gf180mcu_as_sc_mcu7t3v3__fill_2
X_4751_ VDD VDD VSS VSS _4751_/B _4751_/A _5285_/D gf180mcu_as_sc_mcu7t3v3__and2_2
X_4682_ VDD VDD VSS VSS _5248_/D _5102_/Q _4731_/B _4682_/C gf180mcu_as_sc_mcu7t3v3__ao21_2
X_3702_ VDD VDD VSS VSS _3706_/B _3702_/C _3792_/B _4078_/A gf180mcu_as_sc_mcu7t3v3__aoi21_2
XTAP_TAPCELL_ROW_173_1527 VDD VSS gf180mcu_as_sc_mcu7t3v3__tap_2
XFILLER_70_1291 VDD VDD VSS VSS gf180mcu_as_sc_mcu7t3v3__fillcap_8
X_3633_ VDD VDD VSS VSS _3634_/C _4006_/A _3650_/B _3633_/C gf180mcu_as_sc_mcu7t3v3__ao21_2
XTAP_TAPCELL_ROW_173_1538 VDD VSS gf180mcu_as_sc_mcu7t3v3__tap_2
XTAP_TAPCELL_ROW_190_1863 VDD VSS gf180mcu_as_sc_mcu7t3v3__tap_2
XTAP_TAPCELL_ROW_190_1852 VDD VSS gf180mcu_as_sc_mcu7t3v3__tap_2
X_3564_ VDD VDD VSS VSS _3564_/Y _3797_/C _3798_/A gf180mcu_as_sc_mcu7t3v3__nor2b_2
X_3495_ VDD VDD VSS VSS _4151_/A _3495_/B _3495_/C _3495_/D _3497_/C gf180mcu_as_sc_mcu7t3v3__ao211_2
X_2515_ VDD VDD VSS VSS _2517_/D _4749_/A _4663_/A _5240_/Q gf180mcu_as_sc_mcu7t3v3__aoi21_2
X_5234_ VDD VDD VSS VSS _5277_/CLK _5234_/D _5234_/Q gf180mcu_as_sc_mcu7t3v3__dfxtp_2
X_2446_ VDD VDD VSS VSS _4132_/A _2446_/A gf180mcu_as_sc_mcu7t3v3__inv_2
X_5165_ VDD VDD VSS VSS _5178_/CLK _5165_/D _5165_/Q gf180mcu_as_sc_mcu7t3v3__dfxtp_2
XPHY_EDGE_ROW_59_1_Left_251 VDD VSS gf180mcu_as_sc_mcu7t3v3__tap_2
X_4116_ VDD VDD VSS VSS _4251_/B _4116_/B _4141_/D gf180mcu_as_sc_mcu7t3v3__nor2_2
XPHY_EDGE_ROW_14_3_Right_55 VDD VSS gf180mcu_as_sc_mcu7t3v3__tap_2
X_5096_ VDD VDD VSS VSS _5277_/CLK _5096_/D _5096_/Q gf180mcu_as_sc_mcu7t3v3__dfxtp_2
XTAP_TAPCELL_ROW_148_1_1101 VDD VSS gf180mcu_as_sc_mcu7t3v3__tap_2
X_4047_ VDD VDD VSS VSS _4047_/A _4101_/C _4047_/C _4047_/D _4049_/C gf180mcu_as_sc_mcu7t3v3__ao211_2
XFILLER_169_205 VDD VDD VSS VSS gf180mcu_as_sc_mcu7t3v3__fillcap_4
XFILLER_166_901 VDD VDD VSS VSS gf180mcu_as_sc_mcu7t3v3__fill_2
X_4949_ VDD VDD VSS VSS _5158_/CLK _4949_/D _4949_/Q gf180mcu_as_sc_mcu7t3v3__dfxtp_2
XFILLER_165_422 VDD VDD VSS VSS gf180mcu_as_sc_mcu7t3v3__fill_2
XFILLER_149_69 VDD VDD VSS VSS gf180mcu_as_sc_mcu7t3v3__fill_1
XFILLER_177_282 VDD VDD VSS VSS gf180mcu_as_sc_mcu7t3v3__fillcap_4
XFILLER_192_274 VDD VDD VSS VSS gf180mcu_as_sc_mcu7t3v3__fillcap_4
XPHY_EDGE_ROW_131_3_Left_503 VDD VSS gf180mcu_as_sc_mcu7t3v3__tap_2
XFILLER_152_138 VDD VDD VSS VSS gf180mcu_as_sc_mcu7t3v3__fillcap_16
XFILLER_180_425 VDD VDD VSS VSS gf180mcu_as_sc_mcu7t3v3__fillcap_16
XFILLER_180_447 VDD VDD VSS VSS gf180mcu_as_sc_mcu7t3v3__fill_1
XFILLER_0_822 VDD VDD VSS VSS gf180mcu_as_sc_mcu7t3v3__fill_1
XFILLER_160_160 VDD VDD VSS VSS gf180mcu_as_sc_mcu7t3v3__fill_2
XFILLER_0_833 VDD VDD VSS VSS gf180mcu_as_sc_mcu7t3v3__fill_2
XFILLER_0_899 VDD VDD VSS VSS gf180mcu_as_sc_mcu7t3v3__fill_2
XPHY_EDGE_ROW_126_3_Left_498 VDD VSS gf180mcu_as_sc_mcu7t3v3__tap_2
XFILLER_175_208 VDD VDD VSS VSS gf180mcu_as_sc_mcu7t3v3__fill_2
XFILLER_188_558 VDD VDD VSS VSS gf180mcu_as_sc_mcu7t3v3__fillcap_8
XFILLER_90_31 VDD VDD VSS VSS gf180mcu_as_sc_mcu7t3v3__fillcap_4
XFILLER_93_1291 VDD VDD VSS VSS gf180mcu_as_sc_mcu7t3v3__fillcap_8
X_4875__1093 VDD VDD VSS VSS _4875_/D gf180mcu_as_sc_mcu7t3v3__tiel_4
XFILLER_157_912 VDD VDD VSS VSS gf180mcu_as_sc_mcu7t3v3__fillcap_16
XFILLER_169_772 VDD VDD VSS VSS gf180mcu_as_sc_mcu7t3v3__fillcap_16
XFILLER_180_1283 VDD VDD VSS VSS gf180mcu_as_sc_mcu7t3v3__fill_2
XFILLER_12_995 VDD VDD VSS VSS gf180mcu_as_sc_mcu7t3v3__fillcap_16
XFILLER_141_1256 VDD VDD VSS VSS gf180mcu_as_sc_mcu7t3v3__fillcap_16
XPHY_EDGE_ROW_63_3_Left_435 VDD VSS gf180mcu_as_sc_mcu7t3v3__tap_2
XFILLER_183_263 VDD VDD VSS VSS gf180mcu_as_sc_mcu7t3v3__fillcap_4
XFILLER_171_458 VDD VDD VSS VSS gf180mcu_as_sc_mcu7t3v3__fillcap_4
XFILLER_174_1021 VDD VDD VSS VSS gf180mcu_as_sc_mcu7t3v3__fill_2
X_3280_ VDD VDD VSS VSS _3280_/D _3553_/A _3280_/B _3814_/A _3526_/C gf180mcu_as_sc_mcu7t3v3__ao31_2
XFILLER_174_1087 VDD VDD VSS VSS gf180mcu_as_sc_mcu7t3v3__fillcap_16
XTAP_TAPCELL_ROW_166_1397 VDD VSS gf180mcu_as_sc_mcu7t3v3__tap_2
XFILLER_179_503 VDD VDD VSS VSS gf180mcu_as_sc_mcu7t3v3__fillcap_4
XFILLER_179_525 VDD VDD VSS VSS gf180mcu_as_sc_mcu7t3v3__fillcap_4
X_4803_ VDD VDD VSS VSS _5226_/CLK _4803_/D _4803_/Q gf180mcu_as_sc_mcu7t3v3__dfxtp_2
XFILLER_33_1326 VDD VDD VSS VSS gf180mcu_as_sc_mcu7t3v3__fillcap_4
X_4734_ VDD VDD VSS VSS _4735_/B _4734_/B _4747_/D gf180mcu_as_sc_mcu7t3v3__nand2_2
X_2995_ VDD VDD VSS VSS _3046_/B _4920_/Q _2996_/D gf180mcu_as_sc_mcu7t3v3__or2_2
XTAP_TAPCELL_ROW_192_1914 VDD VSS gf180mcu_as_sc_mcu7t3v3__tap_2
XTAP_TAPCELL_ROW_192_1903 VDD VSS gf180mcu_as_sc_mcu7t3v3__tap_2
XFILLER_120_1307 VDD VDD VSS VSS gf180mcu_as_sc_mcu7t3v3__fillcap_16
XFILLER_159_282 VDD VDD VSS VSS gf180mcu_as_sc_mcu7t3v3__fillcap_4
XFILLER_120_1329 VDD VDD VSS VSS gf180mcu_as_sc_mcu7t3v3__fill_1
XFILLER_162_403 VDD VDD VSS VSS gf180mcu_as_sc_mcu7t3v3__fillcap_4
XFILLER_174_263 VDD VDD VSS VSS gf180mcu_as_sc_mcu7t3v3__fillcap_16
X_4665_ VDD VDD VSS VSS _4686_/A _4685_/C gf180mcu_as_sc_mcu7t3v3__inv_2
X_4596_ VDD VDD VSS VSS _5190_/Q _4629_/B _4629_/C _5191_/Q _5190_/D gf180mcu_as_sc_mcu7t3v3__ao22_2
X_3616_ VDD VDD VSS VSS _4845_/D _3616_/C _3654_/B _3616_/A gf180mcu_as_sc_mcu7t3v3__aoi21_2
XFILLER_192_1121 VDD VDD VSS VSS gf180mcu_as_sc_mcu7t3v3__fill_1
XFILLER_192_1132 VDD VDD VSS VSS gf180mcu_as_sc_mcu7t3v3__fill_1
X_3547_ VDD VDD VSS VSS _3786_/A _3798_/A _3562_/A gf180mcu_as_sc_mcu7t3v3__and2_2
XFILLER_157_1285 VDD VDD VSS VSS gf180mcu_as_sc_mcu7t3v3__fillcap_16
XFILLER_153_1149 VDD VDD VSS VSS gf180mcu_as_sc_mcu7t3v3__fillcap_8
XFILLER_192_1187 VDD VDD VSS VSS gf180mcu_as_sc_mcu7t3v3__fill_2
X_3478_ VDD VDD VSS VSS _4137_/A _3493_/C _3494_/C _4138_/D _3480_/C gf180mcu_as_sc_mcu7t3v3__ao22_2
X_5217_ VDD VDD VSS VSS _5220_/CLK _5217_/D _5217_/Q gf180mcu_as_sc_mcu7t3v3__dfxtp_2
X_2429_ VDD VDD VSS VSS _3616_/A _3986_/A gf180mcu_as_sc_mcu7t3v3__inv_2
X_5148_ VDD VDD VSS VSS _5150_/CLK _5148_/D _5148_/Q gf180mcu_as_sc_mcu7t3v3__dfxtp_2
X_5079_ VDD VDD VSS VSS _5086_/CLK _5079_/D _5079_/Q gf180mcu_as_sc_mcu7t3v3__dfxtp_2
XFILLER_71_103 VDD VDD VSS VSS gf180mcu_as_sc_mcu7t3v3__fill_2
XFILLER_129_1310 VDD VDD VSS VSS gf180mcu_as_sc_mcu7t3v3__fill_2
XTAP_TAPCELL_ROW_0_674 VDD VSS gf180mcu_as_sc_mcu7t3v3__tap_2
XTAP_TAPCELL_ROW_0_663 VDD VSS gf180mcu_as_sc_mcu7t3v3__tap_2
XFILLER_164_1245 VDD VDD VSS VSS gf180mcu_as_sc_mcu7t3v3__fillcap_16
XTAP_TAPCELL_ROW_0_696 VDD VSS gf180mcu_as_sc_mcu7t3v3__tap_2
XTAP_TAPCELL_ROW_0_685 VDD VSS gf180mcu_as_sc_mcu7t3v3__tap_2
XFILLER_12_214 VDD VDD VSS VSS gf180mcu_as_sc_mcu7t3v3__fill_2
Xsram2048.u_bank1_924 VDD VDD VSS VSS sram2048.u_bank1/WEN[5] gf180mcu_as_sc_mcu7t3v3__tiel_4
XFILLER_100_41 VDD VDD VSS VSS gf180mcu_as_sc_mcu7t3v3__fill_2
XFILLER_12_247 VDD VDD VSS VSS gf180mcu_as_sc_mcu7t3v3__fillcap_16
XFILLER_166_720 VDD VDD VSS VSS gf180mcu_as_sc_mcu7t3v3__fillcap_4
XTAP_TAPCELL_ROW_11_905 VDD VSS gf180mcu_as_sc_mcu7t3v3__tap_2
XFILLER_154_926 VDD VDD VSS VSS gf180mcu_as_sc_mcu7t3v3__fillcap_16
XFILLER_176_34 VDD VDD VSS VSS gf180mcu_as_sc_mcu7t3v3__fill_1
XFILLER_180_200 VDD VDD VSS VSS gf180mcu_as_sc_mcu7t3v3__fillcap_16
XFILLER_109_83 VDD VDD VSS VSS gf180mcu_as_sc_mcu7t3v3__fillcap_16
XFILLER_180_244 VDD VDD VSS VSS gf180mcu_as_sc_mcu7t3v3__fill_1
XFILLER_136_1314 VDD VDD VSS VSS gf180mcu_as_sc_mcu7t3v3__fillcap_4
XFILLER_175_1352 VDD VDD VSS VSS gf180mcu_as_sc_mcu7t3v3__fill_1
XFILLER_125_60 VDD VDD VSS VSS gf180mcu_as_sc_mcu7t3v3__fill_2
XTAP_TAPCELL_ROW_55_1_1008 VDD VSS gf180mcu_as_sc_mcu7t3v3__tap_2
XFILLER_169_1189 VDD VDD VSS VSS gf180mcu_as_sc_mcu7t3v3__fill_1
XFILLER_188_333 VDD VDD VSS VSS gf180mcu_as_sc_mcu7t3v3__fill_1
XTAP_TAPCELL_ROW_83_3_1994 VDD VSS gf180mcu_as_sc_mcu7t3v3__tap_2
X_2780_ VDD VDD VSS VSS _2781_/D _2780_/B _2883_/B gf180mcu_as_sc_mcu7t3v3__nor2_2
X_4450_ VDD VDD VSS VSS _4451_/D _4450_/B _4573_/A gf180mcu_as_sc_mcu7t3v3__nor2_2
X_4381_ VDD VDD VSS VSS _4385_/B _5065_/Q _4557_/A gf180mcu_as_sc_mcu7t3v3__nand2_2
X_3401_ VDD VDD VSS VSS _3450_/B _4055_/A _3404_/C gf180mcu_as_sc_mcu7t3v3__and2_2
X_3332_ VDD VDD VSS VSS _3373_/S _3984_/D _3332_/A _3334_/B gf180mcu_as_sc_mcu7t3v3__mux2_2
Xfanout709 VDD VDD VSS VSS _4152_/C _4129_/C gf180mcu_as_sc_mcu7t3v3__buff_12
X_3263_ VDD VDD VSS VSS _3263_/B _3263_/A _3275_/A gf180mcu_as_sc_mcu7t3v3__and2_2
XTAP_TAPCELL_ROW_168_1437 VDD VSS gf180mcu_as_sc_mcu7t3v3__tap_2
XFILLER_6_1224 VDD VDD VSS VSS gf180mcu_as_sc_mcu7t3v3__fill_1
X_5002_ VDD VDD VSS VSS _5089_/CLK _5002_/D _5002_/Q gf180mcu_as_sc_mcu7t3v3__dfxtp_2
X_3194_ VDD VDD VSS VSS _3194_/S _3194_/B _4164_/A _3195_/B gf180mcu_as_sc_mcu7t3v3__mux2_2
XTAP_TAPCELL_ROW_185_1762 VDD VSS gf180mcu_as_sc_mcu7t3v3__tap_2
XFILLER_152_1182 VDD VDD VSS VSS gf180mcu_as_sc_mcu7t3v3__fillcap_8
XFILLER_187_1278 VDD VDD VSS VSS gf180mcu_as_sc_mcu7t3v3__fill_2
XFILLER_14_27 VDD VDD VSS VSS gf180mcu_as_sc_mcu7t3v3__fillcap_8
X_2978_ VDD VDD VSS VSS _3046_/B _4918_/Q _2979_/D gf180mcu_as_sc_mcu7t3v3__or2_2
X_4717_ VDD VDD VSS VSS _4717_/S _5261_/Q _5251_/Q _4718_/B gf180mcu_as_sc_mcu7t3v3__mux2_2
XFILLER_163_734 VDD VDD VSS VSS gf180mcu_as_sc_mcu7t3v3__fillcap_16
XFILLER_30_37 VDD VDD VSS VSS gf180mcu_as_sc_mcu7t3v3__fillcap_4
X_4648_ VDD VDD VSS VSS _4649_/C _5234_/Q _5235_/Q _5235_/D gf180mcu_as_sc_mcu7t3v3__mux2_2
XFILLER_146_37 VDD VDD VSS VSS gf180mcu_as_sc_mcu7t3v3__fillcap_16
XFILLER_190_564 VDD VDD VSS VSS gf180mcu_as_sc_mcu7t3v3__fillcap_8
XFILLER_190_597 VDD VDD VSS VSS gf180mcu_as_sc_mcu7t3v3__fillcap_16
XFILLER_2_928 VDD VDD VSS VSS gf180mcu_as_sc_mcu7t3v3__fill_2
X_4579_ VDD VDD VSS VSS _4579_/S _5029_/Q _5058_/Q _4580_/B gf180mcu_as_sc_mcu7t3v3__mux2_2
XFILLER_29_100 VDD VDD VSS VSS gf180mcu_as_sc_mcu7t3v3__fillcap_4
XTAP_TAPCELL_ROW_5_788 VDD VSS gf180mcu_as_sc_mcu7t3v3__tap_2
XTAP_TAPCELL_ROW_5_777 VDD VSS gf180mcu_as_sc_mcu7t3v3__tap_2
XFILLER_79_1326 VDD VDD VSS VSS gf180mcu_as_sc_mcu7t3v3__fill_2
XFILLER_189_108 VDD VDD VSS VSS gf180mcu_as_sc_mcu7t3v3__fill_2
XTAP_TAPCELL_ROW_116_1_1069 VDD VSS gf180mcu_as_sc_mcu7t3v3__tap_2
XFILLER_158_517 VDD VDD VSS VSS gf180mcu_as_sc_mcu7t3v3__fillcap_8
XFILLER_185_314 VDD VDD VSS VSS gf180mcu_as_sc_mcu7t3v3__fillcap_8
XFILLER_187_22 VDD VDD VSS VSS gf180mcu_as_sc_mcu7t3v3__fillcap_16
XFILLER_164_1097 VDD VDD VSS VSS gf180mcu_as_sc_mcu7t3v3__fill_1
XFILLER_185_347 VDD VDD VSS VSS gf180mcu_as_sc_mcu7t3v3__fill_2
XFILLER_187_88 VDD VDD VSS VSS gf180mcu_as_sc_mcu7t3v3__fillcap_16
XFILLER_51_1256 VDD VDD VSS VSS gf180mcu_as_sc_mcu7t3v3__fillcap_4
XFILLER_4_232 VDD VDD VSS VSS gf180mcu_as_sc_mcu7t3v3__fill_2
XFILLER_5_755 VDD VDD VSS VSS gf180mcu_as_sc_mcu7t3v3__fillcap_8
XFILLER_5_788 VDD VDD VSS VSS gf180mcu_as_sc_mcu7t3v3__fillcap_16
XFILLER_1_961 VDD VDD VSS VSS gf180mcu_as_sc_mcu7t3v3__fill_2
XFILLER_0_482 VDD VDD VSS VSS gf180mcu_as_sc_mcu7t3v3__fill_1
XFILLER_171_1068 VDD VDD VSS VSS gf180mcu_as_sc_mcu7t3v3__fill_1
XFILLER_96_85 VDD VDD VSS VSS gf180mcu_as_sc_mcu7t3v3__fillcap_16
Xmesh_tile VDD VDD VSS VSS ne_out[0] gf180mcu_as_sc_mcu7t3v3__tiel_4
XTAP_TAPCELL_ROW_163_1345 VDD VSS gf180mcu_as_sc_mcu7t3v3__tap_2
XTAP_TAPCELL_ROW_163_1334 VDD VSS gf180mcu_as_sc_mcu7t3v3__tap_2
X_3950_ VDD VDD VSS VSS _3950_/A _4023_/B _4023_/C _4917_/Q _3951_/D gf180mcu_as_sc_mcu7t3v3__ao22_2
XTAP_TAPCELL_ROW_180_1670 VDD VSS gf180mcu_as_sc_mcu7t3v3__tap_2
XFILLER_177_804 VDD VDD VSS VSS gf180mcu_as_sc_mcu7t3v3__fillcap_8
X_2901_ VDD VDD VSS VSS _3199_/B _3247_/B _3249_/B gf180mcu_as_sc_mcu7t3v3__nand2b_2
XFILLER_177_837 VDD VDD VSS VSS gf180mcu_as_sc_mcu7t3v3__fill_2
X_3881_ VDD VDD VSS VSS _3897_/B _5171_/Q _4921_/D gf180mcu_as_sc_mcu7t3v3__and2_2
X_2832_ VDD VDD VSS VSS _2832_/S _2832_/B _2832_/A _2832_/Y gf180mcu_as_sc_mcu7t3v3__mux2_2
XPHY_EDGE_ROW_68_1_Left_260 VDD VSS gf180mcu_as_sc_mcu7t3v3__tap_2
XFILLER_77_2 VDD VDD VSS VSS gf180mcu_as_sc_mcu7t3v3__fill_2
X_2763_ VDD VDD VSS VSS _2764_/B _2810_/A _2771_/B gf180mcu_as_sc_mcu7t3v3__xnor2_2
XTAP_TAPCELL_ROW_31_3_1942 VDD VSS gf180mcu_as_sc_mcu7t3v3__tap_2
XPHY_EDGE_ROW_23_3_Right_64 VDD VSS gf180mcu_as_sc_mcu7t3v3__tap_2
XFILLER_184_380 VDD VDD VSS VSS gf180mcu_as_sc_mcu7t3v3__fillcap_4
X_4502_ VDD VDD VSS VSS _4502_/D _4502_/A _4502_/B _4502_/C _4503_/B gf180mcu_as_sc_mcu7t3v3__ao31_2
X_5482_ VDD VDD VSS VSS _5482_/A _5482_/Y gf180mcu_as_sc_mcu7t3v3__buff_2
X_2694_ VDD VDD VSS VSS _4959_/Q _2732_/S _2695_/D gf180mcu_as_sc_mcu7t3v3__and2_2
XFILLER_160_737 VDD VDD VSS VSS gf180mcu_as_sc_mcu7t3v3__fillcap_8
XFILLER_172_597 VDD VDD VSS VSS gf180mcu_as_sc_mcu7t3v3__fillcap_4
X_4433_ VDD VDD VSS VSS _5170_/Q _4548_/B _4433_/C _4433_/D _5170_/D gf180mcu_as_sc_mcu7t3v3__ao211_2
X_4364_ VDD VDD VSS VSS _4365_/B _4364_/A _4364_/B _4370_/A gf180mcu_as_sc_mcu7t3v3__ao21_2
XTAP_TAPCELL_ROW_187_1802 VDD VSS gf180mcu_as_sc_mcu7t3v3__tap_2
XFILLER_67_1296 VDD VDD VSS VSS gf180mcu_as_sc_mcu7t3v3__fill_1
Xfanout517 VDD VDD VSS VSS wire518/Y _3802_/B gf180mcu_as_sc_mcu7t3v3__buff_12
Xfanout539 VDD VDD VSS VSS _4592_/B _4574_/B gf180mcu_as_sc_mcu7t3v3__buff_12
X_4295_ VDD VDD VSS VSS _4328_/B _4295_/B _4329_/A gf180mcu_as_sc_mcu7t3v3__nor2_2
X_3315_ VDD VDD VSS VSS _3965_/D _3372_/B _3315_/C _3315_/D _3316_/A gf180mcu_as_sc_mcu7t3v3__ao22_2
X_3246_ VDD VDD VSS VSS _3510_/D _3247_/B _3542_/A gf180mcu_as_sc_mcu7t3v3__nor2_2
Xmesh_tile_954 VDD VDD VSS VSS ne_out[28] gf180mcu_as_sc_mcu7t3v3__tiel_4
Xmesh_tile_943 VDD VDD VSS VSS ne_out[17] gf180mcu_as_sc_mcu7t3v3__tiel_4
Xmesh_tile_932 VDD VDD VSS VSS ne_out[6] gf180mcu_as_sc_mcu7t3v3__tiel_4
XFILLER_26_103 VDD VDD VSS VSS gf180mcu_as_sc_mcu7t3v3__fill_2
Xmesh_tile_987 VDD VDD VSS VSS north_out[27] gf180mcu_as_sc_mcu7t3v3__tiel_4
Xmesh_tile_976 VDD VDD VSS VSS north_out[16] gf180mcu_as_sc_mcu7t3v3__tiel_4
Xmesh_tile_965 VDD VDD VSS VSS north_out[5] gf180mcu_as_sc_mcu7t3v3__tiel_4
X_3177_ VDD VDD VSS VSS _4152_/A _3177_/B _3177_/C _4151_/D _3178_/C gf180mcu_as_sc_mcu7t3v3__ao22_2
XTAP_TAPCELL_ROW_2_736 VDD VSS gf180mcu_as_sc_mcu7t3v3__tap_2
XTAP_TAPCELL_ROW_2_725 VDD VSS gf180mcu_as_sc_mcu7t3v3__tap_2
Xmesh_tile_998 VDD VDD VSS VSS nw_out[4] gf180mcu_as_sc_mcu7t3v3__tiel_4
XPHY_EDGE_ROW_140_3_Left_512 VDD VSS gf180mcu_as_sc_mcu7t3v3__tap_2
XFILLER_168_815 VDD VDD VSS VSS gf180mcu_as_sc_mcu7t3v3__fillcap_16
XFILLER_74_1256 VDD VDD VSS VSS gf180mcu_as_sc_mcu7t3v3__fillcap_8
Xwire907 VDD VDD VSS VSS wire907/A _3992_/D gf180mcu_as_sc_mcu7t3v3__clkbuff_12
XFILLER_157_14 VDD VDD VSS VSS gf180mcu_as_sc_mcu7t3v3__fillcap_4
XFILLER_182_317 VDD VDD VSS VSS gf180mcu_as_sc_mcu7t3v3__fillcap_4
XFILLER_159_1122 VDD VDD VSS VSS gf180mcu_as_sc_mcu7t3v3__fillcap_8
XFILLER_190_372 VDD VDD VSS VSS gf180mcu_as_sc_mcu7t3v3__fill_2
XFILLER_191_895 VDD VDD VSS VSS gf180mcu_as_sc_mcu7t3v3__fill_2
XTAP_TAPCELL_ROW_135_3_2046 VDD VSS gf180mcu_as_sc_mcu7t3v3__tap_2
XFILLER_2_769 VDD VDD VSS VSS gf180mcu_as_sc_mcu7t3v3__fill_1
XPHY_EDGE_ROW_72_3_Left_444 VDD VSS gf180mcu_as_sc_mcu7t3v3__tap_2
XFILLER_166_1115 VDD VDD VSS VSS gf180mcu_as_sc_mcu7t3v3__fillcap_16
XFILLER_13_342 VDD VDD VSS VSS gf180mcu_as_sc_mcu7t3v3__fillcap_16
XFILLER_159_815 VDD VDD VSS VSS gf180mcu_as_sc_mcu7t3v3__fillcap_8
XFILLER_92_1345 VDD VDD VSS VSS gf180mcu_as_sc_mcu7t3v3__fillcap_8
XFILLER_13_386 VDD VDD VSS VSS gf180mcu_as_sc_mcu7t3v3__fill_1
XFILLER_186_645 VDD VDD VSS VSS gf180mcu_as_sc_mcu7t3v3__fillcap_16
XFILLER_13_397 VDD VDD VSS VSS gf180mcu_as_sc_mcu7t3v3__fillcap_8
XFILLER_167_870 VDD VDD VSS VSS gf180mcu_as_sc_mcu7t3v3__fill_2
XFILLER_174_807 VDD VDD VSS VSS gf180mcu_as_sc_mcu7t3v3__fillcap_16
XFILLER_186_667 VDD VDD VSS VSS gf180mcu_as_sc_mcu7t3v3__fill_1
XFILLER_186_678 VDD VDD VSS VSS gf180mcu_as_sc_mcu7t3v3__fillcap_16
XFILLER_9_368 VDD VDD VSS VSS gf180mcu_as_sc_mcu7t3v3__fillcap_4
XFILLER_154_553 VDD VDD VSS VSS gf180mcu_as_sc_mcu7t3v3__fill_1
XFILLER_177_1266 VDD VDD VSS VSS gf180mcu_as_sc_mcu7t3v3__fill_2
XFILLER_154_597 VDD VDD VSS VSS gf180mcu_as_sc_mcu7t3v3__fill_2
XFILLER_1_780 VDD VDD VSS VSS gf180mcu_as_sc_mcu7t3v3__fillcap_4
X_3100_ VDD VDD VSS VSS _3134_/S _4077_/D _4080_/A _3103_/B gf180mcu_as_sc_mcu7t3v3__mux2_2
XFILLER_7_1352 VDD VDD VSS VSS gf180mcu_as_sc_mcu7t3v3__fill_2
X_4080_ VDD VDD VSS VSS _4080_/A _4159_/B _4159_/C _4080_/D _4081_/D gf180mcu_as_sc_mcu7t3v3__ao22_2
XTAP_TAPCELL_ROW_182_1710 VDD VSS gf180mcu_as_sc_mcu7t3v3__tap_2
Xinput180 VDD VDD VSS VSS rst input180/Y gf180mcu_as_sc_mcu7t3v3__buff_12
X_3031_ VDD VDD VSS VSS _3638_/D _3097_/A _3031_/B _3031_/C _3032_/C gf180mcu_as_sc_mcu7t3v3__ao31_2
XFILLER_184_1204 VDD VDD VSS VSS gf180mcu_as_sc_mcu7t3v3__fillcap_16
XFILLER_188_1351 VDD VDD VSS VSS gf180mcu_as_sc_mcu7t3v3__fillcap_4
XFILLER_97_1256 VDD VDD VSS VSS gf180mcu_as_sc_mcu7t3v3__fill_2
Xinput191 VDD VDD VSS VSS se_in[19] _4089_/A gf180mcu_as_sc_mcu7t3v3__buff_12
X_4982_ VDD VDD VSS VSS clkload8/A _4982_/D _4982_/Q gf180mcu_as_sc_mcu7t3v3__dfxtp_2
X_3933_ VDD VDD VSS VSS _3933_/A _4159_/B _4159_/C _3933_/D _3934_/D gf180mcu_as_sc_mcu7t3v3__ao22_2
XFILLER_176_100 VDD VDD VSS VSS gf180mcu_as_sc_mcu7t3v3__fillcap_4
XFILLER_189_483 VDD VDD VSS VSS gf180mcu_as_sc_mcu7t3v3__fillcap_4
X_3864_ VDD VDD VSS VSS _5141_/Q _5142_/Q _3864_/C _3868_/A gf180mcu_as_sc_mcu7t3v3__nor3_2
X_2815_ VDD VDD VSS VSS _4694_/B _2815_/A _2826_/B gf180mcu_as_sc_mcu7t3v3__and2_2
XFILLER_160_1292 VDD VDD VSS VSS gf180mcu_as_sc_mcu7t3v3__fill_2
XFILLER_192_637 VDD VDD VSS VSS gf180mcu_as_sc_mcu7t3v3__fillcap_4
XFILLER_192_648 VDD VDD VSS VSS gf180mcu_as_sc_mcu7t3v3__fillcap_4
XFILLER_34_1262 VDD VDD VSS VSS gf180mcu_as_sc_mcu7t3v3__fill_1
X_3795_ VDD VDD VSS VSS _3795_/B _3795_/A _4868_/D gf180mcu_as_sc_mcu7t3v3__and2_2
X_2746_ VDD VDD VSS VSS _4626_/B _2746_/B _2838_/B gf180mcu_as_sc_mcu7t3v3__nor2_2
XFILLER_121_1298 VDD VDD VSS VSS gf180mcu_as_sc_mcu7t3v3__fill_1
XFILLER_160_501 VDD VDD VSS VSS gf180mcu_as_sc_mcu7t3v3__fill_2
X_4888__1080 VDD VDD VSS VSS _4888_/D gf180mcu_as_sc_mcu7t3v3__tiel_4
X_2677_ VDD VDD VSS VSS _2731_/S _5099_/Q _2677_/Y gf180mcu_as_sc_mcu7t3v3__and2_2
XFILLER_160_534 VDD VDD VSS VSS gf180mcu_as_sc_mcu7t3v3__fill_2
XFILLER_172_383 VDD VDD VSS VSS gf180mcu_as_sc_mcu7t3v3__fill_2
XFILLER_191_1208 VDD VDD VSS VSS gf180mcu_as_sc_mcu7t3v3__fillcap_4
X_4416_ VDD VDD VSS VSS _5168_/Q _4548_/B _4416_/C _4416_/D _5168_/D gf180mcu_as_sc_mcu7t3v3__ao211_2
XTAP_TAPCELL_ROW_7_828 VDD VSS gf180mcu_as_sc_mcu7t3v3__tap_2
XTAP_TAPCELL_ROW_7_817 VDD VSS gf180mcu_as_sc_mcu7t3v3__tap_2
XFILLER_8_1127 VDD VDD VSS VSS gf180mcu_as_sc_mcu7t3v3__fill_2
X_4347_ VDD VDD VSS VSS _4347_/Y _4350_/C _4554_/B gf180mcu_as_sc_mcu7t3v3__nand2b_2
XFILLER_80_1260 VDD VDD VSS VSS gf180mcu_as_sc_mcu7t3v3__fill_2
X_4278_ VDD VDD VSS VSS _4281_/S _4698_/B _5112_/Q _5112_/D gf180mcu_as_sc_mcu7t3v3__mux2_2
X_3229_ VDD VDD VSS VSS _3513_/A _3240_/B _3229_/C _3229_/D _3230_/A gf180mcu_as_sc_mcu7t3v3__ao22_2
XFILLER_153_6 VDD VDD VSS VSS gf180mcu_as_sc_mcu7t3v3__fillcap_4
XFILLER_165_1192 VDD VDD VSS VSS gf180mcu_as_sc_mcu7t3v3__fillcap_4
XFILLER_168_645 VDD VDD VSS VSS gf180mcu_as_sc_mcu7t3v3__fill_2
XFILLER_11_846 VDD VDD VSS VSS gf180mcu_as_sc_mcu7t3v3__fill_2
XFILLER_156_807 VDD VDD VSS VSS gf180mcu_as_sc_mcu7t3v3__fillcap_16
XFILLER_168_667 VDD VDD VSS VSS gf180mcu_as_sc_mcu7t3v3__fillcap_16
XFILLER_7_806 VDD VDD VSS VSS gf180mcu_as_sc_mcu7t3v3__fillcap_8
XFILLER_164_873 VDD VDD VSS VSS gf180mcu_as_sc_mcu7t3v3__fill_2
XFILLER_170_309 VDD VDD VSS VSS gf180mcu_as_sc_mcu7t3v3__fillcap_4
XFILLER_184_34 VDD VDD VSS VSS gf180mcu_as_sc_mcu7t3v3__fill_1
XFILLER_117_50 VDD VDD VSS VSS gf180mcu_as_sc_mcu7t3v3__fillcap_4
XFILLER_77_32 VDD VDD VSS VSS gf180mcu_as_sc_mcu7t3v3__fill_2
Xfanout870 VDD VDD VSS VSS _2675_/C _2730_/A gf180mcu_as_sc_mcu7t3v3__buff_12
Xfanout892 VDD VDD VSS VSS _3870_/A _4199_/A gf180mcu_as_sc_mcu7t3v3__buff_12
XFILLER_93_31 VDD VDD VSS VSS gf180mcu_as_sc_mcu7t3v3__fillcap_16
XFILLER_178_409 VDD VDD VSS VSS gf180mcu_as_sc_mcu7t3v3__fill_1
XFILLER_187_932 VDD VDD VSS VSS gf180mcu_as_sc_mcu7t3v3__fill_1
XFILLER_13_172 VDD VDD VSS VSS gf180mcu_as_sc_mcu7t3v3__fillcap_16
XFILLER_144_1265 VDD VDD VSS VSS gf180mcu_as_sc_mcu7t3v3__fillcap_16
XFILLER_159_656 VDD VDD VSS VSS gf180mcu_as_sc_mcu7t3v3__fillcap_16
XFILLER_9_110 VDD VDD VSS VSS gf180mcu_as_sc_mcu7t3v3__fill_1
XTAP_TAPCELL_ROW_158_1255 VDD VSS gf180mcu_as_sc_mcu7t3v3__tap_2
XTAP_TAPCELL_ROW_158_1244 VDD VSS gf180mcu_as_sc_mcu7t3v3__tap_2
XFILLER_158_166 VDD VDD VSS VSS gf180mcu_as_sc_mcu7t3v3__fillcap_8
XFILLER_158_177 VDD VDD VSS VSS gf180mcu_as_sc_mcu7t3v3__fillcap_16
XFILLER_174_615 VDD VDD VSS VSS gf180mcu_as_sc_mcu7t3v3__fill_1
XFILLER_186_497 VDD VDD VSS VSS gf180mcu_as_sc_mcu7t3v3__fill_1
XFILLER_187_998 VDD VDD VSS VSS gf180mcu_as_sc_mcu7t3v3__fillcap_4
XFILLER_9_176 VDD VDD VSS VSS gf180mcu_as_sc_mcu7t3v3__fillcap_4
X_3580_ VDD VDD VSS VSS _3944_/A _3652_/D _3580_/C _3580_/Y _3580_/D gf180mcu_as_sc_mcu7t3v3__aoi211_2
X_2600_ VDD VDD VSS VSS _4765_/Q _4764_/Q _2601_/C gf180mcu_as_sc_mcu7t3v3__xnor2_2
XTAP_TAPCELL_ROW_175_1580 VDD VSS gf180mcu_as_sc_mcu7t3v3__tap_2
XFILLER_155_895 VDD VDD VSS VSS gf180mcu_as_sc_mcu7t3v3__fillcap_8
XFILLER_6_861 VDD VDD VSS VSS gf180mcu_as_sc_mcu7t3v3__fillcap_8
X_2531_ VDD VDD VSS VSS _4371_/B _2802_/A _2747_/A gf180mcu_as_sc_mcu7t3v3__nand2_2
X_5250_ VDD VDD VSS VSS _5280_/CLK _5250_/D _5250_/Q gf180mcu_as_sc_mcu7t3v3__dfxtp_2
XTAP_TAPCELL_ROW_171_1499 VDD VSS gf180mcu_as_sc_mcu7t3v3__tap_2
XTAP_TAPCELL_ROW_171_1488 VDD VSS gf180mcu_as_sc_mcu7t3v3__tap_2
X_4201_ VDD VDD VSS VSS _4230_/B _4217_/B _4218_/C _5037_/Q _5037_/D gf180mcu_as_sc_mcu7t3v3__ao22_2
X_2462_ VDD VDD VSS VSS _4588_/A _2462_/B _2462_/A _4350_/D gf180mcu_as_sc_mcu7t3v3__mux2_2
XFILLER_116_1301 VDD VDD VSS VSS gf180mcu_as_sc_mcu7t3v3__fill_2
X_5181_ VDD VDD VSS VSS _5181_/CLK _5181_/D _5181_/Q gf180mcu_as_sc_mcu7t3v3__dfxtp_2
X_2393_ VDD VDD VSS VSS _2882_/A _4763_/Q gf180mcu_as_sc_mcu7t3v3__inv_2
XFILLER_3_51 VDD VDD VSS VSS gf180mcu_as_sc_mcu7t3v3__fillcap_4
XFILLER_64_1288 VDD VDD VSS VSS gf180mcu_as_sc_mcu7t3v3__fill_1
XFILLER_64_1299 VDD VDD VSS VSS gf180mcu_as_sc_mcu7t3v3__fillcap_4
X_4132_ VDD VDD VSS VSS _4132_/A _4141_/B _4132_/C _4132_/D _4133_/B gf180mcu_as_sc_mcu7t3v3__ao22_2
XFILLER_151_1269 VDD VDD VSS VSS gf180mcu_as_sc_mcu7t3v3__fillcap_16
X_4063_ VDD VDD VSS VSS _4063_/A _4103_/B _4063_/C _4063_/D _4065_/C gf180mcu_as_sc_mcu7t3v3__ao211_2
X_3014_ VDD VDD VSS VSS _3097_/A _3014_/B _3994_/A _3015_/B gf180mcu_as_sc_mcu7t3v3__mux2_2
XPHY_EDGE_ROW_20_1_Right_529 VDD VSS gf180mcu_as_sc_mcu7t3v3__tap_2
XFILLER_184_1012 VDD VDD VSS VSS gf180mcu_as_sc_mcu7t3v3__fill_2
XFILLER_188_1170 VDD VDD VSS VSS gf180mcu_as_sc_mcu7t3v3__fill_2
XTAP_TAPCELL_ROW_18_3_1929 VDD VSS gf180mcu_as_sc_mcu7t3v3__tap_2
X_4965_ VDD VDD VSS VSS _5232_/CLK _4965_/D _4965_/Q gf180mcu_as_sc_mcu7t3v3__dfxtp_2
XFILLER_178_921 VDD VDD VSS VSS gf180mcu_as_sc_mcu7t3v3__fillcap_16
XFILLER_178_954 VDD VDD VSS VSS gf180mcu_as_sc_mcu7t3v3__fillcap_16
X_3916_ VDD VDD VSS VSS _3924_/C _3931_/B gf180mcu_as_sc_mcu7t3v3__inv_2
X_4896_ VDD VDD VSS VSS clkload5/A _4896_/D _4896_/Q gf180mcu_as_sc_mcu7t3v3__dfxtp_2
XFILLER_164_103 VDD VDD VSS VSS gf180mcu_as_sc_mcu7t3v3__fill_2
XFILLER_165_615 VDD VDD VSS VSS gf180mcu_as_sc_mcu7t3v3__fill_2
XFILLER_177_486 VDD VDD VSS VSS gf180mcu_as_sc_mcu7t3v3__fillcap_4
XFILLER_178_998 VDD VDD VSS VSS gf180mcu_as_sc_mcu7t3v3__fillcap_16
XFILLER_192_401 VDD VDD VSS VSS gf180mcu_as_sc_mcu7t3v3__fill_2
XFILLER_192_412 VDD VDD VSS VSS gf180mcu_as_sc_mcu7t3v3__fill_1
XFILLER_22_27 VDD VDD VSS VSS gf180mcu_as_sc_mcu7t3v3__fillcap_8
X_3847_ VDD VDD VSS VSS _3847_/S _3847_/B _3847_/A _3848_/B gf180mcu_as_sc_mcu7t3v3__mux2_2
XFILLER_165_648 VDD VDD VSS VSS gf180mcu_as_sc_mcu7t3v3__fill_1
X_3778_ VDD VDD VSS VSS _3778_/B _4159_/D _3779_/D gf180mcu_as_sc_mcu7t3v3__and2_2
XFILLER_192_467 VDD VDD VSS VSS gf180mcu_as_sc_mcu7t3v3__fillcap_4
XFILLER_192_478 VDD VDD VSS VSS gf180mcu_as_sc_mcu7t3v3__fillcap_4
X_2729_ VDD VDD VSS VSS _2730_/D _2832_/S _2736_/B _2729_/A gf180mcu_as_sc_mcu7t3v3__aoi21b_2
XFILLER_156_1114 VDD VDD VSS VSS gf180mcu_as_sc_mcu7t3v3__fill_1
XFILLER_154_26 VDD VDD VSS VSS gf180mcu_as_sc_mcu7t3v3__fill_1
XFILLER_154_37 VDD VDD VSS VSS gf180mcu_as_sc_mcu7t3v3__fill_1
XFILLER_156_1147 VDD VDD VSS VSS gf180mcu_as_sc_mcu7t3v3__fillcap_8
XFILLER_191_1049 VDD VDD VSS VSS gf180mcu_as_sc_mcu7t3v3__fill_1
Xoutput451 VDD VDD VSS VSS _4904_/Q west_out[31] gf180mcu_as_sc_mcu7t3v3__buff_12
Xoutput440 VDD VDD VSS VSS _4894_/Q west_out[21] gf180mcu_as_sc_mcu7t3v3__buff_12
XPHY_EDGE_ROW_20_1_Left_212 VDD VSS gf180mcu_as_sc_mcu7t3v3__tap_2
XFILLER_187_206 VDD VDD VSS VSS gf180mcu_as_sc_mcu7t3v3__fillcap_4
XFILLER_11_632 VDD VDD VSS VSS gf180mcu_as_sc_mcu7t3v3__fillcap_8
XFILLER_168_442 VDD VDD VSS VSS gf180mcu_as_sc_mcu7t3v3__fillcap_8
XFILLER_183_401 VDD VDD VSS VSS gf180mcu_as_sc_mcu7t3v3__fillcap_4
XFILLER_13_1121 VDD VDD VSS VSS gf180mcu_as_sc_mcu7t3v3__fill_1
XFILLER_13_1143 VDD VDD VSS VSS gf180mcu_as_sc_mcu7t3v3__fill_2
XFILLER_184_968 VDD VDD VSS VSS gf180mcu_as_sc_mcu7t3v3__fill_1
XFILLER_6_124 VDD VDD VSS VSS gf180mcu_as_sc_mcu7t3v3__fill_1
XFILLER_7_636 VDD VDD VSS VSS gf180mcu_as_sc_mcu7t3v3__fill_1
XFILLER_183_467 VDD VDD VSS VSS gf180mcu_as_sc_mcu7t3v3__fill_1
XFILLER_183_489 VDD VDD VSS VSS gf180mcu_as_sc_mcu7t3v3__fill_1
XTAP_TAPCELL_ROW_153_1152 VDD VSS gf180mcu_as_sc_mcu7t3v3__tap_2
XFILLER_3_842 VDD VDD VSS VSS gf180mcu_as_sc_mcu7t3v3__fillcap_4
XFILLER_87_1288 VDD VDD VSS VSS gf180mcu_as_sc_mcu7t3v3__fillcap_8
XFILLER_152_898 VDD VDD VSS VSS gf180mcu_as_sc_mcu7t3v3__fillcap_8
XFILLER_3_886 VDD VDD VSS VSS gf180mcu_as_sc_mcu7t3v3__fillcap_16
XPHY_EDGE_ROW_155_Left_347 VDD VSS gf180mcu_as_sc_mcu7t3v3__tap_2
XFILLER_111_1264 VDD VDD VSS VSS gf180mcu_as_sc_mcu7t3v3__fillcap_4
XFILLER_150_1291 VDD VDD VSS VSS gf180mcu_as_sc_mcu7t3v3__fillcap_16
XPHY_EDGE_ROW_32_3_Right_73 VDD VSS gf180mcu_as_sc_mcu7t3v3__tap_2
XFILLER_146_1305 VDD VDD VSS VSS gf180mcu_as_sc_mcu7t3v3__fillcap_4
XFILLER_185_1332 VDD VDD VSS VSS gf180mcu_as_sc_mcu7t3v3__fillcap_16
XFILLER_185_1354 VDD VDD VSS VSS gf180mcu_as_sc_mcu7t3v3__fill_1
XFILLER_179_718 VDD VDD VSS VSS gf180mcu_as_sc_mcu7t3v3__fillcap_16
XFILLER_178_239 VDD VDD VSS VSS gf180mcu_as_sc_mcu7t3v3__fillcap_4
XPHY_EDGE_ROW_35_3_Left_407 VDD VSS gf180mcu_as_sc_mcu7t3v3__tap_2
X_4750_ VDD VDD VSS VSS _5278_/D _4750_/A _4750_/B _4750_/C _4750_/D gf180mcu_as_sc_mcu7t3v3__aoi22_2
XPHY_EDGE_ROW_164_Left_356 VDD VSS gf180mcu_as_sc_mcu7t3v3__tap_2
XFILLER_159_475 VDD VDD VSS VSS gf180mcu_as_sc_mcu7t3v3__fill_2
X_4681_ VDD VDD VSS VSS _5248_/Q _4685_/C _4681_/C _5249_/Q _4682_/C gf180mcu_as_sc_mcu7t3v3__ao22_2
X_3701_ VDD VDD VSS VSS _3702_/C _4077_/D _3781_/S _3701_/C gf180mcu_as_sc_mcu7t3v3__ao21_2
X_3632_ VDD VDD VSS VSS _4006_/D _3649_/B _3648_/C _4005_/A _3633_/C gf180mcu_as_sc_mcu7t3v3__ao22_2
XTAP_TAPCELL_ROW_173_1539 VDD VSS gf180mcu_as_sc_mcu7t3v3__tap_2
XTAP_TAPCELL_ROW_173_1528 VDD VSS gf180mcu_as_sc_mcu7t3v3__tap_2
XFILLER_162_629 VDD VDD VSS VSS gf180mcu_as_sc_mcu7t3v3__fillcap_16
XFILLER_174_467 VDD VDD VSS VSS gf180mcu_as_sc_mcu7t3v3__fill_1
XTAP_TAPCELL_ROW_190_1864 VDD VSS gf180mcu_as_sc_mcu7t3v3__tap_2
XTAP_TAPCELL_ROW_190_1853 VDD VSS gf180mcu_as_sc_mcu7t3v3__tap_2
XFILLER_161_139 VDD VDD VSS VSS gf180mcu_as_sc_mcu7t3v3__fill_1
X_3563_ VDD VDD VSS VSS _3563_/Y _3563_/B _3563_/A gf180mcu_as_sc_mcu7t3v3__nor2_2
X_3494_ VDD VDD VSS VSS _4153_/A _3494_/B _3494_/C _4151_/D _3495_/D gf180mcu_as_sc_mcu7t3v3__ao22_2
X_2514_ VDD VDD VSS VSS _4663_/A _5240_/Q _4703_/D gf180mcu_as_sc_mcu7t3v3__and2_2
X_5233_ VDD VDD VSS VSS _5277_/CLK _5233_/D _5233_/Q gf180mcu_as_sc_mcu7t3v3__dfxtp_2
X_2445_ VDD VDD VSS VSS _4124_/A _2445_/A gf180mcu_as_sc_mcu7t3v3__inv_2
XPHY_EDGE_ROW_173_Left_365 VDD VSS gf180mcu_as_sc_mcu7t3v3__tap_2
X_5164_ VDD VDD VSS VSS _5164_/CLK _5164_/D _5164_/Q gf180mcu_as_sc_mcu7t3v3__dfxtp_2
XTAP_TAPCELL_ROW_73_1_1026 VDD VSS gf180mcu_as_sc_mcu7t3v3__tap_2
XFILLER_190_1082 VDD VDD VSS VSS gf180mcu_as_sc_mcu7t3v3__fill_2
XFILLER_5_1119 VDD VDD VSS VSS gf180mcu_as_sc_mcu7t3v3__fill_1
XFILLER_9_1266 VDD VDD VSS VSS gf180mcu_as_sc_mcu7t3v3__fill_2
X_4115_ VDD VDD VSS VSS _4115_/A _4127_/C _4115_/C _4115_/D _4116_/B gf180mcu_as_sc_mcu7t3v3__ao22_2
X_5095_ VDD VDD VSS VSS _5095_/CLK _5095_/D _5095_/Q gf180mcu_as_sc_mcu7t3v3__dfxtp_2
XFILLER_17_27 VDD VDD VSS VSS gf180mcu_as_sc_mcu7t3v3__fill_2
XFILLER_186_1107 VDD VDD VSS VSS gf180mcu_as_sc_mcu7t3v3__fill_1
X_4046_ VDD VDD VSS VSS _4046_/A _4101_/B _4103_/B _4046_/D _4047_/D gf180mcu_as_sc_mcu7t3v3__ao22_2
XPHY_EDGE_ROW_14_1_Left_385 VDD VSS gf180mcu_as_sc_mcu7t3v3__tap_2
XPHY_EDGE_ROW_182_Left_374 VDD VSS gf180mcu_as_sc_mcu7t3v3__tap_2
XFILLER_127_1260 VDD VDD VSS VSS gf180mcu_as_sc_mcu7t3v3__fill_1
X_4948_ VDD VDD VSS VSS _5097_/CLK _4948_/D _4948_/Q gf180mcu_as_sc_mcu7t3v3__dfxtp_2
XFILLER_162_1173 VDD VDD VSS VSS gf180mcu_as_sc_mcu7t3v3__fillcap_4
XFILLER_165_401 VDD VDD VSS VSS gf180mcu_as_sc_mcu7t3v3__fillcap_8
X_4879_ VDD VDD VSS VSS clkload4/A _4879_/D _4879_/Q gf180mcu_as_sc_mcu7t3v3__dfxtp_2
XFILLER_181_916 VDD VDD VSS VSS gf180mcu_as_sc_mcu7t3v3__fill_2
XFILLER_10_1327 VDD VDD VSS VSS gf180mcu_as_sc_mcu7t3v3__fill_1
XPHY_EDGE_ROW_81_3_Left_453 VDD VSS gf180mcu_as_sc_mcu7t3v3__tap_2
XFILLER_165_69 VDD VDD VSS VSS gf180mcu_as_sc_mcu7t3v3__fill_1
XPHY_EDGE_ROW_191_Left_383 VDD VSS gf180mcu_as_sc_mcu7t3v3__tap_2
XFILLER_0_845 VDD VDD VSS VSS gf180mcu_as_sc_mcu7t3v3__fill_1
XFILLER_58_34 VDD VDD VSS VSS gf180mcu_as_sc_mcu7t3v3__fill_1
XFILLER_134_1275 VDD VDD VSS VSS gf180mcu_as_sc_mcu7t3v3__fillcap_8
XFILLER_74_33 VDD VDD VSS VSS gf180mcu_as_sc_mcu7t3v3__fill_2
XFILLER_167_1084 VDD VDD VSS VSS gf180mcu_as_sc_mcu7t3v3__fillcap_4
XFILLER_157_902 VDD VDD VSS VSS gf180mcu_as_sc_mcu7t3v3__fill_1
XFILLER_169_762 VDD VDD VSS VSS gf180mcu_as_sc_mcu7t3v3__fillcap_8
XFILLER_12_963 VDD VDD VSS VSS gf180mcu_as_sc_mcu7t3v3__fillcap_4
XFILLER_156_412 VDD VDD VSS VSS gf180mcu_as_sc_mcu7t3v3__fillcap_4
XFILLER_11_473 VDD VDD VSS VSS gf180mcu_as_sc_mcu7t3v3__fillcap_4
XFILLER_157_957 VDD VDD VSS VSS gf180mcu_as_sc_mcu7t3v3__fillcap_16
XFILLER_7_422 VDD VDD VSS VSS gf180mcu_as_sc_mcu7t3v3__fillcap_4
XFILLER_157_979 VDD VDD VSS VSS gf180mcu_as_sc_mcu7t3v3__fill_1
XFILLER_172_938 VDD VDD VSS VSS gf180mcu_as_sc_mcu7t3v3__fillcap_4
XFILLER_184_787 VDD VDD VSS VSS gf180mcu_as_sc_mcu7t3v3__fill_2
XFILLER_174_1011 VDD VDD VSS VSS gf180mcu_as_sc_mcu7t3v3__fillcap_4
XFILLER_180_971 VDD VDD VSS VSS gf180mcu_as_sc_mcu7t3v3__fill_2
XFILLER_3_672 VDD VDD VSS VSS gf180mcu_as_sc_mcu7t3v3__fill_1
XFILLER_113_1326 VDD VDD VSS VSS gf180mcu_as_sc_mcu7t3v3__fillcap_4
XFILLER_4_1152 VDD VDD VSS VSS gf180mcu_as_sc_mcu7t3v3__fill_2
XTAP_TAPCELL_ROW_166_1398 VDD VSS gf180mcu_as_sc_mcu7t3v3__tap_2
XTAP_TAPCELL_ROW_134_1_1087 VDD VSS gf180mcu_as_sc_mcu7t3v3__tap_2
XFILLER_0_52 VDD VDD VSS VSS gf180mcu_as_sc_mcu7t3v3__fillcap_16
XFILLER_0_74 VDD VDD VSS VSS gf180mcu_as_sc_mcu7t3v3__fill_2
XFILLER_181_1026 VDD VDD VSS VSS gf180mcu_as_sc_mcu7t3v3__fillcap_16
XFILLER_179_559 VDD VDD VSS VSS gf180mcu_as_sc_mcu7t3v3__fill_1
X_4802_ VDD VDD VSS VSS _5226_/CLK _4802_/D _4802_/Q gf180mcu_as_sc_mcu7t3v3__dfxtp_2
X_2994_ VDD VDD VSS VSS _3045_/A _2994_/B _2994_/C _3045_/D _2996_/C gf180mcu_as_sc_mcu7t3v3__ao211_2
XFILLER_72_1354 VDD VDD VSS VSS gf180mcu_as_sc_mcu7t3v3__fill_1
XFILLER_9_72 VDD VDD VSS VSS gf180mcu_as_sc_mcu7t3v3__fillcap_16
X_4733_ VDD VDD VSS VSS _4733_/A _4733_/B _4733_/C _5268_/D _4742_/C gf180mcu_as_sc_mcu7t3v3__aoi211_2
XTAP_TAPCELL_ROW_192_1915 VDD VSS gf180mcu_as_sc_mcu7t3v3__tap_2
XTAP_TAPCELL_ROW_192_1904 VDD VSS gf180mcu_as_sc_mcu7t3v3__tap_2
XFILLER_187_592 VDD VDD VSS VSS gf180mcu_as_sc_mcu7t3v3__fill_1
XTAP_TAPCELL_ROW_92_3_2003 VDD VSS gf180mcu_as_sc_mcu7t3v3__tap_2
X_4664_ VDD VDD VSS VSS _4674_/B _4666_/B _4683_/C gf180mcu_as_sc_mcu7t3v3__nor2_2
XFILLER_162_426 VDD VDD VSS VSS gf180mcu_as_sc_mcu7t3v3__fill_2
Xmax_cap620 VDD VDD VSS VSS _2605_/C _2831_/A gf180mcu_as_sc_mcu7t3v3__clkbuff_12
X_4595_ VDD VDD VSS VSS _5189_/Q _4629_/B _4629_/C _5190_/Q _5189_/D gf180mcu_as_sc_mcu7t3v3__ao22_2
X_3615_ VDD VDD VSS VSS _3615_/D _3730_/A _3615_/B _3615_/C _3616_/C gf180mcu_as_sc_mcu7t3v3__ao31_2
XFILLER_157_1220 VDD VDD VSS VSS gf180mcu_as_sc_mcu7t3v3__fill_1
XFILLER_192_1111 VDD VDD VSS VSS gf180mcu_as_sc_mcu7t3v3__fill_2
Xmax_cap653 VDD VDD VSS VSS _3467_/B _3502_/B gf180mcu_as_sc_mcu7t3v3__clkbuff_12
X_3546_ VDD VDD VSS VSS _3797_/C _3563_/A _3786_/A gf180mcu_as_sc_mcu7t3v3__and2_2
XFILLER_153_1106 VDD VDD VSS VSS gf180mcu_as_sc_mcu7t3v3__fillcap_8
XFILLER_171_982 VDD VDD VSS VSS gf180mcu_as_sc_mcu7t3v3__fillcap_8
XFILLER_192_1177 VDD VDD VSS VSS gf180mcu_as_sc_mcu7t3v3__fillcap_4
X_5216_ VDD VDD VSS VSS _5216_/CLK _5216_/D _5216_/Q gf180mcu_as_sc_mcu7t3v3__dfxtp_2
X_3477_ VDD VDD VSS VSS _4132_/A _3477_/B _3477_/C _4829_/D _3730_/D gf180mcu_as_sc_mcu7t3v3__aoi211_2
X_2428_ VDD VDD VSS VSS _3608_/A _3978_/A gf180mcu_as_sc_mcu7t3v3__inv_2
X_5147_ VDD VDD VSS VSS _5150_/CLK _5147_/D _5147_/Q gf180mcu_as_sc_mcu7t3v3__dfxtp_2
X_5078_ VDD VDD VSS VSS _5095_/CLK _5078_/D _5078_/Q gf180mcu_as_sc_mcu7t3v3__dfxtp_2
X_4029_ VDD VDD VSS VSS _4029_/A _4102_/B _4102_/C _4927_/Q _4031_/C gf180mcu_as_sc_mcu7t3v3__ao22_2
XTAP_TAPCELL_ROW_0_664 VDD VSS gf180mcu_as_sc_mcu7t3v3__tap_2
XFILLER_164_1224 VDD VDD VSS VSS gf180mcu_as_sc_mcu7t3v3__fill_1
XTAP_TAPCELL_ROW_0_697 VDD VSS gf180mcu_as_sc_mcu7t3v3__tap_2
XTAP_TAPCELL_ROW_0_686 VDD VSS gf180mcu_as_sc_mcu7t3v3__tap_2
XTAP_TAPCELL_ROW_0_675 VDD VSS gf180mcu_as_sc_mcu7t3v3__tap_2
Xsram2048.u_bank1_925 VDD VDD VSS VSS sram2048.u_bank1/WEN[6] gf180mcu_as_sc_mcu7t3v3__tiel_4
XFILLER_157_209 VDD VDD VSS VSS gf180mcu_as_sc_mcu7t3v3__fill_1
XFILLER_8_208 VDD VDD VSS VSS gf180mcu_as_sc_mcu7t3v3__fillcap_8
XTAP_TAPCELL_ROW_11_906 VDD VSS gf180mcu_as_sc_mcu7t3v3__tap_2
XFILLER_181_702 VDD VDD VSS VSS gf180mcu_as_sc_mcu7t3v3__fillcap_16
XFILLER_5_904 VDD VDD VSS VSS gf180mcu_as_sc_mcu7t3v3__fillcap_4
XFILLER_153_426 VDD VDD VSS VSS gf180mcu_as_sc_mcu7t3v3__fill_2
XFILLER_158_1017 VDD VDD VSS VSS gf180mcu_as_sc_mcu7t3v3__fillcap_16
XFILLER_5_948 VDD VDD VSS VSS gf180mcu_as_sc_mcu7t3v3__fill_1
XFILLER_88_1350 VDD VDD VSS VSS gf180mcu_as_sc_mcu7t3v3__fillcap_4
XFILLER_175_1320 VDD VDD VSS VSS gf180mcu_as_sc_mcu7t3v3__fill_2
XFILLER_49_1323 VDD VDD VSS VSS gf180mcu_as_sc_mcu7t3v3__fill_1
XFILLER_69_33 VDD VDD VSS VSS gf180mcu_as_sc_mcu7t3v3__fill_1
XFILLER_161_492 VDD VDD VSS VSS gf180mcu_as_sc_mcu7t3v3__fillcap_4
XFILLER_0_686 VDD VDD VSS VSS gf180mcu_as_sc_mcu7t3v3__fill_2
XFILLER_85_76 VDD VDD VSS VSS gf180mcu_as_sc_mcu7t3v3__fill_1
XFILLER_169_1135 VDD VDD VSS VSS gf180mcu_as_sc_mcu7t3v3__fillcap_16
XFILLER_189_802 VDD VDD VSS VSS gf180mcu_as_sc_mcu7t3v3__fill_1
XFILLER_188_312 VDD VDD VSS VSS gf180mcu_as_sc_mcu7t3v3__fill_2
XFILLER_189_835 VDD VDD VSS VSS gf180mcu_as_sc_mcu7t3v3__fillcap_4
XFILLER_189_846 VDD VDD VSS VSS gf180mcu_as_sc_mcu7t3v3__fill_1
XPHY_EDGE_ROW_108_1_Left_300 VDD VSS gf180mcu_as_sc_mcu7t3v3__tap_2
XFILLER_11_292 VDD VDD VSS VSS gf180mcu_as_sc_mcu7t3v3__fillcap_4
XFILLER_12_793 VDD VDD VSS VSS gf180mcu_as_sc_mcu7t3v3__fillcap_8
XFILLER_172_702 VDD VDD VSS VSS gf180mcu_as_sc_mcu7t3v3__fill_1
XFILLER_184_562 VDD VDD VSS VSS gf180mcu_as_sc_mcu7t3v3__fillcap_16
XFILLER_8_753 VDD VDD VSS VSS gf180mcu_as_sc_mcu7t3v3__fill_1
XFILLER_172_768 VDD VDD VSS VSS gf180mcu_as_sc_mcu7t3v3__fill_2
X_4380_ VDD VDD VSS VSS _4380_/B _4380_/A _5164_/D gf180mcu_as_sc_mcu7t3v3__and2_2
X_3400_ VDD VDD VSS VSS _3400_/B _3525_/A _4819_/D gf180mcu_as_sc_mcu7t3v3__and2_2
XFILLER_153_982 VDD VDD VSS VSS gf180mcu_as_sc_mcu7t3v3__fillcap_4
XFILLER_166_90 VDD VDD VSS VSS gf180mcu_as_sc_mcu7t3v3__fill_1
Xclkbuf_leaf_11_clk_regs VDD VDD VSS VSS clkbuf_leaf_9_clk_regs/A _5075_/CLK gf180mcu_as_sc_mcu7t3v3__clkbuff_12
X_3331_ VDD VDD VSS VSS _3981_/A _3372_/B _3331_/C _3331_/D _3332_/A gf180mcu_as_sc_mcu7t3v3__ao22_2
XFILLER_180_790 VDD VDD VSS VSS gf180mcu_as_sc_mcu7t3v3__fill_2
X_3262_ VDD VDD VSS VSS _3520_/B _3776_/A _3262_/Y gf180mcu_as_sc_mcu7t3v3__and2_2
XTAP_TAPCELL_ROW_168_1438 VDD VSS gf180mcu_as_sc_mcu7t3v3__tap_2
XFILLER_117_1292 VDD VDD VSS VSS gf180mcu_as_sc_mcu7t3v3__fillcap_8
X_5001_ VDD VDD VSS VSS _5175_/CLK _5001_/D _5001_/Q gf180mcu_as_sc_mcu7t3v3__dfxtp_2
X_3193_ VDD VDD VSS VSS _4163_/A _3207_/S _3193_/C _3193_/D _3194_/B gf180mcu_as_sc_mcu7t3v3__ao22_2
XTAP_TAPCELL_ROW_185_1763 VDD VSS gf180mcu_as_sc_mcu7t3v3__tap_2
XTAP_TAPCELL_ROW_185_1752 VDD VSS gf180mcu_as_sc_mcu7t3v3__tap_2
XFILLER_187_1224 VDD VDD VSS VSS gf180mcu_as_sc_mcu7t3v3__fillcap_16
XTAP_TAPCELL_ROW_68_1_1021 VDD VSS gf180mcu_as_sc_mcu7t3v3__tap_2
XFILLER_163_1290 VDD VDD VSS VSS gf180mcu_as_sc_mcu7t3v3__fillcap_8
X_2977_ VDD VDD VSS VSS _3045_/A _2977_/B _2977_/C _3045_/D _2979_/C gf180mcu_as_sc_mcu7t3v3__ao211_2
XFILLER_163_702 VDD VDD VSS VSS gf180mcu_as_sc_mcu7t3v3__fillcap_16
XFILLER_175_562 VDD VDD VSS VSS gf180mcu_as_sc_mcu7t3v3__fillcap_4
X_4716_ VDD VDD VSS VSS _4721_/A _4716_/B _5107_/Q _5260_/D gf180mcu_as_sc_mcu7t3v3__mux2_2
X_4647_ VDD VDD VSS VSS _5234_/D _4647_/A _4660_/A _4647_/C gf180mcu_as_sc_mcu7t3v3__ao21_2
X_4578_ VDD VDD VSS VSS _4581_/C _5000_/Q _4579_/S gf180mcu_as_sc_mcu7t3v3__nand2b_2
X_3529_ VDD VDD VSS VSS _3557_/B _3922_/B _3559_/A gf180mcu_as_sc_mcu7t3v3__nand2_2
XFILLER_83_1280 VDD VDD VSS VSS gf180mcu_as_sc_mcu7t3v3__fillcap_4
XFILLER_131_1256 VDD VDD VSS VSS gf180mcu_as_sc_mcu7t3v3__fillcap_4
XFILLER_170_1283 VDD VDD VSS VSS gf180mcu_as_sc_mcu7t3v3__fill_1
XFILLER_183_6 VDD VDD VSS VSS gf180mcu_as_sc_mcu7t3v3__fillcap_16
XTAP_TAPCELL_ROW_88_3_1999 VDD VSS gf180mcu_as_sc_mcu7t3v3__tap_2
XTAP_TAPCELL_ROW_5_789 VDD VSS gf180mcu_as_sc_mcu7t3v3__tap_2
XTAP_TAPCELL_ROW_5_778 VDD VSS gf180mcu_as_sc_mcu7t3v3__tap_2
XFILLER_131_1289 VDD VDD VSS VSS gf180mcu_as_sc_mcu7t3v3__fill_2
XFILLER_111_52 VDD VDD VSS VSS gf180mcu_as_sc_mcu7t3v3__fillcap_16
XFILLER_13_546 VDD VDD VSS VSS gf180mcu_as_sc_mcu7t3v3__fillcap_4
XFILLER_164_1087 VDD VDD VSS VSS gf180mcu_as_sc_mcu7t3v3__fillcap_8
XFILLER_186_849 VDD VDD VSS VSS gf180mcu_as_sc_mcu7t3v3__fill_1
XPHY_EDGE_ROW_111_1_Right_620 VDD VSS gf180mcu_as_sc_mcu7t3v3__tap_2
XFILLER_153_212 VDD VDD VSS VSS gf180mcu_as_sc_mcu7t3v3__fillcap_16
XFILLER_154_713 VDD VDD VSS VSS gf180mcu_as_sc_mcu7t3v3__fillcap_4
XFILLER_153_234 VDD VDD VSS VSS gf180mcu_as_sc_mcu7t3v3__fill_1
XFILLER_154_779 VDD VDD VSS VSS gf180mcu_as_sc_mcu7t3v3__fillcap_8
XFILLER_181_554 VDD VDD VSS VSS gf180mcu_as_sc_mcu7t3v3__fillcap_4
XPHY_EDGE_ROW_107_3_Left_479 VDD VSS gf180mcu_as_sc_mcu7t3v3__tap_2
XPHY_EDGE_ROW_41_3_Right_82 VDD VSS gf180mcu_as_sc_mcu7t3v3__tap_2
XFILLER_153_278 VDD VDD VSS VSS gf180mcu_as_sc_mcu7t3v3__fill_2
XFILLER_5_767 VDD VDD VSS VSS gf180mcu_as_sc_mcu7t3v3__fill_2
XFILLER_175_1150 VDD VDD VSS VSS gf180mcu_as_sc_mcu7t3v3__fill_1
XFILLER_20_93 VDD VDD VSS VSS gf180mcu_as_sc_mcu7t3v3__fillcap_8
XFILLER_171_1047 VDD VDD VSS VSS gf180mcu_as_sc_mcu7t3v3__fill_2
XFILLER_96_53 VDD VDD VSS VSS gf180mcu_as_sc_mcu7t3v3__fillcap_16
XPHY_EDGE_ROW_44_3_Left_416 VDD VSS gf180mcu_as_sc_mcu7t3v3__tap_2
XFILLER_0_450 VDD VDD VSS VSS gf180mcu_as_sc_mcu7t3v3__fill_1
XFILLER_62_1353 VDD VDD VSS VSS gf180mcu_as_sc_mcu7t3v3__fill_2
XFILLER_23_1326 VDD VDD VSS VSS gf180mcu_as_sc_mcu7t3v3__fillcap_4
XFILLER_110_1307 VDD VDD VSS VSS gf180mcu_as_sc_mcu7t3v3__fill_2
XFILLER_152_81 VDD VDD VSS VSS gf180mcu_as_sc_mcu7t3v3__fill_2
XFILLER_35_104 VDD VDD VSS VSS gf180mcu_as_sc_mcu7t3v3__fill_1
XTAP_TAPCELL_ROW_163_1346 VDD VSS gf180mcu_as_sc_mcu7t3v3__tap_2
XTAP_TAPCELL_ROW_163_1335 VDD VSS gf180mcu_as_sc_mcu7t3v3__tap_2
XTAP_TAPCELL_ROW_180_1671 VDD VSS gf180mcu_as_sc_mcu7t3v3__tap_2
XTAP_TAPCELL_ROW_180_1660 VDD VSS gf180mcu_as_sc_mcu7t3v3__tap_2
XFILLER_1_1188 VDD VDD VSS VSS gf180mcu_as_sc_mcu7t3v3__fill_2
X_2900_ VDD VDD VSS VSS _3247_/B _4946_/Q _4944_/Q gf180mcu_as_sc_mcu7t3v3__nand2_2
XFILLER_182_1165 VDD VDD VSS VSS gf180mcu_as_sc_mcu7t3v3__fillcap_4
XFILLER_189_687 VDD VDD VSS VSS gf180mcu_as_sc_mcu7t3v3__fill_2
X_3880_ VDD VDD VSS VSS _4946_/D _5170_/Q _4920_/D gf180mcu_as_sc_mcu7t3v3__and2_2
XFILLER_182_1198 VDD VDD VSS VSS gf180mcu_as_sc_mcu7t3v3__fill_2
X_2831_ VDD VDD VSS VSS _4952_/D _2831_/B _2831_/A _2832_/A gf180mcu_as_sc_mcu7t3v3__mux2_2
XTAP_TAPCELL_ROW_129_1_1082 VDD VSS gf180mcu_as_sc_mcu7t3v3__tap_2
XFILLER_157_562 VDD VDD VSS VSS gf180mcu_as_sc_mcu7t3v3__fill_1
X_2762_ VDD VDD VSS VSS _2764_/B _2810_/C _2810_/B gf180mcu_as_sc_mcu7t3v3__nand2_2
X_5481_ VDD VDD VSS VSS _5481_/A _5481_/Y gf180mcu_as_sc_mcu7t3v3__buff_2
X_4501_ VDD VDD VSS VSS _4502_/D _4501_/B _4502_/A gf180mcu_as_sc_mcu7t3v3__nor2_2
X_4432_ VDD VDD VSS VSS _4433_/D _4432_/B _4582_/A gf180mcu_as_sc_mcu7t3v3__nor2_2
X_2693_ VDD VDD VSS VSS _2723_/A _2693_/B _2693_/A _2693_/Y gf180mcu_as_sc_mcu7t3v3__mux2_2
XFILLER_119_1321 VDD VDD VSS VSS gf180mcu_as_sc_mcu7t3v3__fill_2
X_4363_ VDD VDD VSS VSS _4379_/B _4363_/B _5160_/Q _5160_/D gf180mcu_as_sc_mcu7t3v3__mux2_2
XTAP_TAPCELL_ROW_187_1803 VDD VSS gf180mcu_as_sc_mcu7t3v3__tap_2
XFILLER_67_1286 VDD VDD VSS VSS gf180mcu_as_sc_mcu7t3v3__fillcap_8
Xfanout507 VDD VDD VSS VSS _3739_/B fanout507/Y gf180mcu_as_sc_mcu7t3v3__buff_12
Xfanout529 VDD VDD VSS VSS _4523_/C _4540_/C gf180mcu_as_sc_mcu7t3v3__buff_12
X_4294_ VDD VDD VSS VSS _4294_/B _4294_/A _4295_/B gf180mcu_as_sc_mcu7t3v3__xnor2_2
X_3314_ VDD VDD VSS VSS _3419_/B _3968_/A _3315_/D gf180mcu_as_sc_mcu7t3v3__or2_2
XTAP_TAPCELL_ROW_101_3_2012 VDD VSS gf180mcu_as_sc_mcu7t3v3__tap_2
XFILLER_154_1267 VDD VDD VSS VSS gf180mcu_as_sc_mcu7t3v3__fill_1
XFILLER_154_1278 VDD VDD VSS VSS gf180mcu_as_sc_mcu7t3v3__fillcap_4
X_3245_ VDD VDD VSS VSS _3534_/A _3932_/A _3245_/C _3268_/A gf180mcu_as_sc_mcu7t3v3__nand3_2
Xmesh_tile_944 VDD VDD VSS VSS ne_out[18] gf180mcu_as_sc_mcu7t3v3__tiel_4
Xmesh_tile_933 VDD VDD VSS VSS ne_out[7] gf180mcu_as_sc_mcu7t3v3__tiel_4
Xmesh_tile_977 VDD VDD VSS VSS north_out[17] gf180mcu_as_sc_mcu7t3v3__tiel_4
Xmesh_tile_966 VDD VDD VSS VSS north_out[6] gf180mcu_as_sc_mcu7t3v3__tiel_4
Xmesh_tile_955 VDD VDD VSS VSS ne_out[29] gf180mcu_as_sc_mcu7t3v3__tiel_4
X_3176_ VDD VDD VSS VSS _3176_/S _4151_/A _4153_/A _3178_/B gf180mcu_as_sc_mcu7t3v3__mux2_2
XTAP_TAPCELL_ROW_2_737 VDD VSS gf180mcu_as_sc_mcu7t3v3__tap_2
XTAP_TAPCELL_ROW_2_726 VDD VSS gf180mcu_as_sc_mcu7t3v3__tap_2
Xmesh_tile_999 VDD VDD VSS VSS nw_out[5] gf180mcu_as_sc_mcu7t3v3__tiel_4
Xmesh_tile_988 VDD VDD VSS VSS north_out[28] gf180mcu_as_sc_mcu7t3v3__tiel_4
XPHY_EDGE_ROW_150_1_Right_659 VDD VSS gf180mcu_as_sc_mcu7t3v3__tap_2
XPHY_EDGE_ROW_90_3_Left_462 VDD VSS gf180mcu_as_sc_mcu7t3v3__tap_2
XFILLER_179_142 VDD VDD VSS VSS gf180mcu_as_sc_mcu7t3v3__fillcap_8
XFILLER_74_1268 VDD VDD VSS VSS gf180mcu_as_sc_mcu7t3v3__fill_2
Xwire908 VDD VDD VSS VSS wire908/A _3976_/D gf180mcu_as_sc_mcu7t3v3__clkbuff_12
XFILLER_176_893 VDD VDD VSS VSS gf180mcu_as_sc_mcu7t3v3__fillcap_8
XFILLER_11_1274 VDD VDD VSS VSS gf180mcu_as_sc_mcu7t3v3__fillcap_8
XFILLER_172_1301 VDD VDD VSS VSS gf180mcu_as_sc_mcu7t3v3__fill_2
XFILLER_2_737 VDD VDD VSS VSS gf180mcu_as_sc_mcu7t3v3__fill_2
XFILLER_173_69 VDD VDD VSS VSS gf180mcu_as_sc_mcu7t3v3__fill_1
XFILLER_2_759 VDD VDD VSS VSS gf180mcu_as_sc_mcu7t3v3__fillcap_8
XFILLER_46_1326 VDD VDD VSS VSS gf180mcu_as_sc_mcu7t3v3__fill_2
XFILLER_66_34 VDD VDD VSS VSS gf180mcu_as_sc_mcu7t3v3__fill_1
XFILLER_17_104 VDD VDD VSS VSS gf180mcu_as_sc_mcu7t3v3__fill_1
XTAP_TAPCELL_ROW_36_3_1947 VDD VSS gf180mcu_as_sc_mcu7t3v3__tap_2
XFILLER_186_613 VDD VDD VSS VSS gf180mcu_as_sc_mcu7t3v3__fillcap_16
XFILLER_13_376 VDD VDD VSS VSS gf180mcu_as_sc_mcu7t3v3__fillcap_8
XFILLER_185_189 VDD VDD VSS VSS gf180mcu_as_sc_mcu7t3v3__fill_2
XFILLER_12_1038 VDD VDD VSS VSS gf180mcu_as_sc_mcu7t3v3__fillcap_16
XPHY_EDGE_ROW_112_1_Right_621 VDD VSS gf180mcu_as_sc_mcu7t3v3__tap_2
XFILLER_31_92 VDD VDD VSS VSS gf180mcu_as_sc_mcu7t3v3__fill_2
XTAP_TAPCELL_ROW_9_870 VDD VSS gf180mcu_as_sc_mcu7t3v3__tap_2
XFILLER_163_80 VDD VDD VSS VSS gf180mcu_as_sc_mcu7t3v3__fill_2
XTAP_TAPCELL_ROW_182_1711 VDD VSS gf180mcu_as_sc_mcu7t3v3__tap_2
XTAP_TAPCELL_ROW_182_1700 VDD VSS gf180mcu_as_sc_mcu7t3v3__tap_2
Xinput170 VDD VDD VSS VSS nw_in[31] _3513_/A gf180mcu_as_sc_mcu7t3v3__buff_12
Xinput181 VDD VDD VSS VSS se_in[0] _3934_/A gf180mcu_as_sc_mcu7t3v3__buff_12
X_3030_ VDD VDD VSS VSS _3031_/C _3030_/C _3042_/C _4008_/D gf180mcu_as_sc_mcu7t3v3__aoi21_2
Xinput192 VDD VDD VSS VSS se_in[1] wire881/A gf180mcu_as_sc_mcu7t3v3__buff_12
X_4981_ VDD VDD VSS VSS _5095_/CLK _4981_/D _4981_/Q gf180mcu_as_sc_mcu7t3v3__dfxtp_2
X_3932_ VDD VDD VSS VSS _3932_/A _3932_/B _3932_/C _3932_/Y _3932_/D gf180mcu_as_sc_mcu7t3v3__aoi211_2
X_3863_ VDD VDD VSS VSS _5140_/Q _5139_/Q _3864_/C gf180mcu_as_sc_mcu7t3v3__or2_2
X_2814_ VDD VDD VSS VSS _2818_/S _2825_/B _4756_/Q _4755_/D gf180mcu_as_sc_mcu7t3v3__mux2_2
XFILLER_158_871 VDD VDD VSS VSS gf180mcu_as_sc_mcu7t3v3__fillcap_4
XFILLER_192_627 VDD VDD VSS VSS gf180mcu_as_sc_mcu7t3v3__fillcap_4
X_3794_ VDD VDD VSS VSS _3794_/S _3794_/B _3794_/A _3795_/B gf180mcu_as_sc_mcu7t3v3__mux2_2
XFILLER_69_1326 VDD VDD VSS VSS gf180mcu_as_sc_mcu7t3v3__fill_2
X_2745_ VDD VDD VSS VSS _2745_/B _2745_/A _2746_/B gf180mcu_as_sc_mcu7t3v3__xnor2_2
X_2676_ VDD VDD VSS VSS _2676_/A _2676_/B _2676_/C _2676_/D _2676_/Y gf180mcu_as_sc_mcu7t3v3__ao22_2
X_4415_ VDD VDD VSS VSS _4416_/D _4415_/B _4582_/A gf180mcu_as_sc_mcu7t3v3__nor2_2
X_4346_ VDD VDD VSS VSS _4379_/B _4346_/B _5157_/Q _5157_/D gf180mcu_as_sc_mcu7t3v3__mux2_2
XTAP_TAPCELL_ROW_7_829 VDD VSS gf180mcu_as_sc_mcu7t3v3__tap_2
XTAP_TAPCELL_ROW_7_818 VDD VSS gf180mcu_as_sc_mcu7t3v3__tap_2
XFILLER_154_1053 VDD VDD VSS VSS gf180mcu_as_sc_mcu7t3v3__fill_2
X_4277_ VDD VDD VSS VSS _4281_/S _4696_/B _5111_/Q _5111_/D gf180mcu_as_sc_mcu7t3v3__mux2_2
X_3228_ VDD VDD VSS VSS _3228_/B _3228_/A _3229_/D gf180mcu_as_sc_mcu7t3v3__or2_2
XFILLER_36_37 VDD VDD VSS VSS gf180mcu_as_sc_mcu7t3v3__fillcap_4
XFILLER_41_1256 VDD VDD VSS VSS gf180mcu_as_sc_mcu7t3v3__fillcap_16
X_3159_ VDD VDD VSS VSS _3176_/S _4135_/D _4138_/A _3161_/B gf180mcu_as_sc_mcu7t3v3__mux2_2
XFILLER_161_1024 VDD VDD VSS VSS gf180mcu_as_sc_mcu7t3v3__fill_2
XFILLER_168_613 VDD VDD VSS VSS gf180mcu_as_sc_mcu7t3v3__fillcap_16
XFILLER_10_313 VDD VDD VSS VSS gf180mcu_as_sc_mcu7t3v3__fill_2
XFILLER_167_134 VDD VDD VSS VSS gf180mcu_as_sc_mcu7t3v3__fillcap_4
XFILLER_6_317 VDD VDD VSS VSS gf180mcu_as_sc_mcu7t3v3__fill_1
XFILLER_163_340 VDD VDD VSS VSS gf180mcu_as_sc_mcu7t3v3__fillcap_8
XFILLER_117_62 VDD VDD VSS VSS gf180mcu_as_sc_mcu7t3v3__fillcap_8
XTAP_TAPCELL_ROW_91_1_1044 VDD VSS gf180mcu_as_sc_mcu7t3v3__tap_2
XFILLER_117_95 VDD VDD VSS VSS gf180mcu_as_sc_mcu7t3v3__fillcap_8
Xfanout871 VDD VDD VSS VSS _2736_/C _2675_/C gf180mcu_as_sc_mcu7t3v3__buff_12
Xfanout893 VDD VDD VSS VSS _3738_/D _3870_/A gf180mcu_as_sc_mcu7t3v3__buff_12
XFILLER_2_1294 VDD VDD VSS VSS gf180mcu_as_sc_mcu7t3v3__fill_1
XFILLER_158_101 VDD VDD VSS VSS gf180mcu_as_sc_mcu7t3v3__fillcap_4
XFILLER_183_1282 VDD VDD VSS VSS gf180mcu_as_sc_mcu7t3v3__fill_2
XFILLER_187_922 VDD VDD VSS VSS gf180mcu_as_sc_mcu7t3v3__fill_1
XFILLER_158_123 VDD VDD VSS VSS gf180mcu_as_sc_mcu7t3v3__fillcap_4
XFILLER_9_133 VDD VDD VSS VSS gf180mcu_as_sc_mcu7t3v3__fillcap_4
XTAP_TAPCELL_ROW_158_1245 VDD VSS gf180mcu_as_sc_mcu7t3v3__tap_2
XTAP_TAPCELL_ROW_158_1256 VDD VSS gf180mcu_as_sc_mcu7t3v3__tap_2
XTAP_TAPCELL_ROW_175_1570 VDD VSS gf180mcu_as_sc_mcu7t3v3__tap_2
XFILLER_170_800 VDD VDD VSS VSS gf180mcu_as_sc_mcu7t3v3__fillcap_4
XFILLER_170_811 VDD VDD VSS VSS gf180mcu_as_sc_mcu7t3v3__fill_1
XFILLER_6_873 VDD VDD VSS VSS gf180mcu_as_sc_mcu7t3v3__fill_2
XPHY_EDGE_ROW_113_1_Right_622 VDD VSS gf180mcu_as_sc_mcu7t3v3__tap_2
X_2530_ VDD VDD VSS VSS _2541_/B _2530_/B _2534_/B gf180mcu_as_sc_mcu7t3v3__nor2b_2
XFILLER_154_384 VDD VDD VSS VSS gf180mcu_as_sc_mcu7t3v3__fill_1
XFILLER_177_1064 VDD VDD VSS VSS gf180mcu_as_sc_mcu7t3v3__fillcap_4
XFILLER_182_693 VDD VDD VSS VSS gf180mcu_as_sc_mcu7t3v3__fillcap_8
XFILLER_6_895 VDD VDD VSS VSS gf180mcu_as_sc_mcu7t3v3__fill_1
X_2461_ VDD VDD VSS VSS _4341_/S _5032_/Q _5061_/Q _2462_/A gf180mcu_as_sc_mcu7t3v3__mux2_2
XTAP_TAPCELL_ROW_171_1489 VDD VSS gf180mcu_as_sc_mcu7t3v3__tap_2
XFILLER_170_877 VDD VDD VSS VSS gf180mcu_as_sc_mcu7t3v3__fillcap_16
XFILLER_177_1097 VDD VDD VSS VSS gf180mcu_as_sc_mcu7t3v3__fillcap_4
XFILLER_181_192 VDD VDD VSS VSS gf180mcu_as_sc_mcu7t3v3__fill_1
X_4200_ VDD VDD VSS VSS _4229_/B _4220_/B _4220_/C _5036_/Q _5036_/D gf180mcu_as_sc_mcu7t3v3__ao22_2
XPHY_EDGE_ROW_49_1_Left_241 VDD VSS gf180mcu_as_sc_mcu7t3v3__tap_2
XFILLER_155_1351 VDD VDD VSS VSS gf180mcu_as_sc_mcu7t3v3__fillcap_4
XFILLER_64_1256 VDD VDD VSS VSS gf180mcu_as_sc_mcu7t3v3__fillcap_16
X_5180_ VDD VDD VSS VSS _5181_/CLK _5180_/D _5180_/Q gf180mcu_as_sc_mcu7t3v3__dfxtp_2
X_2392_ VDD VDD VSS VSS _3847_/A _4913_/Q gf180mcu_as_sc_mcu7t3v3__inv_2
XPHY_EDGE_ROW_101_1_Left_293 VDD VSS gf180mcu_as_sc_mcu7t3v3__tap_2
X_4131_ VDD VDD VSS VSS _4132_/D _4131_/C _4155_/B _4131_/A gf180mcu_as_sc_mcu7t3v3__aoi21_2
XFILLER_99_1319 VDD VDD VSS VSS gf180mcu_as_sc_mcu7t3v3__fillcap_4
X_4062_ VDD VDD VSS VSS _4101_/C _4062_/A _4063_/D gf180mcu_as_sc_mcu7t3v3__and2_2
X_3013_ VDD VDD VSS VSS _3992_/D _3042_/C _3013_/C _3013_/D _3014_/B gf180mcu_as_sc_mcu7t3v3__ao211_2
X_4964_ VDD VDD VSS VSS _5232_/CLK _4964_/D _4964_/Q gf180mcu_as_sc_mcu7t3v3__dfxtp_2
X_3915_ VDD VDD VSS VSS _3931_/B _3932_/D _3915_/A gf180mcu_as_sc_mcu7t3v3__nor2_2
X_4895_ VDD VDD VSS VSS _4895_/CLK _4895_/D _4895_/Q gf180mcu_as_sc_mcu7t3v3__dfxtp_2
X_3846_ VDD VDD VSS VSS _3847_/B _3847_/A _3846_/B _4914_/Q gf180mcu_as_sc_mcu7t3v3__aoi21_2
XFILLER_192_457 VDD VDD VSS VSS gf180mcu_as_sc_mcu7t3v3__fillcap_4
X_3777_ VDD VDD VSS VSS _3792_/D _4160_/D _3777_/B _3799_/D _3779_/C gf180mcu_as_sc_mcu7t3v3__ao31_2
XFILLER_161_800 VDD VDD VSS VSS gf180mcu_as_sc_mcu7t3v3__fill_2
X_2728_ VDD VDD VSS VSS _2735_/A _2728_/B _2728_/C _2735_/D _2730_/C gf180mcu_as_sc_mcu7t3v3__ao211_2
XFILLER_160_332 VDD VDD VSS VSS gf180mcu_as_sc_mcu7t3v3__fillcap_16
Xoutput452 VDD VDD VSS VSS _4905_/Q west_out[32] gf180mcu_as_sc_mcu7t3v3__buff_12
Xoutput441 VDD VDD VSS VSS _4895_/Q west_out[22] gf180mcu_as_sc_mcu7t3v3__buff_12
Xoutput430 VDD VDD VSS VSS _4885_/Q west_out[12] gf180mcu_as_sc_mcu7t3v3__buff_12
X_2659_ VDD VDD VSS VSS _2659_/S _2659_/B _5266_/Q _2662_/C gf180mcu_as_sc_mcu7t3v3__mux2_2
XFILLER_160_387 VDD VDD VSS VSS gf180mcu_as_sc_mcu7t3v3__fillcap_8
X_4329_ VDD VDD VSS VSS _4331_/D _4371_/B _4371_/A _4329_/A gf180mcu_as_sc_mcu7t3v3__aoi21b_2
XFILLER_103_53 VDD VDD VSS VSS gf180mcu_as_sc_mcu7t3v3__fillcap_4
XFILLER_167_1233 VDD VDD VSS VSS gf180mcu_as_sc_mcu7t3v3__fillcap_16
XFILLER_103_86 VDD VDD VSS VSS gf180mcu_as_sc_mcu7t3v3__fill_1
XPHY_EDGE_ROW_116_3_Left_488 VDD VSS gf180mcu_as_sc_mcu7t3v3__tap_2
XPHY_EDGE_ROW_50_3_Right_91 VDD VSS gf180mcu_as_sc_mcu7t3v3__tap_2
XFILLER_169_944 VDD VDD VSS VSS gf180mcu_as_sc_mcu7t3v3__fillcap_4
XFILLER_168_454 VDD VDD VSS VSS gf180mcu_as_sc_mcu7t3v3__fill_1
XPHY_EDGE_ROW_53_3_Left_425 VDD VSS gf180mcu_as_sc_mcu7t3v3__tap_2
XFILLER_11_677 VDD VDD VSS VSS gf180mcu_as_sc_mcu7t3v3__fillcap_16
XFILLER_11_699 VDD VDD VSS VSS gf180mcu_as_sc_mcu7t3v3__fill_1
XFILLER_184_958 VDD VDD VSS VSS gf180mcu_as_sc_mcu7t3v3__fillcap_8
XFILLER_104_1272 VDD VDD VSS VSS gf180mcu_as_sc_mcu7t3v3__fillcap_4
XFILLER_13_1155 VDD VDD VSS VSS gf180mcu_as_sc_mcu7t3v3__fill_1
XFILLER_155_159 VDD VDD VSS VSS gf180mcu_as_sc_mcu7t3v3__fillcap_4
XFILLER_170_107 VDD VDD VSS VSS gf180mcu_as_sc_mcu7t3v3__fillcap_16
XFILLER_183_479 VDD VDD VSS VSS gf180mcu_as_sc_mcu7t3v3__fillcap_8
XFILLER_152_811 VDD VDD VSS VSS gf180mcu_as_sc_mcu7t3v3__fillcap_4
XFILLER_152_822 VDD VDD VSS VSS gf180mcu_as_sc_mcu7t3v3__fill_2
XFILLER_164_671 VDD VDD VSS VSS gf180mcu_as_sc_mcu7t3v3__fill_1
XFILLER_87_1256 VDD VDD VSS VSS gf180mcu_as_sc_mcu7t3v3__fillcap_16
XTAP_TAPCELL_ROW_153_1153 VDD VSS gf180mcu_as_sc_mcu7t3v3__tap_2
XFILLER_152_866 VDD VDD VSS VSS gf180mcu_as_sc_mcu7t3v3__fillcap_16
XFILLER_88_32 VDD VDD VSS VSS gf180mcu_as_sc_mcu7t3v3__fill_2
XFILLER_88_43 VDD VDD VSS VSS gf180mcu_as_sc_mcu7t3v3__fill_1
XPHY_EDGE_ROW_157_Right_19 VDD VSS gf180mcu_as_sc_mcu7t3v3__tap_2
Xfanout690 VDD VDD VSS VSS _3727_/C _3649_/C gf180mcu_as_sc_mcu7t3v3__buff_12
XFILLER_59_1314 VDD VDD VSS VSS gf180mcu_as_sc_mcu7t3v3__fill_1
Xclkbuf_leaf_36_clk_regs VDD VDD VSS VSS clkbuf_leaf_7_clk_regs/A clkload7/A gf180mcu_as_sc_mcu7t3v3__clkbuff_12
X_4879__1089 VDD VDD VSS VSS _4879_/D gf180mcu_as_sc_mcu7t3v3__tiel_4
XPHY_EDGE_ROW_166_Right_28 VDD VSS gf180mcu_as_sc_mcu7t3v3__tap_2
XTAP_TAPCELL_ROW_177_1610 VDD VSS gf180mcu_as_sc_mcu7t3v3__tap_2
X_3700_ VDD VDD VSS VSS _4080_/A _3779_/B _3748_/C _4079_/A _3701_/C gf180mcu_as_sc_mcu7t3v3__ao22_2
XFILLER_159_487 VDD VDD VSS VSS gf180mcu_as_sc_mcu7t3v3__fill_2
XFILLER_186_273 VDD VDD VSS VSS gf180mcu_as_sc_mcu7t3v3__fillcap_16
X_4680_ VDD VDD VSS VSS _5247_/D _5101_/Q _4700_/S _4680_/C gf180mcu_as_sc_mcu7t3v3__ao21_2
XFILLER_70_1282 VDD VDD VSS VSS gf180mcu_as_sc_mcu7t3v3__fillcap_4
X_3631_ VDD VDD VSS VSS _4003_/A _3723_/B _3631_/C _3631_/Y _3699_/D gf180mcu_as_sc_mcu7t3v3__aoi211_2
XTAP_TAPCELL_ROW_173_1529 VDD VSS gf180mcu_as_sc_mcu7t3v3__tap_2
XFILLER_174_457 VDD VDD VSS VSS gf180mcu_as_sc_mcu7t3v3__fillcap_8
XFILLER_190_906 VDD VDD VSS VSS gf180mcu_as_sc_mcu7t3v3__fill_2
X_3562_ VDD VDD VSS VSS _3562_/Y _3562_/B _3562_/A gf180mcu_as_sc_mcu7t3v3__nor2b_2
XTAP_TAPCELL_ROW_190_1854 VDD VSS gf180mcu_as_sc_mcu7t3v3__tap_2
XFILLER_155_671 VDD VDD VSS VSS gf180mcu_as_sc_mcu7t3v3__fill_1
XFILLER_161_107 VDD VDD VSS VSS gf180mcu_as_sc_mcu7t3v3__fill_1
X_2513_ VDD VDD VSS VSS _2845_/D _2747_/A _2847_/A _4663_/A gf180mcu_as_sc_mcu7t3v3__nand3_2
XTAP_TAPCELL_ROW_190_1865 VDD VSS gf180mcu_as_sc_mcu7t3v3__tap_2
XPHY_EDGE_ROW_175_Right_37 VDD VSS gf180mcu_as_sc_mcu7t3v3__tap_2
XPHY_EDGE_ROW_114_1_Right_623 VDD VSS gf180mcu_as_sc_mcu7t3v3__tap_2
X_3493_ VDD VDD VSS VSS _4942_/Q _3493_/B _3493_/C _4152_/A _3495_/C gf180mcu_as_sc_mcu7t3v3__ao22_2
XFILLER_170_696 VDD VDD VSS VSS gf180mcu_as_sc_mcu7t3v3__fill_2
X_5232_ VDD VDD VSS VSS _5232_/CLK _5232_/D _5232_/Q gf180mcu_as_sc_mcu7t3v3__dfxtp_2
X_2444_ VDD VDD VSS VSS _4115_/A _2444_/A gf180mcu_as_sc_mcu7t3v3__inv_2
X_5163_ VDD VDD VSS VSS _5164_/CLK _5163_/D _5163_/Q gf180mcu_as_sc_mcu7t3v3__dfxtp_2
X_4114_ VDD VDD VSS VSS _4115_/D _4114_/C _4163_/B _4114_/A gf180mcu_as_sc_mcu7t3v3__aoi21_2
X_5094_ VDD VDD VSS VSS _5095_/CLK _5094_/D _5094_/Q gf180mcu_as_sc_mcu7t3v3__dfxtp_2
X_4045_ VDD VDD VSS VSS _4045_/A _4102_/B _4102_/C _4929_/Q _4047_/C gf180mcu_as_sc_mcu7t3v3__ao22_2
XPHY_EDGE_ROW_184_Right_46 VDD VSS gf180mcu_as_sc_mcu7t3v3__tap_2
XFILLER_162_1141 VDD VDD VSS VSS gf180mcu_as_sc_mcu7t3v3__fill_2
XFILLER_166_903 VDD VDD VSS VSS gf180mcu_as_sc_mcu7t3v3__fill_1
XFILLER_178_730 VDD VDD VSS VSS gf180mcu_as_sc_mcu7t3v3__fillcap_4
X_4947_ VDD VDD VSS VSS _5203_/CLK _4947_/D _4947_/Q gf180mcu_as_sc_mcu7t3v3__dfxtp_2
XFILLER_137_104 VDD VDD VSS VSS gf180mcu_as_sc_mcu7t3v3__fill_1
XFILLER_178_796 VDD VDD VSS VSS gf180mcu_as_sc_mcu7t3v3__fill_1
X_4878_ VDD VDD VSS VSS clkload4/A _4878_/D _4878_/Q gf180mcu_as_sc_mcu7t3v3__dfxtp_2
XFILLER_165_435 VDD VDD VSS VSS gf180mcu_as_sc_mcu7t3v3__fillcap_8
XFILLER_166_947 VDD VDD VSS VSS gf180mcu_as_sc_mcu7t3v3__fillcap_4
XFILLER_192_210 VDD VDD VSS VSS gf180mcu_as_sc_mcu7t3v3__fill_2
X_3829_ VDD VDD VSS VSS _4752_/B _3835_/B _4909_/Q gf180mcu_as_sc_mcu7t3v3__nor2_2
XFILLER_165_468 VDD VDD VSS VSS gf180mcu_as_sc_mcu7t3v3__fill_2
XFILLER_180_405 VDD VDD VSS VSS gf180mcu_as_sc_mcu7t3v3__fill_1
XFILLER_152_129 VDD VDD VSS VSS gf180mcu_as_sc_mcu7t3v3__fillcap_4
XFILLER_0_857 VDD VDD VSS VSS gf180mcu_as_sc_mcu7t3v3__fill_2
XFILLER_160_173 VDD VDD VSS VSS gf180mcu_as_sc_mcu7t3v3__fill_2
XFILLER_134_1287 VDD VDD VSS VSS gf180mcu_as_sc_mcu7t3v3__fill_2
XTAP_TAPCELL_ROW_100_1_1053 VDD VSS gf180mcu_as_sc_mcu7t3v3__tap_2
XFILLER_167_1052 VDD VDD VSS VSS gf180mcu_as_sc_mcu7t3v3__fillcap_4
XFILLER_188_505 VDD VDD VSS VSS gf180mcu_as_sc_mcu7t3v3__fill_1
XFILLER_188_527 VDD VDD VSS VSS gf180mcu_as_sc_mcu7t3v3__fillcap_4
XFILLER_169_730 VDD VDD VSS VSS gf180mcu_as_sc_mcu7t3v3__fillcap_16
XFILLER_168_251 VDD VDD VSS VSS gf180mcu_as_sc_mcu7t3v3__fill_1
XFILLER_139_82 VDD VDD VSS VSS gf180mcu_as_sc_mcu7t3v3__fillcap_16
XFILLER_156_457 VDD VDD VSS VSS gf180mcu_as_sc_mcu7t3v3__fillcap_8
XFILLER_8_979 VDD VDD VSS VSS gf180mcu_as_sc_mcu7t3v3__fillcap_8
XFILLER_184_799 VDD VDD VSS VSS gf180mcu_as_sc_mcu7t3v3__fillcap_4
XFILLER_152_630 VDD VDD VSS VSS gf180mcu_as_sc_mcu7t3v3__fillcap_16
XFILLER_178_1192 VDD VDD VSS VSS gf180mcu_as_sc_mcu7t3v3__fillcap_8
XTAP_TAPCELL_ROW_166_1399 VDD VSS gf180mcu_as_sc_mcu7t3v3__tap_2
XFILLER_0_31 VDD VDD VSS VSS gf180mcu_as_sc_mcu7t3v3__fill_2
XFILLER_185_1185 VDD VDD VSS VSS gf180mcu_as_sc_mcu7t3v3__fillcap_4
X_4801_ VDD VDD VSS VSS _5226_/CLK _4801_/D _4801_/Q gf180mcu_as_sc_mcu7t3v3__dfxtp_2
X_2993_ VDD VDD VSS VSS _3974_/A _3044_/B _3044_/C _3973_/D _2994_/C gf180mcu_as_sc_mcu7t3v3__ao22_2
XFILLER_9_62 VDD VDD VSS VSS gf180mcu_as_sc_mcu7t3v3__fillcap_8
X_4732_ VDD VDD VSS VSS _5267_/D _4732_/A _4732_/B _4732_/C gf180mcu_as_sc_mcu7t3v3__ao21_2
XTAP_TAPCELL_ROW_192_1905 VDD VSS gf180mcu_as_sc_mcu7t3v3__tap_2
X_4663_ VDD VDD VSS VSS _4666_/B _4708_/C _4663_/B _4663_/A gf180mcu_as_sc_mcu7t3v3__aoi21_2
XTAP_TAPCELL_ROW_192_1916 VDD VSS gf180mcu_as_sc_mcu7t3v3__tap_2
XFILLER_163_928 VDD VDD VSS VSS gf180mcu_as_sc_mcu7t3v3__fillcap_8
XFILLER_175_755 VDD VDD VSS VSS gf180mcu_as_sc_mcu7t3v3__fillcap_8
X_3614_ VDD VDD VSS VSS _3615_/C _3614_/C _3653_/B _3985_/A gf180mcu_as_sc_mcu7t3v3__aoi21_2
Xmax_cap621 VDD VDD VSS VSS _2699_/D _4262_/B gf180mcu_as_sc_mcu7t3v3__clkbuff_12
X_4594_ VDD VDD VSS VSS _4594_/Y _4742_/C _4594_/A gf180mcu_as_sc_mcu7t3v3__nor2_2
XFILLER_157_1210 VDD VDD VSS VSS gf180mcu_as_sc_mcu7t3v3__fillcap_8
XFILLER_192_1101 VDD VDD VSS VSS gf180mcu_as_sc_mcu7t3v3__fill_2
X_3545_ VDD VDD VSS VSS _3563_/B _3797_/C _3798_/A gf180mcu_as_sc_mcu7t3v3__nand2_2
XFILLER_171_994 VDD VDD VSS VSS gf180mcu_as_sc_mcu7t3v3__fill_1
XPHY_EDGE_ROW_115_1_Right_624 VDD VSS gf180mcu_as_sc_mcu7t3v3__tap_2
X_3476_ VDD VDD VSS VSS _4131_/A _3523_/B _3476_/C _3477_/C _3476_/D gf180mcu_as_sc_mcu7t3v3__aoi211_2
XFILLER_153_1118 VDD VDD VSS VSS gf180mcu_as_sc_mcu7t3v3__fill_2
XFILLER_192_1167 VDD VDD VSS VSS gf180mcu_as_sc_mcu7t3v3__fillcap_4
XFILLER_192_1189 VDD VDD VSS VSS gf180mcu_as_sc_mcu7t3v3__fill_1
XFILLER_9_1020 VDD VDD VSS VSS gf180mcu_as_sc_mcu7t3v3__fillcap_4
X_5215_ VDD VDD VSS VSS _5216_/CLK _5215_/D _5215_/Q gf180mcu_as_sc_mcu7t3v3__dfxtp_2
X_2427_ VDD VDD VSS VSS _3971_/A _2427_/A gf180mcu_as_sc_mcu7t3v3__inv_2
X_5146_ VDD VDD VSS VSS _5150_/CLK _5146_/D _5146_/Q gf180mcu_as_sc_mcu7t3v3__dfxtp_2
X_5077_ VDD VDD VSS VSS _5089_/CLK _5077_/D _5077_/Q gf180mcu_as_sc_mcu7t3v3__dfxtp_2
X_4028_ VDD VDD VSS VSS _4989_/Q _4076_/B _4240_/B _4076_/D _4989_/D gf180mcu_as_sc_mcu7t3v3__ao22_2
XFILLER_129_1312 VDD VDD VSS VSS gf180mcu_as_sc_mcu7t3v3__fill_1
XTAP_TAPCELL_ROW_0_665 VDD VSS gf180mcu_as_sc_mcu7t3v3__tap_2
XFILLER_44_37 VDD VDD VSS VSS gf180mcu_as_sc_mcu7t3v3__fill_1
XTAP_TAPCELL_ROW_0_698 VDD VSS gf180mcu_as_sc_mcu7t3v3__tap_2
XTAP_TAPCELL_ROW_0_687 VDD VSS gf180mcu_as_sc_mcu7t3v3__tap_2
XTAP_TAPCELL_ROW_0_676 VDD VSS gf180mcu_as_sc_mcu7t3v3__tap_2
XFILLER_12_216 VDD VDD VSS VSS gf180mcu_as_sc_mcu7t3v3__fill_1
XFILLER_164_1269 VDD VDD VSS VSS gf180mcu_as_sc_mcu7t3v3__fillcap_4
Xsram2048.u_bank1_926 VDD VDD VSS VSS sram2048.u_bank1/WEN[7] gf180mcu_as_sc_mcu7t3v3__tiel_4
XFILLER_100_43 VDD VDD VSS VSS gf180mcu_as_sc_mcu7t3v3__fill_1
XFILLER_185_519 VDD VDD VSS VSS gf180mcu_as_sc_mcu7t3v3__fillcap_16
XFILLER_100_87 VDD VDD VSS VSS gf180mcu_as_sc_mcu7t3v3__fillcap_16
XTAP_TAPCELL_ROW_11_907 VDD VSS gf180mcu_as_sc_mcu7t3v3__tap_2
XFILLER_140_1291 VDD VDD VSS VSS gf180mcu_as_sc_mcu7t3v3__fill_2
XFILLER_175_1332 VDD VDD VSS VSS gf180mcu_as_sc_mcu7t3v3__fillcap_16
XFILLER_125_62 VDD VDD VSS VSS gf180mcu_as_sc_mcu7t3v3__fill_1
XFILLER_18_71 VDD VDD VSS VSS gf180mcu_as_sc_mcu7t3v3__fillcap_8
XFILLER_85_88 VDD VDD VSS VSS gf180mcu_as_sc_mcu7t3v3__fillcap_4
XFILLER_141_72 VDD VDD VSS VSS gf180mcu_as_sc_mcu7t3v3__fillcap_4
XFILLER_169_1169 VDD VDD VSS VSS gf180mcu_as_sc_mcu7t3v3__fillcap_16
XTAP_TAPCELL_ROW_97_3_2008 VDD VSS gf180mcu_as_sc_mcu7t3v3__tap_2
XFILLER_188_357 VDD VDD VSS VSS gf180mcu_as_sc_mcu7t3v3__fillcap_8
XTAP_TAPCELL_ROW_161_1296 VDD VSS gf180mcu_as_sc_mcu7t3v3__tap_2
XPHY_EDGE_ROW_58_1_Left_250 VDD VSS gf180mcu_as_sc_mcu7t3v3__tap_2
XFILLER_12_750 VDD VDD VSS VSS gf180mcu_as_sc_mcu7t3v3__fill_2
XFILLER_157_744 VDD VDD VSS VSS gf180mcu_as_sc_mcu7t3v3__fillcap_16
XFILLER_8_765 VDD VDD VSS VSS gf180mcu_as_sc_mcu7t3v3__fillcap_4
XFILLER_157_788 VDD VDD VSS VSS gf180mcu_as_sc_mcu7t3v3__fillcap_4
XFILLER_172_714 VDD VDD VSS VSS gf180mcu_as_sc_mcu7t3v3__fill_2
XFILLER_8_798 VDD VDD VSS VSS gf180mcu_as_sc_mcu7t3v3__fillcap_4
XFILLER_160_909 VDD VDD VSS VSS gf180mcu_as_sc_mcu7t3v3__fillcap_16
XFILLER_171_224 VDD VDD VSS VSS gf180mcu_as_sc_mcu7t3v3__fillcap_8
XFILLER_171_279 VDD VDD VSS VSS gf180mcu_as_sc_mcu7t3v3__fill_1
X_3330_ VDD VDD VSS VSS _3419_/B _3983_/A _3331_/D gf180mcu_as_sc_mcu7t3v3__or2_2
XFILLER_152_482 VDD VDD VSS VSS gf180mcu_as_sc_mcu7t3v3__fill_2
X_5000_ VDD VDD VSS VSS clkload9/A _5000_/D _5000_/Q gf180mcu_as_sc_mcu7t3v3__dfxtp_2
X_3261_ VDD VDD VSS VSS _3263_/B _3261_/B _3776_/A gf180mcu_as_sc_mcu7t3v3__nand2_2
XTAP_TAPCELL_ROW_168_1439 VDD VSS gf180mcu_as_sc_mcu7t3v3__tap_2
X_3192_ VDD VDD VSS VSS _3193_/D _3192_/A _3206_/B _3192_/C _3192_/D gf180mcu_as_sc_mcu7t3v3__aoi22_2
XTAP_TAPCELL_ROW_185_1753 VDD VSS gf180mcu_as_sc_mcu7t3v3__tap_2
XTAP_TAPCELL_ROW_185_1764 VDD VSS gf180mcu_as_sc_mcu7t3v3__tap_2
XTAP_TAPCELL_ROW_54_3_1965 VDD VSS gf180mcu_as_sc_mcu7t3v3__tap_2
XPHY_EDGE_ROW_130_3_Left_502 VDD VSS gf180mcu_as_sc_mcu7t3v3__tap_2
XFILLER_37_1272 VDD VDD VSS VSS gf180mcu_as_sc_mcu7t3v3__fillcap_4
X_2976_ VDD VDD VSS VSS _3959_/A _3044_/B _3044_/C _3958_/A _2977_/C gf180mcu_as_sc_mcu7t3v3__ao22_2
X_4715_ VDD VDD VSS VSS _4717_/S _5260_/Q _5261_/Q _4716_/B gf180mcu_as_sc_mcu7t3v3__mux2_2
X_4646_ VDD VDD VSS VSS _4646_/D _4733_/A _5235_/Q _4646_/C _4647_/C gf180mcu_as_sc_mcu7t3v3__ao31_2
XPHY_EDGE_ROW_100_3_Right_141 VDD VSS gf180mcu_as_sc_mcu7t3v3__tap_2
X_4577_ VDD VDD VSS VSS _4581_/B _5087_/Q _4579_/S gf180mcu_as_sc_mcu7t3v3__nand2_2
X_3528_ VDD VDD VSS VSS _3922_/B _3528_/B _3528_/A gf180mcu_as_sc_mcu7t3v3__nor2b_2
XPHY_EDGE_ROW_125_3_Left_497 VDD VSS gf180mcu_as_sc_mcu7t3v3__tap_2
XPHY_EDGE_ROW_116_1_Right_625 VDD VSS gf180mcu_as_sc_mcu7t3v3__tap_2
X_4874__1094 VDD VDD VSS VSS _4874_/D gf180mcu_as_sc_mcu7t3v3__tiel_4
X_3459_ VDD VDD VSS VSS _3460_/A _4109_/D _3500_/B _3459_/C gf180mcu_as_sc_mcu7t3v3__ao21_2
XFILLER_170_1251 VDD VDD VSS VSS gf180mcu_as_sc_mcu7t3v3__fillcap_4
X_5129_ VDD VDD VSS VSS _5216_/CLK _5129_/D _5129_/Q gf180mcu_as_sc_mcu7t3v3__dfxtp_2
XTAP_TAPCELL_ROW_5_779 VDD VSS gf180mcu_as_sc_mcu7t3v3__tap_2
XPHY_EDGE_ROW_62_3_Left_434 VDD VSS gf180mcu_as_sc_mcu7t3v3__tap_2
XFILLER_176_6 VDD VDD VSS VSS gf180mcu_as_sc_mcu7t3v3__fillcap_16
XFILLER_164_1033 VDD VDD VSS VSS gf180mcu_as_sc_mcu7t3v3__fill_1
XFILLER_164_1077 VDD VDD VSS VSS gf180mcu_as_sc_mcu7t3v3__fillcap_8
XFILLER_185_349 VDD VDD VSS VSS gf180mcu_as_sc_mcu7t3v3__fill_1
XFILLER_103_1326 VDD VDD VSS VSS gf180mcu_as_sc_mcu7t3v3__fill_2
XFILLER_166_541 VDD VDD VSS VSS gf180mcu_as_sc_mcu7t3v3__fillcap_4
XFILLER_181_500 VDD VDD VSS VSS gf180mcu_as_sc_mcu7t3v3__fillcap_4
XFILLER_5_702 VDD VDD VSS VSS gf180mcu_as_sc_mcu7t3v3__fillcap_16
XFILLER_161_290 VDD VDD VSS VSS gf180mcu_as_sc_mcu7t3v3__fillcap_4
XFILLER_62_1332 VDD VDD VSS VSS gf180mcu_as_sc_mcu7t3v3__fill_1
XTAP_TAPCELL_ROW_163_1347 VDD VSS gf180mcu_as_sc_mcu7t3v3__tap_2
XTAP_TAPCELL_ROW_163_1336 VDD VSS gf180mcu_as_sc_mcu7t3v3__tap_2
XTAP_TAPCELL_ROW_180_1672 VDD VSS gf180mcu_as_sc_mcu7t3v3__tap_2
XTAP_TAPCELL_ROW_180_1661 VDD VSS gf180mcu_as_sc_mcu7t3v3__tap_2
XFILLER_189_644 VDD VDD VSS VSS gf180mcu_as_sc_mcu7t3v3__fillcap_4
XFILLER_189_655 VDD VDD VSS VSS gf180mcu_as_sc_mcu7t3v3__fill_1
XFILLER_147_1264 VDD VDD VSS VSS gf180mcu_as_sc_mcu7t3v3__fillcap_4
X_2830_ VDD VDD VSS VSS _4751_/A _2830_/B _5285_/Q _5284_/D gf180mcu_as_sc_mcu7t3v3__mux2_2
XFILLER_177_839 VDD VDD VSS VSS gf180mcu_as_sc_mcu7t3v3__fill_1
XFILLER_77_4 VDD VDD VSS VSS gf180mcu_as_sc_mcu7t3v3__fill_1
X_2761_ VDD VDD VSS VSS _4691_/A _2766_/B _2766_/C _2761_/D _2810_/C gf180mcu_as_sc_mcu7t3v3__ao211_2
X_5480_ VDD VDD VSS VSS _5480_/A _5480_/Y gf180mcu_as_sc_mcu7t3v3__buff_2
X_4500_ VDD VDD VSS VSS _4500_/S _5020_/Q _5049_/Q _4501_/B gf180mcu_as_sc_mcu7t3v3__mux2_2
X_2692_ VDD VDD VSS VSS _2701_/A _2692_/B _2692_/A _2693_/A gf180mcu_as_sc_mcu7t3v3__mux2_2
XANTENNA_1 VDD VDD VSS VSS _4772_/D gf180mcu_as_sc_mcu7t3v3__diode_2
X_4431_ VDD VDD VSS VSS _4431_/D _4560_/A _4431_/B _4431_/C _4432_/B gf180mcu_as_sc_mcu7t3v3__ao31_2
XFILLER_172_566 VDD VDD VSS VSS gf180mcu_as_sc_mcu7t3v3__fill_1
XFILLER_153_791 VDD VDD VSS VSS gf180mcu_as_sc_mcu7t3v3__fillcap_16
XFILLER_6_96 VDD VDD VSS VSS gf180mcu_as_sc_mcu7t3v3__fillcap_8
X_4362_ VDD VDD VSS VSS _4363_/B _4362_/C _4362_/B _4573_/A gf180mcu_as_sc_mcu7t3v3__ao21b_2
XTAP_TAPCELL_ROW_187_1804 VDD VSS gf180mcu_as_sc_mcu7t3v3__tap_2
XFILLER_152_290 VDD VDD VSS VSS gf180mcu_as_sc_mcu7t3v3__fillcap_8
XFILLER_154_1235 VDD VDD VSS VSS gf180mcu_as_sc_mcu7t3v3__fillcap_4
XFILLER_154_1257 VDD VDD VSS VSS gf180mcu_as_sc_mcu7t3v3__fill_1
X_4293_ VDD VDD VSS VSS _4297_/S _5125_/Q _5126_/Q _5125_/D gf180mcu_as_sc_mcu7t3v3__mux2_2
X_3313_ VDD VDD VSS VSS _3968_/D _3370_/B _3313_/C _3386_/D _3315_/C gf180mcu_as_sc_mcu7t3v3__ao211_2
X_3244_ VDD VDD VSS VSS _3932_/A _3534_/A _3818_/B gf180mcu_as_sc_mcu7t3v3__and2_2
Xmesh_tile_945 VDD VDD VSS VSS ne_out[19] gf180mcu_as_sc_mcu7t3v3__tiel_4
Xmesh_tile_934 VDD VDD VSS VSS ne_out[8] gf180mcu_as_sc_mcu7t3v3__tiel_4
XFILLER_132_19 VDD VDD VSS VSS gf180mcu_as_sc_mcu7t3v3__fillcap_4
Xmesh_tile_978 VDD VDD VSS VSS north_out[18] gf180mcu_as_sc_mcu7t3v3__tiel_4
Xmesh_tile_967 VDD VDD VSS VSS north_out[7] gf180mcu_as_sc_mcu7t3v3__tiel_4
Xmesh_tile_956 VDD VDD VSS VSS ne_out[30] gf180mcu_as_sc_mcu7t3v3__tiel_4
X_3175_ VDD VDD VSS VSS _4154_/A _3240_/B _3239_/A _4154_/D _3181_/B gf180mcu_as_sc_mcu7t3v3__ao22_2
XTAP_TAPCELL_ROW_2_738 VDD VSS gf180mcu_as_sc_mcu7t3v3__tap_2
XTAP_TAPCELL_ROW_2_727 VDD VSS gf180mcu_as_sc_mcu7t3v3__tap_2
Xmesh_tile_989 VDD VDD VSS VSS north_out[29] gf180mcu_as_sc_mcu7t3v3__tiel_4
XFILLER_167_349 VDD VDD VSS VSS gf180mcu_as_sc_mcu7t3v3__fill_1
XFILLER_41_27 VDD VDD VSS VSS gf180mcu_as_sc_mcu7t3v3__fillcap_4
Xwire909 VDD VDD VSS VSS wire909/A _3956_/A gf180mcu_as_sc_mcu7t3v3__clkbuff_12
X_2959_ VDD VDD VSS VSS _3046_/B _4916_/Q _2962_/C gf180mcu_as_sc_mcu7t3v3__or2_2
XFILLER_163_544 VDD VDD VSS VSS gf180mcu_as_sc_mcu7t3v3__fillcap_4
XFILLER_163_566 VDD VDD VSS VSS gf180mcu_as_sc_mcu7t3v3__fill_2
XFILLER_191_897 VDD VDD VSS VSS gf180mcu_as_sc_mcu7t3v3__fill_1
X_4629_ VDD VDD VSS VSS _5220_/Q _4629_/B _4629_/C _4629_/D _5220_/D gf180mcu_as_sc_mcu7t3v3__ao22_2
XFILLER_190_374 VDD VDD VSS VSS gf180mcu_as_sc_mcu7t3v3__fill_1
XFILLER_2_716 VDD VDD VSS VSS gf180mcu_as_sc_mcu7t3v3__fillcap_4
XPHY_EDGE_ROW_101_3_Right_142 VDD VSS gf180mcu_as_sc_mcu7t3v3__tap_2
XFILLER_106_53 VDD VDD VSS VSS gf180mcu_as_sc_mcu7t3v3__fillcap_16
XPHY_EDGE_ROW_117_1_Right_626 VDD VSS gf180mcu_as_sc_mcu7t3v3__tap_2
XFILLER_92_1303 VDD VDD VSS VSS gf180mcu_as_sc_mcu7t3v3__fill_2
XFILLER_15_61 VDD VDD VSS VSS gf180mcu_as_sc_mcu7t3v3__fillcap_8
XFILLER_15_72 VDD VDD VSS VSS gf180mcu_as_sc_mcu7t3v3__fillcap_16
XFILLER_158_349 VDD VDD VSS VSS gf180mcu_as_sc_mcu7t3v3__fillcap_4
XFILLER_9_348 VDD VDD VSS VSS gf180mcu_as_sc_mcu7t3v3__fill_2
XFILLER_12_1017 VDD VDD VSS VSS gf180mcu_as_sc_mcu7t3v3__fill_2
XTAP_TAPCELL_ROW_106_3_2017 VDD VSS gf180mcu_as_sc_mcu7t3v3__tap_2
XFILLER_177_1224 VDD VDD VSS VSS gf180mcu_as_sc_mcu7t3v3__fillcap_16
XFILLER_154_577 VDD VDD VSS VSS gf180mcu_as_sc_mcu7t3v3__fillcap_8
XFILLER_177_1257 VDD VDD VSS VSS gf180mcu_as_sc_mcu7t3v3__fill_2
XFILLER_177_1268 VDD VDD VSS VSS gf180mcu_as_sc_mcu7t3v3__fill_1
XFILLER_181_352 VDD VDD VSS VSS gf180mcu_as_sc_mcu7t3v3__fillcap_8
XFILLER_154_599 VDD VDD VSS VSS gf180mcu_as_sc_mcu7t3v3__fill_1
XTAP_TAPCELL_ROW_9_871 VDD VSS gf180mcu_as_sc_mcu7t3v3__tap_2
XTAP_TAPCELL_ROW_9_860 VDD VSS gf180mcu_as_sc_mcu7t3v3__tap_2
XFILLER_7_1332 VDD VDD VSS VSS gf180mcu_as_sc_mcu7t3v3__fillcap_16
XFILLER_7_1354 VDD VDD VSS VSS gf180mcu_as_sc_mcu7t3v3__fill_1
XTAP_TAPCELL_ROW_182_1701 VDD VSS gf180mcu_as_sc_mcu7t3v3__tap_2
Xinput160 VDD VDD VSS VSS nw_in[22] _4110_/A gf180mcu_as_sc_mcu7t3v3__buff_12
Xinput171 VDD VDD VSS VSS nw_in[32] _3522_/A gf180mcu_as_sc_mcu7t3v3__buff_12
XTAP_TAPCELL_ROW_182_1712 VDD VSS gf180mcu_as_sc_mcu7t3v3__tap_2
XFILLER_114_1285 VDD VDD VSS VSS gf180mcu_as_sc_mcu7t3v3__fillcap_4
Xinput182 VDD VDD VSS VSS se_in[10] _4017_/A gf180mcu_as_sc_mcu7t3v3__buff_12
Xinput193 VDD VDD VSS VSS se_in[20] _4097_/A gf180mcu_as_sc_mcu7t3v3__buff_12
XFILLER_149_1326 VDD VDD VSS VSS gf180mcu_as_sc_mcu7t3v3__fillcap_4
XFILLER_97_1258 VDD VDD VSS VSS gf180mcu_as_sc_mcu7t3v3__fill_1
XFILLER_97_1269 VDD VDD VSS VSS gf180mcu_as_sc_mcu7t3v3__fill_2
XFILLER_184_1239 VDD VDD VSS VSS gf180mcu_as_sc_mcu7t3v3__fillcap_8
X_4980_ VDD VDD VSS VSS clkload8/A _4980_/D _4980_/Q gf180mcu_as_sc_mcu7t3v3__dfxtp_2
X_3931_ VDD VDD VSS VSS _3931_/B _3931_/A _3931_/Y gf180mcu_as_sc_mcu7t3v3__and2_2
XFILLER_189_496 VDD VDD VSS VSS gf180mcu_as_sc_mcu7t3v3__fill_1
X_3862_ VDD VDD VSS VSS _3868_/C _3862_/A _3871_/B _3862_/C _3869_/C gf180mcu_as_sc_mcu7t3v3__ao31_2
XTAP_TAPCELL_ROW_49_3_1960 VDD VSS gf180mcu_as_sc_mcu7t3v3__tap_2
X_2813_ VDD VDD VSS VSS _4692_/B _2833_/A _2825_/B gf180mcu_as_sc_mcu7t3v3__and2_2
XFILLER_9_860 VDD VDD VSS VSS gf180mcu_as_sc_mcu7t3v3__fillcap_16
X_3793_ VDD VDD VSS VSS _3794_/B _3793_/A _3802_/B _3793_/C gf180mcu_as_sc_mcu7t3v3__ao21_2
XFILLER_160_1294 VDD VDD VSS VSS gf180mcu_as_sc_mcu7t3v3__fill_1
XFILLER_173_842 VDD VDD VSS VSS gf180mcu_as_sc_mcu7t3v3__fill_2
X_2744_ VDD VDD VSS VSS _4947_/Q _2744_/B _2744_/A _5485_/A gf180mcu_as_sc_mcu7t3v3__mux2_2
XFILLER_172_352 VDD VDD VSS VSS gf180mcu_as_sc_mcu7t3v3__fillcap_4
X_2675_ VDD VDD VSS VSS _2676_/D _2675_/C _2736_/B _2675_/A gf180mcu_as_sc_mcu7t3v3__aoi21b_2
X_4414_ VDD VDD VSS VSS _4414_/D _4502_/A _4414_/B _4414_/C _4415_/B gf180mcu_as_sc_mcu7t3v3__ao31_2
XFILLER_154_1010 VDD VDD VSS VSS gf180mcu_as_sc_mcu7t3v3__fillcap_4
X_4345_ VDD VDD VSS VSS _4346_/B _4345_/C _4345_/B _4554_/B gf180mcu_as_sc_mcu7t3v3__aoi21_2
XTAP_TAPCELL_ROW_7_819 VDD VSS gf180mcu_as_sc_mcu7t3v3__tap_2
X_4276_ VDD VDD VSS VSS _4281_/S _4694_/B _5110_/Q _5110_/D gf180mcu_as_sc_mcu7t3v3__mux2_2
XFILLER_189_1117 VDD VDD VSS VSS gf180mcu_as_sc_mcu7t3v3__fill_2
X_3227_ VDD VDD VSS VSS _3227_/S _3512_/A _3511_/A _3228_/B gf180mcu_as_sc_mcu7t3v3__mux2_2
X_3158_ VDD VDD VSS VSS _4136_/A _3240_/B _3239_/A _4135_/A _3164_/B gf180mcu_as_sc_mcu7t3v3__ao22_2
XPHY_EDGE_ROW_41_1_Right_550 VDD VSS gf180mcu_as_sc_mcu7t3v3__tap_2
X_3089_ VDD VDD VSS VSS _4067_/A _3131_/A _3089_/C _4787_/D _3730_/D gf180mcu_as_sc_mcu7t3v3__aoi211_2
XFILLER_11_804 VDD VDD VSS VSS gf180mcu_as_sc_mcu7t3v3__fill_2
XFILLER_52_37 VDD VDD VSS VSS gf180mcu_as_sc_mcu7t3v3__fill_1
XFILLER_10_325 VDD VDD VSS VSS gf180mcu_as_sc_mcu7t3v3__fill_1
XFILLER_11_837 VDD VDD VSS VSS gf180mcu_as_sc_mcu7t3v3__fill_2
XFILLER_11_848 VDD VDD VSS VSS gf180mcu_as_sc_mcu7t3v3__fill_1
XFILLER_167_146 VDD VDD VSS VSS gf180mcu_as_sc_mcu7t3v3__fill_1
XFILLER_168_37 VDD VDD VSS VSS gf180mcu_as_sc_mcu7t3v3__fillcap_16
XFILLER_168_647 VDD VDD VSS VSS gf180mcu_as_sc_mcu7t3v3__fill_1
XFILLER_183_606 VDD VDD VSS VSS gf180mcu_as_sc_mcu7t3v3__fill_1
XFILLER_163_352 VDD VDD VSS VSS gf180mcu_as_sc_mcu7t3v3__fill_2
XFILLER_164_853 VDD VDD VSS VSS gf180mcu_as_sc_mcu7t3v3__fillcap_16
XFILLER_163_396 VDD VDD VSS VSS gf180mcu_as_sc_mcu7t3v3__fillcap_8
XFILLER_184_69 VDD VDD VSS VSS gf180mcu_as_sc_mcu7t3v3__fillcap_16
XFILLER_191_672 VDD VDD VSS VSS gf180mcu_as_sc_mcu7t3v3__fill_2
XPHY_EDGE_ROW_102_3_Right_143 VDD VSS gf180mcu_as_sc_mcu7t3v3__tap_2
XFILLER_172_1143 VDD VDD VSS VSS gf180mcu_as_sc_mcu7t3v3__fillcap_8
XFILLER_172_1165 VDD VDD VSS VSS gf180mcu_as_sc_mcu7t3v3__fillcap_4
XFILLER_172_1176 VDD VDD VSS VSS gf180mcu_as_sc_mcu7t3v3__fillcap_4
Xfanout872 VDD VDD VSS VSS _2565_/A _2736_/C gf180mcu_as_sc_mcu7t3v3__buff_12
Xfanout883 VDD VDD VSS VSS _3654_/D _3580_/D gf180mcu_as_sc_mcu7t3v3__buff_12
Xfanout894 VDD VDD VSS VSS _3805_/C _3738_/D gf180mcu_as_sc_mcu7t3v3__buff_12
XPHY_EDGE_ROW_118_1_Right_627 VDD VSS gf180mcu_as_sc_mcu7t3v3__tap_2
XPHY_EDGE_ROW_22_3_Right_63 VDD VSS gf180mcu_as_sc_mcu7t3v3__tap_2
XFILLER_133_95 VDD VDD VSS VSS gf180mcu_as_sc_mcu7t3v3__fillcap_8
XFILLER_187_912 VDD VDD VSS VSS gf180mcu_as_sc_mcu7t3v3__fillcap_8
XFILLER_96_1291 VDD VDD VSS VSS gf180mcu_as_sc_mcu7t3v3__fillcap_16
XFILLER_144_1256 VDD VDD VSS VSS gf180mcu_as_sc_mcu7t3v3__fill_2
XFILLER_187_978 VDD VDD VSS VSS gf180mcu_as_sc_mcu7t3v3__fill_2
XTAP_TAPCELL_ROW_158_1246 VDD VSS gf180mcu_as_sc_mcu7t3v3__tap_2
XFILLER_13_196 VDD VDD VSS VSS gf180mcu_as_sc_mcu7t3v3__fillcap_4
XFILLER_42_70 VDD VDD VSS VSS gf180mcu_as_sc_mcu7t3v3__fillcap_8
XFILLER_9_167 VDD VDD VSS VSS gf180mcu_as_sc_mcu7t3v3__fill_2
XTAP_TAPCELL_ROW_158_1257 VDD VSS gf180mcu_as_sc_mcu7t3v3__tap_2
XFILLER_155_842 VDD VDD VSS VSS gf180mcu_as_sc_mcu7t3v3__fill_2
XFILLER_9_189 VDD VDD VSS VSS gf180mcu_as_sc_mcu7t3v3__fill_1
XTAP_TAPCELL_ROW_175_1571 VDD VSS gf180mcu_as_sc_mcu7t3v3__tap_2
XFILLER_154_352 VDD VDD VSS VSS gf180mcu_as_sc_mcu7t3v3__fillcap_8
XFILLER_154_374 VDD VDD VSS VSS gf180mcu_as_sc_mcu7t3v3__fillcap_8
XFILLER_29_1300 VDD VDD VSS VSS gf180mcu_as_sc_mcu7t3v3__fillcap_8
X_2460_ VDD VDD VSS VSS _4341_/S _5090_/Q _5003_/Q _2462_/B gf180mcu_as_sc_mcu7t3v3__mux2_2
XPHY_EDGE_ROW_80_1_Right_589 VDD VSS gf180mcu_as_sc_mcu7t3v3__tap_2
XFILLER_116_1303 VDD VDD VSS VSS gf180mcu_as_sc_mcu7t3v3__fill_1
XFILLER_174_80 VDD VDD VSS VSS gf180mcu_as_sc_mcu7t3v3__fillcap_16
X_4130_ VDD VDD VSS VSS _4130_/A _4153_/B _4130_/C _4130_/D _4131_/C gf180mcu_as_sc_mcu7t3v3__ao211_2
X_2391_ VDD VDD VSS VSS _2699_/A _5099_/Q gf180mcu_as_sc_mcu7t3v3__inv_2
X_4061_ VDD VDD VSS VSS _4061_/A _4102_/B _4102_/C _4931_/Q _4063_/C gf180mcu_as_sc_mcu7t3v3__ao22_2
X_3012_ VDD VDD VSS VSS _3992_/A _3042_/B _3012_/C _3012_/D _3013_/D gf180mcu_as_sc_mcu7t3v3__ao22_2
XFILLER_184_1014 VDD VDD VSS VSS gf180mcu_as_sc_mcu7t3v3__fill_1
X_4963_ VDD VDD VSS VSS _5164_/CLK _4963_/D _4963_/Q gf180mcu_as_sc_mcu7t3v3__dfxtp_2
X_3914_ VDD VDD VSS VSS _3932_/D _3914_/A _3914_/B _3929_/A gf180mcu_as_sc_mcu7t3v3__ao21_2
XFILLER_177_422 VDD VDD VSS VSS gf180mcu_as_sc_mcu7t3v3__fillcap_8
XFILLER_189_282 VDD VDD VSS VSS gf180mcu_as_sc_mcu7t3v3__fill_1
X_4894_ VDD VDD VSS VSS _4895_/CLK _4894_/D _4894_/Q gf180mcu_as_sc_mcu7t3v3__dfxtp_2
XFILLER_165_617 VDD VDD VSS VSS gf180mcu_as_sc_mcu7t3v3__fill_1
X_3845_ VDD VDD VSS VSS _3845_/B _3845_/A _3847_/S gf180mcu_as_sc_mcu7t3v3__or2_2
XTAP_TAPCELL_ROW_96_1_1049 VDD VSS gf180mcu_as_sc_mcu7t3v3__tap_2
X_3776_ VDD VDD VSS VSS _3780_/C _3776_/A _3776_/B _4161_/A gf180mcu_as_sc_mcu7t3v3__ao21_2
XFILLER_173_661 VDD VDD VSS VSS gf180mcu_as_sc_mcu7t3v3__fill_2
X_2727_ VDD VDD VSS VSS _2734_/S _2727_/B _2727_/A _2728_/C gf180mcu_as_sc_mcu7t3v3__mux2_2
XPHY_EDGE_ROW_71_3_Left_443 VDD VSS gf180mcu_as_sc_mcu7t3v3__tap_2
Xoutput420 VDD VDD VSS VSS _4808_/Q south_out[3] gf180mcu_as_sc_mcu7t3v3__buff_12
XFILLER_161_856 VDD VDD VSS VSS gf180mcu_as_sc_mcu7t3v3__fillcap_4
Xclkbuf_leaf_6_clk_regs VDD VDD VSS VSS clkbuf_leaf_6_clk_regs/A clkload2/A gf180mcu_as_sc_mcu7t3v3__clkbuff_12
Xoutput453 VDD VDD VSS VSS _4906_/Q west_out[33] gf180mcu_as_sc_mcu7t3v3__buff_12
Xoutput442 VDD VDD VSS VSS _4896_/Q west_out[23] gf180mcu_as_sc_mcu7t3v3__buff_12
Xoutput431 VDD VDD VSS VSS _4886_/Q west_out[13] gf180mcu_as_sc_mcu7t3v3__buff_12
X_2658_ VDD VDD VSS VSS _2818_/S _5261_/Q _5249_/Q _2659_/B gf180mcu_as_sc_mcu7t3v3__mux2_2
X_2589_ VDD VDD VSS VSS _2589_/Y _2589_/C _4949_/Q _2589_/A gf180mcu_as_sc_mcu7t3v3__aoi21b_2
X_4328_ VDD VDD VSS VSS _4328_/A _4328_/B _4328_/C _5156_/Q _5156_/D gf180mcu_as_sc_mcu7t3v3__ao22_2
X_4259_ VDD VDD VSS VSS _4643_/B _4643_/A _4259_/B _4259_/C _4260_/B gf180mcu_as_sc_mcu7t3v3__ao31_2
XPHY_EDGE_ROW_42_1_Right_551 VDD VSS gf180mcu_as_sc_mcu7t3v3__tap_2
XFILLER_167_1278 VDD VDD VSS VSS gf180mcu_as_sc_mcu7t3v3__fill_2
XFILLER_187_219 VDD VDD VSS VSS gf180mcu_as_sc_mcu7t3v3__fillcap_4
XFILLER_63_69 VDD VDD VSS VSS gf180mcu_as_sc_mcu7t3v3__fill_1
XFILLER_169_956 VDD VDD VSS VSS gf180mcu_as_sc_mcu7t3v3__fillcap_16
XFILLER_169_989 VDD VDD VSS VSS gf180mcu_as_sc_mcu7t3v3__fillcap_16
Xwire514 VDD VDD VSS VSS _3667_/B _3729_/B gf180mcu_as_sc_mcu7t3v3__clkbuff_12
XFILLER_10_177 VDD VDD VSS VSS gf180mcu_as_sc_mcu7t3v3__fillcap_8
XFILLER_6_104 VDD VDD VSS VSS gf180mcu_as_sc_mcu7t3v3__fill_1
XFILLER_6_115 VDD VDD VSS VSS gf180mcu_as_sc_mcu7t3v3__fill_2
XFILLER_13_1145 VDD VDD VSS VSS gf180mcu_as_sc_mcu7t3v3__fill_1
XFILLER_164_650 VDD VDD VSS VSS gf180mcu_as_sc_mcu7t3v3__fill_2
XFILLER_104_1295 VDD VDD VSS VSS gf180mcu_as_sc_mcu7t3v3__fill_2
XFILLER_3_811 VDD VDD VSS VSS gf180mcu_as_sc_mcu7t3v3__fill_1
XTAP_TAPCELL_ROW_153_1154 VDD VSS gf180mcu_as_sc_mcu7t3v3__tap_2
XFILLER_174_1227 VDD VDD VSS VSS gf180mcu_as_sc_mcu7t3v3__fillcap_8
XFILLER_2_321 VDD VDD VSS VSS gf180mcu_as_sc_mcu7t3v3__fill_1
XFILLER_88_55 VDD VDD VSS VSS gf180mcu_as_sc_mcu7t3v3__fillcap_16
XPHY_EDGE_ROW_103_3_Right_144 VDD VSS gf180mcu_as_sc_mcu7t3v3__tap_2
XFILLER_4_1324 VDD VDD VSS VSS gf180mcu_as_sc_mcu7t3v3__fillcap_4
XFILLER_92_103 VDD VDD VSS VSS gf180mcu_as_sc_mcu7t3v3__fill_2
Xfanout680 VDD VDD VSS VSS _4594_/Y _4629_/C gf180mcu_as_sc_mcu7t3v3__buff_12
Xfanout691 VDD VDD VSS VSS wire694/Y _3727_/C gf180mcu_as_sc_mcu7t3v3__buff_12
XPHY_EDGE_ROW_119_1_Right_628 VDD VSS gf180mcu_as_sc_mcu7t3v3__tap_2
XFILLER_150_1271 VDD VDD VSS VSS gf180mcu_as_sc_mcu7t3v3__fillcap_16
XFILLER_59_1326 VDD VDD VSS VSS gf180mcu_as_sc_mcu7t3v3__fillcap_4
X_4887__1081 VDD VDD VSS VSS _4887_/D gf180mcu_as_sc_mcu7t3v3__tiel_4
XFILLER_159_411 VDD VDD VSS VSS gf180mcu_as_sc_mcu7t3v3__fillcap_8
XFILLER_187_720 VDD VDD VSS VSS gf180mcu_as_sc_mcu7t3v3__fill_1
XTAP_TAPCELL_ROW_177_1600 VDD VSS gf180mcu_as_sc_mcu7t3v3__tap_2
XFILLER_187_753 VDD VDD VSS VSS gf180mcu_as_sc_mcu7t3v3__fillcap_16
XTAP_TAPCELL_ROW_177_1611 VDD VSS gf180mcu_as_sc_mcu7t3v3__tap_2
XFILLER_186_241 VDD VDD VSS VSS gf180mcu_as_sc_mcu7t3v3__fillcap_4
X_3630_ VDD VDD VSS VSS _3631_/C _3630_/C _3783_/B _4001_/A gf180mcu_as_sc_mcu7t3v3__aoi21_2
XFILLER_31_1256 VDD VDD VSS VSS gf180mcu_as_sc_mcu7t3v3__fill_1
X_3561_ VDD VDD VSS VSS _3561_/Y _3561_/B _3561_/A gf180mcu_as_sc_mcu7t3v3__nor2_2
XTAP_TAPCELL_ROW_190_1855 VDD VSS gf180mcu_as_sc_mcu7t3v3__tap_2
X_2512_ VDD VDD VSS VSS _5262_/Q _4662_/C _4708_/B _2517_/C gf180mcu_as_sc_mcu7t3v3__nand3_2
X_3492_ VDD VDD VSS VSS _3492_/B _3525_/A _4831_/D gf180mcu_as_sc_mcu7t3v3__and2_2
X_5231_ VDD VDD VSS VSS _5232_/CLK _5231_/D _5231_/Q gf180mcu_as_sc_mcu7t3v3__dfxtp_2
X_2443_ VDD VDD VSS VSS _3731_/A _4106_/A gf180mcu_as_sc_mcu7t3v3__inv_2
XFILLER_68_100 VDD VDD VSS VSS gf180mcu_as_sc_mcu7t3v3__fillcap_4
X_5162_ VDD VDD VSS VSS _5164_/CLK _5162_/D _5162_/Q gf180mcu_as_sc_mcu7t3v3__dfxtp_2
XFILLER_190_1084 VDD VDD VSS VSS gf180mcu_as_sc_mcu7t3v3__fill_1
X_5093_ VDD VDD VSS VSS _5185_/CLK _5093_/D _5093_/Q gf180mcu_as_sc_mcu7t3v3__dfxtp_2
X_4113_ VDD VDD VSS VSS _4113_/A _4159_/B _4113_/C _4113_/D _4114_/C gf180mcu_as_sc_mcu7t3v3__ao211_2
X_4044_ VDD VDD VSS VSS _4991_/Q _4076_/B _4242_/B _4076_/D _4991_/D gf180mcu_as_sc_mcu7t3v3__ao22_2
XFILLER_162_1120 VDD VDD VSS VSS gf180mcu_as_sc_mcu7t3v3__fillcap_4
X_4946_ VDD VDD VSS VSS clkload1/A _4946_/D _4946_/Q gf180mcu_as_sc_mcu7t3v3__dfxtp_2
XFILLER_178_764 VDD VDD VSS VSS gf180mcu_as_sc_mcu7t3v3__fillcap_4
X_4877_ VDD VDD VSS VSS clkload4/A _4877_/D _4877_/Q gf180mcu_as_sc_mcu7t3v3__dfxtp_2
X_3828_ VDD VDD VSS VSS _3828_/B _4914_/Q _3835_/B gf180mcu_as_sc_mcu7t3v3__and2_2
XFILLER_181_918 VDD VDD VSS VSS gf180mcu_as_sc_mcu7t3v3__fill_1
XFILLER_192_244 VDD VDD VSS VSS gf180mcu_as_sc_mcu7t3v3__fill_2
XFILLER_180_417 VDD VDD VSS VSS gf180mcu_as_sc_mcu7t3v3__fill_1
X_3759_ VDD VDD VSS VSS _3760_/C _3759_/C _3802_/B _4139_/A gf180mcu_as_sc_mcu7t3v3__aoi21_2
XFILLER_0_803 VDD VDD VSS VSS gf180mcu_as_sc_mcu7t3v3__fill_2
XFILLER_161_664 VDD VDD VSS VSS gf180mcu_as_sc_mcu7t3v3__fillcap_4
XFILLER_161_697 VDD VDD VSS VSS gf180mcu_as_sc_mcu7t3v3__fill_2
XFILLER_0_869 VDD VDD VSS VSS gf180mcu_as_sc_mcu7t3v3__fill_2
XTAP_TAPCELL_ROW_72_3_1983 VDD VSS gf180mcu_as_sc_mcu7t3v3__tap_2
XFILLER_114_64 VDD VDD VSS VSS gf180mcu_as_sc_mcu7t3v3__fillcap_4
XPHY_EDGE_ROW_43_1_Right_552 VDD VSS gf180mcu_as_sc_mcu7t3v3__tap_2
XFILLER_130_74 VDD VDD VSS VSS gf180mcu_as_sc_mcu7t3v3__fill_2
XFILLER_180_1275 VDD VDD VSS VSS gf180mcu_as_sc_mcu7t3v3__fillcap_8
XFILLER_90_67 VDD VDD VSS VSS gf180mcu_as_sc_mcu7t3v3__fill_2
XFILLER_180_1297 VDD VDD VSS VSS gf180mcu_as_sc_mcu7t3v3__fillcap_4
XFILLER_183_222 VDD VDD VSS VSS gf180mcu_as_sc_mcu7t3v3__fillcap_4
XFILLER_8_947 VDD VDD VSS VSS gf180mcu_as_sc_mcu7t3v3__fillcap_16
XFILLER_156_469 VDD VDD VSS VSS gf180mcu_as_sc_mcu7t3v3__fill_2
XFILLER_183_255 VDD VDD VSS VSS gf180mcu_as_sc_mcu7t3v3__fillcap_8
XFILLER_99_54 VDD VDD VSS VSS gf180mcu_as_sc_mcu7t3v3__fill_2
XFILLER_99_87 VDD VDD VSS VSS gf180mcu_as_sc_mcu7t3v3__fillcap_16
XFILLER_180_973 VDD VDD VSS VSS gf180mcu_as_sc_mcu7t3v3__fill_1
XPHY_EDGE_ROW_104_3_Right_145 VDD VSS gf180mcu_as_sc_mcu7t3v3__tap_2
XFILLER_171_92 VDD VDD VSS VSS gf180mcu_as_sc_mcu7t3v3__fill_1
XFILLER_4_1154 VDD VDD VSS VSS gf180mcu_as_sc_mcu7t3v3__fill_1
XFILLER_0_76 VDD VDD VSS VSS gf180mcu_as_sc_mcu7t3v3__fill_1
X_4800_ VDD VDD VSS VSS _5226_/CLK _4800_/D _4800_/Q gf180mcu_as_sc_mcu7t3v3__dfxtp_2
XFILLER_72_1323 VDD VDD VSS VSS gf180mcu_as_sc_mcu7t3v3__fillcap_4
X_2992_ VDD VDD VSS VSS _3043_/S _3973_/A _3975_/A _2994_/B gf180mcu_as_sc_mcu7t3v3__mux2_2
X_4731_ VDD VDD VSS VSS _5266_/D _5111_/Q _4731_/B _4731_/C gf180mcu_as_sc_mcu7t3v3__ao21_2
XTAP_TAPCELL_ROW_192_1906 VDD VSS gf180mcu_as_sc_mcu7t3v3__tap_2
XFILLER_174_200 VDD VDD VSS VSS gf180mcu_as_sc_mcu7t3v3__fillcap_16
X_4662_ VDD VDD VSS VSS _4663_/B _4703_/A _4746_/A _4662_/C gf180mcu_as_sc_mcu7t3v3__ao21_2
XTAP_TAPCELL_ROW_192_1917 VDD VSS gf180mcu_as_sc_mcu7t3v3__tap_2
XTAP_TAPCELL_ROW_13_960 VDD VSS gf180mcu_as_sc_mcu7t3v3__tap_2
XFILLER_175_767 VDD VDD VSS VSS gf180mcu_as_sc_mcu7t3v3__fill_2
X_3613_ VDD VDD VSS VSS _3613_/D _3984_/D _3728_/B _3728_/C _3614_/C gf180mcu_as_sc_mcu7t3v3__ao31_2
XFILLER_162_428 VDD VDD VSS VSS gf180mcu_as_sc_mcu7t3v3__fill_1
X_4593_ VDD VDD VSS VSS _4748_/A _4594_/A _4750_/D gf180mcu_as_sc_mcu7t3v3__and2_2
XFILLER_162_439 VDD VDD VSS VSS gf180mcu_as_sc_mcu7t3v3__fillcap_16
X_3544_ VDD VDD VSS VSS _3787_/A _3818_/D _3544_/C _3797_/C gf180mcu_as_sc_mcu7t3v3__nand3_2
XFILLER_157_1244 VDD VDD VSS VSS gf180mcu_as_sc_mcu7t3v3__fill_1
Xmax_cap655 VDD VDD VSS VSS _3267_/Y fanout650/A gf180mcu_as_sc_mcu7t3v3__clkbuff_12
X_3475_ VDD VDD VSS VSS _4126_/D _3495_/B _3475_/C _3475_/D _3476_/C gf180mcu_as_sc_mcu7t3v3__ao211_2
X_5214_ VDD VDD VSS VSS _5216_/CLK _5214_/D _5214_/Q gf180mcu_as_sc_mcu7t3v3__dfxtp_2
X_2426_ VDD VDD VSS VSS _3962_/A _2426_/A gf180mcu_as_sc_mcu7t3v3__inv_2
XTAP_TAPCELL_ROW_105_1_1058 VDD VSS gf180mcu_as_sc_mcu7t3v3__tap_2
XFILLER_56_103 VDD VDD VSS VSS gf180mcu_as_sc_mcu7t3v3__fill_2
X_5145_ VDD VDD VSS VSS _5150_/CLK _5145_/D _5145_/Q gf180mcu_as_sc_mcu7t3v3__dfxtp_2
X_5076_ VDD VDD VSS VSS clkload8/A _5076_/D _5076_/Q gf180mcu_as_sc_mcu7t3v3__dfxtp_2
X_4027_ VDD VDD VSS VSS _4027_/A _4027_/B _4027_/C _4240_/B _4067_/D gf180mcu_as_sc_mcu7t3v3__aoi211_2
XFILLER_164_1204 VDD VDD VSS VSS gf180mcu_as_sc_mcu7t3v3__fillcap_16
XFILLER_44_27 VDD VDD VSS VSS gf180mcu_as_sc_mcu7t3v3__fillcap_8
XFILLER_77_1256 VDD VDD VSS VSS gf180mcu_as_sc_mcu7t3v3__fillcap_16
XTAP_TAPCELL_ROW_0_688 VDD VSS gf180mcu_as_sc_mcu7t3v3__tap_2
XTAP_TAPCELL_ROW_0_677 VDD VSS gf180mcu_as_sc_mcu7t3v3__tap_2
XTAP_TAPCELL_ROW_0_666 VDD VSS gf180mcu_as_sc_mcu7t3v3__tap_2
XFILLER_12_206 VDD VDD VSS VSS gf180mcu_as_sc_mcu7t3v3__fillcap_8
XFILLER_164_1237 VDD VDD VSS VSS gf180mcu_as_sc_mcu7t3v3__fill_1
XTAP_TAPCELL_ROW_0_699 VDD VSS gf180mcu_as_sc_mcu7t3v3__tap_2
XFILLER_100_55 VDD VDD VSS VSS gf180mcu_as_sc_mcu7t3v3__fillcap_16
XFILLER_12_239 VDD VDD VSS VSS gf180mcu_as_sc_mcu7t3v3__fillcap_4
X_4929_ VDD VDD VSS VSS _5158_/CLK _4929_/D _4929_/Q gf180mcu_as_sc_mcu7t3v3__dfxtp_2
XTAP_TAPCELL_ROW_11_908 VDD VSS gf180mcu_as_sc_mcu7t3v3__tap_2
XFILLER_176_37 VDD VDD VSS VSS gf180mcu_as_sc_mcu7t3v3__fillcap_16
XFILLER_153_417 VDD VDD VSS VSS gf180mcu_as_sc_mcu7t3v3__fill_2
XFILLER_181_726 VDD VDD VSS VSS gf180mcu_as_sc_mcu7t3v3__fill_2
XFILLER_5_928 VDD VDD VSS VSS gf180mcu_as_sc_mcu7t3v3__fillcap_16
XPHY_EDGE_ROW_31_3_Right_72 VDD VSS gf180mcu_as_sc_mcu7t3v3__tap_2
XFILLER_109_64 VDD VDD VSS VSS gf180mcu_as_sc_mcu7t3v3__fillcap_4
XFILLER_165_299 VDD VDD VSS VSS gf180mcu_as_sc_mcu7t3v3__fillcap_16
XFILLER_175_1300 VDD VDD VSS VSS gf180mcu_as_sc_mcu7t3v3__fill_2
XFILLER_180_247 VDD VDD VSS VSS gf180mcu_as_sc_mcu7t3v3__fillcap_8
XFILLER_192_36 VDD VDD VSS VSS gf180mcu_as_sc_mcu7t3v3__fillcap_4
XPHY_EDGE_ROW_34_3_Left_406 VDD VSS gf180mcu_as_sc_mcu7t3v3__tap_2
XFILLER_0_688 VDD VDD VSS VSS gf180mcu_as_sc_mcu7t3v3__fill_1
XFILLER_47_103 VDD VDD VSS VSS gf180mcu_as_sc_mcu7t3v3__fill_2
XFILLER_60_1260 VDD VDD VSS VSS gf180mcu_as_sc_mcu7t3v3__fill_1
XFILLER_18_83 VDD VDD VSS VSS gf180mcu_as_sc_mcu7t3v3__fill_1
XTAP_TAPCELL_ROW_20_3_1931 VDD VSS gf180mcu_as_sc_mcu7t3v3__tap_2
XFILLER_188_314 VDD VDD VSS VSS gf180mcu_as_sc_mcu7t3v3__fill_1
XPHY_EDGE_ROW_44_1_Right_553 VDD VSS gf180mcu_as_sc_mcu7t3v3__tap_2
XTAP_TAPCELL_ROW_161_1297 VDD VSS gf180mcu_as_sc_mcu7t3v3__tap_2
XFILLER_188_369 VDD VDD VSS VSS gf180mcu_as_sc_mcu7t3v3__fill_2
XFILLER_156_200 VDD VDD VSS VSS gf180mcu_as_sc_mcu7t3v3__fillcap_8
XFILLER_157_712 VDD VDD VSS VSS gf180mcu_as_sc_mcu7t3v3__fillcap_16
XFILLER_156_266 VDD VDD VSS VSS gf180mcu_as_sc_mcu7t3v3__fillcap_4
XFILLER_4_972 VDD VDD VSS VSS gf180mcu_as_sc_mcu7t3v3__fill_1
XFILLER_152_472 VDD VDD VSS VSS gf180mcu_as_sc_mcu7t3v3__fillcap_4
XFILLER_153_995 VDD VDD VSS VSS gf180mcu_as_sc_mcu7t3v3__fillcap_8
XFILLER_180_792 VDD VDD VSS VSS gf180mcu_as_sc_mcu7t3v3__fill_1
XPHY_EDGE_ROW_13_Left_206 VDD VSS gf180mcu_as_sc_mcu7t3v3__tap_2
X_3260_ VDD VDD VSS VSS _3261_/B _3263_/A _3520_/B gf180mcu_as_sc_mcu7t3v3__and2_2
XTAP_TAPCELL_ROW_168_1429 VDD VSS gf180mcu_as_sc_mcu7t3v3__tap_2
XFILLER_38_103 VDD VDD VSS VSS gf180mcu_as_sc_mcu7t3v3__fill_2
X_3191_ VDD VDD VSS VSS _4161_/A _3237_/B _3238_/C _3191_/D _3193_/C gf180mcu_as_sc_mcu7t3v3__ao211_2
XTAP_TAPCELL_ROW_185_1754 VDD VSS gf180mcu_as_sc_mcu7t3v3__tap_2
XPHY_EDGE_ROW_105_3_Right_146 VDD VSS gf180mcu_as_sc_mcu7t3v3__tap_2
XTAP_TAPCELL_ROW_185_1765 VDD VSS gf180mcu_as_sc_mcu7t3v3__tap_2
XPHY_EDGE_ROW_80_3_Left_452 VDD VSS gf180mcu_as_sc_mcu7t3v3__tap_2
Xclkbuf_leaf_20_clk_regs VDD VDD VSS VSS clkload0/A _5285_/CLK gf180mcu_as_sc_mcu7t3v3__clkbuff_12
XFILLER_163_1281 VDD VDD VSS VSS gf180mcu_as_sc_mcu7t3v3__fill_2
X_4714_ VDD VDD VSS VSS _4721_/A _4714_/B _5106_/Q _5259_/D gf180mcu_as_sc_mcu7t3v3__mux2_2
X_2975_ VDD VDD VSS VSS _3043_/S _3956_/D _3960_/A _2977_/B gf180mcu_as_sc_mcu7t3v3__mux2_2
XTAP_TAPCELL_ROW_124_3_2035 VDD VSS gf180mcu_as_sc_mcu7t3v3__tap_2
X_4645_ VDD VDD VSS VSS _4645_/B _5234_/Q _4646_/D gf180mcu_as_sc_mcu7t3v3__and2_2
XFILLER_146_29 VDD VDD VSS VSS gf180mcu_as_sc_mcu7t3v3__fillcap_4
XFILLER_190_523 VDD VDD VSS VSS gf180mcu_as_sc_mcu7t3v3__fill_2
X_4576_ VDD VDD VSS VSS _4576_/B _4591_/A _4583_/C gf180mcu_as_sc_mcu7t3v3__and2_2
X_3527_ VDD VDD VSS VSS _3527_/B _3848_/A _4838_/D gf180mcu_as_sc_mcu7t3v3__and2_2
X_3458_ VDD VDD VSS VSS _4111_/A _3503_/B _3458_/C _3458_/D _3459_/C gf180mcu_as_sc_mcu7t3v3__ao211_2
X_3389_ VDD VDD VSS VSS _3389_/S _4037_/A _3389_/A _3391_/B gf180mcu_as_sc_mcu7t3v3__mux2_2
X_2409_ VDD VDD VSS VSS _4337_/B _5158_/Q gf180mcu_as_sc_mcu7t3v3__inv_2
X_5128_ VDD VDD VSS VSS _5216_/CLK _5128_/D _5128_/Q gf180mcu_as_sc_mcu7t3v3__dfxtp_2
XPHY_EDGE_ROW_179_Left_371 VDD VSS gf180mcu_as_sc_mcu7t3v3__tap_2
X_5059_ VDD VDD VSS VSS _5175_/CLK _5059_/D _5059_/Q gf180mcu_as_sc_mcu7t3v3__dfxtp_2
XFILLER_169_6 VDD VDD VSS VSS gf180mcu_as_sc_mcu7t3v3__fillcap_16
XPHY_EDGE_ROW_188_Left_380 VDD VSS gf180mcu_as_sc_mcu7t3v3__tap_2
XFILLER_112_2 VDD VDD VSS VSS gf180mcu_as_sc_mcu7t3v3__fillcap_8
XFILLER_154_737 VDD VDD VSS VSS gf180mcu_as_sc_mcu7t3v3__fillcap_16
XFILLER_166_597 VDD VDD VSS VSS gf180mcu_as_sc_mcu7t3v3__fillcap_8
XFILLER_5_769 VDD VDD VSS VSS gf180mcu_as_sc_mcu7t3v3__fill_1
XFILLER_1_920 VDD VDD VSS VSS gf180mcu_as_sc_mcu7t3v3__fillcap_4
XFILLER_96_33 VDD VDD VSS VSS gf180mcu_as_sc_mcu7t3v3__fill_2
XFILLER_171_1049 VDD VDD VSS VSS gf180mcu_as_sc_mcu7t3v3__fill_1
XTAP_TAPCELL_ROW_163_1337 VDD VSS gf180mcu_as_sc_mcu7t3v3__tap_2
XFILLER_152_83 VDD VDD VSS VSS gf180mcu_as_sc_mcu7t3v3__fill_1
XTAP_TAPCELL_ROW_163_1348 VDD VSS gf180mcu_as_sc_mcu7t3v3__tap_2
XTAP_TAPCELL_ROW_180_1673 VDD VSS gf180mcu_as_sc_mcu7t3v3__tap_2
XTAP_TAPCELL_ROW_180_1662 VDD VSS gf180mcu_as_sc_mcu7t3v3__tap_2
XFILLER_182_1123 VDD VDD VSS VSS gf180mcu_as_sc_mcu7t3v3__fillcap_16
XPHY_EDGE_ROW_45_1_Right_554 VDD VSS gf180mcu_as_sc_mcu7t3v3__tap_2
XFILLER_188_177 VDD VDD VSS VSS gf180mcu_as_sc_mcu7t3v3__fillcap_4
XFILLER_157_553 VDD VDD VSS VSS gf180mcu_as_sc_mcu7t3v3__fillcap_4
XFILLER_169_380 VDD VDD VSS VSS gf180mcu_as_sc_mcu7t3v3__fill_1
X_2760_ VDD VDD VSS VSS _4691_/A _2765_/B _2765_/C _2809_/B _2810_/B gf180mcu_as_sc_mcu7t3v3__ao211_2
XFILLER_12_592 VDD VDD VSS VSS gf180mcu_as_sc_mcu7t3v3__fill_2
XFILLER_184_372 VDD VDD VSS VSS gf180mcu_as_sc_mcu7t3v3__fillcap_8
XFILLER_185_884 VDD VDD VSS VSS gf180mcu_as_sc_mcu7t3v3__fill_2
XFILLER_8_541 VDD VDD VSS VSS gf180mcu_as_sc_mcu7t3v3__fill_2
X_2691_ VDD VDD VSS VSS _2692_/B _2699_/D _2691_/B _2691_/C gf180mcu_as_sc_mcu7t3v3__ao21_2
XANTENNA_2 VDD VDD VSS VSS _4775_/D gf180mcu_as_sc_mcu7t3v3__diode_2
XFILLER_172_523 VDD VDD VSS VSS gf180mcu_as_sc_mcu7t3v3__fill_2
X_4430_ VDD VDD VSS VSS _4431_/D _4430_/B _4560_/A gf180mcu_as_sc_mcu7t3v3__nor2_2
XFILLER_119_1301 VDD VDD VSS VSS gf180mcu_as_sc_mcu7t3v3__fill_1
XFILLER_6_64 VDD VDD VSS VSS gf180mcu_as_sc_mcu7t3v3__fillcap_4
XFILLER_119_1323 VDD VDD VSS VSS gf180mcu_as_sc_mcu7t3v3__fill_1
X_4361_ VDD VDD VSS VSS _4696_/B _4563_/C _4361_/C _4554_/B _4362_/C gf180mcu_as_sc_mcu7t3v3__ao22_2
XTAP_TAPCELL_ROW_187_1805 VDD VSS gf180mcu_as_sc_mcu7t3v3__tap_2
Xfanout509 VDD VDD VSS VSS _3775_/B _3803_/B gf180mcu_as_sc_mcu7t3v3__buff_12
X_4292_ VDD VDD VSS VSS _4329_/A _4327_/C _4627_/B _4297_/S gf180mcu_as_sc_mcu7t3v3__mux2_2
X_3312_ VDD VDD VSS VSS _4919_/Q _3369_/B _3369_/C _3967_/A _3313_/C gf180mcu_as_sc_mcu7t3v3__ao22_2
X_3243_ VDD VDD VSS VSS _4804_/D _3738_/D _3243_/B _3243_/A gf180mcu_as_sc_mcu7t3v3__aoi21_2
XFILLER_6_1013 VDD VDD VSS VSS gf180mcu_as_sc_mcu7t3v3__fill_2
Xmesh_tile_935 VDD VDD VSS VSS ne_out[9] gf180mcu_as_sc_mcu7t3v3__tiel_4
XPHY_EDGE_ROW_106_3_Right_147 VDD VSS gf180mcu_as_sc_mcu7t3v3__tap_2
Xmesh_tile_968 VDD VDD VSS VSS north_out[8] gf180mcu_as_sc_mcu7t3v3__tiel_4
Xmesh_tile_957 VDD VDD VSS VSS ne_out[31] gf180mcu_as_sc_mcu7t3v3__tiel_4
Xmesh_tile_946 VDD VDD VSS VSS ne_out[20] gf180mcu_as_sc_mcu7t3v3__tiel_4
X_3174_ VDD VDD VSS VSS _3174_/B _3907_/A _4797_/D gf180mcu_as_sc_mcu7t3v3__and2_2
XTAP_TAPCELL_ROW_2_728 VDD VSS gf180mcu_as_sc_mcu7t3v3__tap_2
Xmesh_tile_979 VDD VDD VSS VSS north_out[19] gf180mcu_as_sc_mcu7t3v3__tiel_4
XFILLER_130_1280 VDD VDD VSS VSS gf180mcu_as_sc_mcu7t3v3__fillcap_8
XFILLER_130_1291 VDD VDD VSS VSS gf180mcu_as_sc_mcu7t3v3__fillcap_4
XFILLER_126_1305 VDD VDD VSS VSS gf180mcu_as_sc_mcu7t3v3__fillcap_4
XFILLER_165_1354 VDD VDD VSS VSS gf180mcu_as_sc_mcu7t3v3__fill_1
XFILLER_168_807 VDD VDD VSS VSS gf180mcu_as_sc_mcu7t3v3__fillcap_4
X_2958_ VDD VDD VSS VSS _3043_/S _3938_/D _3942_/A _2961_/B gf180mcu_as_sc_mcu7t3v3__mux2_2
XFILLER_157_39 VDD VDD VSS VSS gf180mcu_as_sc_mcu7t3v3__fillcap_16
X_4628_ VDD VDD VSS VSS _4628_/S _4628_/B _4628_/A _4629_/D gf180mcu_as_sc_mcu7t3v3__mux2_2
X_2889_ VDD VDD VSS VSS _3548_/A _3776_/A _3776_/B _3227_/S gf180mcu_as_sc_mcu7t3v3__nand3_2
XFILLER_85_1322 VDD VDD VSS VSS gf180mcu_as_sc_mcu7t3v3__fill_2
X_4559_ VDD VDD VSS VSS _4559_/S _5027_/Q _5056_/Q _4560_/B gf180mcu_as_sc_mcu7t3v3__mux2_2
XFILLER_173_38 VDD VDD VSS VSS gf180mcu_as_sc_mcu7t3v3__fill_2
XFILLER_170_1082 VDD VDD VSS VSS gf180mcu_as_sc_mcu7t3v3__fill_2
XFILLER_13_334 VDD VDD VSS VSS gf180mcu_as_sc_mcu7t3v3__fillcap_4
XFILLER_158_317 VDD VDD VSS VSS gf180mcu_as_sc_mcu7t3v3__fillcap_16
XFILLER_107_1260 VDD VDD VSS VSS gf180mcu_as_sc_mcu7t3v3__fill_2
XFILLER_167_884 VDD VDD VSS VSS gf180mcu_as_sc_mcu7t3v3__fillcap_16
XFILLER_154_523 VDD VDD VSS VSS gf180mcu_as_sc_mcu7t3v3__fill_2
XFILLER_182_865 VDD VDD VSS VSS gf180mcu_as_sc_mcu7t3v3__fill_2
XFILLER_31_72 VDD VDD VSS VSS gf180mcu_as_sc_mcu7t3v3__fillcap_4
XFILLER_31_94 VDD VDD VSS VSS gf180mcu_as_sc_mcu7t3v3__fill_1
XFILLER_181_364 VDD VDD VSS VSS gf180mcu_as_sc_mcu7t3v3__fill_2
XPHY_EDGE_ROW_39_1_Left_231 VDD VSS gf180mcu_as_sc_mcu7t3v3__tap_2
XTAP_TAPCELL_ROW_9_861 VDD VSS gf180mcu_as_sc_mcu7t3v3__tap_2
XFILLER_1_772 VDD VDD VSS VSS gf180mcu_as_sc_mcu7t3v3__fillcap_8
XFILLER_27_1272 VDD VDD VSS VSS gf180mcu_as_sc_mcu7t3v3__fillcap_16
XTAP_TAPCELL_ROW_182_1702 VDD VSS gf180mcu_as_sc_mcu7t3v3__tap_2
XFILLER_114_1264 VDD VDD VSS VSS gf180mcu_as_sc_mcu7t3v3__fill_2
Xinput150 VDD VDD VSS VSS nw_in[13] _4038_/A gf180mcu_as_sc_mcu7t3v3__buff_12
Xinput161 VDD VDD VSS VSS nw_in[23] _4119_/A gf180mcu_as_sc_mcu7t3v3__buff_12
Xinput172 VDD VDD VSS VSS nw_in[33] _3553_/A gf180mcu_as_sc_mcu7t3v3__buff_12
XTAP_TAPCELL_ROW_182_1713 VDD VSS gf180mcu_as_sc_mcu7t3v3__tap_2
XFILLER_149_1305 VDD VDD VSS VSS gf180mcu_as_sc_mcu7t3v3__fillcap_4
Xinput183 VDD VDD VSS VSS se_in[11] wire882/A gf180mcu_as_sc_mcu7t3v3__buff_12
Xinput194 VDD VDD VSS VSS se_in[21] _4105_/A gf180mcu_as_sc_mcu7t3v3__buff_12
X_3930_ VDD VDD VSS VSS _3930_/A _4160_/C _4129_/C _4915_/Q _3934_/C gf180mcu_as_sc_mcu7t3v3__ao22_2
X_3861_ VDD VDD VSS VSS _5127_/Q _4691_/A _3862_/C gf180mcu_as_sc_mcu7t3v3__and2_2
XPHY_EDGE_ROW_46_1_Right_555 VDD VSS gf180mcu_as_sc_mcu7t3v3__tap_2
X_3792_ VDD VDD VSS VSS _3792_/A _3792_/B _3792_/C _3792_/D _3793_/C gf180mcu_as_sc_mcu7t3v3__ao211_2
X_2812_ VDD VDD VSS VSS _2818_/S _2812_/B _4755_/Q _4754_/D gf180mcu_as_sc_mcu7t3v3__mux2_2
XFILLER_164_309 VDD VDD VSS VSS gf180mcu_as_sc_mcu7t3v3__fillcap_4
XFILLER_192_607 VDD VDD VSS VSS gf180mcu_as_sc_mcu7t3v3__fillcap_4
XFILLER_192_618 VDD VDD VSS VSS gf180mcu_as_sc_mcu7t3v3__fillcap_4
XFILLER_75_2 VDD VDD VSS VSS gf180mcu_as_sc_mcu7t3v3__fillcap_4
X_2743_ VDD VDD VSS VSS _4947_/Q _2743_/B _2743_/A _5484_/A gf180mcu_as_sc_mcu7t3v3__mux2_2
XFILLER_173_821 VDD VDD VSS VSS gf180mcu_as_sc_mcu7t3v3__fill_1
XFILLER_173_832 VDD VDD VSS VSS gf180mcu_as_sc_mcu7t3v3__fillcap_8
XFILLER_34_1287 VDD VDD VSS VSS gf180mcu_as_sc_mcu7t3v3__fill_2
XFILLER_69_1317 VDD VDD VSS VSS gf180mcu_as_sc_mcu7t3v3__fillcap_4
XFILLER_121_1268 VDD VDD VSS VSS gf180mcu_as_sc_mcu7t3v3__fillcap_16
XFILLER_184_191 VDD VDD VSS VSS gf180mcu_as_sc_mcu7t3v3__fill_2
X_2674_ VDD VDD VSS VSS _5198_/Q _2858_/B _2674_/C _2674_/D _2676_/C gf180mcu_as_sc_mcu7t3v3__ao211_2
X_4413_ VDD VDD VSS VSS _4414_/D _4413_/B _4502_/A gf180mcu_as_sc_mcu7t3v3__nor2_2
X_4344_ VDD VDD VSS VSS _4350_/C _4344_/B _4344_/C _4345_/C _4554_/B gf180mcu_as_sc_mcu7t3v3__aoi211_2
XTAP_TAPCELL_ROW_119_3_2030 VDD VSS gf180mcu_as_sc_mcu7t3v3__tap_2
XFILLER_154_1055 VDD VDD VSS VSS gf180mcu_as_sc_mcu7t3v3__fill_1
XFILLER_100_103 VDD VDD VSS VSS gf180mcu_as_sc_mcu7t3v3__fill_2
X_4275_ VDD VDD VSS VSS _4275_/S _4692_/B _5109_/Q _5109_/D gf180mcu_as_sc_mcu7t3v3__mux2_2
X_3226_ VDD VDD VSS VSS _3914_/A _3247_/B _3228_/A _3229_/C _3226_/D gf180mcu_as_sc_mcu7t3v3__oai211_2
X_3157_ VDD VDD VSS VSS _4132_/A _3182_/B _3157_/C _4795_/D _3775_/D gf180mcu_as_sc_mcu7t3v3__aoi211_2
XPHY_EDGE_ROW_106_3_Left_478 VDD VSS gf180mcu_as_sc_mcu7t3v3__tap_2
XPHY_EDGE_ROW_107_3_Right_148 VDD VSS gf180mcu_as_sc_mcu7t3v3__tap_2
XPHY_EDGE_ROW_40_3_Right_81 VDD VSS gf180mcu_as_sc_mcu7t3v3__tap_2
X_3088_ VDD VDD VSS VSS _3131_/A _3088_/B _3088_/C _3089_/C gf180mcu_as_sc_mcu7t3v3__nor3_2
XPHY_EDGE_ROW_6_Left_199 VDD VSS gf180mcu_as_sc_mcu7t3v3__tap_2
XPHY_EDGE_ROW_43_3_Left_415 VDD VSS gf180mcu_as_sc_mcu7t3v3__tap_2
XFILLER_52_49 VDD VDD VSS VSS gf180mcu_as_sc_mcu7t3v3__fillcap_4
XFILLER_10_359 VDD VDD VSS VSS gf180mcu_as_sc_mcu7t3v3__fillcap_4
XFILLER_184_37 VDD VDD VSS VSS gf180mcu_as_sc_mcu7t3v3__fillcap_16
XFILLER_117_42 VDD VDD VSS VSS gf180mcu_as_sc_mcu7t3v3__fill_1
Xfanout840 VDD VDD VSS VSS _4975_/D _4751_/A gf180mcu_as_sc_mcu7t3v3__buff_12
XPHY_EDGE_ROW_69_3_Right_110 VDD VSS gf180mcu_as_sc_mcu7t3v3__tap_2
Xfanout884 VDD VDD VSS VSS _3654_/D _3638_/D gf180mcu_as_sc_mcu7t3v3__buff_12
Xfanout895 VDD VDD VSS VSS _3803_/C _3805_/C gf180mcu_as_sc_mcu7t3v3__buff_12
XFILLER_93_67 VDD VDD VSS VSS gf180mcu_as_sc_mcu7t3v3__fill_2
XFILLER_26_83 VDD VDD VSS VSS gf180mcu_as_sc_mcu7t3v3__fillcap_4
XFILLER_96_1281 VDD VDD VSS VSS gf180mcu_as_sc_mcu7t3v3__fill_1
XFILLER_13_120 VDD VDD VSS VSS gf180mcu_as_sc_mcu7t3v3__fillcap_16
XFILLER_183_1262 VDD VDD VSS VSS gf180mcu_as_sc_mcu7t3v3__fillcap_16
XFILLER_183_1284 VDD VDD VSS VSS gf180mcu_as_sc_mcu7t3v3__fill_1
XFILLER_159_648 VDD VDD VSS VSS gf180mcu_as_sc_mcu7t3v3__fillcap_4
XFILLER_186_489 VDD VDD VSS VSS gf180mcu_as_sc_mcu7t3v3__fillcap_8
XTAP_TAPCELL_ROW_158_1247 VDD VSS gf180mcu_as_sc_mcu7t3v3__tap_2
XFILLER_167_681 VDD VDD VSS VSS gf180mcu_as_sc_mcu7t3v3__fillcap_16
XTAP_TAPCELL_ROW_62_1_1015 VDD VSS gf180mcu_as_sc_mcu7t3v3__tap_2
XTAP_TAPCELL_ROW_175_1572 VDD VSS gf180mcu_as_sc_mcu7t3v3__tap_2
XFILLER_158_93 VDD VDD VSS VSS gf180mcu_as_sc_mcu7t3v3__fill_1
XFILLER_5_352 VDD VDD VSS VSS gf180mcu_as_sc_mcu7t3v3__fillcap_4
XFILLER_155_1320 VDD VDD VSS VSS gf180mcu_as_sc_mcu7t3v3__fillcap_4
XFILLER_170_846 VDD VDD VSS VSS gf180mcu_as_sc_mcu7t3v3__fillcap_16
XFILLER_29_1323 VDD VDD VSS VSS gf180mcu_as_sc_mcu7t3v3__fill_1
X_2390_ VDD VDD VSS VSS _2534_/A _5277_/Q gf180mcu_as_sc_mcu7t3v3__inv_2
XFILLER_3_43 VDD VDD VSS VSS gf180mcu_as_sc_mcu7t3v3__fillcap_8
X_4060_ VDD VDD VSS VSS _4993_/Q _4150_/B _4244_/B _4150_/D _4993_/D gf180mcu_as_sc_mcu7t3v3__ao22_2
X_3011_ VDD VDD VSS VSS _3046_/B _4922_/Q _3012_/D gf180mcu_as_sc_mcu7t3v3__or2_2
XFILLER_188_1184 VDD VDD VSS VSS gf180mcu_as_sc_mcu7t3v3__fillcap_16
XFILLER_40_1291 VDD VDD VSS VSS gf180mcu_as_sc_mcu7t3v3__fill_2
XFILLER_178_902 VDD VDD VSS VSS gf180mcu_as_sc_mcu7t3v3__fill_1
X_4962_ VDD VDD VSS VSS _5164_/CLK _4962_/D _4962_/Q gf180mcu_as_sc_mcu7t3v3__dfxtp_2
X_4893_ VDD VDD VSS VSS _4895_/CLK _4893_/D _4893_/Q gf180mcu_as_sc_mcu7t3v3__dfxtp_2
X_3913_ VDD VDD VSS VSS _3913_/Y _4076_/D _4199_/A gf180mcu_as_sc_mcu7t3v3__nor2_2
XFILLER_123_1308 VDD VDD VSS VSS gf180mcu_as_sc_mcu7t3v3__fill_2
X_3844_ VDD VDD VSS VSS _4912_/D _4753_/A _3844_/B _3844_/A gf180mcu_as_sc_mcu7t3v3__aoi21_2
XFILLER_165_629 VDD VDD VSS VSS gf180mcu_as_sc_mcu7t3v3__fill_1
XPHY_EDGE_ROW_47_1_Right_556 VDD VSS gf180mcu_as_sc_mcu7t3v3__tap_2
XFILLER_164_139 VDD VDD VSS VSS gf180mcu_as_sc_mcu7t3v3__fillcap_16
XFILLER_192_437 VDD VDD VSS VSS gf180mcu_as_sc_mcu7t3v3__fillcap_4
XFILLER_192_448 VDD VDD VSS VSS gf180mcu_as_sc_mcu7t3v3__fillcap_4
X_3775_ VDD VDD VSS VSS _3775_/A _3775_/B _3775_/C _4866_/D _3775_/D gf180mcu_as_sc_mcu7t3v3__aoi211_2
XFILLER_161_802 VDD VDD VSS VSS gf180mcu_as_sc_mcu7t3v3__fill_1
X_2726_ VDD VDD VSS VSS _5163_/Q _4272_/S _4275_/S _5187_/Q _2727_/B gf180mcu_as_sc_mcu7t3v3__ao22_2
Xoutput410 VDD VDD VSS VSS _4830_/Q south_out[25] gf180mcu_as_sc_mcu7t3v3__buff_12
X_2657_ VDD VDD VSS VSS _2657_/Y _2723_/A _2657_/B _2657_/C _2657_/D gf180mcu_as_sc_mcu7t3v3__aoi22_2
Xoutput443 VDD VDD VSS VSS _4897_/Q west_out[24] gf180mcu_as_sc_mcu7t3v3__buff_12
Xoutput432 VDD VDD VSS VSS _4887_/Q west_out[14] gf180mcu_as_sc_mcu7t3v3__buff_12
Xoutput421 VDD VDD VSS VSS _4809_/Q south_out[4] gf180mcu_as_sc_mcu7t3v3__buff_12
XFILLER_160_367 VDD VDD VSS VSS gf180mcu_as_sc_mcu7t3v3__fillcap_4
XFILLER_82_1325 VDD VDD VSS VSS gf180mcu_as_sc_mcu7t3v3__fillcap_4
Xoutput454 VDD VDD VSS VSS _4876_/Q west_out[3] gf180mcu_as_sc_mcu7t3v3__buff_12
X_2588_ VDD VDD VSS VSS _2588_/Y _2588_/B _2588_/A gf180mcu_as_sc_mcu7t3v3__nand2b_2
X_4327_ VDD VDD VSS VSS _4328_/C _5233_/Q _4329_/A _4327_/C gf180mcu_as_sc_mcu7t3v3__ao21_2
X_4258_ VDD VDD VSS VSS _4260_/A _4258_/C _4259_/B _4643_/A gf180mcu_as_sc_mcu7t3v3__aoi21_2
X_3209_ VDD VDD VSS VSS _3209_/B _3907_/A _4800_/D gf180mcu_as_sc_mcu7t3v3__and2_2
X_4189_ VDD VDD VSS VSS _4249_/B _4189_/B _4189_/C _5027_/Q _5027_/D gf180mcu_as_sc_mcu7t3v3__ao22_2
XPHY_EDGE_ROW_108_3_Right_149 VDD VSS gf180mcu_as_sc_mcu7t3v3__tap_2
XFILLER_103_99 VDD VDD VSS VSS gf180mcu_as_sc_mcu7t3v3__fillcap_4
XFILLER_151_6 VDD VDD VSS VSS gf180mcu_as_sc_mcu7t3v3__fillcap_16
XFILLER_168_412 VDD VDD VSS VSS gf180mcu_as_sc_mcu7t3v3__fill_2
XFILLER_11_613 VDD VDD VSS VSS gf180mcu_as_sc_mcu7t3v3__fillcap_4
XFILLER_17_1260 VDD VDD VSS VSS gf180mcu_as_sc_mcu7t3v3__fill_2
XFILLER_13_1124 VDD VDD VSS VSS gf180mcu_as_sc_mcu7t3v3__fill_2
XFILLER_168_489 VDD VDD VSS VSS gf180mcu_as_sc_mcu7t3v3__fill_2
XFILLER_177_990 VDD VDD VSS VSS gf180mcu_as_sc_mcu7t3v3__fill_2
XFILLER_10_189 VDD VDD VSS VSS gf180mcu_as_sc_mcu7t3v3__fill_1
XFILLER_12_96 VDD VDD VSS VSS gf180mcu_as_sc_mcu7t3v3__fillcap_8
XFILLER_139_1326 VDD VDD VSS VSS gf180mcu_as_sc_mcu7t3v3__fill_2
XFILLER_152_824 VDD VDD VSS VSS gf180mcu_as_sc_mcu7t3v3__fill_1
XFILLER_163_150 VDD VDD VSS VSS gf180mcu_as_sc_mcu7t3v3__fillcap_4
XFILLER_178_1353 VDD VDD VSS VSS gf180mcu_as_sc_mcu7t3v3__fill_2
XFILLER_191_470 VDD VDD VSS VSS gf180mcu_as_sc_mcu7t3v3__fillcap_16
XTAP_TAPCELL_ROW_153_1155 VDD VSS gf180mcu_as_sc_mcu7t3v3__tap_2
XTAP_TAPCELL_ROW_153_1144 VDD VSS gf180mcu_as_sc_mcu7t3v3__tap_2
XFILLER_174_1239 VDD VDD VSS VSS gf180mcu_as_sc_mcu7t3v3__fill_2
XFILLER_191_492 VDD VDD VSS VSS gf180mcu_as_sc_mcu7t3v3__fillcap_16
XFILLER_88_34 VDD VDD VSS VSS gf180mcu_as_sc_mcu7t3v3__fill_1
XTAP_TAPCELL_ROW_170_1480 VDD VSS gf180mcu_as_sc_mcu7t3v3__tap_2
XFILLER_5_2 VDD VDD VSS VSS gf180mcu_as_sc_mcu7t3v3__fillcap_8
XTAP_TAPCELL_ROW_123_1_1076 VDD VSS gf180mcu_as_sc_mcu7t3v3__tap_2
XFILLER_24_1264 VDD VDD VSS VSS gf180mcu_as_sc_mcu7t3v3__fill_2
Xfanout670 VDD VDD VSS VSS _2930_/Y _3239_/A gf180mcu_as_sc_mcu7t3v3__buff_12
Xfanout681 VDD VDD VSS VSS _4611_/B _4609_/B gf180mcu_as_sc_mcu7t3v3__buff_12
Xfanout692 VDD VDD VSS VSS wire694/Y _3778_/B gf180mcu_as_sc_mcu7t3v3__buff_12
XFILLER_111_1256 VDD VDD VSS VSS gf180mcu_as_sc_mcu7t3v3__fillcap_8
XTAP_TAPCELL_ROW_177_1601 VDD VSS gf180mcu_as_sc_mcu7t3v3__tap_2
XTAP_TAPCELL_ROW_177_1612 VDD VSS gf180mcu_as_sc_mcu7t3v3__tap_2
XFILLER_159_489 VDD VDD VSS VSS gf180mcu_as_sc_mcu7t3v3__fill_1
XFILLER_174_437 VDD VDD VSS VSS gf180mcu_as_sc_mcu7t3v3__fillcap_4
XFILLER_179_1106 VDD VDD VSS VSS gf180mcu_as_sc_mcu7t3v3__fillcap_4
X_3560_ VDD VDD VSS VSS _3805_/B _3805_/A _3560_/Y gf180mcu_as_sc_mcu7t3v3__or2_2
XFILLER_154_150 VDD VDD VSS VSS gf180mcu_as_sc_mcu7t3v3__fillcap_16
XFILLER_183_982 VDD VDD VSS VSS gf180mcu_as_sc_mcu7t3v3__fillcap_4
X_2511_ VDD VDD VSS VSS _2517_/B _4662_/C _4708_/B _2511_/C gf180mcu_as_sc_mcu7t3v3__ao21_2
XTAP_TAPCELL_ROW_190_1856 VDD VSS gf180mcu_as_sc_mcu7t3v3__tap_2
X_5230_ VDD VDD VSS VSS _5232_/CLK _5230_/D _5230_/Q gf180mcu_as_sc_mcu7t3v3__dfxtp_2
X_3491_ VDD VDD VSS VSS _3505_/S _3491_/B _4148_/A _3492_/B gf180mcu_as_sc_mcu7t3v3__mux2_2
XTAP_TAPCELL_ROW_26_1_979 VDD VSS gf180mcu_as_sc_mcu7t3v3__tap_2
X_2442_ VDD VDD VSS VSS _4099_/A _2442_/A gf180mcu_as_sc_mcu7t3v3__inv_2
XFILLER_170_698 VDD VDD VSS VSS gf180mcu_as_sc_mcu7t3v3__fill_1
X_5161_ VDD VDD VSS VSS _5188_/CLK _5161_/D _5161_/Q gf180mcu_as_sc_mcu7t3v3__dfxtp_2
X_5092_ VDD VDD VSS VSS _5175_/CLK _5092_/D _5092_/Q gf180mcu_as_sc_mcu7t3v3__dfxtp_2
X_4112_ VDD VDD VSS VSS _4112_/A _4160_/C _4129_/C _4937_/Q _4113_/D gf180mcu_as_sc_mcu7t3v3__ao22_2
X_4043_ VDD VDD VSS VSS _4043_/A _4067_/B _4043_/C _4242_/B _4067_/D gf180mcu_as_sc_mcu7t3v3__aoi211_2
XFILLER_169_209 VDD VDD VSS VSS gf180mcu_as_sc_mcu7t3v3__fill_1
X_4945_ VDD VDD VSS VSS clkload1/A _4945_/D _4945_/Q gf180mcu_as_sc_mcu7t3v3__dfxtp_2
XFILLER_127_1296 VDD VDD VSS VSS gf180mcu_as_sc_mcu7t3v3__fill_2
X_4876_ VDD VDD VSS VSS clkload4/A _4876_/D _4876_/Q gf180mcu_as_sc_mcu7t3v3__dfxtp_2
XFILLER_177_275 VDD VDD VSS VSS gf180mcu_as_sc_mcu7t3v3__fillcap_4
XFILLER_177_286 VDD VDD VSS VSS gf180mcu_as_sc_mcu7t3v3__fill_2
XFILLER_192_212 VDD VDD VSS VSS gf180mcu_as_sc_mcu7t3v3__fill_1
X_3827_ VDD VDD VSS VSS _4908_/D _3827_/B _4246_/S gf180mcu_as_sc_mcu7t3v3__nor2_2
XPHY_EDGE_ROW_48_1_Right_557 VDD VSS gf180mcu_as_sc_mcu7t3v3__tap_2
X_3758_ VDD VDD VSS VSS _4136_/A _3772_/B _3758_/C _3803_/B _3759_/C gf180mcu_as_sc_mcu7t3v3__ao211_2
XFILLER_192_278 VDD VDD VSS VSS gf180mcu_as_sc_mcu7t3v3__fill_2
X_2709_ VDD VDD VSS VSS _2723_/A _2709_/B _2709_/C _2709_/D _2709_/Y gf180mcu_as_sc_mcu7t3v3__ao22_2
XFILLER_161_632 VDD VDD VSS VSS gf180mcu_as_sc_mcu7t3v3__fillcap_16
XFILLER_165_39 VDD VDD VSS VSS gf180mcu_as_sc_mcu7t3v3__fill_2
XFILLER_173_492 VDD VDD VSS VSS gf180mcu_as_sc_mcu7t3v3__fill_1
X_3689_ VDD VDD VSS VSS _3689_/D _4064_/D _3728_/B _3728_/C _3690_/C gf180mcu_as_sc_mcu7t3v3__ao31_2
XFILLER_0_815 VDD VDD VSS VSS gf180mcu_as_sc_mcu7t3v3__fill_1
XFILLER_173_1250 VDD VDD VSS VSS gf180mcu_as_sc_mcu7t3v3__fillcap_8
XFILLER_86_1291 VDD VDD VSS VSS gf180mcu_as_sc_mcu7t3v3__fillcap_8
XFILLER_134_1256 VDD VDD VSS VSS gf180mcu_as_sc_mcu7t3v3__fillcap_4
XFILLER_181_38 VDD VDD VSS VSS gf180mcu_as_sc_mcu7t3v3__fillcap_16
XFILLER_58_48 VDD VDD VSS VSS gf180mcu_as_sc_mcu7t3v3__fill_1
XPHY_EDGE_ROW_160_Left_352 VDD VSS gf180mcu_as_sc_mcu7t3v3__tap_2
XPHY_EDGE_ROW_48_1_Left_240 VDD VSS gf180mcu_as_sc_mcu7t3v3__tap_2
XFILLER_106_1303 VDD VDD VSS VSS gf180mcu_as_sc_mcu7t3v3__fill_2
XFILLER_12_944 VDD VDD VSS VSS gf180mcu_as_sc_mcu7t3v3__fill_1
XFILLER_142_2 VDD VDD VSS VSS gf180mcu_as_sc_mcu7t3v3__fill_1
XFILLER_180_1243 VDD VDD VSS VSS gf180mcu_as_sc_mcu7t3v3__fillcap_16
XPHY_EDGE_ROW_100_1_Left_292 VDD VSS gf180mcu_as_sc_mcu7t3v3__tap_2
XTAP_TAPCELL_ROW_142_3_2053 VDD VSS gf180mcu_as_sc_mcu7t3v3__tap_2
XFILLER_156_404 VDD VDD VSS VSS gf180mcu_as_sc_mcu7t3v3__fillcap_8
XFILLER_23_62 VDD VDD VSS VSS gf180mcu_as_sc_mcu7t3v3__fillcap_8
XTAP_TAPCELL_ROW_172_1520 VDD VSS gf180mcu_as_sc_mcu7t3v3__tap_2
XFILLER_152_610 VDD VDD VSS VSS gf180mcu_as_sc_mcu7t3v3__fill_2
XFILLER_165_993 VDD VDD VSS VSS gf180mcu_as_sc_mcu7t3v3__fillcap_8
XFILLER_183_267 VDD VDD VSS VSS gf180mcu_as_sc_mcu7t3v3__fill_2
XFILLER_180_963 VDD VDD VSS VSS gf180mcu_as_sc_mcu7t3v3__fillcap_8
XFILLER_155_72 VDD VDD VSS VSS gf180mcu_as_sc_mcu7t3v3__fillcap_8
XFILLER_191_1350 VDD VDD VSS VSS gf180mcu_as_sc_mcu7t3v3__fill_1
XTAP_TAPCELL_ROW_57_1_1010 VDD VSS gf180mcu_as_sc_mcu7t3v3__tap_2
XFILLER_0_33 VDD VDD VSS VSS gf180mcu_as_sc_mcu7t3v3__fill_1
XFILLER_179_529 VDD VDD VSS VSS gf180mcu_as_sc_mcu7t3v3__fill_2
XFILLER_185_1154 VDD VDD VSS VSS gf180mcu_as_sc_mcu7t3v3__fillcap_4
X_2991_ VDD VDD VSS VSS _3976_/A _3042_/B _3042_/C _3976_/D _2997_/B gf180mcu_as_sc_mcu7t3v3__ao22_2
XFILLER_175_702 VDD VDD VSS VSS gf180mcu_as_sc_mcu7t3v3__fill_1
XFILLER_187_562 VDD VDD VSS VSS gf180mcu_as_sc_mcu7t3v3__fillcap_16
X_4730_ VDD VDD VSS VSS _5251_/Q _4730_/B _4730_/C _5266_/Q _4731_/C gf180mcu_as_sc_mcu7t3v3__ao22_2
XFILLER_159_286 VDD VDD VSS VSS gf180mcu_as_sc_mcu7t3v3__fill_1
X_4661_ VDD VDD VSS VSS _4731_/B _5485_/A _5240_/Q _5240_/D gf180mcu_as_sc_mcu7t3v3__mux2_2
XTAP_TAPCELL_ROW_192_1918 VDD VSS gf180mcu_as_sc_mcu7t3v3__tap_2
XTAP_TAPCELL_ROW_192_1907 VDD VSS gf180mcu_as_sc_mcu7t3v3__tap_2
XTAP_TAPCELL_ROW_13_961 VDD VSS gf180mcu_as_sc_mcu7t3v3__tap_2
XTAP_TAPCELL_ROW_13_950 VDD VSS gf180mcu_as_sc_mcu7t3v3__tap_2
XFILLER_163_908 VDD VDD VSS VSS gf180mcu_as_sc_mcu7t3v3__fill_2
X_3612_ VDD VDD VSS VSS _4921_/Q _3648_/B _3649_/C _3981_/D _3613_/D gf180mcu_as_sc_mcu7t3v3__ao22_2
XFILLER_162_418 VDD VDD VSS VSS gf180mcu_as_sc_mcu7t3v3__fillcap_8
X_4592_ VDD VDD VSS VSS _5188_/Q _4592_/B _4592_/C _4592_/D _5188_/D gf180mcu_as_sc_mcu7t3v3__ao211_2
XFILLER_155_492 VDD VDD VSS VSS gf180mcu_as_sc_mcu7t3v3__fillcap_4
X_3543_ VDD VDD VSS VSS _3798_/A _3799_/B _3777_/B gf180mcu_as_sc_mcu7t3v3__nor2_2
XTAP_TAPCELL_ROW_77_3_1988 VDD VSS gf180mcu_as_sc_mcu7t3v3__tap_2
XFILLER_157_1256 VDD VDD VSS VSS gf180mcu_as_sc_mcu7t3v3__fillcap_4
XFILLER_192_1147 VDD VDD VSS VSS gf180mcu_as_sc_mcu7t3v3__fillcap_4
XPHY_EDGE_ROW_115_3_Left_487 VDD VSS gf180mcu_as_sc_mcu7t3v3__tap_2
X_3474_ VDD VDD VSS VSS _4126_/A _3496_/B _3496_/C _4127_/A _3475_/D gf180mcu_as_sc_mcu7t3v3__ao22_2
XFILLER_192_1158 VDD VDD VSS VSS gf180mcu_as_sc_mcu7t3v3__fillcap_4
X_5213_ VDD VDD VSS VSS _5216_/CLK _5213_/D _5213_/Q gf180mcu_as_sc_mcu7t3v3__dfxtp_2
X_2425_ VDD VDD VSS VSS _3953_/A _3302_/A gf180mcu_as_sc_mcu7t3v3__inv_2
X_5144_ VDD VDD VSS VSS _5152_/CLK _5144_/D _5144_/Q gf180mcu_as_sc_mcu7t3v3__dfxtp_2
XPHY_EDGE_ROW_52_3_Left_424 VDD VSS gf180mcu_as_sc_mcu7t3v3__tap_2
X_5075_ VDD VDD VSS VSS _5075_/CLK _5075_/D _5075_/Q gf180mcu_as_sc_mcu7t3v3__dfxtp_2
X_4026_ VDD VDD VSS VSS _4027_/C _4026_/B _4026_/A gf180mcu_as_sc_mcu7t3v3__nor2_2
XTAP_TAPCELL_ROW_0_689 VDD VSS gf180mcu_as_sc_mcu7t3v3__tap_2
XTAP_TAPCELL_ROW_0_678 VDD VSS gf180mcu_as_sc_mcu7t3v3__tap_2
XTAP_TAPCELL_ROW_0_667 VDD VSS gf180mcu_as_sc_mcu7t3v3__tap_2
X_4928_ VDD VDD VSS VSS clkload1/A _4928_/D _4928_/Q gf180mcu_as_sc_mcu7t3v3__dfxtp_2
XFILLER_165_212 VDD VDD VSS VSS gf180mcu_as_sc_mcu7t3v3__fillcap_16
XFILLER_166_724 VDD VDD VSS VSS gf180mcu_as_sc_mcu7t3v3__fill_1
XTAP_TAPCELL_ROW_11_909 VDD VSS gf180mcu_as_sc_mcu7t3v3__tap_2
XFILLER_53_1290 VDD VDD VSS VSS gf180mcu_as_sc_mcu7t3v3__fillcap_4
X_4859_ VDD VDD VSS VSS _5278_/CLK _4859_/D _4859_/Q gf180mcu_as_sc_mcu7t3v3__dfxtp_2
XPHY_EDGE_ROW_49_1_Right_558 VDD VSS gf180mcu_as_sc_mcu7t3v3__tap_2
XFILLER_140_1293 VDD VDD VSS VSS gf180mcu_as_sc_mcu7t3v3__fill_1
XFILLER_49_1326 VDD VDD VSS VSS gf180mcu_as_sc_mcu7t3v3__fill_2
XFILLER_162_963 VDD VDD VSS VSS gf180mcu_as_sc_mcu7t3v3__fill_2
XFILLER_136_1318 VDD VDD VSS VSS gf180mcu_as_sc_mcu7t3v3__fill_2
XFILLER_161_484 VDD VDD VSS VSS gf180mcu_as_sc_mcu7t3v3__fillcap_4
XTAP_TAPCELL_ROW_118_1_1071 VDD VSS gf180mcu_as_sc_mcu7t3v3__tap_2
XFILLER_21_1256 VDD VDD VSS VSS gf180mcu_as_sc_mcu7t3v3__fillcap_4
XTAP_TAPCELL_ROW_165_1390 VDD VSS gf180mcu_as_sc_mcu7t3v3__tap_2
XTAP_TAPCELL_ROW_25_1_978 VDD VSS gf180mcu_as_sc_mcu7t3v3__tap_2
XTAP_TAPCELL_ROW_161_1298 VDD VSS gf180mcu_as_sc_mcu7t3v3__tap_2
XFILLER_157_702 VDD VDD VSS VSS gf180mcu_as_sc_mcu7t3v3__fill_2
XFILLER_156_212 VDD VDD VSS VSS gf180mcu_as_sc_mcu7t3v3__fill_1
XFILLER_169_562 VDD VDD VSS VSS gf180mcu_as_sc_mcu7t3v3__fillcap_16
XFILLER_157_768 VDD VDD VSS VSS gf180mcu_as_sc_mcu7t3v3__fill_2
XFILLER_8_734 VDD VDD VSS VSS gf180mcu_as_sc_mcu7t3v3__fill_1
XFILLER_172_716 VDD VDD VSS VSS gf180mcu_as_sc_mcu7t3v3__fill_1
XFILLER_153_974 VDD VDD VSS VSS gf180mcu_as_sc_mcu7t3v3__fillcap_4
XFILLER_166_82 VDD VDD VSS VSS gf180mcu_as_sc_mcu7t3v3__fillcap_8
XFILLER_152_484 VDD VDD VSS VSS gf180mcu_as_sc_mcu7t3v3__fill_1
XFILLER_180_782 VDD VDD VSS VSS gf180mcu_as_sc_mcu7t3v3__fillcap_8
XFILLER_152_1153 VDD VDD VSS VSS gf180mcu_as_sc_mcu7t3v3__fill_2
X_3190_ VDD VDD VSS VSS _3237_/B _3204_/C _3227_/S gf180mcu_as_sc_mcu7t3v3__nor2_2
XTAP_TAPCELL_ROW_185_1766 VDD VSS gf180mcu_as_sc_mcu7t3v3__tap_2
XTAP_TAPCELL_ROW_185_1755 VDD VSS gf180mcu_as_sc_mcu7t3v3__tap_2
XFILLER_179_348 VDD VDD VSS VSS gf180mcu_as_sc_mcu7t3v3__fill_2
X_2974_ VDD VDD VSS VSS _3957_/A _3042_/B _3042_/C _3956_/A _2980_/B gf180mcu_as_sc_mcu7t3v3__ao22_2
X_4713_ VDD VDD VSS VSS _4717_/S _5259_/Q _5260_/Q _4714_/B gf180mcu_as_sc_mcu7t3v3__mux2_2
XFILLER_187_392 VDD VDD VSS VSS gf180mcu_as_sc_mcu7t3v3__fillcap_4
XFILLER_124_1299 VDD VDD VSS VSS gf180mcu_as_sc_mcu7t3v3__fillcap_4
XFILLER_159_1318 VDD VDD VSS VSS gf180mcu_as_sc_mcu7t3v3__fill_1
X_4644_ VDD VDD VSS VSS _4646_/C _4647_/A _4649_/C _4645_/B gf180mcu_as_sc_mcu7t3v3__nor3_2
XFILLER_190_535 VDD VDD VSS VSS gf180mcu_as_sc_mcu7t3v3__fill_2
X_4575_ VDD VDD VSS VSS _5188_/Q _4590_/B _4590_/C _5106_/Q _4576_/B gf180mcu_as_sc_mcu7t3v3__ao22_2
X_3526_ VDD VDD VSS VSS _3817_/B _3526_/B _3526_/C _3526_/D _3527_/B gf180mcu_as_sc_mcu7t3v3__ao211_2
XFILLER_170_281 VDD VDD VSS VSS gf180mcu_as_sc_mcu7t3v3__fill_1
XFILLER_39_39 VDD VDD VSS VSS gf180mcu_as_sc_mcu7t3v3__fillcap_4
X_3457_ VDD VDD VSS VSS _3501_/C _4113_/A _3458_/D gf180mcu_as_sc_mcu7t3v3__and2_2
XTAP_TAPCELL_ROW_25_3_1936 VDD VSS gf180mcu_as_sc_mcu7t3v3__tap_2
XFILLER_170_1220 VDD VDD VSS VSS gf180mcu_as_sc_mcu7t3v3__fillcap_4
XFILLER_44_1256 VDD VDD VSS VSS gf180mcu_as_sc_mcu7t3v3__fillcap_4
XFILLER_83_1272 VDD VDD VSS VSS gf180mcu_as_sc_mcu7t3v3__fillcap_8
XFILLER_83_1294 VDD VDD VSS VSS gf180mcu_as_sc_mcu7t3v3__fillcap_16
X_3388_ VDD VDD VSS VSS _4037_/D _3451_/B _3388_/C _3388_/D _3389_/A gf180mcu_as_sc_mcu7t3v3__ao22_2
X_2408_ VDD VDD VSS VSS _4364_/A _5160_/Q gf180mcu_as_sc_mcu7t3v3__inv_2
XFILLER_170_1275 VDD VDD VSS VSS gf180mcu_as_sc_mcu7t3v3__fillcap_8
XFILLER_29_104 VDD VDD VSS VSS gf180mcu_as_sc_mcu7t3v3__fill_1
X_5127_ VDD VDD VSS VSS _5220_/CLK _5127_/D _5127_/Q gf180mcu_as_sc_mcu7t3v3__dfxtp_2
X_5058_ VDD VDD VSS VSS clkload9/A _5058_/D _5058_/Q gf180mcu_as_sc_mcu7t3v3__dfxtp_2
XPHY_EDGE_ROW_2_Right_2 VDD VSS gf180mcu_as_sc_mcu7t3v3__tap_2
X_4009_ VDD VDD VSS VSS _4009_/A _4025_/B _4009_/C _4009_/D _4010_/B gf180mcu_as_sc_mcu7t3v3__ao211_2
XFILLER_164_1013 VDD VDD VSS VSS gf180mcu_as_sc_mcu7t3v3__fill_2
XFILLER_154_705 VDD VDD VSS VSS gf180mcu_as_sc_mcu7t3v3__fillcap_8
XFILLER_5_726 VDD VDD VSS VSS gf180mcu_as_sc_mcu7t3v3__fill_1
XFILLER_4_247 VDD VDD VSS VSS gf180mcu_as_sc_mcu7t3v3__fill_2
XFILLER_175_1186 VDD VDD VSS VSS gf180mcu_as_sc_mcu7t3v3__fillcap_4
XFILLER_62_1345 VDD VDD VSS VSS gf180mcu_as_sc_mcu7t3v3__fillcap_8
Xinput310 VDD VDD VSS VSS west_in[3] _3956_/D gf180mcu_as_sc_mcu7t3v3__buff_12
XTAP_TAPCELL_ROW_4_770 VDD VSS gf180mcu_as_sc_mcu7t3v3__tap_2
XTAP_TAPCELL_ROW_163_1338 VDD VSS gf180mcu_as_sc_mcu7t3v3__tap_2
XTAP_TAPCELL_ROW_163_1349 VDD VSS gf180mcu_as_sc_mcu7t3v3__tap_2
XFILLER_189_602 VDD VDD VSS VSS gf180mcu_as_sc_mcu7t3v3__fillcap_4
XTAP_TAPCELL_ROW_180_1674 VDD VSS gf180mcu_as_sc_mcu7t3v3__tap_2
XTAP_TAPCELL_ROW_180_1663 VDD VSS gf180mcu_as_sc_mcu7t3v3__tap_2
XFILLER_177_819 VDD VDD VSS VSS gf180mcu_as_sc_mcu7t3v3__fillcap_4
XFILLER_182_1157 VDD VDD VSS VSS gf180mcu_as_sc_mcu7t3v3__fillcap_8
XFILLER_185_852 VDD VDD VSS VSS gf180mcu_as_sc_mcu7t3v3__fillcap_16
XFILLER_184_340 VDD VDD VSS VSS gf180mcu_as_sc_mcu7t3v3__fillcap_16
X_2690_ VDD VDD VSS VSS _2735_/A _2690_/B _2690_/C _2734_/S _2691_/C gf180mcu_as_sc_mcu7t3v3__ao22_2
XANTENNA_3 VDD VDD VSS VSS _4788_/D gf180mcu_as_sc_mcu7t3v3__diode_2
XFILLER_184_384 VDD VDD VSS VSS gf180mcu_as_sc_mcu7t3v3__fill_1
XFILLER_8_597 VDD VDD VSS VSS gf180mcu_as_sc_mcu7t3v3__fillcap_16
X_4360_ VDD VDD VSS VSS _4366_/S _5161_/Q _4360_/A _4361_/C gf180mcu_as_sc_mcu7t3v3__mux2_2
XFILLER_67_1256 VDD VDD VSS VSS gf180mcu_as_sc_mcu7t3v3__fillcap_16
X_3311_ VDD VDD VSS VSS _3962_/A _3424_/B _3311_/C _4808_/D _3580_/D gf180mcu_as_sc_mcu7t3v3__aoi211_2
XFILLER_4_781 VDD VDD VSS VSS gf180mcu_as_sc_mcu7t3v3__fillcap_16
X_4291_ VDD VDD VSS VSS _4627_/B _4649_/A _4291_/A gf180mcu_as_sc_mcu7t3v3__nand2_2
XTAP_TAPCELL_ROW_187_1806 VDD VSS gf180mcu_as_sc_mcu7t3v3__tap_2
X_3242_ VDD VDD VSS VSS _4803_/D _3738_/D _3242_/B _3242_/A gf180mcu_as_sc_mcu7t3v3__aoi21_2
Xmesh_tile_936 VDD VDD VSS VSS ne_out[10] gf180mcu_as_sc_mcu7t3v3__tiel_4
X_3173_ VDD VDD VSS VSS _3194_/S _3173_/B _4148_/A _3174_/B gf180mcu_as_sc_mcu7t3v3__mux2_2
XFILLER_187_1002 VDD VDD VSS VSS gf180mcu_as_sc_mcu7t3v3__fill_2
Xmesh_tile_969 VDD VDD VSS VSS north_out[9] gf180mcu_as_sc_mcu7t3v3__tiel_4
Xmesh_tile_958 VDD VDD VSS VSS ne_out[32] gf180mcu_as_sc_mcu7t3v3__tiel_4
Xmesh_tile_947 VDD VDD VSS VSS ne_out[21] gf180mcu_as_sc_mcu7t3v3__tiel_4
XTAP_TAPCELL_ROW_2_729 VDD VSS gf180mcu_as_sc_mcu7t3v3__tap_2
XFILLER_176_830 VDD VDD VSS VSS gf180mcu_as_sc_mcu7t3v3__fill_1
X_2957_ VDD VDD VSS VSS _2964_/B _3047_/B _3943_/A gf180mcu_as_sc_mcu7t3v3__nand2_2
XFILLER_157_18 VDD VDD VSS VSS gf180mcu_as_sc_mcu7t3v3__fill_2
XFILLER_176_863 VDD VDD VSS VSS gf180mcu_as_sc_mcu7t3v3__fillcap_4
XFILLER_176_874 VDD VDD VSS VSS gf180mcu_as_sc_mcu7t3v3__fill_1
X_2888_ VDD VDD VSS VSS _3788_/A _3796_/A _3776_/B gf180mcu_as_sc_mcu7t3v3__or2_2
XTAP_TAPCELL_ROW_80_1_1033 VDD VSS gf180mcu_as_sc_mcu7t3v3__tap_2
XFILLER_175_384 VDD VDD VSS VSS gf180mcu_as_sc_mcu7t3v3__fill_2
XFILLER_50_1260 VDD VDD VSS VSS gf180mcu_as_sc_mcu7t3v3__fill_2
X_4627_ VDD VDD VSS VSS _4627_/B _4627_/A _4628_/A gf180mcu_as_sc_mcu7t3v3__and2_2
XFILLER_102_1350 VDD VDD VSS VSS gf180mcu_as_sc_mcu7t3v3__fillcap_4
XFILLER_190_387 VDD VDD VSS VSS gf180mcu_as_sc_mcu7t3v3__fillcap_16
XFILLER_1_206 VDD VDD VSS VSS gf180mcu_as_sc_mcu7t3v3__fillcap_4
X_4558_ VDD VDD VSS VSS _4561_/C _4998_/Q _4559_/S gf180mcu_as_sc_mcu7t3v3__nand2b_2
X_4489_ VDD VDD VSS VSS _4570_/S _5019_/Q _5048_/Q _4490_/B gf180mcu_as_sc_mcu7t3v3__mux2_2
X_3509_ VDD VDD VSS VSS _3511_/C _3518_/C _3509_/B _3509_/A gf180mcu_as_sc_mcu7t3v3__aoi21_2
XTAP_TAPCELL_ROW_24_1_977 VDD VSS gf180mcu_as_sc_mcu7t3v3__tap_2
XFILLER_106_77 VDD VDD VSS VSS gf180mcu_as_sc_mcu7t3v3__fill_2
XFILLER_181_6 VDD VDD VSS VSS gf180mcu_as_sc_mcu7t3v3__fillcap_16
XFILLER_122_76 VDD VDD VSS VSS gf180mcu_as_sc_mcu7t3v3__fill_2
XFILLER_92_1305 VDD VDD VSS VSS gf180mcu_as_sc_mcu7t3v3__fill_1
XFILLER_13_302 VDD VDD VSS VSS gf180mcu_as_sc_mcu7t3v3__fillcap_4
XFILLER_185_104 VDD VDD VSS VSS gf180mcu_as_sc_mcu7t3v3__fillcap_4
XFILLER_12_1019 VDD VDD VSS VSS gf180mcu_as_sc_mcu7t3v3__fill_1
XFILLER_181_310 VDD VDD VSS VSS gf180mcu_as_sc_mcu7t3v3__fillcap_4
XFILLER_177_1259 VDD VDD VSS VSS gf180mcu_as_sc_mcu7t3v3__fill_1
XFILLER_181_343 VDD VDD VSS VSS gf180mcu_as_sc_mcu7t3v3__fillcap_4
XFILLER_182_877 VDD VDD VSS VSS gf180mcu_as_sc_mcu7t3v3__fillcap_4
XFILLER_182_888 VDD VDD VSS VSS gf180mcu_as_sc_mcu7t3v3__fill_1
XFILLER_5_567 VDD VDD VSS VSS gf180mcu_as_sc_mcu7t3v3__fill_2
XTAP_TAPCELL_ROW_9_862 VDD VSS gf180mcu_as_sc_mcu7t3v3__tap_2
XFILLER_153_1270 VDD VDD VSS VSS gf180mcu_as_sc_mcu7t3v3__fillcap_4
XFILLER_163_72 VDD VDD VSS VSS gf180mcu_as_sc_mcu7t3v3__fillcap_8
XFILLER_7_1323 VDD VDD VSS VSS gf180mcu_as_sc_mcu7t3v3__fillcap_4
Xinput140 VDD VDD VSS VSS north_in[4] _3967_/A gf180mcu_as_sc_mcu7t3v3__buff_12
Xinput151 VDD VDD VSS VSS nw_in[14] _4048_/A gf180mcu_as_sc_mcu7t3v3__buff_12
Xinput162 VDD VDD VSS VSS nw_in[24] _4127_/A gf180mcu_as_sc_mcu7t3v3__buff_12
XTAP_TAPCELL_ROW_182_1703 VDD VSS gf180mcu_as_sc_mcu7t3v3__tap_2
Xinput173 VDD VDD VSS VSS nw_in[3] _3957_/A gf180mcu_as_sc_mcu7t3v3__buff_12
Xinput184 VDD VDD VSS VSS se_in[12] _4033_/A gf180mcu_as_sc_mcu7t3v3__buff_12
Xinput195 VDD VDD VSS VSS se_in[22] _4114_/A gf180mcu_as_sc_mcu7t3v3__buff_12
XPHY_EDGE_ROW_124_3_Left_496 VDD VSS gf180mcu_as_sc_mcu7t3v3__tap_2
XFILLER_176_104 VDD VDD VSS VSS gf180mcu_as_sc_mcu7t3v3__fill_1
XFILLER_189_487 VDD VDD VSS VSS gf180mcu_as_sc_mcu7t3v3__fill_2
X_3860_ VDD VDD VSS VSS _5128_/Q _5129_/Q _5130_/Q _3871_/B gf180mcu_as_sc_mcu7t3v3__nor3_2
X_4873__1095 VDD VDD VSS VSS _4873_/D gf180mcu_as_sc_mcu7t3v3__tiel_4
X_3791_ VDD VDD VSS VSS _3791_/A _3791_/B _3791_/C _3799_/D _3792_/C gf180mcu_as_sc_mcu7t3v3__ao22_2
X_2811_ VDD VDD VSS VSS _4953_/D _2811_/C _2841_/A _4719_/A gf180mcu_as_sc_mcu7t3v3__aoi21_2
XFILLER_158_885 VDD VDD VSS VSS gf180mcu_as_sc_mcu7t3v3__fill_2
XFILLER_160_1241 VDD VDD VSS VSS gf180mcu_as_sc_mcu7t3v3__fillcap_4
X_2742_ VDD VDD VSS VSS _4947_/Q _2742_/B _2742_/A _5483_/A gf180mcu_as_sc_mcu7t3v3__mux2_2
XPHY_EDGE_ROW_61_3_Left_433 VDD VSS gf180mcu_as_sc_mcu7t3v3__tap_2
XFILLER_9_884 VDD VDD VSS VSS gf180mcu_as_sc_mcu7t3v3__fill_2
XFILLER_68_2 VDD VDD VSS VSS gf180mcu_as_sc_mcu7t3v3__fill_1
X_4412_ VDD VDD VSS VSS _4456_/S _5010_/Q _5039_/Q _4413_/B gf180mcu_as_sc_mcu7t3v3__mux2_2
X_2673_ VDD VDD VSS VSS _2673_/B _5134_/Q _2674_/D gf180mcu_as_sc_mcu7t3v3__and2_2
XFILLER_172_387 VDD VDD VSS VSS gf180mcu_as_sc_mcu7t3v3__fillcap_8
XFILLER_173_899 VDD VDD VSS VSS gf180mcu_as_sc_mcu7t3v3__fillcap_8
XTAP_TAPCELL_ROW_141_1_1094 VDD VSS gf180mcu_as_sc_mcu7t3v3__tap_2
X_4343_ VDD VDD VSS VSS _4350_/A _4718_/A _4344_/C gf180mcu_as_sc_mcu7t3v3__and2_2
X_4274_ VDD VDD VSS VSS _4281_/S _4718_/A _5108_/Q _5108_/D gf180mcu_as_sc_mcu7t3v3__mux2_2
XFILLER_132_1310 VDD VDD VSS VSS gf180mcu_as_sc_mcu7t3v3__fillcap_8
X_3225_ VDD VDD VSS VSS _3226_/D _3225_/B _3225_/A gf180mcu_as_sc_mcu7t3v3__nand2_2
XFILLER_189_1119 VDD VDD VSS VSS gf180mcu_as_sc_mcu7t3v3__fill_1
X_3156_ VDD VDD VSS VSS _3182_/B _3156_/B _3156_/C _3157_/C gf180mcu_as_sc_mcu7t3v3__nor3_2
X_3087_ VDD VDD VSS VSS _4066_/A _3130_/B _3087_/C _3087_/D _3088_/C gf180mcu_as_sc_mcu7t3v3__ao22_2
XFILLER_11_806 VDD VDD VSS VSS gf180mcu_as_sc_mcu7t3v3__fill_1
XFILLER_11_817 VDD VDD VSS VSS gf180mcu_as_sc_mcu7t3v3__fillcap_16
XFILLER_11_839 VDD VDD VSS VSS gf180mcu_as_sc_mcu7t3v3__fill_1
XFILLER_176_660 VDD VDD VSS VSS gf180mcu_as_sc_mcu7t3v3__fillcap_4
X_3989_ VDD VDD VSS VSS _3989_/A _4021_/C _4024_/C _3989_/D _3991_/C gf180mcu_as_sc_mcu7t3v3__ao22_2
XFILLER_163_310 VDD VDD VSS VSS gf180mcu_as_sc_mcu7t3v3__fillcap_8
XFILLER_182_107 VDD VDD VSS VSS gf180mcu_as_sc_mcu7t3v3__fill_2
XFILLER_175_192 VDD VDD VSS VSS gf180mcu_as_sc_mcu7t3v3__fillcap_16
XFILLER_191_674 VDD VDD VSS VSS gf180mcu_as_sc_mcu7t3v3__fill_1
XFILLER_117_54 VDD VDD VSS VSS gf180mcu_as_sc_mcu7t3v3__fill_1
XTAP_TAPCELL_ROW_6_810 VDD VSS gf180mcu_as_sc_mcu7t3v3__tap_2
Xdelaybuf_0_clk VDD VDD VSS VSS clk delaybuf_1_clk/A gf180mcu_as_sc_mcu7t3v3__clkbuff_12
Xfanout830 VDD VDD VSS VSS _4586_/S _4473_/A gf180mcu_as_sc_mcu7t3v3__buff_12
Xfanout841 VDD VDD VSS VSS _4974_/Q _4975_/D gf180mcu_as_sc_mcu7t3v3__buff_12
Xfanout885 VDD VDD VSS VSS _3615_/D _3654_/D gf180mcu_as_sc_mcu7t3v3__buff_12
XFILLER_133_64 VDD VDD VSS VSS gf180mcu_as_sc_mcu7t3v3__fillcap_4
Xfanout896 VDD VDD VSS VSS _3803_/C _2851_/A gf180mcu_as_sc_mcu7t3v3__buff_12
XFILLER_172_2 VDD VDD VSS VSS gf180mcu_as_sc_mcu7t3v3__fillcap_16
XFILLER_13_154 VDD VDD VSS VSS gf180mcu_as_sc_mcu7t3v3__fillcap_16
XFILLER_187_958 VDD VDD VSS VSS gf180mcu_as_sc_mcu7t3v3__fillcap_16
XFILLER_186_457 VDD VDD VSS VSS gf180mcu_as_sc_mcu7t3v3__fillcap_16
XTAP_TAPCELL_ROW_158_1248 VDD VSS gf180mcu_as_sc_mcu7t3v3__tap_2
XTAP_TAPCELL_ROW_175_1573 VDD VSS gf180mcu_as_sc_mcu7t3v3__tap_2
XTAP_TAPCELL_ROW_175_1562 VDD VSS gf180mcu_as_sc_mcu7t3v3__tap_2
XFILLER_154_321 VDD VDD VSS VSS gf180mcu_as_sc_mcu7t3v3__fill_2
XFILLER_155_844 VDD VDD VSS VSS gf180mcu_as_sc_mcu7t3v3__fill_1
XFILLER_120_1291 VDD VDD VSS VSS gf180mcu_as_sc_mcu7t3v3__fillcap_16
XFILLER_155_1310 VDD VDD VSS VSS gf180mcu_as_sc_mcu7t3v3__fill_2
XFILLER_155_1332 VDD VDD VSS VSS gf180mcu_as_sc_mcu7t3v3__fill_1
XFILLER_190_1223 VDD VDD VSS VSS gf180mcu_as_sc_mcu7t3v3__fill_2
XFILLER_116_1327 VDD VDD VSS VSS gf180mcu_as_sc_mcu7t3v3__fill_1
XFILLER_190_1289 VDD VDD VSS VSS gf180mcu_as_sc_mcu7t3v3__fill_2
X_3010_ VDD VDD VSS VSS _3045_/A _3010_/B _3010_/C _3045_/D _3012_/C gf180mcu_as_sc_mcu7t3v3__ao211_2
X_4961_ VDD VDD VSS VSS _5164_/CLK _4961_/D _4961_/Q gf180mcu_as_sc_mcu7t3v3__dfxtp_2
X_4892_ VDD VDD VSS VSS _4895_/CLK _4892_/D _4892_/Q gf180mcu_as_sc_mcu7t3v3__dfxtp_2
X_3912_ VDD VDD VSS VSS _4198_/A _4908_/Q _3912_/Y gf180mcu_as_sc_mcu7t3v3__and2_2
XTAP_TAPCELL_ROW_23_1_976 VDD VSS gf180mcu_as_sc_mcu7t3v3__tap_2
XFILLER_149_104 VDD VDD VSS VSS gf180mcu_as_sc_mcu7t3v3__fill_1
X_3843_ VDD VDD VSS VSS _3843_/S _3843_/B _3845_/A _3844_/B gf180mcu_as_sc_mcu7t3v3__mux2_2
XFILLER_158_682 VDD VDD VSS VSS gf180mcu_as_sc_mcu7t3v3__fillcap_16
XFILLER_164_107 VDD VDD VSS VSS gf180mcu_as_sc_mcu7t3v3__fillcap_4
XFILLER_192_427 VDD VDD VSS VSS gf180mcu_as_sc_mcu7t3v3__fillcap_4
X_3774_ VDD VDD VSS VSS _4155_/A _3802_/B _3803_/B _3775_/C _3774_/D gf180mcu_as_sc_mcu7t3v3__aoi211_2
X_2725_ VDD VDD VSS VSS _2732_/S _4963_/Q _4972_/Q _2727_/A gf180mcu_as_sc_mcu7t3v3__mux2_2
XFILLER_160_302 VDD VDD VSS VSS gf180mcu_as_sc_mcu7t3v3__fill_1
Xoutput411 VDD VDD VSS VSS _4831_/Q south_out[26] gf180mcu_as_sc_mcu7t3v3__buff_12
Xoutput400 VDD VDD VSS VSS _4821_/Q south_out[16] gf180mcu_as_sc_mcu7t3v3__buff_12
X_2656_ VDD VDD VSS VSS _2666_/B _2656_/B _2656_/C _2722_/B _2657_/D gf180mcu_as_sc_mcu7t3v3__ao211_2
Xoutput444 VDD VDD VSS VSS _4898_/Q west_out[25] gf180mcu_as_sc_mcu7t3v3__buff_12
Xoutput433 VDD VDD VSS VSS _4888_/Q west_out[15] gf180mcu_as_sc_mcu7t3v3__buff_12
Xoutput422 VDD VDD VSS VSS _4810_/Q south_out[5] gf180mcu_as_sc_mcu7t3v3__buff_12
Xoutput455 VDD VDD VSS VSS _4877_/Q west_out[4] gf180mcu_as_sc_mcu7t3v3__buff_12
X_2587_ VDD VDD VSS VSS _2587_/Y _2588_/B _2588_/A gf180mcu_as_sc_mcu7t3v3__nand2_2
X_4326_ VDD VDD VSS VSS _4326_/S _5156_/Q _5155_/Q _5155_/D gf180mcu_as_sc_mcu7t3v3__mux2_2
X_4257_ VDD VDD VSS VSS _4257_/S _4257_/B _5093_/Q _5093_/D gf180mcu_as_sc_mcu7t3v3__mux2_2
X_4188_ VDD VDD VSS VSS _4248_/B _4189_/B _4189_/C _5026_/Q _5026_/D gf180mcu_as_sc_mcu7t3v3__ao22_2
X_3208_ VDD VDD VSS VSS _3209_/B _3794_/A _3218_/B _3208_/C gf180mcu_as_sc_mcu7t3v3__ao21_2
X_3139_ VDD VDD VSS VSS _3140_/C _3139_/C _3192_/C _4109_/A gf180mcu_as_sc_mcu7t3v3__aoi21_2
XFILLER_179_38 VDD VDD VSS VSS gf180mcu_as_sc_mcu7t3v3__fillcap_16
XFILLER_156_608 VDD VDD VSS VSS gf180mcu_as_sc_mcu7t3v3__fillcap_16
XFILLER_168_457 VDD VDD VSS VSS gf180mcu_as_sc_mcu7t3v3__fillcap_16
XFILLER_183_405 VDD VDD VSS VSS gf180mcu_as_sc_mcu7t3v3__fill_2
XFILLER_143_1280 VDD VDD VSS VSS gf180mcu_as_sc_mcu7t3v3__fillcap_16
XFILLER_104_1264 VDD VDD VSS VSS gf180mcu_as_sc_mcu7t3v3__fill_1
XFILLER_13_1158 VDD VDD VSS VSS gf180mcu_as_sc_mcu7t3v3__fillcap_16
XFILLER_178_1321 VDD VDD VSS VSS gf180mcu_as_sc_mcu7t3v3__fillcap_4
XFILLER_104_1286 VDD VDD VSS VSS gf180mcu_as_sc_mcu7t3v3__fill_2
XFILLER_104_1297 VDD VDD VSS VSS gf180mcu_as_sc_mcu7t3v3__fill_1
XFILLER_128_53 VDD VDD VSS VSS gf180mcu_as_sc_mcu7t3v3__fill_2
XFILLER_152_803 VDD VDD VSS VSS gf180mcu_as_sc_mcu7t3v3__fillcap_8
XFILLER_164_663 VDD VDD VSS VSS gf180mcu_as_sc_mcu7t3v3__fill_2
XFILLER_192_983 VDD VDD VSS VSS gf180mcu_as_sc_mcu7t3v3__fill_2
XTAP_TAPCELL_ROW_153_1156 VDD VSS gf180mcu_as_sc_mcu7t3v3__tap_2
XTAP_TAPCELL_ROW_153_1145 VDD VSS gf180mcu_as_sc_mcu7t3v3__tap_2
XFILLER_163_195 VDD VDD VSS VSS gf180mcu_as_sc_mcu7t3v3__fillcap_8
XFILLER_3_824 VDD VDD VSS VSS gf180mcu_as_sc_mcu7t3v3__fillcap_16
XFILLER_3_846 VDD VDD VSS VSS gf180mcu_as_sc_mcu7t3v3__fill_1
XTAP_TAPCELL_ROW_170_1470 VDD VSS gf180mcu_as_sc_mcu7t3v3__tap_2
XTAP_TAPCELL_ROW_170_1481 VDD VSS gf180mcu_as_sc_mcu7t3v3__tap_2
Xfanout671 VDD VDD VSS VSS _4325_/S _4314_/S gf180mcu_as_sc_mcu7t3v3__buff_12
Xfanout682 VDD VDD VSS VSS _4621_/B _4617_/B gf180mcu_as_sc_mcu7t3v3__buff_12
Xfanout693 VDD VDD VSS VSS wire694/Y _3769_/B gf180mcu_as_sc_mcu7t3v3__buff_12
XFILLER_24_1287 VDD VDD VSS VSS gf180mcu_as_sc_mcu7t3v3__fill_2
XFILLER_160_51 VDD VDD VSS VSS gf180mcu_as_sc_mcu7t3v3__fillcap_16
XFILLER_37_72 VDD VDD VSS VSS gf180mcu_as_sc_mcu7t3v3__fill_2
XTAP_TAPCELL_ROW_177_1613 VDD VSS gf180mcu_as_sc_mcu7t3v3__tap_2
XTAP_TAPCELL_ROW_177_1602 VDD VSS gf180mcu_as_sc_mcu7t3v3__tap_2
XFILLER_175_906 VDD VDD VSS VSS gf180mcu_as_sc_mcu7t3v3__fillcap_4
XFILLER_187_799 VDD VDD VSS VSS gf180mcu_as_sc_mcu7t3v3__fillcap_4
Xclkbuf_3_7__f_clk_regs VDD VDD VSS VSS clkbuf_2_3_0_clk_regs/Y clkload0/A gf180mcu_as_sc_mcu7t3v3__clkbuff_12
XFILLER_6_662 VDD VDD VSS VSS gf180mcu_as_sc_mcu7t3v3__fill_2
X_3490_ VDD VDD VSS VSS _4146_/A _3496_/C _3490_/C _3490_/D _3491_/B gf180mcu_as_sc_mcu7t3v3__ao211_2
X_2510_ VDD VDD VSS VSS _4708_/B _4630_/A _3871_/A gf180mcu_as_sc_mcu7t3v3__nor2b_2
XTAP_TAPCELL_ROW_190_1857 VDD VSS gf180mcu_as_sc_mcu7t3v3__tap_2
XFILLER_154_195 VDD VDD VSS VSS gf180mcu_as_sc_mcu7t3v3__fill_2
X_2441_ VDD VDD VSS VSS _4091_/A _2441_/A gf180mcu_as_sc_mcu7t3v3__inv_2
XFILLER_155_1151 VDD VDD VSS VSS gf180mcu_as_sc_mcu7t3v3__fill_1
XFILLER_190_1042 VDD VDD VSS VSS gf180mcu_as_sc_mcu7t3v3__fill_1
X_5160_ VDD VDD VSS VSS _5164_/CLK _5160_/D _5160_/Q gf180mcu_as_sc_mcu7t3v3__dfxtp_2
Xclkbuf_leaf_14_clk_regs VDD VDD VSS VSS clkbuf_3_3__f_clk_regs/Y _5086_/CLK gf180mcu_as_sc_mcu7t3v3__clkbuff_12
XFILLER_9_1259 VDD VDD VSS VSS gf180mcu_as_sc_mcu7t3v3__fill_1
X_5091_ VDD VDD VSS VSS _5175_/CLK _5091_/D _5091_/Q gf180mcu_as_sc_mcu7t3v3__dfxtp_2
X_4111_ VDD VDD VSS VSS _4159_/C _4111_/A _4113_/C gf180mcu_as_sc_mcu7t3v3__and2_2
X_4042_ VDD VDD VSS VSS _4043_/C _4042_/B _4042_/A gf180mcu_as_sc_mcu7t3v3__nor2_2
X_4944_ VDD VDD VSS VSS clkload2/A _4944_/D _4944_/Q gf180mcu_as_sc_mcu7t3v3__dfxtp_2
XPHY_EDGE_ROW_153_Right_15 VDD VSS gf180mcu_as_sc_mcu7t3v3__tap_2
X_4875_ VDD VDD VSS VSS clkload4/A _4875_/D _4875_/Q gf180mcu_as_sc_mcu7t3v3__dfxtp_2
XFILLER_166_939 VDD VDD VSS VSS gf180mcu_as_sc_mcu7t3v3__fillcap_4
X_3826_ VDD VDD VSS VSS _3827_/B _3826_/B _4908_/Q gf180mcu_as_sc_mcu7t3v3__nor2_2
XFILLER_158_490 VDD VDD VSS VSS gf180mcu_as_sc_mcu7t3v3__fillcap_16
XFILLER_192_246 VDD VDD VSS VSS gf180mcu_as_sc_mcu7t3v3__fill_1
X_3757_ VDD VDD VSS VSS _3758_/C _4135_/A _3791_/B _3757_/C gf180mcu_as_sc_mcu7t3v3__ao21_2
XPHY_EDGE_ROW_21_3_Right_62 VDD VSS gf180mcu_as_sc_mcu7t3v3__tap_2
X_2708_ VDD VDD VSS VSS _2709_/D _2832_/S _2722_/B _2708_/A gf180mcu_as_sc_mcu7t3v3__aoi21b_2
X_3688_ VDD VDD VSS VSS _4931_/Q _3727_/B _3727_/C _4062_/A _3689_/D gf180mcu_as_sc_mcu7t3v3__ao22_2
X_2639_ VDD VDD VSS VSS _2639_/S _2639_/B _2639_/A _2640_/B gf180mcu_as_sc_mcu7t3v3__mux2_2
XPHY_EDGE_ROW_162_Right_24 VDD VSS gf180mcu_as_sc_mcu7t3v3__tap_2
XFILLER_0_827 VDD VDD VSS VSS gf180mcu_as_sc_mcu7t3v3__fill_2
XFILLER_161_699 VDD VDD VSS VSS gf180mcu_as_sc_mcu7t3v3__fill_1
XFILLER_173_1262 VDD VDD VSS VSS gf180mcu_as_sc_mcu7t3v3__fillcap_16
XPHY_EDGE_ROW_149_3_Left_521 VDD VSS gf180mcu_as_sc_mcu7t3v3__tap_2
X_4309_ VDD VDD VSS VSS _4314_/S _5139_/Q _5138_/Q _5138_/D gf180mcu_as_sc_mcu7t3v3__mux2_2
XFILLER_74_37 VDD VDD VSS VSS gf180mcu_as_sc_mcu7t3v3__fillcap_4
XFILLER_167_1022 VDD VDD VSS VSS gf180mcu_as_sc_mcu7t3v3__fill_1
XFILLER_58_1350 VDD VDD VSS VSS gf180mcu_as_sc_mcu7t3v3__fillcap_4
XPHY_EDGE_ROW_171_Right_33 VDD VSS gf180mcu_as_sc_mcu7t3v3__tap_2
XFILLER_130_76 VDD VDD VSS VSS gf180mcu_as_sc_mcu7t3v3__fill_1
XFILLER_167_1099 VDD VDD VSS VSS gf180mcu_as_sc_mcu7t3v3__fillcap_16
XFILLER_11_433 VDD VDD VSS VSS gf180mcu_as_sc_mcu7t3v3__fillcap_4
XFILLER_8_905 VDD VDD VSS VSS gf180mcu_as_sc_mcu7t3v3__fillcap_16
XFILLER_12_967 VDD VDD VSS VSS gf180mcu_as_sc_mcu7t3v3__fill_2
XFILLER_135_2 VDD VDD VSS VSS gf180mcu_as_sc_mcu7t3v3__fillcap_4
XFILLER_156_416 VDD VDD VSS VSS gf180mcu_as_sc_mcu7t3v3__fill_2
XFILLER_157_928 VDD VDD VSS VSS gf180mcu_as_sc_mcu7t3v3__fill_2
XFILLER_169_788 VDD VDD VSS VSS gf180mcu_as_sc_mcu7t3v3__fillcap_16
XFILLER_11_477 VDD VDD VSS VSS gf180mcu_as_sc_mcu7t3v3__fill_2
XFILLER_184_747 VDD VDD VSS VSS gf180mcu_as_sc_mcu7t3v3__fill_1
XFILLER_7_426 VDD VDD VSS VSS gf180mcu_as_sc_mcu7t3v3__fill_2
XTAP_TAPCELL_ROW_172_1521 VDD VSS gf180mcu_as_sc_mcu7t3v3__tap_2
XTAP_TAPCELL_ROW_172_1510 VDD VSS gf180mcu_as_sc_mcu7t3v3__tap_2
XFILLER_99_67 VDD VDD VSS VSS gf180mcu_as_sc_mcu7t3v3__fill_2
XPHY_EDGE_ROW_180_Right_42 VDD VSS gf180mcu_as_sc_mcu7t3v3__tap_2
XFILLER_30_1291 VDD VDD VSS VSS gf180mcu_as_sc_mcu7t3v3__fillcap_8
XFILLER_3_632 VDD VDD VSS VSS gf180mcu_as_sc_mcu7t3v3__fill_1
XFILLER_65_1321 VDD VDD VSS VSS gf180mcu_as_sc_mcu7t3v3__fill_2
XTAP_TAPCELL_ROW_43_3_1954 VDD VSS gf180mcu_as_sc_mcu7t3v3__tap_2
XFILLER_152_1302 VDD VDD VSS VSS gf180mcu_as_sc_mcu7t3v3__fillcap_4
XFILLER_3_698 VDD VDD VSS VSS gf180mcu_as_sc_mcu7t3v3__fill_2
XFILLER_152_1324 VDD VDD VSS VSS gf180mcu_as_sc_mcu7t3v3__fill_2
XTAP_TAPCELL_ROW_22_1_975 VDD VSS gf180mcu_as_sc_mcu7t3v3__tap_2
XFILLER_171_50 VDD VDD VSS VSS gf180mcu_as_sc_mcu7t3v3__fill_1
XFILLER_171_72 VDD VDD VSS VSS gf180mcu_as_sc_mcu7t3v3__fillcap_16
Xfanout490 VDD VDD VSS VSS _4582_/A _4553_/D gf180mcu_as_sc_mcu7t3v3__buff_12
XPHY_EDGE_ROW_70_3_Left_442 VDD VSS gf180mcu_as_sc_mcu7t3v3__tap_2
XFILLER_185_1122 VDD VDD VSS VSS gf180mcu_as_sc_mcu7t3v3__fillcap_16
X_2990_ VDD VDD VSS VSS _4775_/D _2990_/C _3065_/B _3971_/A gf180mcu_as_sc_mcu7t3v3__aoi21_2
X_4660_ VDD VDD VSS VSS _5239_/D _4660_/C _4660_/B _4660_/A gf180mcu_as_sc_mcu7t3v3__aoi21b_2
XTAP_TAPCELL_ROW_192_1919 VDD VSS gf180mcu_as_sc_mcu7t3v3__tap_2
XTAP_TAPCELL_ROW_192_1908 VDD VSS gf180mcu_as_sc_mcu7t3v3__tap_2
XTAP_TAPCELL_ROW_13_962 VDD VSS gf180mcu_as_sc_mcu7t3v3__tap_2
XTAP_TAPCELL_ROW_13_951 VDD VSS gf180mcu_as_sc_mcu7t3v3__tap_2
XTAP_TAPCELL_ROW_13_940 VDD VSS gf180mcu_as_sc_mcu7t3v3__tap_2
XFILLER_159_298 VDD VDD VSS VSS gf180mcu_as_sc_mcu7t3v3__fillcap_16
XFILLER_175_769 VDD VDD VSS VSS gf180mcu_as_sc_mcu7t3v3__fill_1
X_3611_ VDD VDD VSS VSS _3615_/B _3611_/C _3652_/B _3984_/A gf180mcu_as_sc_mcu7t3v3__aoi21_2
X_4591_ VDD VDD VSS VSS _4591_/B _4591_/A _4592_/D gf180mcu_as_sc_mcu7t3v3__and2_2
XFILLER_157_1202 VDD VDD VSS VSS gf180mcu_as_sc_mcu7t3v3__fill_1
XFILLER_50_2 VDD VDD VSS VSS gf180mcu_as_sc_mcu7t3v3__fillcap_4
XFILLER_7_982 VDD VDD VSS VSS gf180mcu_as_sc_mcu7t3v3__fillcap_4
Xmax_cap635 VDD VDD VSS VSS _3923_/Y fanout634/A gf180mcu_as_sc_mcu7t3v3__clkbuff_12
X_3542_ VDD VDD VSS VSS _3914_/B _3542_/A _3542_/Y gf180mcu_as_sc_mcu7t3v3__and2_2
XFILLER_192_1137 VDD VDD VSS VSS gf180mcu_as_sc_mcu7t3v3__fillcap_4
X_3473_ VDD VDD VSS VSS _4128_/A _3494_/C _3473_/C _3473_/D _3475_/C gf180mcu_as_sc_mcu7t3v3__ao211_2
XFILLER_9_1012 VDD VDD VSS VSS gf180mcu_as_sc_mcu7t3v3__fillcap_8
X_5212_ VDD VDD VSS VSS _5212_/CLK _5212_/D _5212_/Q gf180mcu_as_sc_mcu7t3v3__dfxtp_2
X_2424_ VDD VDD VSS VSS _3944_/A _2424_/A gf180mcu_as_sc_mcu7t3v3__inv_2
XFILLER_9_1045 VDD VDD VSS VSS gf180mcu_as_sc_mcu7t3v3__fill_1
X_5143_ VDD VDD VSS VSS _5152_/CLK _5143_/D _5143_/Q gf180mcu_as_sc_mcu7t3v3__dfxtp_2
X_5074_ VDD VDD VSS VSS clkload9/A _5074_/D _5074_/Q gf180mcu_as_sc_mcu7t3v3__dfxtp_2
X_4025_ VDD VDD VSS VSS _4025_/A _4025_/B _4025_/C _4025_/D _4026_/B gf180mcu_as_sc_mcu7t3v3__ao211_2
XTAP_TAPCELL_ROW_147_3_2058 VDD VSS gf180mcu_as_sc_mcu7t3v3__tap_2
XFILLER_129_1326 VDD VDD VSS VSS gf180mcu_as_sc_mcu7t3v3__fillcap_4
XTAP_TAPCELL_ROW_0_679 VDD VSS gf180mcu_as_sc_mcu7t3v3__tap_2
XTAP_TAPCELL_ROW_0_668 VDD VSS gf180mcu_as_sc_mcu7t3v3__tap_2
X_4927_ VDD VDD VSS VSS _5158_/CLK _4927_/D _4927_/Q gf180mcu_as_sc_mcu7t3v3__dfxtp_2
XFILLER_178_563 VDD VDD VSS VSS gf180mcu_as_sc_mcu7t3v3__fillcap_4
X_4858_ VDD VDD VSS VSS _5278_/CLK _4858_/D _4858_/Q gf180mcu_as_sc_mcu7t3v3__dfxtp_2
X_3809_ VDD VDD VSS VSS _3932_/C _3818_/C _3818_/D gf180mcu_as_sc_mcu7t3v3__nand2_2
XFILLER_140_1272 VDD VDD VSS VSS gf180mcu_as_sc_mcu7t3v3__fillcap_16
XFILLER_153_419 VDD VDD VSS VSS gf180mcu_as_sc_mcu7t3v3__fill_1
XFILLER_181_728 VDD VDD VSS VSS gf180mcu_as_sc_mcu7t3v3__fill_1
XFILLER_5_908 VDD VDD VSS VSS gf180mcu_as_sc_mcu7t3v3__fill_2
X_4789_ VDD VDD VSS VSS _5267_/CLK _4789_/D _4789_/Q gf180mcu_as_sc_mcu7t3v3__dfxtp_2
XFILLER_10_1139 VDD VDD VSS VSS gf180mcu_as_sc_mcu7t3v3__fillcap_4
XFILLER_162_942 VDD VDD VSS VSS gf180mcu_as_sc_mcu7t3v3__fill_2
XFILLER_180_216 VDD VDD VSS VSS gf180mcu_as_sc_mcu7t3v3__fillcap_16
XFILLER_88_1354 VDD VDD VSS VSS gf180mcu_as_sc_mcu7t3v3__fill_1
XFILLER_109_99 VDD VDD VSS VSS gf180mcu_as_sc_mcu7t3v3__fillcap_4
X_4886__1082 VDD VDD VSS VSS _4886_/D gf180mcu_as_sc_mcu7t3v3__tiel_4
XFILLER_161_496 VDD VDD VSS VSS gf180mcu_as_sc_mcu7t3v3__fill_2
XFILLER_125_76 VDD VDD VSS VSS gf180mcu_as_sc_mcu7t3v3__fill_1
XFILLER_112_1352 VDD VDD VSS VSS gf180mcu_as_sc_mcu7t3v3__fill_2
XFILLER_85_69 VDD VDD VSS VSS gf180mcu_as_sc_mcu7t3v3__fill_1
XFILLER_141_64 VDD VDD VSS VSS gf180mcu_as_sc_mcu7t3v3__fillcap_4
XTAP_TAPCELL_ROW_165_1380 VDD VSS gf180mcu_as_sc_mcu7t3v3__tap_2
XFILLER_189_839 VDD VDD VSS VSS gf180mcu_as_sc_mcu7t3v3__fill_1
X_4952__1101 VDD VDD VSS VSS _4952_/RN gf180mcu_as_sc_mcu7t3v3__tieh_4
XTAP_TAPCELL_ROW_161_1299 VDD VSS gf180mcu_as_sc_mcu7t3v3__tap_2
XFILLER_34_73 VDD VDD VSS VSS gf180mcu_as_sc_mcu7t3v3__fillcap_4
XFILLER_8_702 VDD VDD VSS VSS gf180mcu_as_sc_mcu7t3v3__fillcap_16
XFILLER_184_522 VDD VDD VSS VSS gf180mcu_as_sc_mcu7t3v3__fill_2
XFILLER_7_212 VDD VDD VSS VSS gf180mcu_as_sc_mcu7t3v3__fill_1
XFILLER_11_296 VDD VDD VSS VSS gf180mcu_as_sc_mcu7t3v3__fill_2
XFILLER_153_942 VDD VDD VSS VSS gf180mcu_as_sc_mcu7t3v3__fillcap_16
XFILLER_7_267 VDD VDD VSS VSS gf180mcu_as_sc_mcu7t3v3__fill_2
XFILLER_152_441 VDD VDD VSS VSS gf180mcu_as_sc_mcu7t3v3__fill_1
XFILLER_152_1121 VDD VDD VSS VSS gf180mcu_as_sc_mcu7t3v3__fill_1
XFILLER_152_1132 VDD VDD VSS VSS gf180mcu_as_sc_mcu7t3v3__fillcap_4
XFILLER_156_1290 VDD VDD VSS VSS gf180mcu_as_sc_mcu7t3v3__fillcap_4
XFILLER_191_1192 VDD VDD VSS VSS gf180mcu_as_sc_mcu7t3v3__fillcap_16
XTAP_TAPCELL_ROW_185_1767 VDD VSS gf180mcu_as_sc_mcu7t3v3__tap_2
XTAP_TAPCELL_ROW_185_1756 VDD VSS gf180mcu_as_sc_mcu7t3v3__tap_2
XFILLER_179_305 VDD VDD VSS VSS gf180mcu_as_sc_mcu7t3v3__fillcap_16
X_2973_ VDD VDD VSS VSS _3953_/A _3049_/B _2973_/C _2973_/Y _3654_/D gf180mcu_as_sc_mcu7t3v3__aoi211_2
XFILLER_187_360 VDD VDD VSS VSS gf180mcu_as_sc_mcu7t3v3__fillcap_4
XFILLER_188_872 VDD VDD VSS VSS gf180mcu_as_sc_mcu7t3v3__fill_2
X_4712_ VDD VDD VSS VSS _4721_/A _4712_/B _5105_/Q _5258_/D gf180mcu_as_sc_mcu7t3v3__mux2_2
XFILLER_124_1256 VDD VDD VSS VSS gf180mcu_as_sc_mcu7t3v3__fillcap_4
XFILLER_175_555 VDD VDD VSS VSS gf180mcu_as_sc_mcu7t3v3__fillcap_4
X_4643_ VDD VDD VSS VSS _4643_/B _4643_/A _4649_/C gf180mcu_as_sc_mcu7t3v3__and2_2
XFILLER_156_780 VDD VDD VSS VSS gf180mcu_as_sc_mcu7t3v3__fillcap_16
X_4574_ VDD VDD VSS VSS _5186_/Q _4574_/B _4574_/C _4574_/D _5186_/D gf180mcu_as_sc_mcu7t3v3__ao211_2
XFILLER_157_1032 VDD VDD VSS VSS gf180mcu_as_sc_mcu7t3v3__fill_2
X_3525_ VDD VDD VSS VSS _3525_/B _3525_/A _4837_/D gf180mcu_as_sc_mcu7t3v3__and2_2
XFILLER_171_772 VDD VDD VSS VSS gf180mcu_as_sc_mcu7t3v3__fillcap_16
XFILLER_130_102 VDD VDD VSS VSS gf180mcu_as_sc_mcu7t3v3__fill_2
XFILLER_170_293 VDD VDD VSS VSS gf180mcu_as_sc_mcu7t3v3__fillcap_16
X_3456_ VDD VDD VSS VSS _4937_/Q _3456_/B _3501_/B _4112_/A _3458_/C gf180mcu_as_sc_mcu7t3v3__ao22_2
X_3387_ VDD VDD VSS VSS _3419_/B _4040_/A _3388_/D gf180mcu_as_sc_mcu7t3v3__or2_2
X_2407_ VDD VDD VSS VSS _2539_/B _5163_/Q gf180mcu_as_sc_mcu7t3v3__inv_2
X_5126_ VDD VDD VSS VSS _5275_/CLK _5126_/D _5126_/Q gf180mcu_as_sc_mcu7t3v3__dfxtp_2
X_5057_ VDD VDD VSS VSS _5089_/CLK _5057_/D _5057_/Q gf180mcu_as_sc_mcu7t3v3__dfxtp_2
X_4008_ VDD VDD VSS VSS _4008_/A _4022_/B _4021_/B _4008_/D _4009_/D gf180mcu_as_sc_mcu7t3v3__ao22_2
XFILLER_187_38 VDD VDD VSS VSS gf180mcu_as_sc_mcu7t3v3__fillcap_16
XTAP_TAPCELL_ROW_21_1_974 VDD VSS gf180mcu_as_sc_mcu7t3v3__tap_2
XFILLER_178_382 VDD VDD VSS VSS gf180mcu_as_sc_mcu7t3v3__fill_2
XFILLER_90_1288 VDD VDD VSS VSS gf180mcu_as_sc_mcu7t3v3__fill_1
XFILLER_90_1299 VDD VDD VSS VSS gf180mcu_as_sc_mcu7t3v3__fill_2
XPHY_EDGE_ROW_29_1_Left_221 VDD VSS gf180mcu_as_sc_mcu7t3v3__tap_2
XFILLER_181_558 VDD VDD VSS VSS gf180mcu_as_sc_mcu7t3v3__fill_2
XFILLER_181_569 VDD VDD VSS VSS gf180mcu_as_sc_mcu7t3v3__fillcap_4
XFILLER_136_53 VDD VDD VSS VSS gf180mcu_as_sc_mcu7t3v3__fill_1
XFILLER_0_410 VDD VDD VSS VSS gf180mcu_as_sc_mcu7t3v3__fill_1
XFILLER_136_75 VDD VDD VSS VSS gf180mcu_as_sc_mcu7t3v3__fillcap_4
XFILLER_161_282 VDD VDD VSS VSS gf180mcu_as_sc_mcu7t3v3__fillcap_8
XFILLER_1_933 VDD VDD VSS VSS gf180mcu_as_sc_mcu7t3v3__fill_1
Xinput300 VDD VDD VSS VSS west_in[25] _4135_/D gf180mcu_as_sc_mcu7t3v3__buff_12
Xinput311 VDD VDD VSS VSS west_in[4] _3965_/D gf180mcu_as_sc_mcu7t3v3__buff_12
XTAP_TAPCELL_ROW_167_1420 VDD VSS gf180mcu_as_sc_mcu7t3v3__tap_2
XFILLER_152_52 VDD VDD VSS VSS gf180mcu_as_sc_mcu7t3v3__fill_2
XTAP_TAPCELL_ROW_4_771 VDD VSS gf180mcu_as_sc_mcu7t3v3__tap_2
XTAP_TAPCELL_ROW_4_760 VDD VSS gf180mcu_as_sc_mcu7t3v3__tap_2
XFILLER_1_1115 VDD VDD VSS VSS gf180mcu_as_sc_mcu7t3v3__fillcap_4
XTAP_TAPCELL_ROW_163_1339 VDD VSS gf180mcu_as_sc_mcu7t3v3__tap_2
XTAP_TAPCELL_ROW_180_1675 VDD VSS gf180mcu_as_sc_mcu7t3v3__tap_2
XTAP_TAPCELL_ROW_180_1664 VDD VSS gf180mcu_as_sc_mcu7t3v3__tap_2
XFILLER_188_102 VDD VDD VSS VSS gf180mcu_as_sc_mcu7t3v3__fill_2
XFILLER_45_72 VDD VDD VSS VSS gf180mcu_as_sc_mcu7t3v3__fill_2
XFILLER_147_1256 VDD VDD VSS VSS gf180mcu_as_sc_mcu7t3v3__fillcap_8
XFILLER_182_1169 VDD VDD VSS VSS gf180mcu_as_sc_mcu7t3v3__fill_2
XFILLER_157_511 VDD VDD VSS VSS gf180mcu_as_sc_mcu7t3v3__fill_2
XFILLER_157_533 VDD VDD VSS VSS gf180mcu_as_sc_mcu7t3v3__fill_2
XFILLER_185_842 VDD VDD VSS VSS gf180mcu_as_sc_mcu7t3v3__fillcap_8
XFILLER_12_594 VDD VDD VSS VSS gf180mcu_as_sc_mcu7t3v3__fill_1
XFILLER_185_886 VDD VDD VSS VSS gf180mcu_as_sc_mcu7t3v3__fill_1
XFILLER_8_543 VDD VDD VSS VSS gf180mcu_as_sc_mcu7t3v3__fill_1
XANTENNA_4 VDD VDD VSS VSS _4852_/D gf180mcu_as_sc_mcu7t3v3__diode_2
XFILLER_153_772 VDD VDD VSS VSS gf180mcu_as_sc_mcu7t3v3__fillcap_8
X_3310_ VDD VDD VSS VSS _3432_/B _3310_/B _3310_/C _3311_/C gf180mcu_as_sc_mcu7t3v3__nor3_2
XFILLER_112_102 VDD VDD VSS VSS gf180mcu_as_sc_mcu7t3v3__fill_2
XFILLER_154_1227 VDD VDD VSS VSS gf180mcu_as_sc_mcu7t3v3__fillcap_8
X_4290_ VDD VDD VSS VSS _4719_/A _4290_/B _5124_/Q _5124_/D gf180mcu_as_sc_mcu7t3v3__mux2_2
XTAP_TAPCELL_ROW_187_1807 VDD VSS gf180mcu_as_sc_mcu7t3v3__tap_2
X_3241_ VDD VDD VSS VSS _3242_/B _3523_/A _3241_/B _3241_/C _3524_/A gf180mcu_as_sc_mcu7t3v3__aoi22_2
X_3172_ VDD VDD VSS VSS _4146_/D _3239_/A _3172_/C _3172_/D _3173_/B gf180mcu_as_sc_mcu7t3v3__ao211_2
Xmesh_tile_959 VDD VDD VSS VSS ne_out[33] gf180mcu_as_sc_mcu7t3v3__tiel_4
Xmesh_tile_948 VDD VDD VSS VSS ne_out[22] gf180mcu_as_sc_mcu7t3v3__tiel_4
Xmesh_tile_937 VDD VDD VSS VSS ne_out[11] gf180mcu_as_sc_mcu7t3v3__tiel_4
XPHY_EDGE_ROW_30_3_Right_71 VDD VSS gf180mcu_as_sc_mcu7t3v3__tap_2
XFILLER_39_1326 VDD VDD VSS VSS gf180mcu_as_sc_mcu7t3v3__fill_2
XPHY_EDGE_ROW_33_3_Left_405 VDD VSS gf180mcu_as_sc_mcu7t3v3__tap_2
X_2956_ VDD VDD VSS VSS _2956_/B _3907_/A _4771_/D gf180mcu_as_sc_mcu7t3v3__and2_2
XFILLER_175_352 VDD VDD VSS VSS gf180mcu_as_sc_mcu7t3v3__fillcap_16
X_2887_ VDD VDD VSS VSS _3811_/A _3788_/A _3796_/A gf180mcu_as_sc_mcu7t3v3__nor2_2
XFILLER_191_834 VDD VDD VSS VSS gf180mcu_as_sc_mcu7t3v3__fillcap_4
X_4626_ VDD VDD VSS VSS _5276_/Q _4626_/B _4626_/A _4628_/B gf180mcu_as_sc_mcu7t3v3__mux2_2
XFILLER_191_867 VDD VDD VSS VSS gf180mcu_as_sc_mcu7t3v3__fill_1
XFILLER_85_1313 VDD VDD VSS VSS gf180mcu_as_sc_mcu7t3v3__fill_2
X_4557_ VDD VDD VSS VSS _4561_/B _5085_/Q _4557_/A gf180mcu_as_sc_mcu7t3v3__nand2_2
X_4488_ VDD VDD VSS VSS _4491_/C _4990_/Q _4570_/S gf180mcu_as_sc_mcu7t3v3__nand2b_2
X_3508_ VDD VDD VSS VSS _3508_/A _3533_/A _3812_/A _3517_/D _3509_/B gf180mcu_as_sc_mcu7t3v3__nand4_2
X_3439_ VDD VDD VSS VSS _4091_/A _3463_/B _3439_/C _4824_/D _3615_/D gf180mcu_as_sc_mcu7t3v3__aoi211_2
XFILLER_170_1084 VDD VDD VSS VSS gf180mcu_as_sc_mcu7t3v3__fill_1
X_5109_ VDD VDD VSS VSS _5188_/CLK _5109_/D _5109_/Q gf180mcu_as_sc_mcu7t3v3__dfxtp_2
XFILLER_122_44 VDD VDD VSS VSS gf180mcu_as_sc_mcu7t3v3__fillcap_16
XFILLER_174_6 VDD VDD VSS VSS gf180mcu_as_sc_mcu7t3v3__fillcap_16
XFILLER_122_88 VDD VDD VSS VSS gf180mcu_as_sc_mcu7t3v3__fillcap_16
XFILLER_13_358 VDD VDD VSS VSS gf180mcu_as_sc_mcu7t3v3__fillcap_16
XFILLER_167_842 VDD VDD VSS VSS gf180mcu_as_sc_mcu7t3v3__fillcap_16
XFILLER_185_138 VDD VDD VSS VSS gf180mcu_as_sc_mcu7t3v3__fill_2
XFILLER_166_330 VDD VDD VSS VSS gf180mcu_as_sc_mcu7t3v3__fill_1
XFILLER_31_52 VDD VDD VSS VSS gf180mcu_as_sc_mcu7t3v3__fillcap_4
XFILLER_182_867 VDD VDD VSS VSS gf180mcu_as_sc_mcu7t3v3__fill_1
XTAP_TAPCELL_ROW_9_863 VDD VSS gf180mcu_as_sc_mcu7t3v3__tap_2
XFILLER_0_240 VDD VDD VSS VSS gf180mcu_as_sc_mcu7t3v3__fillcap_4
XFILLER_27_1296 VDD VDD VSS VSS gf180mcu_as_sc_mcu7t3v3__fill_1
Xinput130 VDD VDD VSS VSS north_in[26] _4144_/A gf180mcu_as_sc_mcu7t3v3__buff_12
Xinput141 VDD VDD VSS VSS north_in[5] _3974_/A gf180mcu_as_sc_mcu7t3v3__buff_12
Xinput152 VDD VDD VSS VSS nw_in[15] _4056_/A gf180mcu_as_sc_mcu7t3v3__buff_12
Xinput163 VDD VDD VSS VSS nw_in[25] _4136_/A gf180mcu_as_sc_mcu7t3v3__buff_12
XTAP_TAPCELL_ROW_182_1704 VDD VSS gf180mcu_as_sc_mcu7t3v3__tap_2
XFILLER_114_1277 VDD VDD VSS VSS gf180mcu_as_sc_mcu7t3v3__fillcap_8
Xinput174 VDD VDD VSS VSS nw_in[4] _3966_/A gf180mcu_as_sc_mcu7t3v3__buff_12
Xinput185 VDD VDD VSS VSS se_in[13] _4041_/A gf180mcu_as_sc_mcu7t3v3__buff_12
Xinput196 VDD VDD VSS VSS se_in[23] _4122_/A gf180mcu_as_sc_mcu7t3v3__buff_12
XFILLER_114_1299 VDD VDD VSS VSS gf180mcu_as_sc_mcu7t3v3__fill_2
XTAP_TAPCELL_ROW_85_1_1038 VDD VSS gf180mcu_as_sc_mcu7t3v3__tap_2
XFILLER_186_1091 VDD VDD VSS VSS gf180mcu_as_sc_mcu7t3v3__fill_2
XFILLER_189_422 VDD VDD VSS VSS gf180mcu_as_sc_mcu7t3v3__fill_2
XFILLER_189_444 VDD VDD VSS VSS gf180mcu_as_sc_mcu7t3v3__fill_1
XFILLER_160_1231 VDD VDD VSS VSS gf180mcu_as_sc_mcu7t3v3__fill_2
XFILLER_73_1272 VDD VDD VSS VSS gf180mcu_as_sc_mcu7t3v3__fill_2
X_3790_ VDD VDD VSS VSS _3790_/A _3932_/B _3790_/C _3790_/D _3791_/C gf180mcu_as_sc_mcu7t3v3__ao22_2
X_2810_ VDD VDD VSS VSS _2810_/A _2810_/B _2810_/C _2841_/A _2810_/D gf180mcu_as_sc_mcu7t3v3__aoi31_2
XFILLER_160_1264 VDD VDD VSS VSS gf180mcu_as_sc_mcu7t3v3__fillcap_16
XFILLER_176_149 VDD VDD VSS VSS gf180mcu_as_sc_mcu7t3v3__fill_1
XFILLER_34_1256 VDD VDD VSS VSS gf180mcu_as_sc_mcu7t3v3__fillcap_4
X_2741_ VDD VDD VSS VSS _4947_/Q _2741_/B _2741_/A _5482_/A gf180mcu_as_sc_mcu7t3v3__mux2_2
XFILLER_157_363 VDD VDD VSS VSS gf180mcu_as_sc_mcu7t3v3__fill_2
XFILLER_172_311 VDD VDD VSS VSS gf180mcu_as_sc_mcu7t3v3__fillcap_4
XFILLER_9_896 VDD VDD VSS VSS gf180mcu_as_sc_mcu7t3v3__fillcap_8
XFILLER_172_344 VDD VDD VSS VSS gf180mcu_as_sc_mcu7t3v3__fillcap_8
X_4411_ VDD VDD VSS VSS _4414_/C _4981_/Q _4456_/S gf180mcu_as_sc_mcu7t3v3__nand2b_2
X_2672_ VDD VDD VSS VSS _2675_/C _2672_/B _2672_/C _2672_/D _2672_/Y gf180mcu_as_sc_mcu7t3v3__ao22_2
XFILLER_98_100 VDD VDD VSS VSS gf180mcu_as_sc_mcu7t3v3__fillcap_4
X_4342_ VDD VDD VSS VSS _4572_/A _4342_/B _4342_/A _4344_/B gf180mcu_as_sc_mcu7t3v3__mux2_2
X_4273_ VDD VDD VSS VSS _4273_/S _5485_/A _5107_/Q _5107_/D gf180mcu_as_sc_mcu7t3v3__mux2_2
X_3224_ VDD VDD VSS VSS _3225_/B _3542_/A _3249_/B _3233_/B _3224_/D gf180mcu_as_sc_mcu7t3v3__aoi22_2
XTAP_TAPCELL_ROW_20_1_973 VDD VSS gf180mcu_as_sc_mcu7t3v3__tap_2
.ends
