* NGSPICE file created from mesh_tile.ext - technology: gf180mcuD

* Black-box entry subcircuit for gf180mcu_as_sc_mcu7t3v3__fill_2 abstract view
.subckt gf180mcu_as_sc_mcu7t3v3__fill_2 VDD VNW VPW VSS
.ends

* Black-box entry subcircuit for gf180mcu_as_sc_mcu7t3v3__or2_2 abstract view
.subckt gf180mcu_as_sc_mcu7t3v3__or2_2 VDD VNW VPW VSS B A Y
.ends

* Black-box entry subcircuit for gf180mcu_as_sc_mcu7t3v3__fill_1 abstract view
.subckt gf180mcu_as_sc_mcu7t3v3__fill_1 VDD VNW VPW VSS
.ends

* Black-box entry subcircuit for gf180mcu_as_sc_mcu7t3v3__tap_2 abstract view
.subckt gf180mcu_as_sc_mcu7t3v3__tap_2 VDD VSS
.ends

* Black-box entry subcircuit for gf180mcu_as_sc_mcu7t3v3__inv_2 abstract view
.subckt gf180mcu_as_sc_mcu7t3v3__inv_2 VDD VNW VPW VSS Y A
.ends

* Black-box entry subcircuit for gf180mcu_as_sc_mcu7t3v3__fillcap_4 abstract view
.subckt gf180mcu_as_sc_mcu7t3v3__fillcap_4 VDD VNW VPW VSS
.ends

* Black-box entry subcircuit for gf180mcu_as_sc_mcu7t3v3__fillcap_16 abstract view
.subckt gf180mcu_as_sc_mcu7t3v3__fillcap_16 VDD VNW VPW VSS
.ends

* Black-box entry subcircuit for gf180mcu_as_sc_mcu7t3v3__ao22_2 abstract view
.subckt gf180mcu_as_sc_mcu7t3v3__ao22_2 VDD VNW VPW VSS A B C D Y
.ends

* Black-box entry subcircuit for gf180mcu_as_sc_mcu7t3v3__aoi21_2 abstract view
.subckt gf180mcu_as_sc_mcu7t3v3__aoi21_2 VDD VNW VPW VSS Y C B A
.ends

* Black-box entry subcircuit for gf180mcu_as_sc_mcu7t3v3__mux2_2 abstract view
.subckt gf180mcu_as_sc_mcu7t3v3__mux2_2 VDD VNW VPW VSS S B A Y
.ends

* Black-box entry subcircuit for gf180mcu_as_sc_mcu7t3v3__buff_12 abstract view
.subckt gf180mcu_as_sc_mcu7t3v3__buff_12 VDD VNW VPW VSS A Y
.ends

* Black-box entry subcircuit for gf180mcu_as_sc_mcu7t3v3__fillcap_8 abstract view
.subckt gf180mcu_as_sc_mcu7t3v3__fillcap_8 VDD VNW VPW VSS
.ends

* Black-box entry subcircuit for gf180mcu_as_sc_mcu7t3v3__ao21_2 abstract view
.subckt gf180mcu_as_sc_mcu7t3v3__ao21_2 VDD VNW VPW VSS Y A B C
.ends

* Black-box entry subcircuit for gf180mcu_as_sc_mcu7t3v3__nand2b_2 abstract view
.subckt gf180mcu_as_sc_mcu7t3v3__nand2b_2 VDD VNW VPW VSS Y B A
.ends

* Black-box entry subcircuit for gf180mcu_as_sc_mcu7t3v3__and2_2 abstract view
.subckt gf180mcu_as_sc_mcu7t3v3__and2_2 VDD VNW VPW VSS B A Y
.ends

* Black-box entry subcircuit for gf180mcu_as_sc_mcu7t3v3__ao211_2 abstract view
.subckt gf180mcu_as_sc_mcu7t3v3__ao211_2 VDD VNW VPW VSS A B C D Y
.ends

* Black-box entry subcircuit for gf180mcu_as_sc_mcu7t3v3__dfxtp_2 abstract view
.subckt gf180mcu_as_sc_mcu7t3v3__dfxtp_2 VDD VNW VPW VSS CLK D Q
.ends

* Black-box entry subcircuit for gf180mcu_as_sc_mcu7t3v3__nand2_2 abstract view
.subckt gf180mcu_as_sc_mcu7t3v3__nand2_2 VDD VNW VPW VSS Y B A
.ends

* Black-box entry subcircuit for gf180mcu_as_sc_mcu7t3v3__nor2_2 abstract view
.subckt gf180mcu_as_sc_mcu7t3v3__nor2_2 VDD VNW VPW VSS Y B A
.ends

* Black-box entry subcircuit for gf180mcu_as_sc_mcu7t3v3__clkbuff_12 abstract view
.subckt gf180mcu_as_sc_mcu7t3v3__clkbuff_12 VDD VNW VPW VSS A Y
.ends

* Black-box entry subcircuit for gf180mcu_as_sc_mcu7t3v3__aoi21b_2 abstract view
.subckt gf180mcu_as_sc_mcu7t3v3__aoi21b_2 VDD VNW VPW VSS Y C B A
.ends

* Black-box entry subcircuit for gf180mcu_as_sc_mcu7t3v3__ao31_2 abstract view
.subckt gf180mcu_as_sc_mcu7t3v3__ao31_2 VDD VNW VPW VSS D A B C Y
.ends

* Black-box entry subcircuit for gf180mcu_as_sc_mcu7t3v3__tiel_4 abstract view
.subckt gf180mcu_as_sc_mcu7t3v3__tiel_4 VDD VNW VPW VSS ZERO
.ends

* Black-box entry subcircuit for gf180mcu_as_sc_mcu7t3v3__nand3_2 abstract view
.subckt gf180mcu_as_sc_mcu7t3v3__nand3_2 VDD VNW VPW VSS A B C Y
.ends

* Black-box entry subcircuit for gf180mcu_as_sc_mcu7t3v3__nor2b_2 abstract view
.subckt gf180mcu_as_sc_mcu7t3v3__nor2b_2 VDD VNW VPW VSS Y B A
.ends

* Black-box entry subcircuit for gf180mcu_as_sc_mcu7t3v3__diode_2 abstract view
.subckt gf180mcu_as_sc_mcu7t3v3__diode_2 VDD VNW VPW VSS DIODE
.ends

* Black-box entry subcircuit for gf180mcu_as_sc_mcu7t3v3__xnor2_2 abstract view
.subckt gf180mcu_as_sc_mcu7t3v3__xnor2_2 VDD VNW VPW VSS B A Y
.ends

* Black-box entry subcircuit for gf180mcu_as_sc_mcu7t3v3__aoi31_2 abstract view
.subckt gf180mcu_as_sc_mcu7t3v3__aoi31_2 VDD VNW VPW VSS A B C Y D
.ends

* Black-box entry subcircuit for gf180mcu_as_sc_mcu7t3v3__clkbuff_4 abstract view
.subckt gf180mcu_as_sc_mcu7t3v3__clkbuff_4 VDD VNW VPW VSS A Y
.ends

* Black-box entry subcircuit for gf180mcu_as_sc_mcu7t3v3__oai211_2 abstract view
.subckt gf180mcu_as_sc_mcu7t3v3__oai211_2 VDD VNW VPW VSS A B C Y D
.ends

* Black-box entry subcircuit for gf180mcu_as_sc_mcu7t3v3__nor3_2 abstract view
.subckt gf180mcu_as_sc_mcu7t3v3__nor3_2 VDD VNW VPW VSS A B C Y
.ends

* Black-box entry subcircuit for gf180mcu_as_sc_mcu7t3v3__aoi211_2 abstract view
.subckt gf180mcu_as_sc_mcu7t3v3__aoi211_2 VDD VNW VPW VSS A B C Y D
.ends

* Black-box entry subcircuit for gf180mcu_as_sc_mcu7t3v3__aoi22_2 abstract view
.subckt gf180mcu_as_sc_mcu7t3v3__aoi22_2 VDD VNW VPW VSS Y A B C D
.ends

* Black-box entry subcircuit for gf180mcu_as_sc_mcu7t3v3__ao21b_2 abstract view
.subckt gf180mcu_as_sc_mcu7t3v3__ao21b_2 VDD VNW VPW VSS Y C B A
.ends

* Black-box entry subcircuit for gf180mcu_as_sc_mcu7t3v3__nand4_2 abstract view
.subckt gf180mcu_as_sc_mcu7t3v3__nand4_2 VDD VNW VPW VSS A B C D Y
.ends

* Black-box entry subcircuit for gf180mcu_as_sc_mcu7t3v3__buff_2 abstract view
.subckt gf180mcu_as_sc_mcu7t3v3__buff_2 VDD VNW VPW VSS A Y
.ends

* Black-box entry subcircuit for gf180mcu_as_sc_mcu7t3v3__inv_6 abstract view
.subckt gf180mcu_as_sc_mcu7t3v3__inv_6 VDD VNW VPW VSS Y A
.ends

* Black-box entry subcircuit for gf180mcu_as_sc_mcu7t3v3__maj3_2 abstract view
.subckt gf180mcu_as_sc_mcu7t3v3__maj3_2 VDD VNW VPW VSS Y A B C
.ends

* Black-box entry subcircuit for gf180mcu_as_sc_mcu7t3v3__inv_4 abstract view
.subckt gf180mcu_as_sc_mcu7t3v3__inv_4 VDD VNW VPW VSS Y A
.ends

* Black-box entry subcircuit for gf180mcu_as_sc_mcu7t3v3__tieh_4 abstract view
.subckt gf180mcu_as_sc_mcu7t3v3__tieh_4 VDD VNW VPW VSS ONE
.ends

* Black-box entry subcircuit for gf180mcu_ocd_ip_sram__sram1024x8m8wm1 abstract view
.subckt gf180mcu_ocd_ip_sram__sram1024x8m8wm1 A[8] A[7] A[6] A[5] A[4] A[3] A[2] A[1]
+ A[0] CEN CLK D[7] D[6] D[5] D[4] D[3] D[2] D[1] D[0] GWEN Q[7] Q[6] Q[5] Q[4] Q[3]
+ Q[2] Q[1] Q[0] VDD VSS WEN[7] WEN[6] WEN[5] WEN[4] WEN[3] WEN[2] WEN[1] WEN[0] A[9]
.ends

* Black-box entry subcircuit for gf180mcu_as_sc_mcu7t3v3__dfsrtp_2 abstract view
.subckt gf180mcu_as_sc_mcu7t3v3__dfsrtp_2 VDD VNW VPW VSS CLK Q RN SN D
.ends

.subckt mesh_tile TILE_ID[0] TILE_ID[1] TILE_ID[2] TILE_ID[3] TILE_ID[4] TILE_ID[5]
+ VDD VSS boot_addr[0] boot_addr[10] boot_addr[1] boot_addr[2] boot_addr[3] boot_addr[4]
+ boot_addr[5] boot_addr[6] boot_addr[7] boot_addr[8] boot_addr[9] boot_data[0] boot_data[1]
+ boot_data[2] boot_data[3] boot_data[4] boot_data[5] boot_data[6] boot_data[7] boot_mode
+ boot_wen clk dft_addr[0] dft_addr[10] dft_addr[1] dft_addr[2] dft_addr[3] dft_addr[4]
+ dft_addr[5] dft_addr[6] dft_addr[7] dft_addr[8] dft_addr[9] dft_ce dft_mode dft_rdata[0]
+ dft_rdata[1] dft_rdata[2] dft_rdata[3] dft_rdata[4] dft_rdata[5] dft_rdata[6] dft_rdata[7]
+ dft_wdata[0] dft_wdata[1] dft_wdata[2] dft_wdata[3] dft_wdata[4] dft_wdata[5] dft_wdata[6]
+ dft_wdata[7] dft_we east_in[0] east_in[10] east_in[11] east_in[12] east_in[13] east_in[14]
+ east_in[15] east_in[16] east_in[17] east_in[18] east_in[19] east_in[1] east_in[20]
+ east_in[21] east_in[22] east_in[23] east_in[24] east_in[25] east_in[26] east_in[27]
+ east_in[28] east_in[29] east_in[2] east_in[30] east_in[31] east_in[32] east_in[33]
+ east_in[34] east_in[35] east_in[3] east_in[4] east_in[5] east_in[6] east_in[7] east_in[8]
+ east_in[9] east_out[0] east_out[10] east_out[11] east_out[12] east_out[13] east_out[14]
+ east_out[15] east_out[16] east_out[17] east_out[18] east_out[19] east_out[1] east_out[20]
+ east_out[21] east_out[22] east_out[23] east_out[24] east_out[25] east_out[26] east_out[27]
+ east_out[28] east_out[29] east_out[2] east_out[30] east_out[31] east_out[32] east_out[33]
+ east_out[34] east_out[35] east_out[3] east_out[4] east_out[5] east_out[6] east_out[7]
+ east_out[8] east_out[9] ne_in[0] ne_in[10] ne_in[11] ne_in[12] ne_in[13] ne_in[14]
+ ne_in[15] ne_in[16] ne_in[17] ne_in[18] ne_in[19] ne_in[1] ne_in[20] ne_in[21] ne_in[22]
+ ne_in[23] ne_in[24] ne_in[25] ne_in[26] ne_in[27] ne_in[28] ne_in[29] ne_in[2] ne_in[30]
+ ne_in[31] ne_in[32] ne_in[33] ne_in[34] ne_in[35] ne_in[3] ne_in[4] ne_in[5] ne_in[6]
+ ne_in[7] ne_in[8] ne_in[9] ne_out[0] ne_out[10] ne_out[11] ne_out[12] ne_out[13]
+ ne_out[14] ne_out[15] ne_out[16] ne_out[17] ne_out[18] ne_out[19] ne_out[1] ne_out[20]
+ ne_out[21] ne_out[22] ne_out[23] ne_out[24] ne_out[25] ne_out[26] ne_out[27] ne_out[28]
+ ne_out[29] ne_out[2] ne_out[30] ne_out[31] ne_out[32] ne_out[33] ne_out[34] ne_out[35]
+ ne_out[3] ne_out[4] ne_out[5] ne_out[6] ne_out[7] ne_out[8] ne_out[9] north_in[0]
+ north_in[10] north_in[11] north_in[12] north_in[13] north_in[14] north_in[15] north_in[16]
+ north_in[17] north_in[18] north_in[19] north_in[1] north_in[20] north_in[21] north_in[22]
+ north_in[23] north_in[24] north_in[25] north_in[26] north_in[27] north_in[28] north_in[29]
+ north_in[2] north_in[30] north_in[31] north_in[32] north_in[33] north_in[34] north_in[35]
+ north_in[3] north_in[4] north_in[5] north_in[6] north_in[7] north_in[8] north_in[9]
+ north_out[0] north_out[10] north_out[11] north_out[12] north_out[13] north_out[14]
+ north_out[15] north_out[16] north_out[17] north_out[18] north_out[19] north_out[1]
+ north_out[20] north_out[21] north_out[22] north_out[23] north_out[24] north_out[25]
+ north_out[26] north_out[27] north_out[28] north_out[29] north_out[2] north_out[30]
+ north_out[31] north_out[32] north_out[33] north_out[34] north_out[35] north_out[3]
+ north_out[4] north_out[5] north_out[6] north_out[7] north_out[8] north_out[9] nw_in[0]
+ nw_in[10] nw_in[11] nw_in[12] nw_in[13] nw_in[14] nw_in[15] nw_in[16] nw_in[17]
+ nw_in[18] nw_in[19] nw_in[1] nw_in[20] nw_in[21] nw_in[22] nw_in[23] nw_in[24] nw_in[25]
+ nw_in[26] nw_in[27] nw_in[28] nw_in[29] nw_in[2] nw_in[30] nw_in[31] nw_in[32] nw_in[33]
+ nw_in[34] nw_in[35] nw_in[3] nw_in[4] nw_in[5] nw_in[6] nw_in[7] nw_in[8] nw_in[9]
+ nw_out[0] nw_out[10] nw_out[11] nw_out[12] nw_out[13] nw_out[14] nw_out[15] nw_out[16]
+ nw_out[17] nw_out[18] nw_out[19] nw_out[1] nw_out[20] nw_out[21] nw_out[22] nw_out[23]
+ nw_out[24] nw_out[25] nw_out[26] nw_out[27] nw_out[28] nw_out[29] nw_out[2] nw_out[30]
+ nw_out[31] nw_out[32] nw_out[33] nw_out[34] nw_out[35] nw_out[3] nw_out[4] nw_out[5]
+ nw_out[6] nw_out[7] nw_out[8] nw_out[9] rst se_in[0] se_in[10] se_in[11] se_in[12]
+ se_in[13] se_in[14] se_in[15] se_in[16] se_in[17] se_in[18] se_in[19] se_in[1] se_in[20]
+ se_in[21] se_in[22] se_in[23] se_in[24] se_in[25] se_in[26] se_in[27] se_in[28]
+ se_in[29] se_in[2] se_in[30] se_in[31] se_in[32] se_in[33] se_in[34] se_in[35] se_in[3]
+ se_in[4] se_in[5] se_in[6] se_in[7] se_in[8] se_in[9] se_out[0] se_out[10] se_out[11]
+ se_out[12] se_out[13] se_out[14] se_out[15] se_out[16] se_out[17] se_out[18] se_out[19]
+ se_out[1] se_out[20] se_out[21] se_out[22] se_out[23] se_out[24] se_out[25] se_out[26]
+ se_out[27] se_out[28] se_out[29] se_out[2] se_out[30] se_out[31] se_out[32] se_out[33]
+ se_out[34] se_out[35] se_out[3] se_out[4] se_out[5] se_out[6] se_out[7] se_out[8]
+ se_out[9] south_in[0] south_in[10] south_in[11] south_in[12] south_in[13] south_in[14]
+ south_in[15] south_in[16] south_in[17] south_in[18] south_in[19] south_in[1] south_in[20]
+ south_in[21] south_in[22] south_in[23] south_in[24] south_in[25] south_in[26] south_in[27]
+ south_in[28] south_in[29] south_in[2] south_in[30] south_in[31] south_in[32] south_in[33]
+ south_in[34] south_in[35] south_in[3] south_in[4] south_in[5] south_in[6] south_in[7]
+ south_in[8] south_in[9] south_out[0] south_out[10] south_out[11] south_out[12] south_out[13]
+ south_out[14] south_out[15] south_out[16] south_out[17] south_out[18] south_out[19]
+ south_out[1] south_out[20] south_out[21] south_out[22] south_out[23] south_out[24]
+ south_out[25] south_out[26] south_out[27] south_out[28] south_out[29] south_out[2]
+ south_out[30] south_out[31] south_out[32] south_out[33] south_out[34] south_out[35]
+ south_out[3] south_out[4] south_out[5] south_out[6] south_out[7] south_out[8] south_out[9]
+ sw_in[0] sw_in[10] sw_in[11] sw_in[12] sw_in[13] sw_in[14] sw_in[15] sw_in[16] sw_in[17]
+ sw_in[18] sw_in[19] sw_in[1] sw_in[20] sw_in[21] sw_in[22] sw_in[23] sw_in[24] sw_in[25]
+ sw_in[26] sw_in[27] sw_in[28] sw_in[29] sw_in[2] sw_in[30] sw_in[31] sw_in[32] sw_in[33]
+ sw_in[34] sw_in[35] sw_in[3] sw_in[4] sw_in[5] sw_in[6] sw_in[7] sw_in[8] sw_in[9]
+ sw_out[0] sw_out[10] sw_out[11] sw_out[12] sw_out[13] sw_out[14] sw_out[15] sw_out[16]
+ sw_out[17] sw_out[18] sw_out[19] sw_out[1] sw_out[20] sw_out[21] sw_out[22] sw_out[23]
+ sw_out[24] sw_out[25] sw_out[26] sw_out[27] sw_out[28] sw_out[29] sw_out[2] sw_out[30]
+ sw_out[31] sw_out[32] sw_out[33] sw_out[34] sw_out[35] sw_out[3] sw_out[4] sw_out[5]
+ sw_out[6] sw_out[7] sw_out[8] sw_out[9] west_in[0] west_in[10] west_in[11] west_in[12]
+ west_in[13] west_in[14] west_in[15] west_in[16] west_in[17] west_in[18] west_in[19]
+ west_in[1] west_in[20] west_in[21] west_in[22] west_in[23] west_in[24] west_in[25]
+ west_in[26] west_in[27] west_in[28] west_in[29] west_in[2] west_in[30] west_in[31]
+ west_in[32] west_in[33] west_in[34] west_in[35] west_in[3] west_in[4] west_in[5]
+ west_in[6] west_in[7] west_in[8] west_in[9] west_out[0] west_out[10] west_out[11]
+ west_out[12] west_out[13] west_out[14] west_out[15] west_out[16] west_out[17] west_out[18]
+ west_out[19] west_out[1] west_out[20] west_out[21] west_out[22] west_out[23] west_out[24]
+ west_out[25] west_out[26] west_out[27] west_out[28] west_out[29] west_out[2] west_out[30]
+ west_out[31] west_out[32] west_out[33] west_out[34] west_out[35] west_out[3] west_out[4]
+ west_out[5] west_out[6] west_out[7] west_out[8] west_out[9]
XFILLER_228_813 VDD VDD VSS VSS gf180mcu_as_sc_mcu7t3v3__fill_2
X_3155_ VDD VDD VSS VSS _6196_/Q _6195_/Q _4196_/B gf180mcu_as_sc_mcu7t3v3__or2_2
XFILLER_223_76 VDD VDD VSS VSS gf180mcu_as_sc_mcu7t3v3__fill_1
XPHY_EDGE_ROW_135_1_Left_363 VDD VSS gf180mcu_as_sc_mcu7t3v3__tap_2
X_3086_ VDD VDD VSS VSS _5224_/A _5870_/B gf180mcu_as_sc_mcu7t3v3__inv_2
XTAP_TAPCELL_ROW_163_1670 VDD VSS gf180mcu_as_sc_mcu7t3v3__tap_2
XTAP_TAPCELL_ROW_163_1681 VDD VSS gf180mcu_as_sc_mcu7t3v3__tap_2
XTAP_TAPCELL_ROW_67_2_2949 VDD VSS gf180mcu_as_sc_mcu7t3v3__tap_2
XFILLER_223_562 VDD VDD VSS VSS gf180mcu_as_sc_mcu7t3v3__fill_2
XFILLER_165_1186 VDD VDD VSS VSS gf180mcu_as_sc_mcu7t3v3__fillcap_4
XFILLER_210_212 VDD VDD VSS VSS gf180mcu_as_sc_mcu7t3v3__fill_1
XPHY_EDGE_ROW_72_1_Left_300 VDD VSS gf180mcu_as_sc_mcu7t3v3__tap_2
XFILLER_10_317 VDD VDD VSS VSS gf180mcu_as_sc_mcu7t3v3__fillcap_16
XFILLER_168_18 VDD VDD VSS VSS gf180mcu_as_sc_mcu7t3v3__fillcap_16
XPHY_EDGE_ROW_126_1_Right_698 VDD VSS gf180mcu_as_sc_mcu7t3v3__tap_2
X_3988_ VDD VDD VSS VSS _4023_/B _4012_/B _4012_/C _6077_/Q _6077_/D gf180mcu_as_sc_mcu7t3v3__ao22_2
X_5727_ VDD VDD VSS VSS _5729_/B _5727_/C _5874_/B _5727_/A gf180mcu_as_sc_mcu7t3v3__aoi21_2
XFILLER_176_694 VDD VDD VSS VSS gf180mcu_as_sc_mcu7t3v3__fillcap_4
XFILLER_182_119 VDD VDD VSS VSS gf180mcu_as_sc_mcu7t3v3__fill_2
X_5658_ VDD VDD VSS VSS _5668_/A _5667_/A gf180mcu_as_sc_mcu7t3v3__inv_2
XTAP_TAPCELL_ROW_94_3_2990 VDD VSS gf180mcu_as_sc_mcu7t3v3__tap_2
XFILLER_163_366 VDD VDD VSS VSS gf180mcu_as_sc_mcu7t3v3__fillcap_4
X_5589_ VDD VDD VSS VSS _5896_/A _5632_/B _5632_/C _5895_/A _5590_/D gf180mcu_as_sc_mcu7t3v3__ao22_2
X_4609_ VDD VDD VSS VSS _6333_/Q _4609_/B _6339_/Q _6339_/D gf180mcu_as_sc_mcu7t3v3__mux2_2
XFILLER_172_1135 VDD VDD VSS VSS gf180mcu_as_sc_mcu7t3v3__fillcap_16
XFILLER_172_1157 VDD VDD VSS VSS gf180mcu_as_sc_mcu7t3v3__fillcap_16
XTAP_TAPCELL_ROW_122_1_1382 VDD VSS gf180mcu_as_sc_mcu7t3v3__tap_2
Xfanout820 VDD VDD VSS VSS _5295_/B _5263_/B gf180mcu_as_sc_mcu7t3v3__buff_12
Xfanout831 VDD VDD VSS VSS _5202_/B _5310_/B gf180mcu_as_sc_mcu7t3v3__buff_12
Xfanout842 VDD VDD VSS VSS _4622_/Y _4945_/C gf180mcu_as_sc_mcu7t3v3__buff_12
XFILLER_213_1154 VDD VDD VSS VSS gf180mcu_as_sc_mcu7t3v3__fillcap_16
XFILLER_218_301 VDD VDD VSS VSS gf180mcu_as_sc_mcu7t3v3__fill_2
XPHY_EDGE_ROW_102_2_Right_939 VDD VSS gf180mcu_as_sc_mcu7t3v3__tap_2
Xfanout853 VDD VDD VSS VSS _4148_/Y _4572_/D gf180mcu_as_sc_mcu7t3v3__buff_12
Xfanout864 VDD VDD VSS VSS _4617_/Y _4792_/B gf180mcu_as_sc_mcu7t3v3__buff_12
XFILLER_133_43 VDD VDD VSS VSS gf180mcu_as_sc_mcu7t3v3__fillcap_8
XPHY_EDGE_ROW_67_1_Left_295 VDD VSS gf180mcu_as_sc_mcu7t3v3__tap_2
Xfanout886 VDD VDD VSS VSS _3300_/Y _4098_/S gf180mcu_as_sc_mcu7t3v3__buff_12
Xfanout897 VDD VDD VSS VSS _6550_/Q _4585_/A gf180mcu_as_sc_mcu7t3v3__buff_12
XFILLER_2_1221 VDD VDD VSS VSS gf180mcu_as_sc_mcu7t3v3__fillcap_4
XTAP_TAPCELL_ROW_224_2777 VDD VSS gf180mcu_as_sc_mcu7t3v3__tap_2
XTAP_TAPCELL_ROW_224_2766 VDD VSS gf180mcu_as_sc_mcu7t3v3__tap_2
XFILLER_2_1243 VDD VDD VSS VSS gf180mcu_as_sc_mcu7t3v3__fillcap_16
XFILLER_57_1212 VDD VDD VSS VSS gf180mcu_as_sc_mcu7t3v3__fill_1
XFILLER_96_1261 VDD VDD VSS VSS gf180mcu_as_sc_mcu7t3v3__fillcap_4
XPHY_EDGE_ROW_88_1_Right_660 VDD VSS gf180mcu_as_sc_mcu7t3v3__tap_2
XFILLER_144_1226 VDD VDD VSS VSS gf180mcu_as_sc_mcu7t3v3__fillcap_16
XFILLER_14_634 VDD VDD VSS VSS gf180mcu_as_sc_mcu7t3v3__fillcap_16
XFILLER_183_1264 VDD VDD VSS VSS gf180mcu_as_sc_mcu7t3v3__fill_1
XFILLER_199_786 VDD VDD VSS VSS gf180mcu_as_sc_mcu7t3v3__fill_1
XFILLER_214_584 VDD VDD VSS VSS gf180mcu_as_sc_mcu7t3v3__fill_1
XFILLER_14_667 VDD VDD VSS VSS gf180mcu_as_sc_mcu7t3v3__fillcap_8
XFILLER_201_212 VDD VDD VSS VSS gf180mcu_as_sc_mcu7t3v3__fillcap_8
XFILLER_9_104 VDD VDD VSS VSS gf180mcu_as_sc_mcu7t3v3__fillcap_16
XFILLER_167_650 VDD VDD VSS VSS gf180mcu_as_sc_mcu7t3v3__fillcap_8
XFILLER_220_1103 VDD VDD VSS VSS gf180mcu_as_sc_mcu7t3v3__fillcap_16
XFILLER_155_823 VDD VDD VSS VSS gf180mcu_as_sc_mcu7t3v3__fillcap_4
XFILLER_154_311 VDD VDD VSS VSS gf180mcu_as_sc_mcu7t3v3__fillcap_4
XFILLER_154_333 VDD VDD VSS VSS gf180mcu_as_sc_mcu7t3v3__fillcap_16
XFILLER_166_171 VDD VDD VSS VSS gf180mcu_as_sc_mcu7t3v3__fillcap_4
XFILLER_166_193 VDD VDD VSS VSS gf180mcu_as_sc_mcu7t3v3__fillcap_4
XFILLER_177_1068 VDD VDD VSS VSS gf180mcu_as_sc_mcu7t3v3__fillcap_16
XFILLER_190_1235 VDD VDD VSS VSS gf180mcu_as_sc_mcu7t3v3__fillcap_4
XFILLER_218_1065 VDD VDD VSS VSS gf180mcu_as_sc_mcu7t3v3__fillcap_16
XPHY_EDGE_ROW_64_2_Right_901 VDD VSS gf180mcu_as_sc_mcu7t3v3__tap_2
XFILLER_151_1208 VDD VDD VSS VSS gf180mcu_as_sc_mcu7t3v3__fillcap_16
XFILLER_218_1087 VDD VDD VSS VSS gf180mcu_as_sc_mcu7t3v3__fillcap_16
XFILLER_150_594 VDD VDD VSS VSS gf180mcu_as_sc_mcu7t3v3__fill_1
XFILLER_3_67 VDD VDD VSS VSS gf180mcu_as_sc_mcu7t3v3__fill_2
XFILLER_7_1154 VDD VDD VSS VSS gf180mcu_as_sc_mcu7t3v3__fillcap_16
XTAP_TAPCELL_ROW_8_1160 VDD VSS gf180mcu_as_sc_mcu7t3v3__tap_2
XTAP_TAPCELL_ROW_72_1_1357 VDD VSS gf180mcu_as_sc_mcu7t3v3__tap_2
XFILLER_224_304 VDD VDD VSS VSS gf180mcu_as_sc_mcu7t3v3__fillcap_8
XFILLER_184_1017 VDD VDD VSS VSS gf180mcu_as_sc_mcu7t3v3__fillcap_16
X_4960_ VDD VDD VSS VSS _6524_/Q _4960_/B _4960_/C _4960_/D _4961_/D gf180mcu_as_sc_mcu7t3v3__ao22_2
XTAP_TAPCELL_ROW_4_1079 VDD VSS gf180mcu_as_sc_mcu7t3v3__tap_2
XFILLER_189_252 VDD VDD VSS VSS gf180mcu_as_sc_mcu7t3v3__fill_1
XFILLER_225_1014 VDD VDD VSS VSS gf180mcu_as_sc_mcu7t3v3__fillcap_16
X_4891_ VDD VDD VSS VSS _4892_/C _5881_/A _4962_/B _4891_/C gf180mcu_as_sc_mcu7t3v3__ao21_2
X_3911_ VDD VDD VSS VSS _3912_/D _3911_/B _5885_/A gf180mcu_as_sc_mcu7t3v3__nand2b_2
X_3842_ VDD VDD VSS VSS _3926_/B _5829_/A _3843_/D gf180mcu_as_sc_mcu7t3v3__and2_2
XFILLER_149_138 VDD VDD VSS VSS gf180mcu_as_sc_mcu7t3v3__fillcap_16
XFILLER_177_447 VDD VDD VSS VSS gf180mcu_as_sc_mcu7t3v3__fill_1
XFILLER_177_458 VDD VDD VSS VSS gf180mcu_as_sc_mcu7t3v3__fillcap_4
XFILLER_177_469 VDD VDD VSS VSS gf180mcu_as_sc_mcu7t3v3__fillcap_16
XFILLER_20_626 VDD VDD VSS VSS gf180mcu_as_sc_mcu7t3v3__fill_1
X_5512_ VDD VDD VSS VSS _5817_/A _5569_/B _5512_/C _5512_/D _5513_/B gf180mcu_as_sc_mcu7t3v3__ao211_2
X_3773_ VDD VDD VSS VSS _6027_/Q _3895_/B _4034_/B _3895_/D _6027_/D gf180mcu_as_sc_mcu7t3v3__ao22_2
X_6492_ VDD VDD VSS VSS _6492_/CLK _6492_/D _6492_/Q gf180mcu_as_sc_mcu7t3v3__dfxtp_2
Xoutput401 VDD VDD VSS VSS _6367_/Q north_out[26] gf180mcu_as_sc_mcu7t3v3__buff_12
X_5443_ VDD VDD VSS VSS _5484_/B _5748_/A _5443_/A _5446_/A gf180mcu_as_sc_mcu7t3v3__mux2_2
XFILLER_156_1119 VDD VDD VSS VSS gf180mcu_as_sc_mcu7t3v3__fillcap_16
Xoutput434 VDD VDD VSS VSS _6400_/Q south_out[23] gf180mcu_as_sc_mcu7t3v3__buff_12
Xoutput423 VDD VDD VSS VSS _6390_/Q south_out[13] gf180mcu_as_sc_mcu7t3v3__buff_12
Xoutput412 VDD VDD VSS VSS _6344_/Q north_out[3] gf180mcu_as_sc_mcu7t3v3__buff_12
X_5374_ VDD VDD VSS VSS _6494_/Q _5490_/B _5491_/B _5683_/A _5375_/C gf180mcu_as_sc_mcu7t3v3__ao22_2
XTAP_TAPCELL_ROW_187_2113 VDD VSS gf180mcu_as_sc_mcu7t3v3__tap_2
XTAP_TAPCELL_ROW_187_2102 VDD VSS gf180mcu_as_sc_mcu7t3v3__tap_2
Xoutput478 VDD VDD VSS VSS _6479_/Q west_out[30] gf180mcu_as_sc_mcu7t3v3__buff_12
Xoutput467 VDD VDD VSS VSS _6469_/Q west_out[20] gf180mcu_as_sc_mcu7t3v3__buff_12
Xoutput456 VDD VDD VSS VSS _6459_/Q west_out[10] gf180mcu_as_sc_mcu7t3v3__buff_12
Xoutput445 VDD VDD VSS VSS _6410_/Q south_out[33] gf180mcu_as_sc_mcu7t3v3__buff_12
X_4325_ VDD VDD VSS VSS _6214_/D _4325_/B _4325_/A gf180mcu_as_sc_mcu7t3v3__nand2_2
Xoutput489 VDD VDD VSS VSS _6457_/Q west_out[8] gf180mcu_as_sc_mcu7t3v3__buff_12
XFILLER_141_594 VDD VDD VSS VSS gf180mcu_as_sc_mcu7t3v3__fillcap_4
XTAP_TAPCELL_ROW_165_1710 VDD VSS gf180mcu_as_sc_mcu7t3v3__tap_2
X_4256_ VDD VDD VSS VSS _5323_/A _4280_/B _4256_/C _4280_/D _4259_/B gf180mcu_as_sc_mcu7t3v3__ao211_2
XTAP_TAPCELL_ROW_114_2_3019 VDD VSS gf180mcu_as_sc_mcu7t3v3__tap_2
X_4187_ VDD VDD VSS VSS _4188_/C _6196_/Q _6195_/Q gf180mcu_as_sc_mcu7t3v3__nand2_2
X_3207_ VDD VDD VSS VSS _3208_/A _6136_/Q _6264_/Q gf180mcu_as_sc_mcu7t3v3__nand2b_2
XFILLER_227_142 VDD VDD VSS VSS gf180mcu_as_sc_mcu7t3v3__fill_1
X_3138_ VDD VDD VSS VSS _3426_/A _4524_/B _4509_/A gf180mcu_as_sc_mcu7t3v3__nor2_2
XTAP_TAPCELL_ROW_206_2452 VDD VSS gf180mcu_as_sc_mcu7t3v3__tap_2
XTAP_TAPCELL_ROW_206_2441 VDD VSS gf180mcu_as_sc_mcu7t3v3__tap_2
X_3069_ VDD VDD VSS VSS _5072_/A _5737_/A gf180mcu_as_sc_mcu7t3v3__inv_2
XFILLER_168_414 VDD VDD VSS VSS gf180mcu_as_sc_mcu7t3v3__fill_1
XFILLER_196_734 VDD VDD VSS VSS gf180mcu_as_sc_mcu7t3v3__fill_1
XTAP_TAPCELL_ROW_198_2297 VDD VSS gf180mcu_as_sc_mcu7t3v3__tap_2
Xwire506 VDD VDD VSS VSS _3364_/Y wire506/Y gf180mcu_as_sc_mcu7t3v3__clkbuff_12
XFILLER_104_1210 VDD VDD VSS VSS gf180mcu_as_sc_mcu7t3v3__fillcap_8
XFILLER_6_107 VDD VDD VSS VSS gf180mcu_as_sc_mcu7t3v3__fillcap_16
XPHY_EDGE_ROW_127_1_Right_699 VDD VSS gf180mcu_as_sc_mcu7t3v3__tap_2
XFILLER_195_299 VDD VDD VSS VSS gf180mcu_as_sc_mcu7t3v3__fill_1
XFILLER_195_49 VDD VDD VSS VSS gf180mcu_as_sc_mcu7t3v3__fillcap_16
XFILLER_151_314 VDD VDD VSS VSS gf180mcu_as_sc_mcu7t3v3__fillcap_16
XFILLER_163_174 VDD VDD VSS VSS gf180mcu_as_sc_mcu7t3v3__fillcap_16
XFILLER_132_594 VDD VDD VSS VSS gf180mcu_as_sc_mcu7t3v3__fillcap_4
Xfanout650 VDD VDD VSS VSS _6005_/B _6525_/D gf180mcu_as_sc_mcu7t3v3__buff_12
XTAP_TAPCELL_ROW_226_2817 VDD VSS gf180mcu_as_sc_mcu7t3v3__tap_2
XTAP_TAPCELL_ROW_226_2806 VDD VSS gf180mcu_as_sc_mcu7t3v3__tap_2
XFILLER_219_632 VDD VDD VSS VSS gf180mcu_as_sc_mcu7t3v3__fillcap_4
Xfanout661 VDD VDD VSS VSS _5842_/C _5856_/B gf180mcu_as_sc_mcu7t3v3__buff_12
Xfanout672 VDD VDD VSS VSS _5639_/B _5632_/C gf180mcu_as_sc_mcu7t3v3__buff_12
Xfanout683 VDD VDD VSS VSS _5314_/S _5296_/C gf180mcu_as_sc_mcu7t3v3__buff_12
XFILLER_207_838 VDD VDD VSS VSS gf180mcu_as_sc_mcu7t3v3__fill_2
XFILLER_219_698 VDD VDD VSS VSS gf180mcu_as_sc_mcu7t3v3__fill_2
XFILLER_160_85 VDD VDD VSS VSS gf180mcu_as_sc_mcu7t3v3__fillcap_16
XFILLER_222_819 VDD VDD VSS VSS gf180mcu_as_sc_mcu7t3v3__fillcap_4
XPHY_EDGE_ROW_89_1_Right_661 VDD VSS gf180mcu_as_sc_mcu7t3v3__tap_2
XFILLER_14_442 VDD VDD VSS VSS gf180mcu_as_sc_mcu7t3v3__fill_2
XFILLER_15_976 VDD VDD VSS VSS gf180mcu_as_sc_mcu7t3v3__fillcap_4
XFILLER_15_998 VDD VDD VSS VSS gf180mcu_as_sc_mcu7t3v3__fillcap_16
XFILLER_199_572 VDD VDD VSS VSS gf180mcu_as_sc_mcu7t3v3__fill_2
XFILLER_202_543 VDD VDD VSS VSS gf180mcu_as_sc_mcu7t3v3__fillcap_16
XFILLER_169_72 VDD VDD VSS VSS gf180mcu_as_sc_mcu7t3v3__fillcap_16
XFILLER_186_222 VDD VDD VSS VSS gf180mcu_as_sc_mcu7t3v3__fill_1
XFILLER_186_244 VDD VDD VSS VSS gf180mcu_as_sc_mcu7t3v3__fill_1
XFILLER_168_992 VDD VDD VSS VSS gf180mcu_as_sc_mcu7t3v3__fillcap_16
XFILLER_174_428 VDD VDD VSS VSS gf180mcu_as_sc_mcu7t3v3__fillcap_16
XFILLER_70_1242 VDD VDD VSS VSS gf180mcu_as_sc_mcu7t3v3__fill_1
XFILLER_70_1264 VDD VDD VSS VSS gf180mcu_as_sc_mcu7t3v3__fill_1
XFILLER_10_681 VDD VDD VSS VSS gf180mcu_as_sc_mcu7t3v3__fillcap_8
XFILLER_155_642 VDD VDD VSS VSS gf180mcu_as_sc_mcu7t3v3__fill_1
XFILLER_155_675 VDD VDD VSS VSS gf180mcu_as_sc_mcu7t3v3__fillcap_4
XFILLER_170_601 VDD VDD VSS VSS gf180mcu_as_sc_mcu7t3v3__fill_2
XFILLER_182_461 VDD VDD VSS VSS gf180mcu_as_sc_mcu7t3v3__fill_2
XFILLER_6_674 VDD VDD VSS VSS gf180mcu_as_sc_mcu7t3v3__fillcap_8
XPHY_EDGE_ROW_102_2_Left_543 VDD VSS gf180mcu_as_sc_mcu7t3v3__tap_2
XPHY_EDGE_ROW_219_Left_447 VDD VSS gf180mcu_as_sc_mcu7t3v3__tap_2
XFILLER_170_667 VDD VDD VSS VSS gf180mcu_as_sc_mcu7t3v3__fillcap_16
XPHY_EDGE_ROW_65_2_Right_902 VDD VSS gf180mcu_as_sc_mcu7t3v3__tap_2
XFILLER_123_594 VDD VDD VSS VSS gf180mcu_as_sc_mcu7t3v3__fillcap_4
XFILLER_190_1065 VDD VDD VSS VSS gf180mcu_as_sc_mcu7t3v3__fillcap_16
XFILLER_190_1087 VDD VDD VSS VSS gf180mcu_as_sc_mcu7t3v3__fillcap_16
X_5090_ VDD VDD VSS VSS _5091_/B _5804_/D _5237_/S _5754_/A gf180mcu_as_sc_mcu7t3v3__aoi21b_2
X_4110_ VDD VDD VSS VSS _4115_/S _6164_/Q _6163_/Q _6163_/D gf180mcu_as_sc_mcu7t3v3__mux2_2
XTAP_TAPCELL_ROW_182_2021 VDD VSS gf180mcu_as_sc_mcu7t3v3__tap_2
XTAP_TAPCELL_ROW_182_2010 VDD VSS gf180mcu_as_sc_mcu7t3v3__tap_2
XFILLER_84_629 VDD VDD VSS VSS gf180mcu_as_sc_mcu7t3v3__fill_1
X_4041_ VDD VDD VSS VSS _4041_/D _4045_/A _4041_/B _4061_/C _6119_/D gf180mcu_as_sc_mcu7t3v3__ao31_2
XFILLER_209_142 VDD VDD VSS VSS gf180mcu_as_sc_mcu7t3v3__fillcap_16
XTAP_TAPCELL_ROW_6_1119 VDD VSS gf180mcu_as_sc_mcu7t3v3__tap_2
XFILLER_209_164 VDD VDD VSS VSS gf180mcu_as_sc_mcu7t3v3__fill_1
Xmesh_tile_1071 VDD VDD VSS VSS ne_out[30] gf180mcu_as_sc_mcu7t3v3__tiel_4
Xmesh_tile_1060 VDD VDD VSS VSS ne_out[19] gf180mcu_as_sc_mcu7t3v3__tiel_4
XPHY_EDGE_ROW_228_Left_456 VDD VSS gf180mcu_as_sc_mcu7t3v3__tap_2
Xmesh_tile_1093 VDD VDD VSS VSS nw_out[16] gf180mcu_as_sc_mcu7t3v3__tiel_4
Xmesh_tile_1082 VDD VDD VSS VSS nw_out[5] gf180mcu_as_sc_mcu7t3v3__tiel_4
X_5992_ VDD VDD VSS VSS _6011_/B _6215_/Q _6505_/D gf180mcu_as_sc_mcu7t3v3__and2_2
XFILLER_127_1210 VDD VDD VSS VSS gf180mcu_as_sc_mcu7t3v3__fillcap_4
XFILLER_206_893 VDD VDD VSS VSS gf180mcu_as_sc_mcu7t3v3__fillcap_16
X_4943_ VDD VDD VSS VSS _4943_/B _5977_/A _6372_/D gf180mcu_as_sc_mcu7t3v3__and2_2
XFILLER_178_734 VDD VDD VSS VSS gf180mcu_as_sc_mcu7t3v3__fill_1
XFILLER_221_830 VDD VDD VSS VSS gf180mcu_as_sc_mcu7t3v3__fillcap_8
XTAP_TAPCELL_ROW_201_2360 VDD VSS gf180mcu_as_sc_mcu7t3v3__tap_2
XFILLER_178_756 VDD VDD VSS VSS gf180mcu_as_sc_mcu7t3v3__fill_1
X_4874_ VDD VDD VSS VSS _4874_/B _5978_/A _6364_/D gf180mcu_as_sc_mcu7t3v3__and2_2
XFILLER_162_1189 VDD VDD VSS VSS gf180mcu_as_sc_mcu7t3v3__fillcap_16
XFILLER_178_789 VDD VDD VSS VSS gf180mcu_as_sc_mcu7t3v3__fillcap_4
XFILLER_192_214 VDD VDD VSS VSS gf180mcu_as_sc_mcu7t3v3__fill_1
XFILLER_197_1208 VDD VDD VSS VSS gf180mcu_as_sc_mcu7t3v3__fillcap_16
X_3825_ VDD VDD VSS VSS _3889_/B _5816_/A _3826_/D gf180mcu_as_sc_mcu7t3v3__and2_2
XFILLER_174_951 VDD VDD VSS VSS gf180mcu_as_sc_mcu7t3v3__fill_1
XFILLER_192_247 VDD VDD VSS VSS gf180mcu_as_sc_mcu7t3v3__fillcap_8
XTAP_TAPCELL_ROW_158_1580 VDD VSS gf180mcu_as_sc_mcu7t3v3__tap_2
XTAP_TAPCELL_ROW_158_1591 VDD VSS gf180mcu_as_sc_mcu7t3v3__tap_2
X_6544_ VDD VDD VSS VSS _6546_/CLK _6544_/D _6544_/Q gf180mcu_as_sc_mcu7t3v3__dfxtp_2
X_3756_ VDD VDD VSS VSS _3869_/B _5759_/A _3757_/D gf180mcu_as_sc_mcu7t3v3__and2_2
XFILLER_192_269 VDD VDD VSS VSS gf180mcu_as_sc_mcu7t3v3__fill_2
XFILLER_203_1186 VDD VDD VSS VSS gf180mcu_as_sc_mcu7t3v3__fillcap_4
XPHY_EDGE_ROW_34_2_Left_475 VDD VSS gf180mcu_as_sc_mcu7t3v3__tap_2
X_6475_ VDD VDD VSS VSS _6484_/CLK _6475_/D _6475_/Q gf180mcu_as_sc_mcu7t3v3__dfxtp_2
X_5426_ VDD VDD VSS VSS _5637_/B _5731_/A _5426_/A _5427_/D gf180mcu_as_sc_mcu7t3v3__mux2_2
X_3687_ VDD VDD VSS VSS _6018_/Q _3830_/B _4022_/D _3830_/D _6018_/D gf180mcu_as_sc_mcu7t3v3__ao22_2
XFILLER_160_155 VDD VDD VSS VSS gf180mcu_as_sc_mcu7t3v3__fillcap_16
XFILLER_160_177 VDD VDD VSS VSS gf180mcu_as_sc_mcu7t3v3__fillcap_16
X_5357_ VDD VDD VSS VSS _5644_/B _5644_/A _5357_/Y gf180mcu_as_sc_mcu7t3v3__and2_2
XFILLER_114_594 VDD VDD VSS VSS gf180mcu_as_sc_mcu7t3v3__fillcap_16
X_5288_ VDD VDD VSS VSS _5289_/D _5288_/C _5309_/B _5340_/B gf180mcu_as_sc_mcu7t3v3__aoi21_2
X_4308_ VDD VDD VSS VSS _6212_/Q _4399_/B _4399_/C _6213_/Q _4309_/C gf180mcu_as_sc_mcu7t3v3__ao22_2
Xwire1017 VDD VDD VSS VSS wire1017/A _5690_/B gf180mcu_as_sc_mcu7t3v3__clkbuff_12
X_4239_ VDD VDD VSS VSS _4239_/A _4280_/B _4239_/C _4280_/D _4243_/B gf180mcu_as_sc_mcu7t3v3__ao211_2
XFILLER_114_45 VDD VDD VSS VSS gf180mcu_as_sc_mcu7t3v3__fillcap_4
XFILLER_210_1135 VDD VDD VSS VSS gf180mcu_as_sc_mcu7t3v3__fillcap_16
XFILLER_167_1012 VDD VDD VSS VSS gf180mcu_as_sc_mcu7t3v3__fillcap_16
XFILLER_210_1157 VDD VDD VSS VSS gf180mcu_as_sc_mcu7t3v3__fillcap_16
XFILLER_215_112 VDD VDD VSS VSS gf180mcu_as_sc_mcu7t3v3__fill_2
XFILLER_74_49 VDD VDD VSS VSS gf180mcu_as_sc_mcu7t3v3__fill_2
XTAP_TAPCELL_ROW_221_2725 VDD VSS gf180mcu_as_sc_mcu7t3v3__tap_2
XTAP_TAPCELL_ROW_221_2714 VDD VSS gf180mcu_as_sc_mcu7t3v3__tap_2
XFILLER_15_206 VDD VDD VSS VSS gf180mcu_as_sc_mcu7t3v3__fillcap_4
XFILLER_15_228 VDD VDD VSS VSS gf180mcu_as_sc_mcu7t3v3__fillcap_16
XFILLER_90_37 VDD VDD VSS VSS gf180mcu_as_sc_mcu7t3v3__fillcap_8
XTAP_TAPCELL_ROW_82_3_2972 VDD VSS gf180mcu_as_sc_mcu7t3v3__tap_2
XFILLER_211_340 VDD VDD VSS VSS gf180mcu_as_sc_mcu7t3v3__fill_1
XFILLER_212_874 VDD VDD VSS VSS gf180mcu_as_sc_mcu7t3v3__fill_1
XTAP_TAPCELL_ROW_178_1945 VDD VSS gf180mcu_as_sc_mcu7t3v3__tap_2
XFILLER_12_979 VDD VDD VSS VSS gf180mcu_as_sc_mcu7t3v3__fillcap_16
XFILLER_156_417 VDD VDD VSS VSS gf180mcu_as_sc_mcu7t3v3__fill_2
XTAP_TAPCELL_ROW_219_2676 VDD VSS gf180mcu_as_sc_mcu7t3v3__tap_2
XFILLER_11_489 VDD VDD VSS VSS gf180mcu_as_sc_mcu7t3v3__fill_1
XFILLER_128_2 VDD VDD VSS VSS gf180mcu_as_sc_mcu7t3v3__fillcap_16
XFILLER_183_214 VDD VDD VSS VSS gf180mcu_as_sc_mcu7t3v3__fill_1
XFILLER_221_1264 VDD VDD VSS VSS gf180mcu_as_sc_mcu7t3v3__fill_1
XTAP_TAPCELL_ROW_219_2687 VDD VSS gf180mcu_as_sc_mcu7t3v3__tap_2
XFILLER_137_664 VDD VDD VSS VSS gf180mcu_as_sc_mcu7t3v3__fill_2
XFILLER_180_932 VDD VDD VSS VSS gf180mcu_as_sc_mcu7t3v3__fill_2
XFILLER_152_678 VDD VDD VSS VSS gf180mcu_as_sc_mcu7t3v3__fill_2
XFILLER_174_1049 VDD VDD VSS VSS gf180mcu_as_sc_mcu7t3v3__fillcap_16
XFILLER_105_594 VDD VDD VSS VSS gf180mcu_as_sc_mcu7t3v3__fillcap_4
XFILLER_215_1046 VDD VDD VSS VSS gf180mcu_as_sc_mcu7t3v3__fillcap_4
XFILLER_3_699 VDD VDD VSS VSS gf180mcu_as_sc_mcu7t3v3__fill_1
XFILLER_215_1068 VDD VDD VSS VSS gf180mcu_as_sc_mcu7t3v3__fillcap_16
XFILLER_4_1135 VDD VDD VSS VSS gf180mcu_as_sc_mcu7t3v3__fillcap_16
XFILLER_206_101 VDD VDD VSS VSS gf180mcu_as_sc_mcu7t3v3__fillcap_4
XFILLER_4_1157 VDD VDD VSS VSS gf180mcu_as_sc_mcu7t3v3__fillcap_16
XFILLER_74_640 VDD VDD VSS VSS gf180mcu_as_sc_mcu7t3v3__fill_1
XFILLER_222_616 VDD VDD VSS VSS gf180mcu_as_sc_mcu7t3v3__fill_2
XTAP_TAPCELL_ROW_1_1038 VDD VSS gf180mcu_as_sc_mcu7t3v3__tap_2
XTAP_TAPCELL_ROW_1_1027 VDD VSS gf180mcu_as_sc_mcu7t3v3__tap_2
XFILLER_15_740 VDD VDD VSS VSS gf180mcu_as_sc_mcu7t3v3__fill_2
XFILLER_159_244 VDD VDD VSS VSS gf180mcu_as_sc_mcu7t3v3__fillcap_16
XFILLER_202_351 VDD VDD VSS VSS gf180mcu_as_sc_mcu7t3v3__fill_1
XFILLER_203_852 VDD VDD VSS VSS gf180mcu_as_sc_mcu7t3v3__fill_2
XFILLER_222_1017 VDD VDD VSS VSS gf180mcu_as_sc_mcu7t3v3__fillcap_16
XFILLER_187_564 VDD VDD VSS VSS gf180mcu_as_sc_mcu7t3v3__fill_1
XFILLER_9_88 VDD VDD VSS VSS gf180mcu_as_sc_mcu7t3v3__fillcap_16
X_4590_ VDD VDD VSS VSS _6337_/Q _6333_/Q _4592_/B gf180mcu_as_sc_mcu7t3v3__and2_2
X_3610_ VDD VDD VSS VSS _5649_/D _3610_/B _5646_/A _3658_/B _3611_/B gf180mcu_as_sc_mcu7t3v3__ao22_2
XFILLER_128_653 VDD VDD VSS VSS gf180mcu_as_sc_mcu7t3v3__fill_1
XFILLER_174_247 VDD VDD VSS VSS gf180mcu_as_sc_mcu7t3v3__fillcap_4
X_3541_ VDD VDD VSS VSS _4615_/A _4615_/B _4617_/A _3546_/B gf180mcu_as_sc_mcu7t3v3__nand3_2
XFILLER_156_995 VDD VDD VSS VSS gf180mcu_as_sc_mcu7t3v3__fillcap_16
XFILLER_196_1263 VDD VDD VSS VSS gf180mcu_as_sc_mcu7t3v3__fill_2
XPHY_EDGE_ROW_144_1_Left_372 VDD VSS gf180mcu_as_sc_mcu7t3v3__tap_2
XFILLER_170_453 VDD VDD VSS VSS gf180mcu_as_sc_mcu7t3v3__fill_2
X_6260_ VDD VDD VSS VSS clkload7/A _6260_/D _6260_/Q gf180mcu_as_sc_mcu7t3v3__dfxtp_2
X_3472_ VDD VDD VSS VSS _3473_/B _5350_/C _5914_/A _5339_/A gf180mcu_as_sc_mcu7t3v3__aoi21_2
XFILLER_171_998 VDD VDD VSS VSS gf180mcu_as_sc_mcu7t3v3__fillcap_16
X_6191_ VDD VDD VSS VSS _6486_/CLK _6191_/D _6191_/Q gf180mcu_as_sc_mcu7t3v3__dfxtp_2
X_5211_ VDD VDD VSS VSS _5861_/A _5292_/B _5292_/C _5864_/A _5213_/B gf180mcu_as_sc_mcu7t3v3__ao22_2
XFILLER_9_1046 VDD VDD VSS VSS gf180mcu_as_sc_mcu7t3v3__fillcap_4
X_5142_ VDD VDD VSS VSS _6508_/Q _5142_/B _5142_/C _5142_/D _5144_/C gf180mcu_as_sc_mcu7t3v3__ao22_2
XFILLER_9_1068 VDD VDD VSS VSS gf180mcu_as_sc_mcu7t3v3__fillcap_16
XPHY_EDGE_ROW_66_2_Right_903 VDD VSS gf180mcu_as_sc_mcu7t3v3__tap_2
XFILLER_215_88 VDD VDD VSS VSS gf180mcu_as_sc_mcu7t3v3__fillcap_16
X_5073_ VDD VDD VSS VSS _5074_/D _5742_/A _5293_/B _5186_/B gf180mcu_as_sc_mcu7t3v3__ao21_2
XFILLER_226_944 VDD VDD VSS VSS gf180mcu_as_sc_mcu7t3v3__fill_1
XPHY_EDGE_ROW_206_Right_74 VDD VSS gf180mcu_as_sc_mcu7t3v3__tap_2
X_4024_ VDD VDD VSS VSS _6107_/Q _4044_/B _4029_/C _4024_/D _6107_/D gf180mcu_as_sc_mcu7t3v3__ao22_2
XTAP_TAPCELL_ROW_203_2400 VDD VSS gf180mcu_as_sc_mcu7t3v3__tap_2
XFILLER_198_807 VDD VDD VSS VSS gf180mcu_as_sc_mcu7t3v3__fill_2
XFILLER_226_988 VDD VDD VSS VSS gf180mcu_as_sc_mcu7t3v3__fillcap_16
XFILLER_12_209 VDD VDD VSS VSS gf180mcu_as_sc_mcu7t3v3__fillcap_16
X_5975_ VDD VDD VSS VSS _6015_/A _6491_/Q _5975_/B _5975_/C _5976_/B gf180mcu_as_sc_mcu7t3v3__ao31_2
X_4926_ VDD VDD VSS VSS _5911_/A _4963_/B _4926_/C _4926_/D _4927_/C gf180mcu_as_sc_mcu7t3v3__ao211_2
XTAP_TAPCELL_ROW_195_2256 VDD VSS gf180mcu_as_sc_mcu7t3v3__tap_2
XTAP_TAPCELL_ROW_195_2245 VDD VSS gf180mcu_as_sc_mcu7t3v3__tap_2
X_4857_ VDD VDD VSS VSS _4857_/B _5853_/A _4858_/C gf180mcu_as_sc_mcu7t3v3__and2_2
XFILLER_14_1221 VDD VDD VSS VSS gf180mcu_as_sc_mcu7t3v3__fillcap_4
XFILLER_166_737 VDD VDD VSS VSS gf180mcu_as_sc_mcu7t3v3__fill_2
XFILLER_176_18 VDD VDD VSS VSS gf180mcu_as_sc_mcu7t3v3__fillcap_16
XFILLER_178_597 VDD VDD VSS VSS gf180mcu_as_sc_mcu7t3v3__fillcap_4
XFILLER_60_29 VDD VDD VSS VSS gf180mcu_as_sc_mcu7t3v3__fillcap_4
X_3808_ VDD VDD VSS VSS _5802_/D _3808_/B _3808_/C _3809_/B _3810_/C gf180mcu_as_sc_mcu7t3v3__ao211_2
XFILLER_119_664 VDD VDD VSS VSS gf180mcu_as_sc_mcu7t3v3__fill_2
XPHY_EDGE_ROW_215_Right_83 VDD VSS gf180mcu_as_sc_mcu7t3v3__tap_2
XTAP_TAPCELL_ROW_173_1853 VDD VSS gf180mcu_as_sc_mcu7t3v3__tap_2
XTAP_TAPCELL_ROW_173_1864 VDD VSS gf180mcu_as_sc_mcu7t3v3__tap_2
X_6527_ VDD VDD VSS VSS _6527_/CLK _6527_/D _6527_/Q gf180mcu_as_sc_mcu7t3v3__dfxtp_2
X_4788_ VDD VDD VSS VSS _4797_/S _4788_/B _5795_/A _4789_/B gf180mcu_as_sc_mcu7t3v3__mux2_2
XFILLER_174_792 VDD VDD VSS VSS gf180mcu_as_sc_mcu7t3v3__fill_2
X_3739_ VDD VDD VSS VSS _5739_/A _3872_/B _3739_/C _3910_/B _3741_/A gf180mcu_as_sc_mcu7t3v3__ao211_2
XFILLER_134_645 VDD VDD VSS VSS gf180mcu_as_sc_mcu7t3v3__fillcap_16
X_6458_ VDD VDD VSS VSS _6474_/CLK _6458_/D _6458_/Q gf180mcu_as_sc_mcu7t3v3__dfxtp_2
XTAP_TAPCELL_ROW_214_2595 VDD VSS gf180mcu_as_sc_mcu7t3v3__tap_2
X_6389_ VDD VDD VSS VSS clkload3/A _6389_/D _6389_/Q gf180mcu_as_sc_mcu7t3v3__dfxtp_2
X_5409_ VDD VDD VSS VSS _5714_/A _5494_/B _5492_/B _5718_/A _5410_/D gf180mcu_as_sc_mcu7t3v3__ao22_2
XPHY_EDGE_ROW_224_Right_92 VDD VSS gf180mcu_as_sc_mcu7t3v3__tap_2
XFILLER_56_640 VDD VDD VSS VSS gf180mcu_as_sc_mcu7t3v3__fill_2
XFILLER_204_605 VDD VDD VSS VSS gf180mcu_as_sc_mcu7t3v3__fill_2
XFILLER_216_454 VDD VDD VSS VSS gf180mcu_as_sc_mcu7t3v3__fill_1
XFILLER_156_225 VDD VDD VSS VSS gf180mcu_as_sc_mcu7t3v3__fillcap_16
XFILLER_157_737 VDD VDD VSS VSS gf180mcu_as_sc_mcu7t3v3__fill_1
XFILLER_156_247 VDD VDD VSS VSS gf180mcu_as_sc_mcu7t3v3__fillcap_16
XFILLER_171_206 VDD VDD VSS VSS gf180mcu_as_sc_mcu7t3v3__fillcap_4
XFILLER_152_420 VDD VDD VSS VSS gf180mcu_as_sc_mcu7t3v3__fill_2
XFILLER_166_62 VDD VDD VSS VSS gf180mcu_as_sc_mcu7t3v3__fillcap_16
XFILLER_153_976 VDD VDD VSS VSS gf180mcu_as_sc_mcu7t3v3__fillcap_4
XFILLER_153_998 VDD VDD VSS VSS gf180mcu_as_sc_mcu7t3v3__fillcap_16
XFILLER_140_626 VDD VDD VSS VSS gf180mcu_as_sc_mcu7t3v3__fill_1
XTAP_TAPCELL_ROW_25_2_2886 VDD VSS gf180mcu_as_sc_mcu7t3v3__tap_2
XFILLER_182_83 VDD VDD VSS VSS gf180mcu_as_sc_mcu7t3v3__fill_1
XFILLER_223_903 VDD VDD VSS VSS gf180mcu_as_sc_mcu7t3v3__fillcap_4
XFILLER_228_1226 VDD VDD VSS VSS gf180mcu_as_sc_mcu7t3v3__fillcap_16
XFILLER_222_435 VDD VDD VSS VSS gf180mcu_as_sc_mcu7t3v3__fillcap_16
XFILLER_223_958 VDD VDD VSS VSS gf180mcu_as_sc_mcu7t3v3__fillcap_16
XFILLER_37_1210 VDD VDD VSS VSS gf180mcu_as_sc_mcu7t3v3__fillcap_4
X_5760_ VDD VDD VSS VSS _5762_/B _5760_/C _5857_/B _5760_/A gf180mcu_as_sc_mcu7t3v3__aoi21_2
XFILLER_163_1262 VDD VDD VSS VSS gf180mcu_as_sc_mcu7t3v3__fill_2
X_5691_ VDD VDD VSS VSS _5691_/A _5799_/B _5691_/C _5799_/D _5692_/D gf180mcu_as_sc_mcu7t3v3__ao22_2
X_4711_ VDD VDD VSS VSS _4713_/C _4711_/C _4878_/B _5724_/B gf180mcu_as_sc_mcu7t3v3__aoi21b_2
X_4642_ VDD VDD VSS VSS _4774_/C _4784_/B _4792_/B gf180mcu_as_sc_mcu7t3v3__nor2b_2
XFILLER_163_718 VDD VDD VSS VSS gf180mcu_as_sc_mcu7t3v3__fillcap_4
XTAP_TAPCELL_ROW_190_2164 VDD VSS gf180mcu_as_sc_mcu7t3v3__tap_2
XTAP_TAPCELL_ROW_190_2153 VDD VSS gf180mcu_as_sc_mcu7t3v3__tap_2
X_4573_ VDD VDD VSS VSS _4602_/A _4581_/B _4573_/B _4573_/C gf180mcu_as_sc_mcu7t3v3__ao21_2
XFILLER_200_1189 VDD VDD VSS VSS gf180mcu_as_sc_mcu7t3v3__fillcap_16
X_6312_ VDD VDD VSS VSS _6313_/CLK _6312_/D _6312_/Q gf180mcu_as_sc_mcu7t3v3__dfxtp_2
X_3524_ VDD VDD VSS VSS _5335_/A _5319_/D _5911_/A gf180mcu_as_sc_mcu7t3v3__nand2b_2
XTAP_TAPCELL_ROW_151_1458 VDD VSS gf180mcu_as_sc_mcu7t3v3__tap_2
X_6243_ VDD VDD VSS VSS _6316_/CLK _6243_/D _6243_/Q gf180mcu_as_sc_mcu7t3v3__dfxtp_2
X_3455_ VDD VDD VSS VSS _4585_/A _3455_/B _6320_/Q _6319_/D gf180mcu_as_sc_mcu7t3v3__mux2_2
X_6174_ VDD VDD VSS VSS _6376_/CLK _6174_/D _6174_/Q gf180mcu_as_sc_mcu7t3v3__dfxtp_2
X_3386_ VDD VDD VSS VSS _4511_/A _3392_/B _3437_/B _3392_/C _3438_/B gf180mcu_as_sc_mcu7t3v3__ao211_2
XPHY_EDGE_ROW_67_2_Right_904 VDD VSS gf180mcu_as_sc_mcu7t3v3__tap_2
X_5125_ VDD VDD VSS VSS _5786_/D _5143_/B _5125_/C _5125_/D _5126_/C gf180mcu_as_sc_mcu7t3v3__ao211_2
XTAP_TAPCELL_ROW_149_1398 VDD VSS gf180mcu_as_sc_mcu7t3v3__tap_2
XTAP_TAPCELL_ROW_14_1270 VDD VSS gf180mcu_as_sc_mcu7t3v3__tap_2
Xload_slew694 VDD VDD VSS VSS _4638_/Y _4842_/C gf180mcu_as_sc_mcu7t3v3__clkbuff_12
X_5056_ VDD VDD VSS VSS _5222_/B _5056_/B _5056_/C _5224_/B _5059_/B gf180mcu_as_sc_mcu7t3v3__ao211_2
XFILLER_55_29 VDD VDD VSS VSS gf180mcu_as_sc_mcu7t3v3__fillcap_8
X_4007_ VDD VDD VSS VSS _4051_/B _4008_/B _4008_/C _6095_/Q _6095_/D gf180mcu_as_sc_mcu7t3v3__ao22_2
XFILLER_168_1151 VDD VDD VSS VSS gf180mcu_as_sc_mcu7t3v3__fillcap_4
XFILLER_198_604 VDD VDD VSS VSS gf180mcu_as_sc_mcu7t3v3__fillcap_4
XFILLER_226_774 VDD VDD VSS VSS gf180mcu_as_sc_mcu7t3v3__fillcap_4
XFILLER_168_1173 VDD VDD VSS VSS gf180mcu_as_sc_mcu7t3v3__fillcap_16
XFILLER_198_637 VDD VDD VSS VSS gf180mcu_as_sc_mcu7t3v3__fillcap_16
XFILLER_214_936 VDD VDD VSS VSS gf180mcu_as_sc_mcu7t3v3__fillcap_8
XFILLER_214_947 VDD VDD VSS VSS gf180mcu_as_sc_mcu7t3v3__fillcap_16
XTAP_TAPCELL_ROW_10_1189 VDD VSS gf180mcu_as_sc_mcu7t3v3__tap_2
XFILLER_209_1170 VDD VDD VSS VSS gf180mcu_as_sc_mcu7t3v3__fillcap_16
X_5958_ VDD VDD VSS VSS _5959_/B _5972_/C _5963_/A _5958_/A gf180mcu_as_sc_mcu7t3v3__aoi21_2
XFILLER_200_107 VDD VDD VSS VSS gf180mcu_as_sc_mcu7t3v3__fillcap_4
XFILLER_209_1192 VDD VDD VSS VSS gf180mcu_as_sc_mcu7t3v3__fillcap_16
XFILLER_90_1245 VDD VDD VSS VSS gf180mcu_as_sc_mcu7t3v3__fillcap_16
X_4909_ VDD VDD VSS VSS _5900_/A _4955_/B _4955_/C _5899_/A _4910_/D gf180mcu_as_sc_mcu7t3v3__ao22_2
XFILLER_166_523 VDD VDD VSS VSS gf180mcu_as_sc_mcu7t3v3__fill_2
XFILLER_194_821 VDD VDD VSS VSS gf180mcu_as_sc_mcu7t3v3__fillcap_8
X_5889_ VDD VDD VSS VSS _5889_/A _5952_/B _5951_/B _5889_/D _5890_/D gf180mcu_as_sc_mcu7t3v3__ao22_2
XTAP_TAPCELL_ROW_216_2624 VDD VSS gf180mcu_as_sc_mcu7t3v3__tap_2
XTAP_TAPCELL_ROW_216_2635 VDD VSS gf180mcu_as_sc_mcu7t3v3__tap_2
XFILLER_153_206 VDD VDD VSS VSS gf180mcu_as_sc_mcu7t3v3__fillcap_4
XFILLER_153_228 VDD VDD VSS VSS gf180mcu_as_sc_mcu7t3v3__fillcap_16
XFILLER_107_656 VDD VDD VSS VSS gf180mcu_as_sc_mcu7t3v3__fillcap_4
XFILLER_175_1100 VDD VDD VSS VSS gf180mcu_as_sc_mcu7t3v3__fillcap_16
XFILLER_175_1122 VDD VDD VSS VSS gf180mcu_as_sc_mcu7t3v3__fillcap_16
XFILLER_4_238 VDD VDD VSS VSS gf180mcu_as_sc_mcu7t3v3__fillcap_4
XFILLER_0_444 VDD VDD VSS VSS gf180mcu_as_sc_mcu7t3v3__fillcap_4
XFILLER_150_979 VDD VDD VSS VSS gf180mcu_as_sc_mcu7t3v3__fillcap_16
XFILLER_1_978 VDD VDD VSS VSS gf180mcu_as_sc_mcu7t3v3__fill_2
Xinput301 VDD VDD VSS VSS sw_in[8] _5746_/A gf180mcu_as_sc_mcu7t3v3__buff_12
Xinput312 VDD VDD VSS VSS west_in[18] _5824_/A gf180mcu_as_sc_mcu7t3v3__buff_12
Xinput323 VDD VDD VSS VSS west_in[28] _5903_/A gf180mcu_as_sc_mcu7t3v3__buff_12
Xinput334 VDD VDD VSS VSS west_in[5] _5718_/A gf180mcu_as_sc_mcu7t3v3__buff_12
XFILLER_152_53 VDD VDD VSS VSS gf180mcu_as_sc_mcu7t3v3__fillcap_16
XFILLER_212_1049 VDD VDD VSS VSS gf180mcu_as_sc_mcu7t3v3__fillcap_16
XTAP_TAPCELL_ROW_70_3_2954 VDD VSS gf180mcu_as_sc_mcu7t3v3__tap_2
XFILLER_1_1116 VDD VDD VSS VSS gf180mcu_as_sc_mcu7t3v3__fillcap_4
XFILLER_217_752 VDD VDD VSS VSS gf180mcu_as_sc_mcu7t3v3__fillcap_4
XFILLER_1_1138 VDD VDD VSS VSS gf180mcu_as_sc_mcu7t3v3__fillcap_16
XPHY_EDGE_ROW_59_2_Left_500 VDD VSS gf180mcu_as_sc_mcu7t3v3__tap_2
XFILLER_204_435 VDD VDD VSS VSS gf180mcu_as_sc_mcu7t3v3__fill_2
XFILLER_44_665 VDD VDD VSS VSS gf180mcu_as_sc_mcu7t3v3__fill_2
XPHY_EDGE_ROW_111_2_Left_552 VDD VSS gf180mcu_as_sc_mcu7t3v3__tap_2
XPHY_EDGE_ROW_134_3_Left_839 VDD VSS gf180mcu_as_sc_mcu7t3v3__tap_2
XFILLER_147_1257 VDD VDD VSS VSS gf180mcu_as_sc_mcu7t3v3__fillcap_4
XFILLER_204_457 VDD VDD VSS VSS gf180mcu_as_sc_mcu7t3v3__fillcap_16
XFILLER_220_939 VDD VDD VSS VSS gf180mcu_as_sc_mcu7t3v3__fillcap_4
XFILLER_157_512 VDD VDD VSS VSS gf180mcu_as_sc_mcu7t3v3__fillcap_16
XFILLER_169_383 VDD VDD VSS VSS gf180mcu_as_sc_mcu7t3v3__fillcap_4
XFILLER_8_522 VDD VDD VSS VSS gf180mcu_as_sc_mcu7t3v3__fill_2
XFILLER_200_663 VDD VDD VSS VSS gf180mcu_as_sc_mcu7t3v3__fill_2
XFILLER_157_578 VDD VDD VSS VSS gf180mcu_as_sc_mcu7t3v3__fill_1
XFILLER_177_72 VDD VDD VSS VSS gf180mcu_as_sc_mcu7t3v3__fillcap_8
XFILLER_184_364 VDD VDD VSS VSS gf180mcu_as_sc_mcu7t3v3__fillcap_4
XANTENNA_5 VDD VDD VSS VSS _6384_/D gf180mcu_as_sc_mcu7t3v3__diode_2
XFILLER_153_784 VDD VDD VSS VSS gf180mcu_as_sc_mcu7t3v3__fillcap_8
XFILLER_113_626 VDD VDD VSS VSS gf180mcu_as_sc_mcu7t3v3__fill_1
XFILLER_180_581 VDD VDD VSS VSS gf180mcu_as_sc_mcu7t3v3__fill_2
XFILLER_113_659 VDD VDD VSS VSS gf180mcu_as_sc_mcu7t3v3__fill_2
XFILLER_3_282 VDD VDD VSS VSS gf180mcu_as_sc_mcu7t3v3__fillcap_16
X_3240_ VDD VDD VSS VSS _3241_/A _3326_/S _3240_/B _3240_/C gf180mcu_as_sc_mcu7t3v3__ao21_2
X_3171_ VDD VDD VSS VSS _4468_/A _6310_/Q _4104_/B gf180mcu_as_sc_mcu7t3v3__and2_2
XFILLER_6_1049 VDD VDD VSS VSS gf180mcu_as_sc_mcu7t3v3__fillcap_16
XFILLER_130_1261 VDD VDD VSS VSS gf180mcu_as_sc_mcu7t3v3__fillcap_4
XFILLER_228_1001 VDD VDD VSS VSS gf180mcu_as_sc_mcu7t3v3__fillcap_4
XPHY_EDGE_ROW_43_2_Left_484 VDD VSS gf180mcu_as_sc_mcu7t3v3__tap_2
XFILLER_228_1056 VDD VDD VSS VSS gf180mcu_as_sc_mcu7t3v3__fillcap_4
X_5812_ VDD VDD VSS VSS _6465_/D _5812_/C _5844_/B _5812_/A gf180mcu_as_sc_mcu7t3v3__aoi21b_2
XFILLER_167_309 VDD VDD VSS VSS gf180mcu_as_sc_mcu7t3v3__fillcap_4
X_5743_ VDD VDD VSS VSS _5743_/A _5800_/B _5743_/C _5743_/D _5744_/D gf180mcu_as_sc_mcu7t3v3__ao211_2
XTAP_TAPCELL_ROW_192_2204 VDD VSS gf180mcu_as_sc_mcu7t3v3__tap_2
XFILLER_222_298 VDD VDD VSS VSS gf180mcu_as_sc_mcu7t3v3__fillcap_4
XPHY_EDGE_ROW_178_Left_406 VDD VSS gf180mcu_as_sc_mcu7t3v3__tap_2
X_5674_ VDD VDD VSS VSS _5674_/Y _5879_/D _5674_/A gf180mcu_as_sc_mcu7t3v3__nor2_2
XFILLER_163_504 VDD VDD VSS VSS gf180mcu_as_sc_mcu7t3v3__fill_1
XFILLER_191_835 VDD VDD VSS VSS gf180mcu_as_sc_mcu7t3v3__fillcap_4
XTAP_TAPCELL_ROW_170_1801 VDD VSS gf180mcu_as_sc_mcu7t3v3__tap_2
X_4625_ VDD VDD VSS VSS _4639_/A _4625_/C _4968_/C _4968_/B gf180mcu_as_sc_mcu7t3v3__aoi21_2
XFILLER_11_1224 VDD VDD VSS VSS gf180mcu_as_sc_mcu7t3v3__fillcap_16
XFILLER_163_559 VDD VDD VSS VSS gf180mcu_as_sc_mcu7t3v3__fill_1
XFILLER_175_397 VDD VDD VSS VSS gf180mcu_as_sc_mcu7t3v3__fillcap_16
X_4556_ VDD VDD VSS VSS _4556_/B _6264_/Q _4579_/B gf180mcu_as_sc_mcu7t3v3__xnor2_2
XFILLER_150_209 VDD VDD VSS VSS gf180mcu_as_sc_mcu7t3v3__fillcap_16
XFILLER_2_709 VDD VDD VSS VSS gf180mcu_as_sc_mcu7t3v3__fillcap_8
X_3507_ VDD VDD VSS VSS _3508_/D _5938_/B _4264_/A gf180mcu_as_sc_mcu7t3v3__nand2b_2
XTAP_TAPCELL_ROW_211_2543 VDD VSS gf180mcu_as_sc_mcu7t3v3__tap_2
XTAP_TAPCELL_ROW_211_2532 VDD VSS gf180mcu_as_sc_mcu7t3v3__tap_2
X_4487_ VDD VDD VSS VSS _6150_/Q _4512_/S _4499_/C _6281_/Q _4488_/C gf180mcu_as_sc_mcu7t3v3__ao22_2
XPHY_EDGE_ROW_107_1_Left_335 VDD VSS gf180mcu_as_sc_mcu7t3v3__tap_2
XTAP_TAPCELL_ROW_16_1310 VDD VSS gf180mcu_as_sc_mcu7t3v3__tap_2
XTAP_TAPCELL_ROW_16_1321 VDD VSS gf180mcu_as_sc_mcu7t3v3__tap_2
Xclkbuf_leaf_9_clk_regs VDD VDD VSS VSS clkload0/A _6316_/CLK gf180mcu_as_sc_mcu7t3v3__clkbuff_12
X_6226_ VDD VDD VSS VSS _6517_/CLK _6226_/D _6226_/Q gf180mcu_as_sc_mcu7t3v3__dfxtp_2
X_3438_ VDD VDD VSS VSS _3438_/A _3438_/B _3438_/C _4103_/A _3438_/D gf180mcu_as_sc_mcu7t3v3__aoi31_2
XPHY_EDGE_ROW_187_Left_415 VDD VSS gf180mcu_as_sc_mcu7t3v3__tap_2
XTAP_TAPCELL_ROW_168_1763 VDD VSS gf180mcu_as_sc_mcu7t3v3__tap_2
Xhold1200 VDD VDD VSS VSS hold1225/Y _6533_/D gf180mcu_as_sc_mcu7t3v3__clkbuff_4
X_6157_ VDD VDD VSS VSS clkload8/A _6157_/D _6157_/Q gf180mcu_as_sc_mcu7t3v3__dfxtp_2
X_3369_ VDD VDD VSS VSS _6527_/Q _3369_/B _3369_/A _3369_/Y gf180mcu_as_sc_mcu7t3v3__mux2_2
XFILLER_218_527 VDD VDD VSS VSS gf180mcu_as_sc_mcu7t3v3__fillcap_4
XTAP_TAPCELL_ROW_12_1229 VDD VSS gf180mcu_as_sc_mcu7t3v3__tap_2
XTAP_TAPCELL_ROW_168_1774 VDD VSS gf180mcu_as_sc_mcu7t3v3__tap_2
Xhold1211 VDD VDD VSS VSS _6338_/Q _4587_/A gf180mcu_as_sc_mcu7t3v3__clkbuff_4
Xhold1222 VDD VDD VSS VSS _6538_/Q hold1222/Y gf180mcu_as_sc_mcu7t3v3__clkbuff_4
Xhold1233 VDD VDD VSS VSS _6549_/Q hold1233/Y gf180mcu_as_sc_mcu7t3v3__clkbuff_4
X_5108_ VDD VDD VSS VSS _5109_/A _5769_/A _5218_/B _5108_/C gf180mcu_as_sc_mcu7t3v3__ao21_2
XPHY_EDGE_ROW_68_2_Right_905 VDD VSS gf180mcu_as_sc_mcu7t3v3__tap_2
X_6088_ VDD VDD VSS VSS _6125_/CLK _6088_/D _6088_/Q gf180mcu_as_sc_mcu7t3v3__dfxtp_2
XFILLER_122_45 VDD VDD VSS VSS gf180mcu_as_sc_mcu7t3v3__fillcap_4
XFILLER_26_621 VDD VDD VSS VSS gf180mcu_as_sc_mcu7t3v3__fillcap_4
X_5039_ VDD VDD VSS VSS _5040_/D _5086_/B _5132_/B _5707_/B gf180mcu_as_sc_mcu7t3v3__aoi21b_2
XFILLER_167_6 VDD VDD VSS VSS gf180mcu_as_sc_mcu7t3v3__fillcap_16
XTAP_TAPCELL_ROW_181_1996 VDD VSS gf180mcu_as_sc_mcu7t3v3__tap_2
XFILLER_198_27 VDD VDD VSS VSS gf180mcu_as_sc_mcu7t3v3__fillcap_8
XFILLER_82_49 VDD VDD VSS VSS gf180mcu_as_sc_mcu7t3v3__fill_2
XFILLER_41_657 VDD VDD VSS VSS gf180mcu_as_sc_mcu7t3v3__fillcap_4
XFILLER_181_1170 VDD VDD VSS VSS gf180mcu_as_sc_mcu7t3v3__fillcap_16
XFILLER_185_139 VDD VDD VSS VSS gf180mcu_as_sc_mcu7t3v3__fill_1
XPHY_EDGE_ROW_196_Left_424 VDD VSS gf180mcu_as_sc_mcu7t3v3__tap_2
XFILLER_181_1192 VDD VDD VSS VSS gf180mcu_as_sc_mcu7t3v3__fillcap_16
XFILLER_182_802 VDD VDD VSS VSS gf180mcu_as_sc_mcu7t3v3__fill_2
XFILLER_194_651 VDD VDD VSS VSS gf180mcu_as_sc_mcu7t3v3__fill_2
XFILLER_208_2 VDD VDD VSS VSS gf180mcu_as_sc_mcu7t3v3__fillcap_16
XFILLER_5_558 VDD VDD VSS VSS gf180mcu_as_sc_mcu7t3v3__fill_2
XFILLER_150_732 VDD VDD VSS VSS gf180mcu_as_sc_mcu7t3v3__fill_2
XPHY_EDGE_ROW_39_1_Left_267 VDD VSS gf180mcu_as_sc_mcu7t3v3__tap_2
XFILLER_110_629 VDD VDD VSS VSS gf180mcu_as_sc_mcu7t3v3__fill_2
Xinput120 VDD VDD VSS VSS ne_in[8] _5739_/A gf180mcu_as_sc_mcu7t3v3__buff_12
XTAP_TAPCELL_ROW_88_3_2981 VDD VSS gf180mcu_as_sc_mcu7t3v3__tap_2
XFILLER_0_274 VDD VDD VSS VSS gf180mcu_as_sc_mcu7t3v3__fillcap_4
XFILLER_114_1245 VDD VDD VSS VSS gf180mcu_as_sc_mcu7t3v3__fillcap_16
XFILLER_209_516 VDD VDD VSS VSS gf180mcu_as_sc_mcu7t3v3__fill_1
Xinput131 VDD VDD VSS VSS north_in[18] _5822_/B gf180mcu_as_sc_mcu7t3v3__buff_12
Xinput142 VDD VDD VSS VSS north_in[28] _5904_/D gf180mcu_as_sc_mcu7t3v3__buff_12
Xinput153 VDD VDD VSS VSS north_in[5] wire1014/A gf180mcu_as_sc_mcu7t3v3__buff_12
Xinput164 VDD VDD VSS VSS nw_in[15] _5802_/D gf180mcu_as_sc_mcu7t3v3__buff_12
Xinput175 VDD VDD VSS VSS nw_in[25] _5881_/A gf180mcu_as_sc_mcu7t3v3__buff_12
Xinput186 VDD VDD VSS VSS nw_in[35] _4986_/A gf180mcu_as_sc_mcu7t3v3__buff_12
Xinput197 VDD VDD VSS VSS se_in[11] _5769_/A gf180mcu_as_sc_mcu7t3v3__buff_12
XFILLER_16_120 VDD VDD VSS VSS gf180mcu_as_sc_mcu7t3v3__fillcap_8
XFILLER_16_142 VDD VDD VSS VSS gf180mcu_as_sc_mcu7t3v3__fillcap_16
XFILLER_186_1081 VDD VDD VSS VSS gf180mcu_as_sc_mcu7t3v3__fillcap_4
XFILLER_160_1221 VDD VDD VSS VSS gf180mcu_as_sc_mcu7t3v3__fillcap_4
XFILLER_189_489 VDD VDD VSS VSS gf180mcu_as_sc_mcu7t3v3__fill_1
XFILLER_9_820 VDD VDD VSS VSS gf180mcu_as_sc_mcu7t3v3__fillcap_16
XPHY_EDGE_ROW_30_2_Right_867 VDD VSS gf180mcu_as_sc_mcu7t3v3__tap_2
XFILLER_157_342 VDD VDD VSS VSS gf180mcu_as_sc_mcu7t3v3__fill_1
XFILLER_158_865 VDD VDD VSS VSS gf180mcu_as_sc_mcu7t3v3__fillcap_8
XFILLER_160_1243 VDD VDD VSS VSS gf180mcu_as_sc_mcu7t3v3__fillcap_16
XFILLER_9_842 VDD VDD VSS VSS gf180mcu_as_sc_mcu7t3v3__fillcap_16
XFILLER_157_386 VDD VDD VSS VSS gf180mcu_as_sc_mcu7t3v3__fill_1
XFILLER_200_493 VDD VDD VSS VSS gf180mcu_as_sc_mcu7t3v3__fillcap_4
XFILLER_201_1262 VDD VDD VSS VSS gf180mcu_as_sc_mcu7t3v3__fill_2
XPHY_EDGE_ROW_200_Left_428 VDD VSS gf180mcu_as_sc_mcu7t3v3__tap_2
X_4410_ VDD VDD VSS VSS _4410_/Y _4602_/C _4411_/A gf180mcu_as_sc_mcu7t3v3__nor2_2
X_5390_ VDD VDD VSS VSS _5699_/B _5491_/C _5484_/B _5390_/D _5392_/C gf180mcu_as_sc_mcu7t3v3__ao211_2
XFILLER_153_592 VDD VDD VSS VSS gf180mcu_as_sc_mcu7t3v3__fillcap_16
XFILLER_193_1030 VDD VDD VSS VSS gf180mcu_as_sc_mcu7t3v3__fillcap_16
XFILLER_193_1052 VDD VDD VSS VSS gf180mcu_as_sc_mcu7t3v3__fillcap_16
X_4341_ VDD VDD VSS VSS _4342_/S _6117_/Q _4341_/C _4369_/D _4345_/C gf180mcu_as_sc_mcu7t3v3__ao211_2
XFILLER_207_67 VDD VDD VSS VSS gf180mcu_as_sc_mcu7t3v3__fill_2
X_4272_ VDD VDD VSS VSS _4272_/A _4280_/B _4272_/C _4280_/D _4275_/B gf180mcu_as_sc_mcu7t3v3__ao211_2
X_6011_ VDD VDD VSS VSS _6011_/B _6202_/Q _6524_/D gf180mcu_as_sc_mcu7t3v3__and2_2
X_3223_ VDD VDD VSS VSS _3223_/B _6336_/Q _3224_/B gf180mcu_as_sc_mcu7t3v3__xnor2_2
XTAP_TAPCELL_ROW_185_2063 VDD VSS gf180mcu_as_sc_mcu7t3v3__tap_2
XTAP_TAPCELL_ROW_185_2074 VDD VSS gf180mcu_as_sc_mcu7t3v3__tap_2
XFILLER_223_44 VDD VDD VSS VSS gf180mcu_as_sc_mcu7t3v3__fill_1
XFILLER_228_847 VDD VDD VSS VSS gf180mcu_as_sc_mcu7t3v3__fill_2
X_3154_ VDD VDD VSS VSS _4224_/B _3154_/A _3161_/A _3154_/C _4215_/A gf180mcu_as_sc_mcu7t3v3__ao31_2
XFILLER_67_598 VDD VDD VSS VSS gf180mcu_as_sc_mcu7t3v3__fill_2
X_3085_ VDD VDD VSS VSS _5214_/A _5862_/B gf180mcu_as_sc_mcu7t3v3__inv_2
XTAP_TAPCELL_ROW_163_1671 VDD VSS gf180mcu_as_sc_mcu7t3v3__tap_2
XTAP_TAPCELL_ROW_163_1682 VDD VSS gf180mcu_as_sc_mcu7t3v3__tap_2
XFILLER_23_602 VDD VDD VSS VSS gf180mcu_as_sc_mcu7t3v3__fillcap_4
XFILLER_165_1154 VDD VDD VSS VSS gf180mcu_as_sc_mcu7t3v3__fillcap_16
XFILLER_196_916 VDD VDD VSS VSS gf180mcu_as_sc_mcu7t3v3__fillcap_16
XFILLER_206_1151 VDD VDD VSS VSS gf180mcu_as_sc_mcu7t3v3__fillcap_4
XFILLER_211_769 VDD VDD VSS VSS gf180mcu_as_sc_mcu7t3v3__fill_1
X_3987_ VDD VDD VSS VSS _4022_/D _4002_/B _4002_/C _6076_/Q _6076_/D gf180mcu_as_sc_mcu7t3v3__ao22_2
XFILLER_206_1173 VDD VDD VSS VSS gf180mcu_as_sc_mcu7t3v3__fillcap_16
XFILLER_210_257 VDD VDD VSS VSS gf180mcu_as_sc_mcu7t3v3__fillcap_4
XPHY_EDGE_ROW_156_Right_24 VDD VSS gf180mcu_as_sc_mcu7t3v3__tap_2
X_5726_ VDD VDD VSS VSS _5726_/A _5864_/B _5726_/C _5726_/D _5727_/C gf180mcu_as_sc_mcu7t3v3__ao211_2
XFILLER_184_18 VDD VDD VSS VSS gf180mcu_as_sc_mcu7t3v3__fillcap_16
XFILLER_191_632 VDD VDD VSS VSS gf180mcu_as_sc_mcu7t3v3__fill_1
X_5657_ VDD VDD VSS VSS _5667_/A _5670_/B _5670_/A gf180mcu_as_sc_mcu7t3v3__nand2b_2
XFILLER_190_142 VDD VDD VSS VSS gf180mcu_as_sc_mcu7t3v3__fill_1
X_5588_ VDD VDD VSS VSS _5590_/C _5898_/A _5616_/B _5588_/C gf180mcu_as_sc_mcu7t3v3__ao21_2
X_4608_ VDD VDD VSS VSS _4609_/B _4610_/C _4608_/B _4610_/A gf180mcu_as_sc_mcu7t3v3__aoi21_2
XFILLER_151_529 VDD VDD VSS VSS gf180mcu_as_sc_mcu7t3v3__fill_1
XFILLER_172_1103 VDD VDD VSS VSS gf180mcu_as_sc_mcu7t3v3__fillcap_16
X_4539_ VDD VDD VSS VSS _4607_/B _4539_/C _4539_/B _4539_/A gf180mcu_as_sc_mcu7t3v3__aoi21_2
XFILLER_213_1100 VDD VDD VSS VSS gf180mcu_as_sc_mcu7t3v3__fillcap_16
XPHY_EDGE_ROW_130_3_Right_210 VDD VSS gf180mcu_as_sc_mcu7t3v3__tap_2
XPHY_EDGE_ROW_165_Right_33 VDD VSS gf180mcu_as_sc_mcu7t3v3__tap_2
Xfanout821 VDD VDD VSS VSS _5295_/B _5312_/B gf180mcu_as_sc_mcu7t3v3__buff_12
Xfanout832 VDD VDD VSS VSS _4974_/Y _5202_/B gf180mcu_as_sc_mcu7t3v3__buff_12
Xfanout843 VDD VDD VSS VSS _4582_/A _4538_/S gf180mcu_as_sc_mcu7t3v3__buff_12
X_6209_ VDD VDD VSS VSS _6517_/CLK _6209_/D _6209_/Q gf180mcu_as_sc_mcu7t3v3__dfxtp_2
XFILLER_213_1122 VDD VDD VSS VSS gf180mcu_as_sc_mcu7t3v3__fillcap_16
XFILLER_219_836 VDD VDD VSS VSS gf180mcu_as_sc_mcu7t3v3__fillcap_4
Xfanout854 VDD VDD VSS VSS _4857_/B _4876_/B gf180mcu_as_sc_mcu7t3v3__buff_12
Xfanout865 VDD VDD VSS VSS _4617_/Y _4746_/B gf180mcu_as_sc_mcu7t3v3__buff_12
XTAP_TAPCELL_ROW_228_2870 VDD VSS gf180mcu_as_sc_mcu7t3v3__tap_2
Xfanout887 VDD VDD VSS VSS _3179_/Y _4603_/A gf180mcu_as_sc_mcu7t3v3__buff_12
Xfanout898 VDD VDD VSS VSS _6521_/Q _5930_/A gf180mcu_as_sc_mcu7t3v3__buff_12
XPHY_EDGE_ROW_69_2_Right_906 VDD VSS gf180mcu_as_sc_mcu7t3v3__tap_2
XTAP_TAPCELL_ROW_224_2778 VDD VSS gf180mcu_as_sc_mcu7t3v3__tap_2
XTAP_TAPCELL_ROW_224_2767 VDD VSS gf180mcu_as_sc_mcu7t3v3__tap_2
XFILLER_199_710 VDD VDD VSS VSS gf180mcu_as_sc_mcu7t3v3__fill_1
XFILLER_183_1232 VDD VDD VSS VSS gf180mcu_as_sc_mcu7t3v3__fill_2
XFILLER_201_224 VDD VDD VSS VSS gf180mcu_as_sc_mcu7t3v3__fill_1
XFILLER_202_769 VDD VDD VSS VSS gf180mcu_as_sc_mcu7t3v3__fillcap_4
XPHY_EDGE_ROW_174_Right_42 VDD VSS gf180mcu_as_sc_mcu7t3v3__tap_2
XFILLER_158_139 VDD VDD VSS VSS gf180mcu_as_sc_mcu7t3v3__fillcap_16
XFILLER_195_960 VDD VDD VSS VSS gf180mcu_as_sc_mcu7t3v3__fillcap_16
XFILLER_158_30 VDD VDD VSS VSS gf180mcu_as_sc_mcu7t3v3__fillcap_4
XFILLER_195_982 VDD VDD VSS VSS gf180mcu_as_sc_mcu7t3v3__fillcap_16
XFILLER_201_279 VDD VDD VSS VSS gf180mcu_as_sc_mcu7t3v3__fill_1
XFILLER_158_85 VDD VDD VSS VSS gf180mcu_as_sc_mcu7t3v3__fillcap_16
XFILLER_155_879 VDD VDD VSS VSS gf180mcu_as_sc_mcu7t3v3__fill_1
XFILLER_181_142 VDD VDD VSS VSS gf180mcu_as_sc_mcu7t3v3__fill_2
XFILLER_218_1011 VDD VDD VSS VSS gf180mcu_as_sc_mcu7t3v3__fillcap_4
XFILLER_218_1033 VDD VDD VSS VSS gf180mcu_as_sc_mcu7t3v3__fillcap_16
XPHY_EDGE_ROW_183_Right_51 VDD VSS gf180mcu_as_sc_mcu7t3v3__tap_2
XFILLER_7_1100 VDD VDD VSS VSS gf180mcu_as_sc_mcu7t3v3__fillcap_16
XFILLER_7_1122 VDD VDD VSS VSS gf180mcu_as_sc_mcu7t3v3__fillcap_16
XTAP_TAPCELL_ROW_8_1150 VDD VSS gf180mcu_as_sc_mcu7t3v3__tap_2
XTAP_TAPCELL_ROW_8_1161 VDD VSS gf180mcu_as_sc_mcu7t3v3__tap_2
XFILLER_184_1007 VDD VDD VSS VSS gf180mcu_as_sc_mcu7t3v3__fillcap_8
XFILLER_40_1261 VDD VDD VSS VSS gf180mcu_as_sc_mcu7t3v3__fillcap_4
XFILLER_189_220 VDD VDD VSS VSS gf180mcu_as_sc_mcu7t3v3__fillcap_4
XPHY_EDGE_ROW_192_Right_60 VDD VSS gf180mcu_as_sc_mcu7t3v3__tap_2
X_4890_ VDD VDD VSS VSS _6518_/Q _4953_/B _4962_/C _5881_/D _4891_/C gf180mcu_as_sc_mcu7t3v3__ao22_2
X_3910_ VDD VDD VSS VSS _5891_/A _3910_/B _3910_/C _3911_/B _3912_/C gf180mcu_as_sc_mcu7t3v3__ao211_2
XFILLER_177_415 VDD VDD VSS VSS gf180mcu_as_sc_mcu7t3v3__fillcap_4
XFILLER_178_949 VDD VDD VSS VSS gf180mcu_as_sc_mcu7t3v3__fill_1
X_3841_ VDD VDD VSS VSS _6512_/Q _3925_/B _3927_/B _5830_/B _3843_/C gf180mcu_as_sc_mcu7t3v3__ao22_2
XPHY_EDGE_ROW_31_2_Right_868 VDD VSS gf180mcu_as_sc_mcu7t3v3__tap_2
X_3772_ VDD VDD VSS VSS _3772_/B _3772_/A _4034_/B gf180mcu_as_sc_mcu7t3v3__and2_2
XFILLER_158_662 VDD VDD VSS VSS gf180mcu_as_sc_mcu7t3v3__fill_2
X_5511_ VDD VDD VSS VSS _5819_/A _5568_/B _5568_/C _5818_/A _5512_/D gf180mcu_as_sc_mcu7t3v3__ao22_2
XFILLER_173_643 VDD VDD VSS VSS gf180mcu_as_sc_mcu7t3v3__fill_1
XFILLER_185_470 VDD VDD VSS VSS gf180mcu_as_sc_mcu7t3v3__fillcap_16
XFILLER_185_492 VDD VDD VSS VSS gf180mcu_as_sc_mcu7t3v3__fill_2
XFILLER_8_171 VDD VDD VSS VSS gf180mcu_as_sc_mcu7t3v3__fillcap_4
X_6491_ VDD VDD VSS VSS _6492_/CLK _6491_/D _6491_/Q gf180mcu_as_sc_mcu7t3v3__dfxtp_2
XFILLER_8_193 VDD VDD VSS VSS gf180mcu_as_sc_mcu7t3v3__fillcap_16
Xoutput402 VDD VDD VSS VSS _6368_/Q north_out[27] gf180mcu_as_sc_mcu7t3v3__buff_12
X_5442_ VDD VDD VSS VSS _5443_/A _5749_/B _5491_/C _5442_/C gf180mcu_as_sc_mcu7t3v3__ao21_2
Xoutput435 VDD VDD VSS VSS _6401_/Q south_out[24] gf180mcu_as_sc_mcu7t3v3__buff_12
Xoutput424 VDD VDD VSS VSS _6391_/Q south_out[14] gf180mcu_as_sc_mcu7t3v3__buff_12
Xoutput413 VDD VDD VSS VSS _6345_/Q north_out[4] gf180mcu_as_sc_mcu7t3v3__buff_12
X_5373_ VDD VDD VSS VSS _5373_/B _5506_/A _6413_/D gf180mcu_as_sc_mcu7t3v3__and2_2
XTAP_TAPCELL_ROW_187_2114 VDD VSS gf180mcu_as_sc_mcu7t3v3__tap_2
XTAP_TAPCELL_ROW_187_2103 VDD VSS gf180mcu_as_sc_mcu7t3v3__tap_2
Xoutput468 VDD VDD VSS VSS _6470_/Q west_out[21] gf180mcu_as_sc_mcu7t3v3__buff_12
Xoutput457 VDD VDD VSS VSS _6460_/Q west_out[11] gf180mcu_as_sc_mcu7t3v3__buff_12
Xoutput446 VDD VDD VSS VSS _6411_/Q south_out[34] gf180mcu_as_sc_mcu7t3v3__buff_12
X_4324_ VDD VDD VSS VSS _4366_/A _4324_/B _4324_/C _4325_/B _4373_/D gf180mcu_as_sc_mcu7t3v3__oai211_2
Xoutput479 VDD VDD VSS VSS _6480_/Q west_out[31] gf180mcu_as_sc_mcu7t3v3__buff_12
X_4255_ VDD VDD VSS VSS _4255_/B _5977_/B _4256_/C gf180mcu_as_sc_mcu7t3v3__and2_2
XTAP_TAPCELL_ROW_165_1711 VDD VSS gf180mcu_as_sc_mcu7t3v3__tap_2
X_4186_ VDD VDD VSS VSS _4231_/S _4186_/B _6195_/Q _6195_/D gf180mcu_as_sc_mcu7t3v3__mux2_2
X_3206_ VDD VDD VSS VSS _6164_/Q _6137_/Q _3209_/C gf180mcu_as_sc_mcu7t3v3__xnor2_2
X_3137_ VDD VDD VSS VSS _4524_/B _6259_/Q _4509_/B gf180mcu_as_sc_mcu7t3v3__nand2_2
XTAP_TAPCELL_ROW_206_2453 VDD VSS gf180mcu_as_sc_mcu7t3v3__tap_2
XTAP_TAPCELL_ROW_206_2442 VDD VSS gf180mcu_as_sc_mcu7t3v3__tap_2
XFILLER_227_198 VDD VDD VSS VSS gf180mcu_as_sc_mcu7t3v3__fill_1
XFILLER_63_29 VDD VDD VSS VSS gf180mcu_as_sc_mcu7t3v3__fillcap_16
X_3068_ VDD VDD VSS VSS _5421_/B _5728_/A gf180mcu_as_sc_mcu7t3v3__inv_2
XFILLER_208_1235 VDD VDD VSS VSS gf180mcu_as_sc_mcu7t3v3__fillcap_4
XFILLER_224_861 VDD VDD VSS VSS gf180mcu_as_sc_mcu7t3v3__fill_2
XFILLER_168_404 VDD VDD VSS VSS gf180mcu_as_sc_mcu7t3v3__fillcap_8
XTAP_TAPCELL_ROW_198_2298 VDD VSS gf180mcu_as_sc_mcu7t3v3__tap_2
XFILLER_10_104 VDD VDD VSS VSS gf180mcu_as_sc_mcu7t3v3__fill_1
XFILLER_11_627 VDD VDD VSS VSS gf180mcu_as_sc_mcu7t3v3__fill_2
XFILLER_13_1116 VDD VDD VSS VSS gf180mcu_as_sc_mcu7t3v3__fillcap_4
XFILLER_143_1260 VDD VDD VSS VSS gf180mcu_as_sc_mcu7t3v3__fill_1
XFILLER_177_982 VDD VDD VSS VSS gf180mcu_as_sc_mcu7t3v3__fillcap_4
XFILLER_211_599 VDD VDD VSS VSS gf180mcu_as_sc_mcu7t3v3__fill_1
Xwire507 VDD VDD VSS VSS _3356_/Y wire507/Y gf180mcu_as_sc_mcu7t3v3__clkbuff_12
XFILLER_13_1138 VDD VDD VSS VSS gf180mcu_as_sc_mcu7t3v3__fillcap_16
X_5709_ VDD VDD VSS VSS _5709_/A _5800_/B _5709_/C _5709_/D _5711_/C gf180mcu_as_sc_mcu7t3v3__ao211_2
XFILLER_163_120 VDD VDD VSS VSS gf180mcu_as_sc_mcu7t3v3__fillcap_16
XFILLER_163_142 VDD VDD VSS VSS gf180mcu_as_sc_mcu7t3v3__fillcap_16
XFILLER_3_837 VDD VDD VSS VSS gf180mcu_as_sc_mcu7t3v3__fill_2
XFILLER_88_37 VDD VDD VSS VSS gf180mcu_as_sc_mcu7t3v3__fillcap_8
XFILLER_2_325 VDD VDD VSS VSS gf180mcu_as_sc_mcu7t3v3__fillcap_4
XPHY_EDGE_ROW_143_3_Left_848 VDD VSS gf180mcu_as_sc_mcu7t3v3__tap_2
XFILLER_160_860 VDD VDD VSS VSS gf180mcu_as_sc_mcu7t3v3__fill_1
XPHY_EDGE_ROW_120_2_Left_561 VDD VSS gf180mcu_as_sc_mcu7t3v3__tap_2
Xfanout640 VDD VDD VSS VSS _3902_/S _3881_/B gf180mcu_as_sc_mcu7t3v3__buff_12
Xfanout651 VDD VDD VSS VSS _5979_/Y _6005_/B gf180mcu_as_sc_mcu7t3v3__buff_12
XTAP_TAPCELL_ROW_226_2818 VDD VSS gf180mcu_as_sc_mcu7t3v3__tap_2
XTAP_TAPCELL_ROW_226_2807 VDD VSS gf180mcu_as_sc_mcu7t3v3__tap_2
XFILLER_219_622 VDD VDD VSS VSS gf180mcu_as_sc_mcu7t3v3__fillcap_8
XFILLER_24_1245 VDD VDD VSS VSS gf180mcu_as_sc_mcu7t3v3__fillcap_16
XPHY_EDGE_ROW_131_3_Right_211 VDD VSS gf180mcu_as_sc_mcu7t3v3__tap_2
Xfanout662 VDD VDD VSS VSS _5671_/Y _5842_/C gf180mcu_as_sc_mcu7t3v3__buff_12
Xfanout673 VDD VDD VSS VSS _5367_/Y _5639_/B gf180mcu_as_sc_mcu7t3v3__buff_12
Xfanout684 VDD VDD VSS VSS _5207_/C _5314_/S gf180mcu_as_sc_mcu7t3v3__buff_12
XFILLER_111_1226 VDD VDD VSS VSS gf180mcu_as_sc_mcu7t3v3__fill_2
Xfanout695 VDD VDD VSS VSS _4406_/C _4399_/C gf180mcu_as_sc_mcu7t3v3__buff_12
XFILLER_160_53 VDD VDD VSS VSS gf180mcu_as_sc_mcu7t3v3__fillcap_16
XFILLER_15_944 VDD VDD VSS VSS gf180mcu_as_sc_mcu7t3v3__fillcap_16
XFILLER_159_426 VDD VDD VSS VSS gf180mcu_as_sc_mcu7t3v3__fill_1
XFILLER_183_1084 VDD VDD VSS VSS gf180mcu_as_sc_mcu7t3v3__fillcap_16
XFILLER_187_713 VDD VDD VSS VSS gf180mcu_as_sc_mcu7t3v3__fillcap_4
XFILLER_202_511 VDD VDD VSS VSS gf180mcu_as_sc_mcu7t3v3__fillcap_4
XFILLER_14_498 VDD VDD VSS VSS gf180mcu_as_sc_mcu7t3v3__fill_1
XFILLER_159_459 VDD VDD VSS VSS gf180mcu_as_sc_mcu7t3v3__fillcap_16
XFILLER_70_1210 VDD VDD VSS VSS gf180mcu_as_sc_mcu7t3v3__fill_2
XFILLER_186_278 VDD VDD VSS VSS gf180mcu_as_sc_mcu7t3v3__fill_2
XFILLER_224_1081 VDD VDD VSS VSS gf180mcu_as_sc_mcu7t3v3__fillcap_4
XFILLER_155_632 VDD VDD VSS VSS gf180mcu_as_sc_mcu7t3v3__fillcap_8
XFILLER_10_693 VDD VDD VSS VSS gf180mcu_as_sc_mcu7t3v3__fill_2
XTAP_TAPCELL_ROW_76_3_2963 VDD VSS gf180mcu_as_sc_mcu7t3v3__tap_2
XFILLER_155_698 VDD VDD VSS VSS gf180mcu_as_sc_mcu7t3v3__fill_2
XFILLER_185_72 VDD VDD VSS VSS gf180mcu_as_sc_mcu7t3v3__fillcap_8
XFILLER_6_686 VDD VDD VSS VSS gf180mcu_as_sc_mcu7t3v3__fill_1
XFILLER_5_174 VDD VDD VSS VSS gf180mcu_as_sc_mcu7t3v3__fillcap_16
XPHY_EDGE_ROW_52_2_Left_493 VDD VSS gf180mcu_as_sc_mcu7t3v3__tap_2
XFILLER_151_860 VDD VDD VSS VSS gf180mcu_as_sc_mcu7t3v3__fill_1
XFILLER_190_1033 VDD VDD VSS VSS gf180mcu_as_sc_mcu7t3v3__fillcap_16
XFILLER_155_1186 VDD VDD VSS VSS gf180mcu_as_sc_mcu7t3v3__fillcap_4
XTAP_TAPCELL_ROW_182_2011 VDD VSS gf180mcu_as_sc_mcu7t3v3__tap_2
XFILLER_77_660 VDD VDD VSS VSS gf180mcu_as_sc_mcu7t3v3__fill_2
X_4040_ VDD VDD VSS VSS _4044_/B _6119_/Q _4041_/D gf180mcu_as_sc_mcu7t3v3__and2_2
XTAP_TAPCELL_ROW_182_2022 VDD VSS gf180mcu_as_sc_mcu7t3v3__tap_2
Xmesh_tile_1061 VDD VDD VSS VSS ne_out[20] gf180mcu_as_sc_mcu7t3v3__tiel_4
Xmesh_tile_1050 VDD VDD VSS VSS ne_out[9] gf180mcu_as_sc_mcu7t3v3__tiel_4
XFILLER_209_198 VDD VDD VSS VSS gf180mcu_as_sc_mcu7t3v3__fill_1
XTAP_TAPCELL_ROW_160_1630 VDD VSS gf180mcu_as_sc_mcu7t3v3__tap_2
Xmesh_tile_1094 VDD VDD VSS VSS nw_out[17] gf180mcu_as_sc_mcu7t3v3__tiel_4
Xmesh_tile_1083 VDD VDD VSS VSS nw_out[6] gf180mcu_as_sc_mcu7t3v3__tiel_4
Xmesh_tile_1072 VDD VDD VSS VSS ne_out[31] gf180mcu_as_sc_mcu7t3v3__tiel_4
X_5991_ VDD VDD VSS VSS _6010_/B _6214_/Q _6504_/D gf180mcu_as_sc_mcu7t3v3__and2_2
XFILLER_220_34 VDD VDD VSS VSS gf180mcu_as_sc_mcu7t3v3__fill_1
Xclkbuf_leaf_23_clk_regs VDD VDD VSS VSS clkload2/A _6525_/CLK gf180mcu_as_sc_mcu7t3v3__clkbuff_12
X_4942_ VDD VDD VSS VSS _4965_/S _4942_/B _5934_/A _4943_/B gf180mcu_as_sc_mcu7t3v3__mux2_2
XFILLER_177_212 VDD VDD VSS VSS gf180mcu_as_sc_mcu7t3v3__fill_2
XTAP_TAPCELL_ROW_201_2361 VDD VSS gf180mcu_as_sc_mcu7t3v3__tap_2
XFILLER_162_1135 VDD VDD VSS VSS gf180mcu_as_sc_mcu7t3v3__fillcap_16
XFILLER_162_1157 VDD VDD VSS VSS gf180mcu_as_sc_mcu7t3v3__fillcap_16
X_4873_ VDD VDD VSS VSS _4883_/A _4873_/B _5867_/A _4874_/B gf180mcu_as_sc_mcu7t3v3__mux2_2
XFILLER_159_982 VDD VDD VSS VSS gf180mcu_as_sc_mcu7t3v3__fillcap_16
XPHY_EDGE_ROW_116_1_Left_344 VDD VSS gf180mcu_as_sc_mcu7t3v3__tap_2
X_3824_ VDD VDD VSS VSS _5814_/B _3886_/C _3824_/C _3824_/D _3826_/C gf180mcu_as_sc_mcu7t3v3__ao211_2
XFILLER_193_749 VDD VDD VSS VSS gf180mcu_as_sc_mcu7t3v3__fillcap_8
XFILLER_203_1154 VDD VDD VSS VSS gf180mcu_as_sc_mcu7t3v3__fillcap_16
XPHY_EDGE_ROW_151_Left_379 VDD VSS gf180mcu_as_sc_mcu7t3v3__tap_2
XPHY_EDGE_ROW_32_2_Right_869 VDD VSS gf180mcu_as_sc_mcu7t3v3__tap_2
XTAP_TAPCELL_ROW_158_1581 VDD VSS gf180mcu_as_sc_mcu7t3v3__tap_2
XTAP_TAPCELL_ROW_158_1592 VDD VSS gf180mcu_as_sc_mcu7t3v3__tap_2
X_6543_ VDD VDD VSS VSS _6546_/CLK _6543_/D _6543_/Q gf180mcu_as_sc_mcu7t3v3__dfxtp_2
X_3755_ VDD VDD VSS VSS _6503_/Q _3868_/B _3868_/C _5757_/B _3757_/C gf180mcu_as_sc_mcu7t3v3__ao22_2
X_6474_ VDD VDD VSS VSS _6474_/CLK _6474_/D _6474_/Q gf180mcu_as_sc_mcu7t3v3__dfxtp_2
X_3686_ VDD VDD VSS VSS _4022_/D _5695_/A _3810_/B _3686_/C gf180mcu_as_sc_mcu7t3v3__ao21_2
XFILLER_160_101 VDD VDD VSS VSS gf180mcu_as_sc_mcu7t3v3__fillcap_4
XFILLER_173_484 VDD VDD VSS VSS gf180mcu_as_sc_mcu7t3v3__fillcap_4
XPHY_EDGE_ROW_12_Right_12 VDD VSS gf180mcu_as_sc_mcu7t3v3__tap_2
X_5425_ VDD VDD VSS VSS _5426_/A _5732_/B _5549_/C _5425_/C gf180mcu_as_sc_mcu7t3v3__ao21_2
XFILLER_160_123 VDD VDD VSS VSS gf180mcu_as_sc_mcu7t3v3__fillcap_16
XFILLER_161_657 VDD VDD VSS VSS gf180mcu_as_sc_mcu7t3v3__fill_1
XFILLER_86_1261 VDD VDD VSS VSS gf180mcu_as_sc_mcu7t3v3__fillcap_4
X_5356_ VDD VDD VSS VSS _5358_/A _5369_/B _5356_/C _5644_/B gf180mcu_as_sc_mcu7t3v3__nor3_2
XFILLER_134_1226 VDD VDD VSS VSS gf180mcu_as_sc_mcu7t3v3__fillcap_16
XFILLER_173_1264 VDD VDD VSS VSS gf180mcu_as_sc_mcu7t3v3__fill_1
X_5287_ VDD VDD VSS VSS _5288_/C _5287_/C _5287_/B _5303_/S gf180mcu_as_sc_mcu7t3v3__aoi21_2
X_4307_ VDD VDD VSS VSS _4307_/S _6054_/Q _6083_/Q _4310_/B gf180mcu_as_sc_mcu7t3v3__mux2_2
XFILLER_75_619 VDD VDD VSS VSS gf180mcu_as_sc_mcu7t3v3__fillcap_4
XPHY_EDGE_ROW_160_Left_388 VDD VSS gf180mcu_as_sc_mcu7t3v3__tap_2
Xwire1018 VDD VDD VSS VSS wire1018/A _5682_/B gf180mcu_as_sc_mcu7t3v3__clkbuff_12
X_4238_ VDD VDD VSS VSS _4280_/B _4238_/B _5979_/A gf180mcu_as_sc_mcu7t3v3__nor2_2
XFILLER_210_1103 VDD VDD VSS VSS gf180mcu_as_sc_mcu7t3v3__fillcap_16
X_4169_ VDD VDD VSS VSS _4170_/D _6183_/Q _6184_/Q gf180mcu_as_sc_mcu7t3v3__nor2_2
XTAP_TAPCELL_ROW_221_2726 VDD VSS gf180mcu_as_sc_mcu7t3v3__tap_2
XTAP_TAPCELL_ROW_221_2715 VDD VSS gf180mcu_as_sc_mcu7t3v3__tap_2
XFILLER_215_135 VDD VDD VSS VSS gf180mcu_as_sc_mcu7t3v3__fillcap_4
XFILLER_130_45 VDD VDD VSS VSS gf180mcu_as_sc_mcu7t3v3__fillcap_4
XFILLER_167_1068 VDD VDD VSS VSS gf180mcu_as_sc_mcu7t3v3__fillcap_16
XFILLER_93_1210 VDD VDD VSS VSS gf180mcu_as_sc_mcu7t3v3__fill_2
XPHY_EDGE_ROW_18_1_Right_590 VDD VSS gf180mcu_as_sc_mcu7t3v3__tap_2
XFILLER_12_925 VDD VDD VSS VSS gf180mcu_as_sc_mcu7t3v3__fillcap_16
XFILLER_12_947 VDD VDD VSS VSS gf180mcu_as_sc_mcu7t3v3__fillcap_16
XFILLER_208_1065 VDD VDD VSS VSS gf180mcu_as_sc_mcu7t3v3__fillcap_16
XFILLER_208_1087 VDD VDD VSS VSS gf180mcu_as_sc_mcu7t3v3__fillcap_16
XFILLER_90_49 VDD VDD VSS VSS gf180mcu_as_sc_mcu7t3v3__fill_2
XPHY_EDGE_ROW_48_1_Left_276 VDD VSS gf180mcu_as_sc_mcu7t3v3__tap_2
XTAP_TAPCELL_ROW_178_1946 VDD VSS gf180mcu_as_sc_mcu7t3v3__tap_2
XFILLER_11_457 VDD VDD VSS VSS gf180mcu_as_sc_mcu7t3v3__fill_1
XFILLER_23_43 VDD VDD VSS VSS gf180mcu_as_sc_mcu7t3v3__fillcap_8
XTAP_TAPCELL_ROW_219_2677 VDD VSS gf180mcu_as_sc_mcu7t3v3__tap_2
XTAP_TAPCELL_ROW_219_2688 VDD VSS gf180mcu_as_sc_mcu7t3v3__tap_2
XFILLER_137_643 VDD VDD VSS VSS gf180mcu_as_sc_mcu7t3v3__fillcap_4
XTAP_TAPCELL_ROW_110_1_1376 VDD VSS gf180mcu_as_sc_mcu7t3v3__tap_2
XFILLER_152_613 VDD VDD VSS VSS gf180mcu_as_sc_mcu7t3v3__fillcap_4
XFILLER_164_473 VDD VDD VSS VSS gf180mcu_as_sc_mcu7t3v3__fillcap_16
XFILLER_152_635 VDD VDD VSS VSS gf180mcu_as_sc_mcu7t3v3__fill_2
XFILLER_152_657 VDD VDD VSS VSS gf180mcu_as_sc_mcu7t3v3__fillcap_8
XFILLER_174_1017 VDD VDD VSS VSS gf180mcu_as_sc_mcu7t3v3__fillcap_16
XFILLER_3_634 VDD VDD VSS VSS gf180mcu_as_sc_mcu7t3v3__fill_1
XFILLER_215_1014 VDD VDD VSS VSS gf180mcu_as_sc_mcu7t3v3__fillcap_16
XFILLER_2_177 VDD VDD VSS VSS gf180mcu_as_sc_mcu7t3v3__fillcap_16
XFILLER_66_619 VDD VDD VSS VSS gf180mcu_as_sc_mcu7t3v3__fillcap_8
XFILLER_4_1103 VDD VDD VSS VSS gf180mcu_as_sc_mcu7t3v3__fillcap_16
XPHY_EDGE_ROW_132_3_Right_212 VDD VSS gf180mcu_as_sc_mcu7t3v3__tap_2
XFILLER_0_36 VDD VDD VSS VSS gf180mcu_as_sc_mcu7t3v3__fillcap_4
XFILLER_219_496 VDD VDD VSS VSS gf180mcu_as_sc_mcu7t3v3__fill_2
XFILLER_74_663 VDD VDD VSS VSS gf180mcu_as_sc_mcu7t3v3__fillcap_4
XTAP_TAPCELL_ROW_1_1039 VDD VSS gf180mcu_as_sc_mcu7t3v3__tap_2
XTAP_TAPCELL_ROW_1_1028 VDD VSS gf180mcu_as_sc_mcu7t3v3__tap_2
XFILLER_159_212 VDD VDD VSS VSS gf180mcu_as_sc_mcu7t3v3__fillcap_16
XFILLER_221_149 VDD VDD VSS VSS gf180mcu_as_sc_mcu7t3v3__fill_1
XFILLER_14_295 VDD VDD VSS VSS gf180mcu_as_sc_mcu7t3v3__fillcap_16
XFILLER_174_204 VDD VDD VSS VSS gf180mcu_as_sc_mcu7t3v3__fillcap_16
XFILLER_128_610 VDD VDD VSS VSS gf180mcu_as_sc_mcu7t3v3__fillcap_16
XFILLER_128_665 VDD VDD VSS VSS gf180mcu_as_sc_mcu7t3v3__fill_2
XFILLER_155_440 VDD VDD VSS VSS gf180mcu_as_sc_mcu7t3v3__fill_1
XFILLER_156_963 VDD VDD VSS VSS gf180mcu_as_sc_mcu7t3v3__fillcap_16
X_3540_ VDD VDD VSS VSS _3540_/A _4947_/A _3540_/C _4973_/A _3540_/D gf180mcu_as_sc_mcu7t3v3__aoi211_2
XFILLER_143_602 VDD VDD VSS VSS gf180mcu_as_sc_mcu7t3v3__fillcap_4
XFILLER_155_484 VDD VDD VSS VSS gf180mcu_as_sc_mcu7t3v3__fillcap_4
X_5210_ VDD VDD VSS VSS _5210_/B _5291_/A _6399_/D gf180mcu_as_sc_mcu7t3v3__and2_2
X_3471_ VDD VDD VSS VSS _5350_/C _5933_/A _5340_/A gf180mcu_as_sc_mcu7t3v3__nor2b_2
X_6190_ VDD VDD VSS VSS _6486_/CLK _6190_/D _6190_/Q gf180mcu_as_sc_mcu7t3v3__dfxtp_2
XFILLER_9_1014 VDD VDD VSS VSS gf180mcu_as_sc_mcu7t3v3__fillcap_16
X_5141_ VDD VDD VSS VSS _5142_/D _5142_/B _5141_/B _5798_/B gf180mcu_as_sc_mcu7t3v3__aoi21b_2
XFILLER_215_67 VDD VDD VSS VSS gf180mcu_as_sc_mcu7t3v3__fill_2
XFILLER_57_619 VDD VDD VSS VSS gf180mcu_as_sc_mcu7t3v3__fillcap_4
X_5072_ VDD VDD VSS VSS _5072_/A _5275_/B _5072_/C _6384_/D _5843_/D gf180mcu_as_sc_mcu7t3v3__aoi211_2
X_4023_ VDD VDD VSS VSS _4055_/S _4023_/B _6106_/Q _6106_/D gf180mcu_as_sc_mcu7t3v3__mux2_2
XTAP_TAPCELL_ROW_203_2401 VDD VSS gf180mcu_as_sc_mcu7t3v3__tap_2
XFILLER_225_422 VDD VDD VSS VSS gf180mcu_as_sc_mcu7t3v3__fillcap_4
XFILLER_80_666 VDD VDD VSS VSS gf180mcu_as_sc_mcu7t3v3__fill_1
X_5974_ VDD VDD VSS VSS _5976_/A _5975_/B _5975_/C _5974_/C _6491_/Q gf180mcu_as_sc_mcu7t3v3__aoi22_2
XTAP_TAPCELL_ROW_19_2_2877 VDD VSS gf180mcu_as_sc_mcu7t3v3__tap_2
XFILLER_100_37 VDD VDD VSS VSS gf180mcu_as_sc_mcu7t3v3__fillcap_8
X_4925_ VDD VDD VSS VSS _5914_/A _4955_/B _4955_/C _5914_/D _4926_/D gf180mcu_as_sc_mcu7t3v3__ao22_2
XTAP_TAPCELL_ROW_195_2257 VDD VSS gf180mcu_as_sc_mcu7t3v3__tap_2
XTAP_TAPCELL_ROW_195_2246 VDD VSS gf180mcu_as_sc_mcu7t3v3__tap_2
X_4856_ VDD VDD VSS VSS _4856_/B _5857_/D _4862_/C gf180mcu_as_sc_mcu7t3v3__and2_2
XFILLER_119_610 VDD VDD VSS VSS gf180mcu_as_sc_mcu7t3v3__fill_2
X_3807_ VDD VDD VSS VSS _3807_/S _5801_/B _3807_/A _3808_/C gf180mcu_as_sc_mcu7t3v3__mux2_2
XFILLER_119_654 VDD VDD VSS VSS gf180mcu_as_sc_mcu7t3v3__fill_1
XTAP_TAPCELL_ROW_173_1854 VDD VSS gf180mcu_as_sc_mcu7t3v3__tap_2
X_6526_ VDD VDD VSS VSS _6526_/CLK _6526_/D _6526_/Q gf180mcu_as_sc_mcu7t3v3__dfxtp_2
X_4787_ VDD VDD VSS VSS _5794_/A _4796_/B _4787_/C _4787_/D _4788_/B gf180mcu_as_sc_mcu7t3v3__ao211_2
XFILLER_10_1119 VDD VDD VSS VSS gf180mcu_as_sc_mcu7t3v3__fillcap_16
X_3738_ VDD VDD VSS VSS _5743_/A _3871_/B _3738_/C _3738_/D _3739_/C gf180mcu_as_sc_mcu7t3v3__ao211_2
X_6457_ VDD VDD VSS VSS _6474_/CLK _6457_/D _6457_/Q gf180mcu_as_sc_mcu7t3v3__dfxtp_2
X_3669_ VDD VDD VSS VSS _6494_/Q _3804_/B _3852_/B _5683_/A _3671_/C gf180mcu_as_sc_mcu7t3v3__ao22_2
XTAP_TAPCELL_ROW_214_2596 VDD VSS gf180mcu_as_sc_mcu7t3v3__tap_2
XTAP_TAPCELL_ROW_214_2585 VDD VSS gf180mcu_as_sc_mcu7t3v3__tap_2
X_6388_ VDD VDD VSS VSS clkload3/A _6388_/D _6388_/Q gf180mcu_as_sc_mcu7t3v3__dfxtp_2
X_5408_ VDD VDD VSS VSS _5484_/B _5715_/A _5408_/A _5410_/C gf180mcu_as_sc_mcu7t3v3__mux2_2
X_5339_ VDD VDD VSS VSS _5339_/A _5915_/A _5339_/C _5340_/D gf180mcu_as_sc_mcu7t3v3__nand3_2
XFILLER_85_49 VDD VDD VSS VSS gf180mcu_as_sc_mcu7t3v3__fill_2
XFILLER_141_22 VDD VDD VSS VSS gf180mcu_as_sc_mcu7t3v3__fillcap_16
XFILLER_16_516 VDD VDD VSS VSS gf180mcu_as_sc_mcu7t3v3__fillcap_8
XFILLER_217_956 VDD VDD VSS VSS gf180mcu_as_sc_mcu7t3v3__fillcap_16
XFILLER_203_116 VDD VDD VSS VSS gf180mcu_as_sc_mcu7t3v3__fillcap_4
XFILLER_71_666 VDD VDD VSS VSS gf180mcu_as_sc_mcu7t3v3__fill_1
XFILLER_180_1065 VDD VDD VSS VSS gf180mcu_as_sc_mcu7t3v3__fillcap_16
XFILLER_197_885 VDD VDD VSS VSS gf180mcu_as_sc_mcu7t3v3__fillcap_16
XPHY_EDGE_ROW_19_1_Right_591 VDD VSS gf180mcu_as_sc_mcu7t3v3__tap_2
XFILLER_180_1087 VDD VDD VSS VSS gf180mcu_as_sc_mcu7t3v3__fillcap_16
XFILLER_200_867 VDD VDD VSS VSS gf180mcu_as_sc_mcu7t3v3__fill_1
XFILLER_211_171 VDD VDD VSS VSS gf180mcu_as_sc_mcu7t3v3__fillcap_4
XFILLER_211_182 VDD VDD VSS VSS gf180mcu_as_sc_mcu7t3v3__fillcap_4
XFILLER_8_737 VDD VDD VSS VSS gf180mcu_as_sc_mcu7t3v3__fillcap_8
XFILLER_11_276 VDD VDD VSS VSS gf180mcu_as_sc_mcu7t3v3__fillcap_4
XFILLER_11_298 VDD VDD VSS VSS gf180mcu_as_sc_mcu7t3v3__fillcap_16
XFILLER_221_1084 VDD VDD VSS VSS gf180mcu_as_sc_mcu7t3v3__fillcap_16
XFILLER_4_943 VDD VDD VSS VSS gf180mcu_as_sc_mcu7t3v3__fill_2
XTAP_TAPCELL_ROW_44_1_1343 VDD VSS gf180mcu_as_sc_mcu7t3v3__tap_2
XFILLER_117_1210 VDD VDD VSS VSS gf180mcu_as_sc_mcu7t3v3__fillcap_16
XFILLER_3_486 VDD VDD VSS VSS gf180mcu_as_sc_mcu7t3v3__fillcap_4
XFILLER_59_50 VDD VDD VSS VSS gf180mcu_as_sc_mcu7t3v3__fill_1
XFILLER_182_73 VDD VDD VSS VSS gf180mcu_as_sc_mcu7t3v3__fillcap_8
XFILLER_152_1189 VDD VDD VSS VSS gf180mcu_as_sc_mcu7t3v3__fillcap_16
XFILLER_187_1208 VDD VDD VSS VSS gf180mcu_as_sc_mcu7t3v3__fillcap_16
XFILLER_47_641 VDD VDD VSS VSS gf180mcu_as_sc_mcu7t3v3__fill_2
XFILLER_207_422 VDD VDD VSS VSS gf180mcu_as_sc_mcu7t3v3__fill_2
XPHY_EDGE_ROW_133_3_Right_213 VDD VSS gf180mcu_as_sc_mcu7t3v3__tap_2
XFILLER_222_403 VDD VDD VSS VSS gf180mcu_as_sc_mcu7t3v3__fillcap_4
XFILLER_15_571 VDD VDD VSS VSS gf180mcu_as_sc_mcu7t3v3__fillcap_16
XFILLER_201_69 VDD VDD VSS VSS gf180mcu_as_sc_mcu7t3v3__fill_1
XTAP_TAPCELL_ROW_64_3_2945 VDD VSS gf180mcu_as_sc_mcu7t3v3__tap_2
XFILLER_188_874 VDD VDD VSS VSS gf180mcu_as_sc_mcu7t3v3__fill_1
X_5690_ VDD VDD VSS VSS _5798_/S _5690_/B _6495_/Q _5691_/C gf180mcu_as_sc_mcu7t3v3__mux2_2
X_4710_ VDD VDD VSS VSS _4711_/C _4877_/B _5728_/D gf180mcu_as_sc_mcu7t3v3__nor2_2
X_4641_ VDD VDD VSS VSS _4646_/C _4876_/B _5676_/D gf180mcu_as_sc_mcu7t3v3__nand2_2
XTAP_TAPCELL_ROW_155_1540 VDD VSS gf180mcu_as_sc_mcu7t3v3__tap_2
XTAP_TAPCELL_ROW_190_2165 VDD VSS gf180mcu_as_sc_mcu7t3v3__tap_2
XTAP_TAPCELL_ROW_190_2154 VDD VSS gf180mcu_as_sc_mcu7t3v3__tap_2
XFILLER_116_602 VDD VDD VSS VSS gf180mcu_as_sc_mcu7t3v3__fill_2
XFILLER_190_505 VDD VDD VSS VSS gf180mcu_as_sc_mcu7t3v3__fill_1
XFILLER_200_1135 VDD VDD VSS VSS gf180mcu_as_sc_mcu7t3v3__fillcap_16
X_4572_ VDD VDD VSS VSS _4572_/D _4572_/A _4572_/B _4572_/C _4573_/C gf180mcu_as_sc_mcu7t3v3__ao31_2
XFILLER_171_741 VDD VDD VSS VSS gf180mcu_as_sc_mcu7t3v3__fillcap_16
XFILLER_200_1157 VDD VDD VSS VSS gf180mcu_as_sc_mcu7t3v3__fillcap_16
X_6311_ VDD VDD VSS VSS _6313_/CLK _6311_/D _6311_/Q gf180mcu_as_sc_mcu7t3v3__dfxtp_2
X_3523_ VDD VDD VSS VSS _3637_/A _5944_/A _4627_/D _3523_/D _4976_/A gf180mcu_as_sc_mcu7t3v3__ao211_2
XTAP_TAPCELL_ROW_151_1459 VDD VSS gf180mcu_as_sc_mcu7t3v3__tap_2
X_6242_ VDD VDD VSS VSS _6316_/CLK _6242_/D _6242_/Q gf180mcu_as_sc_mcu7t3v3__dfxtp_2
X_3454_ VDD VDD VSS VSS _4585_/A _3454_/B _6319_/Q _6318_/D gf180mcu_as_sc_mcu7t3v3__mux2_2
X_6173_ VDD VDD VSS VSS _6376_/CLK _6173_/D _6173_/Q gf180mcu_as_sc_mcu7t3v3__dfxtp_2
X_3385_ VDD VDD VSS VSS _4230_/A _3392_/C _3392_/B _4511_/A gf180mcu_as_sc_mcu7t3v3__aoi21_2
X_5124_ VDD VDD VSS VSS _6506_/Q _5124_/B _5188_/C _5785_/A _5125_/D gf180mcu_as_sc_mcu7t3v3__ao22_2
XTAP_TAPCELL_ROW_149_1399 VDD VSS gf180mcu_as_sc_mcu7t3v3__tap_2
XTAP_TAPCELL_ROW_14_1260 VDD VSS gf180mcu_as_sc_mcu7t3v3__tap_2
X_5055_ VDD VDD VSS VSS _5221_/B _5728_/D _5056_/C gf180mcu_as_sc_mcu7t3v3__and2_2
XFILLER_211_1264 VDD VDD VSS VSS gf180mcu_as_sc_mcu7t3v3__fill_1
XTAP_TAPCELL_ROW_14_1271 VDD VSS gf180mcu_as_sc_mcu7t3v3__tap_2
X_4006_ VDD VDD VSS VSS _4049_/B _4008_/B _4008_/C _6094_/Q _6094_/D gf180mcu_as_sc_mcu7t3v3__ao22_2
XFILLER_53_666 VDD VDD VSS VSS gf180mcu_as_sc_mcu7t3v3__fill_1
XFILLER_164_1049 VDD VDD VSS VSS gf180mcu_as_sc_mcu7t3v3__fillcap_16
XFILLER_71_29 VDD VDD VSS VSS gf180mcu_as_sc_mcu7t3v3__fillcap_16
X_5957_ VDD VDD VSS VSS _6484_/D _5957_/C _5957_/B _5957_/A gf180mcu_as_sc_mcu7t3v3__aoi21b_2
X_4908_ VDD VDD VSS VSS _4908_/B _4908_/A _4910_/C gf180mcu_as_sc_mcu7t3v3__and2_2
XFILLER_166_535 VDD VDD VSS VSS gf180mcu_as_sc_mcu7t3v3__fill_1
XFILLER_205_1046 VDD VDD VSS VSS gf180mcu_as_sc_mcu7t3v3__fillcap_4
XFILLER_205_1068 VDD VDD VSS VSS gf180mcu_as_sc_mcu7t3v3__fillcap_16
X_5888_ VDD VDD VSS VSS _5922_/B _5888_/B _5888_/A _5890_/C gf180mcu_as_sc_mcu7t3v3__mux2_2
XTAP_TAPCELL_ROW_216_2625 VDD VSS gf180mcu_as_sc_mcu7t3v3__tap_2
XFILLER_193_343 VDD VDD VSS VSS gf180mcu_as_sc_mcu7t3v3__fillcap_4
X_4839_ VDD VDD VSS VSS _4840_/C _4839_/B _5839_/A gf180mcu_as_sc_mcu7t3v3__nor2_2
XTAP_TAPCELL_ROW_216_2636 VDD VSS gf180mcu_as_sc_mcu7t3v3__tap_2
X_6509_ VDD VDD VSS VSS _6509_/CLK _6509_/D _6509_/Q gf180mcu_as_sc_mcu7t3v3__dfxtp_2
Xclkbuf_3_7_0_clk_regs VDD VDD VSS VSS clkbuf_0_clk_regs/Y clkload2/A gf180mcu_as_sc_mcu7t3v3__clkbuff_12
XFILLER_150_947 VDD VDD VSS VSS gf180mcu_as_sc_mcu7t3v3__fillcap_16
XFILLER_96_37 VDD VDD VSS VSS gf180mcu_as_sc_mcu7t3v3__fillcap_8
Xinput302 VDD VDD VSS VSS sw_in[9] _5754_/A gf180mcu_as_sc_mcu7t3v3__buff_12
XFILLER_0_478 VDD VDD VSS VSS gf180mcu_as_sc_mcu7t3v3__fillcap_4
XFILLER_212_1017 VDD VDD VSS VSS gf180mcu_as_sc_mcu7t3v3__fillcap_16
Xinput313 VDD VDD VSS VSS west_in[19] _5832_/A gf180mcu_as_sc_mcu7t3v3__buff_12
Xinput324 VDD VDD VSS VSS west_in[29] wire981/A gf180mcu_as_sc_mcu7t3v3__buff_12
Xinput335 VDD VDD VSS VSS west_in[6] _5726_/A gf180mcu_as_sc_mcu7t3v3__buff_12
XFILLER_5_1264 VDD VDD VSS VSS gf180mcu_as_sc_mcu7t3v3__fill_1
XFILLER_205_904 VDD VDD VSS VSS gf180mcu_as_sc_mcu7t3v3__fillcap_4
XPHY_EDGE_ROW_84_3_Left_789 VDD VSS gf180mcu_as_sc_mcu7t3v3__tap_2
XTAP_TAPCELL_ROW_0_990 VDD VSS gf180mcu_as_sc_mcu7t3v3__tap_2
XFILLER_169_340 VDD VDD VSS VSS gf180mcu_as_sc_mcu7t3v3__fillcap_8
XFILLER_185_822 VDD VDD VSS VSS gf180mcu_as_sc_mcu7t3v3__fillcap_4
XFILLER_197_671 VDD VDD VSS VSS gf180mcu_as_sc_mcu7t3v3__fill_1
XFILLER_212_480 VDD VDD VSS VSS gf180mcu_as_sc_mcu7t3v3__fillcap_8
XFILLER_184_321 VDD VDD VSS VSS gf180mcu_as_sc_mcu7t3v3__fill_2
XFILLER_196_192 VDD VDD VSS VSS gf180mcu_as_sc_mcu7t3v3__fill_1
XFILLER_172_527 VDD VDD VSS VSS gf180mcu_as_sc_mcu7t3v3__fillcap_4
XANTENNA_6 VDD VDD VSS VSS _6419_/D gf180mcu_as_sc_mcu7t3v3__diode_2
XFILLER_193_1234 VDD VDD VSS VSS gf180mcu_as_sc_mcu7t3v3__fill_1
XFILLER_193_72 VDD VDD VSS VSS gf180mcu_as_sc_mcu7t3v3__fillcap_16
XFILLER_152_295 VDD VDD VSS VSS gf180mcu_as_sc_mcu7t3v3__fillcap_16
XFILLER_121_660 VDD VDD VSS VSS gf180mcu_as_sc_mcu7t3v3__fill_2
XFILLER_6_1017 VDD VDD VSS VSS gf180mcu_as_sc_mcu7t3v3__fillcap_16
X_3170_ VDD VDD VSS VSS _3176_/D _3175_/A gf180mcu_as_sc_mcu7t3v3__inv_2
XPHY_EDGE_ROW_125_1_Left_353 VDD VSS gf180mcu_as_sc_mcu7t3v3__tap_2
XFILLER_208_775 VDD VDD VSS VSS gf180mcu_as_sc_mcu7t3v3__fillcap_4
XPHY_EDGE_ROW_134_3_Right_214 VDD VSS gf180mcu_as_sc_mcu7t3v3__tap_2
XFILLER_35_666 VDD VDD VSS VSS gf180mcu_as_sc_mcu7t3v3__fill_1
X_5811_ VDD VDD VSS VSS _6012_/A _5875_/S _5811_/B _5811_/C _5812_/C gf180mcu_as_sc_mcu7t3v3__ao31_2
X_5742_ VDD VDD VSS VSS _5742_/A _5799_/B _5742_/C _5799_/D _5743_/D gf180mcu_as_sc_mcu7t3v3__ao22_2
XTAP_TAPCELL_ROW_192_2205 VDD VSS gf180mcu_as_sc_mcu7t3v3__tap_2
XFILLER_194_107 VDD VDD VSS VSS gf180mcu_as_sc_mcu7t3v3__fill_2
XFILLER_194_129 VDD VDD VSS VSS gf180mcu_as_sc_mcu7t3v3__fillcap_4
X_5673_ VDD VDD VSS VSS _5862_/S _5673_/B _6493_/Q _5675_/B gf180mcu_as_sc_mcu7t3v3__mux2_2
XFILLER_163_516 VDD VDD VSS VSS gf180mcu_as_sc_mcu7t3v3__fillcap_16
XPHY_EDGE_ROW_6_Right_6 VDD VSS gf180mcu_as_sc_mcu7t3v3__tap_2
XTAP_TAPCELL_ROW_170_1802 VDD VSS gf180mcu_as_sc_mcu7t3v3__tap_2
X_4624_ VDD VDD VSS VSS _4624_/A _4624_/B _4624_/C _4624_/D _4968_/C gf180mcu_as_sc_mcu7t3v3__ao211_2
XFILLER_191_869 VDD VDD VSS VSS gf180mcu_as_sc_mcu7t3v3__fillcap_4
XFILLER_198_1189 VDD VDD VSS VSS gf180mcu_as_sc_mcu7t3v3__fillcap_16
X_4555_ VDD VDD VSS VSS _4579_/C _4581_/B gf180mcu_as_sc_mcu7t3v3__inv_2
X_3506_ VDD VDD VSS VSS _4968_/B _4977_/A _5952_/A gf180mcu_as_sc_mcu7t3v3__nand2b_2
XTAP_TAPCELL_ROW_211_2544 VDD VSS gf180mcu_as_sc_mcu7t3v3__tap_2
XTAP_TAPCELL_ROW_211_2533 VDD VSS gf180mcu_as_sc_mcu7t3v3__tap_2
X_4486_ VDD VDD VSS VSS _6279_/D _6279_/Q _4503_/C _4486_/C gf180mcu_as_sc_mcu7t3v3__ao21_2
XTAP_TAPCELL_ROW_16_1300 VDD VSS gf180mcu_as_sc_mcu7t3v3__tap_2
XTAP_TAPCELL_ROW_16_1311 VDD VSS gf180mcu_as_sc_mcu7t3v3__tap_2
XTAP_TAPCELL_ROW_16_1322 VDD VSS gf180mcu_as_sc_mcu7t3v3__tap_2
X_6225_ VDD VDD VSS VSS _6518_/CLK _6225_/D _6225_/Q gf180mcu_as_sc_mcu7t3v3__dfxtp_2
X_3437_ VDD VDD VSS VSS _3437_/B _4610_/C _3439_/C gf180mcu_as_sc_mcu7t3v3__and2_2
XPHY_EDGE_ROW_57_1_Left_285 VDD VSS gf180mcu_as_sc_mcu7t3v3__tap_2
X_6156_ VDD VDD VSS VSS clkload9/A _6156_/D _6156_/Q gf180mcu_as_sc_mcu7t3v3__dfxtp_2
X_3368_ VDD VDD VSS VSS _6527_/Q _3368_/B _3368_/A _3368_/Y gf180mcu_as_sc_mcu7t3v3__mux2_2
XFILLER_66_29 VDD VDD VSS VSS gf180mcu_as_sc_mcu7t3v3__fillcap_4
XTAP_TAPCELL_ROW_168_1764 VDD VSS gf180mcu_as_sc_mcu7t3v3__tap_2
Xhold1201 VDD VDD VSS VSS hold1227/Y _6538_/D gf180mcu_as_sc_mcu7t3v3__clkbuff_4
Xhold1212 VDD VDD VSS VSS _6311_/Q _4577_/A gf180mcu_as_sc_mcu7t3v3__clkbuff_4
Xhold1223 VDD VDD VSS VSS _6535_/Q hold1223/Y gf180mcu_as_sc_mcu7t3v3__clkbuff_4
Xhold1234 VDD VDD VSS VSS _6543_/Q hold1234/Y gf180mcu_as_sc_mcu7t3v3__clkbuff_4
X_5107_ VDD VDD VSS VSS _5217_/S _5768_/A _5107_/A _5108_/C gf180mcu_as_sc_mcu7t3v3__mux2_2
X_6087_ VDD VDD VSS VSS _6371_/CLK _6087_/D _6087_/Q gf180mcu_as_sc_mcu7t3v3__dfxtp_2
X_3299_ VDD VDD VSS VSS _3299_/A _3299_/B _3299_/C _3299_/D _3299_/Y gf180mcu_as_sc_mcu7t3v3__ao22_2
XTAP_TAPCELL_ROW_209_2495 VDD VSS gf180mcu_as_sc_mcu7t3v3__tap_2
X_5038_ VDD VDD VSS VSS _5040_/C _5706_/A _5140_/B _5038_/C gf180mcu_as_sc_mcu7t3v3__ao21_2
XFILLER_214_734 VDD VDD VSS VSS gf180mcu_as_sc_mcu7t3v3__fill_1
XTAP_TAPCELL_ROW_181_1997 VDD VSS gf180mcu_as_sc_mcu7t3v3__tap_2
XFILLER_14_839 VDD VDD VSS VSS gf180mcu_as_sc_mcu7t3v3__fillcap_16
XFILLER_198_457 VDD VDD VSS VSS gf180mcu_as_sc_mcu7t3v3__fill_2
XFILLER_15_88 VDD VDD VSS VSS gf180mcu_as_sc_mcu7t3v3__fillcap_16
XFILLER_167_811 VDD VDD VSS VSS gf180mcu_as_sc_mcu7t3v3__fillcap_4
XFILLER_16_1114 VDD VDD VSS VSS gf180mcu_as_sc_mcu7t3v3__fill_2
XFILLER_178_170 VDD VDD VSS VSS gf180mcu_as_sc_mcu7t3v3__fillcap_4
XFILLER_16_1158 VDD VDD VSS VSS gf180mcu_as_sc_mcu7t3v3__fillcap_16
XFILLER_166_365 VDD VDD VSS VSS gf180mcu_as_sc_mcu7t3v3__fillcap_16
XFILLER_210_995 VDD VDD VSS VSS gf180mcu_as_sc_mcu7t3v3__fillcap_16
XFILLER_154_527 VDD VDD VSS VSS gf180mcu_as_sc_mcu7t3v3__fillcap_16
XFILLER_166_398 VDD VDD VSS VSS gf180mcu_as_sc_mcu7t3v3__fillcap_4
XPHY_EDGE_ROW_140_1_Right_712 VDD VSS gf180mcu_as_sc_mcu7t3v3__tap_2
XFILLER_190_891 VDD VDD VSS VSS gf180mcu_as_sc_mcu7t3v3__fill_2
XFILLER_218_1259 VDD VDD VSS VSS gf180mcu_as_sc_mcu7t3v3__fillcap_4
XFILLER_27_1210 VDD VDD VSS VSS gf180mcu_as_sc_mcu7t3v3__fillcap_4
XFILLER_103_660 VDD VDD VSS VSS gf180mcu_as_sc_mcu7t3v3__fill_2
XFILLER_110_619 VDD VDD VSS VSS gf180mcu_as_sc_mcu7t3v3__fillcap_8
XFILLER_150_799 VDD VDD VSS VSS gf180mcu_as_sc_mcu7t3v3__fillcap_4
XFILLER_153_1262 VDD VDD VSS VSS gf180mcu_as_sc_mcu7t3v3__fill_2
XFILLER_163_42 VDD VDD VSS VSS gf180mcu_as_sc_mcu7t3v3__fillcap_16
Xinput110 VDD VDD VSS VSS ne_in[31] _5932_/A gf180mcu_as_sc_mcu7t3v3__buff_12
XPHY_EDGE_ROW_123_2_Right_960 VDD VSS gf180mcu_as_sc_mcu7t3v3__tap_2
Xinput121 VDD VDD VSS VSS ne_in[9] _5752_/D gf180mcu_as_sc_mcu7t3v3__buff_12
Xinput132 VDD VDD VSS VSS north_in[19] _5830_/B gf180mcu_as_sc_mcu7t3v3__buff_12
Xinput143 VDD VDD VSS VSS north_in[29] _5912_/D gf180mcu_as_sc_mcu7t3v3__buff_12
Xinput154 VDD VDD VSS VSS north_in[6] _5724_/B gf180mcu_as_sc_mcu7t3v3__buff_12
Xinput165 VDD VDD VSS VSS nw_in[16] _5809_/A gf180mcu_as_sc_mcu7t3v3__buff_12
Xinput176 VDD VDD VSS VSS nw_in[26] _5891_/A gf180mcu_as_sc_mcu7t3v3__buff_12
Xinput187 VDD VDD VSS VSS nw_in[3] _5702_/A gf180mcu_as_sc_mcu7t3v3__buff_12
Xinput198 VDD VDD VSS VSS se_in[12] _5778_/A gf180mcu_as_sc_mcu7t3v3__buff_12
XFILLER_17_666 VDD VDD VSS VSS gf180mcu_as_sc_mcu7t3v3__fill_1
XFILLER_204_244 VDD VDD VSS VSS gf180mcu_as_sc_mcu7t3v3__fill_1
XFILLER_225_1208 VDD VDD VSS VSS gf180mcu_as_sc_mcu7t3v3__fillcap_16
XFILLER_158_822 VDD VDD VSS VSS gf180mcu_as_sc_mcu7t3v3__fillcap_16
XFILLER_176_107 VDD VDD VSS VSS gf180mcu_as_sc_mcu7t3v3__fillcap_16
XFILLER_188_61 VDD VDD VSS VSS gf180mcu_as_sc_mcu7t3v3__fill_2
XFILLER_158_877 VDD VDD VSS VSS gf180mcu_as_sc_mcu7t3v3__fill_2
XFILLER_200_461 VDD VDD VSS VSS gf180mcu_as_sc_mcu7t3v3__fill_2
XFILLER_157_398 VDD VDD VSS VSS gf180mcu_as_sc_mcu7t3v3__fillcap_8
XFILLER_158_1151 VDD VDD VSS VSS gf180mcu_as_sc_mcu7t3v3__fillcap_4
XFILLER_158_1173 VDD VDD VSS VSS gf180mcu_as_sc_mcu7t3v3__fillcap_16
X_4340_ VDD VDD VSS VSS _4341_/C _4342_/S _6030_/Q gf180mcu_as_sc_mcu7t3v3__nor2b_2
X_4271_ VDD VDD VSS VSS _4271_/B _5977_/B _4272_/C gf180mcu_as_sc_mcu7t3v3__and2_2
XFILLER_80_1212 VDD VDD VSS VSS gf180mcu_as_sc_mcu7t3v3__fill_1
X_6010_ VDD VDD VSS VSS _6010_/B _6201_/Q _6523_/D gf180mcu_as_sc_mcu7t3v3__and2_2
X_3222_ VDD VDD VSS VSS _6334_/Q _6335_/Q _3281_/D _3223_/B gf180mcu_as_sc_mcu7t3v3__nor3_2
XTAP_TAPCELL_ROW_185_2064 VDD VSS gf180mcu_as_sc_mcu7t3v3__tap_2
XFILLER_228_815 VDD VDD VSS VSS gf180mcu_as_sc_mcu7t3v3__fill_1
X_3153_ VDD VDD VSS VSS _4216_/B _4225_/B _4224_/B gf180mcu_as_sc_mcu7t3v3__nor2_2
XTAP_TAPCELL_ROW_185_2075 VDD VSS gf180mcu_as_sc_mcu7t3v3__tap_2
XFILLER_223_34 VDD VDD VSS VSS gf180mcu_as_sc_mcu7t3v3__fillcap_8
XTAP_TAPCELL_ROW_52_3_2927 VDD VSS gf180mcu_as_sc_mcu7t3v3__tap_2
X_3084_ VDD VDD VSS VSS _5205_/A _5854_/B gf180mcu_as_sc_mcu7t3v3__inv_2
XFILLER_165_1100 VDD VDD VSS VSS gf180mcu_as_sc_mcu7t3v3__fillcap_16
XPHY_EDGE_ROW_135_3_Right_215 VDD VSS gf180mcu_as_sc_mcu7t3v3__tap_2
XTAP_TAPCELL_ROW_163_1672 VDD VSS gf180mcu_as_sc_mcu7t3v3__tap_2
XTAP_TAPCELL_ROW_163_1683 VDD VSS gf180mcu_as_sc_mcu7t3v3__tap_2
XFILLER_165_1122 VDD VDD VSS VSS gf180mcu_as_sc_mcu7t3v3__fillcap_16
XFILLER_223_564 VDD VDD VSS VSS gf180mcu_as_sc_mcu7t3v3__fill_1
X_3986_ VDD VDD VSS VSS _6075_/D _3986_/C _4002_/B _4021_/A gf180mcu_as_sc_mcu7t3v3__ao21b_2
X_5725_ VDD VDD VSS VSS _5725_/A _5861_/B _5725_/C _5871_/D _5726_/D gf180mcu_as_sc_mcu7t3v3__ao22_2
XFILLER_149_877 VDD VDD VSS VSS gf180mcu_as_sc_mcu7t3v3__fillcap_4
XFILLER_164_825 VDD VDD VSS VSS gf180mcu_as_sc_mcu7t3v3__fill_1
XFILLER_202_1049 VDD VDD VSS VSS gf180mcu_as_sc_mcu7t3v3__fillcap_16
X_5656_ VDD VDD VSS VSS _5670_/B _5656_/B _5656_/A gf180mcu_as_sc_mcu7t3v3__nand2b_2
XFILLER_175_184 VDD VDD VSS VSS gf180mcu_as_sc_mcu7t3v3__fill_1
X_4607_ VDD VDD VSS VSS _4607_/A _4607_/B _4607_/C _4608_/B gf180mcu_as_sc_mcu7t3v3__nand3_2
X_5587_ VDD VDD VSS VSS _5921_/A _5638_/B _5615_/C _5897_/D _5588_/C gf180mcu_as_sc_mcu7t3v3__ao22_2
XFILLER_190_165 VDD VDD VSS VSS gf180mcu_as_sc_mcu7t3v3__fill_2
X_4538_ VDD VDD VSS VSS _4538_/S _4538_/B _6715_/A _6299_/D gf180mcu_as_sc_mcu7t3v3__mux2_2
Xfanout800 VDD VDD VSS VSS _4410_/Y _4422_/B gf180mcu_as_sc_mcu7t3v3__buff_12
X_4469_ VDD VDD VSS VSS _4470_/B _4471_/A _6275_/Q _4475_/B gf180mcu_as_sc_mcu7t3v3__ao21_2
Xfanout811 VDD VDD VSS VSS _3850_/B _3804_/B gf180mcu_as_sc_mcu7t3v3__buff_12
Xfanout822 VDD VDD VSS VSS _5205_/B _5295_/B gf180mcu_as_sc_mcu7t3v3__buff_12
Xfanout833 VDD VDD VSS VSS _5292_/B _4990_/B gf180mcu_as_sc_mcu7t3v3__buff_12
X_6208_ VDD VDD VSS VSS clkload8/A _6208_/D _6208_/Q gf180mcu_as_sc_mcu7t3v3__dfxtp_2
XFILLER_218_303 VDD VDD VSS VSS gf180mcu_as_sc_mcu7t3v3__fill_1
XFILLER_219_804 VDD VDD VSS VSS gf180mcu_as_sc_mcu7t3v3__fillcap_4
Xfanout844 VDD VDD VSS VSS _4448_/Y _4582_/A gf180mcu_as_sc_mcu7t3v3__buff_12
Xfanout855 VDD VDD VSS VSS _4857_/B _4945_/B gf180mcu_as_sc_mcu7t3v3__buff_12
XTAP_TAPCELL_ROW_228_2860 VDD VSS gf180mcu_as_sc_mcu7t3v3__tap_2
Xfanout888 VDD VDD VSS VSS _3179_/Y _4581_/A gf180mcu_as_sc_mcu7t3v3__buff_12
Xfanout899 VDD VDD VSS VSS _6520_/Q _5921_/A gf180mcu_as_sc_mcu7t3v3__buff_12
X_6139_ VDD VDD VSS VSS _6520_/CLK _6139_/D _6139_/Q gf180mcu_as_sc_mcu7t3v3__dfxtp_2
XTAP_TAPCELL_ROW_228_2871 VDD VSS gf180mcu_as_sc_mcu7t3v3__tap_2
XTAP_TAPCELL_ROW_224_2768 VDD VSS gf180mcu_as_sc_mcu7t3v3__tap_2
XTAP_TAPCELL_ROW_224_2779 VDD VSS gf180mcu_as_sc_mcu7t3v3__tap_2
XFILLER_199_722 VDD VDD VSS VSS gf180mcu_as_sc_mcu7t3v3__fillcap_16
XFILLER_226_391 VDD VDD VSS VSS gf180mcu_as_sc_mcu7t3v3__fill_2
XFILLER_158_107 VDD VDD VSS VSS gf180mcu_as_sc_mcu7t3v3__fillcap_16
XFILLER_202_737 VDD VDD VSS VSS gf180mcu_as_sc_mcu7t3v3__fillcap_4
XFILLER_224_1263 VDD VDD VSS VSS gf180mcu_as_sc_mcu7t3v3__fill_2
XFILLER_158_53 VDD VDD VSS VSS gf180mcu_as_sc_mcu7t3v3__fillcap_16
XFILLER_220_2 VDD VDD VSS VSS gf180mcu_as_sc_mcu7t3v3__fillcap_16
XFILLER_6_802 VDD VDD VSS VSS gf180mcu_as_sc_mcu7t3v3__fill_2
XFILLER_120_1261 VDD VDD VSS VSS gf180mcu_as_sc_mcu7t3v3__fillcap_4
XFILLER_154_357 VDD VDD VSS VSS gf180mcu_as_sc_mcu7t3v3__fill_2
XFILLER_155_869 VDD VDD VSS VSS gf180mcu_as_sc_mcu7t3v3__fillcap_8
XFILLER_177_1048 VDD VDD VSS VSS gf180mcu_as_sc_mcu7t3v3__fill_2
XFILLER_5_323 VDD VDD VSS VSS gf180mcu_as_sc_mcu7t3v3__fill_2
XFILLER_5_356 VDD VDD VSS VSS gf180mcu_as_sc_mcu7t3v3__fill_2
XFILLER_174_30 VDD VDD VSS VSS gf180mcu_as_sc_mcu7t3v3__fillcap_4
XPHY_EDGE_ROW_141_1_Right_713 VDD VSS gf180mcu_as_sc_mcu7t3v3__tap_2
XFILLER_174_85 VDD VDD VSS VSS gf180mcu_as_sc_mcu7t3v3__fillcap_16
XFILLER_1_562 VDD VDD VSS VSS gf180mcu_as_sc_mcu7t3v3__fill_2
XFILLER_3_69 VDD VDD VSS VSS gf180mcu_as_sc_mcu7t3v3__fill_1
XPHY_EDGE_ROW_124_2_Right_961 VDD VSS gf180mcu_as_sc_mcu7t3v3__tap_2
XTAP_TAPCELL_ROW_8_1151 VDD VSS gf180mcu_as_sc_mcu7t3v3__tap_2
XFILLER_190_73 VDD VDD VSS VSS gf180mcu_as_sc_mcu7t3v3__fill_2
XTAP_TAPCELL_ROW_8_1162 VDD VSS gf180mcu_as_sc_mcu7t3v3__tap_2
XFILLER_149_1106 VDD VDD VSS VSS gf180mcu_as_sc_mcu7t3v3__fillcap_16
XFILLER_224_317 VDD VDD VSS VSS gf180mcu_as_sc_mcu7t3v3__fill_2
X_3840_ VDD VDD VSS VSS _3931_/B _5834_/A _3847_/C gf180mcu_as_sc_mcu7t3v3__and2_2
XFILLER_193_909 VDD VDD VSS VSS gf180mcu_as_sc_mcu7t3v3__fill_1
X_3771_ VDD VDD VSS VSS _3772_/B _3893_/C _3865_/B _5770_/A gf180mcu_as_sc_mcu7t3v3__aoi21b_2
XFILLER_158_674 VDD VDD VSS VSS gf180mcu_as_sc_mcu7t3v3__fillcap_4
XPHY_EDGE_ROW_24_2_Left_465 VDD VSS gf180mcu_as_sc_mcu7t3v3__tap_2
X_5510_ VDD VDD VSS VSS _5817_/D _5567_/B _5510_/C _5510_/D _5512_/C gf180mcu_as_sc_mcu7t3v3__ao211_2
XFILLER_199_1262 VDD VDD VSS VSS gf180mcu_as_sc_mcu7t3v3__fill_2
X_6490_ VDD VDD VSS VSS _6490_/CLK _6490_/D _6490_/Q gf180mcu_as_sc_mcu7t3v3__dfxtp_2
XFILLER_218_34 VDD VDD VSS VSS gf180mcu_as_sc_mcu7t3v3__fill_1
X_5441_ VDD VDD VSS VSS _6502_/Q _5490_/B _5491_/B _5750_/A _5442_/C gf180mcu_as_sc_mcu7t3v3__ao22_2
XFILLER_173_699 VDD VDD VSS VSS gf180mcu_as_sc_mcu7t3v3__fill_1
Xoutput425 VDD VDD VSS VSS _6392_/Q south_out[15] gf180mcu_as_sc_mcu7t3v3__buff_12
Xoutput414 VDD VDD VSS VSS _6346_/Q north_out[5] gf180mcu_as_sc_mcu7t3v3__buff_12
Xoutput403 VDD VDD VSS VSS _6369_/Q north_out[28] gf180mcu_as_sc_mcu7t3v3__buff_12
X_5372_ VDD VDD VSS VSS _5568_/B _5679_/A _5372_/A _5373_/B gf180mcu_as_sc_mcu7t3v3__mux2_2
XTAP_TAPCELL_ROW_187_2115 VDD VSS gf180mcu_as_sc_mcu7t3v3__tap_2
XTAP_TAPCELL_ROW_187_2104 VDD VSS gf180mcu_as_sc_mcu7t3v3__tap_2
Xoutput469 VDD VDD VSS VSS _6471_/Q west_out[22] gf180mcu_as_sc_mcu7t3v3__buff_12
Xoutput458 VDD VDD VSS VSS _6461_/Q west_out[12] gf180mcu_as_sc_mcu7t3v3__buff_12
Xoutput447 VDD VDD VSS VSS _6412_/Q south_out[35] gf180mcu_as_sc_mcu7t3v3__buff_12
Xoutput436 VDD VDD VSS VSS _6402_/Q south_out[25] gf180mcu_as_sc_mcu7t3v3__buff_12
X_4323_ VDD VDD VSS VSS _4325_/A _4323_/C _4337_/B _6149_/Q gf180mcu_as_sc_mcu7t3v3__aoi21_2
XFILLER_87_639 VDD VDD VSS VSS gf180mcu_as_sc_mcu7t3v3__fillcap_4
X_4254_ VDD VDD VSS VSS _4362_/D _4254_/B _4254_/A _4255_/B gf180mcu_as_sc_mcu7t3v3__mux2_2
XFILLER_171_1170 VDD VDD VSS VSS gf180mcu_as_sc_mcu7t3v3__fillcap_16
XFILLER_171_1192 VDD VDD VSS VSS gf180mcu_as_sc_mcu7t3v3__fillcap_16
XTAP_TAPCELL_ROW_165_1712 VDD VSS gf180mcu_as_sc_mcu7t3v3__tap_2
X_4185_ VDD VDD VSS VSS _4185_/D _4283_/A _5977_/B _4185_/C _4186_/B gf180mcu_as_sc_mcu7t3v3__ao31_2
X_3205_ VDD VDD VSS VSS _3209_/B _3361_/B gf180mcu_as_sc_mcu7t3v3__inv_2
XFILLER_228_678 VDD VDD VSS VSS gf180mcu_as_sc_mcu7t3v3__fill_2
X_3136_ VDD VDD VSS VSS _3136_/D _4566_/A _3136_/B _3136_/C _3392_/B gf180mcu_as_sc_mcu7t3v3__ao31_2
XTAP_TAPCELL_ROW_206_2454 VDD VSS gf180mcu_as_sc_mcu7t3v3__tap_2
XTAP_TAPCELL_ROW_206_2443 VDD VSS gf180mcu_as_sc_mcu7t3v3__tap_2
XFILLER_215_317 VDD VDD VSS VSS gf180mcu_as_sc_mcu7t3v3__fill_1
XTAP_TAPCELL_ROW_100_2_2998 VDD VSS gf180mcu_as_sc_mcu7t3v3__tap_2
X_3067_ VDD VDD VSS VSS _5404_/A _5711_/A gf180mcu_as_sc_mcu7t3v3__inv_2
XPHY_EDGE_ROW_136_3_Right_216 VDD VSS gf180mcu_as_sc_mcu7t3v3__tap_2
XFILLER_168_427 VDD VDD VSS VSS gf180mcu_as_sc_mcu7t3v3__fill_1
XTAP_TAPCELL_ROW_198_2299 VDD VSS gf180mcu_as_sc_mcu7t3v3__tap_2
XFILLER_168_449 VDD VDD VSS VSS gf180mcu_as_sc_mcu7t3v3__fillcap_4
XFILLER_196_758 VDD VDD VSS VSS gf180mcu_as_sc_mcu7t3v3__fillcap_4
XFILLER_183_419 VDD VDD VSS VSS gf180mcu_as_sc_mcu7t3v3__fill_1
XFILLER_211_589 VDD VDD VSS VSS gf180mcu_as_sc_mcu7t3v3__fillcap_8
Xwire508 VDD VDD VSS VSS _3348_/Y wire508/Y gf180mcu_as_sc_mcu7t3v3__clkbuff_12
X_5708_ VDD VDD VSS VSS _5708_/A _5799_/B _5708_/C _5799_/D _5709_/D gf180mcu_as_sc_mcu7t3v3__ao22_2
X_3969_ VDD VDD VSS VSS _3974_/B _6066_/Q _3970_/D gf180mcu_as_sc_mcu7t3v3__and2_2
XFILLER_104_1245 VDD VDD VSS VSS gf180mcu_as_sc_mcu7t3v3__fillcap_16
XFILLER_128_34 VDD VDD VSS VSS gf180mcu_as_sc_mcu7t3v3__fill_1
XFILLER_128_45 VDD VDD VSS VSS gf180mcu_as_sc_mcu7t3v3__fillcap_4
XFILLER_12_78 VDD VDD VSS VSS gf180mcu_as_sc_mcu7t3v3__fillcap_16
X_5639_ VDD VDD VSS VSS _5952_/A _5639_/B _5639_/C _5639_/D _5641_/C gf180mcu_as_sc_mcu7t3v3__ao211_2
XFILLER_192_997 VDD VDD VSS VSS gf180mcu_as_sc_mcu7t3v3__fillcap_16
XFILLER_176_1081 VDD VDD VSS VSS gf180mcu_as_sc_mcu7t3v3__fillcap_4
XFILLER_88_49 VDD VDD VSS VSS gf180mcu_as_sc_mcu7t3v3__fill_2
XFILLER_144_22 VDD VDD VSS VSS gf180mcu_as_sc_mcu7t3v3__fillcap_8
XPHY_EDGE_ROW_93_3_Left_798 VDD VSS gf180mcu_as_sc_mcu7t3v3__tap_2
Xfanout630 VDD VDD VSS VSS _5188_/B _5207_/B gf180mcu_as_sc_mcu7t3v3__buff_12
XTAP_TAPCELL_ROW_226_2808 VDD VSS gf180mcu_as_sc_mcu7t3v3__tap_2
XFILLER_150_1221 VDD VDD VSS VSS gf180mcu_as_sc_mcu7t3v3__fillcap_4
Xfanout652 VDD VDD VSS VSS _5839_/B _5799_/B gf180mcu_as_sc_mcu7t3v3__buff_12
Xfanout663 VDD VDD VSS VSS _5837_/B _5801_/S gf180mcu_as_sc_mcu7t3v3__buff_12
Xfanout685 VDD VDD VSS VSS _5188_/C _5207_/C gf180mcu_as_sc_mcu7t3v3__buff_12
Xfanout696 VDD VDD VSS VSS _4336_/C _4406_/C gf180mcu_as_sc_mcu7t3v3__buff_12
XTAP_TAPCELL_ROW_22_3_2882 VDD VSS gf180mcu_as_sc_mcu7t3v3__tap_2
XFILLER_206_317 VDD VDD VSS VSS gf180mcu_as_sc_mcu7t3v3__fill_1
XFILLER_218_177 VDD VDD VSS VSS gf180mcu_as_sc_mcu7t3v3__fill_2
XFILLER_15_912 VDD VDD VSS VSS gf180mcu_as_sc_mcu7t3v3__fillcap_16
XFILLER_14_422 VDD VDD VSS VSS gf180mcu_as_sc_mcu7t3v3__fill_1
XTAP_TAPCELL_ROW_3_1070 VDD VSS gf180mcu_as_sc_mcu7t3v3__tap_2
XFILLER_159_416 VDD VDD VSS VSS gf180mcu_as_sc_mcu7t3v3__fillcap_4
XFILLER_183_1052 VDD VDD VSS VSS gf180mcu_as_sc_mcu7t3v3__fillcap_16
XFILLER_199_574 VDD VDD VSS VSS gf180mcu_as_sc_mcu7t3v3__fill_1
XFILLER_187_747 VDD VDD VSS VSS gf180mcu_as_sc_mcu7t3v3__fill_2
XFILLER_5_120 VDD VDD VSS VSS gf180mcu_as_sc_mcu7t3v3__fillcap_16
XPHY_EDGE_ROW_134_1_Left_362 VDD VSS gf180mcu_as_sc_mcu7t3v3__tap_2
XFILLER_170_603 VDD VDD VSS VSS gf180mcu_as_sc_mcu7t3v3__fill_1
XFILLER_182_463 VDD VDD VSS VSS gf180mcu_as_sc_mcu7t3v3__fill_1
XFILLER_185_84 VDD VDD VSS VSS gf180mcu_as_sc_mcu7t3v3__fill_2
XFILLER_5_142 VDD VDD VSS VSS gf180mcu_as_sc_mcu7t3v3__fillcap_16
XFILLER_151_850 VDD VDD VSS VSS gf180mcu_as_sc_mcu7t3v3__fill_1
XFILLER_151_872 VDD VDD VSS VSS gf180mcu_as_sc_mcu7t3v3__fillcap_4
XFILLER_155_1154 VDD VDD VSS VSS gf180mcu_as_sc_mcu7t3v3__fillcap_16
XPHY_EDGE_ROW_142_1_Right_714 VDD VSS gf180mcu_as_sc_mcu7t3v3__tap_2
XTAP_TAPCELL_ROW_182_2012 VDD VSS gf180mcu_as_sc_mcu7t3v3__tap_2
XTAP_TAPCELL_ROW_182_2023 VDD VSS gf180mcu_as_sc_mcu7t3v3__tap_2
XFILLER_204_69 VDD VDD VSS VSS gf180mcu_as_sc_mcu7t3v3__fillcap_16
XPHY_EDGE_ROW_125_2_Right_962 VDD VSS gf180mcu_as_sc_mcu7t3v3__tap_2
Xmesh_tile_1062 VDD VDD VSS VSS ne_out[21] gf180mcu_as_sc_mcu7t3v3__tiel_4
Xmesh_tile_1051 VDD VDD VSS VSS ne_out[10] gf180mcu_as_sc_mcu7t3v3__tiel_4
XTAP_TAPCELL_ROW_160_1620 VDD VSS gf180mcu_as_sc_mcu7t3v3__tap_2
Xmesh_tile_1095 VDD VDD VSS VSS nw_out[18] gf180mcu_as_sc_mcu7t3v3__tiel_4
Xmesh_tile_1084 VDD VDD VSS VSS nw_out[7] gf180mcu_as_sc_mcu7t3v3__tiel_4
Xmesh_tile_1073 VDD VDD VSS VSS ne_out[32] gf180mcu_as_sc_mcu7t3v3__tiel_4
X_5990_ VDD VDD VSS VSS _6006_/B _6213_/Q _6503_/D gf180mcu_as_sc_mcu7t3v3__and2_2
XFILLER_206_873 VDD VDD VSS VSS gf180mcu_as_sc_mcu7t3v3__fill_2
XFILLER_212_309 VDD VDD VSS VSS gf180mcu_as_sc_mcu7t3v3__fillcap_4
X_4941_ VDD VDD VSS VSS _5927_/A _4957_/B _4941_/C _4941_/D _4942_/B gf180mcu_as_sc_mcu7t3v3__ao211_2
XFILLER_162_1103 VDD VDD VSS VSS gf180mcu_as_sc_mcu7t3v3__fillcap_16
X_4872_ VDD VDD VSS VSS _5866_/A _4872_/B _4872_/C _4872_/D _4873_/B gf180mcu_as_sc_mcu7t3v3__ao211_2
XTAP_TAPCELL_ROW_201_2362 VDD VSS gf180mcu_as_sc_mcu7t3v3__tap_2
XTAP_TAPCELL_ROW_201_2351 VDD VSS gf180mcu_as_sc_mcu7t3v3__tap_2
X_3823_ VDD VDD VSS VSS _3888_/B _5813_/A _3824_/D gf180mcu_as_sc_mcu7t3v3__and2_2
XFILLER_159_950 VDD VDD VSS VSS gf180mcu_as_sc_mcu7t3v3__fill_2
XFILLER_177_246 VDD VDD VSS VSS gf180mcu_as_sc_mcu7t3v3__fillcap_4
XFILLER_177_257 VDD VDD VSS VSS gf180mcu_as_sc_mcu7t3v3__fillcap_8
XFILLER_203_1100 VDD VDD VSS VSS gf180mcu_as_sc_mcu7t3v3__fillcap_16
XFILLER_203_1122 VDD VDD VSS VSS gf180mcu_as_sc_mcu7t3v3__fillcap_16
XFILLER_60_594 VDD VDD VSS VSS gf180mcu_as_sc_mcu7t3v3__fill_2
XPHY_EDGE_ROW_60_3_Right_140 VDD VSS gf180mcu_as_sc_mcu7t3v3__tap_2
XPHY_EDGE_ROW_66_1_Left_294 VDD VSS gf180mcu_as_sc_mcu7t3v3__tap_2
XTAP_TAPCELL_ROW_158_1582 VDD VSS gf180mcu_as_sc_mcu7t3v3__tap_2
X_6542_ VDD VDD VSS VSS _6546_/CLK _6542_/D _6542_/Q gf180mcu_as_sc_mcu7t3v3__dfxtp_2
X_3754_ VDD VDD VSS VSS _6025_/Q _3830_/B _4031_/B _3895_/D _6025_/D gf180mcu_as_sc_mcu7t3v3__ao22_2
XFILLER_146_666 VDD VDD VSS VSS gf180mcu_as_sc_mcu7t3v3__fill_1
XFILLER_173_430 VDD VDD VSS VSS gf180mcu_as_sc_mcu7t3v3__fill_2
XFILLER_9_492 VDD VDD VSS VSS gf180mcu_as_sc_mcu7t3v3__fill_2
XTAP_TAPCELL_ROW_158_1593 VDD VSS gf180mcu_as_sc_mcu7t3v3__tap_2
X_6473_ VDD VDD VSS VSS _6474_/CLK _6473_/D _6473_/Q gf180mcu_as_sc_mcu7t3v3__dfxtp_2
X_3685_ VDD VDD VSS VSS _5694_/A _3809_/B _3685_/C _3685_/D _3686_/C gf180mcu_as_sc_mcu7t3v3__ao211_2
XFILLER_173_463 VDD VDD VSS VSS gf180mcu_as_sc_mcu7t3v3__fill_2
X_5424_ VDD VDD VSS VSS _6500_/Q _5631_/B _5549_/B _5733_/A _5425_/C gf180mcu_as_sc_mcu7t3v3__ao22_2
XFILLER_173_496 VDD VDD VSS VSS gf180mcu_as_sc_mcu7t3v3__fill_2
XTAP_TAPCELL_ROW_40_3_2909 VDD VSS gf180mcu_as_sc_mcu7t3v3__tap_2
X_5355_ VDD VDD VSS VSS _5356_/C _5358_/C gf180mcu_as_sc_mcu7t3v3__inv_2
X_5286_ VDD VDD VSS VSS _5930_/D _5312_/B _5302_/C _5286_/D _5287_/B gf180mcu_as_sc_mcu7t3v3__ao22_2
X_4306_ VDD VDD VSS VSS _4342_/S _6112_/Q _4306_/C _4369_/D _4310_/C gf180mcu_as_sc_mcu7t3v3__ao211_2
Xwire1019 VDD VDD VSS VSS wire1019/A _5798_/B gf180mcu_as_sc_mcu7t3v3__clkbuff_12
X_4237_ VDD VDD VSS VSS _4238_/B _4237_/B _6166_/Q gf180mcu_as_sc_mcu7t3v3__nand2_2
X_4168_ VDD VDD VSS VSS _4170_/C _6181_/Q _6182_/Q gf180mcu_as_sc_mcu7t3v3__nor2_2
XTAP_TAPCELL_ROW_221_2716 VDD VSS gf180mcu_as_sc_mcu7t3v3__tap_2
XFILLER_215_114 VDD VDD VSS VSS gf180mcu_as_sc_mcu7t3v3__fill_1
XFILLER_83_664 VDD VDD VSS VSS gf180mcu_as_sc_mcu7t3v3__fill_2
X_4099_ VDD VDD VSS VSS _4101_/S _6720_/A _6159_/Q _6159_/D gf180mcu_as_sc_mcu7t3v3__mux2_2
X_3119_ VDD VDD VSS VSS _3172_/B _6260_/Q _6259_/Q gf180mcu_as_sc_mcu7t3v3__nand2_2
XTAP_TAPCELL_ROW_221_2727 VDD VSS gf180mcu_as_sc_mcu7t3v3__tap_2
XFILLER_208_1011 VDD VDD VSS VSS gf180mcu_as_sc_mcu7t3v3__fillcap_4
XFILLER_208_1033 VDD VDD VSS VSS gf180mcu_as_sc_mcu7t3v3__fillcap_16
XFILLER_212_832 VDD VDD VSS VSS gf180mcu_as_sc_mcu7t3v3__fill_2
XPHY_EDGE_ROW_137_3_Right_217 VDD VSS gf180mcu_as_sc_mcu7t3v3__tap_2
XFILLER_11_403 VDD VDD VSS VSS gf180mcu_as_sc_mcu7t3v3__fillcap_8
XFILLER_142_6 VDD VDD VSS VSS gf180mcu_as_sc_mcu7t3v3__fillcap_16
XFILLER_157_909 VDD VDD VSS VSS gf180mcu_as_sc_mcu7t3v3__fill_1
XFILLER_169_758 VDD VDD VSS VSS gf180mcu_as_sc_mcu7t3v3__fillcap_8
XTAP_TAPCELL_ROW_178_1947 VDD VSS gf180mcu_as_sc_mcu7t3v3__tap_2
XFILLER_139_22 VDD VDD VSS VSS gf180mcu_as_sc_mcu7t3v3__fillcap_16
XFILLER_169_769 VDD VDD VSS VSS gf180mcu_as_sc_mcu7t3v3__fill_1
XFILLER_184_717 VDD VDD VSS VSS gf180mcu_as_sc_mcu7t3v3__fill_2
XFILLER_212_898 VDD VDD VSS VSS gf180mcu_as_sc_mcu7t3v3__fillcap_8
XFILLER_11_469 VDD VDD VSS VSS gf180mcu_as_sc_mcu7t3v3__fillcap_16
XTAP_TAPCELL_ROW_219_2689 VDD VSS gf180mcu_as_sc_mcu7t3v3__tap_2
XTAP_TAPCELL_ROW_219_2678 VDD VSS gf180mcu_as_sc_mcu7t3v3__tap_2
XFILLER_137_666 VDD VDD VSS VSS gf180mcu_as_sc_mcu7t3v3__fill_1
XFILLER_183_249 VDD VDD VSS VSS gf180mcu_as_sc_mcu7t3v3__fillcap_8
XFILLER_164_452 VDD VDD VSS VSS gf180mcu_as_sc_mcu7t3v3__fill_2
XFILLER_30_1261 VDD VDD VSS VSS gf180mcu_as_sc_mcu7t3v3__fillcap_4
XFILLER_191_282 VDD VDD VSS VSS gf180mcu_as_sc_mcu7t3v3__fill_2
XFILLER_155_54 VDD VDD VSS VSS gf180mcu_as_sc_mcu7t3v3__fillcap_16
XFILLER_2_123 VDD VDD VSS VSS gf180mcu_as_sc_mcu7t3v3__fill_2
XTAP_TAPCELL_ROW_5_1110 VDD VSS gf180mcu_as_sc_mcu7t3v3__tap_2
XFILLER_206_158 VDD VDD VSS VSS gf180mcu_as_sc_mcu7t3v3__fill_2
XTAP_TAPCELL_ROW_1_1029 VDD VSS gf180mcu_as_sc_mcu7t3v3__tap_2
XFILLER_221_128 VDD VDD VSS VSS gf180mcu_as_sc_mcu7t3v3__fill_1
XFILLER_14_241 VDD VDD VSS VSS gf180mcu_as_sc_mcu7t3v3__fillcap_4
XFILLER_14_263 VDD VDD VSS VSS gf180mcu_as_sc_mcu7t3v3__fillcap_16
XFILLER_202_364 VDD VDD VSS VSS gf180mcu_as_sc_mcu7t3v3__fill_2
XFILLER_42_594 VDD VDD VSS VSS gf180mcu_as_sc_mcu7t3v3__fillcap_8
XFILLER_9_68 VDD VDD VSS VSS gf180mcu_as_sc_mcu7t3v3__fill_2
XFILLER_156_931 VDD VDD VSS VSS gf180mcu_as_sc_mcu7t3v3__fill_2
XFILLER_196_1221 VDD VDD VSS VSS gf180mcu_as_sc_mcu7t3v3__fillcap_4
XFILLER_155_452 VDD VDD VSS VSS gf180mcu_as_sc_mcu7t3v3__fillcap_16
XFILLER_196_1243 VDD VDD VSS VSS gf180mcu_as_sc_mcu7t3v3__fillcap_8
XFILLER_170_422 VDD VDD VSS VSS gf180mcu_as_sc_mcu7t3v3__fillcap_16
X_3470_ VDD VDD VSS VSS _5319_/D _3470_/B _3470_/C _5319_/A _5350_/B gf180mcu_as_sc_mcu7t3v3__ao22_2
XTAP_TAPCELL_ROW_153_1490 VDD VSS gf180mcu_as_sc_mcu7t3v3__tap_2
X_5140_ VDD VDD VSS VSS _5142_/C _5797_/A _5140_/B _5140_/C gf180mcu_as_sc_mcu7t3v3__ao21_2
XPHY_EDGE_ROW_143_1_Right_715 VDD VSS gf180mcu_as_sc_mcu7t3v3__tap_2
X_5071_ VDD VDD VSS VSS _5736_/A _5098_/B _5071_/C _5072_/C _5275_/B gf180mcu_as_sc_mcu7t3v3__aoi211_2
X_4022_ VDD VDD VSS VSS _6105_/Q _4044_/B _4029_/C _4022_/D _6105_/D gf180mcu_as_sc_mcu7t3v3__ao22_2
XTAP_TAPCELL_ROW_203_2402 VDD VSS gf180mcu_as_sc_mcu7t3v3__tap_2
XFILLER_65_664 VDD VDD VSS VSS gf180mcu_as_sc_mcu7t3v3__fill_2
XPHY_EDGE_ROW_126_2_Right_963 VDD VSS gf180mcu_as_sc_mcu7t3v3__tap_2
XFILLER_198_809 VDD VDD VSS VSS gf180mcu_as_sc_mcu7t3v3__fill_1
X_5973_ VDD VDD VSS VSS _5974_/C _5973_/B _6492_/Q gf180mcu_as_sc_mcu7t3v3__nand2_2
XFILLER_213_629 VDD VDD VSS VSS gf180mcu_as_sc_mcu7t3v3__fill_1
X_4924_ VDD VDD VSS VSS _5915_/A _4924_/B _4924_/C _4924_/D _4926_/C gf180mcu_as_sc_mcu7t3v3__ao211_2
XFILLER_100_27 VDD VDD VSS VSS gf180mcu_as_sc_mcu7t3v3__fillcap_8
XTAP_TAPCELL_ROW_195_2258 VDD VSS gf180mcu_as_sc_mcu7t3v3__tap_2
XTAP_TAPCELL_ROW_195_2247 VDD VSS gf180mcu_as_sc_mcu7t3v3__tap_2
XFILLER_100_49 VDD VDD VSS VSS gf180mcu_as_sc_mcu7t3v3__fill_2
XFILLER_33_594 VDD VDD VSS VSS gf180mcu_as_sc_mcu7t3v3__fillcap_16
X_4855_ VDD VDD VSS VSS _6362_/D _4855_/C _4950_/D _5851_/A gf180mcu_as_sc_mcu7t3v3__aoi21b_2
XFILLER_159_780 VDD VDD VSS VSS gf180mcu_as_sc_mcu7t3v3__fillcap_4
XFILLER_165_216 VDD VDD VSS VSS gf180mcu_as_sc_mcu7t3v3__fill_2
XPHY_EDGE_ROW_61_3_Right_141 VDD VSS gf180mcu_as_sc_mcu7t3v3__tap_2
X_4786_ VDD VDD VSS VSS _5793_/A _4795_/B _4795_/C _5793_/D _4787_/D gf180mcu_as_sc_mcu7t3v3__ao22_2
X_3806_ VDD VDD VSS VSS _3806_/S _5800_/A _3806_/A _3807_/A gf180mcu_as_sc_mcu7t3v3__mux2_2
XFILLER_140_1242 VDD VDD VSS VSS gf180mcu_as_sc_mcu7t3v3__fill_1
XTAP_TAPCELL_ROW_173_1855 VDD VSS gf180mcu_as_sc_mcu7t3v3__tap_2
X_6525_ VDD VDD VSS VSS _6525_/CLK _6525_/D _6525_/Q gf180mcu_as_sc_mcu7t3v3__dfxtp_2
X_3737_ VDD VDD VSS VSS _3869_/B _5740_/A _3738_/D gf180mcu_as_sc_mcu7t3v3__and2_2
XFILLER_119_666 VDD VDD VSS VSS gf180mcu_as_sc_mcu7t3v3__fill_1
XFILLER_134_625 VDD VDD VSS VSS gf180mcu_as_sc_mcu7t3v3__fill_2
XFILLER_161_422 VDD VDD VSS VSS gf180mcu_as_sc_mcu7t3v3__fillcap_8
XFILLER_173_271 VDD VDD VSS VSS gf180mcu_as_sc_mcu7t3v3__fillcap_8
X_6456_ VDD VDD VSS VSS _6474_/CLK _6456_/D _6456_/Q gf180mcu_as_sc_mcu7t3v3__dfxtp_2
X_3668_ VDD VDD VSS VSS _3830_/D _4018_/B _3904_/B _6016_/Q _6016_/D gf180mcu_as_sc_mcu7t3v3__ao22_2
XTAP_TAPCELL_ROW_58_3_2936 VDD VSS gf180mcu_as_sc_mcu7t3v3__tap_2
XTAP_TAPCELL_ROW_214_2597 VDD VSS gf180mcu_as_sc_mcu7t3v3__tap_2
XTAP_TAPCELL_ROW_214_2586 VDD VSS gf180mcu_as_sc_mcu7t3v3__tap_2
XFILLER_161_444 VDD VDD VSS VSS gf180mcu_as_sc_mcu7t3v3__fillcap_4
XFILLER_161_477 VDD VDD VSS VSS gf180mcu_as_sc_mcu7t3v3__fillcap_8
X_6387_ VDD VDD VSS VSS clkload3/A _6387_/D _6387_/Q gf180mcu_as_sc_mcu7t3v3__dfxtp_2
X_5407_ VDD VDD VSS VSS _5408_/A _5716_/B _5491_/C _5407_/C gf180mcu_as_sc_mcu7t3v3__ao21_2
X_3599_ VDD VDD VSS VSS _3607_/B _4239_/A _5912_/A gf180mcu_as_sc_mcu7t3v3__nand2b_2
X_5338_ VDD VDD VSS VSS _5362_/A _5361_/B _5338_/C _5365_/C _5367_/A gf180mcu_as_sc_mcu7t3v3__nand4_2
XFILLER_173_1084 VDD VDD VSS VSS gf180mcu_as_sc_mcu7t3v3__fillcap_16
XFILLER_60_1210 VDD VDD VSS VSS gf180mcu_as_sc_mcu7t3v3__fillcap_8
X_5269_ VDD VDD VSS VSS _5294_/A _5911_/A _5913_/A _5270_/D gf180mcu_as_sc_mcu7t3v3__mux2_2
XFILLER_205_90 VDD VDD VSS VSS gf180mcu_as_sc_mcu7t3v3__fill_1
XFILLER_214_1081 VDD VDD VSS VSS gf180mcu_as_sc_mcu7t3v3__fillcap_4
XFILLER_217_924 VDD VDD VSS VSS gf180mcu_as_sc_mcu7t3v3__fillcap_16
XPHY_EDGE_ROW_124_3_Left_829 VDD VSS gf180mcu_as_sc_mcu7t3v3__tap_2
XFILLER_3_1170 VDD VDD VSS VSS gf180mcu_as_sc_mcu7t3v3__fillcap_16
XPHY_EDGE_ROW_101_2_Left_542 VDD VSS gf180mcu_as_sc_mcu7t3v3__tap_2
XFILLER_3_1192 VDD VDD VSS VSS gf180mcu_as_sc_mcu7t3v3__fillcap_16
XFILLER_169_533 VDD VDD VSS VSS gf180mcu_as_sc_mcu7t3v3__fill_2
XFILLER_180_1000 VDD VDD VSS VSS gf180mcu_as_sc_mcu7t3v3__fillcap_8
XFILLER_12_723 VDD VDD VSS VSS gf180mcu_as_sc_mcu7t3v3__fillcap_8
XFILLER_180_1033 VDD VDD VSS VSS gf180mcu_as_sc_mcu7t3v3__fillcap_16
XFILLER_24_594 VDD VDD VSS VSS gf180mcu_as_sc_mcu7t3v3__fillcap_8
XPHY_EDGE_ROW_138_3_Right_218 VDD VSS gf180mcu_as_sc_mcu7t3v3__tap_2
XFILLER_11_244 VDD VDD VSS VSS gf180mcu_as_sc_mcu7t3v3__fillcap_16
XFILLER_12_767 VDD VDD VSS VSS gf180mcu_as_sc_mcu7t3v3__fillcap_4
XFILLER_221_1030 VDD VDD VSS VSS gf180mcu_as_sc_mcu7t3v3__fillcap_16
XFILLER_149_290 VDD VDD VSS VSS gf180mcu_as_sc_mcu7t3v3__fillcap_16
XFILLER_221_1052 VDD VDD VSS VSS gf180mcu_as_sc_mcu7t3v3__fillcap_16
XFILLER_8_749 VDD VDD VSS VSS gf180mcu_as_sc_mcu7t3v3__fill_1
XFILLER_153_923 VDD VDD VSS VSS gf180mcu_as_sc_mcu7t3v3__fill_2
XFILLER_165_772 VDD VDD VSS VSS gf180mcu_as_sc_mcu7t3v3__fillcap_4
XFILLER_125_636 VDD VDD VSS VSS gf180mcu_as_sc_mcu7t3v3__fillcap_16
XFILLER_164_271 VDD VDD VSS VSS gf180mcu_as_sc_mcu7t3v3__fillcap_4
XFILLER_152_1135 VDD VDD VSS VSS gf180mcu_as_sc_mcu7t3v3__fillcap_16
XFILLER_152_1157 VDD VDD VSS VSS gf180mcu_as_sc_mcu7t3v3__fillcap_16
XFILLER_8_1081 VDD VDD VSS VSS gf180mcu_as_sc_mcu7t3v3__fillcap_4
XFILLER_47_664 VDD VDD VSS VSS gf180mcu_as_sc_mcu7t3v3__fill_2
XPHY_EDGE_ROW_33_2_Left_474 VDD VSS gf180mcu_as_sc_mcu7t3v3__tap_2
XFILLER_208_979 VDD VDD VSS VSS gf180mcu_as_sc_mcu7t3v3__fillcap_16
XFILLER_223_916 VDD VDD VSS VSS gf180mcu_as_sc_mcu7t3v3__fill_1
XFILLER_228_1217 VDD VDD VSS VSS gf180mcu_as_sc_mcu7t3v3__fillcap_4
XFILLER_76_1261 VDD VDD VSS VSS gf180mcu_as_sc_mcu7t3v3__fillcap_4
XFILLER_163_1253 VDD VDD VSS VSS gf180mcu_as_sc_mcu7t3v3__fill_2
XFILLER_163_1264 VDD VDD VSS VSS gf180mcu_as_sc_mcu7t3v3__fill_1
XFILLER_124_1226 VDD VDD VSS VSS gf180mcu_as_sc_mcu7t3v3__fillcap_16
X_4640_ VDD VDD VSS VSS _4646_/B _4875_/B _5676_/A gf180mcu_as_sc_mcu7t3v3__nand2_2
XFILLER_200_1103 VDD VDD VSS VSS gf180mcu_as_sc_mcu7t3v3__fillcap_16
XTAP_TAPCELL_ROW_155_1530 VDD VSS gf180mcu_as_sc_mcu7t3v3__tap_2
XTAP_TAPCELL_ROW_190_2155 VDD VSS gf180mcu_as_sc_mcu7t3v3__tap_2
XFILLER_190_517 VDD VDD VSS VSS gf180mcu_as_sc_mcu7t3v3__fill_1
X_6310_ VDD VDD VSS VSS _6531_/CLK _6310_/D _6310_/Q gf180mcu_as_sc_mcu7t3v3__dfxtp_2
X_4571_ VDD VDD VSS VSS _4581_/B _6315_/Q _6266_/Q _4571_/C _4572_/C gf180mcu_as_sc_mcu7t3v3__ao31_2
XTAP_TAPCELL_ROW_190_2166 VDD VSS gf180mcu_as_sc_mcu7t3v3__tap_2
XFILLER_155_260 VDD VDD VSS VSS gf180mcu_as_sc_mcu7t3v3__fillcap_16
XFILLER_155_282 VDD VDD VSS VSS gf180mcu_as_sc_mcu7t3v3__fillcap_16
X_3522_ VDD VDD VSS VSS _4627_/C _4627_/D _3523_/D _5652_/D gf180mcu_as_sc_mcu7t3v3__nor3_2
XFILLER_157_1046 VDD VDD VSS VSS gf180mcu_as_sc_mcu7t3v3__fillcap_4
XFILLER_226_34 VDD VDD VSS VSS gf180mcu_as_sc_mcu7t3v3__fill_1
XFILLER_83_1210 VDD VDD VSS VSS gf180mcu_as_sc_mcu7t3v3__fill_2
X_6241_ VDD VDD VSS VSS _6316_/CLK _6241_/D _6241_/Q gf180mcu_as_sc_mcu7t3v3__dfxtp_2
X_3453_ VDD VDD VSS VSS _4585_/A _3453_/B _6318_/Q _6317_/D gf180mcu_as_sc_mcu7t3v3__mux2_2
XFILLER_157_1068 VDD VDD VSS VSS gf180mcu_as_sc_mcu7t3v3__fillcap_16
XFILLER_170_263 VDD VDD VSS VSS gf180mcu_as_sc_mcu7t3v3__fill_2
X_6172_ VDD VDD VSS VSS _6316_/CLK _6172_/D _6172_/Q gf180mcu_as_sc_mcu7t3v3__dfxtp_2
X_5123_ VDD VDD VSS VSS _5123_/A _5186_/B _5124_/B _5125_/C _5123_/D gf180mcu_as_sc_mcu7t3v3__aoi211_2
X_3384_ VDD VDD VSS VSS _3391_/C _4444_/A _4511_/A gf180mcu_as_sc_mcu7t3v3__nor2_2
XPHY_EDGE_ROW_144_1_Right_716 VDD VSS gf180mcu_as_sc_mcu7t3v3__tap_2
Xload_slew674 VDD VDD VSS VSS _5367_/Y _5535_/C gf180mcu_as_sc_mcu7t3v3__clkbuff_12
XFILLER_211_1232 VDD VDD VSS VSS gf180mcu_as_sc_mcu7t3v3__fill_2
XTAP_TAPCELL_ROW_14_1261 VDD VSS gf180mcu_as_sc_mcu7t3v3__tap_2
X_5054_ VDD VDD VSS VSS _5725_/A _5183_/B _5222_/C _5726_/A _5056_/B gf180mcu_as_sc_mcu7t3v3__ao22_2
XTAP_TAPCELL_ROW_14_1272 VDD VSS gf180mcu_as_sc_mcu7t3v3__tap_2
X_4005_ VDD VDD VSS VSS _4047_/B _4008_/B _4008_/C _6093_/Q _6093_/D gf180mcu_as_sc_mcu7t3v3__ao22_2
XFILLER_164_1017 VDD VDD VSS VSS gf180mcu_as_sc_mcu7t3v3__fillcap_16
XPHY_EDGE_ROW_127_2_Right_964 VDD VSS gf180mcu_as_sc_mcu7t3v3__tap_2
XFILLER_213_448 VDD VDD VSS VSS gf180mcu_as_sc_mcu7t3v3__fill_2
X_5956_ VDD VDD VSS VSS _5956_/B _5956_/A _6483_/D gf180mcu_as_sc_mcu7t3v3__and2_2
XFILLER_178_352 VDD VDD VSS VSS gf180mcu_as_sc_mcu7t3v3__fillcap_4
XFILLER_205_1014 VDD VDD VSS VSS gf180mcu_as_sc_mcu7t3v3__fillcap_16
X_5887_ VDD VDD VSS VSS _5912_/A _5936_/B _5930_/C _5887_/D _5888_/A gf180mcu_as_sc_mcu7t3v3__ao22_2
X_4907_ VDD VDD VSS VSS _4933_/B _5895_/A _4908_/B gf180mcu_as_sc_mcu7t3v3__or2_2
XFILLER_221_492 VDD VDD VSS VSS gf180mcu_as_sc_mcu7t3v3__fill_2
X_4838_ VDD VDD VSS VSS _5842_/D _4838_/B _4838_/C _4945_/C _4841_/C gf180mcu_as_sc_mcu7t3v3__ao211_2
XTAP_TAPCELL_ROW_216_2637 VDD VSS gf180mcu_as_sc_mcu7t3v3__tap_2
XTAP_TAPCELL_ROW_216_2626 VDD VSS gf180mcu_as_sc_mcu7t3v3__tap_2
XPHY_EDGE_ROW_62_3_Right_142 VDD VSS gf180mcu_as_sc_mcu7t3v3__tap_2
X_4769_ VDD VDD VSS VSS _4883_/A _4769_/B _5779_/A _4770_/B gf180mcu_as_sc_mcu7t3v3__mux2_2
X_6508_ VDD VDD VSS VSS _6520_/CLK _6508_/D _6508_/Q gf180mcu_as_sc_mcu7t3v3__dfxtp_2
XFILLER_136_34 VDD VDD VSS VSS gf180mcu_as_sc_mcu7t3v3__fill_1
XFILLER_20_45 VDD VDD VSS VSS gf180mcu_as_sc_mcu7t3v3__fillcap_4
XPHY_EDGE_ROW_29_1_Left_257 VDD VSS gf180mcu_as_sc_mcu7t3v3__tap_2
X_6439_ VDD VDD VSS VSS _6448_/CLK _6439_/D _6439_/Q gf180mcu_as_sc_mcu7t3v3__dfxtp_2
XFILLER_136_45 VDD VDD VSS VSS gf180mcu_as_sc_mcu7t3v3__fillcap_4
XFILLER_96_27 VDD VDD VSS VSS gf180mcu_as_sc_mcu7t3v3__fillcap_8
XFILLER_96_49 VDD VDD VSS VSS gf180mcu_as_sc_mcu7t3v3__fill_2
Xinput303 VDD VDD VSS VSS west_in[0] _5676_/A gf180mcu_as_sc_mcu7t3v3__buff_12
XFILLER_29_43 VDD VDD VSS VSS gf180mcu_as_sc_mcu7t3v3__fillcap_8
Xinput314 VDD VDD VSS VSS west_in[1] _5684_/A gf180mcu_as_sc_mcu7t3v3__buff_12
Xinput325 VDD VDD VSS VSS west_in[2] _5692_/A gf180mcu_as_sc_mcu7t3v3__buff_12
Xinput336 VDD VDD VSS VSS west_in[7] _5734_/A gf180mcu_as_sc_mcu7t3v3__buff_12
XFILLER_29_664 VDD VDD VSS VSS gf180mcu_as_sc_mcu7t3v3__fill_2
XPHY_EDGE_ROW_143_1_Left_371 VDD VSS gf180mcu_as_sc_mcu7t3v3__tap_2
XFILLER_16_336 VDD VDD VSS VSS gf180mcu_as_sc_mcu7t3v3__fillcap_4
XFILLER_188_127 VDD VDD VSS VSS gf180mcu_as_sc_mcu7t3v3__fillcap_4
XFILLER_204_448 VDD VDD VSS VSS gf180mcu_as_sc_mcu7t3v3__fillcap_4
XTAP_TAPCELL_ROW_0_991 VDD VSS gf180mcu_as_sc_mcu7t3v3__tap_2
XFILLER_12_520 VDD VDD VSS VSS gf180mcu_as_sc_mcu7t3v3__fillcap_4
XFILLER_169_352 VDD VDD VSS VSS gf180mcu_as_sc_mcu7t3v3__fillcap_8
XFILLER_197_650 VDD VDD VSS VSS gf180mcu_as_sc_mcu7t3v3__fillcap_4
XFILLER_213_971 VDD VDD VSS VSS gf180mcu_as_sc_mcu7t3v3__fillcap_8
XFILLER_213_982 VDD VDD VSS VSS gf180mcu_as_sc_mcu7t3v3__fillcap_16
XPHY_EDGE_ROW_139_3_Right_219 VDD VSS gf180mcu_as_sc_mcu7t3v3__tap_2
XFILLER_12_575 VDD VDD VSS VSS gf180mcu_as_sc_mcu7t3v3__fillcap_4
XFILLER_12_597 VDD VDD VSS VSS gf180mcu_as_sc_mcu7t3v3__fillcap_16
XFILLER_8_524 VDD VDD VSS VSS gf180mcu_as_sc_mcu7t3v3__fill_1
XANTENNA_7 VDD VDD VSS VSS _6455_/D gf180mcu_as_sc_mcu7t3v3__diode_2
XFILLER_113_606 VDD VDD VSS VSS gf180mcu_as_sc_mcu7t3v3__fill_2
XFILLER_152_241 VDD VDD VSS VSS gf180mcu_as_sc_mcu7t3v3__fillcap_4
XFILLER_193_1224 VDD VDD VSS VSS gf180mcu_as_sc_mcu7t3v3__fillcap_8
XFILLER_6_69 VDD VDD VSS VSS gf180mcu_as_sc_mcu7t3v3__fillcap_16
XTAP_TAPCELL_ROW_28_3_2891 VDD VSS gf180mcu_as_sc_mcu7t3v3__tap_2
XFILLER_152_263 VDD VDD VSS VSS gf180mcu_as_sc_mcu7t3v3__fillcap_16
XFILLER_180_583 VDD VDD VSS VSS gf180mcu_as_sc_mcu7t3v3__fill_1
XTAP_TAPCELL_ROW_140_1_1391 VDD VSS gf180mcu_as_sc_mcu7t3v3__tap_2
XFILLER_212_69 VDD VDD VSS VSS gf180mcu_as_sc_mcu7t3v3__fillcap_16
XFILLER_35_634 VDD VDD VSS VSS gf180mcu_as_sc_mcu7t3v3__fillcap_16
XFILLER_211_908 VDD VDD VSS VSS gf180mcu_as_sc_mcu7t3v3__fill_2
XFILLER_50_615 VDD VDD VSS VSS gf180mcu_as_sc_mcu7t3v3__fill_1
X_5810_ VDD VDD VSS VSS _5811_/C _5810_/A _5954_/B _5871_/B _5810_/D gf180mcu_as_sc_mcu7t3v3__aoi22_2
XFILLER_50_626 VDD VDD VSS VSS gf180mcu_as_sc_mcu7t3v3__fill_1
X_5741_ VDD VDD VSS VSS _5741_/S _5741_/B _6501_/Q _5742_/C gf180mcu_as_sc_mcu7t3v3__mux2_2
XTAP_TAPCELL_ROW_192_2206 VDD VSS gf180mcu_as_sc_mcu7t3v3__tap_2
XFILLER_203_492 VDD VDD VSS VSS gf180mcu_as_sc_mcu7t3v3__fillcap_8
XFILLER_210_429 VDD VDD VSS VSS gf180mcu_as_sc_mcu7t3v3__fillcap_8
X_5672_ VDD VDD VSS VSS _5936_/B _5950_/C _5672_/C _5672_/Y gf180mcu_as_sc_mcu7t3v3__nor3_2
XFILLER_198_1135 VDD VDD VSS VSS gf180mcu_as_sc_mcu7t3v3__fillcap_16
XFILLER_198_1157 VDD VDD VSS VSS gf180mcu_as_sc_mcu7t3v3__fillcap_16
X_4623_ VDD VDD VSS VSS _4889_/A _4896_/A _4689_/A gf180mcu_as_sc_mcu7t3v3__and2_2
XTAP_TAPCELL_ROW_170_1803 VDD VSS gf180mcu_as_sc_mcu7t3v3__tap_2
X_4554_ VDD VDD VSS VSS _4581_/B _4566_/A _4607_/A gf180mcu_as_sc_mcu7t3v3__nor2_2
X_3505_ VDD VDD VSS VSS _4624_/D _4624_/C _3510_/B gf180mcu_as_sc_mcu7t3v3__or2_2
XTAP_TAPCELL_ROW_211_2545 VDD VSS gf180mcu_as_sc_mcu7t3v3__tap_2
XTAP_TAPCELL_ROW_211_2534 VDD VSS gf180mcu_as_sc_mcu7t3v3__tap_2
X_6224_ VDD VDD VSS VSS _6517_/CLK _6224_/D _6224_/Q gf180mcu_as_sc_mcu7t3v3__dfxtp_2
X_4485_ VDD VDD VSS VSS _6142_/Q _4512_/S _4499_/C _6280_/Q _4486_/C gf180mcu_as_sc_mcu7t3v3__ao22_2
XTAP_TAPCELL_ROW_16_1301 VDD VSS gf180mcu_as_sc_mcu7t3v3__tap_2
XTAP_TAPCELL_ROW_16_1312 VDD VSS gf180mcu_as_sc_mcu7t3v3__tap_2
X_3436_ VDD VDD VSS VSS _6541_/D _6227_/Q _4462_/B _4478_/A gf180mcu_as_sc_mcu7t3v3__ao21_2
XFILLER_106_37 VDD VDD VSS VSS gf180mcu_as_sc_mcu7t3v3__fillcap_8
XTAP_TAPCELL_ROW_16_1323 VDD VSS gf180mcu_as_sc_mcu7t3v3__tap_2
X_6155_ VDD VDD VSS VSS _6365_/CLK _6155_/D _6155_/Q gf180mcu_as_sc_mcu7t3v3__dfxtp_2
X_3367_ VDD VDD VSS VSS _6527_/Q _3367_/B _3367_/A _3367_/Y gf180mcu_as_sc_mcu7t3v3__mux2_2
XFILLER_170_1065 VDD VDD VSS VSS gf180mcu_as_sc_mcu7t3v3__fillcap_16
XTAP_TAPCELL_ROW_168_1765 VDD VSS gf180mcu_as_sc_mcu7t3v3__tap_2
Xhold1202 VDD VDD VSS VSS hold1229/Y _6547_/D gf180mcu_as_sc_mcu7t3v3__clkbuff_4
Xhold1213 VDD VDD VSS VSS _6277_/Q _4477_/A gf180mcu_as_sc_mcu7t3v3__clkbuff_4
Xhold1224 VDD VDD VSS VSS _6540_/Q hold1224/Y gf180mcu_as_sc_mcu7t3v3__clkbuff_4
X_6086_ VDD VDD VSS VSS _6368_/CLK _6086_/D _6086_/Q gf180mcu_as_sc_mcu7t3v3__dfxtp_2
X_5106_ VDD VDD VSS VSS _5106_/D _5297_/A _5106_/B _5106_/C _5107_/A gf180mcu_as_sc_mcu7t3v3__ao31_2
XTAP_TAPCELL_ROW_90_1_1366 VDD VSS gf180mcu_as_sc_mcu7t3v3__tap_2
XFILLER_170_1087 VDD VDD VSS VSS gf180mcu_as_sc_mcu7t3v3__fillcap_16
XPHY_EDGE_ROW_145_1_Right_717 VDD VSS gf180mcu_as_sc_mcu7t3v3__tap_2
X_5037_ VDD VDD VSS VSS _5037_/D _5709_/A _5139_/B _5139_/C _5038_/C gf180mcu_as_sc_mcu7t3v3__ao31_2
X_3298_ VDD VDD VSS VSS _3299_/D _3332_/A _6528_/D _3298_/A gf180mcu_as_sc_mcu7t3v3__aoi21b_2
XTAP_TAPCELL_ROW_209_2496 VDD VSS gf180mcu_as_sc_mcu7t3v3__tap_2
XFILLER_211_1084 VDD VDD VSS VSS gf180mcu_as_sc_mcu7t3v3__fillcap_16
XFILLER_198_403 VDD VDD VSS VSS gf180mcu_as_sc_mcu7t3v3__fill_1
XFILLER_26_645 VDD VDD VSS VSS gf180mcu_as_sc_mcu7t3v3__fill_2
XFILLER_82_29 VDD VDD VSS VSS gf180mcu_as_sc_mcu7t3v3__fillcap_4
XTAP_TAPCELL_ROW_181_1998 VDD VSS gf180mcu_as_sc_mcu7t3v3__tap_2
XFILLER_0_1162 VDD VDD VSS VSS gf180mcu_as_sc_mcu7t3v3__fill_2
XFILLER_14_807 VDD VDD VSS VSS gf180mcu_as_sc_mcu7t3v3__fillcap_16
XFILLER_213_212 VDD VDD VSS VSS gf180mcu_as_sc_mcu7t3v3__fill_2
XPHY_EDGE_ROW_128_2_Right_965 VDD VSS gf180mcu_as_sc_mcu7t3v3__tap_2
XFILLER_107_1210 VDD VDD VSS VSS gf180mcu_as_sc_mcu7t3v3__fill_2
XFILLER_198_447 VDD VDD VSS VSS gf180mcu_as_sc_mcu7t3v3__fillcap_8
XFILLER_213_267 VDD VDD VSS VSS gf180mcu_as_sc_mcu7t3v3__fill_1
XFILLER_166_300 VDD VDD VSS VSS gf180mcu_as_sc_mcu7t3v3__fillcap_8
X_5939_ VDD VDD VSS VSS _5939_/A _5953_/B _5953_/C _5939_/D _5940_/D gf180mcu_as_sc_mcu7t3v3__ao22_2
XTAP_TAPCELL_ROW_46_3_2918 VDD VSS gf180mcu_as_sc_mcu7t3v3__tap_2
XFILLER_210_963 VDD VDD VSS VSS gf180mcu_as_sc_mcu7t3v3__fillcap_16
XFILLER_182_804 VDD VDD VSS VSS gf180mcu_as_sc_mcu7t3v3__fill_1
XFILLER_194_653 VDD VDD VSS VSS gf180mcu_as_sc_mcu7t3v3__fill_1
XFILLER_147_22 VDD VDD VSS VSS gf180mcu_as_sc_mcu7t3v3__fillcap_16
XFILLER_177_1208 VDD VDD VSS VSS gf180mcu_as_sc_mcu7t3v3__fillcap_16
XFILLER_193_174 VDD VDD VSS VSS gf180mcu_as_sc_mcu7t3v3__fillcap_16
XPHY_EDGE_ROW_63_3_Right_143 VDD VSS gf180mcu_as_sc_mcu7t3v3__tap_2
XFILLER_218_1205 VDD VDD VSS VSS gf180mcu_as_sc_mcu7t3v3__fillcap_16
XFILLER_150_712 VDD VDD VSS VSS gf180mcu_as_sc_mcu7t3v3__fillcap_4
XFILLER_190_870 VDD VDD VSS VSS gf180mcu_as_sc_mcu7t3v3__fillcap_4
XFILLER_218_1227 VDD VDD VSS VSS gf180mcu_as_sc_mcu7t3v3__fillcap_16
XFILLER_0_210 VDD VDD VSS VSS gf180mcu_as_sc_mcu7t3v3__fill_2
XFILLER_150_734 VDD VDD VSS VSS gf180mcu_as_sc_mcu7t3v3__fill_1
XFILLER_162_594 VDD VDD VSS VSS gf180mcu_as_sc_mcu7t3v3__fill_1
Xinput100 VDD VDD VSS VSS ne_in[22] _5857_/D gf180mcu_as_sc_mcu7t3v3__buff_12
Xinput111 VDD VDD VSS VSS ne_in[32] _5939_/D gf180mcu_as_sc_mcu7t3v3__buff_12
Xinput122 VDD VDD VSS VSS north_in[0] _5673_/B gf180mcu_as_sc_mcu7t3v3__buff_12
Xinput133 VDD VDD VSS VSS north_in[1] wire1018/A gf180mcu_as_sc_mcu7t3v3__buff_12
Xinput144 VDD VDD VSS VSS north_in[2] wire1017/A gf180mcu_as_sc_mcu7t3v3__buff_12
Xinput155 VDD VDD VSS VSS north_in[7] _5732_/B gf180mcu_as_sc_mcu7t3v3__buff_12
Xinput166 VDD VDD VSS VSS nw_in[17] _5817_/A gf180mcu_as_sc_mcu7t3v3__buff_12
Xinput177 VDD VDD VSS VSS nw_in[27] _5900_/A gf180mcu_as_sc_mcu7t3v3__buff_12
XFILLER_5_1084 VDD VDD VSS VSS gf180mcu_as_sc_mcu7t3v3__fillcap_16
Xinput188 VDD VDD VSS VSS nw_in[4] _5710_/A gf180mcu_as_sc_mcu7t3v3__buff_12
Xinput199 VDD VDD VSS VSS se_in[13] _5786_/A gf180mcu_as_sc_mcu7t3v3__buff_12
XFILLER_17_634 VDD VDD VSS VSS gf180mcu_as_sc_mcu7t3v3__fillcap_4
XFILLER_205_702 VDD VDD VSS VSS gf180mcu_as_sc_mcu7t3v3__fillcap_4
XFILLER_217_562 VDD VDD VSS VSS gf180mcu_as_sc_mcu7t3v3__fillcap_4
XFILLER_16_166 VDD VDD VSS VSS gf180mcu_as_sc_mcu7t3v3__fillcap_4
XFILLER_205_757 VDD VDD VSS VSS gf180mcu_as_sc_mcu7t3v3__fillcap_8
XFILLER_16_188 VDD VDD VSS VSS gf180mcu_as_sc_mcu7t3v3__fillcap_8
XFILLER_177_609 VDD VDD VSS VSS gf180mcu_as_sc_mcu7t3v3__fill_2
XFILLER_32_626 VDD VDD VSS VSS gf180mcu_as_sc_mcu7t3v3__fill_1
XFILLER_188_95 VDD VDD VSS VSS gf180mcu_as_sc_mcu7t3v3__fill_2
XTAP_TAPCELL_ROW_32_1_1337 VDD VSS gf180mcu_as_sc_mcu7t3v3__tap_2
XFILLER_172_314 VDD VDD VSS VSS gf180mcu_as_sc_mcu7t3v3__fill_1
XFILLER_201_1264 VDD VDD VSS VSS gf180mcu_as_sc_mcu7t3v3__fill_1
XFILLER_8_387 VDD VDD VSS VSS gf180mcu_as_sc_mcu7t3v3__fill_2
XFILLER_172_358 VDD VDD VSS VSS gf180mcu_as_sc_mcu7t3v3__fillcap_4
XFILLER_207_69 VDD VDD VSS VSS gf180mcu_as_sc_mcu7t3v3__fill_1
X_4270_ VDD VDD VSS VSS _4362_/D _4270_/B _4270_/A _4271_/B gf180mcu_as_sc_mcu7t3v3__mux2_2
XFILLER_154_1049 VDD VDD VSS VSS gf180mcu_as_sc_mcu7t3v3__fillcap_16
X_3221_ VDD VDD VSS VSS _4072_/A _6528_/D _3358_/A gf180mcu_as_sc_mcu7t3v3__or2_2
Xclkbuf_leaf_17_clk_regs VDD VDD VSS VSS clkload1/A _6370_/CLK gf180mcu_as_sc_mcu7t3v3__clkbuff_12
X_3152_ VDD VDD VSS VSS _4225_/B _4607_/A _3154_/C gf180mcu_as_sc_mcu7t3v3__nor2b_2
XTAP_TAPCELL_ROW_185_2076 VDD VSS gf180mcu_as_sc_mcu7t3v3__tap_2
XTAP_TAPCELL_ROW_185_2065 VDD VSS gf180mcu_as_sc_mcu7t3v3__tap_2
XFILLER_228_849 VDD VDD VSS VSS gf180mcu_as_sc_mcu7t3v3__fill_1
XFILLER_208_551 VDD VDD VSS VSS gf180mcu_as_sc_mcu7t3v3__fillcap_4
XTAP_TAPCELL_ROW_11_1220 VDD VSS gf180mcu_as_sc_mcu7t3v3__tap_2
X_3083_ VDD VDD VSS VSS _5195_/A _5846_/B gf180mcu_as_sc_mcu7t3v3__inv_2
XTAP_TAPCELL_ROW_163_1673 VDD VSS gf180mcu_as_sc_mcu7t3v3__tap_2
XTAP_TAPCELL_ROW_163_1684 VDD VSS gf180mcu_as_sc_mcu7t3v3__tap_2
XFILLER_23_626 VDD VDD VSS VSS gf180mcu_as_sc_mcu7t3v3__fillcap_4
X_3985_ VDD VDD VSS VSS _4002_/C _6075_/Q _3986_/C gf180mcu_as_sc_mcu7t3v3__and2_2
XFILLER_149_834 VDD VDD VSS VSS gf180mcu_as_sc_mcu7t3v3__fillcap_16
X_5724_ VDD VDD VSS VSS _5862_/S _5724_/B _6499_/Q _5725_/C gf180mcu_as_sc_mcu7t3v3__mux2_2
XFILLER_202_1017 VDD VDD VSS VSS gf180mcu_as_sc_mcu7t3v3__fillcap_16
X_5655_ VDD VDD VSS VSS _5878_/S _5655_/B _5672_/C _5671_/B _5670_/A gf180mcu_as_sc_mcu7t3v3__nand4_2
XFILLER_15_1170 VDD VDD VSS VSS gf180mcu_as_sc_mcu7t3v3__fillcap_16
XFILLER_15_1192 VDD VDD VSS VSS gf180mcu_as_sc_mcu7t3v3__fillcap_16
XFILLER_163_314 VDD VDD VSS VSS gf180mcu_as_sc_mcu7t3v3__fillcap_16
X_4606_ VDD VDD VSS VSS _4607_/C _4606_/B _4606_/A gf180mcu_as_sc_mcu7t3v3__nand2_2
X_5586_ VDD VDD VSS VSS _5586_/B _5586_/A _6439_/D gf180mcu_as_sc_mcu7t3v3__and2_2
XFILLER_137_1214 VDD VDD VSS VSS gf180mcu_as_sc_mcu7t3v3__fill_1
XFILLER_190_177 VDD VDD VSS VSS gf180mcu_as_sc_mcu7t3v3__fillcap_4
XPHY_EDGE_ROW_110_2_Left_551 VDD VSS gf180mcu_as_sc_mcu7t3v3__tap_2
XPHY_EDGE_ROW_133_3_Left_838 VDD VSS gf180mcu_as_sc_mcu7t3v3__tap_2
X_4537_ VDD VDD VSS VSS _4537_/S _6299_/Q _6289_/Q _4538_/B gf180mcu_as_sc_mcu7t3v3__mux2_2
XFILLER_144_594 VDD VDD VSS VSS gf180mcu_as_sc_mcu7t3v3__fillcap_8
XFILLER_77_18 VDD VDD VSS VSS gf180mcu_as_sc_mcu7t3v3__fillcap_4
X_4468_ VDD VDD VSS VSS _4477_/B _4468_/A _4468_/B _4468_/C gf180mcu_as_sc_mcu7t3v3__ao21_2
Xfanout801 VDD VDD VSS VSS _4400_/B _4407_/B gf180mcu_as_sc_mcu7t3v3__buff_12
Xfanout812 VDD VDD VSS VSS _3925_/B _3897_/B gf180mcu_as_sc_mcu7t3v3__buff_12
Xfanout823 VDD VDD VSS VSS _4978_/Y _5205_/B gf180mcu_as_sc_mcu7t3v3__buff_12
X_6207_ VDD VDD VSS VSS clkload8/A _6207_/D _6207_/Q gf180mcu_as_sc_mcu7t3v3__dfxtp_2
X_3419_ VDD VDD VSS VSS _3419_/B _4455_/A _3421_/B gf180mcu_as_sc_mcu7t3v3__or2_2
Xfanout845 VDD VDD VSS VSS _4601_/D _4520_/S gf180mcu_as_sc_mcu7t3v3__buff_12
Xfanout856 VDD VDD VSS VSS fanout857/Y _4857_/B gf180mcu_as_sc_mcu7t3v3__buff_12
Xfanout867 VDD VDD VSS VSS _5973_/B _3655_/A gf180mcu_as_sc_mcu7t3v3__buff_12
X_6138_ VDD VDD VSS VSS clkload5/A _6138_/D _6138_/Q gf180mcu_as_sc_mcu7t3v3__dfxtp_2
X_4399_ VDD VDD VSS VSS _6225_/Q _4399_/B _4399_/C _6226_/Q _4400_/C gf180mcu_as_sc_mcu7t3v3__ao22_2
XTAP_TAPCELL_ROW_228_2861 VDD VSS gf180mcu_as_sc_mcu7t3v3__tap_2
XTAP_TAPCELL_ROW_228_2850 VDD VSS gf180mcu_as_sc_mcu7t3v3__tap_2
XTAP_TAPCELL_ROW_228_2872 VDD VSS gf180mcu_as_sc_mcu7t3v3__tap_2
XPHY_EDGE_ROW_146_1_Right_718 VDD VSS gf180mcu_as_sc_mcu7t3v3__tap_2
X_6069_ VDD VDD VSS VSS _6370_/CLK _6069_/D _6069_/Q gf180mcu_as_sc_mcu7t3v3__dfxtp_2
XTAP_TAPCELL_ROW_224_2769 VDD VSS gf180mcu_as_sc_mcu7t3v3__tap_2
XFILLER_172_6 VDD VDD VSS VSS gf180mcu_as_sc_mcu7t3v3__fillcap_16
XFILLER_227_882 VDD VDD VSS VSS gf180mcu_as_sc_mcu7t3v3__fill_2
XFILLER_198_200 VDD VDD VSS VSS gf180mcu_as_sc_mcu7t3v3__fill_2
XFILLER_226_370 VDD VDD VSS VSS gf180mcu_as_sc_mcu7t3v3__fill_1
XFILLER_183_1234 VDD VDD VSS VSS gf180mcu_as_sc_mcu7t3v3__fill_1
XFILLER_198_244 VDD VDD VSS VSS gf180mcu_as_sc_mcu7t3v3__fill_1
XFILLER_13_136 VDD VDD VSS VSS gf180mcu_as_sc_mcu7t3v3__fillcap_4
XFILLER_13_158 VDD VDD VSS VSS gf180mcu_as_sc_mcu7t3v3__fillcap_16
XFILLER_186_406 VDD VDD VSS VSS gf180mcu_as_sc_mcu7t3v3__fill_2
XFILLER_187_929 VDD VDD VSS VSS gf180mcu_as_sc_mcu7t3v3__fillcap_4
XFILLER_198_277 VDD VDD VSS VSS gf180mcu_as_sc_mcu7t3v3__fillcap_4
XPHY_EDGE_ROW_129_2_Right_966 VDD VSS gf180mcu_as_sc_mcu7t3v3__tap_2
XTAP_TAPCELL_ROW_81_2_2970 VDD VSS gf180mcu_as_sc_mcu7t3v3__tap_2
XFILLER_155_815 VDD VDD VSS VSS gf180mcu_as_sc_mcu7t3v3__fillcap_8
XFILLER_194_472 VDD VDD VSS VSS gf180mcu_as_sc_mcu7t3v3__fillcap_16
XFILLER_170_807 VDD VDD VSS VSS gf180mcu_as_sc_mcu7t3v3__fill_1
XPHY_EDGE_ROW_42_2_Left_483 VDD VSS gf180mcu_as_sc_mcu7t3v3__tap_2
XFILLER_154_369 VDD VDD VSS VSS gf180mcu_as_sc_mcu7t3v3__fillcap_16
XPHY_EDGE_ROW_64_3_Right_144 VDD VSS gf180mcu_as_sc_mcu7t3v3__tap_2
XFILLER_135_594 VDD VDD VSS VSS gf180mcu_as_sc_mcu7t3v3__fillcap_8
XFILLER_150_531 VDD VDD VSS VSS gf180mcu_as_sc_mcu7t3v3__fill_2
XFILLER_174_53 VDD VDD VSS VSS gf180mcu_as_sc_mcu7t3v3__fillcap_16
XFILLER_190_1205 VDD VDD VSS VSS gf180mcu_as_sc_mcu7t3v3__fillcap_16
XFILLER_190_1227 VDD VDD VSS VSS gf180mcu_as_sc_mcu7t3v3__fillcap_8
XFILLER_150_597 VDD VDD VSS VSS gf180mcu_as_sc_mcu7t3v3__fillcap_8
XFILLER_3_59 VDD VDD VSS VSS gf180mcu_as_sc_mcu7t3v3__fillcap_8
XFILLER_190_85 VDD VDD VSS VSS gf180mcu_as_sc_mcu7t3v3__fillcap_16
XTAP_TAPCELL_ROW_8_1163 VDD VSS gf180mcu_as_sc_mcu7t3v3__tap_2
XTAP_TAPCELL_ROW_8_1152 VDD VSS gf180mcu_as_sc_mcu7t3v3__tap_2
XFILLER_188_1189 VDD VDD VSS VSS gf180mcu_as_sc_mcu7t3v3__fillcap_16
XFILLER_199_72 VDD VDD VSS VSS gf180mcu_as_sc_mcu7t3v3__fillcap_16
XPHY_EDGE_ROW_106_1_Left_334 VDD VSS gf180mcu_as_sc_mcu7t3v3__tap_2
XFILLER_20_629 VDD VDD VSS VSS gf180mcu_as_sc_mcu7t3v3__fillcap_16
X_3770_ VDD VDD VSS VSS _5769_/A _3892_/B _3865_/B _3770_/D _3772_/A gf180mcu_as_sc_mcu7t3v3__ao211_2
XFILLER_158_664 VDD VDD VSS VSS gf180mcu_as_sc_mcu7t3v3__fill_1
XFILLER_157_174 VDD VDD VSS VSS gf180mcu_as_sc_mcu7t3v3__fillcap_16
XFILLER_158_697 VDD VDD VSS VSS gf180mcu_as_sc_mcu7t3v3__fillcap_16
XFILLER_186_995 VDD VDD VSS VSS gf180mcu_as_sc_mcu7t3v3__fillcap_16
X_5440_ VDD VDD VSS VSS _5448_/A _5497_/B _5754_/A gf180mcu_as_sc_mcu7t3v3__nand2_2
XFILLER_195_1116 VDD VDD VSS VSS gf180mcu_as_sc_mcu7t3v3__fillcap_4
XFILLER_195_1138 VDD VDD VSS VSS gf180mcu_as_sc_mcu7t3v3__fillcap_16
XFILLER_160_317 VDD VDD VSS VSS gf180mcu_as_sc_mcu7t3v3__fillcap_16
XFILLER_172_155 VDD VDD VSS VSS gf180mcu_as_sc_mcu7t3v3__fillcap_16
XFILLER_172_177 VDD VDD VSS VSS gf180mcu_as_sc_mcu7t3v3__fill_1
XFILLER_173_689 VDD VDD VSS VSS gf180mcu_as_sc_mcu7t3v3__fill_2
Xoutput426 VDD VDD VSS VSS _6393_/Q south_out[16] gf180mcu_as_sc_mcu7t3v3__buff_12
Xoutput415 VDD VDD VSS VSS _6347_/Q north_out[6] gf180mcu_as_sc_mcu7t3v3__buff_12
Xoutput404 VDD VDD VSS VSS _6370_/Q north_out[29] gf180mcu_as_sc_mcu7t3v3__buff_12
X_5371_ VDD VDD VSS VSS _5568_/C _5678_/A _5371_/A _5372_/A gf180mcu_as_sc_mcu7t3v3__mux2_2
XTAP_TAPCELL_ROW_187_2105 VDD VSS gf180mcu_as_sc_mcu7t3v3__tap_2
XFILLER_126_594 VDD VDD VSS VSS gf180mcu_as_sc_mcu7t3v3__fillcap_16
Xoutput459 VDD VDD VSS VSS _6462_/Q west_out[13] gf180mcu_as_sc_mcu7t3v3__buff_12
Xoutput448 VDD VDD VSS VSS _6380_/Q south_out[3] gf180mcu_as_sc_mcu7t3v3__buff_12
Xoutput437 VDD VDD VSS VSS _6403_/Q south_out[26] gf180mcu_as_sc_mcu7t3v3__buff_12
X_4322_ VDD VDD VSS VSS _6214_/Q _4336_/B _4336_/C _6215_/Q _4323_/C gf180mcu_as_sc_mcu7t3v3__ao22_2
XTAP_TAPCELL_ROW_187_2116 VDD VSS gf180mcu_as_sc_mcu7t3v3__tap_2
X_4253_ VDD VDD VSS VSS _4370_/S _6047_/Q _6076_/Q _4254_/B gf180mcu_as_sc_mcu7t3v3__mux2_2
X_3204_ VDD VDD VSS VSS _3361_/B _6136_/Q _6137_/Q gf180mcu_as_sc_mcu7t3v3__nor2_2
XTAP_TAPCELL_ROW_165_1713 VDD VSS gf180mcu_as_sc_mcu7t3v3__tap_2
X_4184_ VDD VDD VSS VSS _4230_/B _4184_/B _4337_/B _6715_/A _4185_/D gf180mcu_as_sc_mcu7t3v3__ao22_2
X_3135_ VDD VDD VSS VSS _4566_/A _3136_/B _3136_/C _3391_/B _3136_/D gf180mcu_as_sc_mcu7t3v3__aoi31_2
XTAP_TAPCELL_ROW_206_2444 VDD VSS gf180mcu_as_sc_mcu7t3v3__tap_2
XFILLER_103_27 VDD VDD VSS VSS gf180mcu_as_sc_mcu7t3v3__fillcap_16
X_3066_ VDD VDD VSS VSS _5029_/A _5700_/A gf180mcu_as_sc_mcu7t3v3__inv_2
XTAP_TAPCELL_ROW_206_2455 VDD VSS gf180mcu_as_sc_mcu7t3v3__tap_2
XPHY_EDGE_ROW_38_1_Left_266 VDD VSS gf180mcu_as_sc_mcu7t3v3__tap_2
XPHY_EDGE_ROW_70_1_Right_642 VDD VSS gf180mcu_as_sc_mcu7t3v3__tap_2
XFILLER_11_629 VDD VDD VSS VSS gf180mcu_as_sc_mcu7t3v3__fill_1
XFILLER_177_940 VDD VDD VSS VSS gf180mcu_as_sc_mcu7t3v3__fill_2
XFILLER_17_1210 VDD VDD VSS VSS gf180mcu_as_sc_mcu7t3v3__fillcap_16
X_3968_ VDD VDD VSS VSS _3968_/D _4051_/A _4049_/B _3974_/D _6065_/D gf180mcu_as_sc_mcu7t3v3__ao31_2
XFILLER_10_139 VDD VDD VSS VSS gf180mcu_as_sc_mcu7t3v3__fillcap_16
Xwire509 VDD VDD VSS VSS _3340_/Y wire509/Y gf180mcu_as_sc_mcu7t3v3__clkbuff_12
X_5707_ VDD VDD VSS VSS _5798_/S _5707_/B _6497_/Q _5708_/C gf180mcu_as_sc_mcu7t3v3__mux2_2
XFILLER_164_601 VDD VDD VSS VSS gf180mcu_as_sc_mcu7t3v3__fill_2
XPHY_EDGE_ROW_53_2_Right_890 VDD VSS gf180mcu_as_sc_mcu7t3v3__tap_2
X_3899_ VDD VDD VSS VSS _5879_/A _3925_/C _3899_/C _3899_/D _3901_/C gf180mcu_as_sc_mcu7t3v3__ao211_2
XFILLER_191_431 VDD VDD VSS VSS gf180mcu_as_sc_mcu7t3v3__fill_1
X_5638_ VDD VDD VSS VSS _6524_/Q _5638_/B _5638_/C _5950_/D _5639_/D gf180mcu_as_sc_mcu7t3v3__ao22_2
XFILLER_152_818 VDD VDD VSS VSS gf180mcu_as_sc_mcu7t3v3__fillcap_4
XFILLER_164_678 VDD VDD VSS VSS gf180mcu_as_sc_mcu7t3v3__fill_2
XFILLER_191_475 VDD VDD VSS VSS gf180mcu_as_sc_mcu7t3v3__fillcap_4
X_5569_ VDD VDD VSS VSS _5874_/A _5569_/B _5569_/C _5569_/D _5570_/B gf180mcu_as_sc_mcu7t3v3__ao211_2
XFILLER_117_594 VDD VDD VSS VSS gf180mcu_as_sc_mcu7t3v3__fill_1
XFILLER_3_839 VDD VDD VSS VSS gf180mcu_as_sc_mcu7t3v3__fill_1
XFILLER_215_1208 VDD VDD VSS VSS gf180mcu_as_sc_mcu7t3v3__fillcap_16
XFILLER_144_34 VDD VDD VSS VSS gf180mcu_as_sc_mcu7t3v3__fill_1
XFILLER_144_45 VDD VDD VSS VSS gf180mcu_as_sc_mcu7t3v3__fillcap_4
Xfanout620 VDD VDD VSS VSS _5842_/B _5802_/B gf180mcu_as_sc_mcu7t3v3__buff_12
Xfanout631 VDD VDD VSS VSS _4842_/B _4795_/B gf180mcu_as_sc_mcu7t3v3__buff_12
Xfanout642 VDD VDD VSS VSS _3910_/B _3930_/B gf180mcu_as_sc_mcu7t3v3__buff_12
XTAP_TAPCELL_ROW_226_2809 VDD VSS gf180mcu_as_sc_mcu7t3v3__tap_2
Xfanout653 VDD VDD VSS VSS _5922_/B _5871_/B gf180mcu_as_sc_mcu7t3v3__buff_12
Xfanout664 VDD VDD VSS VSS _5946_/C _5873_/B gf180mcu_as_sc_mcu7t3v3__buff_12
Xfanout675 VDD VDD VSS VSS _5535_/B _5494_/B gf180mcu_as_sc_mcu7t3v3__buff_12
Xfanout686 VDD VDD VSS VSS _4995_/Y _5188_/C gf180mcu_as_sc_mcu7t3v3__buff_12
Xfanout697 VDD VDD VSS VSS _4241_/Y _4336_/C gf180mcu_as_sc_mcu7t3v3__buff_12
XFILLER_37_43 VDD VDD VSS VSS gf180mcu_as_sc_mcu7t3v3__fillcap_8
XFILLER_2_1065 VDD VDD VSS VSS gf180mcu_as_sc_mcu7t3v3__fillcap_16
XPHY_EDGE_ROW_147_1_Right_719 VDD VSS gf180mcu_as_sc_mcu7t3v3__tap_2
XFILLER_199_531 VDD VDD VSS VSS gf180mcu_as_sc_mcu7t3v3__fill_2
XFILLER_2_1087 VDD VDD VSS VSS gf180mcu_as_sc_mcu7t3v3__fillcap_16
XTAP_TAPCELL_ROW_3_1071 VDD VSS gf180mcu_as_sc_mcu7t3v3__tap_2
XTAP_TAPCELL_ROW_3_1060 VDD VSS gf180mcu_as_sc_mcu7t3v3__tap_2
XFILLER_202_524 VDD VDD VSS VSS gf180mcu_as_sc_mcu7t3v3__fill_1
XFILLER_70_1212 VDD VDD VSS VSS gf180mcu_as_sc_mcu7t3v3__fill_1
XFILLER_186_247 VDD VDD VSS VSS gf180mcu_as_sc_mcu7t3v3__fillcap_4
XFILLER_10_695 VDD VDD VSS VSS gf180mcu_as_sc_mcu7t3v3__fill_1
XFILLER_154_155 VDD VDD VSS VSS gf180mcu_as_sc_mcu7t3v3__fillcap_16
XFILLER_154_177 VDD VDD VSS VSS gf180mcu_as_sc_mcu7t3v3__fillcap_16
XFILLER_183_998 VDD VDD VSS VSS gf180mcu_as_sc_mcu7t3v3__fillcap_4
XFILLER_155_1100 VDD VDD VSS VSS gf180mcu_as_sc_mcu7t3v3__fillcap_16
XPHY_EDGE_ROW_65_3_Right_145 VDD VSS gf180mcu_as_sc_mcu7t3v3__tap_2
XFILLER_155_1122 VDD VDD VSS VSS gf180mcu_as_sc_mcu7t3v3__fillcap_16
XFILLER_190_1013 VDD VDD VSS VSS gf180mcu_as_sc_mcu7t3v3__fill_2
XFILLER_2_850 VDD VDD VSS VSS gf180mcu_as_sc_mcu7t3v3__fillcap_4
XFILLER_9_1208 VDD VDD VSS VSS gf180mcu_as_sc_mcu7t3v3__fillcap_16
XFILLER_1_360 VDD VDD VSS VSS gf180mcu_as_sc_mcu7t3v3__fill_1
XTAP_TAPCELL_ROW_182_2024 VDD VSS gf180mcu_as_sc_mcu7t3v3__tap_2
XTAP_TAPCELL_ROW_182_2013 VDD VSS gf180mcu_as_sc_mcu7t3v3__tap_2
XFILLER_204_37 VDD VDD VSS VSS gf180mcu_as_sc_mcu7t3v3__fillcap_16
XFILLER_225_627 VDD VDD VSS VSS gf180mcu_as_sc_mcu7t3v3__fill_2
Xmesh_tile_1052 VDD VDD VSS VSS ne_out[11] gf180mcu_as_sc_mcu7t3v3__tiel_4
XFILLER_92_665 VDD VDD VSS VSS gf180mcu_as_sc_mcu7t3v3__fill_2
XTAP_TAPCELL_ROW_160_1621 VDD VSS gf180mcu_as_sc_mcu7t3v3__tap_2
Xmesh_tile_1096 VDD VDD VSS VSS nw_out[19] gf180mcu_as_sc_mcu7t3v3__tiel_4
Xmesh_tile_1085 VDD VDD VSS VSS nw_out[8] gf180mcu_as_sc_mcu7t3v3__tiel_4
Xmesh_tile_1074 VDD VDD VSS VSS ne_out[33] gf180mcu_as_sc_mcu7t3v3__tiel_4
Xmesh_tile_1063 VDD VDD VSS VSS ne_out[22] gf180mcu_as_sc_mcu7t3v3__tiel_4
X_4940_ VDD VDD VSS VSS _4941_/D _4940_/C _4948_/B _5340_/B gf180mcu_as_sc_mcu7t3v3__aoi21_2
XFILLER_220_69 VDD VDD VSS VSS gf180mcu_as_sc_mcu7t3v3__fillcap_16
X_4871_ VDD VDD VSS VSS _5865_/A _4871_/B _4871_/C _5865_/D _4872_/D gf180mcu_as_sc_mcu7t3v3__ao22_2
XTAP_TAPCELL_ROW_201_2363 VDD VSS gf180mcu_as_sc_mcu7t3v3__tap_2
XTAP_TAPCELL_ROW_201_2352 VDD VSS gf180mcu_as_sc_mcu7t3v3__tap_2
XFILLER_178_737 VDD VDD VSS VSS gf180mcu_as_sc_mcu7t3v3__fill_1
X_3822_ VDD VDD VSS VSS _6510_/Q _3897_/B _3887_/B _5815_/A _3824_/C gf180mcu_as_sc_mcu7t3v3__ao22_2
X_6541_ VDD VDD VSS VSS clkload9/A _6541_/D _6541_/Q gf180mcu_as_sc_mcu7t3v3__dfxtp_2
XFILLER_201_590 VDD VDD VSS VSS gf180mcu_as_sc_mcu7t3v3__fill_2
XTAP_TAPCELL_ROW_158_1583 VDD VSS gf180mcu_as_sc_mcu7t3v3__tap_2
X_3753_ VDD VDD VSS VSS _3753_/B _3753_/A _4031_/B gf180mcu_as_sc_mcu7t3v3__and2_2
XFILLER_192_239 VDD VDD VSS VSS gf180mcu_as_sc_mcu7t3v3__fillcap_4
XTAP_TAPCELL_ROW_158_1594 VDD VSS gf180mcu_as_sc_mcu7t3v3__tap_2
X_6472_ VDD VDD VSS VSS _6474_/CLK _6472_/D _6472_/Q gf180mcu_as_sc_mcu7t3v3__dfxtp_2
X_3684_ VDD VDD VSS VSS _3808_/B _5693_/A _3685_/D gf180mcu_as_sc_mcu7t3v3__and2_2
XFILLER_12_1151 VDD VDD VSS VSS gf180mcu_as_sc_mcu7t3v3__fillcap_4
XFILLER_12_1173 VDD VDD VSS VSS gf180mcu_as_sc_mcu7t3v3__fillcap_16
X_5423_ VDD VDD VSS VSS _5551_/B _5735_/D _5427_/C gf180mcu_as_sc_mcu7t3v3__and2_2
XFILLER_47_1214 VDD VDD VSS VSS gf180mcu_as_sc_mcu7t3v3__fill_1
Xclkbuf_leaf_32_clk_regs VDD VDD VSS VSS clkbuf_3_6_0_clk_regs/Y _6422_/CLK gf180mcu_as_sc_mcu7t3v3__clkbuff_12
X_5354_ VDD VDD VSS VSS _5354_/A _5661_/A _5354_/C _5661_/B _5358_/C gf180mcu_as_sc_mcu7t3v3__nand4_2
XFILLER_0_809 VDD VDD VSS VSS gf180mcu_as_sc_mcu7t3v3__fillcap_4
XPHY_EDGE_ROW_206_Left_434 VDD VSS gf180mcu_as_sc_mcu7t3v3__tap_2
X_4305_ VDD VDD VSS VSS _4306_/C _4342_/S _6025_/Q gf180mcu_as_sc_mcu7t3v3__nor2b_2
X_5285_ VDD VDD VSS VSS _5301_/S _5929_/A _5931_/A _5286_/D gf180mcu_as_sc_mcu7t3v3__mux2_2
XFILLER_228_410 VDD VDD VSS VSS gf180mcu_as_sc_mcu7t3v3__fillcap_4
X_4236_ VDD VDD VSS VSS _4236_/A _4236_/B _4236_/C _5979_/A gf180mcu_as_sc_mcu7t3v3__nand3_2
XFILLER_114_37 VDD VDD VSS VSS gf180mcu_as_sc_mcu7t3v3__fillcap_8
XFILLER_214_1263 VDD VDD VSS VSS gf180mcu_as_sc_mcu7t3v3__fill_2
X_4167_ VDD VDD VSS VSS _6188_/Q _6187_/Q _4167_/C _4170_/B gf180mcu_as_sc_mcu7t3v3__nor3_2
X_3118_ VDD VDD VSS VSS _3172_/A _4509_/B _3121_/C gf180mcu_as_sc_mcu7t3v3__or2_2
XTAP_TAPCELL_ROW_221_2717 VDD VSS gf180mcu_as_sc_mcu7t3v3__tap_2
XFILLER_215_104 VDD VDD VSS VSS gf180mcu_as_sc_mcu7t3v3__fillcap_8
X_4098_ VDD VDD VSS VSS _4098_/S _6719_/A _6158_/Q _6158_/D gf180mcu_as_sc_mcu7t3v3__mux2_2
XTAP_TAPCELL_ROW_221_2728 VDD VSS gf180mcu_as_sc_mcu7t3v3__tap_2
XFILLER_110_1261 VDD VDD VSS VSS gf180mcu_as_sc_mcu7t3v3__fillcap_4
XFILLER_167_1048 VDD VDD VSS VSS gf180mcu_as_sc_mcu7t3v3__fill_2
XFILLER_93_1212 VDD VDD VSS VSS gf180mcu_as_sc_mcu7t3v3__fill_1
X_3049_ VDD VDD VSS VSS _4511_/A _4539_/A gf180mcu_as_sc_mcu7t3v3__inv_2
XFILLER_224_682 VDD VDD VSS VSS gf180mcu_as_sc_mcu7t3v3__fill_1
XPHY_EDGE_ROW_215_Left_443 VDD VSS gf180mcu_as_sc_mcu7t3v3__tap_2
XPHY_EDGE_ROW_71_1_Right_643 VDD VSS gf180mcu_as_sc_mcu7t3v3__tap_2
XFILLER_168_225 VDD VDD VSS VSS gf180mcu_as_sc_mcu7t3v3__fill_1
XFILLER_196_523 VDD VDD VSS VSS gf180mcu_as_sc_mcu7t3v3__fill_2
XTAP_TAPCELL_ROW_178_1948 VDD VSS gf180mcu_as_sc_mcu7t3v3__tap_2
XTAP_TAPCELL_ROW_178_1937 VDD VSS gf180mcu_as_sc_mcu7t3v3__tap_2
XFILLER_180_1259 VDD VDD VSS VSS gf180mcu_as_sc_mcu7t3v3__fillcap_4
XFILLER_8_909 VDD VDD VSS VSS gf180mcu_as_sc_mcu7t3v3__fillcap_16
XFILLER_149_450 VDD VDD VSS VSS gf180mcu_as_sc_mcu7t3v3__fill_1
XTAP_TAPCELL_ROW_219_2679 VDD VSS gf180mcu_as_sc_mcu7t3v3__tap_2
XFILLER_221_1256 VDD VDD VSS VSS gf180mcu_as_sc_mcu7t3v3__fillcap_4
XFILLER_99_27 VDD VDD VSS VSS gf180mcu_as_sc_mcu7t3v3__fillcap_16
XPHY_EDGE_ROW_54_2_Right_891 VDD VSS gf180mcu_as_sc_mcu7t3v3__tap_2
XFILLER_180_902 VDD VDD VSS VSS gf180mcu_as_sc_mcu7t3v3__fill_2
XFILLER_152_637 VDD VDD VSS VSS gf180mcu_as_sc_mcu7t3v3__fill_1
XFILLER_155_22 VDD VDD VSS VSS gf180mcu_as_sc_mcu7t3v3__fillcap_16
XFILLER_191_272 VDD VDD VSS VSS gf180mcu_as_sc_mcu7t3v3__fillcap_8
XPHY_EDGE_ROW_224_Left_452 VDD VSS gf180mcu_as_sc_mcu7t3v3__tap_2
XFILLER_151_136 VDD VDD VSS VSS gf180mcu_as_sc_mcu7t3v3__fillcap_4
XFILLER_151_158 VDD VDD VSS VSS gf180mcu_as_sc_mcu7t3v3__fillcap_16
XFILLER_155_88 VDD VDD VSS VSS gf180mcu_as_sc_mcu7t3v3__fillcap_16
XFILLER_59_640 VDD VDD VSS VSS gf180mcu_as_sc_mcu7t3v3__fill_2
XFILLER_171_54 VDD VDD VSS VSS gf180mcu_as_sc_mcu7t3v3__fillcap_16
XFILLER_8_1263 VDD VDD VSS VSS gf180mcu_as_sc_mcu7t3v3__fill_2
XFILLER_207_616 VDD VDD VSS VSS gf180mcu_as_sc_mcu7t3v3__fill_2
XTAP_TAPCELL_ROW_5_1111 VDD VSS gf180mcu_as_sc_mcu7t3v3__tap_2
XTAP_TAPCELL_ROW_5_1100 VDD VSS gf180mcu_as_sc_mcu7t3v3__tap_2
XFILLER_189_1262 VDD VDD VSS VSS gf180mcu_as_sc_mcu7t3v3__fill_2
XFILLER_15_732 VDD VDD VSS VSS gf180mcu_as_sc_mcu7t3v3__fillcap_8
XFILLER_187_512 VDD VDD VSS VSS gf180mcu_as_sc_mcu7t3v3__fillcap_4
XFILLER_15_798 VDD VDD VSS VSS gf180mcu_as_sc_mcu7t3v3__fillcap_16
XFILLER_226_1189 VDD VDD VSS VSS gf180mcu_as_sc_mcu7t3v3__fillcap_16
XFILLER_11_960 VDD VDD VSS VSS gf180mcu_as_sc_mcu7t3v3__fillcap_16
XFILLER_161_1170 VDD VDD VSS VSS gf180mcu_as_sc_mcu7t3v3__fillcap_16
XFILLER_202_387 VDD VDD VSS VSS gf180mcu_as_sc_mcu7t3v3__fillcap_16
XFILLER_11_982 VDD VDD VSS VSS gf180mcu_as_sc_mcu7t3v3__fillcap_16
XFILLER_128_645 VDD VDD VSS VSS gf180mcu_as_sc_mcu7t3v3__fillcap_8
XFILLER_161_1192 VDD VDD VSS VSS gf180mcu_as_sc_mcu7t3v3__fillcap_16
XFILLER_168_792 VDD VDD VSS VSS gf180mcu_as_sc_mcu7t3v3__fill_2
XFILLER_196_1255 VDD VDD VSS VSS gf180mcu_as_sc_mcu7t3v3__fillcap_8
XFILLER_182_294 VDD VDD VSS VSS gf180mcu_as_sc_mcu7t3v3__fillcap_4
XFILLER_192_1119 VDD VDD VSS VSS gf180mcu_as_sc_mcu7t3v3__fillcap_16
XFILLER_143_659 VDD VDD VSS VSS gf180mcu_as_sc_mcu7t3v3__fill_2
XPHY_EDGE_ROW_66_3_Right_146 VDD VSS gf180mcu_as_sc_mcu7t3v3__tap_2
XTAP_TAPCELL_ROW_153_1491 VDD VSS gf180mcu_as_sc_mcu7t3v3__tap_2
XFILLER_151_670 VDD VDD VSS VSS gf180mcu_as_sc_mcu7t3v3__fillcap_16
X_5070_ VDD VDD VSS VSS _5207_/B _5735_/A _5070_/A _5071_/C gf180mcu_as_sc_mcu7t3v3__mux2_2
XFILLER_215_69 VDD VDD VSS VSS gf180mcu_as_sc_mcu7t3v3__fill_1
X_4021_ VDD VDD VSS VSS _6104_/D _4021_/C _4029_/C _4021_/A gf180mcu_as_sc_mcu7t3v3__ao21b_2
XFILLER_65_643 VDD VDD VSS VSS gf180mcu_as_sc_mcu7t3v3__fill_2
XTAP_TAPCELL_ROW_203_2403 VDD VSS gf180mcu_as_sc_mcu7t3v3__tap_2
X_5972_ VDD VDD VSS VSS _6490_/D _5972_/C _5972_/B _5972_/A gf180mcu_as_sc_mcu7t3v3__aoi21_2
XFILLER_178_501 VDD VDD VSS VSS gf180mcu_as_sc_mcu7t3v3__fill_2
XPHY_EDGE_ROW_142_3_Left_847 VDD VSS gf180mcu_as_sc_mcu7t3v3__tap_2
X_4923_ VDD VDD VSS VSS _5912_/A _4953_/B _4953_/C _5912_/D _4924_/D gf180mcu_as_sc_mcu7t3v3__ao22_2
XFILLER_166_1081 VDD VDD VSS VSS gf180mcu_as_sc_mcu7t3v3__fillcap_4
XTAP_TAPCELL_ROW_195_2259 VDD VSS gf180mcu_as_sc_mcu7t3v3__tap_2
XTAP_TAPCELL_ROW_195_2248 VDD VSS gf180mcu_as_sc_mcu7t3v3__tap_2
XFILLER_178_567 VDD VDD VSS VSS gf180mcu_as_sc_mcu7t3v3__fill_2
X_4854_ VDD VDD VSS VSS _5925_/D _4883_/A _4854_/B _4854_/C _4855_/C gf180mcu_as_sc_mcu7t3v3__ao31_2
XFILLER_119_612 VDD VDD VSS VSS gf180mcu_as_sc_mcu7t3v3__fill_1
XFILLER_140_1210 VDD VDD VSS VSS gf180mcu_as_sc_mcu7t3v3__fillcap_16
XFILLER_220_173 VDD VDD VSS VSS gf180mcu_as_sc_mcu7t3v3__fill_2
X_4785_ VDD VDD VSS VSS _4794_/S _4785_/B _6507_/Q _4787_/C gf180mcu_as_sc_mcu7t3v3__mux2_2
X_3805_ VDD VDD VSS VSS _5797_/A _3805_/B _3805_/C _3805_/D _3806_/A gf180mcu_as_sc_mcu7t3v3__ao211_2
X_6524_ VDD VDD VSS VSS _6525_/CLK _6524_/D _6524_/Q gf180mcu_as_sc_mcu7t3v3__dfxtp_2
X_3736_ VDD VDD VSS VSS _3738_/C _5742_/A _3757_/B _3736_/C gf180mcu_as_sc_mcu7t3v3__ao21_2
XTAP_TAPCELL_ROW_173_1856 VDD VSS gf180mcu_as_sc_mcu7t3v3__tap_2
XFILLER_161_412 VDD VDD VSS VSS gf180mcu_as_sc_mcu7t3v3__fillcap_4
XFILLER_161_434 VDD VDD VSS VSS gf180mcu_as_sc_mcu7t3v3__fill_2
X_6455_ VDD VDD VSS VSS _6474_/CLK _6455_/D _6455_/Q gf180mcu_as_sc_mcu7t3v3__dfxtp_2
X_3667_ VDD VDD VSS VSS _6486_/Q _5958_/A _4053_/A _3667_/Y _5972_/C gf180mcu_as_sc_mcu7t3v3__aoi31_2
XTAP_TAPCELL_ROW_214_2598 VDD VSS gf180mcu_as_sc_mcu7t3v3__tap_2
XTAP_TAPCELL_ROW_214_2587 VDD VSS gf180mcu_as_sc_mcu7t3v3__tap_2
X_6386_ VDD VDD VSS VSS clkload3/A _6386_/D _6386_/Q gf180mcu_as_sc_mcu7t3v3__dfxtp_2
X_5406_ VDD VDD VSS VSS _6498_/Q _5490_/B _5491_/B _5717_/A _5407_/C gf180mcu_as_sc_mcu7t3v3__ao22_2
X_3598_ VDD VDD VSS VSS _3607_/A _3598_/B _5921_/A gf180mcu_as_sc_mcu7t3v3__nand2b_2
XFILLER_161_489 VDD VDD VSS VSS gf180mcu_as_sc_mcu7t3v3__fill_1
XFILLER_173_1041 VDD VDD VSS VSS gf180mcu_as_sc_mcu7t3v3__fillcap_8
XFILLER_173_1052 VDD VDD VSS VSS gf180mcu_as_sc_mcu7t3v3__fillcap_16
X_5337_ VDD VDD VSS VSS _5652_/C _5652_/D _5337_/C _5337_/D _5365_/C gf180mcu_as_sc_mcu7t3v3__nand4_2
X_5268_ VDD VDD VSS VSS _5268_/B _5291_/A _6405_/D gf180mcu_as_sc_mcu7t3v3__and2_2
XFILLER_85_18 VDD VDD VSS VSS gf180mcu_as_sc_mcu7t3v3__fillcap_4
X_4219_ VDD VDD VSS VSS _4349_/S _6073_/Q _6102_/Q _4220_/B gf180mcu_as_sc_mcu7t3v3__mux2_2
XFILLER_18_34 VDD VDD VSS VSS gf180mcu_as_sc_mcu7t3v3__fill_1
XFILLER_228_240 VDD VDD VSS VSS gf180mcu_as_sc_mcu7t3v3__fillcap_4
X_5199_ VDD VDD VSS VSS _5200_/A _5850_/A _5308_/B _5199_/C gf180mcu_as_sc_mcu7t3v3__ao21_2
XFILLER_141_46 VDD VDD VSS VSS gf180mcu_as_sc_mcu7t3v3__fillcap_4
XFILLER_18_45 VDD VDD VSS VSS gf180mcu_as_sc_mcu7t3v3__fillcap_4
XFILLER_216_468 VDD VDD VSS VSS gf180mcu_as_sc_mcu7t3v3__fill_2
XPHY_EDGE_ROW_74_3_Left_779 VDD VSS gf180mcu_as_sc_mcu7t3v3__tap_2
XPHY_EDGE_ROW_51_2_Left_492 VDD VSS gf180mcu_as_sc_mcu7t3v3__tap_2
XFILLER_180_1012 VDD VDD VSS VSS gf180mcu_as_sc_mcu7t3v3__fill_2
XFILLER_11_212 VDD VDD VSS VSS gf180mcu_as_sc_mcu7t3v3__fillcap_16
XFILLER_212_663 VDD VDD VSS VSS gf180mcu_as_sc_mcu7t3v3__fill_2
XPHY_EDGE_ROW_72_1_Right_644 VDD VSS gf180mcu_as_sc_mcu7t3v3__tap_2
XFILLER_153_902 VDD VDD VSS VSS gf180mcu_as_sc_mcu7t3v3__fill_2
XPHY_EDGE_ROW_55_2_Right_892 VDD VSS gf180mcu_as_sc_mcu7t3v3__tap_2
XPHY_EDGE_ROW_202_Right_70 VDD VSS gf180mcu_as_sc_mcu7t3v3__tap_2
XFILLER_153_968 VDD VDD VSS VSS gf180mcu_as_sc_mcu7t3v3__fillcap_8
XFILLER_140_629 VDD VDD VSS VSS gf180mcu_as_sc_mcu7t3v3__fillcap_16
XFILLER_152_1103 VDD VDD VSS VSS gf180mcu_as_sc_mcu7t3v3__fillcap_16
XFILLER_156_1261 VDD VDD VSS VSS gf180mcu_as_sc_mcu7t3v3__fillcap_4
XFILLER_117_1234 VDD VDD VSS VSS gf180mcu_as_sc_mcu7t3v3__fillcap_4
XPHY_EDGE_ROW_115_1_Left_343 VDD VSS gf180mcu_as_sc_mcu7t3v3__tap_2
XFILLER_208_947 VDD VDD VSS VSS gf180mcu_as_sc_mcu7t3v3__fillcap_16
XFILLER_15_562 VDD VDD VSS VSS gf180mcu_as_sc_mcu7t3v3__fill_2
XFILLER_188_832 VDD VDD VSS VSS gf180mcu_as_sc_mcu7t3v3__fillcap_4
XFILLER_201_49 VDD VDD VSS VSS gf180mcu_as_sc_mcu7t3v3__fillcap_16
XFILLER_175_515 VDD VDD VSS VSS gf180mcu_as_sc_mcu7t3v3__fill_2
XFILLER_202_195 VDD VDD VSS VSS gf180mcu_as_sc_mcu7t3v3__fillcap_4
XTAP_TAPCELL_ROW_155_1531 VDD VSS gf180mcu_as_sc_mcu7t3v3__tap_2
X_4570_ VDD VDD VSS VSS _4570_/B _4570_/A _4572_/B gf180mcu_as_sc_mcu7t3v3__or2_2
XTAP_TAPCELL_ROW_190_2156 VDD VSS gf180mcu_as_sc_mcu7t3v3__tap_2
XFILLER_162_209 VDD VDD VSS VSS gf180mcu_as_sc_mcu7t3v3__fillcap_16
X_3521_ VDD VDD VSS VSS _4627_/A _4627_/B _4628_/A _3521_/D _3523_/D gf180mcu_as_sc_mcu7t3v3__nand4_2
XTAP_TAPCELL_ROW_190_2167 VDD VSS gf180mcu_as_sc_mcu7t3v3__tap_2
XFILLER_116_615 VDD VDD VSS VSS gf180mcu_as_sc_mcu7t3v3__fill_1
XFILLER_157_1014 VDD VDD VSS VSS gf180mcu_as_sc_mcu7t3v3__fillcap_16
XFILLER_7_772 VDD VDD VSS VSS gf180mcu_as_sc_mcu7t3v3__fill_1
XFILLER_171_765 VDD VDD VSS VSS gf180mcu_as_sc_mcu7t3v3__fillcap_4
X_6240_ VDD VDD VSS VSS _6316_/CLK _6240_/D _6240_/Q gf180mcu_as_sc_mcu7t3v3__dfxtp_2
X_3452_ VDD VDD VSS VSS _6550_/D _3458_/B _6331_/Q _6330_/D gf180mcu_as_sc_mcu7t3v3__mux2_2
XFILLER_131_629 VDD VDD VSS VSS gf180mcu_as_sc_mcu7t3v3__fill_1
X_6171_ VDD VDD VSS VSS _6526_/CLK _6171_/D _6171_/Q gf180mcu_as_sc_mcu7t3v3__dfxtp_2
X_3383_ VDD VDD VSS VSS _4444_/A _4539_/A _3392_/C gf180mcu_as_sc_mcu7t3v3__and2_2
XPHY_EDGE_ROW_47_1_Left_275 VDD VSS gf180mcu_as_sc_mcu7t3v3__tap_2
XPHY_EDGE_ROW_67_3_Right_147 VDD VSS gf180mcu_as_sc_mcu7t3v3__tap_2
X_5122_ VDD VDD VSS VSS _5123_/D _5122_/C _5122_/B _5122_/A gf180mcu_as_sc_mcu7t3v3__aoi21_2
X_5053_ VDD VDD VSS VSS _5053_/B _5164_/A _6382_/D gf180mcu_as_sc_mcu7t3v3__and2_2
XTAP_TAPCELL_ROW_14_1262 VDD VSS gf180mcu_as_sc_mcu7t3v3__tap_2
XTAP_TAPCELL_ROW_14_1273 VDD VSS gf180mcu_as_sc_mcu7t3v3__tap_2
X_4004_ VDD VDD VSS VSS _4045_/B _4012_/B _4012_/C _6092_/Q _6092_/D gf180mcu_as_sc_mcu7t3v3__ao22_2
XFILLER_111_27 VDD VDD VSS VSS gf180mcu_as_sc_mcu7t3v3__fillcap_16
XFILLER_20_1261 VDD VDD VSS VSS gf180mcu_as_sc_mcu7t3v3__fillcap_4
XFILLER_213_405 VDD VDD VSS VSS gf180mcu_as_sc_mcu7t3v3__fillcap_4
XFILLER_197_139 VDD VDD VSS VSS gf180mcu_as_sc_mcu7t3v3__fill_1
XFILLER_206_490 VDD VDD VSS VSS gf180mcu_as_sc_mcu7t3v3__fillcap_16
X_5955_ VDD VDD VSS VSS _5955_/S _5955_/B _5955_/A _5956_/B gf180mcu_as_sc_mcu7t3v3__mux2_2
X_5886_ VDD VDD VSS VSS _5930_/C _5886_/B _5936_/B gf180mcu_as_sc_mcu7t3v3__nor2_2
X_4906_ VDD VDD VSS VSS _5896_/A _4963_/B _4906_/C _4932_/D _4908_/A gf180mcu_as_sc_mcu7t3v3__ao211_2
X_4837_ VDD VDD VSS VSS _4837_/B _5840_/A _4838_/C gf180mcu_as_sc_mcu7t3v3__and2_2
XFILLER_166_548 VDD VDD VSS VSS gf180mcu_as_sc_mcu7t3v3__fill_2
XTAP_TAPCELL_ROW_216_2638 VDD VSS gf180mcu_as_sc_mcu7t3v3__tap_2
XTAP_TAPCELL_ROW_216_2627 VDD VSS gf180mcu_as_sc_mcu7t3v3__tap_2
XFILLER_14_1065 VDD VDD VSS VSS gf180mcu_as_sc_mcu7t3v3__fillcap_16
X_4768_ VDD VDD VSS VSS _5778_/A _4872_/B _4768_/C _4768_/D _4769_/B gf180mcu_as_sc_mcu7t3v3__ao211_2
XFILLER_14_1087 VDD VDD VSS VSS gf180mcu_as_sc_mcu7t3v3__fillcap_16
XFILLER_162_732 VDD VDD VSS VSS gf180mcu_as_sc_mcu7t3v3__fill_2
X_6507_ VDD VDD VSS VSS _6518_/CLK _6507_/D _6507_/Q gf180mcu_as_sc_mcu7t3v3__dfxtp_2
X_4699_ VDD VDD VSS VSS _5716_/B _4784_/B _4774_/C _5717_/A _4700_/C gf180mcu_as_sc_mcu7t3v3__ao22_2
X_3719_ VDD VDD VSS VSS _5723_/A _3891_/B _3719_/C _3719_/D _3721_/C gf180mcu_as_sc_mcu7t3v3__ao211_2
XFILLER_107_648 VDD VDD VSS VSS gf180mcu_as_sc_mcu7t3v3__fillcap_8
XFILLER_162_754 VDD VDD VSS VSS gf180mcu_as_sc_mcu7t3v3__fillcap_4
XPHY_EDGE_ROW_157_Left_385 VDD VSS gf180mcu_as_sc_mcu7t3v3__tap_2
X_6438_ VDD VDD VSS VSS _6448_/CLK _6438_/D _6438_/Q gf180mcu_as_sc_mcu7t3v3__dfxtp_2
XFILLER_122_629 VDD VDD VSS VSS gf180mcu_as_sc_mcu7t3v3__fill_1
XFILLER_150_927 VDD VDD VSS VSS gf180mcu_as_sc_mcu7t3v3__fillcap_4
X_6369_ VDD VDD VSS VSS _6371_/CLK _6369_/D _6369_/Q gf180mcu_as_sc_mcu7t3v3__dfxtp_2
XFILLER_130_662 VDD VDD VSS VSS gf180mcu_as_sc_mcu7t3v3__fillcap_4
Xinput304 VDD VDD VSS VSS west_in[10] _5761_/D gf180mcu_as_sc_mcu7t3v3__buff_12
Xinput315 VDD VDD VSS VSS west_in[20] _5842_/D gf180mcu_as_sc_mcu7t3v3__buff_12
Xinput326 VDD VDD VSS VSS west_in[30] wire980/A gf180mcu_as_sc_mcu7t3v3__buff_12
XFILLER_152_34 VDD VDD VSS VSS gf180mcu_as_sc_mcu7t3v3__fill_1
Xinput337 VDD VDD VSS VSS west_in[8] _5743_/A gf180mcu_as_sc_mcu7t3v3__buff_12
XFILLER_186_1221 VDD VDD VSS VSS gf180mcu_as_sc_mcu7t3v3__fillcap_4
XFILLER_205_928 VDD VDD VSS VSS gf180mcu_as_sc_mcu7t3v3__fillcap_16
XPHY_EDGE_ROW_166_Left_394 VDD VSS gf180mcu_as_sc_mcu7t3v3__tap_2
XFILLER_147_1249 VDD VDD VSS VSS gf180mcu_as_sc_mcu7t3v3__fillcap_8
XFILLER_227_1240 VDD VDD VSS VSS gf180mcu_as_sc_mcu7t3v3__fillcap_16
XTAP_TAPCELL_ROW_0_992 VDD VSS gf180mcu_as_sc_mcu7t3v3__tap_2
XFILLER_227_1262 VDD VDD VSS VSS gf180mcu_as_sc_mcu7t3v3__fill_2
XFILLER_12_543 VDD VDD VSS VSS gf180mcu_as_sc_mcu7t3v3__fillcap_16
XFILLER_169_364 VDD VDD VSS VSS gf180mcu_as_sc_mcu7t3v3__fill_1
XFILLER_169_375 VDD VDD VSS VSS gf180mcu_as_sc_mcu7t3v3__fillcap_8
XFILLER_196_161 VDD VDD VSS VSS gf180mcu_as_sc_mcu7t3v3__fill_2
XFILLER_200_633 VDD VDD VSS VSS gf180mcu_as_sc_mcu7t3v3__fill_1
XPHY_EDGE_ROW_73_1_Right_645 VDD VSS gf180mcu_as_sc_mcu7t3v3__tap_2
XTAP_TAPCELL_ROW_140_3_3059 VDD VSS gf180mcu_as_sc_mcu7t3v3__tap_2
XANTENNA_8 VDD VDD VSS VSS _6479_/D gf180mcu_as_sc_mcu7t3v3__diode_2
XFILLER_6_37 VDD VDD VSS VSS gf180mcu_as_sc_mcu7t3v3__fillcap_16
XPHY_EDGE_ROW_56_2_Right_893 VDD VSS gf180mcu_as_sc_mcu7t3v3__tap_2
XTAP_TAPCELL_ROW_150_1450 VDD VSS gf180mcu_as_sc_mcu7t3v3__tap_2
XFILLER_0_970 VDD VDD VSS VSS gf180mcu_as_sc_mcu7t3v3__fill_2
XFILLER_130_1242 VDD VDD VSS VSS gf180mcu_as_sc_mcu7t3v3__fill_1
XFILLER_208_733 VDD VDD VSS VSS gf180mcu_as_sc_mcu7t3v3__fill_2
XFILLER_212_37 VDD VDD VSS VSS gf180mcu_as_sc_mcu7t3v3__fillcap_16
XFILLER_207_276 VDD VDD VSS VSS gf180mcu_as_sc_mcu7t3v3__fillcap_4
XFILLER_228_1026 VDD VDD VSS VSS gf180mcu_as_sc_mcu7t3v3__fill_2
XFILLER_179_139 VDD VDD VSS VSS gf180mcu_as_sc_mcu7t3v3__fill_1
X_5740_ VDD VDD VSS VSS _5797_/B _5740_/A _5743_/C gf180mcu_as_sc_mcu7t3v3__and2_2
XFILLER_163_1084 VDD VDD VSS VSS gf180mcu_as_sc_mcu7t3v3__fillcap_16
XFILLER_198_1103 VDD VDD VSS VSS gf180mcu_as_sc_mcu7t3v3__fillcap_16
X_5671_ VDD VDD VSS VSS _5671_/Y _5671_/B _5671_/A gf180mcu_as_sc_mcu7t3v3__nor2_2
XFILLER_204_1081 VDD VDD VSS VSS gf180mcu_as_sc_mcu7t3v3__fillcap_4
X_4622_ VDD VDD VSS VSS _4840_/B _4792_/B _4622_/Y gf180mcu_as_sc_mcu7t3v3__or2_2
XTAP_TAPCELL_ROW_170_1804 VDD VSS gf180mcu_as_sc_mcu7t3v3__tap_2
X_4553_ VDD VDD VSS VSS _4553_/B _4553_/A _6305_/D gf180mcu_as_sc_mcu7t3v3__or2_2
X_4484_ VDD VDD VSS VSS _4499_/C _4484_/B _4551_/B gf180mcu_as_sc_mcu7t3v3__nor2_2
X_3504_ VDD VDD VSS VSS _4624_/D _4977_/A _5952_/A gf180mcu_as_sc_mcu7t3v3__nor2b_2
XTAP_TAPCELL_ROW_211_2546 VDD VSS gf180mcu_as_sc_mcu7t3v3__tap_2
XTAP_TAPCELL_ROW_211_2535 VDD VSS gf180mcu_as_sc_mcu7t3v3__tap_2
X_6223_ VDD VDD VSS VSS _6518_/CLK _6223_/D _6223_/Q gf180mcu_as_sc_mcu7t3v3__dfxtp_2
X_3435_ VDD VDD VSS VSS _4478_/A _4070_/C _4462_/B gf180mcu_as_sc_mcu7t3v3__nor2_2
XFILLER_106_27 VDD VDD VSS VSS gf180mcu_as_sc_mcu7t3v3__fillcap_8
XTAP_TAPCELL_ROW_16_1302 VDD VSS gf180mcu_as_sc_mcu7t3v3__tap_2
XTAP_TAPCELL_ROW_16_1313 VDD VSS gf180mcu_as_sc_mcu7t3v3__tap_2
XFILLER_106_49 VDD VDD VSS VSS gf180mcu_as_sc_mcu7t3v3__fill_2
XFILLER_170_1033 VDD VDD VSS VSS gf180mcu_as_sc_mcu7t3v3__fillcap_16
XPHY_EDGE_ROW_68_3_Right_148 VDD VSS gf180mcu_as_sc_mcu7t3v3__tap_2
XTAP_TAPCELL_ROW_16_1324 VDD VSS gf180mcu_as_sc_mcu7t3v3__tap_2
X_6154_ VDD VDD VSS VSS _6365_/CLK _6154_/D _6154_/Q gf180mcu_as_sc_mcu7t3v3__dfxtp_2
X_3366_ VDD VDD VSS VSS _6527_/Q _3366_/B _3366_/A _3366_/Y gf180mcu_as_sc_mcu7t3v3__mux2_2
XTAP_TAPCELL_ROW_168_1766 VDD VSS gf180mcu_as_sc_mcu7t3v3__tap_2
Xhold1203 VDD VDD VSS VSS hold1231/Y _6543_/D gf180mcu_as_sc_mcu7t3v3__clkbuff_4
Xhold1214 VDD VDD VSS VSS _6332_/Q _4574_/C gf180mcu_as_sc_mcu7t3v3__clkbuff_4
Xhold1225 VDD VDD VSS VSS _6534_/Q hold1225/Y gf180mcu_as_sc_mcu7t3v3__clkbuff_4
X_6085_ VDD VDD VSS VSS _6370_/CLK _6085_/D _6085_/Q gf180mcu_as_sc_mcu7t3v3__dfxtp_2
X_5105_ VDD VDD VSS VSS _6504_/Q _5234_/B _5226_/C _5768_/D _5106_/D gf180mcu_as_sc_mcu7t3v3__ao22_2
X_3297_ VDD VDD VSS VSS _6236_/Q _4448_/B _3360_/A _3297_/D _3299_/C gf180mcu_as_sc_mcu7t3v3__ao211_2
XFILLER_211_1030 VDD VDD VSS VSS gf180mcu_as_sc_mcu7t3v3__fillcap_16
X_5036_ VDD VDD VSS VSS _5037_/D _5708_/A _5138_/B _5132_/B gf180mcu_as_sc_mcu7t3v3__ao21_2
XTAP_TAPCELL_ROW_209_2497 VDD VSS gf180mcu_as_sc_mcu7t3v3__tap_2
XFILLER_122_37 VDD VDD VSS VSS gf180mcu_as_sc_mcu7t3v3__fillcap_8
XFILLER_211_1052 VDD VDD VSS VSS gf180mcu_as_sc_mcu7t3v3__fillcap_16
XTAP_TAPCELL_ROW_181_1999 VDD VSS gf180mcu_as_sc_mcu7t3v3__tap_2
XFILLER_198_415 VDD VDD VSS VSS gf180mcu_as_sc_mcu7t3v3__fillcap_4
XFILLER_0_1185 VDD VDD VSS VSS gf180mcu_as_sc_mcu7t3v3__fill_1
XFILLER_0_1196 VDD VDD VSS VSS gf180mcu_as_sc_mcu7t3v3__fill_1
XFILLER_179_651 VDD VDD VSS VSS gf180mcu_as_sc_mcu7t3v3__fill_1
XFILLER_198_459 VDD VDD VSS VSS gf180mcu_as_sc_mcu7t3v3__fill_1
X_5938_ VDD VDD VSS VSS _5952_/B _5938_/B _5938_/A _5940_/C gf180mcu_as_sc_mcu7t3v3__mux2_2
XFILLER_15_68 VDD VDD VSS VSS gf180mcu_as_sc_mcu7t3v3__fill_2
XFILLER_16_1116 VDD VDD VSS VSS gf180mcu_as_sc_mcu7t3v3__fill_1
XFILLER_201_419 VDD VDD VSS VSS gf180mcu_as_sc_mcu7t3v3__fill_1
XFILLER_166_312 VDD VDD VSS VSS gf180mcu_as_sc_mcu7t3v3__fill_2
XFILLER_193_120 VDD VDD VSS VSS gf180mcu_as_sc_mcu7t3v3__fillcap_4
X_5869_ VDD VDD VSS VSS _5869_/B _5869_/A _5874_/C gf180mcu_as_sc_mcu7t3v3__and2_2
XFILLER_193_142 VDD VDD VSS VSS gf180mcu_as_sc_mcu7t3v3__fillcap_16
XFILLER_31_45 VDD VDD VSS VSS gf180mcu_as_sc_mcu7t3v3__fillcap_4
XFILLER_190_893 VDD VDD VSS VSS gf180mcu_as_sc_mcu7t3v3__fill_1
XFILLER_66_1261 VDD VDD VSS VSS gf180mcu_as_sc_mcu7t3v3__fillcap_4
XFILLER_0_244 VDD VDD VSS VSS gf180mcu_as_sc_mcu7t3v3__fill_2
XFILLER_153_1253 VDD VDD VSS VSS gf180mcu_as_sc_mcu7t3v3__fill_2
Xinput101 VDD VDD VSS VSS ne_in[23] _5865_/D gf180mcu_as_sc_mcu7t3v3__buff_12
XFILLER_153_1264 VDD VDD VSS VSS gf180mcu_as_sc_mcu7t3v3__fill_1
XFILLER_163_66 VDD VDD VSS VSS gf180mcu_as_sc_mcu7t3v3__fillcap_4
XFILLER_163_88 VDD VDD VSS VSS gf180mcu_as_sc_mcu7t3v3__fillcap_16
XFILLER_209_508 VDD VDD VSS VSS gf180mcu_as_sc_mcu7t3v3__fillcap_8
Xinput112 VDD VDD VSS VSS ne_in[33] _5946_/D gf180mcu_as_sc_mcu7t3v3__buff_12
Xinput123 VDD VDD VSS VSS north_in[10] _5757_/B gf180mcu_as_sc_mcu7t3v3__buff_12
Xinput134 VDD VDD VSS VSS north_in[20] _5838_/B gf180mcu_as_sc_mcu7t3v3__buff_12
Xinput145 VDD VDD VSS VSS north_in[30] _5921_/D gf180mcu_as_sc_mcu7t3v3__buff_12
XFILLER_5_1030 VDD VDD VSS VSS gf180mcu_as_sc_mcu7t3v3__fillcap_16
Xinput156 VDD VDD VSS VSS north_in[8] _5741_/B gf180mcu_as_sc_mcu7t3v3__buff_12
Xinput167 VDD VDD VSS VSS nw_in[18] _5825_/A gf180mcu_as_sc_mcu7t3v3__buff_12
Xinput178 VDD VDD VSS VSS nw_in[28] _5907_/A gf180mcu_as_sc_mcu7t3v3__buff_12
XFILLER_17_602 VDD VDD VSS VSS gf180mcu_as_sc_mcu7t3v3__fillcap_4
XFILLER_5_1052 VDD VDD VSS VSS gf180mcu_as_sc_mcu7t3v3__fillcap_16
XPHY_EDGE_ROW_174_Left_402 VDD VSS gf180mcu_as_sc_mcu7t3v3__tap_2
Xinput189 VDD VDD VSS VSS nw_in[5] _5719_/A gf180mcu_as_sc_mcu7t3v3__buff_12
XFILLER_16_101 VDD VDD VSS VSS gf180mcu_as_sc_mcu7t3v3__fill_1
XFILLER_205_769 VDD VDD VSS VSS gf180mcu_as_sc_mcu7t3v3__fill_1
XFILLER_73_1210 VDD VDD VSS VSS gf180mcu_as_sc_mcu7t3v3__fill_1
XFILLER_188_41 VDD VDD VSS VSS gf180mcu_as_sc_mcu7t3v3__fill_1
XFILLER_13_874 VDD VDD VSS VSS gf180mcu_as_sc_mcu7t3v3__fillcap_16
XFILLER_188_63 VDD VDD VSS VSS gf180mcu_as_sc_mcu7t3v3__fill_1
XFILLER_197_492 VDD VDD VSS VSS gf180mcu_as_sc_mcu7t3v3__fill_2
XFILLER_8_311 VDD VDD VSS VSS gf180mcu_as_sc_mcu7t3v3__fillcap_4
XFILLER_12_373 VDD VDD VSS VSS gf180mcu_as_sc_mcu7t3v3__fill_2
XFILLER_158_879 VDD VDD VSS VSS gf180mcu_as_sc_mcu7t3v3__fill_1
XFILLER_8_333 VDD VDD VSS VSS gf180mcu_as_sc_mcu7t3v3__fillcap_16
XPHY_EDGE_ROW_183_Left_411 VDD VSS gf180mcu_as_sc_mcu7t3v3__tap_2
XPHY_EDGE_ROW_74_1_Right_646 VDD VSS gf180mcu_as_sc_mcu7t3v3__tap_2
XFILLER_185_698 VDD VDD VSS VSS gf180mcu_as_sc_mcu7t3v3__fill_2
XFILLER_201_1232 VDD VDD VSS VSS gf180mcu_as_sc_mcu7t3v3__fill_2
XPHY_EDGE_ROW_139_2_Left_580 VDD VSS gf180mcu_as_sc_mcu7t3v3__tap_2
XFILLER_153_562 VDD VDD VSS VSS gf180mcu_as_sc_mcu7t3v3__fillcap_4
XPHY_EDGE_ROW_57_2_Right_894 VDD VSS gf180mcu_as_sc_mcu7t3v3__tap_2
XPHY_EDGE_ROW_99_3_Left_804 VDD VSS gf180mcu_as_sc_mcu7t3v3__tap_2
XTAP_TAPCELL_ROW_75_2_2961 VDD VSS gf180mcu_as_sc_mcu7t3v3__tap_2
XFILLER_154_1017 VDD VDD VSS VSS gf180mcu_as_sc_mcu7t3v3__fillcap_16
XFILLER_207_59 VDD VDD VSS VSS gf180mcu_as_sc_mcu7t3v3__fillcap_8
X_3220_ VDD VDD VSS VSS _3299_/A _3220_/B _3220_/C _3220_/D _3220_/Y gf180mcu_as_sc_mcu7t3v3__ao22_2
XPHY_EDGE_ROW_192_Left_420 VDD VSS gf180mcu_as_sc_mcu7t3v3__tap_2
X_3151_ VDD VDD VSS VSS _4566_/A _4570_/A _3154_/C gf180mcu_as_sc_mcu7t3v3__or2_2
XTAP_TAPCELL_ROW_185_2077 VDD VSS gf180mcu_as_sc_mcu7t3v3__tap_2
XTAP_TAPCELL_ROW_185_2066 VDD VSS gf180mcu_as_sc_mcu7t3v3__tap_2
XTAP_TAPCELL_ROW_11_1210 VDD VSS gf180mcu_as_sc_mcu7t3v3__tap_2
X_3082_ VDD VDD VSS VSS _5538_/A _5842_/A gf180mcu_as_sc_mcu7t3v3__inv_2
XTAP_TAPCELL_ROW_163_1674 VDD VSS gf180mcu_as_sc_mcu7t3v3__tap_2
XFILLER_149_813 VDD VDD VSS VSS gf180mcu_as_sc_mcu7t3v3__fill_2
XFILLER_189_982 VDD VDD VSS VSS gf180mcu_as_sc_mcu7t3v3__fillcap_16
X_3984_ VDD VDD VSS VSS _4018_/B _4012_/B _4012_/C _6074_/Q _6074_/D gf180mcu_as_sc_mcu7t3v3__ao22_2
X_5723_ VDD VDD VSS VSS _5873_/B _5723_/A _5726_/C gf180mcu_as_sc_mcu7t3v3__and2_2
XFILLER_175_120 VDD VDD VSS VSS gf180mcu_as_sc_mcu7t3v3__fillcap_16
XFILLER_175_142 VDD VDD VSS VSS gf180mcu_as_sc_mcu7t3v3__fillcap_4
X_5654_ VDD VDD VSS VSS _5654_/A _5654_/B _5654_/C _5671_/B gf180mcu_as_sc_mcu7t3v3__nand3_2
XFILLER_176_698 VDD VDD VSS VSS gf180mcu_as_sc_mcu7t3v3__fill_2
XFILLER_190_101 VDD VDD VSS VSS gf180mcu_as_sc_mcu7t3v3__fillcap_4
XFILLER_191_624 VDD VDD VSS VSS gf180mcu_as_sc_mcu7t3v3__fillcap_4
X_4605_ VDD VDD VSS VSS _4606_/B _6300_/Q _6301_/Q gf180mcu_as_sc_mcu7t3v3__nor2_2
XFILLER_11_1046 VDD VDD VSS VSS gf180mcu_as_sc_mcu7t3v3__fillcap_4
XFILLER_163_348 VDD VDD VSS VSS gf180mcu_as_sc_mcu7t3v3__fill_2
X_5585_ VDD VDD VSS VSS _5891_/A _5585_/B _5585_/C _5585_/D _5586_/B gf180mcu_as_sc_mcu7t3v3__ao211_2
XFILLER_11_1068 VDD VDD VSS VSS gf180mcu_as_sc_mcu7t3v3__fillcap_16
XFILLER_190_167 VDD VDD VSS VSS gf180mcu_as_sc_mcu7t3v3__fill_1
X_4536_ VDD VDD VSS VSS _4538_/S _4536_/B _6145_/Q _6298_/D gf180mcu_as_sc_mcu7t3v3__mux2_2
XPHY_EDGE_ROW_83_3_Left_788 VDD VSS gf180mcu_as_sc_mcu7t3v3__tap_2
X_4467_ VDD VDD VSS VSS _4468_/C _6272_/Q _6273_/Q _6273_/D gf180mcu_as_sc_mcu7t3v3__mux2_2
Xfanout802 VDD VDD VSS VSS _4226_/B _4400_/B gf180mcu_as_sc_mcu7t3v3__buff_12
Xfanout813 VDD VDD VSS VSS _3868_/B _3925_/B gf180mcu_as_sc_mcu7t3v3__buff_12
Xfanout824 VDD VDD VSS VSS _5122_/A _5139_/B gf180mcu_as_sc_mcu7t3v3__buff_12
X_6206_ VDD VDD VSS VSS _6546_/CLK _6206_/D _6206_/Q gf180mcu_as_sc_mcu7t3v3__dfxtp_2
X_4398_ VDD VDD VSS VSS _4398_/S _6067_/Q _6096_/Q _4401_/B gf180mcu_as_sc_mcu7t3v3__mux2_2
X_3418_ VDD VDD VSS VSS _3419_/B _6309_/Q _6308_/Q _6264_/Q gf180mcu_as_sc_mcu7t3v3__aoi21b_2
Xfanout835 VDD VDD VSS VSS _4887_/B _4877_/B gf180mcu_as_sc_mcu7t3v3__buff_12
Xfanout846 VDD VDD VSS VSS _4601_/D _4512_/S gf180mcu_as_sc_mcu7t3v3__buff_12
Xfanout857 VDD VDD VSS VSS _4628_/Y fanout857/Y gf180mcu_as_sc_mcu7t3v3__buff_12
X_6137_ VDD VDD VSS VSS clkload7/A _6137_/D _6137_/Q gf180mcu_as_sc_mcu7t3v3__dfxtp_2
X_3349_ VDD VDD VSS VSS _6209_/Q _3361_/B _4101_/S _6217_/Q _3354_/B gf180mcu_as_sc_mcu7t3v3__ao22_2
XTAP_TAPCELL_ROW_228_2851 VDD VSS gf180mcu_as_sc_mcu7t3v3__tap_2
XTAP_TAPCELL_ROW_228_2840 VDD VSS gf180mcu_as_sc_mcu7t3v3__tap_2
XPHY_EDGE_ROW_69_3_Right_149 VDD VSS gf180mcu_as_sc_mcu7t3v3__tap_2
Xfanout868 VDD VDD VSS VSS _3202_/Y _6550_/D gf180mcu_as_sc_mcu7t3v3__buff_12
XTAP_TAPCELL_ROW_228_2873 VDD VSS gf180mcu_as_sc_mcu7t3v3__tap_2
XTAP_TAPCELL_ROW_228_2862 VDD VSS gf180mcu_as_sc_mcu7t3v3__tap_2
XFILLER_93_18 VDD VDD VSS VSS gf180mcu_as_sc_mcu7t3v3__fillcap_8
X_6068_ VDD VDD VSS VSS _6525_/CLK _6068_/D _6068_/Q gf180mcu_as_sc_mcu7t3v3__dfxtp_2
XFILLER_199_702 VDD VDD VSS VSS gf180mcu_as_sc_mcu7t3v3__fillcap_8
XFILLER_96_1210 VDD VDD VSS VSS gf180mcu_as_sc_mcu7t3v3__fillcap_8
X_5019_ VDD VDD VSS VSS _5019_/D _5692_/A _5139_/B _5139_/C _5020_/C gf180mcu_as_sc_mcu7t3v3__ao31_2
XFILLER_14_605 VDD VDD VSS VSS gf180mcu_as_sc_mcu7t3v3__fill_2
XFILLER_165_6 VDD VDD VSS VSS gf180mcu_as_sc_mcu7t3v3__fillcap_8
XFILLER_183_1224 VDD VDD VSS VSS gf180mcu_as_sc_mcu7t3v3__fillcap_8
XFILLER_26_45 VDD VDD VSS VSS gf180mcu_as_sc_mcu7t3v3__fillcap_4
XFILLER_13_104 VDD VDD VSS VSS gf180mcu_as_sc_mcu7t3v3__fillcap_16
XFILLER_199_746 VDD VDD VSS VSS gf180mcu_as_sc_mcu7t3v3__fillcap_4
XFILLER_224_1221 VDD VDD VSS VSS gf180mcu_as_sc_mcu7t3v3__fillcap_4
XFILLER_167_610 VDD VDD VSS VSS gf180mcu_as_sc_mcu7t3v3__fillcap_4
XFILLER_179_492 VDD VDD VSS VSS gf180mcu_as_sc_mcu7t3v3__fill_1
XFILLER_224_1243 VDD VDD VSS VSS gf180mcu_as_sc_mcu7t3v3__fillcap_16
XFILLER_158_22 VDD VDD VSS VSS gf180mcu_as_sc_mcu7t3v3__fillcap_8
XPHY_EDGE_ROW_124_1_Left_352 VDD VSS gf180mcu_as_sc_mcu7t3v3__tap_2
XFILLER_10_855 VDD VDD VSS VSS gf180mcu_as_sc_mcu7t3v3__fillcap_16
XFILLER_10_877 VDD VDD VSS VSS gf180mcu_as_sc_mcu7t3v3__fillcap_16
XFILLER_155_827 VDD VDD VSS VSS gf180mcu_as_sc_mcu7t3v3__fill_2
XFILLER_6_804 VDD VDD VSS VSS gf180mcu_as_sc_mcu7t3v3__fill_1
XFILLER_166_197 VDD VDD VSS VSS gf180mcu_as_sc_mcu7t3v3__fill_1
XFILLER_177_1028 VDD VDD VSS VSS gf180mcu_as_sc_mcu7t3v3__fillcap_16
XFILLER_181_112 VDD VDD VSS VSS gf180mcu_as_sc_mcu7t3v3__fill_2
XFILLER_190_1239 VDD VDD VSS VSS gf180mcu_as_sc_mcu7t3v3__fill_1
XFILLER_3_27 VDD VDD VSS VSS gf180mcu_as_sc_mcu7t3v3__fillcap_16
XFILLER_96_619 VDD VDD VSS VSS gf180mcu_as_sc_mcu7t3v3__fill_1
XPHY_EDGE_ROW_152_Right_20 VDD VSS gf180mcu_as_sc_mcu7t3v3__tap_2
XFILLER_188_1135 VDD VDD VSS VSS gf180mcu_as_sc_mcu7t3v3__fillcap_16
XFILLER_190_53 VDD VDD VSS VSS gf180mcu_as_sc_mcu7t3v3__fillcap_16
XTAP_TAPCELL_ROW_8_1164 VDD VSS gf180mcu_as_sc_mcu7t3v3__tap_2
XTAP_TAPCELL_ROW_8_1153 VDD VSS gf180mcu_as_sc_mcu7t3v3__tap_2
XFILLER_188_1157 VDD VDD VSS VSS gf180mcu_as_sc_mcu7t3v3__fillcap_16
XFILLER_189_201 VDD VDD VSS VSS gf180mcu_as_sc_mcu7t3v3__fillcap_8
XFILLER_189_212 VDD VDD VSS VSS gf180mcu_as_sc_mcu7t3v3__fillcap_8
XPHY_EDGE_ROW_56_1_Left_284 VDD VSS gf180mcu_as_sc_mcu7t3v3__tap_2
XFILLER_157_120 VDD VDD VSS VSS gf180mcu_as_sc_mcu7t3v3__fillcap_16
XFILLER_157_142 VDD VDD VSS VSS gf180mcu_as_sc_mcu7t3v3__fillcap_16
XFILLER_186_963 VDD VDD VSS VSS gf180mcu_as_sc_mcu7t3v3__fillcap_16
XFILLER_201_772 VDD VDD VSS VSS gf180mcu_as_sc_mcu7t3v3__fillcap_4
XFILLER_160_1065 VDD VDD VSS VSS gf180mcu_as_sc_mcu7t3v3__fillcap_16
XFILLER_160_1087 VDD VDD VSS VSS gf180mcu_as_sc_mcu7t3v3__fillcap_16
XFILLER_172_101 VDD VDD VSS VSS gf180mcu_as_sc_mcu7t3v3__fillcap_4
XFILLER_199_1264 VDD VDD VSS VSS gf180mcu_as_sc_mcu7t3v3__fill_1
XPHY_EDGE_ROW_75_1_Right_647 VDD VSS gf180mcu_as_sc_mcu7t3v3__tap_2
XTAP_TAPCELL_ROW_122_2_3031 VDD VSS gf180mcu_as_sc_mcu7t3v3__tap_2
XFILLER_172_123 VDD VDD VSS VSS gf180mcu_as_sc_mcu7t3v3__fillcap_16
XFILLER_201_1084 VDD VDD VSS VSS gf180mcu_as_sc_mcu7t3v3__fillcap_16
XFILLER_218_69 VDD VDD VSS VSS gf180mcu_as_sc_mcu7t3v3__fillcap_16
Xoutput416 VDD VDD VSS VSS _6348_/Q north_out[7] gf180mcu_as_sc_mcu7t3v3__buff_12
Xoutput405 VDD VDD VSS VSS _6343_/Q north_out[2] gf180mcu_as_sc_mcu7t3v3__buff_12
X_5370_ VDD VDD VSS VSS _5371_/A _5669_/A _5569_/B _5370_/C gf180mcu_as_sc_mcu7t3v3__ao21_2
XTAP_TAPCELL_ROW_187_2106 VDD VSS gf180mcu_as_sc_mcu7t3v3__tap_2
XFILLER_172_189 VDD VDD VSS VSS gf180mcu_as_sc_mcu7t3v3__fillcap_16
XFILLER_5_870 VDD VDD VSS VSS gf180mcu_as_sc_mcu7t3v3__fillcap_4
Xoutput449 VDD VDD VSS VSS _6381_/Q south_out[4] gf180mcu_as_sc_mcu7t3v3__buff_12
Xoutput438 VDD VDD VSS VSS _6404_/Q south_out[27] gf180mcu_as_sc_mcu7t3v3__buff_12
Xoutput427 VDD VDD VSS VSS _6394_/Q south_out[17] gf180mcu_as_sc_mcu7t3v3__buff_12
X_4321_ VDD VDD VSS VSS _4321_/S _6056_/Q _6085_/Q _4324_/B gf180mcu_as_sc_mcu7t3v3__mux2_2
XFILLER_4_391 VDD VDD VSS VSS gf180mcu_as_sc_mcu7t3v3__fill_2
XPHY_EDGE_ROW_58_2_Right_895 VDD VSS gf180mcu_as_sc_mcu7t3v3__tap_2
X_4252_ VDD VDD VSS VSS _4363_/S _6105_/Q _6018_/Q _4254_/A gf180mcu_as_sc_mcu7t3v3__mux2_2
X_3203_ VDD VDD VSS VSS _3261_/A _3280_/B gf180mcu_as_sc_mcu7t3v3__inv_2
XFILLER_228_614 VDD VDD VSS VSS gf180mcu_as_sc_mcu7t3v3__fillcap_4
XFILLER_95_630 VDD VDD VSS VSS gf180mcu_as_sc_mcu7t3v3__fillcap_4
XTAP_TAPCELL_ROW_165_1703 VDD VSS gf180mcu_as_sc_mcu7t3v3__tap_2
XTAP_TAPCELL_ROW_165_1714 VDD VSS gf180mcu_as_sc_mcu7t3v3__tap_2
X_4183_ VDD VDD VSS VSS _5977_/B _4283_/A _4183_/Y gf180mcu_as_sc_mcu7t3v3__and2_2
X_3134_ VDD VDD VSS VSS _3134_/D _4539_/A _4579_/A _3134_/C _3136_/C gf180mcu_as_sc_mcu7t3v3__ao31_2
XTAP_TAPCELL_ROW_206_2445 VDD VSS gf180mcu_as_sc_mcu7t3v3__tap_2
XFILLER_167_1208 VDD VDD VSS VSS gf180mcu_as_sc_mcu7t3v3__fillcap_16
X_3065_ VDD VDD VSS VSS _4670_/A _5687_/A gf180mcu_as_sc_mcu7t3v3__inv_2
XTAP_TAPCELL_ROW_206_2456 VDD VSS gf180mcu_as_sc_mcu7t3v3__tap_2
XFILLER_208_1205 VDD VDD VSS VSS gf180mcu_as_sc_mcu7t3v3__fillcap_16
XFILLER_208_1227 VDD VDD VSS VSS gf180mcu_as_sc_mcu7t3v3__fillcap_8
XFILLER_223_352 VDD VDD VSS VSS gf180mcu_as_sc_mcu7t3v3__fillcap_8
XFILLER_10_107 VDD VDD VSS VSS gf180mcu_as_sc_mcu7t3v3__fillcap_16
XFILLER_56_1260 VDD VDD VSS VSS gf180mcu_as_sc_mcu7t3v3__fillcap_4
X_3967_ VDD VDD VSS VSS _3974_/B _6065_/Q _3968_/D gf180mcu_as_sc_mcu7t3v3__and2_2
X_5706_ VDD VDD VSS VSS _5797_/B _5706_/A _5709_/C gf180mcu_as_sc_mcu7t3v3__and2_2
XFILLER_149_698 VDD VDD VSS VSS gf180mcu_as_sc_mcu7t3v3__fillcap_16
XFILLER_176_473 VDD VDD VSS VSS gf180mcu_as_sc_mcu7t3v3__fill_2
X_3898_ VDD VDD VSS VSS _3926_/B _5877_/A _3899_/D gf180mcu_as_sc_mcu7t3v3__and2_2
XFILLER_191_443 VDD VDD VSS VSS gf180mcu_as_sc_mcu7t3v3__fillcap_16
XFILLER_192_944 VDD VDD VSS VSS gf180mcu_as_sc_mcu7t3v3__fill_1
XFILLER_192_955 VDD VDD VSS VSS gf180mcu_as_sc_mcu7t3v3__fill_1
X_5637_ VDD VDD VSS VSS _5637_/B _5951_/A _5639_/C gf180mcu_as_sc_mcu7t3v3__and2_2
XFILLER_3_829 VDD VDD VSS VSS gf180mcu_as_sc_mcu7t3v3__fillcap_8
X_5568_ VDD VDD VSS VSS _5875_/A _5568_/B _5568_/C _5869_/A _5569_/D gf180mcu_as_sc_mcu7t3v3__ao22_2
XFILLER_2_317 VDD VDD VSS VSS gf180mcu_as_sc_mcu7t3v3__fillcap_8
XFILLER_88_29 VDD VDD VSS VSS gf180mcu_as_sc_mcu7t3v3__fillcap_4
X_4519_ VDD VDD VSS VSS _4527_/S _6292_/Q _4519_/A _6292_/D gf180mcu_as_sc_mcu7t3v3__mux2_2
XFILLER_78_619 VDD VDD VSS VSS gf180mcu_as_sc_mcu7t3v3__fill_1
X_5499_ VDD VDD VSS VSS _6509_/Q _5571_/B _5571_/C _5810_/D _5500_/C gf180mcu_as_sc_mcu7t3v3__ao22_2
XFILLER_132_598 VDD VDD VSS VSS gf180mcu_as_sc_mcu7t3v3__fill_2
Xfanout610 VDD VDD VSS VSS _4183_/Y _4373_/D gf180mcu_as_sc_mcu7t3v3__buff_12
Xfanout621 VDD VDD VSS VSS _5954_/B _5869_/B gf180mcu_as_sc_mcu7t3v3__buff_12
Xfanout632 VDD VDD VSS VSS _4962_/B _4871_/B gf180mcu_as_sc_mcu7t3v3__buff_12
XFILLER_150_1234 VDD VDD VSS VSS gf180mcu_as_sc_mcu7t3v3__fillcap_16
XFILLER_86_641 VDD VDD VSS VSS gf180mcu_as_sc_mcu7t3v3__fill_1
Xfanout643 VDD VDD VSS VSS fanout644/Y _3910_/B gf180mcu_as_sc_mcu7t3v3__buff_12
Xfanout654 VDD VDD VSS VSS _5931_/B _5922_/B gf180mcu_as_sc_mcu7t3v3__buff_12
Xfanout665 VDD VDD VSS VSS _5946_/C _5953_/C gf180mcu_as_sc_mcu7t3v3__buff_12
Xfanout676 VDD VDD VSS VSS _5583_/B _5567_/B gf180mcu_as_sc_mcu7t3v3__buff_12
Xfanout687 VDD VDD VSS VSS _4961_/B _4948_/B gf180mcu_as_sc_mcu7t3v3__buff_12
Xfanout698 VDD VDD VSS VSS _4406_/B _4399_/B gf180mcu_as_sc_mcu7t3v3__buff_12
XFILLER_160_34 VDD VDD VSS VSS gf180mcu_as_sc_mcu7t3v3__fill_1
XFILLER_2_1011 VDD VDD VSS VSS gf180mcu_as_sc_mcu7t3v3__fillcap_4
XFILLER_2_1033 VDD VDD VSS VSS gf180mcu_as_sc_mcu7t3v3__fillcap_16
XTAP_TAPCELL_ROW_3_1072 VDD VSS gf180mcu_as_sc_mcu7t3v3__tap_2
XTAP_TAPCELL_ROW_3_1061 VDD VSS gf180mcu_as_sc_mcu7t3v3__tap_2
XFILLER_214_352 VDD VDD VSS VSS gf180mcu_as_sc_mcu7t3v3__fillcap_4
Xclkbuf_leaf_2_clk_regs VDD VDD VSS VSS clkbuf_3_4_0_clk_regs/Y _6509_/CLK gf180mcu_as_sc_mcu7t3v3__clkbuff_12
XFILLER_14_457 VDD VDD VSS VSS gf180mcu_as_sc_mcu7t3v3__fillcap_16
XFILLER_169_54 VDD VDD VSS VSS gf180mcu_as_sc_mcu7t3v3__fillcap_16
XFILLER_154_101 VDD VDD VSS VSS gf180mcu_as_sc_mcu7t3v3__fillcap_4
XFILLER_155_602 VDD VDD VSS VSS gf180mcu_as_sc_mcu7t3v3__fill_2
XFILLER_154_123 VDD VDD VSS VSS gf180mcu_as_sc_mcu7t3v3__fillcap_16
XFILLER_185_31 VDD VDD VSS VSS gf180mcu_as_sc_mcu7t3v3__fill_1
XFILLER_155_679 VDD VDD VSS VSS gf180mcu_as_sc_mcu7t3v3__fill_1
XFILLER_6_689 VDD VDD VSS VSS gf180mcu_as_sc_mcu7t3v3__fillcap_4
XFILLER_123_598 VDD VDD VSS VSS gf180mcu_as_sc_mcu7t3v3__fill_2
XTAP_TAPCELL_ROW_182_2025 VDD VSS gf180mcu_as_sc_mcu7t3v3__tap_2
XTAP_TAPCELL_ROW_182_2014 VDD VSS gf180mcu_as_sc_mcu7t3v3__tap_2
XFILLER_204_27 VDD VDD VSS VSS gf180mcu_as_sc_mcu7t3v3__fillcap_8
XTAP_TAPCELL_ROW_146_3_3068 VDD VSS gf180mcu_as_sc_mcu7t3v3__tap_2
Xmesh_tile_1042 VDD VDD VSS VSS ne_out[1] gf180mcu_as_sc_mcu7t3v3__tiel_4
Xmesh_tile_1053 VDD VDD VSS VSS ne_out[12] gf180mcu_as_sc_mcu7t3v3__tiel_4
XTAP_TAPCELL_ROW_160_1622 VDD VSS gf180mcu_as_sc_mcu7t3v3__tap_2
Xmesh_tile_1086 VDD VDD VSS VSS nw_out[9] gf180mcu_as_sc_mcu7t3v3__tiel_4
Xmesh_tile_1075 VDD VDD VSS VSS ne_out[34] gf180mcu_as_sc_mcu7t3v3__tiel_4
Xmesh_tile_1064 VDD VDD VSS VSS ne_out[23] gf180mcu_as_sc_mcu7t3v3__tiel_4
XFILLER_220_37 VDD VDD VSS VSS gf180mcu_as_sc_mcu7t3v3__fillcap_16
Xmesh_tile_1097 VDD VDD VSS VSS nw_out[20] gf180mcu_as_sc_mcu7t3v3__tiel_4
XFILLER_127_1214 VDD VDD VSS VSS gf180mcu_as_sc_mcu7t3v3__fill_1
X_4870_ VDD VDD VSS VSS _6516_/Q _4960_/B _4870_/C _4870_/D _4872_/C gf180mcu_as_sc_mcu7t3v3__ao22_2
XTAP_TAPCELL_ROW_201_2364 VDD VSS gf180mcu_as_sc_mcu7t3v3__tap_2
XTAP_TAPCELL_ROW_201_2353 VDD VSS gf180mcu_as_sc_mcu7t3v3__tap_2
X_3821_ VDD VDD VSS VSS _6032_/Q _3830_/B _4041_/B _3830_/D _6032_/D gf180mcu_as_sc_mcu7t3v3__ao22_2
XTAP_TAPCELL_ROW_197_2290 VDD VSS gf180mcu_as_sc_mcu7t3v3__tap_2
XFILLER_159_952 VDD VDD VSS VSS gf180mcu_as_sc_mcu7t3v3__fill_1
X_6540_ VDD VDD VSS VSS clkload9/A _6540_/D _6540_/Q gf180mcu_as_sc_mcu7t3v3__dfxtp_2
XTAP_TAPCELL_ROW_63_2_2943 VDD VSS gf180mcu_as_sc_mcu7t3v3__tap_2
XFILLER_146_624 VDD VDD VSS VSS gf180mcu_as_sc_mcu7t3v3__fill_2
X_3752_ VDD VDD VSS VSS _3753_/B _3922_/C _3856_/B _5754_/A gf180mcu_as_sc_mcu7t3v3__aoi21b_2
XFILLER_158_484 VDD VDD VSS VSS gf180mcu_as_sc_mcu7t3v3__fillcap_4
XFILLER_173_443 VDD VDD VSS VSS gf180mcu_as_sc_mcu7t3v3__fillcap_16
XFILLER_174_944 VDD VDD VSS VSS gf180mcu_as_sc_mcu7t3v3__fill_1
XFILLER_9_472 VDD VDD VSS VSS gf180mcu_as_sc_mcu7t3v3__fillcap_8
XTAP_TAPCELL_ROW_158_1584 VDD VSS gf180mcu_as_sc_mcu7t3v3__tap_2
X_6471_ VDD VDD VSS VSS _6474_/CLK _6471_/D _6471_/Q gf180mcu_as_sc_mcu7t3v3__dfxtp_2
X_3683_ VDD VDD VSS VSS _5693_/D _3807_/S _3683_/C _3683_/D _3685_/C gf180mcu_as_sc_mcu7t3v3__ao211_2
XFILLER_173_476 VDD VDD VSS VSS gf180mcu_as_sc_mcu7t3v3__fillcap_8
XPHY_EDGE_ROW_76_1_Right_648 VDD VSS gf180mcu_as_sc_mcu7t3v3__tap_2
X_5422_ VDD VDD VSS VSS _6419_/D _5909_/D _5422_/B _5422_/A gf180mcu_as_sc_mcu7t3v3__aoi21_2
XTAP_TAPCELL_ROW_62_1_1352 VDD VSS gf180mcu_as_sc_mcu7t3v3__tap_2
X_5353_ VDD VDD VSS VSS _5661_/B _5353_/C _5353_/B _5353_/A gf180mcu_as_sc_mcu7t3v3__aoi21_2
X_4304_ VDD VDD VSS VSS _6211_/D _4304_/B _4304_/A gf180mcu_as_sc_mcu7t3v3__nand2_2
XPHY_EDGE_ROW_59_2_Right_896 VDD VSS gf180mcu_as_sc_mcu7t3v3__tap_2
X_5284_ VDD VDD VSS VSS _5933_/A _5304_/B _5296_/C _5932_/A _5289_/C gf180mcu_as_sc_mcu7t3v3__ao22_2
X_4235_ VDD VDD VSS VSS _4235_/B _5977_/B _4239_/C gf180mcu_as_sc_mcu7t3v3__and2_2
XFILLER_114_27 VDD VDD VSS VSS gf180mcu_as_sc_mcu7t3v3__fillcap_8
XFILLER_114_49 VDD VDD VSS VSS gf180mcu_as_sc_mcu7t3v3__fill_2
XFILLER_228_444 VDD VDD VSS VSS gf180mcu_as_sc_mcu7t3v3__fillcap_4
X_4166_ VDD VDD VSS VSS _6185_/Q _6186_/Q _4167_/C gf180mcu_as_sc_mcu7t3v3__or2_2
XPHY_EDGE_ROW_114_3_Left_819 VDD VSS gf180mcu_as_sc_mcu7t3v3__tap_2
X_3117_ VDD VDD VSS VSS _3134_/C _6260_/Q _4509_/B gf180mcu_as_sc_mcu7t3v3__nor2_2
XFILLER_83_666 VDD VDD VSS VSS gf180mcu_as_sc_mcu7t3v3__fill_1
X_4097_ VDD VDD VSS VSS _4101_/S _6718_/A _6157_/Q _6157_/D gf180mcu_as_sc_mcu7t3v3__mux2_2
XTAP_TAPCELL_ROW_221_2718 VDD VSS gf180mcu_as_sc_mcu7t3v3__tap_2
X_3048_ VDD VDD VSS VSS _4584_/A _6552_/Q gf180mcu_as_sc_mcu7t3v3__inv_2
XFILLER_130_37 VDD VDD VSS VSS gf180mcu_as_sc_mcu7t3v3__fillcap_8
XFILLER_180_1205 VDD VDD VSS VSS gf180mcu_as_sc_mcu7t3v3__fillcap_16
XFILLER_180_1227 VDD VDD VSS VSS gf180mcu_as_sc_mcu7t3v3__fillcap_16
XFILLER_212_834 VDD VDD VSS VSS gf180mcu_as_sc_mcu7t3v3__fill_1
XTAP_TAPCELL_ROW_178_1949 VDD VSS gf180mcu_as_sc_mcu7t3v3__tap_2
XTAP_TAPCELL_ROW_178_1938 VDD VSS gf180mcu_as_sc_mcu7t3v3__tap_2
XFILLER_149_440 VDD VDD VSS VSS gf180mcu_as_sc_mcu7t3v3__fill_2
XFILLER_184_719 VDD VDD VSS VSS gf180mcu_as_sc_mcu7t3v3__fill_1
X_4999_ VDD VDD VSS VSS _5661_/C _4999_/B _5354_/C gf180mcu_as_sc_mcu7t3v3__nor2_2
XFILLER_139_46 VDD VDD VSS VSS gf180mcu_as_sc_mcu7t3v3__fillcap_4
XFILLER_221_1224 VDD VDD VSS VSS gf180mcu_as_sc_mcu7t3v3__fillcap_16
XFILLER_165_966 VDD VDD VSS VSS gf180mcu_as_sc_mcu7t3v3__fill_2
XFILLER_164_454 VDD VDD VSS VSS gf180mcu_as_sc_mcu7t3v3__fill_1
XFILLER_151_104 VDD VDD VSS VSS gf180mcu_as_sc_mcu7t3v3__fillcap_16
XFILLER_178_1189 VDD VDD VSS VSS gf180mcu_as_sc_mcu7t3v3__fillcap_16
XFILLER_191_284 VDD VDD VSS VSS gf180mcu_as_sc_mcu7t3v3__fill_1
XFILLER_3_604 VDD VDD VSS VSS gf180mcu_as_sc_mcu7t3v3__fill_1
XFILLER_160_660 VDD VDD VSS VSS gf180mcu_as_sc_mcu7t3v3__fillcap_4
XFILLER_219_1186 VDD VDD VSS VSS gf180mcu_as_sc_mcu7t3v3__fillcap_4
XFILLER_171_22 VDD VDD VSS VSS gf180mcu_as_sc_mcu7t3v3__fillcap_16
XFILLER_219_422 VDD VDD VSS VSS gf180mcu_as_sc_mcu7t3v3__fill_2
XPHY_EDGE_ROW_23_2_Left_464 VDD VSS gf180mcu_as_sc_mcu7t3v3__tap_2
XPHY_EDGE_ROW_38_1_Right_610 VDD VSS gf180mcu_as_sc_mcu7t3v3__tap_2
XTAP_TAPCELL_ROW_5_1112 VDD VSS gf180mcu_as_sc_mcu7t3v3__tap_2
XTAP_TAPCELL_ROW_5_1101 VDD VSS gf180mcu_as_sc_mcu7t3v3__tap_2
XFILLER_171_88 VDD VDD VSS VSS gf180mcu_as_sc_mcu7t3v3__fillcap_16
XFILLER_185_1116 VDD VDD VSS VSS gf180mcu_as_sc_mcu7t3v3__fillcap_4
XFILLER_185_1138 VDD VDD VSS VSS gf180mcu_as_sc_mcu7t3v3__fillcap_16
XFILLER_206_138 VDD VDD VSS VSS gf180mcu_as_sc_mcu7t3v3__fillcap_16
XFILLER_215_672 VDD VDD VSS VSS gf180mcu_as_sc_mcu7t3v3__fill_1
XFILLER_15_766 VDD VDD VSS VSS gf180mcu_as_sc_mcu7t3v3__fillcap_4
XFILLER_15_788 VDD VDD VSS VSS gf180mcu_as_sc_mcu7t3v3__fill_2
XFILLER_226_1135 VDD VDD VSS VSS gf180mcu_as_sc_mcu7t3v3__fillcap_16
XFILLER_226_1157 VDD VDD VSS VSS gf180mcu_as_sc_mcu7t3v3__fillcap_16
XFILLER_202_366 VDD VDD VSS VSS gf180mcu_as_sc_mcu7t3v3__fill_1
XFILLER_187_579 VDD VDD VSS VSS gf180mcu_as_sc_mcu7t3v3__fill_2
XFILLER_156_933 VDD VDD VSS VSS gf180mcu_as_sc_mcu7t3v3__fill_1
XFILLER_196_85 VDD VDD VSS VSS gf180mcu_as_sc_mcu7t3v3__fillcap_16
XFILLER_7_976 VDD VDD VSS VSS gf180mcu_as_sc_mcu7t3v3__fillcap_4
Xwire874 VDD VDD VSS VSS _3371_/Y _6722_/A gf180mcu_as_sc_mcu7t3v3__clkbuff_12
XFILLER_7_998 VDD VDD VSS VSS gf180mcu_as_sc_mcu7t3v3__fillcap_16
XFILLER_89_50 VDD VDD VSS VSS gf180mcu_as_sc_mcu7t3v3__fill_1
XFILLER_170_468 VDD VDD VSS VSS gf180mcu_as_sc_mcu7t3v3__fillcap_16
XTAP_TAPCELL_ROW_153_1492 VDD VSS gf180mcu_as_sc_mcu7t3v3__tap_2
XFILLER_215_59 VDD VDD VSS VSS gf180mcu_as_sc_mcu7t3v3__fillcap_8
XFILLER_2_681 VDD VDD VSS VSS gf180mcu_as_sc_mcu7t3v3__fill_1
X_4020_ VDD VDD VSS VSS _4060_/B _6104_/Q _4021_/C gf180mcu_as_sc_mcu7t3v3__and2_2
XFILLER_65_666 VDD VDD VSS VSS gf180mcu_as_sc_mcu7t3v3__fill_1
XTAP_TAPCELL_ROW_203_2404 VDD VSS gf180mcu_as_sc_mcu7t3v3__tap_2
X_5971_ VDD VDD VSS VSS _5971_/S _5971_/B _5971_/A _5972_/B gf180mcu_as_sc_mcu7t3v3__mux2_2
XTAP_TAPCELL_ROW_199_2330 VDD VSS gf180mcu_as_sc_mcu7t3v3__tap_2
XTAP_TAPCELL_ROW_110_2_3013 VDD VSS gf180mcu_as_sc_mcu7t3v3__tap_2
X_4922_ VDD VDD VSS VSS _4959_/B _5913_/A _4924_/C gf180mcu_as_sc_mcu7t3v3__and2_2
XFILLER_205_1208 VDD VDD VSS VSS gf180mcu_as_sc_mcu7t3v3__fillcap_16
XFILLER_205_160 VDD VDD VSS VSS gf180mcu_as_sc_mcu7t3v3__fillcap_4
XPHY_EDGE_ROW_92_3_Left_797 VDD VSS gf180mcu_as_sc_mcu7t3v3__tap_2
XTAP_TAPCELL_ROW_195_2249 VDD VSS gf180mcu_as_sc_mcu7t3v3__tap_2
X_4853_ VDD VDD VSS VSS _4854_/C _4853_/C _4872_/B _5850_/A gf180mcu_as_sc_mcu7t3v3__aoi21_2
XFILLER_159_760 VDD VDD VSS VSS gf180mcu_as_sc_mcu7t3v3__fillcap_8
XFILLER_193_505 VDD VDD VSS VSS gf180mcu_as_sc_mcu7t3v3__fillcap_16
X_4784_ VDD VDD VSS VSS _5790_/B _4784_/B _4784_/C _4784_/D _4785_/B gf180mcu_as_sc_mcu7t3v3__ao22_2
X_3804_ VDD VDD VSS VSS _6508_/Q _3804_/B _3804_/C _5798_/B _3805_/D gf180mcu_as_sc_mcu7t3v3__ao22_2
XFILLER_119_624 VDD VDD VSS VSS gf180mcu_as_sc_mcu7t3v3__fillcap_16
X_6523_ VDD VDD VSS VSS _6525_/CLK _6523_/D _6523_/Q gf180mcu_as_sc_mcu7t3v3__dfxtp_2
X_3735_ VDD VDD VSS VSS _6501_/Q _3868_/B _3868_/C _5741_/B _3736_/C gf180mcu_as_sc_mcu7t3v3__ao22_2
XFILLER_109_27 VDD VDD VSS VSS gf180mcu_as_sc_mcu7t3v3__fillcap_16
XPHY_EDGE_ROW_19_1_Left_247 VDD VSS gf180mcu_as_sc_mcu7t3v3__tap_2
XTAP_TAPCELL_ROW_173_1857 VDD VSS gf180mcu_as_sc_mcu7t3v3__tap_2
X_6454_ VDD VDD VSS VSS clkload4/A _6454_/D _6454_/Q gf180mcu_as_sc_mcu7t3v3__dfxtp_2
XFILLER_162_958 VDD VDD VSS VSS gf180mcu_as_sc_mcu7t3v3__fillcap_16
XPHY_EDGE_ROW_77_1_Right_649 VDD VSS gf180mcu_as_sc_mcu7t3v3__tap_2
X_5405_ VDD VDD VSS VSS _6417_/D _5804_/D _5405_/B _5405_/A gf180mcu_as_sc_mcu7t3v3__aoi21_2
X_3666_ VDD VDD VSS VSS _3666_/B _3666_/A _4018_/B gf180mcu_as_sc_mcu7t3v3__and2_2
XTAP_TAPCELL_ROW_214_2588 VDD VSS gf180mcu_as_sc_mcu7t3v3__tap_2
X_6385_ VDD VDD VSS VSS clkload3/A _6385_/D _6385_/Q gf180mcu_as_sc_mcu7t3v3__dfxtp_2
X_3597_ VDD VDD VSS VSS _6525_/Q _4979_/A _4979_/B _4979_/C _5325_/D gf180mcu_as_sc_mcu7t3v3__nand4_2
XTAP_TAPCELL_ROW_214_2599 VDD VSS gf180mcu_as_sc_mcu7t3v3__tap_2
X_5336_ VDD VDD VSS VSS _5336_/A _5336_/B _5652_/B _5337_/D _5652_/A gf180mcu_as_sc_mcu7t3v3__aoi211_2
X_5267_ VDD VDD VSS VSS _5267_/S _5910_/A _5267_/A _5268_/B gf180mcu_as_sc_mcu7t3v3__mux2_2
X_4218_ VDD VDD VSS VSS _4349_/S _6131_/Q _6044_/Q _4220_/A gf180mcu_as_sc_mcu7t3v3__mux2_2
XFILLER_60_1245 VDD VDD VSS VSS gf180mcu_as_sc_mcu7t3v3__fillcap_16
X_5198_ VDD VDD VSS VSS _5217_/S _5849_/A _5198_/A _5199_/C gf180mcu_as_sc_mcu7t3v3__mux2_2
XFILLER_228_274 VDD VDD VSS VSS gf180mcu_as_sc_mcu7t3v3__fillcap_4
XPHY_EDGE_ROW_133_1_Left_361 VDD VSS gf180mcu_as_sc_mcu7t3v3__tap_2
X_4149_ VDD VDD VSS VSS _4215_/A _6196_/Q _4149_/A _4184_/B gf180mcu_as_sc_mcu7t3v3__mux2_2
XFILLER_71_658 VDD VDD VSS VSS gf180mcu_as_sc_mcu7t3v3__fillcap_4
XFILLER_34_45 VDD VDD VSS VSS gf180mcu_as_sc_mcu7t3v3__fillcap_4
XTAP_TAPCELL_ROW_0_1020 VDD VSS gf180mcu_as_sc_mcu7t3v3__tap_2
XFILLER_196_321 VDD VDD VSS VSS gf180mcu_as_sc_mcu7t3v3__fill_2
XFILLER_165_730 VDD VDD VSS VSS gf180mcu_as_sc_mcu7t3v3__fill_2
XFILLER_7_206 VDD VDD VSS VSS gf180mcu_as_sc_mcu7t3v3__fillcap_4
XFILLER_7_228 VDD VDD VSS VSS gf180mcu_as_sc_mcu7t3v3__fillcap_16
Xclkload0 VDD VDD VSS VSS clkload0/A clkload0/Y gf180mcu_as_sc_mcu7t3v3__clkbuff_12
XFILLER_165_752 VDD VDD VSS VSS gf180mcu_as_sc_mcu7t3v3__fill_2
XFILLER_153_936 VDD VDD VSS VSS gf180mcu_as_sc_mcu7t3v3__fillcap_16
XFILLER_180_733 VDD VDD VSS VSS gf180mcu_as_sc_mcu7t3v3__fill_2
XFILLER_152_457 VDD VDD VSS VSS gf180mcu_as_sc_mcu7t3v3__fillcap_4
XFILLER_4_979 VDD VDD VSS VSS gf180mcu_as_sc_mcu7t3v3__fillcap_16
XFILLER_191_1186 VDD VDD VSS VSS gf180mcu_as_sc_mcu7t3v3__fillcap_4
XPHY_EDGE_ROW_65_1_Left_293 VDD VSS gf180mcu_as_sc_mcu7t3v3__tap_2
XFILLER_47_666 VDD VDD VSS VSS gf180mcu_as_sc_mcu7t3v3__fill_1
XPHY_EDGE_ROW_39_1_Right_611 VDD VSS gf180mcu_as_sc_mcu7t3v3__tap_2
XFILLER_207_436 VDD VDD VSS VSS gf180mcu_as_sc_mcu7t3v3__fillcap_16
XFILLER_223_907 VDD VDD VSS VSS gf180mcu_as_sc_mcu7t3v3__fill_2
XFILLER_76_1241 VDD VDD VSS VSS gf180mcu_as_sc_mcu7t3v3__fill_2
XFILLER_37_1214 VDD VDD VSS VSS gf180mcu_as_sc_mcu7t3v3__fill_1
XFILLER_163_1233 VDD VDD VSS VSS gf180mcu_as_sc_mcu7t3v3__fillcap_16
XFILLER_163_1255 VDD VDD VSS VSS gf180mcu_as_sc_mcu7t3v3__fill_1
XFILLER_199_181 VDD VDD VSS VSS gf180mcu_as_sc_mcu7t3v3__fillcap_16
XFILLER_187_376 VDD VDD VSS VSS gf180mcu_as_sc_mcu7t3v3__fill_2
XFILLER_202_163 VDD VDD VSS VSS gf180mcu_as_sc_mcu7t3v3__fill_2
XFILLER_203_697 VDD VDD VSS VSS gf180mcu_as_sc_mcu7t3v3__fill_2
XFILLER_204_1263 VDD VDD VSS VSS gf180mcu_as_sc_mcu7t3v3__fill_2
XFILLER_156_752 VDD VDD VSS VSS gf180mcu_as_sc_mcu7t3v3__fillcap_8
XFILLER_7_740 VDD VDD VSS VSS gf180mcu_as_sc_mcu7t3v3__fillcap_4
XTAP_TAPCELL_ROW_155_1532 VDD VSS gf180mcu_as_sc_mcu7t3v3__tap_2
X_3520_ VDD VDD VSS VSS _3521_/D _5937_/A _5936_/D gf180mcu_as_sc_mcu7t3v3__nand2b_2
XTAP_TAPCELL_ROW_190_2168 VDD VSS gf180mcu_as_sc_mcu7t3v3__tap_2
XTAP_TAPCELL_ROW_190_2157 VDD VSS gf180mcu_as_sc_mcu7t3v3__tap_2
XFILLER_156_785 VDD VDD VSS VSS gf180mcu_as_sc_mcu7t3v3__fill_2
XFILLER_100_1261 VDD VDD VSS VSS gf180mcu_as_sc_mcu7t3v3__fillcap_4
X_3451_ VDD VDD VSS VSS _6721_/A _4584_/A _3458_/B gf180mcu_as_sc_mcu7t3v3__and2_2
XFILLER_83_1212 VDD VDD VSS VSS gf180mcu_as_sc_mcu7t3v3__fill_1
X_6170_ VDD VDD VSS VSS _6526_/CLK _6170_/D _6170_/Q gf180mcu_as_sc_mcu7t3v3__dfxtp_2
X_3382_ VDD VDD VSS VSS _4584_/A _6550_/Q _6715_/A _4444_/A _3382_/D gf180mcu_as_sc_mcu7t3v3__aoi31_2
X_5121_ VDD VDD VSS VSS _5122_/C _5783_/A _5293_/B _5186_/B gf180mcu_as_sc_mcu7t3v3__ao21_2
XFILLER_170_1259 VDD VDD VSS VSS gf180mcu_as_sc_mcu7t3v3__fill_2
XFILLER_211_1234 VDD VDD VSS VSS gf180mcu_as_sc_mcu7t3v3__fill_1
X_5052_ VDD VDD VSS VSS _5228_/S _5721_/A _5052_/A _5053_/B gf180mcu_as_sc_mcu7t3v3__mux2_2
XFILLER_226_734 VDD VDD VSS VSS gf180mcu_as_sc_mcu7t3v3__fill_1
XTAP_TAPCELL_ROW_14_1263 VDD VSS gf180mcu_as_sc_mcu7t3v3__tap_2
XTAP_TAPCELL_ROW_14_1274 VDD VSS gf180mcu_as_sc_mcu7t3v3__tap_2
X_4003_ VDD VDD VSS VSS _4043_/B _4008_/B _4008_/C _6091_/Q _6091_/D gf180mcu_as_sc_mcu7t3v3__ao22_2
XFILLER_38_666 VDD VDD VSS VSS gf180mcu_as_sc_mcu7t3v3__fill_1
XTAP_TAPCELL_ROW_51_2_2925 VDD VSS gf180mcu_as_sc_mcu7t3v3__tap_2
XFILLER_198_608 VDD VDD VSS VSS gf180mcu_as_sc_mcu7t3v3__fill_2
XTAP_TAPCELL_ROW_128_2_3040 VDD VSS gf180mcu_as_sc_mcu7t3v3__tap_2
XFILLER_178_310 VDD VDD VSS VSS gf180mcu_as_sc_mcu7t3v3__fillcap_4
X_5954_ VDD VDD VSS VSS _5954_/A _5954_/B _5954_/C _5954_/D _5955_/B gf180mcu_as_sc_mcu7t3v3__ao211_2
X_5885_ VDD VDD VSS VSS _5947_/B _5885_/A _5891_/C gf180mcu_as_sc_mcu7t3v3__and2_2
X_4905_ VDD VDD VSS VSS _4932_/D _5921_/A _4953_/B _4924_/B gf180mcu_as_sc_mcu7t3v3__ao21_2
XFILLER_221_461 VDD VDD VSS VSS gf180mcu_as_sc_mcu7t3v3__fillcap_4
XFILLER_222_995 VDD VDD VSS VSS gf180mcu_as_sc_mcu7t3v3__fillcap_16
X_4836_ VDD VDD VSS VSS _4836_/B _5978_/A _6360_/D gf180mcu_as_sc_mcu7t3v3__and2_2
XFILLER_14_1011 VDD VDD VSS VSS gf180mcu_as_sc_mcu7t3v3__fillcap_4
XFILLER_14_1033 VDD VDD VSS VSS gf180mcu_as_sc_mcu7t3v3__fillcap_16
XFILLER_166_527 VDD VDD VSS VSS gf180mcu_as_sc_mcu7t3v3__fillcap_8
XFILLER_178_387 VDD VDD VSS VSS gf180mcu_as_sc_mcu7t3v3__fill_1
XTAP_TAPCELL_ROW_216_2628 VDD VSS gf180mcu_as_sc_mcu7t3v3__tap_2
XFILLER_181_508 VDD VDD VSS VSS gf180mcu_as_sc_mcu7t3v3__fillcap_4
X_6506_ VDD VDD VSS VSS _6506_/CLK _6506_/D _6506_/Q gf180mcu_as_sc_mcu7t3v3__dfxtp_2
X_4767_ VDD VDD VSS VSS _5777_/A _4871_/B _4871_/C _5772_/A _4768_/D gf180mcu_as_sc_mcu7t3v3__ao22_2
XFILLER_179_1240 VDD VDD VSS VSS gf180mcu_as_sc_mcu7t3v3__fillcap_16
XFILLER_179_1262 VDD VDD VSS VSS gf180mcu_as_sc_mcu7t3v3__fill_2
XFILLER_4_209 VDD VDD VSS VSS gf180mcu_as_sc_mcu7t3v3__fillcap_4
X_4698_ VDD VDD VSS VSS _4698_/B _4912_/A _6345_/D gf180mcu_as_sc_mcu7t3v3__and2_2
X_3718_ VDD VDD VSS VSS _3889_/B _5726_/A _3719_/D gf180mcu_as_sc_mcu7t3v3__and2_2
XFILLER_174_593 VDD VDD VSS VSS gf180mcu_as_sc_mcu7t3v3__fill_2
X_6437_ VDD VDD VSS VSS _6437_/CLK _6437_/D _6437_/Q gf180mcu_as_sc_mcu7t3v3__dfxtp_2
X_3649_ VDD VDD VSS VSS _3655_/A _3650_/B _3651_/A _3649_/Y gf180mcu_as_sc_mcu7t3v3__nor3_2
XFILLER_115_660 VDD VDD VSS VSS gf180mcu_as_sc_mcu7t3v3__fill_2
XFILLER_161_276 VDD VDD VSS VSS gf180mcu_as_sc_mcu7t3v3__fillcap_4
XPHY_EDGE_ROW_199_Right_67 VDD VSS gf180mcu_as_sc_mcu7t3v3__tap_2
X_6368_ VDD VDD VSS VSS _6368_/CLK _6368_/D _6368_/Q gf180mcu_as_sc_mcu7t3v3__dfxtp_2
XFILLER_161_298 VDD VDD VSS VSS gf180mcu_as_sc_mcu7t3v3__fillcap_16
X_5319_ VDD VDD VSS VSS _5319_/A _5926_/A _5917_/A _5319_/D _5320_/B gf180mcu_as_sc_mcu7t3v3__ao211_2
XFILLER_0_448 VDD VDD VSS VSS gf180mcu_as_sc_mcu7t3v3__fill_1
Xinput305 VDD VDD VSS VSS west_in[11] _5767_/A gf180mcu_as_sc_mcu7t3v3__buff_12
Xinput316 VDD VDD VSS VSS west_in[21] _5848_/A gf180mcu_as_sc_mcu7t3v3__buff_12
Xinput327 VDD VDD VSS VSS west_in[31] wire979/A gf180mcu_as_sc_mcu7t3v3__buff_12
X_6299_ VDD VDD VSS VSS clkload6/A _6299_/D _6299_/Q gf180mcu_as_sc_mcu7t3v3__dfxtp_2
XFILLER_216_1189 VDD VDD VSS VSS gf180mcu_as_sc_mcu7t3v3__fillcap_16
Xinput338 VDD VDD VSS VSS west_in[9] _5751_/A gf180mcu_as_sc_mcu7t3v3__buff_12
XFILLER_151_1170 VDD VDD VSS VSS gf180mcu_as_sc_mcu7t3v3__fillcap_16
XFILLER_151_1192 VDD VDD VSS VSS gf180mcu_as_sc_mcu7t3v3__fillcap_16
XFILLER_29_655 VDD VDD VSS VSS gf180mcu_as_sc_mcu7t3v3__fillcap_4
XFILLER_5_1256 VDD VDD VSS VSS gf180mcu_as_sc_mcu7t3v3__fillcap_4
XFILLER_16_305 VDD VDD VSS VSS gf180mcu_as_sc_mcu7t3v3__fill_1
XFILLER_217_756 VDD VDD VSS VSS gf180mcu_as_sc_mcu7t3v3__fill_2
XFILLER_29_666 VDD VDD VSS VSS gf180mcu_as_sc_mcu7t3v3__fill_1
XFILLER_182_1119 VDD VDD VSS VSS gf180mcu_as_sc_mcu7t3v3__fillcap_16
XTAP_TAPCELL_ROW_0_993 VDD VSS gf180mcu_as_sc_mcu7t3v3__tap_2
XFILLER_223_1116 VDD VDD VSS VSS gf180mcu_as_sc_mcu7t3v3__fillcap_4
XFILLER_223_1138 VDD VDD VSS VSS gf180mcu_as_sc_mcu7t3v3__fillcap_16
XFILLER_184_313 VDD VDD VSS VSS gf180mcu_as_sc_mcu7t3v3__fill_2
XFILLER_184_335 VDD VDD VSS VSS gf180mcu_as_sc_mcu7t3v3__fill_2
XFILLER_200_667 VDD VDD VSS VSS gf180mcu_as_sc_mcu7t3v3__fill_1
XFILLER_177_54 VDD VDD VSS VSS gf180mcu_as_sc_mcu7t3v3__fillcap_4
XFILLER_184_368 VDD VDD VSS VSS gf180mcu_as_sc_mcu7t3v3__fill_2
XANTENNA_9 VDD VDD VSS VSS _6484_/D gf180mcu_as_sc_mcu7t3v3__diode_2
XFILLER_6_27 VDD VDD VSS VSS gf180mcu_as_sc_mcu7t3v3__fillcap_8
XFILLER_153_744 VDD VDD VSS VSS gf180mcu_as_sc_mcu7t3v3__fillcap_4
XFILLER_4_721 VDD VDD VSS VSS gf180mcu_as_sc_mcu7t3v3__fill_2
XTAP_TAPCELL_ROW_150_1440 VDD VSS gf180mcu_as_sc_mcu7t3v3__tap_2
XFILLER_121_630 VDD VDD VSS VSS gf180mcu_as_sc_mcu7t3v3__fillcap_8
XFILLER_121_652 VDD VDD VSS VSS gf180mcu_as_sc_mcu7t3v3__fillcap_8
XFILLER_156_1081 VDD VDD VSS VSS gf180mcu_as_sc_mcu7t3v3__fillcap_4
Xfanout1010 VDD VDD VSS VSS input194/Y _3178_/A gf180mcu_as_sc_mcu7t3v3__buff_12
XFILLER_0_993 VDD VDD VSS VSS gf180mcu_as_sc_mcu7t3v3__fillcap_4
XFILLER_130_1210 VDD VDD VSS VSS gf180mcu_as_sc_mcu7t3v3__fillcap_16
XFILLER_207_200 VDD VDD VSS VSS gf180mcu_as_sc_mcu7t3v3__fillcap_8
XFILLER_228_1049 VDD VDD VSS VSS gf180mcu_as_sc_mcu7t3v3__fill_1
XFILLER_35_658 VDD VDD VSS VSS gf180mcu_as_sc_mcu7t3v3__fillcap_4
XFILLER_163_1030 VDD VDD VSS VSS gf180mcu_as_sc_mcu7t3v3__fillcap_16
XFILLER_222_247 VDD VDD VSS VSS gf180mcu_as_sc_mcu7t3v3__fill_2
XFILLER_163_1052 VDD VDD VSS VSS gf180mcu_as_sc_mcu7t3v3__fillcap_16
XFILLER_203_472 VDD VDD VSS VSS gf180mcu_as_sc_mcu7t3v3__fillcap_8
XFILLER_204_995 VDD VDD VSS VSS gf180mcu_as_sc_mcu7t3v3__fillcap_16
X_5670_ VDD VDD VSS VSS _5670_/Y _5670_/B _5670_/A gf180mcu_as_sc_mcu7t3v3__nor2_2
X_4621_ VDD VDD VSS VSS _4889_/A _4860_/B _4792_/B gf180mcu_as_sc_mcu7t3v3__nor2_2
XFILLER_191_839 VDD VDD VSS VSS gf180mcu_as_sc_mcu7t3v3__fill_1
XPHY_EDGE_ROW_123_3_Left_828 VDD VSS gf180mcu_as_sc_mcu7t3v3__tap_2
XTAP_TAPCELL_ROW_170_1805 VDD VSS gf180mcu_as_sc_mcu7t3v3__tap_2
X_4552_ VDD VDD VSS VSS _6304_/D _6289_/Q _4552_/B _4552_/C gf180mcu_as_sc_mcu7t3v3__ao21_2
XFILLER_156_593 VDD VDD VSS VSS gf180mcu_as_sc_mcu7t3v3__fill_2
XPHY_EDGE_ROW_100_2_Left_541 VDD VSS gf180mcu_as_sc_mcu7t3v3__tap_2
X_4483_ VDD VDD VSS VSS _4504_/A _4484_/B _4538_/S gf180mcu_as_sc_mcu7t3v3__nand2_2
X_3503_ VDD VDD VSS VSS _4624_/C _4272_/A _5945_/A gf180mcu_as_sc_mcu7t3v3__nor2b_2
XTAP_TAPCELL_ROW_211_2536 VDD VSS gf180mcu_as_sc_mcu7t3v3__tap_2
X_6222_ VDD VDD VSS VSS _6506_/CLK _6222_/D _6222_/Q gf180mcu_as_sc_mcu7t3v3__dfxtp_2
X_3434_ VDD VDD VSS VSS _3434_/A _3434_/B _4102_/D _4070_/C _3434_/D gf180mcu_as_sc_mcu7t3v3__aoi31_2
XTAP_TAPCELL_ROW_211_2547 VDD VSS gf180mcu_as_sc_mcu7t3v3__tap_2
XTAP_TAPCELL_ROW_16_1303 VDD VSS gf180mcu_as_sc_mcu7t3v3__tap_2
XFILLER_170_1012 VDD VDD VSS VSS gf180mcu_as_sc_mcu7t3v3__fill_2
XPHY_EDGE_ROW_221_Right_89 VDD VSS gf180mcu_as_sc_mcu7t3v3__tap_2
XTAP_TAPCELL_ROW_16_1314 VDD VSS gf180mcu_as_sc_mcu7t3v3__tap_2
XTAP_TAPCELL_ROW_16_1325 VDD VSS gf180mcu_as_sc_mcu7t3v3__tap_2
X_6153_ VDD VDD VSS VSS _6509_/CLK _6153_/D _6153_/Q gf180mcu_as_sc_mcu7t3v3__dfxtp_2
X_3365_ VDD VDD VSS VSS _6527_/Q _3365_/B _3365_/A _3365_/Y gf180mcu_as_sc_mcu7t3v3__mux2_2
XTAP_TAPCELL_ROW_168_1767 VDD VSS gf180mcu_as_sc_mcu7t3v3__tap_2
Xhold1204 VDD VDD VSS VSS hold1226/Y _6545_/D gf180mcu_as_sc_mcu7t3v3__clkbuff_4
Xhold1215 VDD VDD VSS VSS _6190_/Q _4140_/B gf180mcu_as_sc_mcu7t3v3__clkbuff_4
X_6084_ VDD VDD VSS VSS _6519_/CLK _6084_/D _6084_/Q gf180mcu_as_sc_mcu7t3v3__dfxtp_2
X_5104_ VDD VDD VSS VSS _5106_/C _5195_/B _5104_/A gf180mcu_as_sc_mcu7t3v3__nand2_2
X_3296_ VDD VDD VSS VSS _3296_/B _6172_/Q _3297_/D gf180mcu_as_sc_mcu7t3v3__and2_2
Xhold1226 VDD VDD VSS VSS _6546_/Q hold1226/Y gf180mcu_as_sc_mcu7t3v3__clkbuff_4
X_5035_ VDD VDD VSS VSS _5035_/B _5291_/A _6380_/D gf180mcu_as_sc_mcu7t3v3__and2_2
XFILLER_122_27 VDD VDD VSS VSS gf180mcu_as_sc_mcu7t3v3__fillcap_8
XTAP_TAPCELL_ROW_69_2_2952 VDD VSS gf180mcu_as_sc_mcu7t3v3__tap_2
XTAP_TAPCELL_ROW_209_2498 VDD VSS gf180mcu_as_sc_mcu7t3v3__tap_2
XFILLER_122_49 VDD VDD VSS VSS gf180mcu_as_sc_mcu7t3v3__fill_2
XFILLER_26_625 VDD VDD VSS VSS gf180mcu_as_sc_mcu7t3v3__fill_2
XFILLER_26_647 VDD VDD VSS VSS gf180mcu_as_sc_mcu7t3v3__fill_1
XFILLER_0_1153 VDD VDD VSS VSS gf180mcu_as_sc_mcu7t3v3__fill_2
XFILLER_199_928 VDD VDD VSS VSS gf180mcu_as_sc_mcu7t3v3__fillcap_16
XFILLER_213_214 VDD VDD VSS VSS gf180mcu_as_sc_mcu7t3v3__fill_1
XFILLER_214_748 VDD VDD VSS VSS gf180mcu_as_sc_mcu7t3v3__fillcap_4
XFILLER_226_597 VDD VDD VSS VSS gf180mcu_as_sc_mcu7t3v3__fill_1
XFILLER_0_1164 VDD VDD VSS VSS gf180mcu_as_sc_mcu7t3v3__fill_1
X_5937_ VDD VDD VSS VSS _5938_/A _5937_/A _5951_/B _5937_/C gf180mcu_as_sc_mcu7t3v3__ao21_2
XFILLER_107_1212 VDD VDD VSS VSS gf180mcu_as_sc_mcu7t3v3__fill_1
XFILLER_16_1106 VDD VDD VSS VSS gf180mcu_as_sc_mcu7t3v3__fillcap_8
XFILLER_16_1128 VDD VDD VSS VSS gf180mcu_as_sc_mcu7t3v3__fillcap_16
XFILLER_178_162 VDD VDD VSS VSS gf180mcu_as_sc_mcu7t3v3__fillcap_8
XFILLER_194_611 VDD VDD VSS VSS gf180mcu_as_sc_mcu7t3v3__fill_1
X_5868_ VDD VDD VSS VSS _5868_/B _5893_/A _6472_/D gf180mcu_as_sc_mcu7t3v3__and2_2
XFILLER_194_677 VDD VDD VSS VSS gf180mcu_as_sc_mcu7t3v3__fill_1
X_5799_ VDD VDD VSS VSS _5799_/A _5799_/B _5799_/C _5799_/D _5800_/D gf180mcu_as_sc_mcu7t3v3__ao22_2
X_4819_ VDD VDD VSS VSS _5824_/A _4885_/B _4819_/C _4867_/D _4822_/C gf180mcu_as_sc_mcu7t3v3__ao211_2
XFILLER_194_688 VDD VDD VSS VSS gf180mcu_as_sc_mcu7t3v3__fillcap_16
XPHY_EDGE_ROW_32_2_Left_473 VDD VSS gf180mcu_as_sc_mcu7t3v3__tap_2
XFILLER_147_46 VDD VDD VSS VSS gf180mcu_as_sc_mcu7t3v3__fillcap_4
XFILLER_162_563 VDD VDD VSS VSS gf180mcu_as_sc_mcu7t3v3__fillcap_4
XFILLER_0_212 VDD VDD VSS VSS gf180mcu_as_sc_mcu7t3v3__fill_1
Xinput102 VDD VDD VSS VSS ne_in[24] _5873_/A gf180mcu_as_sc_mcu7t3v3__buff_12
XFILLER_0_278 VDD VDD VSS VSS gf180mcu_as_sc_mcu7t3v3__fill_2
Xinput113 VDD VDD VSS VSS ne_in[34] _5953_/D gf180mcu_as_sc_mcu7t3v3__buff_12
Xinput124 VDD VDD VSS VSS north_in[11] _5765_/B gf180mcu_as_sc_mcu7t3v3__buff_12
Xinput135 VDD VDD VSS VSS north_in[21] _5846_/B gf180mcu_as_sc_mcu7t3v3__buff_12
Xinput146 VDD VDD VSS VSS north_in[31] _5930_/D gf180mcu_as_sc_mcu7t3v3__buff_12
Xinput157 VDD VDD VSS VSS north_in[9] wire1013/A gf180mcu_as_sc_mcu7t3v3__buff_12
Xinput168 VDD VDD VSS VSS nw_in[19] _5833_/A gf180mcu_as_sc_mcu7t3v3__buff_12
Xinput179 VDD VDD VSS VSS nw_in[29] _5914_/A gf180mcu_as_sc_mcu7t3v3__buff_12
XTAP_TAPCELL_ROW_21_2_2880 VDD VSS gf180mcu_as_sc_mcu7t3v3__tap_2
XFILLER_204_225 VDD VDD VSS VSS gf180mcu_as_sc_mcu7t3v3__fillcap_4
XFILLER_189_438 VDD VDD VSS VSS gf180mcu_as_sc_mcu7t3v3__fillcap_16
XFILLER_204_247 VDD VDD VSS VSS gf180mcu_as_sc_mcu7t3v3__fillcap_4
XFILLER_32_639 VDD VDD VSS VSS gf180mcu_as_sc_mcu7t3v3__fill_2
XFILLER_13_842 VDD VDD VSS VSS gf180mcu_as_sc_mcu7t3v3__fillcap_16
XFILLER_158_803 VDD VDD VSS VSS gf180mcu_as_sc_mcu7t3v3__fill_2
XFILLER_201_954 VDD VDD VSS VSS gf180mcu_as_sc_mcu7t3v3__fillcap_16
XFILLER_157_368 VDD VDD VSS VSS gf180mcu_as_sc_mcu7t3v3__fillcap_16
XFILLER_188_97 VDD VDD VSS VSS gf180mcu_as_sc_mcu7t3v3__fill_1
XFILLER_201_998 VDD VDD VSS VSS gf180mcu_as_sc_mcu7t3v3__fillcap_16
XFILLER_200_497 VDD VDD VSS VSS gf180mcu_as_sc_mcu7t3v3__fill_2
XFILLER_197_1170 VDD VDD VSS VSS gf180mcu_as_sc_mcu7t3v3__fillcap_16
XFILLER_197_1192 VDD VDD VSS VSS gf180mcu_as_sc_mcu7t3v3__fillcap_16
XFILLER_207_27 VDD VDD VSS VSS gf180mcu_as_sc_mcu7t3v3__fillcap_16
XFILLER_154_1007 VDD VDD VSS VSS gf180mcu_as_sc_mcu7t3v3__fillcap_8
XFILLER_180_382 VDD VDD VSS VSS gf180mcu_as_sc_mcu7t3v3__fill_2
X_3150_ VDD VDD VSS VSS _4455_/A _4480_/A _4224_/B gf180mcu_as_sc_mcu7t3v3__or2_2
XTAP_TAPCELL_ROW_185_2078 VDD VSS gf180mcu_as_sc_mcu7t3v3__tap_2
XTAP_TAPCELL_ROW_185_2067 VDD VSS gf180mcu_as_sc_mcu7t3v3__tap_2
X_3081_ VDD VDD VSS VSS _4840_/A _5838_/B gf180mcu_as_sc_mcu7t3v3__inv_2
XTAP_TAPCELL_ROW_11_1211 VDD VSS gf180mcu_as_sc_mcu7t3v3__tap_2
XTAP_TAPCELL_ROW_163_1675 VDD VSS gf180mcu_as_sc_mcu7t3v3__tap_2
Xclkbuf_3_6_0_clk_regs VDD VDD VSS VSS clkbuf_0_clk_regs/Y clkbuf_3_6_0_clk_regs/Y
+ gf180mcu_as_sc_mcu7t3v3__clkbuff_12
XFILLER_208_597 VDD VDD VSS VSS gf180mcu_as_sc_mcu7t3v3__fillcap_4
XFILLER_23_606 VDD VDD VSS VSS gf180mcu_as_sc_mcu7t3v3__fill_1
XPHY_EDGE_ROW_28_1_Left_256 VDD VSS gf180mcu_as_sc_mcu7t3v3__tap_2
XFILLER_90_594 VDD VDD VSS VSS gf180mcu_as_sc_mcu7t3v3__fillcap_8
Xclkbuf_leaf_26_clk_regs VDD VDD VSS VSS clkload2/A _6486_/CLK gf180mcu_as_sc_mcu7t3v3__clkbuff_12
X_5722_ VDD VDD VSS VSS _5722_/B _5796_/A _6454_/D gf180mcu_as_sc_mcu7t3v3__and2_2
X_3983_ VDD VDD VSS VSS _5960_/A _5958_/A _4053_/A _3983_/Y _5972_/C gf180mcu_as_sc_mcu7t3v3__aoi31_2
XFILLER_15_190 VDD VDD VSS VSS gf180mcu_as_sc_mcu7t3v3__fillcap_16
XFILLER_188_482 VDD VDD VSS VSS gf180mcu_as_sc_mcu7t3v3__fill_1
XFILLER_204_792 VDD VDD VSS VSS gf180mcu_as_sc_mcu7t3v3__fill_1
XFILLER_31_661 VDD VDD VSS VSS gf180mcu_as_sc_mcu7t3v3__fill_1
X_5653_ VDD VDD VSS VSS _5878_/S _5655_/B _5672_/C _5671_/A gf180mcu_as_sc_mcu7t3v3__nand3_2
XFILLER_11_1014 VDD VDD VSS VSS gf180mcu_as_sc_mcu7t3v3__fillcap_16
X_5584_ VDD VDD VSS VSS _5892_/A _5584_/B _5584_/C _5885_/A _5585_/D gf180mcu_as_sc_mcu7t3v3__ao22_2
X_4604_ VDD VDD VSS VSS _6303_/Q _6302_/Q _6304_/Q _4606_/A gf180mcu_as_sc_mcu7t3v3__nor3_2
XFILLER_176_1221 VDD VDD VSS VSS gf180mcu_as_sc_mcu7t3v3__fillcap_4
XPHY_EDGE_ROW_142_1_Left_370 VDD VSS gf180mcu_as_sc_mcu7t3v3__tap_2
X_4535_ VDD VDD VSS VSS _4537_/S _6298_/Q _6299_/Q _4536_/B gf180mcu_as_sc_mcu7t3v3__mux2_2
XFILLER_117_27 VDD VDD VSS VSS gf180mcu_as_sc_mcu7t3v3__fillcap_16
XFILLER_176_1243 VDD VDD VSS VSS gf180mcu_as_sc_mcu7t3v3__fillcap_16
XFILLER_190_157 VDD VDD VSS VSS gf180mcu_as_sc_mcu7t3v3__fillcap_8
X_4466_ VDD VDD VSS VSS _6272_/D _4466_/A _4478_/A _4466_/C gf180mcu_as_sc_mcu7t3v3__ao21_2
XFILLER_217_1240 VDD VDD VSS VSS gf180mcu_as_sc_mcu7t3v3__fillcap_16
XFILLER_217_1262 VDD VDD VSS VSS gf180mcu_as_sc_mcu7t3v3__fill_2
Xfanout803 VDD VDD VSS VSS _4226_/B _4337_/B gf180mcu_as_sc_mcu7t3v3__buff_12
Xfanout814 VDD VDD VSS VSS _3850_/B _3868_/B gf180mcu_as_sc_mcu7t3v3__buff_12
Xfanout825 VDD VDD VSS VSS _5301_/S _5294_/A gf180mcu_as_sc_mcu7t3v3__buff_12
X_6205_ VDD VDD VSS VSS _6506_/CLK _6205_/D _6205_/Q gf180mcu_as_sc_mcu7t3v3__dfxtp_2
X_4397_ VDD VDD VSS VSS _4405_/S _6125_/Q _4397_/C _4404_/D _4401_/C gf180mcu_as_sc_mcu7t3v3__ao211_2
X_3417_ VDD VDD VSS VSS _6163_/Q _3417_/B _3417_/A _3420_/A gf180mcu_as_sc_mcu7t3v3__mux2_2
XTAP_TAPCELL_ROW_116_2_3022 VDD VSS gf180mcu_as_sc_mcu7t3v3__tap_2
Xfanout836 VDD VDD VSS VSS _4839_/B _4887_/B gf180mcu_as_sc_mcu7t3v3__buff_12
Xfanout847 VDD VDD VSS VSS _4601_/D _4551_/B gf180mcu_as_sc_mcu7t3v3__buff_12
X_6136_ VDD VDD VSS VSS clkload7/A _6136_/D _6136_/Q gf180mcu_as_sc_mcu7t3v3__dfxtp_2
X_3348_ VDD VDD VSS VSS _3356_/A _3348_/B _3348_/C _3348_/D _3348_/Y gf180mcu_as_sc_mcu7t3v3__ao22_2
XTAP_TAPCELL_ROW_228_2852 VDD VSS gf180mcu_as_sc_mcu7t3v3__tap_2
XTAP_TAPCELL_ROW_228_2841 VDD VSS gf180mcu_as_sc_mcu7t3v3__tap_2
XFILLER_100_633 VDD VDD VSS VSS gf180mcu_as_sc_mcu7t3v3__fill_2
XFILLER_218_317 VDD VDD VSS VSS gf180mcu_as_sc_mcu7t3v3__fillcap_4
Xfanout869 VDD VDD VSS VSS _3202_/Y _3280_/B gf180mcu_as_sc_mcu7t3v3__buff_12
XTAP_TAPCELL_ROW_228_2863 VDD VSS gf180mcu_as_sc_mcu7t3v3__tap_2
X_6067_ VDD VDD VSS VSS _6125_/CLK _6067_/D _6067_/Q gf180mcu_as_sc_mcu7t3v3__dfxtp_2
X_3279_ VDD VDD VSS VSS _3280_/D _3280_/B _4499_/D gf180mcu_as_sc_mcu7t3v3__nor2_2
XFILLER_227_884 VDD VDD VSS VSS gf180mcu_as_sc_mcu7t3v3__fill_1
X_5018_ VDD VDD VSS VSS _5019_/D _5691_/A _5138_/B _5132_/B gf180mcu_as_sc_mcu7t3v3__ao21_2
XFILLER_214_523 VDD VDD VSS VSS gf180mcu_as_sc_mcu7t3v3__fill_2
XFILLER_226_383 VDD VDD VSS VSS gf180mcu_as_sc_mcu7t3v3__fill_2
XFILLER_2_1259 VDD VDD VSS VSS gf180mcu_as_sc_mcu7t3v3__fillcap_4
XFILLER_158_6 VDD VDD VSS VSS gf180mcu_as_sc_mcu7t3v3__fillcap_16
XFILLER_198_213 VDD VDD VSS VSS gf180mcu_as_sc_mcu7t3v3__fillcap_4
XFILLER_10_823 VDD VDD VSS VSS gf180mcu_as_sc_mcu7t3v3__fillcap_16
XFILLER_158_34 VDD VDD VSS VSS gf180mcu_as_sc_mcu7t3v3__fill_1
XFILLER_167_666 VDD VDD VSS VSS gf180mcu_as_sc_mcu7t3v3__fill_2
XFILLER_220_1119 VDD VDD VSS VSS gf180mcu_as_sc_mcu7t3v3__fillcap_16
XFILLER_42_45 VDD VDD VSS VSS gf180mcu_as_sc_mcu7t3v3__fillcap_4
XFILLER_120_1242 VDD VDD VSS VSS gf180mcu_as_sc_mcu7t3v3__fill_1
XFILLER_154_349 VDD VDD VSS VSS gf180mcu_as_sc_mcu7t3v3__fillcap_8
XFILLER_5_315 VDD VDD VSS VSS gf180mcu_as_sc_mcu7t3v3__fillcap_8
XFILLER_174_22 VDD VDD VSS VSS gf180mcu_as_sc_mcu7t3v3__fillcap_8
XFILLER_162_360 VDD VDD VSS VSS gf180mcu_as_sc_mcu7t3v3__fill_1
XFILLER_150_533 VDD VDD VSS VSS gf180mcu_as_sc_mcu7t3v3__fill_1
XFILLER_153_1084 VDD VDD VSS VSS gf180mcu_as_sc_mcu7t3v3__fillcap_16
XFILLER_188_1103 VDD VDD VSS VSS gf180mcu_as_sc_mcu7t3v3__fillcap_16
XTAP_TAPCELL_ROW_8_1165 VDD VSS gf180mcu_as_sc_mcu7t3v3__tap_2
XTAP_TAPCELL_ROW_8_1154 VDD VSS gf180mcu_as_sc_mcu7t3v3__tap_2
XFILLER_189_224 VDD VDD VSS VSS gf180mcu_as_sc_mcu7t3v3__fill_1
XFILLER_177_419 VDD VDD VSS VSS gf180mcu_as_sc_mcu7t3v3__fill_1
XFILLER_201_740 VDD VDD VSS VSS gf180mcu_as_sc_mcu7t3v3__fillcap_4
XFILLER_12_171 VDD VDD VSS VSS gf180mcu_as_sc_mcu7t3v3__fillcap_4
XFILLER_160_1033 VDD VDD VSS VSS gf180mcu_as_sc_mcu7t3v3__fillcap_16
XFILLER_12_193 VDD VDD VSS VSS gf180mcu_as_sc_mcu7t3v3__fillcap_16
XFILLER_199_1232 VDD VDD VSS VSS gf180mcu_as_sc_mcu7t3v3__fill_2
XFILLER_201_1030 VDD VDD VSS VSS gf180mcu_as_sc_mcu7t3v3__fillcap_16
XFILLER_201_1052 VDD VDD VSS VSS gf180mcu_as_sc_mcu7t3v3__fillcap_16
XFILLER_218_37 VDD VDD VSS VSS gf180mcu_as_sc_mcu7t3v3__fillcap_16
XFILLER_154_872 VDD VDD VSS VSS gf180mcu_as_sc_mcu7t3v3__fill_2
XFILLER_161_809 VDD VDD VSS VSS gf180mcu_as_sc_mcu7t3v3__fillcap_4
Xoutput417 VDD VDD VSS VSS _6349_/Q north_out[8] gf180mcu_as_sc_mcu7t3v3__buff_12
Xoutput406 VDD VDD VSS VSS _6371_/Q north_out[30] gf180mcu_as_sc_mcu7t3v3__buff_12
Xoutput439 VDD VDD VSS VSS _6405_/Q south_out[28] gf180mcu_as_sc_mcu7t3v3__buff_12
Xoutput428 VDD VDD VSS VSS _6395_/Q south_out[18] gf180mcu_as_sc_mcu7t3v3__buff_12
X_4320_ VDD VDD VSS VSS _4321_/S _6114_/Q _4320_/C _4369_/D _4324_/C gf180mcu_as_sc_mcu7t3v3__ao211_2
XTAP_TAPCELL_ROW_187_2107 VDD VSS gf180mcu_as_sc_mcu7t3v3__tap_2
XFILLER_87_609 VDD VDD VSS VSS gf180mcu_as_sc_mcu7t3v3__fillcap_4
X_4251_ VDD VDD VSS VSS _4251_/D _4283_/A _4251_/B _4251_/C _6204_/D gf180mcu_as_sc_mcu7t3v3__ao31_2
X_3202_ VDD VDD VSS VSS _3202_/Y _4601_/A _6334_/Q gf180mcu_as_sc_mcu7t3v3__nor2_2
XTAP_TAPCELL_ROW_165_1704 VDD VSS gf180mcu_as_sc_mcu7t3v3__tap_2
XTAP_TAPCELL_ROW_165_1715 VDD VSS gf180mcu_as_sc_mcu7t3v3__tap_2
X_4182_ VDD VDD VSS VSS _4362_/D _4182_/B _4182_/A _4185_/C gf180mcu_as_sc_mcu7t3v3__mux2_2
XFILLER_228_648 VDD VDD VSS VSS gf180mcu_as_sc_mcu7t3v3__fillcap_4
XFILLER_95_664 VDD VDD VSS VSS gf180mcu_as_sc_mcu7t3v3__fill_2
X_3133_ VDD VDD VSS VSS _4539_/A _4579_/A _6300_/Q _3134_/C _3136_/B gf180mcu_as_sc_mcu7t3v3__nand4_2
X_3064_ VDD VDD VSS VSS _4994_/A _5673_/B gf180mcu_as_sc_mcu7t3v3__inv_2
XTAP_TAPCELL_ROW_206_2457 VDD VSS gf180mcu_as_sc_mcu7t3v3__tap_2
XTAP_TAPCELL_ROW_206_2446 VDD VSS gf180mcu_as_sc_mcu7t3v3__tap_2
XTAP_TAPCELL_ROW_223_2760 VDD VSS gf180mcu_as_sc_mcu7t3v3__tap_2
XFILLER_208_1239 VDD VDD VSS VSS gf180mcu_as_sc_mcu7t3v3__fill_1
XFILLER_63_594 VDD VDD VSS VSS gf180mcu_as_sc_mcu7t3v3__fillcap_4
XFILLER_17_1234 VDD VDD VSS VSS gf180mcu_as_sc_mcu7t3v3__fillcap_4
XFILLER_195_216 VDD VDD VSS VSS gf180mcu_as_sc_mcu7t3v3__fill_2
X_3966_ VDD VDD VSS VSS _3966_/D _4051_/A _4047_/B _3974_/D _6064_/D gf180mcu_as_sc_mcu7t3v3__ao31_2
XFILLER_143_1242 VDD VDD VSS VSS gf180mcu_as_sc_mcu7t3v3__fillcap_16
XFILLER_149_644 VDD VDD VSS VSS gf180mcu_as_sc_mcu7t3v3__fill_2
XFILLER_149_655 VDD VDD VSS VSS gf180mcu_as_sc_mcu7t3v3__fillcap_16
XFILLER_177_942 VDD VDD VSS VSS gf180mcu_as_sc_mcu7t3v3__fill_1
X_5705_ VDD VDD VSS VSS _5705_/B _5705_/A _6452_/D gf180mcu_as_sc_mcu7t3v3__and2_2
XFILLER_177_975 VDD VDD VSS VSS gf180mcu_as_sc_mcu7t3v3__fillcap_4
XFILLER_177_986 VDD VDD VSS VSS gf180mcu_as_sc_mcu7t3v3__fill_1
XFILLER_192_912 VDD VDD VSS VSS gf180mcu_as_sc_mcu7t3v3__fillcap_16
X_5636_ VDD VDD VSS VSS _5636_/B _5643_/A _6446_/D gf180mcu_as_sc_mcu7t3v3__and2_2
X_3897_ VDD VDD VSS VSS _6518_/Q _3897_/B _3927_/B _5878_/B _3899_/C gf180mcu_as_sc_mcu7t3v3__ao22_2
XFILLER_128_37 VDD VDD VSS VSS gf180mcu_as_sc_mcu7t3v3__fillcap_8
X_5567_ VDD VDD VSS VSS _5569_/C _5873_/A _5567_/B _5567_/C gf180mcu_as_sc_mcu7t3v3__ao21_2
XFILLER_2_329 VDD VDD VSS VSS gf180mcu_as_sc_mcu7t3v3__fill_2
X_5498_ VDD VDD VSS VSS _6428_/D _5498_/B _5804_/D gf180mcu_as_sc_mcu7t3v3__nor2_2
X_4518_ VDD VDD VSS VSS _4520_/S _6719_/A _6293_/Q _4519_/A gf180mcu_as_sc_mcu7t3v3__mux2_2
XFILLER_171_190 VDD VDD VSS VSS gf180mcu_as_sc_mcu7t3v3__fillcap_16
XFILLER_63_1210 VDD VDD VSS VSS gf180mcu_as_sc_mcu7t3v3__fill_2
X_4449_ VDD VDD VSS VSS _4546_/B _6156_/Q _6259_/Q _6259_/D gf180mcu_as_sc_mcu7t3v3__mux2_2
XTAP_TAPCELL_ROW_57_2_2934 VDD VSS gf180mcu_as_sc_mcu7t3v3__tap_2
Xfanout600 VDD VDD VSS VSS _5308_/B _5306_/B gf180mcu_as_sc_mcu7t3v3__buff_12
Xfanout611 VDD VDD VSS VSS wire617/Y _3809_/B gf180mcu_as_sc_mcu7t3v3__buff_12
Xfanout622 VDD VDD VSS VSS _5954_/B _5947_/B gf180mcu_as_sc_mcu7t3v3__buff_12
Xfanout633 VDD VDD VSS VSS _4962_/B _4955_/B gf180mcu_as_sc_mcu7t3v3__buff_12
Xfanout644 VDD VDD VSS VSS _3652_/Y fanout644/Y gf180mcu_as_sc_mcu7t3v3__buff_12
Xfanout655 VDD VDD VSS VSS _5839_/B _5931_/B gf180mcu_as_sc_mcu7t3v3__buff_12
Xfanout666 VDD VDD VSS VSS _5857_/C _5946_/C gf180mcu_as_sc_mcu7t3v3__buff_12
Xfanout677 VDD VDD VSS VSS _5640_/B _5583_/B gf180mcu_as_sc_mcu7t3v3__buff_12
Xfanout699 VDD VDD VSS VSS _4336_/B _4406_/B gf180mcu_as_sc_mcu7t3v3__buff_12
X_6119_ VDD VDD VSS VSS _6506_/CLK _6119_/D _6119_/Q gf180mcu_as_sc_mcu7t3v3__dfxtp_2
XFILLER_199_500 VDD VDD VSS VSS gf180mcu_as_sc_mcu7t3v3__fill_2
XTAP_TAPCELL_ROW_3_1062 VDD VSS gf180mcu_as_sc_mcu7t3v3__tap_2
XFILLER_183_1044 VDD VDD VSS VSS gf180mcu_as_sc_mcu7t3v3__fillcap_4
XFILLER_187_717 VDD VDD VSS VSS gf180mcu_as_sc_mcu7t3v3__fill_2
XFILLER_202_515 VDD VDD VSS VSS gf180mcu_as_sc_mcu7t3v3__fill_2
XFILLER_54_594 VDD VDD VSS VSS gf180mcu_as_sc_mcu7t3v3__fillcap_4
XTAP_TAPCELL_ROW_3_1073 VDD VSS gf180mcu_as_sc_mcu7t3v3__tap_2
XFILLER_169_22 VDD VDD VSS VSS gf180mcu_as_sc_mcu7t3v3__fillcap_16
XFILLER_202_559 VDD VDD VSS VSS gf180mcu_as_sc_mcu7t3v3__fill_1
XFILLER_169_88 VDD VDD VSS VSS gf180mcu_as_sc_mcu7t3v3__fillcap_16
XFILLER_183_912 VDD VDD VSS VSS gf180mcu_as_sc_mcu7t3v3__fillcap_4
XFILLER_194_1151 VDD VDD VSS VSS gf180mcu_as_sc_mcu7t3v3__fillcap_4
XTAP_TAPCELL_ROW_92_2_2986 VDD VSS gf180mcu_as_sc_mcu7t3v3__tap_2
XFILLER_151_842 VDD VDD VSS VSS gf180mcu_as_sc_mcu7t3v3__fillcap_8
XFILLER_194_1173 VDD VDD VSS VSS gf180mcu_as_sc_mcu7t3v3__fillcap_16
XTAP_TAPCELL_ROW_182_2026 VDD VSS gf180mcu_as_sc_mcu7t3v3__tap_2
XTAP_TAPCELL_ROW_182_2015 VDD VSS gf180mcu_as_sc_mcu7t3v3__tap_2
XFILLER_209_125 VDD VDD VSS VSS gf180mcu_as_sc_mcu7t3v3__fillcap_4
XFILLER_77_664 VDD VDD VSS VSS gf180mcu_as_sc_mcu7t3v3__fill_2
XFILLER_209_158 VDD VDD VSS VSS gf180mcu_as_sc_mcu7t3v3__fillcap_4
Xmesh_tile_1043 VDD VDD VSS VSS ne_out[2] gf180mcu_as_sc_mcu7t3v3__tiel_4
XFILLER_225_629 VDD VDD VSS VSS gf180mcu_as_sc_mcu7t3v3__fill_1
Xmesh_tile_1087 VDD VDD VSS VSS nw_out[10] gf180mcu_as_sc_mcu7t3v3__tiel_4
Xmesh_tile_1076 VDD VDD VSS VSS ne_out[35] gf180mcu_as_sc_mcu7t3v3__tiel_4
Xmesh_tile_1065 VDD VDD VSS VSS ne_out[24] gf180mcu_as_sc_mcu7t3v3__tiel_4
Xmesh_tile_1054 VDD VDD VSS VSS ne_out[13] gf180mcu_as_sc_mcu7t3v3__tiel_4
XPHY_EDGE_ROW_132_3_Left_837 VDD VSS gf180mcu_as_sc_mcu7t3v3__tap_2
XTAP_TAPCELL_ROW_160_1623 VDD VSS gf180mcu_as_sc_mcu7t3v3__tap_2
Xmesh_tile_1098 VDD VDD VSS VSS nw_out[21] gf180mcu_as_sc_mcu7t3v3__tiel_4
XFILLER_221_802 VDD VDD VSS VSS gf180mcu_as_sc_mcu7t3v3__fill_2
XFILLER_45_594 VDD VDD VSS VSS gf180mcu_as_sc_mcu7t3v3__fillcap_4
XTAP_TAPCELL_ROW_201_2365 VDD VSS gf180mcu_as_sc_mcu7t3v3__tap_2
XTAP_TAPCELL_ROW_201_2354 VDD VSS gf180mcu_as_sc_mcu7t3v3__tap_2
X_3820_ VDD VDD VSS VSS _4041_/B _5812_/A _3932_/B _3820_/C gf180mcu_as_sc_mcu7t3v3__ao21_2
XTAP_TAPCELL_ROW_197_2291 VDD VSS gf180mcu_as_sc_mcu7t3v3__tap_2
XTAP_TAPCELL_ROW_197_2280 VDD VSS gf180mcu_as_sc_mcu7t3v3__tap_2
XFILLER_177_238 VDD VDD VSS VSS gf180mcu_as_sc_mcu7t3v3__fillcap_8
X_3751_ VDD VDD VSS VSS _5753_/A _3849_/B _3810_/B _3751_/D _3753_/A gf180mcu_as_sc_mcu7t3v3__ao211_2
XFILLER_173_400 VDD VDD VSS VSS gf180mcu_as_sc_mcu7t3v3__fillcap_8
XFILLER_173_422 VDD VDD VSS VSS gf180mcu_as_sc_mcu7t3v3__fillcap_8
XFILLER_185_282 VDD VDD VSS VSS gf180mcu_as_sc_mcu7t3v3__fillcap_4
XFILLER_201_592 VDD VDD VSS VSS gf180mcu_as_sc_mcu7t3v3__fill_1
XTAP_TAPCELL_ROW_158_1585 VDD VSS gf180mcu_as_sc_mcu7t3v3__tap_2
X_6470_ VDD VDD VSS VSS _6474_/CLK _6470_/D _6470_/Q gf180mcu_as_sc_mcu7t3v3__dfxtp_2
X_3682_ VDD VDD VSS VSS _3806_/S _5692_/A _3683_/D gf180mcu_as_sc_mcu7t3v3__and2_2
XFILLER_199_1084 VDD VDD VSS VSS gf180mcu_as_sc_mcu7t3v3__fillcap_16
XFILLER_64_2 VDD VDD VSS VSS gf180mcu_as_sc_mcu7t3v3__fillcap_8
XFILLER_86_1210 VDD VDD VSS VSS gf180mcu_as_sc_mcu7t3v3__fillcap_8
X_5421_ VDD VDD VSS VSS _5568_/C _5421_/B _5421_/A _5422_/B gf180mcu_as_sc_mcu7t3v3__mux2_2
XFILLER_173_488 VDD VDD VSS VSS gf180mcu_as_sc_mcu7t3v3__fill_2
X_5352_ VDD VDD VSS VSS _5659_/A _5659_/B _5369_/B gf180mcu_as_sc_mcu7t3v3__and2_2
XFILLER_153_190 VDD VDD VSS VSS gf180mcu_as_sc_mcu7t3v3__fillcap_16
XFILLER_173_1224 VDD VDD VSS VSS gf180mcu_as_sc_mcu7t3v3__fillcap_16
X_4303_ VDD VDD VSS VSS _4366_/A _4303_/B _4303_/C _4304_/B _4366_/D gf180mcu_as_sc_mcu7t3v3__oai211_2
X_5283_ VDD VDD VSS VSS _5283_/B _5291_/A _6407_/D gf180mcu_as_sc_mcu7t3v3__and2_2
XFILLER_214_1221 VDD VDD VSS VSS gf180mcu_as_sc_mcu7t3v3__fillcap_4
XFILLER_214_1243 VDD VDD VSS VSS gf180mcu_as_sc_mcu7t3v3__fillcap_16
X_4234_ VDD VDD VSS VSS _4348_/D _4234_/B _4234_/A _4235_/B gf180mcu_as_sc_mcu7t3v3__mux2_2
XTAP_TAPCELL_ROW_225_2800 VDD VSS gf180mcu_as_sc_mcu7t3v3__tap_2
X_4165_ VDD VDD VSS VSS _6192_/Q _6191_/Q _4165_/C _4170_/A gf180mcu_as_sc_mcu7t3v3__nor3_2
X_3116_ VDD VDD VSS VSS _6260_/Q _6259_/Q _3172_/A gf180mcu_as_sc_mcu7t3v3__or2_2
XFILLER_216_629 VDD VDD VSS VSS gf180mcu_as_sc_mcu7t3v3__fillcap_4
XPHY_EDGE_ROW_41_2_Left_482 VDD VSS gf180mcu_as_sc_mcu7t3v3__tap_2
XPHY_EDGE_ROW_64_3_Left_769 VDD VSS gf180mcu_as_sc_mcu7t3v3__tap_2
X_4096_ VDD VDD VSS VSS _4098_/S _6717_/A _6156_/Q _6156_/D gf180mcu_as_sc_mcu7t3v3__mux2_2
XTAP_TAPCELL_ROW_221_2719 VDD VSS gf180mcu_as_sc_mcu7t3v3__tap_2
XFILLER_130_27 VDD VDD VSS VSS gf180mcu_as_sc_mcu7t3v3__fillcap_8
XFILLER_167_1028 VDD VDD VSS VSS gf180mcu_as_sc_mcu7t3v3__fillcap_16
XFILLER_215_139 VDD VDD VSS VSS gf180mcu_as_sc_mcu7t3v3__fill_1
X_3047_ VDD VDD VSS VSS _3392_/D _6324_/Q gf180mcu_as_sc_mcu7t3v3__inv_2
XFILLER_130_49 VDD VDD VSS VSS gf180mcu_as_sc_mcu7t3v3__fill_2
XPHY_EDGE_ROW_171_Right_39 VDD VSS gf180mcu_as_sc_mcu7t3v3__tap_2
XTAP_TAPCELL_ROW_178_1939 VDD VSS gf180mcu_as_sc_mcu7t3v3__tap_2
XFILLER_196_569 VDD VDD VSS VSS gf180mcu_as_sc_mcu7t3v3__fillcap_4
X_4998_ VDD VDD VSS VSS _5661_/D _5354_/A _4999_/B gf180mcu_as_sc_mcu7t3v3__nand2b_2
XFILLER_177_772 VDD VDD VSS VSS gf180mcu_as_sc_mcu7t3v3__fill_1
X_3949_ VDD VDD VSS VSS _4030_/B _3962_/C _3963_/B _6053_/Q _6053_/D gf180mcu_as_sc_mcu7t3v3__ao22_2
XFILLER_137_647 VDD VDD VSS VSS gf180mcu_as_sc_mcu7t3v3__fill_2
XFILLER_164_433 VDD VDD VSS VSS gf180mcu_as_sc_mcu7t3v3__fill_1
XFILLER_176_271 VDD VDD VSS VSS gf180mcu_as_sc_mcu7t3v3__fill_1
XFILLER_165_989 VDD VDD VSS VSS gf180mcu_as_sc_mcu7t3v3__fillcap_16
XFILLER_178_1135 VDD VDD VSS VSS gf180mcu_as_sc_mcu7t3v3__fillcap_16
XFILLER_180_904 VDD VDD VSS VSS gf180mcu_as_sc_mcu7t3v3__fill_1
XTAP_TAPCELL_ROW_104_2_3004 VDD VSS gf180mcu_as_sc_mcu7t3v3__tap_2
X_5619_ VDD VDD VSS VSS _5933_/A _5630_/B _5619_/C _5619_/D _5621_/C gf180mcu_as_sc_mcu7t3v3__ao211_2
XFILLER_152_617 VDD VDD VSS VSS gf180mcu_as_sc_mcu7t3v3__fill_2
XFILLER_178_1157 VDD VDD VSS VSS gf180mcu_as_sc_mcu7t3v3__fillcap_16
XPHY_EDGE_ROW_180_Right_48 VDD VSS gf180mcu_as_sc_mcu7t3v3__tap_2
XFILLER_219_1154 VDD VDD VSS VSS gf180mcu_as_sc_mcu7t3v3__fillcap_16
XPHY_EDGE_ROW_105_1_Left_333 VDD VSS gf180mcu_as_sc_mcu7t3v3__tap_2
XFILLER_8_1221 VDD VDD VSS VSS gf180mcu_as_sc_mcu7t3v3__fillcap_4
XFILLER_8_1243 VDD VDD VSS VSS gf180mcu_as_sc_mcu7t3v3__fillcap_16
XFILLER_59_642 VDD VDD VSS VSS gf180mcu_as_sc_mcu7t3v3__fill_1
XFILLER_59_664 VDD VDD VSS VSS gf180mcu_as_sc_mcu7t3v3__fill_2
XFILLER_150_1065 VDD VDD VSS VSS gf180mcu_as_sc_mcu7t3v3__fillcap_16
XTAP_TAPCELL_ROW_5_1102 VDD VSS gf180mcu_as_sc_mcu7t3v3__tap_2
XFILLER_0_18 VDD VDD VSS VSS gf180mcu_as_sc_mcu7t3v3__fillcap_16
XFILLER_150_1087 VDD VDD VSS VSS gf180mcu_as_sc_mcu7t3v3__fillcap_16
XFILLER_189_1264 VDD VDD VSS VSS gf180mcu_as_sc_mcu7t3v3__fill_1
XFILLER_207_618 VDD VDD VSS VSS gf180mcu_as_sc_mcu7t3v3__fill_1
XFILLER_215_640 VDD VDD VSS VSS gf180mcu_as_sc_mcu7t3v3__fill_1
XFILLER_199_352 VDD VDD VSS VSS gf180mcu_as_sc_mcu7t3v3__fillcap_4
XFILLER_226_1103 VDD VDD VSS VSS gf180mcu_as_sc_mcu7t3v3__fillcap_16
XFILLER_27_594 VDD VDD VSS VSS gf180mcu_as_sc_mcu7t3v3__fillcap_4
XFILLER_187_558 VDD VDD VSS VSS gf180mcu_as_sc_mcu7t3v3__fill_2
XFILLER_156_912 VDD VDD VSS VSS gf180mcu_as_sc_mcu7t3v3__fill_1
XFILLER_156_923 VDD VDD VSS VSS gf180mcu_as_sc_mcu7t3v3__fillcap_8
XFILLER_155_422 VDD VDD VSS VSS gf180mcu_as_sc_mcu7t3v3__fillcap_16
XFILLER_196_53 VDD VDD VSS VSS gf180mcu_as_sc_mcu7t3v3__fillcap_16
XFILLER_7_944 VDD VDD VSS VSS gf180mcu_as_sc_mcu7t3v3__fillcap_16
XFILLER_10_472 VDD VDD VSS VSS gf180mcu_as_sc_mcu7t3v3__fill_2
XFILLER_167_293 VDD VDD VSS VSS gf180mcu_as_sc_mcu7t3v3__fillcap_16
XFILLER_6_454 VDD VDD VSS VSS gf180mcu_as_sc_mcu7t3v3__fill_1
Xwire875 VDD VDD VSS VSS _3370_/Y _6721_/A gf180mcu_as_sc_mcu7t3v3__clkbuff_12
XFILLER_155_488 VDD VDD VSS VSS gf180mcu_as_sc_mcu7t3v3__fill_2
XFILLER_157_1208 VDD VDD VSS VSS gf180mcu_as_sc_mcu7t3v3__fillcap_16
XFILLER_182_263 VDD VDD VSS VSS gf180mcu_as_sc_mcu7t3v3__fillcap_4
XPHY_EDGE_ROW_37_1_Left_265 VDD VSS gf180mcu_as_sc_mcu7t3v3__tap_2
XTAP_TAPCELL_ROW_153_1493 VDD VSS gf180mcu_as_sc_mcu7t3v3__tap_2
XFILLER_150_171 VDD VDD VSS VSS gf180mcu_as_sc_mcu7t3v3__fillcap_4
XFILLER_215_27 VDD VDD VSS VSS gf180mcu_as_sc_mcu7t3v3__fillcap_16
XFILLER_150_193 VDD VDD VSS VSS gf180mcu_as_sc_mcu7t3v3__fillcap_16
XFILLER_225_426 VDD VDD VSS VSS gf180mcu_as_sc_mcu7t3v3__fill_2
XFILLER_80_626 VDD VDD VSS VSS gf180mcu_as_sc_mcu7t3v3__fill_1
X_5970_ VDD VDD VSS VSS _5975_/C _5970_/A _5971_/S gf180mcu_as_sc_mcu7t3v3__or2_2
XTAP_TAPCELL_ROW_199_2331 VDD VSS gf180mcu_as_sc_mcu7t3v3__tap_2
XTAP_TAPCELL_ROW_199_2320 VDD VSS gf180mcu_as_sc_mcu7t3v3__tap_2
XFILLER_18_594 VDD VDD VSS VSS gf180mcu_as_sc_mcu7t3v3__fillcap_4
X_4921_ VDD VDD VSS VSS _4921_/B _5977_/A _6369_/D gf180mcu_as_sc_mcu7t3v3__and2_2
XFILLER_178_503 VDD VDD VSS VSS gf180mcu_as_sc_mcu7t3v3__fill_1
XFILLER_178_514 VDD VDD VSS VSS gf180mcu_as_sc_mcu7t3v3__fillcap_4
X_4852_ VDD VDD VSS VSS _4853_/C _5849_/A _4871_/B _4852_/C gf180mcu_as_sc_mcu7t3v3__ao21_2
X_3803_ VDD VDD VSS VSS _4792_/A _3905_/B _3905_/C _3805_/C gf180mcu_as_sc_mcu7t3v3__nor3_2
XFILLER_159_772 VDD VDD VSS VSS gf180mcu_as_sc_mcu7t3v3__fillcap_8
XFILLER_178_569 VDD VDD VSS VSS gf180mcu_as_sc_mcu7t3v3__fill_1
XFILLER_193_528 VDD VDD VSS VSS gf180mcu_as_sc_mcu7t3v3__fillcap_4
X_4783_ VDD VDD VSS VSS _4784_/D _4784_/B _4792_/B _5791_/A gf180mcu_as_sc_mcu7t3v3__aoi21b_2
XFILLER_140_1245 VDD VDD VSS VSS gf180mcu_as_sc_mcu7t3v3__fillcap_16
X_6522_ VDD VDD VSS VSS _6525_/CLK _6522_/D _6522_/Q gf180mcu_as_sc_mcu7t3v3__dfxtp_2
X_3734_ VDD VDD VSS VSS _3867_/B _5745_/A _3741_/D gf180mcu_as_sc_mcu7t3v3__and2_2
XTAP_TAPCELL_ROW_218_2670 VDD VSS gf180mcu_as_sc_mcu7t3v3__tap_2
XTAP_TAPCELL_ROW_173_1847 VDD VSS gf180mcu_as_sc_mcu7t3v3__tap_2
XTAP_TAPCELL_ROW_173_1858 VDD VSS gf180mcu_as_sc_mcu7t3v3__tap_2
X_6453_ VDD VDD VSS VSS clkload4/A _6453_/D _6453_/Q gf180mcu_as_sc_mcu7t3v3__dfxtp_2
X_3665_ VDD VDD VSS VSS _3666_/B _3893_/C _3865_/B _5679_/A gf180mcu_as_sc_mcu7t3v3__aoi21b_2
X_5404_ VDD VDD VSS VSS _5405_/B _5404_/A _5496_/B _5404_/C gf180mcu_as_sc_mcu7t3v3__ao21_2
XTAP_TAPCELL_ROW_214_2589 VDD VSS gf180mcu_as_sc_mcu7t3v3__tap_2
XFILLER_161_436 VDD VDD VSS VSS gf180mcu_as_sc_mcu7t3v3__fill_1
X_6384_ VDD VDD VSS VSS _6527_/CLK _6384_/D _6384_/Q gf180mcu_as_sc_mcu7t3v3__dfxtp_2
X_3596_ VDD VDD VSS VSS _4979_/D _3596_/B _3596_/C _5646_/A gf180mcu_as_sc_mcu7t3v3__nor3_2
XFILLER_0_608 VDD VDD VSS VSS gf180mcu_as_sc_mcu7t3v3__fillcap_4
XFILLER_161_469 VDD VDD VSS VSS gf180mcu_as_sc_mcu7t3v3__fill_1
X_5335_ VDD VDD VSS VSS _5335_/A _5335_/B _5335_/C _5652_/B _5335_/D gf180mcu_as_sc_mcu7t3v3__aoi211_2
XFILLER_125_27 VDD VDD VSS VSS gf180mcu_as_sc_mcu7t3v3__fillcap_16
XFILLER_170_992 VDD VDD VSS VSS gf180mcu_as_sc_mcu7t3v3__fillcap_16
X_5266_ VDD VDD VSS VSS _5908_/A _5306_/B _5266_/C _5266_/D _5267_/A gf180mcu_as_sc_mcu7t3v3__ao211_2
X_4217_ VDD VDD VSS VSS _4217_/A _4217_/B _4217_/C _4221_/C _4243_/A gf180mcu_as_sc_mcu7t3v3__aoi211_2
XFILLER_56_623 VDD VDD VSS VSS gf180mcu_as_sc_mcu7t3v3__fillcap_4
X_5197_ VDD VDD VSS VSS _5197_/D _5297_/A _5197_/B _5197_/C _5198_/A gf180mcu_as_sc_mcu7t3v3__ao31_2
X_4148_ VDD VDD VSS VSS _4148_/Y _6135_/Q _4148_/B _6526_/Q gf180mcu_as_sc_mcu7t3v3__ao21_2
X_4079_ VDD VDD VSS VSS _4085_/S _6716_/A _6139_/Q _6139_/D gf180mcu_as_sc_mcu7t3v3__mux2_2
XFILLER_225_982 VDD VDD VSS VSS gf180mcu_as_sc_mcu7t3v3__fillcap_16
XTAP_TAPCELL_ROW_0_1010 VDD VSS gf180mcu_as_sc_mcu7t3v3__tap_2
XFILLER_169_503 VDD VDD VSS VSS gf180mcu_as_sc_mcu7t3v3__fillcap_4
XTAP_TAPCELL_ROW_0_1021 VDD VSS gf180mcu_as_sc_mcu7t3v3__tap_2
XFILLER_12_737 VDD VDD VSS VSS gf180mcu_as_sc_mcu7t3v3__fill_2
XFILLER_140_6 VDD VDD VSS VSS gf180mcu_as_sc_mcu7t3v3__fillcap_16
XFILLER_180_1014 VDD VDD VSS VSS gf180mcu_as_sc_mcu7t3v3__fill_1
XFILLER_197_856 VDD VDD VSS VSS gf180mcu_as_sc_mcu7t3v3__fillcap_4
XFILLER_169_569 VDD VDD VSS VSS gf180mcu_as_sc_mcu7t3v3__fillcap_8
XTAP_TAPCELL_ROW_128_1_1385 VDD VSS gf180mcu_as_sc_mcu7t3v3__tap_2
Xclkload1 VDD VDD VSS VSS clkload1/A clkload1/Y gf180mcu_as_sc_mcu7t3v3__clkbuff_12
XTAP_TAPCELL_ROW_45_2_2916 VDD VSS gf180mcu_as_sc_mcu7t3v3__tap_2
XFILLER_50_45 VDD VDD VSS VSS gf180mcu_as_sc_mcu7t3v3__fillcap_4
XFILLER_166_78 VDD VDD VSS VSS gf180mcu_as_sc_mcu7t3v3__fillcap_16
XFILLER_4_947 VDD VDD VSS VSS gf180mcu_as_sc_mcu7t3v3__fillcap_16
XFILLER_161_970 VDD VDD VSS VSS gf180mcu_as_sc_mcu7t3v3__fillcap_8
XFILLER_191_1154 VDD VDD VSS VSS gf180mcu_as_sc_mcu7t3v3__fillcap_16
XFILLER_207_404 VDD VDD VSS VSS gf180mcu_as_sc_mcu7t3v3__fillcap_4
XFILLER_228_1209 VDD VDD VSS VSS gf180mcu_as_sc_mcu7t3v3__fillcap_8
XFILLER_222_407 VDD VDD VSS VSS gf180mcu_as_sc_mcu7t3v3__fill_1
XTAP_TAPCELL_ROW_100_1_1371 VDD VSS gf180mcu_as_sc_mcu7t3v3__tap_2
XFILLER_15_531 VDD VDD VSS VSS gf180mcu_as_sc_mcu7t3v3__fillcap_4
XFILLER_203_632 VDD VDD VSS VSS gf180mcu_as_sc_mcu7t3v3__fillcap_4
XFILLER_215_492 VDD VDD VSS VSS gf180mcu_as_sc_mcu7t3v3__fillcap_4
XTAP_TAPCELL_ROW_80_2_2968 VDD VSS gf180mcu_as_sc_mcu7t3v3__tap_2
XTAP_TAPCELL_ROW_155_1533 VDD VSS gf180mcu_as_sc_mcu7t3v3__tap_2
XTAP_TAPCELL_ROW_190_2169 VDD VSS gf180mcu_as_sc_mcu7t3v3__tap_2
XTAP_TAPCELL_ROW_190_2158 VDD VSS gf180mcu_as_sc_mcu7t3v3__tap_2
XFILLER_170_233 VDD VDD VSS VSS gf180mcu_as_sc_mcu7t3v3__fill_2
XFILLER_196_1065 VDD VDD VSS VSS gf180mcu_as_sc_mcu7t3v3__fillcap_16
XFILLER_196_1087 VDD VDD VSS VSS gf180mcu_as_sc_mcu7t3v3__fillcap_16
XFILLER_6_295 VDD VDD VSS VSS gf180mcu_as_sc_mcu7t3v3__fillcap_16
X_3450_ VDD VDD VSS VSS _6550_/D _3457_/B _6330_/Q _6329_/D gf180mcu_as_sc_mcu7t3v3__mux2_2
XFILLER_124_661 VDD VDD VSS VSS gf180mcu_as_sc_mcu7t3v3__fillcap_4
XFILLER_226_37 VDD VDD VSS VSS gf180mcu_as_sc_mcu7t3v3__fillcap_16
X_3381_ VDD VDD VSS VSS _3382_/D _4585_/A _6317_/Q gf180mcu_as_sc_mcu7t3v3__nor2b_2
XFILLER_170_1205 VDD VDD VSS VSS gf180mcu_as_sc_mcu7t3v3__fillcap_16
X_5120_ VDD VDD VSS VSS _5781_/A _5183_/B _5184_/B _5784_/A _5122_/B gf180mcu_as_sc_mcu7t3v3__ao22_2
XFILLER_170_1227 VDD VDD VSS VSS gf180mcu_as_sc_mcu7t3v3__fillcap_16
X_5051_ VDD VDD VSS VSS _5720_/A _5144_/B _5051_/C _5051_/D _5052_/A gf180mcu_as_sc_mcu7t3v3__ao211_2
XFILLER_211_1224 VDD VDD VSS VSS gf180mcu_as_sc_mcu7t3v3__fillcap_8
X_4002_ VDD VDD VSS VSS _4041_/B _4002_/B _4002_/C _6090_/Q _6090_/D gf180mcu_as_sc_mcu7t3v3__ao22_2
XTAP_TAPCELL_ROW_14_1264 VDD VSS gf180mcu_as_sc_mcu7t3v3__tap_2
XFILLER_1_72 VDD VDD VSS VSS gf180mcu_as_sc_mcu7t3v3__fillcap_16
XFILLER_20_1241 VDD VDD VSS VSS gf180mcu_as_sc_mcu7t3v3__fill_2
XFILLER_214_908 VDD VDD VSS VSS gf180mcu_as_sc_mcu7t3v3__fill_1
XFILLER_225_212 VDD VDD VSS VSS gf180mcu_as_sc_mcu7t3v3__fill_1
XFILLER_207_960 VDD VDD VSS VSS gf180mcu_as_sc_mcu7t3v3__fillcap_16
XFILLER_225_278 VDD VDD VSS VSS gf180mcu_as_sc_mcu7t3v3__fill_2
XFILLER_168_1189 VDD VDD VSS VSS gf180mcu_as_sc_mcu7t3v3__fillcap_16
XFILLER_206_481 VDD VDD VSS VSS gf180mcu_as_sc_mcu7t3v3__fill_2
XFILLER_207_982 VDD VDD VSS VSS gf180mcu_as_sc_mcu7t3v3__fillcap_16
XFILLER_213_429 VDD VDD VSS VSS gf180mcu_as_sc_mcu7t3v3__fillcap_4
X_5953_ VDD VDD VSS VSS _5953_/A _5953_/B _5953_/C _5953_/D _5954_/D gf180mcu_as_sc_mcu7t3v3__ao22_2
XFILLER_222_963 VDD VDD VSS VSS gf180mcu_as_sc_mcu7t3v3__fillcap_16
X_5884_ VDD VDD VSS VSS _5884_/B _5956_/A _6474_/D gf180mcu_as_sc_mcu7t3v3__and2_2
X_4904_ VDD VDD VSS VSS _5898_/A _4959_/B _4953_/C _5897_/D _4906_/C gf180mcu_as_sc_mcu7t3v3__ao22_2
XFILLER_209_1186 VDD VDD VSS VSS gf180mcu_as_sc_mcu7t3v3__fillcap_4
X_4835_ VDD VDD VSS VSS _4965_/S _4835_/B _5835_/A _4836_/B gf180mcu_as_sc_mcu7t3v3__mux2_2
XTAP_TAPCELL_ROW_50_1_1346 VDD VSS gf180mcu_as_sc_mcu7t3v3__tap_2
X_4766_ VDD VDD VSS VSS _6505_/Q _4880_/B _4766_/C _4766_/D _4768_/C gf180mcu_as_sc_mcu7t3v3__ao22_2
XTAP_TAPCELL_ROW_216_2629 VDD VSS gf180mcu_as_sc_mcu7t3v3__tap_2
XFILLER_193_347 VDD VDD VSS VSS gf180mcu_as_sc_mcu7t3v3__fill_2
X_6505_ VDD VDD VSS VSS _6517_/CLK _6505_/D _6505_/Q gf180mcu_as_sc_mcu7t3v3__dfxtp_2
X_3717_ VDD VDD VSS VSS _5724_/B _3886_/C _3717_/C _3717_/D _3719_/C gf180mcu_as_sc_mcu7t3v3__ao211_2
XFILLER_162_701 VDD VDD VSS VSS gf180mcu_as_sc_mcu7t3v3__fill_2
X_4697_ VDD VDD VSS VSS _4797_/S _4697_/B _5712_/A _4698_/B gf180mcu_as_sc_mcu7t3v3__mux2_2
XFILLER_162_734 VDD VDD VSS VSS gf180mcu_as_sc_mcu7t3v3__fill_1
XFILLER_175_1116 VDD VDD VSS VSS gf180mcu_as_sc_mcu7t3v3__fillcap_4
XFILLER_175_1138 VDD VDD VSS VSS gf180mcu_as_sc_mcu7t3v3__fillcap_16
XFILLER_20_37 VDD VDD VSS VSS gf180mcu_as_sc_mcu7t3v3__fillcap_8
X_6436_ VDD VDD VSS VSS _6437_/CLK _6436_/D _6436_/Q gf180mcu_as_sc_mcu7t3v3__dfxtp_2
X_3648_ VDD VDD VSS VSS _3982_/B _6486_/Q _3648_/Y gf180mcu_as_sc_mcu7t3v3__and2_2
XFILLER_136_37 VDD VDD VSS VSS gf180mcu_as_sc_mcu7t3v3__fillcap_8
XFILLER_161_244 VDD VDD VSS VSS gf180mcu_as_sc_mcu7t3v3__fillcap_16
X_6367_ VDD VDD VSS VSS _6368_/CLK _6367_/D _6367_/Q gf180mcu_as_sc_mcu7t3v3__dfxtp_2
X_3579_ VDD VDD VSS VSS _3585_/C _5329_/A _5930_/D _5329_/C gf180mcu_as_sc_mcu7t3v3__ao21_2
XFILLER_216_1135 VDD VDD VSS VSS gf180mcu_as_sc_mcu7t3v3__fillcap_16
X_5318_ VDD VDD VSS VSS _6412_/D _5909_/D _5318_/B _5318_/A gf180mcu_as_sc_mcu7t3v3__aoi21b_2
XFILLER_130_631 VDD VDD VSS VSS gf180mcu_as_sc_mcu7t3v3__fill_1
XFILLER_216_1157 VDD VDD VSS VSS gf180mcu_as_sc_mcu7t3v3__fillcap_16
Xinput306 VDD VDD VSS VSS west_in[12] _5776_/A gf180mcu_as_sc_mcu7t3v3__buff_12
Xinput317 VDD VDD VSS VSS west_in[22] _5856_/A gf180mcu_as_sc_mcu7t3v3__buff_12
X_6298_ VDD VDD VSS VSS clkload5/A _6298_/D _6298_/Q gf180mcu_as_sc_mcu7t3v3__dfxtp_2
XFILLER_5_1224 VDD VDD VSS VSS gf180mcu_as_sc_mcu7t3v3__fillcap_16
Xinput328 VDD VDD VSS VSS west_in[32] wire978/A gf180mcu_as_sc_mcu7t3v3__buff_12
X_5249_ VDD VDD VSS VSS _5900_/A _5304_/B _5296_/C _5899_/A _5257_/C gf180mcu_as_sc_mcu7t3v3__ao22_2
XFILLER_152_69 VDD VDD VSS VSS gf180mcu_as_sc_mcu7t3v3__fillcap_16
XFILLER_29_623 VDD VDD VSS VSS gf180mcu_as_sc_mcu7t3v3__fillcap_16
XFILLER_205_908 VDD VDD VSS VSS gf180mcu_as_sc_mcu7t3v3__fill_2
XFILLER_216_234 VDD VDD VSS VSS gf180mcu_as_sc_mcu7t3v3__fill_1
XFILLER_188_119 VDD VDD VSS VSS gf180mcu_as_sc_mcu7t3v3__fillcap_8
XFILLER_197_642 VDD VDD VSS VSS gf180mcu_as_sc_mcu7t3v3__fillcap_8
XFILLER_227_1264 VDD VDD VSS VSS gf180mcu_as_sc_mcu7t3v3__fill_1
XTAP_TAPCELL_ROW_0_994 VDD VSS gf180mcu_as_sc_mcu7t3v3__tap_2
XFILLER_200_613 VDD VDD VSS VSS gf180mcu_as_sc_mcu7t3v3__fillcap_16
XFILLER_12_567 VDD VDD VSS VSS gf180mcu_as_sc_mcu7t3v3__fillcap_8
XFILLER_12_589 VDD VDD VSS VSS gf180mcu_as_sc_mcu7t3v3__fillcap_4
XFILLER_157_528 VDD VDD VSS VSS gf180mcu_as_sc_mcu7t3v3__fillcap_16
XFILLER_177_22 VDD VDD VSS VSS gf180mcu_as_sc_mcu7t3v3__fillcap_16
XFILLER_185_837 VDD VDD VSS VSS gf180mcu_as_sc_mcu7t3v3__fill_2
XFILLER_196_163 VDD VDD VSS VSS gf180mcu_as_sc_mcu7t3v3__fill_1
XPHY_EDGE_ROW_129_2_Left_570 VDD VSS gf180mcu_as_sc_mcu7t3v3__tap_2
XFILLER_200_679 VDD VDD VSS VSS gf180mcu_as_sc_mcu7t3v3__fillcap_16
XFILLER_193_43 VDD VDD VSS VSS gf180mcu_as_sc_mcu7t3v3__fillcap_16
XFILLER_3_254 VDD VDD VSS VSS gf180mcu_as_sc_mcu7t3v3__fill_1
XPHY_EDGE_ROW_141_3_Left_846 VDD VSS gf180mcu_as_sc_mcu7t3v3__tap_2
XTAP_TAPCELL_ROW_150_1441 VDD VSS gf180mcu_as_sc_mcu7t3v3__tap_2
XFILLER_4_799 VDD VDD VSS VSS gf180mcu_as_sc_mcu7t3v3__fillcap_4
XFILLER_3_298 VDD VDD VSS VSS gf180mcu_as_sc_mcu7t3v3__fill_2
Xfanout1000 VDD VDD VSS VSS _4248_/A _3598_/B gf180mcu_as_sc_mcu7t3v3__buff_12
XFILLER_0_972 VDD VDD VSS VSS gf180mcu_as_sc_mcu7t3v3__fill_1
XFILLER_121_664 VDD VDD VSS VSS gf180mcu_as_sc_mcu7t3v3__fill_2
XFILLER_207_223 VDD VDD VSS VSS gf180mcu_as_sc_mcu7t3v3__fill_2
XFILLER_208_779 VDD VDD VSS VSS gf180mcu_as_sc_mcu7t3v3__fill_1
XFILLER_228_1017 VDD VDD VSS VSS gf180mcu_as_sc_mcu7t3v3__fill_2
XFILLER_223_727 VDD VDD VSS VSS gf180mcu_as_sc_mcu7t3v3__fillcap_4
XFILLER_228_1028 VDD VDD VSS VSS gf180mcu_as_sc_mcu7t3v3__fill_1
XFILLER_204_963 VDD VDD VSS VSS gf180mcu_as_sc_mcu7t3v3__fillcap_16
XFILLER_50_618 VDD VDD VSS VSS gf180mcu_as_sc_mcu7t3v3__fillcap_8
XFILLER_50_629 VDD VDD VSS VSS gf180mcu_as_sc_mcu7t3v3__fill_2
XFILLER_188_675 VDD VDD VSS VSS gf180mcu_as_sc_mcu7t3v3__fill_2
XTAP_TAPCELL_ROW_98_2_2995 VDD VSS gf180mcu_as_sc_mcu7t3v3__tap_2
X_4620_ VDD VDD VSS VSS _4620_/Y _4977_/C _4620_/B _4620_/A gf180mcu_as_sc_mcu7t3v3__aoi21_2
XFILLER_50_1245 VDD VDD VSS VSS gf180mcu_as_sc_mcu7t3v3__fillcap_16
XTAP_TAPCELL_ROW_170_1806 VDD VSS gf180mcu_as_sc_mcu7t3v3__tap_2
X_4551_ VDD VDD VSS VSS _6149_/Q _4551_/B _4551_/C _6304_/Q _4552_/C gf180mcu_as_sc_mcu7t3v3__ao22_2
XFILLER_171_520 VDD VDD VSS VSS gf180mcu_as_sc_mcu7t3v3__fill_1
XFILLER_190_339 VDD VDD VSS VSS gf180mcu_as_sc_mcu7t3v3__fill_1
XPHY_EDGE_ROW_73_3_Left_778 VDD VSS gf180mcu_as_sc_mcu7t3v3__tap_2
Xwire491 VDD VDD VSS VSS _5917_/Y _6478_/D gf180mcu_as_sc_mcu7t3v3__clkbuff_12
X_4482_ VDD VDD VSS VSS _4484_/B _4538_/S _4503_/C gf180mcu_as_sc_mcu7t3v3__and2_2
X_3502_ VDD VDD VSS VSS _4624_/B _4272_/A _5945_/A gf180mcu_as_sc_mcu7t3v3__nand2b_2
XTAP_TAPCELL_ROW_211_2537 VDD VSS gf180mcu_as_sc_mcu7t3v3__tap_2
XPHY_EDGE_ROW_50_2_Left_491 VDD VSS gf180mcu_as_sc_mcu7t3v3__tap_2
X_6221_ VDD VDD VSS VSS _6519_/CLK _6221_/D _6221_/Q gf180mcu_as_sc_mcu7t3v3__dfxtp_2
X_3433_ VDD VDD VSS VSS _4102_/D _3433_/B _6264_/Q gf180mcu_as_sc_mcu7t3v3__nand2_2
XTAP_TAPCELL_ROW_211_2548 VDD VSS gf180mcu_as_sc_mcu7t3v3__tap_2
XTAP_TAPCELL_ROW_16_1304 VDD VSS gf180mcu_as_sc_mcu7t3v3__tap_2
X_6152_ VDD VDD VSS VSS _6509_/CLK _6152_/D _6152_/Q gf180mcu_as_sc_mcu7t3v3__dfxtp_2
XFILLER_112_631 VDD VDD VSS VSS gf180mcu_as_sc_mcu7t3v3__fill_1
XTAP_TAPCELL_ROW_16_1315 VDD VSS gf180mcu_as_sc_mcu7t3v3__tap_2
XTAP_TAPCELL_ROW_16_1326 VDD VSS gf180mcu_as_sc_mcu7t3v3__tap_2
X_5103_ VDD VDD VSS VSS _5222_/B _5103_/B _5103_/C _5195_/B _5106_/B gf180mcu_as_sc_mcu7t3v3__ao211_2
X_3364_ VDD VDD VSS VSS _3364_/A _3364_/B _3364_/C _3364_/D _3364_/Y gf180mcu_as_sc_mcu7t3v3__ao22_2
XTAP_TAPCELL_ROW_168_1757 VDD VSS gf180mcu_as_sc_mcu7t3v3__tap_2
XTAP_TAPCELL_ROW_168_1768 VDD VSS gf180mcu_as_sc_mcu7t3v3__tap_2
Xhold1205 VDD VDD VSS VSS hold1228/Y _6536_/D gf180mcu_as_sc_mcu7t3v3__clkbuff_4
Xhold1216 VDD VDD VSS VSS _6134_/Q _4069_/C gf180mcu_as_sc_mcu7t3v3__clkbuff_4
X_6083_ VDD VDD VSS VSS _6371_/CLK _6083_/D _6083_/Q gf180mcu_as_sc_mcu7t3v3__dfxtp_2
X_3295_ VDD VDD VSS VSS _3299_/A _3295_/B _3295_/C _3295_/D _3295_/Y gf180mcu_as_sc_mcu7t3v3__ao22_2
Xhold1227 VDD VDD VSS VSS _6539_/Q hold1227/Y gf180mcu_as_sc_mcu7t3v3__clkbuff_4
X_5034_ VDD VDD VSS VSS _5267_/S _5704_/A _5034_/A _5035_/B gf180mcu_as_sc_mcu7t3v3__mux2_2
XTAP_TAPCELL_ROW_209_2499 VDD VSS gf180mcu_as_sc_mcu7t3v3__tap_2
XFILLER_199_907 VDD VDD VSS VSS gf180mcu_as_sc_mcu7t3v3__fill_2
XFILLER_214_705 VDD VDD VSS VSS gf180mcu_as_sc_mcu7t3v3__fill_2
XFILLER_0_1121 VDD VDD VSS VSS gf180mcu_as_sc_mcu7t3v3__fill_1
XFILLER_26_659 VDD VDD VSS VSS gf180mcu_as_sc_mcu7t3v3__fillcap_8
X_5936_ VDD VDD VSS VSS _6522_/Q _5936_/B _5950_/C _5936_/D _5937_/C gf180mcu_as_sc_mcu7t3v3__ao22_2
XFILLER_166_314 VDD VDD VSS VSS gf180mcu_as_sc_mcu7t3v3__fill_1
XFILLER_178_174 VDD VDD VSS VSS gf180mcu_as_sc_mcu7t3v3__fill_1
XFILLER_181_1186 VDD VDD VSS VSS gf180mcu_as_sc_mcu7t3v3__fillcap_4
XFILLER_210_944 VDD VDD VSS VSS gf180mcu_as_sc_mcu7t3v3__fill_1
XPHY_EDGE_ROW_114_1_Left_342 VDD VSS gf180mcu_as_sc_mcu7t3v3__tap_2
X_5867_ VDD VDD VSS VSS _5875_/S _5867_/B _5867_/A _5868_/B gf180mcu_as_sc_mcu7t3v3__mux2_2
X_5798_ VDD VDD VSS VSS _5798_/S _5798_/B _6508_/Q _5799_/C gf180mcu_as_sc_mcu7t3v3__mux2_2
X_4818_ VDD VDD VSS VSS _4945_/B _5821_/A _4819_/C gf180mcu_as_sc_mcu7t3v3__and2_2
XFILLER_147_14 VDD VDD VSS VSS gf180mcu_as_sc_mcu7t3v3__fill_1
XFILLER_154_509 VDD VDD VSS VSS gf180mcu_as_sc_mcu7t3v3__fillcap_16
XFILLER_181_306 VDD VDD VSS VSS gf180mcu_as_sc_mcu7t3v3__fill_2
XFILLER_193_166 VDD VDD VSS VSS gf180mcu_as_sc_mcu7t3v3__fill_1
X_4749_ VDD VDD VSS VSS _5760_/A _4862_/B _4856_/B _5756_/A _4750_/D gf180mcu_as_sc_mcu7t3v3__ao22_2
XFILLER_147_594 VDD VDD VSS VSS gf180mcu_as_sc_mcu7t3v3__fillcap_8
XFILLER_162_542 VDD VDD VSS VSS gf180mcu_as_sc_mcu7t3v3__fill_1
X_6419_ VDD VDD VSS VSS _6437_/CLK _6419_/D _6419_/Q gf180mcu_as_sc_mcu7t3v3__dfxtp_2
XFILLER_150_737 VDD VDD VSS VSS gf180mcu_as_sc_mcu7t3v3__fillcap_16
XFILLER_162_597 VDD VDD VSS VSS gf180mcu_as_sc_mcu7t3v3__fillcap_8
XFILLER_0_246 VDD VDD VSS VSS gf180mcu_as_sc_mcu7t3v3__fill_1
XFILLER_153_1233 VDD VDD VSS VSS gf180mcu_as_sc_mcu7t3v3__fillcap_16
XFILLER_1_769 VDD VDD VSS VSS gf180mcu_as_sc_mcu7t3v3__fill_1
XFILLER_27_1214 VDD VDD VSS VSS gf180mcu_as_sc_mcu7t3v3__fill_1
XFILLER_103_664 VDD VDD VSS VSS gf180mcu_as_sc_mcu7t3v3__fill_2
XFILLER_153_1255 VDD VDD VSS VSS gf180mcu_as_sc_mcu7t3v3__fill_1
Xinput103 VDD VDD VSS VSS ne_in[25] _5881_/D gf180mcu_as_sc_mcu7t3v3__buff_12
Xinput114 VDD VDD VSS VSS ne_in[35] _5346_/A gf180mcu_as_sc_mcu7t3v3__buff_12
Xinput125 VDD VDD VSS VSS north_in[12] _5774_/B gf180mcu_as_sc_mcu7t3v3__buff_12
Xinput136 VDD VDD VSS VSS north_in[22] _5854_/B gf180mcu_as_sc_mcu7t3v3__buff_12
Xinput147 VDD VDD VSS VSS north_in[32] _3570_/B gf180mcu_as_sc_mcu7t3v3__buff_12
Xinput158 VDD VDD VSS VSS nw_in[0] _5669_/A gf180mcu_as_sc_mcu7t3v3__buff_12
Xinput169 VDD VDD VSS VSS nw_in[1] _5685_/A gf180mcu_as_sc_mcu7t3v3__buff_12
XFILLER_56_33 VDD VDD VSS VSS gf180mcu_as_sc_mcu7t3v3__fill_2
XFILLER_205_749 VDD VDD VSS VSS gf180mcu_as_sc_mcu7t3v3__fill_1
XFILLER_16_158 VDD VDD VSS VSS gf180mcu_as_sc_mcu7t3v3__fillcap_8
XFILLER_198_940 VDD VDD VSS VSS gf180mcu_as_sc_mcu7t3v3__fillcap_4
XFILLER_201_922 VDD VDD VSS VSS gf180mcu_as_sc_mcu7t3v3__fillcap_16
XPHY_EDGE_ROW_46_1_Left_274 VDD VSS gf180mcu_as_sc_mcu7t3v3__tap_2
XFILLER_157_314 VDD VDD VSS VSS gf180mcu_as_sc_mcu7t3v3__fillcap_16
XFILLER_169_174 VDD VDD VSS VSS gf180mcu_as_sc_mcu7t3v3__fillcap_16
XFILLER_198_995 VDD VDD VSS VSS gf180mcu_as_sc_mcu7t3v3__fillcap_16
XFILLER_9_836 VDD VDD VSS VSS gf180mcu_as_sc_mcu7t3v3__fillcap_4
XFILLER_160_1259 VDD VDD VSS VSS gf180mcu_as_sc_mcu7t3v3__fill_2
XFILLER_200_443 VDD VDD VSS VSS gf180mcu_as_sc_mcu7t3v3__fill_1
XFILLER_9_858 VDD VDD VSS VSS gf180mcu_as_sc_mcu7t3v3__fillcap_16
XFILLER_172_306 VDD VDD VSS VSS gf180mcu_as_sc_mcu7t3v3__fillcap_8
XFILLER_184_177 VDD VDD VSS VSS gf180mcu_as_sc_mcu7t3v3__fill_2
XFILLER_201_1234 VDD VDD VSS VSS gf180mcu_as_sc_mcu7t3v3__fill_1
XFILLER_193_1046 VDD VDD VSS VSS gf180mcu_as_sc_mcu7t3v3__fillcap_4
XFILLER_193_1068 VDD VDD VSS VSS gf180mcu_as_sc_mcu7t3v3__fillcap_16
XFILLER_80_1238 VDD VDD VSS VSS gf180mcu_as_sc_mcu7t3v3__fillcap_4
XTAP_TAPCELL_ROW_185_2079 VDD VSS gf180mcu_as_sc_mcu7t3v3__tap_2
XTAP_TAPCELL_ROW_185_2068 VDD VSS gf180mcu_as_sc_mcu7t3v3__tap_2
X_3080_ VDD VDD VSS VSS _5177_/A _5830_/B gf180mcu_as_sc_mcu7t3v3__inv_2
XTAP_TAPCELL_ROW_11_1212 VDD VSS gf180mcu_as_sc_mcu7t3v3__tap_2
XFILLER_169_1240 VDD VDD VSS VSS gf180mcu_as_sc_mcu7t3v3__fillcap_16
XFILLER_208_543 VDD VDD VSS VSS gf180mcu_as_sc_mcu7t3v3__fillcap_8
XFILLER_169_1262 VDD VDD VSS VSS gf180mcu_as_sc_mcu7t3v3__fill_2
XTAP_TAPCELL_ROW_163_1676 VDD VSS gf180mcu_as_sc_mcu7t3v3__tap_2
XFILLER_23_618 VDD VDD VSS VSS gf180mcu_as_sc_mcu7t3v3__fillcap_8
X_3982_ VDD VDD VSS VSS _3982_/B _5960_/A _3982_/Y gf180mcu_as_sc_mcu7t3v3__and2_2
XTAP_TAPCELL_ROW_180_1990 VDD VSS gf180mcu_as_sc_mcu7t3v3__tap_2
XFILLER_94_2 VDD VDD VSS VSS gf180mcu_as_sc_mcu7t3v3__fill_2
XPHY_EDGE_ROW_110_2_Right_947 VDD VSS gf180mcu_as_sc_mcu7t3v3__tap_2
X_5721_ VDD VDD VSS VSS _5795_/S _5721_/B _5721_/A _5722_/B gf180mcu_as_sc_mcu7t3v3__mux2_2
XFILLER_149_815 VDD VDD VSS VSS gf180mcu_as_sc_mcu7t3v3__fill_1
XFILLER_164_807 VDD VDD VSS VSS gf180mcu_as_sc_mcu7t3v3__fillcap_4
XFILLER_188_494 VDD VDD VSS VSS gf180mcu_as_sc_mcu7t3v3__fill_2
XFILLER_206_1189 VDD VDD VSS VSS gf180mcu_as_sc_mcu7t3v3__fillcap_16
X_5652_ VDD VDD VSS VSS _5652_/A _5652_/B _5652_/C _5672_/C _5652_/D gf180mcu_as_sc_mcu7t3v3__oai211_2
XFILLER_176_678 VDD VDD VSS VSS gf180mcu_as_sc_mcu7t3v3__fillcap_4
X_5583_ VDD VDD VSS VSS _5890_/A _5583_/B _5583_/C _5583_/D _5585_/C gf180mcu_as_sc_mcu7t3v3__ao211_2
X_4603_ VDD VDD VSS VSS _4603_/B _4603_/A _6338_/D gf180mcu_as_sc_mcu7t3v3__and2_2
XFILLER_129_594 VDD VDD VSS VSS gf180mcu_as_sc_mcu7t3v3__fillcap_16
XFILLER_175_199 VDD VDD VSS VSS gf180mcu_as_sc_mcu7t3v3__fillcap_8
X_4534_ VDD VDD VSS VSS _4538_/S _4534_/B _6144_/Q _6297_/D gf180mcu_as_sc_mcu7t3v3__mux2_2
XFILLER_171_372 VDD VDD VSS VSS gf180mcu_as_sc_mcu7t3v3__fill_1
XFILLER_172_1119 VDD VDD VSS VSS gf180mcu_as_sc_mcu7t3v3__fillcap_16
X_4465_ VDD VDD VSS VSS _4465_/D _4471_/A _6273_/Q _4465_/C _4466_/C gf180mcu_as_sc_mcu7t3v3__ao31_2
Xfanout804 VDD VDD VSS VSS _4157_/Y _4226_/B gf180mcu_as_sc_mcu7t3v3__buff_12
Xfanout815 VDD VDD VSS VSS _5132_/B _5141_/B gf180mcu_as_sc_mcu7t3v3__buff_12
X_6204_ VDD VDD VSS VSS _6365_/CLK _6204_/D _6204_/Q gf180mcu_as_sc_mcu7t3v3__dfxtp_2
X_4396_ VDD VDD VSS VSS _4397_/C _4405_/S _6038_/Q gf180mcu_as_sc_mcu7t3v3__nor2b_2
X_3416_ VDD VDD VSS VSS _6164_/Q _6219_/Q _6203_/Q _3417_/A gf180mcu_as_sc_mcu7t3v3__mux2_2
XFILLER_213_1116 VDD VDD VSS VSS gf180mcu_as_sc_mcu7t3v3__fillcap_4
XFILLER_219_808 VDD VDD VSS VSS gf180mcu_as_sc_mcu7t3v3__fill_2
Xfanout826 VDD VDD VSS VSS _5301_/S _5222_/B gf180mcu_as_sc_mcu7t3v3__buff_12
Xfanout837 VDD VDD VSS VSS _4858_/B _4875_/B gf180mcu_as_sc_mcu7t3v3__buff_12
Xfanout848 VDD VDD VSS VSS _4447_/Y _4601_/D gf180mcu_as_sc_mcu7t3v3__buff_12
X_6135_ VDD VDD VSS VSS clkload7/A _6135_/D _6135_/Q gf180mcu_as_sc_mcu7t3v3__dfxtp_2
X_3347_ VDD VDD VSS VSS _3348_/D _3356_/A _3355_/B _3347_/A gf180mcu_as_sc_mcu7t3v3__aoi21b_2
XTAP_TAPCELL_ROW_228_2842 VDD VSS gf180mcu_as_sc_mcu7t3v3__tap_2
XFILLER_133_27 VDD VDD VSS VSS gf180mcu_as_sc_mcu7t3v3__fillcap_16
XFILLER_213_1138 VDD VDD VSS VSS gf180mcu_as_sc_mcu7t3v3__fillcap_16
Xfanout859 VDD VDD VSS VSS _4840_/B _4784_/B gf180mcu_as_sc_mcu7t3v3__buff_12
X_6066_ VDD VDD VSS VSS _6520_/CLK _6066_/D _6066_/Q gf180mcu_as_sc_mcu7t3v3__dfxtp_2
XTAP_TAPCELL_ROW_228_2864 VDD VSS gf180mcu_as_sc_mcu7t3v3__tap_2
XTAP_TAPCELL_ROW_228_2853 VDD VSS gf180mcu_as_sc_mcu7t3v3__tap_2
XFILLER_2_1205 VDD VDD VSS VSS gf180mcu_as_sc_mcu7t3v3__fillcap_16
X_5017_ VDD VDD VSS VSS _5017_/B _5164_/A _6378_/D gf180mcu_as_sc_mcu7t3v3__and2_2
X_3278_ VDD VDD VSS VSS _3291_/B _3278_/B _3278_/C _3278_/D _3278_/Y gf180mcu_as_sc_mcu7t3v3__ao22_2
XFILLER_227_874 VDD VDD VSS VSS gf180mcu_as_sc_mcu7t3v3__fillcap_8
XFILLER_2_1227 VDD VDD VSS VSS gf180mcu_as_sc_mcu7t3v3__fillcap_16
XFILLER_96_1245 VDD VDD VSS VSS gf180mcu_as_sc_mcu7t3v3__fillcap_16
XFILLER_14_607 VDD VDD VSS VSS gf180mcu_as_sc_mcu7t3v3__fill_1
XFILLER_14_618 VDD VDD VSS VSS gf180mcu_as_sc_mcu7t3v3__fillcap_16
XFILLER_214_568 VDD VDD VSS VSS gf180mcu_as_sc_mcu7t3v3__fillcap_16
XFILLER_226_395 VDD VDD VSS VSS gf180mcu_as_sc_mcu7t3v3__fillcap_4
XFILLER_198_247 VDD VDD VSS VSS gf180mcu_as_sc_mcu7t3v3__fill_2
XFILLER_10_802 VDD VDD VSS VSS gf180mcu_as_sc_mcu7t3v3__fill_2
X_5919_ VDD VDD VSS VSS _5952_/B _5919_/A _5923_/C gf180mcu_as_sc_mcu7t3v3__and2_2
XFILLER_120_1210 VDD VDD VSS VSS gf180mcu_as_sc_mcu7t3v3__fillcap_16
XFILLER_154_317 VDD VDD VSS VSS gf180mcu_as_sc_mcu7t3v3__fillcap_16
XFILLER_166_155 VDD VDD VSS VSS gf180mcu_as_sc_mcu7t3v3__fillcap_16
XFILLER_195_976 VDD VDD VSS VSS gf180mcu_as_sc_mcu7t3v3__fillcap_4
XFILLER_195_998 VDD VDD VSS VSS gf180mcu_as_sc_mcu7t3v3__fillcap_16
XFILLER_166_177 VDD VDD VSS VSS gf180mcu_as_sc_mcu7t3v3__fillcap_16
XFILLER_181_114 VDD VDD VSS VSS gf180mcu_as_sc_mcu7t3v3__fill_1
XPHY_EDGE_ROW_15_Left_244 VDD VSS gf180mcu_as_sc_mcu7t3v3__tap_2
XFILLER_162_383 VDD VDD VSS VSS gf180mcu_as_sc_mcu7t3v3__fill_2
XFILLER_174_34 VDD VDD VSS VSS gf180mcu_as_sc_mcu7t3v3__fill_1
XFILLER_1_522 VDD VDD VSS VSS gf180mcu_as_sc_mcu7t3v3__fill_2
XFILLER_218_1049 VDD VDD VSS VSS gf180mcu_as_sc_mcu7t3v3__fillcap_16
XFILLER_153_1030 VDD VDD VSS VSS gf180mcu_as_sc_mcu7t3v3__fillcap_16
XFILLER_153_1052 VDD VDD VSS VSS gf180mcu_as_sc_mcu7t3v3__fillcap_16
XFILLER_7_1116 VDD VDD VSS VSS gf180mcu_as_sc_mcu7t3v3__fillcap_4
XFILLER_67_43 VDD VDD VSS VSS gf180mcu_as_sc_mcu7t3v3__fillcap_8
XFILLER_7_1138 VDD VDD VSS VSS gf180mcu_as_sc_mcu7t3v3__fillcap_16
XTAP_TAPCELL_ROW_8_1166 VDD VSS gf180mcu_as_sc_mcu7t3v3__tap_2
XTAP_TAPCELL_ROW_8_1155 VDD VSS gf180mcu_as_sc_mcu7t3v3__tap_2
XFILLER_189_236 VDD VDD VSS VSS gf180mcu_as_sc_mcu7t3v3__fillcap_4
XFILLER_220_527 VDD VDD VSS VSS gf180mcu_as_sc_mcu7t3v3__fillcap_4
XFILLER_186_943 VDD VDD VSS VSS gf180mcu_as_sc_mcu7t3v3__fill_2
XFILLER_201_763 VDD VDD VSS VSS gf180mcu_as_sc_mcu7t3v3__fillcap_4
XFILLER_9_644 VDD VDD VSS VSS gf180mcu_as_sc_mcu7t3v3__fillcap_4
XFILLER_158_678 VDD VDD VSS VSS gf180mcu_as_sc_mcu7t3v3__fill_1
XFILLER_185_486 VDD VDD VSS VSS gf180mcu_as_sc_mcu7t3v3__fillcap_4
Xoutput407 VDD VDD VSS VSS _6372_/Q north_out[31] gf180mcu_as_sc_mcu7t3v3__buff_12
XFILLER_154_895 VDD VDD VSS VSS gf180mcu_as_sc_mcu7t3v3__fill_2
XFILLER_4_360 VDD VDD VSS VSS gf180mcu_as_sc_mcu7t3v3__fillcap_4
Xoutput429 VDD VDD VSS VSS _6396_/Q south_out[19] gf180mcu_as_sc_mcu7t3v3__buff_12
Xoutput418 VDD VDD VSS VSS _6350_/Q north_out[9] gf180mcu_as_sc_mcu7t3v3__buff_12
XTAP_TAPCELL_ROW_187_2108 VDD VSS gf180mcu_as_sc_mcu7t3v3__tap_2
XFILLER_10_1081 VDD VDD VSS VSS gf180mcu_as_sc_mcu7t3v3__fillcap_4
X_4250_ VDD VDD VSS VSS _6204_/Q _4336_/B _4336_/C _6205_/Q _4251_/D gf180mcu_as_sc_mcu7t3v3__ao22_2
XFILLER_136_1261 VDD VDD VSS VSS gf180mcu_as_sc_mcu7t3v3__fillcap_4
X_4181_ VDD VDD VSS VSS _4342_/S _6069_/Q _6098_/Q _4182_/B gf180mcu_as_sc_mcu7t3v3__mux2_2
X_3201_ VDD VDD VSS VSS _4601_/A _6333_/Q _6337_/Q gf180mcu_as_sc_mcu7t3v3__nand2b_2
XTAP_TAPCELL_ROW_165_1705 VDD VSS gf180mcu_as_sc_mcu7t3v3__tap_2
XTAP_TAPCELL_ROW_165_1716 VDD VSS gf180mcu_as_sc_mcu7t3v3__tap_2
X_3132_ VDD VDD VSS VSS _4539_/B _6259_/Q _4509_/B gf180mcu_as_sc_mcu7t3v3__nor2_2
XPHY_EDGE_ROW_104_3_Left_809 VDD VSS gf180mcu_as_sc_mcu7t3v3__tap_2
XFILLER_209_852 VDD VDD VSS VSS gf180mcu_as_sc_mcu7t3v3__fillcap_4
X_3063_ VDD VDD VSS VSS _4499_/D _6287_/Q gf180mcu_as_sc_mcu7t3v3__inv_2
XTAP_TAPCELL_ROW_86_2_2977 VDD VSS gf180mcu_as_sc_mcu7t3v3__tap_2
XTAP_TAPCELL_ROW_206_2458 VDD VSS gf180mcu_as_sc_mcu7t3v3__tap_2
XTAP_TAPCELL_ROW_206_2447 VDD VSS gf180mcu_as_sc_mcu7t3v3__tap_2
XFILLER_209_885 VDD VDD VSS VSS gf180mcu_as_sc_mcu7t3v3__fill_2
XTAP_TAPCELL_ROW_223_2761 VDD VSS gf180mcu_as_sc_mcu7t3v3__tap_2
XTAP_TAPCELL_ROW_223_2750 VDD VSS gf180mcu_as_sc_mcu7t3v3__tap_2
XFILLER_223_332 VDD VDD VSS VSS gf180mcu_as_sc_mcu7t3v3__fillcap_4
XFILLER_143_1210 VDD VDD VSS VSS gf180mcu_as_sc_mcu7t3v3__fillcap_16
XFILLER_195_206 VDD VDD VSS VSS gf180mcu_as_sc_mcu7t3v3__fillcap_4
XPHY_EDGE_ROW_111_2_Right_948 VDD VSS gf180mcu_as_sc_mcu7t3v3__tap_2
X_3965_ VDD VDD VSS VSS _3974_/B _6064_/Q _3966_/D gf180mcu_as_sc_mcu7t3v3__and2_2
X_5704_ VDD VDD VSS VSS _5705_/B _5804_/D _5844_/B _5704_/A gf180mcu_as_sc_mcu7t3v3__aoi21b_2
X_3896_ VDD VDD VSS VSS _3911_/B _5882_/A _3903_/C gf180mcu_as_sc_mcu7t3v3__and2_2
XFILLER_12_27 VDD VDD VSS VSS gf180mcu_as_sc_mcu7t3v3__fillcap_8
X_5635_ VDD VDD VSS VSS _5642_/S _5948_/A _5635_/A _5636_/B gf180mcu_as_sc_mcu7t3v3__mux2_2
XFILLER_176_497 VDD VDD VSS VSS gf180mcu_as_sc_mcu7t3v3__fill_1
XFILLER_128_49 VDD VDD VSS VSS gf180mcu_as_sc_mcu7t3v3__fill_2
XFILLER_163_136 VDD VDD VSS VSS gf180mcu_as_sc_mcu7t3v3__fillcap_4
XFILLER_163_158 VDD VDD VSS VSS gf180mcu_as_sc_mcu7t3v3__fillcap_16
XFILLER_164_659 VDD VDD VSS VSS gf180mcu_as_sc_mcu7t3v3__fillcap_4
X_5566_ VDD VDD VSS VSS _5872_/A _5566_/B _5566_/C _5566_/D _5567_/C gf180mcu_as_sc_mcu7t3v3__ao22_2
X_5497_ VDD VDD VSS VSS _5804_/A _5497_/B _5497_/C _5497_/D _5498_/B gf180mcu_as_sc_mcu7t3v3__ao22_2
X_4517_ VDD VDD VSS VSS _4527_/S _6291_/Q _4517_/A _6291_/D gf180mcu_as_sc_mcu7t3v3__mux2_2
X_4448_ VDD VDD VSS VSS _4448_/Y _4448_/B _6135_/Q gf180mcu_as_sc_mcu7t3v3__nand2_2
XFILLER_144_37 VDD VDD VSS VSS gf180mcu_as_sc_mcu7t3v3__fillcap_8
Xfanout601 VDD VDD VSS VSS _5098_/B _5308_/B gf180mcu_as_sc_mcu7t3v3__buff_12
Xfanout612 VDD VDD VSS VSS wire617/Y _3849_/B gf180mcu_as_sc_mcu7t3v3__buff_12
Xfanout623 VDD VDD VSS VSS _5858_/B _5954_/B gf180mcu_as_sc_mcu7t3v3__buff_12
Xfanout634 VDD VDD VSS VSS _4862_/B _4962_/B gf180mcu_as_sc_mcu7t3v3__buff_12
Xfanout656 VDD VDD VSS VSS _5674_/Y _5839_/B gf180mcu_as_sc_mcu7t3v3__buff_12
Xfanout667 VDD VDD VSS VSS _5837_/B _5857_/C gf180mcu_as_sc_mcu7t3v3__buff_12
X_4379_ VDD VDD VSS VSS _4381_/A _4379_/C _4400_/B _6141_/Q gf180mcu_as_sc_mcu7t3v3__aoi21_2
XFILLER_150_1258 VDD VDD VSS VSS gf180mcu_as_sc_mcu7t3v3__fill_2
Xfanout678 VDD VDD VSS VSS _5551_/B _5640_/B gf180mcu_as_sc_mcu7t3v3__buff_12
Xfanout689 VDD VDD VSS VSS _4842_/C _4795_/C gf180mcu_as_sc_mcu7t3v3__buff_12
X_6118_ VDD VDD VSS VSS _6371_/CLK _6118_/D _6118_/Q gf180mcu_as_sc_mcu7t3v3__dfxtp_2
X_6049_ VDD VDD VSS VSS _6506_/CLK _6049_/D _6049_/Q gf180mcu_as_sc_mcu7t3v3__dfxtp_2
XFILLER_160_69 VDD VDD VSS VSS gf180mcu_as_sc_mcu7t3v3__fillcap_16
XFILLER_170_6 VDD VDD VSS VSS gf180mcu_as_sc_mcu7t3v3__fillcap_16
XPHY_EDGE_ROW_73_2_Right_910 VDD VSS gf180mcu_as_sc_mcu7t3v3__tap_2
XFILLER_187_1170 VDD VDD VSS VSS gf180mcu_as_sc_mcu7t3v3__fillcap_16
XFILLER_187_1192 VDD VDD VSS VSS gf180mcu_as_sc_mcu7t3v3__fillcap_16
XPHY_EDGE_ROW_98_3_Left_803 VDD VSS gf180mcu_as_sc_mcu7t3v3__tap_2
XTAP_TAPCELL_ROW_3_1063 VDD VSS gf180mcu_as_sc_mcu7t3v3__tap_2
XTAP_TAPCELL_ROW_3_1074 VDD VSS gf180mcu_as_sc_mcu7t3v3__tap_2
XFILLER_202_527 VDD VDD VSS VSS gf180mcu_as_sc_mcu7t3v3__fillcap_16
XFILLER_168_954 VDD VDD VSS VSS gf180mcu_as_sc_mcu7t3v3__fill_1
XFILLER_10_621 VDD VDD VSS VSS gf180mcu_as_sc_mcu7t3v3__fill_2
XFILLER_155_604 VDD VDD VSS VSS gf180mcu_as_sc_mcu7t3v3__fill_1
XFILLER_211_2 VDD VDD VSS VSS gf180mcu_as_sc_mcu7t3v3__fill_2
XFILLER_183_979 VDD VDD VSS VSS gf180mcu_as_sc_mcu7t3v3__fill_1
XFILLER_185_66 VDD VDD VSS VSS gf180mcu_as_sc_mcu7t3v3__fillcap_4
XFILLER_151_821 VDD VDD VSS VSS gf180mcu_as_sc_mcu7t3v3__fillcap_4
XFILLER_151_876 VDD VDD VSS VSS gf180mcu_as_sc_mcu7t3v3__fill_1
XFILLER_190_1049 VDD VDD VSS VSS gf180mcu_as_sc_mcu7t3v3__fillcap_16
XFILLER_1_352 VDD VDD VSS VSS gf180mcu_as_sc_mcu7t3v3__fillcap_8
XTAP_TAPCELL_ROW_182_2016 VDD VSS gf180mcu_as_sc_mcu7t3v3__tap_2
Xmesh_tile_1044 VDD VDD VSS VSS ne_out[3] gf180mcu_as_sc_mcu7t3v3__tiel_4
XFILLER_224_107 VDD VDD VSS VSS gf180mcu_as_sc_mcu7t3v3__fill_2
XTAP_TAPCELL_ROW_160_1613 VDD VSS gf180mcu_as_sc_mcu7t3v3__tap_2
Xmesh_tile_1077 VDD VDD VSS VSS nw_out[0] gf180mcu_as_sc_mcu7t3v3__tiel_4
Xmesh_tile_1066 VDD VDD VSS VSS ne_out[25] gf180mcu_as_sc_mcu7t3v3__tiel_4
Xmesh_tile_1055 VDD VDD VSS VSS ne_out[14] gf180mcu_as_sc_mcu7t3v3__tiel_4
XFILLER_166_1221 VDD VDD VSS VSS gf180mcu_as_sc_mcu7t3v3__fillcap_4
XFILLER_205_332 VDD VDD VSS VSS gf180mcu_as_sc_mcu7t3v3__fill_2
XTAP_TAPCELL_ROW_160_1624 VDD VSS gf180mcu_as_sc_mcu7t3v3__tap_2
Xmesh_tile_1099 VDD VDD VSS VSS nw_out[22] gf180mcu_as_sc_mcu7t3v3__tiel_4
Xmesh_tile_1088 VDD VDD VSS VSS nw_out[11] gf180mcu_as_sc_mcu7t3v3__tiel_4
XFILLER_166_1243 VDD VDD VSS VSS gf180mcu_as_sc_mcu7t3v3__fillcap_16
XFILLER_206_877 VDD VDD VSS VSS gf180mcu_as_sc_mcu7t3v3__fillcap_16
XPHY_EDGE_ROW_82_3_Left_787 VDD VSS gf180mcu_as_sc_mcu7t3v3__tap_2
XTAP_TAPCELL_ROW_201_2366 VDD VSS gf180mcu_as_sc_mcu7t3v3__tap_2
XTAP_TAPCELL_ROW_201_2355 VDD VSS gf180mcu_as_sc_mcu7t3v3__tap_2
XTAP_TAPCELL_ROW_197_2281 VDD VSS gf180mcu_as_sc_mcu7t3v3__tap_2
XFILLER_158_431 VDD VDD VSS VSS gf180mcu_as_sc_mcu7t3v3__fillcap_8
XFILLER_159_943 VDD VDD VSS VSS gf180mcu_as_sc_mcu7t3v3__fill_2
XFILLER_207_1262 VDD VDD VSS VSS gf180mcu_as_sc_mcu7t3v3__fill_2
X_3750_ VDD VDD VSS VSS _3873_/S _3750_/B _5752_/A _3751_/D gf180mcu_as_sc_mcu7t3v3__mux2_2
XTAP_TAPCELL_ROW_197_2292 VDD VSS gf180mcu_as_sc_mcu7t3v3__tap_2
XFILLER_159_998 VDD VDD VSS VSS gf180mcu_as_sc_mcu7t3v3__fillcap_16
XFILLER_199_1030 VDD VDD VSS VSS gf180mcu_as_sc_mcu7t3v3__fillcap_16
XFILLER_146_626 VDD VDD VSS VSS gf180mcu_as_sc_mcu7t3v3__fill_1
XFILLER_146_637 VDD VDD VSS VSS gf180mcu_as_sc_mcu7t3v3__fill_2
XFILLER_199_1052 VDD VDD VSS VSS gf180mcu_as_sc_mcu7t3v3__fillcap_16
XTAP_TAPCELL_ROW_158_1586 VDD VSS gf180mcu_as_sc_mcu7t3v3__tap_2
X_3681_ VDD VDD VSS VSS _5691_/A _3852_/B _3681_/C _3681_/D _3683_/C gf180mcu_as_sc_mcu7t3v3__ao211_2
X_5420_ VDD VDD VSS VSS _5421_/A _5420_/C _5569_/B _5727_/A gf180mcu_as_sc_mcu7t3v3__aoi21_2
XFILLER_57_2 VDD VDD VSS VSS gf180mcu_as_sc_mcu7t3v3__fillcap_16
X_5351_ VDD VDD VSS VSS _5659_/A _5351_/B _5351_/A gf180mcu_as_sc_mcu7t3v3__nor2_2
XFILLER_160_139 VDD VDD VSS VSS gf180mcu_as_sc_mcu7t3v3__fillcap_16
X_5282_ VDD VDD VSS VSS _5316_/S _5612_/A _5282_/A _5283_/B gf180mcu_as_sc_mcu7t3v3__mux2_2
X_4302_ VDD VDD VSS VSS _4304_/A _4302_/C _4400_/B _6146_/Q gf180mcu_as_sc_mcu7t3v3__aoi21_2
X_4233_ VDD VDD VSS VSS _4335_/S _6045_/Q _6074_/Q _4234_/B gf180mcu_as_sc_mcu7t3v3__mux2_2
XFILLER_68_665 VDD VDD VSS VSS gf180mcu_as_sc_mcu7t3v3__fill_2
XPHY_EDGE_ROW_123_1_Left_351 VDD VSS gf180mcu_as_sc_mcu7t3v3__tap_2
X_4164_ VDD VDD VSS VSS _6189_/Q _6190_/Q _4165_/C gf180mcu_as_sc_mcu7t3v3__or2_2
XFILLER_210_1119 VDD VDD VSS VSS gf180mcu_as_sc_mcu7t3v3__fillcap_16
X_4095_ VDD VDD VSS VSS _4098_/S _6716_/A _6155_/Q _6155_/D gf180mcu_as_sc_mcu7t3v3__mux2_2
X_3115_ VDD VDD VSS VSS _3121_/B _4579_/D _6267_/Q _4509_/B gf180mcu_as_sc_mcu7t3v3__aoi21_2
X_3046_ VDD VDD VSS VSS _4570_/A _4456_/A gf180mcu_as_sc_mcu7t3v3__inv_2
XFILLER_224_652 VDD VDD VSS VSS gf180mcu_as_sc_mcu7t3v3__fill_1
XFILLER_211_368 VDD VDD VSS VSS gf180mcu_as_sc_mcu7t3v3__fillcap_4
Xclkbuf_leaf_10_clk_regs VDD VDD VSS VSS clkbuf_3_2_0_clk_regs/Y clkload9/A gf180mcu_as_sc_mcu7t3v3__clkbuff_12
X_4997_ VDD VDD VSS VSS _5669_/A _5217_/S _5226_/C _5677_/A _5006_/C gf180mcu_as_sc_mcu7t3v3__ao22_2
XPHY_EDGE_ROW_112_2_Right_949 VDD VSS gf180mcu_as_sc_mcu7t3v3__tap_2
X_3948_ VDD VDD VSS VSS _6052_/Q _3975_/C _3948_/C _4029_/D _6052_/D gf180mcu_as_sc_mcu7t3v3__ao22_2
XFILLER_178_1103 VDD VDD VSS VSS gf180mcu_as_sc_mcu7t3v3__fillcap_16
XFILLER_192_732 VDD VDD VSS VSS gf180mcu_as_sc_mcu7t3v3__fill_2
XFILLER_30_1210 VDD VDD VSS VSS gf180mcu_as_sc_mcu7t3v3__fillcap_8
X_3879_ VDD VDD VSS VSS _5864_/A _3889_/B _3879_/C _3879_/D _3880_/C gf180mcu_as_sc_mcu7t3v3__ao211_2
XFILLER_165_968 VDD VDD VSS VSS gf180mcu_as_sc_mcu7t3v3__fill_1
X_5618_ VDD VDD VSS VSS _5932_/A _5640_/B _5632_/C _5928_/A _5619_/D gf180mcu_as_sc_mcu7t3v3__ao22_2
XFILLER_155_14 VDD VDD VSS VSS gf180mcu_as_sc_mcu7t3v3__fill_1
XFILLER_164_489 VDD VDD VSS VSS gf180mcu_as_sc_mcu7t3v3__fillcap_16
XFILLER_219_1100 VDD VDD VSS VSS gf180mcu_as_sc_mcu7t3v3__fillcap_16
XFILLER_219_1122 VDD VDD VSS VSS gf180mcu_as_sc_mcu7t3v3__fillcap_16
XPHY_EDGE_ROW_98_1_Right_670 VDD VSS gf180mcu_as_sc_mcu7t3v3__tap_2
X_5549_ VDD VDD VSS VSS _5855_/A _5549_/B _5549_/C _5854_/B _5550_/C gf180mcu_as_sc_mcu7t3v3__ao22_2
XPHY_EDGE_ROW_55_1_Left_283 VDD VSS gf180mcu_as_sc_mcu7t3v3__tap_2
XFILLER_150_1011 VDD VDD VSS VSS gf180mcu_as_sc_mcu7t3v3__fillcap_4
XFILLER_150_1033 VDD VDD VSS VSS gf180mcu_as_sc_mcu7t3v3__fillcap_16
XFILLER_48_45 VDD VDD VSS VSS gf180mcu_as_sc_mcu7t3v3__fillcap_4
XFILLER_189_1232 VDD VDD VSS VSS gf180mcu_as_sc_mcu7t3v3__fill_2
XFILLER_4_1119 VDD VDD VSS VSS gf180mcu_as_sc_mcu7t3v3__fillcap_16
Xfanout497 VDD VDD VSS VSS _4014_/B _4008_/B gf180mcu_as_sc_mcu7t3v3__buff_12
XTAP_TAPCELL_ROW_5_1103 VDD VSS gf180mcu_as_sc_mcu7t3v3__tap_2
XFILLER_206_107 VDD VDD VSS VSS gf180mcu_as_sc_mcu7t3v3__fill_2
XFILLER_15_702 VDD VDD VSS VSS gf180mcu_as_sc_mcu7t3v3__fillcap_16
XFILLER_199_320 VDD VDD VSS VSS gf180mcu_as_sc_mcu7t3v3__fill_2
XPHY_EDGE_ROW_74_2_Right_911 VDD VSS gf180mcu_as_sc_mcu7t3v3__tap_2
XFILLER_159_206 VDD VDD VSS VSS gf180mcu_as_sc_mcu7t3v3__fillcap_4
XFILLER_187_504 VDD VDD VSS VSS gf180mcu_as_sc_mcu7t3v3__fillcap_8
XFILLER_202_313 VDD VDD VSS VSS gf180mcu_as_sc_mcu7t3v3__fill_2
XFILLER_203_836 VDD VDD VSS VSS gf180mcu_as_sc_mcu7t3v3__fillcap_4
XFILLER_159_228 VDD VDD VSS VSS gf180mcu_as_sc_mcu7t3v3__fillcap_16
XPHY_EDGE_ROW_202_Left_430 VDD VSS gf180mcu_as_sc_mcu7t3v3__tap_2
Xwire810 VDD VDD VSS VSS _3611_/B _3905_/C gf180mcu_as_sc_mcu7t3v3__clkbuff_12
XFILLER_10_451 VDD VDD VSS VSS gf180mcu_as_sc_mcu7t3v3__fillcap_4
XFILLER_128_626 VDD VDD VSS VSS gf180mcu_as_sc_mcu7t3v3__fill_1
XFILLER_195_592 VDD VDD VSS VSS gf180mcu_as_sc_mcu7t3v3__fillcap_4
XFILLER_7_912 VDD VDD VSS VSS gf180mcu_as_sc_mcu7t3v3__fillcap_16
XFILLER_156_979 VDD VDD VSS VSS gf180mcu_as_sc_mcu7t3v3__fillcap_16
XFILLER_182_242 VDD VDD VSS VSS gf180mcu_as_sc_mcu7t3v3__fill_2
XFILLER_183_743 VDD VDD VSS VSS gf180mcu_as_sc_mcu7t3v3__fill_2
Xwire876 VDD VDD VSS VSS _3369_/Y _6720_/A gf180mcu_as_sc_mcu7t3v3__clkbuff_12
XTAP_TAPCELL_ROW_153_1494 VDD VSS gf180mcu_as_sc_mcu7t3v3__tap_2
XFILLER_2_650 VDD VDD VSS VSS gf180mcu_as_sc_mcu7t3v3__fill_1
XFILLER_151_695 VDD VDD VSS VSS gf180mcu_as_sc_mcu7t3v3__fillcap_4
XFILLER_46_1261 VDD VDD VSS VSS gf180mcu_as_sc_mcu7t3v3__fillcap_4
XTAP_TAPCELL_ROW_39_2_2907 VDD VSS gf180mcu_as_sc_mcu7t3v3__tap_2
XFILLER_65_602 VDD VDD VSS VSS gf180mcu_as_sc_mcu7t3v3__fill_1
XFILLER_65_657 VDD VDD VSS VSS gf180mcu_as_sc_mcu7t3v3__fillcap_4
XTAP_TAPCELL_ROW_199_2332 VDD VSS gf180mcu_as_sc_mcu7t3v3__tap_2
XTAP_TAPCELL_ROW_199_2321 VDD VSS gf180mcu_as_sc_mcu7t3v3__tap_2
XFILLER_206_652 VDD VDD VSS VSS gf180mcu_as_sc_mcu7t3v3__fill_1
X_4920_ VDD VDD VSS VSS _4965_/S _4920_/B _5910_/A _4921_/B gf180mcu_as_sc_mcu7t3v3__mux2_2
X_4851_ VDD VDD VSS VSS _6514_/Q _4851_/B _4871_/C _5849_/D _4852_/C gf180mcu_as_sc_mcu7t3v3__ao22_2
XFILLER_221_644 VDD VDD VSS VSS gf180mcu_as_sc_mcu7t3v3__fill_2
XFILLER_53_1210 VDD VDD VSS VSS gf180mcu_as_sc_mcu7t3v3__fill_2
X_3802_ VDD VDD VSS VSS _6030_/Q _3895_/B _4038_/B _3895_/D _6030_/D gf180mcu_as_sc_mcu7t3v3__ao22_2
XFILLER_14_1205 VDD VDD VSS VSS gf180mcu_as_sc_mcu7t3v3__fillcap_16
XFILLER_221_699 VDD VDD VSS VSS gf180mcu_as_sc_mcu7t3v3__fill_1
X_4782_ VDD VDD VSS VSS _5792_/A _4838_/B _4782_/C _4792_/B _4784_/C gf180mcu_as_sc_mcu7t3v3__ao211_2
XFILLER_14_1227 VDD VDD VSS VSS gf180mcu_as_sc_mcu7t3v3__fillcap_8
XFILLER_159_784 VDD VDD VSS VSS gf180mcu_as_sc_mcu7t3v3__fill_2
XFILLER_9_260 VDD VDD VSS VSS gf180mcu_as_sc_mcu7t3v3__fillcap_16
X_6521_ VDD VDD VSS VSS _6525_/CLK _6521_/D _6521_/Q gf180mcu_as_sc_mcu7t3v3__dfxtp_2
X_3733_ VDD VDD VSS VSS _6023_/Q _3830_/B _4029_/D _3830_/D _6023_/D gf180mcu_as_sc_mcu7t3v3__ao22_2
XTAP_TAPCELL_ROW_218_2671 VDD VSS gf180mcu_as_sc_mcu7t3v3__tap_2
XTAP_TAPCELL_ROW_218_2660 VDD VSS gf180mcu_as_sc_mcu7t3v3__tap_2
XFILLER_119_648 VDD VDD VSS VSS gf180mcu_as_sc_mcu7t3v3__fillcap_4
XFILLER_173_231 VDD VDD VSS VSS gf180mcu_as_sc_mcu7t3v3__fill_1
XFILLER_9_282 VDD VDD VSS VSS gf180mcu_as_sc_mcu7t3v3__fillcap_16
XTAP_TAPCELL_ROW_173_1848 VDD VSS gf180mcu_as_sc_mcu7t3v3__tap_2
XTAP_TAPCELL_ROW_173_1859 VDD VSS gf180mcu_as_sc_mcu7t3v3__tap_2
X_6452_ VDD VDD VSS VSS clkload4/A _6452_/D _6452_/Q gf180mcu_as_sc_mcu7t3v3__dfxtp_2
X_3664_ VDD VDD VSS VSS _3664_/B _3865_/B _3666_/A gf180mcu_as_sc_mcu7t3v3__or2_2
XFILLER_134_629 VDD VDD VSS VSS gf180mcu_as_sc_mcu7t3v3__fillcap_16
X_5403_ VDD VDD VSS VSS _5404_/C _5403_/B _5403_/A gf180mcu_as_sc_mcu7t3v3__nor2_2
XFILLER_161_448 VDD VDD VSS VSS gf180mcu_as_sc_mcu7t3v3__fill_2
X_6383_ VDD VDD VSS VSS _6527_/CLK _6383_/D _6383_/Q gf180mcu_as_sc_mcu7t3v3__dfxtp_2
X_3595_ VDD VDD VSS VSS _3595_/A _3595_/B _3595_/C _3595_/D _3596_/C gf180mcu_as_sc_mcu7t3v3__nand4_2
X_5334_ VDD VDD VSS VSS _5638_/C _5338_/C _5361_/B gf180mcu_as_sc_mcu7t3v3__nand2_2
XTAP_TAPCELL_ROW_74_2_2959 VDD VSS gf180mcu_as_sc_mcu7t3v3__tap_2
X_5265_ VDD VDD VSS VSS _5266_/D _5265_/C _5309_/B _5903_/A gf180mcu_as_sc_mcu7t3v3__aoi21b_2
XFILLER_228_210 VDD VDD VSS VSS gf180mcu_as_sc_mcu7t3v3__fill_2
X_5196_ VDD VDD VSS VSS _6514_/Q _5233_/C _5226_/C _5849_/D _5197_/D gf180mcu_as_sc_mcu7t3v3__ao22_2
X_4216_ VDD VDD VSS VSS _4217_/C _4216_/B _6200_/Q gf180mcu_as_sc_mcu7t3v3__nor2_2
XFILLER_205_72 VDD VDD VSS VSS gf180mcu_as_sc_mcu7t3v3__fillcap_16
X_4147_ VDD VDD VSS VSS _4230_/B _6526_/Q _4148_/B _6135_/Q gf180mcu_as_sc_mcu7t3v3__aoi21_2
XFILLER_18_37 VDD VDD VSS VSS gf180mcu_as_sc_mcu7t3v3__fillcap_8
XFILLER_141_38 VDD VDD VSS VSS gf180mcu_as_sc_mcu7t3v3__fillcap_8
X_4078_ VDD VDD VSS VSS _4085_/S _6715_/A _6138_/Q _6138_/D gf180mcu_as_sc_mcu7t3v3__mux2_2
XTAP_TAPCELL_ROW_0_1000 VDD VSS gf180mcu_as_sc_mcu7t3v3__tap_2
X_3029_ VDD VDD VSS VSS _3470_/B _5914_/A gf180mcu_as_sc_mcu7t3v3__inv_2
XFILLER_149_1260 VDD VDD VSS VSS gf180mcu_as_sc_mcu7t3v3__fill_1
XFILLER_184_1151 VDD VDD VSS VSS gf180mcu_as_sc_mcu7t3v3__fillcap_4
XFILLER_184_1173 VDD VDD VSS VSS gf180mcu_as_sc_mcu7t3v3__fillcap_16
XTAP_TAPCELL_ROW_0_1011 VDD VSS gf180mcu_as_sc_mcu7t3v3__tap_2
XTAP_TAPCELL_ROW_0_1022 VDD VSS gf180mcu_as_sc_mcu7t3v3__tap_2
XFILLER_196_312 VDD VDD VSS VSS gf180mcu_as_sc_mcu7t3v3__fill_2
XFILLER_156_209 VDD VDD VSS VSS gf180mcu_as_sc_mcu7t3v3__fillcap_16
XFILLER_225_1170 VDD VDD VSS VSS gf180mcu_as_sc_mcu7t3v3__fillcap_16
XFILLER_165_732 VDD VDD VSS VSS gf180mcu_as_sc_mcu7t3v3__fill_1
XFILLER_225_1192 VDD VDD VSS VSS gf180mcu_as_sc_mcu7t3v3__fillcap_16
X_6719_ VDD VDD VSS VSS _6719_/A _6719_/Y gf180mcu_as_sc_mcu7t3v3__buff_2
Xclkload2 VDD VDD VSS VSS clkload2/A clkload2/Y gf180mcu_as_sc_mcu7t3v3__clkbuff_12
XFILLER_165_754 VDD VDD VSS VSS gf180mcu_as_sc_mcu7t3v3__fill_1
XFILLER_164_275 VDD VDD VSS VSS gf180mcu_as_sc_mcu7t3v3__fill_2
XFILLER_165_776 VDD VDD VSS VSS gf180mcu_as_sc_mcu7t3v3__fill_1
XFILLER_191_1100 VDD VDD VSS VSS gf180mcu_as_sc_mcu7t3v3__fillcap_16
XPHY_EDGE_ROW_99_1_Right_671 VDD VSS gf180mcu_as_sc_mcu7t3v3__tap_2
XFILLER_156_1253 VDD VDD VSS VSS gf180mcu_as_sc_mcu7t3v3__fillcap_8
XFILLER_191_1122 VDD VDD VSS VSS gf180mcu_as_sc_mcu7t3v3__fillcap_16
XFILLER_117_1226 VDD VDD VSS VSS gf180mcu_as_sc_mcu7t3v3__fillcap_8
XFILLER_160_481 VDD VDD VSS VSS gf180mcu_as_sc_mcu7t3v3__fill_1
XFILLER_161_982 VDD VDD VSS VSS gf180mcu_as_sc_mcu7t3v3__fillcap_16
XFILLER_182_45 VDD VDD VSS VSS gf180mcu_as_sc_mcu7t3v3__fillcap_4
XFILLER_59_44 VDD VDD VSS VSS gf180mcu_as_sc_mcu7t3v3__fillcap_4
XFILLER_208_939 VDD VDD VSS VSS gf180mcu_as_sc_mcu7t3v3__fillcap_4
XFILLER_219_276 VDD VDD VSS VSS gf180mcu_as_sc_mcu7t3v3__fillcap_4
XFILLER_189_1084 VDD VDD VSS VSS gf180mcu_as_sc_mcu7t3v3__fillcap_16
XFILLER_223_909 VDD VDD VSS VSS gf180mcu_as_sc_mcu7t3v3__fill_1
XFILLER_76_1210 VDD VDD VSS VSS gf180mcu_as_sc_mcu7t3v3__fill_2
XPHY_EDGE_ROW_75_2_Right_912 VDD VSS gf180mcu_as_sc_mcu7t3v3__tap_2
XFILLER_15_587 VDD VDD VSS VSS gf180mcu_as_sc_mcu7t3v3__fillcap_4
XFILLER_163_1224 VDD VDD VSS VSS gf180mcu_as_sc_mcu7t3v3__fill_2
XFILLER_187_356 VDD VDD VSS VSS gf180mcu_as_sc_mcu7t3v3__fill_1
XFILLER_203_699 VDD VDD VSS VSS gf180mcu_as_sc_mcu7t3v3__fill_1
XFILLER_204_1221 VDD VDD VSS VSS gf180mcu_as_sc_mcu7t3v3__fillcap_4
XTAP_TAPCELL_ROW_194_2240 VDD VSS gf180mcu_as_sc_mcu7t3v3__tap_2
XFILLER_187_378 VDD VDD VSS VSS gf180mcu_as_sc_mcu7t3v3__fill_1
XFILLER_204_1243 VDD VDD VSS VSS gf180mcu_as_sc_mcu7t3v3__fillcap_8
XPHY_EDGE_ROW_7_Left_236 VDD VSS gf180mcu_as_sc_mcu7t3v3__tap_2
XFILLER_196_1011 VDD VDD VSS VSS gf180mcu_as_sc_mcu7t3v3__fillcap_4
XPHY_EDGE_ROW_113_3_Left_818 VDD VSS gf180mcu_as_sc_mcu7t3v3__tap_2
XTAP_TAPCELL_ROW_155_1523 VDD VSS gf180mcu_as_sc_mcu7t3v3__tap_2
XTAP_TAPCELL_ROW_155_1534 VDD VSS gf180mcu_as_sc_mcu7t3v3__tap_2
XTAP_TAPCELL_ROW_190_2159 VDD VSS gf180mcu_as_sc_mcu7t3v3__tap_2
XFILLER_156_787 VDD VDD VSS VSS gf180mcu_as_sc_mcu7t3v3__fill_1
XFILLER_156_798 VDD VDD VSS VSS gf180mcu_as_sc_mcu7t3v3__fillcap_4
XFILLER_171_702 VDD VDD VSS VSS gf180mcu_as_sc_mcu7t3v3__fillcap_16
XFILLER_183_573 VDD VDD VSS VSS gf180mcu_as_sc_mcu7t3v3__fill_2
XFILLER_196_1033 VDD VDD VSS VSS gf180mcu_as_sc_mcu7t3v3__fillcap_16
XFILLER_6_241 VDD VDD VSS VSS gf180mcu_as_sc_mcu7t3v3__fillcap_4
XFILLER_170_201 VDD VDD VSS VSS gf180mcu_as_sc_mcu7t3v3__fill_1
XFILLER_171_757 VDD VDD VSS VSS gf180mcu_as_sc_mcu7t3v3__fillcap_8
XFILLER_6_263 VDD VDD VSS VSS gf180mcu_as_sc_mcu7t3v3__fillcap_16
X_3380_ VDD VDD VSS VSS _6715_/A _4584_/A _3440_/B gf180mcu_as_sc_mcu7t3v3__and2_2
X_5050_ VDD VDD VSS VSS _5719_/A _5143_/B _5143_/C _5714_/A _5051_/D gf180mcu_as_sc_mcu7t3v3__ao22_2
XFILLER_38_613 VDD VDD VSS VSS gf180mcu_as_sc_mcu7t3v3__fillcap_4
X_4001_ VDD VDD VSS VSS _4039_/B _4012_/B _4012_/C _6089_/Q _6089_/D gf180mcu_as_sc_mcu7t3v3__ao22_2
XTAP_TAPCELL_ROW_14_1265 VDD VSS gf180mcu_as_sc_mcu7t3v3__tap_2
XFILLER_168_1135 VDD VDD VSS VSS gf180mcu_as_sc_mcu7t3v3__fillcap_16
XFILLER_168_1157 VDD VDD VSS VSS gf180mcu_as_sc_mcu7t3v3__fillcap_16
XFILLER_53_627 VDD VDD VSS VSS gf180mcu_as_sc_mcu7t3v3__fillcap_4
X_5952_ VDD VDD VSS VSS _5954_/C _5952_/C _5952_/B _5952_/A gf180mcu_as_sc_mcu7t3v3__aoi21b_2
X_4903_ VDD VDD VSS VSS _4903_/B _5978_/A _6367_/D gf180mcu_as_sc_mcu7t3v3__and2_2
XFILLER_209_1154 VDD VDD VSS VSS gf180mcu_as_sc_mcu7t3v3__fillcap_16
X_5883_ VDD VDD VSS VSS _5948_/S _5883_/B _5883_/A _5884_/B gf180mcu_as_sc_mcu7t3v3__mux2_2
XFILLER_166_507 VDD VDD VSS VSS gf180mcu_as_sc_mcu7t3v3__fillcap_16
XFILLER_178_356 VDD VDD VSS VSS gf180mcu_as_sc_mcu7t3v3__fill_2
X_4834_ VDD VDD VSS VSS _4835_/B _5834_/A _4957_/B _4834_/C gf180mcu_as_sc_mcu7t3v3__ao21_2
XPHY_EDGE_ROW_22_2_Left_463 VDD VSS gf180mcu_as_sc_mcu7t3v3__tap_2
X_4765_ VDD VDD VSS VSS _5114_/A _4878_/B _4765_/C _4766_/D _4880_/B gf180mcu_as_sc_mcu7t3v3__aoi211_2
XFILLER_159_592 VDD VDD VSS VSS gf180mcu_as_sc_mcu7t3v3__fillcap_4
X_6504_ VDD VDD VSS VSS _6517_/CLK _6504_/D _6504_/Q gf180mcu_as_sc_mcu7t3v3__dfxtp_2
X_3716_ VDD VDD VSS VSS _3888_/B _5725_/A _3717_/D gf180mcu_as_sc_mcu7t3v3__and2_2
XFILLER_179_1264 VDD VDD VSS VSS gf180mcu_as_sc_mcu7t3v3__fill_1
X_4696_ VDD VDD VSS VSS _4697_/B _5711_/A _4796_/B _4696_/C gf180mcu_as_sc_mcu7t3v3__ao21_2
XFILLER_161_212 VDD VDD VSS VSS gf180mcu_as_sc_mcu7t3v3__fillcap_16
XFILLER_20_27 VDD VDD VSS VSS gf180mcu_as_sc_mcu7t3v3__fillcap_8
XFILLER_20_49 VDD VDD VSS VSS gf180mcu_as_sc_mcu7t3v3__fill_2
X_6435_ VDD VDD VSS VSS _6448_/CLK _6435_/D _6435_/Q gf180mcu_as_sc_mcu7t3v3__dfxtp_2
X_3647_ VDD VDD VSS VSS _4053_/A _5958_/A _3982_/B gf180mcu_as_sc_mcu7t3v3__and2_2
XFILLER_115_640 VDD VDD VSS VSS gf180mcu_as_sc_mcu7t3v3__fillcap_16
XFILLER_136_49 VDD VDD VSS VSS gf180mcu_as_sc_mcu7t3v3__fill_2
XFILLER_150_919 VDD VDD VSS VSS gf180mcu_as_sc_mcu7t3v3__fillcap_8
XFILLER_216_1103 VDD VDD VSS VSS gf180mcu_as_sc_mcu7t3v3__fillcap_16
X_6366_ VDD VDD VSS VSS _6370_/CLK _6366_/D _6366_/Q gf180mcu_as_sc_mcu7t3v3__dfxtp_2
X_3578_ VDD VDD VSS VSS _5329_/C _3598_/B _5921_/D gf180mcu_as_sc_mcu7t3v3__nor2b_2
XFILLER_0_406 VDD VDD VSS VSS gf180mcu_as_sc_mcu7t3v3__fill_2
XFILLER_170_790 VDD VDD VSS VSS gf180mcu_as_sc_mcu7t3v3__fillcap_4
X_5317_ VDD VDD VSS VSS _5317_/B _5396_/A _6411_/D gf180mcu_as_sc_mcu7t3v3__and2_2
XFILLER_130_654 VDD VDD VSS VSS gf180mcu_as_sc_mcu7t3v3__fillcap_8
Xinput307 VDD VDD VSS VSS west_in[13] _5784_/A gf180mcu_as_sc_mcu7t3v3__buff_12
Xinput318 VDD VDD VSS VSS west_in[23] _5864_/A gf180mcu_as_sc_mcu7t3v3__buff_12
X_6297_ VDD VDD VSS VSS clkload6/A _6297_/D _6297_/Q gf180mcu_as_sc_mcu7t3v3__dfxtp_2
XFILLER_152_37 VDD VDD VSS VSS gf180mcu_as_sc_mcu7t3v3__fillcap_16
Xinput329 VDD VDD VSS VSS west_in[33] wire977/A gf180mcu_as_sc_mcu7t3v3__buff_12
X_5248_ VDD VDD VSS VSS _5248_/B _5291_/A _6403_/D gf180mcu_as_sc_mcu7t3v3__and2_2
XFILLER_99_1210 VDD VDD VSS VSS gf180mcu_as_sc_mcu7t3v3__fill_2
X_5179_ VDD VDD VSS VSS _5833_/A _5304_/B _5296_/C _5833_/D _5180_/D gf180mcu_as_sc_mcu7t3v3__ao22_2
XFILLER_186_1235 VDD VDD VSS VSS gf180mcu_as_sc_mcu7t3v3__fillcap_4
XFILLER_149_1090 VDD VDD VSS VSS gf180mcu_as_sc_mcu7t3v3__fillcap_16
XFILLER_212_430 VDD VDD VSS VSS gf180mcu_as_sc_mcu7t3v3__fillcap_16
XTAP_TAPCELL_ROW_0_995 VDD VSS gf180mcu_as_sc_mcu7t3v3__tap_2
XFILLER_12_524 VDD VDD VSS VSS gf180mcu_as_sc_mcu7t3v3__fill_1
XFILLER_197_665 VDD VDD VSS VSS gf180mcu_as_sc_mcu7t3v3__fillcap_4
XFILLER_12_579 VDD VDD VSS VSS gf180mcu_as_sc_mcu7t3v3__fill_2
XFILLER_212_496 VDD VDD VSS VSS gf180mcu_as_sc_mcu7t3v3__fillcap_4
XFILLER_165_540 VDD VDD VSS VSS gf180mcu_as_sc_mcu7t3v3__fill_2
XFILLER_153_713 VDD VDD VSS VSS gf180mcu_as_sc_mcu7t3v3__fill_1
XFILLER_165_573 VDD VDD VSS VSS gf180mcu_as_sc_mcu7t3v3__fillcap_16
XTAP_TAPCELL_ROW_150_1442 VDD VSS gf180mcu_as_sc_mcu7t3v3__tap_2
XFILLER_193_88 VDD VDD VSS VSS gf180mcu_as_sc_mcu7t3v3__fillcap_4
XPHY_EDGE_ROW_91_3_Left_796 VDD VSS gf180mcu_as_sc_mcu7t3v3__tap_2
Xfanout1001 VDD VDD VSS VSS input2/Y _4248_/A gf180mcu_as_sc_mcu7t3v3__buff_12
XFILLER_0_951 VDD VDD VSS VSS gf180mcu_as_sc_mcu7t3v3__fill_1
XPHY_EDGE_ROW_98_2_Left_539 VDD VSS gf180mcu_as_sc_mcu7t3v3__tap_2
XFILLER_130_1245 VDD VDD VSS VSS gf180mcu_as_sc_mcu7t3v3__fillcap_16
XPHY_EDGE_ROW_18_1_Left_246 VDD VSS gf180mcu_as_sc_mcu7t3v3__tap_2
XFILLER_16_852 VDD VDD VSS VSS gf180mcu_as_sc_mcu7t3v3__fillcap_16
XFILLER_204_942 VDD VDD VSS VSS gf180mcu_as_sc_mcu7t3v3__fill_2
XPHY_EDGE_ROW_153_Left_381 VDD VSS gf180mcu_as_sc_mcu7t3v3__tap_2
XFILLER_187_131 VDD VDD VSS VSS gf180mcu_as_sc_mcu7t3v3__fill_2
XPHY_EDGE_ROW_76_2_Right_913 VDD VSS gf180mcu_as_sc_mcu7t3v3__tap_2
XFILLER_175_337 VDD VDD VSS VSS gf180mcu_as_sc_mcu7t3v3__fill_1
XFILLER_50_1235 VDD VDD VSS VSS gf180mcu_as_sc_mcu7t3v3__fillcap_8
XFILLER_11_1208 VDD VDD VSS VSS gf180mcu_as_sc_mcu7t3v3__fillcap_16
XPHY_EDGE_ROW_132_1_Left_360 VDD VSS gf180mcu_as_sc_mcu7t3v3__tap_2
XTAP_TAPCELL_ROW_170_1807 VDD VSS gf180mcu_as_sc_mcu7t3v3__tap_2
X_4550_ VDD VDD VSS VSS _6303_/D _6148_/Q _4551_/B _4550_/C gf180mcu_as_sc_mcu7t3v3__ao21_2
XFILLER_171_532 VDD VDD VSS VSS gf180mcu_as_sc_mcu7t3v3__fillcap_4
Xwire492 VDD VDD VSS VSS _4670_/Y _6342_/D gf180mcu_as_sc_mcu7t3v3__clkbuff_12
X_4481_ VDD VDD VSS VSS _4610_/C _4481_/A _4524_/B _4481_/C _4484_/B gf180mcu_as_sc_mcu7t3v3__ao31_2
X_3501_ VDD VDD VSS VSS _4624_/A _4264_/A _5938_/B gf180mcu_as_sc_mcu7t3v3__nand2b_2
XPHY_EDGE_ROW_162_Left_390 VDD VSS gf180mcu_as_sc_mcu7t3v3__tap_2
X_6220_ VDD VDD VSS VSS _6546_/CLK _6220_/D _6220_/Q gf180mcu_as_sc_mcu7t3v3__dfxtp_2
X_3432_ VDD VDD VSS VSS _3434_/D _3432_/B _3432_/A gf180mcu_as_sc_mcu7t3v3__nor2b_2
XTAP_TAPCELL_ROW_211_2538 VDD VSS gf180mcu_as_sc_mcu7t3v3__tap_2
X_6151_ VDD VDD VSS VSS _6509_/CLK _6151_/D _6151_/Q gf180mcu_as_sc_mcu7t3v3__dfxtp_2
X_3363_ VDD VDD VSS VSS _3364_/D _3364_/A _3363_/B _3363_/A gf180mcu_as_sc_mcu7t3v3__aoi21b_2
XFILLER_152_790 VDD VDD VSS VSS gf180mcu_as_sc_mcu7t3v3__fillcap_4
XFILLER_170_1014 VDD VDD VSS VSS gf180mcu_as_sc_mcu7t3v3__fill_1
XTAP_TAPCELL_ROW_16_1305 VDD VSS gf180mcu_as_sc_mcu7t3v3__tap_2
XTAP_TAPCELL_ROW_16_1316 VDD VSS gf180mcu_as_sc_mcu7t3v3__tap_2
XTAP_TAPCELL_ROW_16_1327 VDD VSS gf180mcu_as_sc_mcu7t3v3__tap_2
X_5102_ VDD VDD VSS VSS _5221_/B _5766_/A _5103_/C gf180mcu_as_sc_mcu7t3v3__and2_2
XFILLER_112_665 VDD VDD VSS VSS gf180mcu_as_sc_mcu7t3v3__fill_2
XTAP_TAPCELL_ROW_168_1758 VDD VSS gf180mcu_as_sc_mcu7t3v3__tap_2
XTAP_TAPCELL_ROW_168_1769 VDD VSS gf180mcu_as_sc_mcu7t3v3__tap_2
Xhold1206 VDD VDD VSS VSS hold1232/Y _6535_/D gf180mcu_as_sc_mcu7t3v3__clkbuff_4
X_6082_ VDD VDD VSS VSS _6368_/CLK _6082_/D _6082_/Q gf180mcu_as_sc_mcu7t3v3__dfxtp_2
X_3294_ VDD VDD VSS VSS _3295_/D _3299_/A _3294_/B _3294_/A gf180mcu_as_sc_mcu7t3v3__aoi21b_2
XTAP_TAPCELL_ROW_54_3_2930 VDD VSS gf180mcu_as_sc_mcu7t3v3__tap_2
Xhold1217 VDD VDD VSS VSS _6208_/Q _5985_/A gf180mcu_as_sc_mcu7t3v3__clkbuff_4
Xhold1228 VDD VDD VSS VSS _6537_/Q hold1228/Y gf180mcu_as_sc_mcu7t3v3__clkbuff_4
X_5033_ VDD VDD VSS VSS _5703_/A _5144_/B _5033_/C _5033_/D _5034_/A gf180mcu_as_sc_mcu7t3v3__ao211_2
XFILLER_0_1155 VDD VDD VSS VSS gf180mcu_as_sc_mcu7t3v3__fill_1
XFILLER_0_1177 VDD VDD VSS VSS gf180mcu_as_sc_mcu7t3v3__fillcap_4
X_5935_ VDD VDD VSS VSS _5935_/B _5956_/A _6480_/D gf180mcu_as_sc_mcu7t3v3__and2_2
XFILLER_178_131 VDD VDD VSS VSS gf180mcu_as_sc_mcu7t3v3__fill_1
XFILLER_181_1154 VDD VDD VSS VSS gf180mcu_as_sc_mcu7t3v3__fillcap_16
X_5866_ VDD VDD VSS VSS _5866_/A _5869_/B _5866_/C _5866_/D _5867_/B gf180mcu_as_sc_mcu7t3v3__ao211_2
XFILLER_221_293 VDD VDD VSS VSS gf180mcu_as_sc_mcu7t3v3__fillcap_4
X_4817_ VDD VDD VSS VSS _4817_/B _4826_/A _6358_/D gf180mcu_as_sc_mcu7t3v3__and2_2
XFILLER_166_337 VDD VDD VSS VSS gf180mcu_as_sc_mcu7t3v3__fill_1
XFILLER_222_1151 VDD VDD VSS VSS gf180mcu_as_sc_mcu7t3v3__fillcap_4
XPHY_EDGE_ROW_64_1_Left_292 VDD VSS gf180mcu_as_sc_mcu7t3v3__tap_2
X_5797_ VDD VDD VSS VSS _5797_/B _5797_/A _5800_/C gf180mcu_as_sc_mcu7t3v3__and2_2
XFILLER_222_1173 VDD VDD VSS VSS gf180mcu_as_sc_mcu7t3v3__fillcap_16
X_4748_ VDD VDD VSS VSS _4896_/A _4748_/B _6503_/Q _4750_/C gf180mcu_as_sc_mcu7t3v3__mux2_2
XPHY_EDGE_ROW_17_1_Left_457 VDD VSS gf180mcu_as_sc_mcu7t3v3__tap_2
X_4679_ VDD VDD VSS VSS _4679_/B _5956_/A _6343_/D gf180mcu_as_sc_mcu7t3v3__and2_2
XFILLER_190_874 VDD VDD VSS VSS gf180mcu_as_sc_mcu7t3v3__fill_1
XPHY_EDGE_ROW_1_Right_1 VDD VSS gf180mcu_as_sc_mcu7t3v3__tap_2
X_6418_ VDD VDD VSS VSS _6422_/CLK _6418_/D _6418_/Q gf180mcu_as_sc_mcu7t3v3__dfxtp_2
XFILLER_150_716 VDD VDD VSS VSS gf180mcu_as_sc_mcu7t3v3__fill_1
X_6349_ VDD VDD VSS VSS _6526_/CLK _6349_/D _6349_/Q gf180mcu_as_sc_mcu7t3v3__dfxtp_2
Xmax_cap792 VDD VDD VSS VSS fanout791/Y _4841_/B gf180mcu_as_sc_mcu7t3v3__clkbuff_12
XFILLER_163_58 VDD VDD VSS VSS gf180mcu_as_sc_mcu7t3v3__fillcap_8
Xinput104 VDD VDD VSS VSS ne_in[26] _5890_/A gf180mcu_as_sc_mcu7t3v3__buff_12
Xinput115 VDD VDD VSS VSS ne_in[3] _5697_/A gf180mcu_as_sc_mcu7t3v3__buff_12
Xinput126 VDD VDD VSS VSS north_in[13] _5782_/B gf180mcu_as_sc_mcu7t3v3__buff_12
Xinput137 VDD VDD VSS VSS north_in[23] _5862_/B gf180mcu_as_sc_mcu7t3v3__buff_12
Xinput148 VDD VDD VSS VSS north_in[33] _5302_/A gf180mcu_as_sc_mcu7t3v3__buff_12
Xinput159 VDD VDD VSS VSS nw_in[10] _5760_/A gf180mcu_as_sc_mcu7t3v3__buff_12
XFILLER_56_45 VDD VDD VSS VSS gf180mcu_as_sc_mcu7t3v3__fillcap_4
XFILLER_16_104 VDD VDD VSS VSS gf180mcu_as_sc_mcu7t3v3__fillcap_16
XFILLER_217_566 VDD VDD VSS VSS gf180mcu_as_sc_mcu7t3v3__fill_2
XFILLER_186_1065 VDD VDD VSS VSS gf180mcu_as_sc_mcu7t3v3__fillcap_16
XTAP_TAPCELL_ROW_116_1_1379 VDD VSS gf180mcu_as_sc_mcu7t3v3__tap_2
XFILLER_186_1087 VDD VDD VSS VSS gf180mcu_as_sc_mcu7t3v3__fillcap_16
XFILLER_25_660 VDD VDD VSS VSS gf180mcu_as_sc_mcu7t3v3__fill_2
XFILLER_72_33 VDD VDD VSS VSS gf180mcu_as_sc_mcu7t3v3__fill_2
XFILLER_13_833 VDD VDD VSS VSS gf180mcu_as_sc_mcu7t3v3__fillcap_4
XFILLER_169_120 VDD VDD VSS VSS gf180mcu_as_sc_mcu7t3v3__fillcap_16
XFILLER_169_142 VDD VDD VSS VSS gf180mcu_as_sc_mcu7t3v3__fillcap_16
XFILLER_198_963 VDD VDD VSS VSS gf180mcu_as_sc_mcu7t3v3__fillcap_16
XFILLER_213_772 VDD VDD VSS VSS gf180mcu_as_sc_mcu7t3v3__fillcap_4
XFILLER_158_838 VDD VDD VSS VSS gf180mcu_as_sc_mcu7t3v3__fill_2
XFILLER_160_1205 VDD VDD VSS VSS gf180mcu_as_sc_mcu7t3v3__fillcap_16
XFILLER_160_1227 VDD VDD VSS VSS gf180mcu_as_sc_mcu7t3v3__fillcap_16
XFILLER_227_1084 VDD VDD VSS VSS gf180mcu_as_sc_mcu7t3v3__fillcap_16
XFILLER_40_663 VDD VDD VSS VSS gf180mcu_as_sc_mcu7t3v3__fillcap_4
XFILLER_9_804 VDD VDD VSS VSS gf180mcu_as_sc_mcu7t3v3__fillcap_16
XFILLER_12_365 VDD VDD VSS VSS gf180mcu_as_sc_mcu7t3v3__fillcap_8
XFILLER_12_387 VDD VDD VSS VSS gf180mcu_as_sc_mcu7t3v3__fill_1
XFILLER_201_978 VDD VDD VSS VSS gf180mcu_as_sc_mcu7t3v3__fill_2
XFILLER_184_167 VDD VDD VSS VSS gf180mcu_as_sc_mcu7t3v3__fill_1
XFILLER_200_477 VDD VDD VSS VSS gf180mcu_as_sc_mcu7t3v3__fillcap_16
XFILLER_201_1224 VDD VDD VSS VSS gf180mcu_as_sc_mcu7t3v3__fillcap_8
XFILLER_153_521 VDD VDD VSS VSS gf180mcu_as_sc_mcu7t3v3__fillcap_4
XFILLER_172_329 VDD VDD VSS VSS gf180mcu_as_sc_mcu7t3v3__fill_2
XFILLER_193_1014 VDD VDD VSS VSS gf180mcu_as_sc_mcu7t3v3__fillcap_16
XFILLER_10_1263 VDD VDD VSS VSS gf180mcu_as_sc_mcu7t3v3__fill_2
XFILLER_158_1189 VDD VDD VSS VSS gf180mcu_as_sc_mcu7t3v3__fillcap_16
XFILLER_180_384 VDD VDD VSS VSS gf180mcu_as_sc_mcu7t3v3__fill_1
XTAP_TAPCELL_ROW_189_2150 VDD VSS gf180mcu_as_sc_mcu7t3v3__tap_2
XFILLER_4_597 VDD VDD VSS VSS gf180mcu_as_sc_mcu7t3v3__fillcap_4
XFILLER_228_809 VDD VDD VSS VSS gf180mcu_as_sc_mcu7t3v3__fillcap_4
XTAP_TAPCELL_ROW_185_2069 VDD VSS gf180mcu_as_sc_mcu7t3v3__tap_2
XTAP_TAPCELL_ROW_11_1213 VDD VSS gf180mcu_as_sc_mcu7t3v3__tap_2
XFILLER_208_555 VDD VDD VSS VSS gf180mcu_as_sc_mcu7t3v3__fill_1
XPHY_EDGE_ROW_17_1_Right_721 VDD VSS gf180mcu_as_sc_mcu7t3v3__tap_2
XFILLER_165_1116 VDD VDD VSS VSS gf180mcu_as_sc_mcu7t3v3__fillcap_4
XTAP_TAPCELL_ROW_145_2_3066 VDD VSS gf180mcu_as_sc_mcu7t3v3__tap_2
XTAP_TAPCELL_ROW_163_1677 VDD VSS gf180mcu_as_sc_mcu7t3v3__tap_2
XFILLER_165_1138 VDD VDD VSS VSS gf180mcu_as_sc_mcu7t3v3__fillcap_16
X_3981_ VDD VDD VSS VSS _3981_/D _4053_/A _4061_/B _3981_/C _6073_/D gf180mcu_as_sc_mcu7t3v3__ao31_2
XTAP_TAPCELL_ROW_180_1980 VDD VSS gf180mcu_as_sc_mcu7t3v3__tap_2
XFILLER_16_682 VDD VDD VSS VSS gf180mcu_as_sc_mcu7t3v3__fillcap_16
XFILLER_188_440 VDD VDD VSS VSS gf180mcu_as_sc_mcu7t3v3__fillcap_4
XFILLER_189_974 VDD VDD VSS VSS gf180mcu_as_sc_mcu7t3v3__fillcap_4
X_5720_ VDD VDD VSS VSS _5721_/B _5720_/A _5802_/B _5720_/C gf180mcu_as_sc_mcu7t3v3__ao21_2
XFILLER_203_282 VDD VDD VSS VSS gf180mcu_as_sc_mcu7t3v3__fill_2
XFILLER_206_1135 VDD VDD VSS VSS gf180mcu_as_sc_mcu7t3v3__fillcap_16
XFILLER_206_1157 VDD VDD VSS VSS gf180mcu_as_sc_mcu7t3v3__fillcap_16
XPHY_EDGE_ROW_77_2_Right_914 VDD VSS gf180mcu_as_sc_mcu7t3v3__tap_2
X_5651_ VDD VDD VSS VSS _5651_/Y _5886_/B _5878_/S gf180mcu_as_sc_mcu7t3v3__nand2_2
XFILLER_191_616 VDD VDD VSS VSS gf180mcu_as_sc_mcu7t3v3__fillcap_8
X_5582_ VDD VDD VSS VSS _5889_/D _5632_/B _5632_/C _5889_/A _5583_/D gf180mcu_as_sc_mcu7t3v3__ao22_2
X_4602_ VDD VDD VSS VSS _6337_/D _4602_/C _4602_/B _4602_/A gf180mcu_as_sc_mcu7t3v3__aoi21b_2
XFILLER_7_72 VDD VDD VSS VSS gf180mcu_as_sc_mcu7t3v3__fillcap_16
X_4533_ VDD VDD VSS VSS _4537_/S _6297_/Q _6298_/Q _4534_/B gf180mcu_as_sc_mcu7t3v3__mux2_2
XFILLER_171_340 VDD VDD VSS VSS gf180mcu_as_sc_mcu7t3v3__fillcap_8
X_6203_ VDD VDD VSS VSS _6365_/CLK _6203_/D _6203_/Q gf180mcu_as_sc_mcu7t3v3__dfxtp_2
X_4464_ VDD VDD VSS VSS _4464_/B _6272_/Q _4465_/D gf180mcu_as_sc_mcu7t3v3__and2_2
Xclkbuf_leaf_35_clk_regs VDD VDD VSS VSS clkbuf_3_0_0_clk_regs/Y _6527_/CLK gf180mcu_as_sc_mcu7t3v3__clkbuff_12
Xfanout805 VDD VDD VSS VSS _3850_/C _3804_/C gf180mcu_as_sc_mcu7t3v3__buff_12
Xfanout816 VDD VDD VSS VSS _5186_/B _5132_/B gf180mcu_as_sc_mcu7t3v3__buff_12
X_4395_ VDD VDD VSS VSS _6224_/D _4395_/B _4395_/A gf180mcu_as_sc_mcu7t3v3__nand2_2
X_3415_ VDD VDD VSS VSS _6164_/Q _6195_/Q _6211_/Q _3417_/B gf180mcu_as_sc_mcu7t3v3__mux2_2
XFILLER_217_1264 VDD VDD VSS VSS gf180mcu_as_sc_mcu7t3v3__fill_1
Xfanout827 VDD VDD VSS VSS _5122_/A _5301_/S gf180mcu_as_sc_mcu7t3v3__buff_12
Xfanout838 VDD VDD VSS VSS _4858_/B _4885_/B gf180mcu_as_sc_mcu7t3v3__buff_12
Xfanout849 VDD VDD VSS VSS _4599_/A _4546_/B gf180mcu_as_sc_mcu7t3v3__buff_12
X_6134_ VDD VDD VSS VSS _6313_/CLK _6134_/D _6134_/Q gf180mcu_as_sc_mcu7t3v3__dfxtp_2
X_3346_ VDD VDD VSS VSS _4076_/B _3346_/B _3346_/C _3346_/D _3348_/C gf180mcu_as_sc_mcu7t3v3__ao22_2
XTAP_TAPCELL_ROW_228_2843 VDD VSS gf180mcu_as_sc_mcu7t3v3__tap_2
X_6065_ VDD VDD VSS VSS _6492_/CLK _6065_/D _6065_/Q gf180mcu_as_sc_mcu7t3v3__dfxtp_2
XTAP_TAPCELL_ROW_228_2865 VDD VSS gf180mcu_as_sc_mcu7t3v3__tap_2
XTAP_TAPCELL_ROW_228_2854 VDD VSS gf180mcu_as_sc_mcu7t3v3__tap_2
X_5016_ VDD VDD VSS VSS _5237_/S _5687_/A _5016_/A _5017_/B gf180mcu_as_sc_mcu7t3v3__mux2_2
X_3277_ VDD VDD VSS VSS _3278_/D _3277_/C _3277_/B _3277_/A gf180mcu_as_sc_mcu7t3v3__aoi21b_2
XFILLER_227_842 VDD VDD VSS VSS gf180mcu_as_sc_mcu7t3v3__fillcap_4
XFILLER_213_72 VDD VDD VSS VSS gf180mcu_as_sc_mcu7t3v3__fillcap_16
XFILLER_26_37 VDD VDD VSS VSS gf180mcu_as_sc_mcu7t3v3__fillcap_8
XFILLER_199_738 VDD VDD VSS VSS gf180mcu_as_sc_mcu7t3v3__fillcap_8
XFILLER_179_440 VDD VDD VSS VSS gf180mcu_as_sc_mcu7t3v3__fillcap_8
X_5918_ VDD VDD VSS VSS _5925_/B _5947_/B _5918_/A gf180mcu_as_sc_mcu7t3v3__nand2_2
XFILLER_166_123 VDD VDD VSS VSS gf180mcu_as_sc_mcu7t3v3__fillcap_16
XFILLER_195_944 VDD VDD VSS VSS gf180mcu_as_sc_mcu7t3v3__fillcap_16
X_5849_ VDD VDD VSS VSS _5849_/A _5874_/B _5873_/B _5849_/D _5850_/D gf180mcu_as_sc_mcu7t3v3__ao22_2
XFILLER_158_69 VDD VDD VSS VSS gf180mcu_as_sc_mcu7t3v3__fillcap_16
XFILLER_6_807 VDD VDD VSS VSS gf180mcu_as_sc_mcu7t3v3__fill_2
XFILLER_181_104 VDD VDD VSS VSS gf180mcu_as_sc_mcu7t3v3__fillcap_8
XTAP_TAPCELL_ROW_80_1_1361 VDD VSS gf180mcu_as_sc_mcu7t3v3__tap_2
XFILLER_218_1017 VDD VDD VSS VSS gf180mcu_as_sc_mcu7t3v3__fillcap_16
XTAP_TAPCELL_ROW_8_1156 VDD VSS gf180mcu_as_sc_mcu7t3v3__tap_2
XFILLER_40_1245 VDD VDD VSS VSS gf180mcu_as_sc_mcu7t3v3__fillcap_16
XPHY_EDGE_ROW_122_3_Left_827 VDD VSS gf180mcu_as_sc_mcu7t3v3__tap_2
XFILLER_217_352 VDD VDD VSS VSS gf180mcu_as_sc_mcu7t3v3__fill_1
XFILLER_83_32 VDD VDD VSS VSS gf180mcu_as_sc_mcu7t3v3__fillcap_4
XFILLER_199_43 VDD VDD VSS VSS gf180mcu_as_sc_mcu7t3v3__fillcap_16
XFILLER_198_771 VDD VDD VSS VSS gf180mcu_as_sc_mcu7t3v3__fill_2
XFILLER_13_663 VDD VDD VSS VSS gf180mcu_as_sc_mcu7t3v3__fill_1
XFILLER_160_1013 VDD VDD VSS VSS gf180mcu_as_sc_mcu7t3v3__fill_2
XFILLER_185_454 VDD VDD VSS VSS gf180mcu_as_sc_mcu7t3v3__fillcap_16
XFILLER_199_1234 VDD VDD VSS VSS gf180mcu_as_sc_mcu7t3v3__fill_1
XTAP_TAPCELL_ROW_32_2_2896 VDD VSS gf180mcu_as_sc_mcu7t3v3__tap_2
XFILLER_173_627 VDD VDD VSS VSS gf180mcu_as_sc_mcu7t3v3__fill_2
XFILLER_8_155 VDD VDD VSS VSS gf180mcu_as_sc_mcu7t3v3__fillcap_16
XFILLER_8_177 VDD VDD VSS VSS gf180mcu_as_sc_mcu7t3v3__fillcap_16
XFILLER_9_689 VDD VDD VSS VSS gf180mcu_as_sc_mcu7t3v3__fill_1
Xoutput408 VDD VDD VSS VSS _6373_/Q north_out[32] gf180mcu_as_sc_mcu7t3v3__buff_12
XFILLER_154_874 VDD VDD VSS VSS gf180mcu_as_sc_mcu7t3v3__fill_1
Xoutput419 VDD VDD VSS VSS _6377_/Q south_out[0] gf180mcu_as_sc_mcu7t3v3__buff_12
XTAP_TAPCELL_ROW_187_2109 VDD VSS gf180mcu_as_sc_mcu7t3v3__tap_2
XFILLER_180_181 VDD VDD VSS VSS gf180mcu_as_sc_mcu7t3v3__fill_1
XFILLER_136_1240 VDD VDD VSS VSS gf180mcu_as_sc_mcu7t3v3__fill_2
X_4180_ VDD VDD VSS VSS _4342_/S _6127_/Q _6040_/Q _4182_/A gf180mcu_as_sc_mcu7t3v3__mux2_2
X_3200_ VDD VDD VSS VSS _3200_/Y _3200_/B _3200_/A gf180mcu_as_sc_mcu7t3v3__nand2b_2
XTAP_TAPCELL_ROW_165_1706 VDD VSS gf180mcu_as_sc_mcu7t3v3__tap_2
XTAP_TAPCELL_ROW_165_1717 VDD VSS gf180mcu_as_sc_mcu7t3v3__tap_2
X_3131_ VDD VDD VSS VSS _3136_/D _4566_/A _4481_/A _6278_/Q gf180mcu_as_sc_mcu7t3v3__aoi21_2
XFILLER_171_1186 VDD VDD VSS VSS gf180mcu_as_sc_mcu7t3v3__fillcap_4
XFILLER_95_666 VDD VDD VSS VSS gf180mcu_as_sc_mcu7t3v3__fill_1
XPHY_EDGE_ROW_54_3_Left_759 VDD VSS gf180mcu_as_sc_mcu7t3v3__tap_2
XPHY_EDGE_ROW_31_2_Left_472 VDD VSS gf180mcu_as_sc_mcu7t3v3__tap_2
X_3062_ VDD VDD VSS VSS _4497_/D _6286_/Q gf180mcu_as_sc_mcu7t3v3__inv_2
XTAP_TAPCELL_ROW_206_2448 VDD VSS gf180mcu_as_sc_mcu7t3v3__tap_2
XTAP_TAPCELL_ROW_22_1_1332 VDD VSS gf180mcu_as_sc_mcu7t3v3__tap_2
XTAP_TAPCELL_ROW_223_2762 VDD VSS gf180mcu_as_sc_mcu7t3v3__tap_2
XTAP_TAPCELL_ROW_223_2751 VDD VSS gf180mcu_as_sc_mcu7t3v3__tap_2
XPHY_EDGE_ROW_209_Right_77 VDD VSS gf180mcu_as_sc_mcu7t3v3__tap_2
XFILLER_211_539 VDD VDD VSS VSS gf180mcu_as_sc_mcu7t3v3__fillcap_4
XFILLER_56_1252 VDD VDD VSS VSS gf180mcu_as_sc_mcu7t3v3__fillcap_8
X_3964_ VDD VDD VSS VSS _3964_/D _4043_/A _4045_/B _3975_/B _6063_/D gf180mcu_as_sc_mcu7t3v3__ao31_2
XFILLER_176_421 VDD VDD VSS VSS gf180mcu_as_sc_mcu7t3v3__fillcap_4
XFILLER_204_591 VDD VDD VSS VSS gf180mcu_as_sc_mcu7t3v3__fillcap_4
X_5703_ VDD VDD VSS VSS _5703_/A _5802_/B _5703_/C _5844_/B _5705_/A gf180mcu_as_sc_mcu7t3v3__ao211_2
X_3895_ VDD VDD VSS VSS _6040_/Q _3895_/B _4055_/B _3895_/D _6040_/D gf180mcu_as_sc_mcu7t3v3__ao22_2
XFILLER_149_679 VDD VDD VSS VSS gf180mcu_as_sc_mcu7t3v3__fill_1
XPHY_EDGE_ROW_78_2_Right_915 VDD VSS gf180mcu_as_sc_mcu7t3v3__tap_2
X_5634_ VDD VDD VSS VSS _5947_/A _5634_/B _5634_/C _5634_/D _5635_/A gf180mcu_as_sc_mcu7t3v3__ao211_2
XFILLER_163_104 VDD VDD VSS VSS gf180mcu_as_sc_mcu7t3v3__fillcap_16
XFILLER_191_402 VDD VDD VSS VSS gf180mcu_as_sc_mcu7t3v3__fillcap_4
XFILLER_192_947 VDD VDD VSS VSS gf180mcu_as_sc_mcu7t3v3__fillcap_8
XPHY_EDGE_ROW_218_Right_86 VDD VSS gf180mcu_as_sc_mcu7t3v3__tap_2
X_5565_ VDD VDD VSS VSS _5566_/D _5565_/B _5872_/D gf180mcu_as_sc_mcu7t3v3__nand2b_2
XTAP_TAPCELL_ROW_42_3_2912 VDD VSS gf180mcu_as_sc_mcu7t3v3__tap_2
XFILLER_191_479 VDD VDD VSS VSS gf180mcu_as_sc_mcu7t3v3__fill_1
X_5496_ VDD VDD VSS VSS _5497_/D _5497_/B _5496_/B _5802_/A gf180mcu_as_sc_mcu7t3v3__aoi21_2
X_4516_ VDD VDD VSS VSS _4520_/S _6718_/A _6292_/Q _4517_/A gf180mcu_as_sc_mcu7t3v3__mux2_2
X_4447_ VDD VDD VSS VSS _4448_/B _6135_/Q _4447_/Y gf180mcu_as_sc_mcu7t3v3__and2_2
XFILLER_63_1212 VDD VDD VSS VSS gf180mcu_as_sc_mcu7t3v3__fill_1
Xfanout602 VDD VDD VSS VSS _5189_/B _5098_/B gf180mcu_as_sc_mcu7t3v3__buff_12
Xfanout613 VDD VDD VSS VSS _3931_/B _3892_/B gf180mcu_as_sc_mcu7t3v3__buff_12
Xfanout624 VDD VDD VSS VSS _5842_/B _5858_/B gf180mcu_as_sc_mcu7t3v3__buff_12
XFILLER_144_49 VDD VDD VSS VSS gf180mcu_as_sc_mcu7t3v3__fill_2
Xfanout635 VDD VDD VSS VSS _4842_/B _4862_/B gf180mcu_as_sc_mcu7t3v3__buff_12
Xfanout646 VDD VDD VSS VSS _3358_/A _3343_/A gf180mcu_as_sc_mcu7t3v3__buff_12
Xfanout657 VDD VDD VSS VSS _5842_/C _5800_/B gf180mcu_as_sc_mcu7t3v3__buff_12
X_6117_ VDD VDD VSS VSS _6125_/CLK _6117_/D _6117_/Q gf180mcu_as_sc_mcu7t3v3__dfxtp_2
X_4378_ VDD VDD VSS VSS _6222_/Q _4406_/B _4406_/C _6223_/Q _4379_/C gf180mcu_as_sc_mcu7t3v3__ao22_2
Xfanout668 VDD VDD VSS VSS _5670_/Y _5837_/B gf180mcu_as_sc_mcu7t3v3__buff_12
Xfanout679 VDD VDD VSS VSS _5535_/B _5551_/B gf180mcu_as_sc_mcu7t3v3__buff_12
X_3329_ VDD VDD VSS VSS _6206_/Q _3361_/B _4098_/S _6214_/Q _3330_/C gf180mcu_as_sc_mcu7t3v3__ao22_2
XPHY_EDGE_ROW_227_Right_95 VDD VSS gf180mcu_as_sc_mcu7t3v3__tap_2
X_6048_ VDD VDD VSS VSS _6371_/CLK _6048_/D _6048_/Q gf180mcu_as_sc_mcu7t3v3__dfxtp_2
XFILLER_160_37 VDD VDD VSS VSS gf180mcu_as_sc_mcu7t3v3__fillcap_16
XFILLER_15_906 VDD VDD VSS VSS gf180mcu_as_sc_mcu7t3v3__fillcap_4
XFILLER_15_928 VDD VDD VSS VSS gf180mcu_as_sc_mcu7t3v3__fillcap_16
XFILLER_163_6 VDD VDD VSS VSS gf180mcu_as_sc_mcu7t3v3__fillcap_4
XFILLER_183_1002 VDD VDD VSS VSS gf180mcu_as_sc_mcu7t3v3__fill_1
XFILLER_215_834 VDD VDD VSS VSS gf180mcu_as_sc_mcu7t3v3__fillcap_4
XFILLER_14_438 VDD VDD VSS VSS gf180mcu_as_sc_mcu7t3v3__fillcap_4
XFILLER_53_35 VDD VDD VSS VSS gf180mcu_as_sc_mcu7t3v3__fillcap_16
XTAP_TAPCELL_ROW_3_1075 VDD VSS gf180mcu_as_sc_mcu7t3v3__tap_2
XTAP_TAPCELL_ROW_3_1064 VDD VSS gf180mcu_as_sc_mcu7t3v3__tap_2
XFILLER_183_1068 VDD VDD VSS VSS gf180mcu_as_sc_mcu7t3v3__fillcap_16
XFILLER_186_218 VDD VDD VSS VSS gf180mcu_as_sc_mcu7t3v3__fillcap_4
XFILLER_187_719 VDD VDD VSS VSS gf180mcu_as_sc_mcu7t3v3__fill_1
XFILLER_224_1065 VDD VDD VSS VSS gf180mcu_as_sc_mcu7t3v3__fillcap_16
XFILLER_210_561 VDD VDD VSS VSS gf180mcu_as_sc_mcu7t3v3__fill_1
XFILLER_224_1087 VDD VDD VSS VSS gf180mcu_as_sc_mcu7t3v3__fillcap_16
XFILLER_70_1238 VDD VDD VSS VSS gf180mcu_as_sc_mcu7t3v3__fillcap_4
XFILLER_210_583 VDD VDD VSS VSS gf180mcu_as_sc_mcu7t3v3__fill_1
XFILLER_182_457 VDD VDD VSS VSS gf180mcu_as_sc_mcu7t3v3__fillcap_4
XFILLER_5_136 VDD VDD VSS VSS gf180mcu_as_sc_mcu7t3v3__fillcap_4
XFILLER_159_1262 VDD VDD VSS VSS gf180mcu_as_sc_mcu7t3v3__fill_2
XFILLER_5_158 VDD VDD VSS VSS gf180mcu_as_sc_mcu7t3v3__fillcap_16
XPHY_EDGE_ROW_27_1_Left_255 VDD VSS gf180mcu_as_sc_mcu7t3v3__tap_2
XFILLER_190_1017 VDD VDD VSS VSS gf180mcu_as_sc_mcu7t3v3__fillcap_16
XFILLER_2_854 VDD VDD VSS VSS gf180mcu_as_sc_mcu7t3v3__fill_2
XPHY_EDGE_ROW_40_2_Right_877 VDD VSS gf180mcu_as_sc_mcu7t3v3__tap_2
XFILLER_150_387 VDD VDD VSS VSS gf180mcu_as_sc_mcu7t3v3__fill_2
XTAP_TAPCELL_ROW_182_2017 VDD VSS gf180mcu_as_sc_mcu7t3v3__tap_2
XFILLER_77_666 VDD VDD VSS VSS gf180mcu_as_sc_mcu7t3v3__fill_1
XFILLER_209_138 VDD VDD VSS VSS gf180mcu_as_sc_mcu7t3v3__fill_2
XFILLER_94_31 VDD VDD VSS VSS gf180mcu_as_sc_mcu7t3v3__fillcap_4
Xmesh_tile_1078 VDD VDD VSS VSS nw_out[1] gf180mcu_as_sc_mcu7t3v3__tiel_4
Xmesh_tile_1067 VDD VDD VSS VSS ne_out[26] gf180mcu_as_sc_mcu7t3v3__tiel_4
Xmesh_tile_1056 VDD VDD VSS VSS ne_out[15] gf180mcu_as_sc_mcu7t3v3__tiel_4
Xmesh_tile_1045 VDD VDD VSS VSS ne_out[4] gf180mcu_as_sc_mcu7t3v3__tiel_4
XFILLER_220_18 VDD VDD VSS VSS gf180mcu_as_sc_mcu7t3v3__fillcap_16
XTAP_TAPCELL_ROW_160_1614 VDD VSS gf180mcu_as_sc_mcu7t3v3__tap_2
XTAP_TAPCELL_ROW_160_1625 VDD VSS gf180mcu_as_sc_mcu7t3v3__tap_2
Xmesh_tile_1089 VDD VDD VSS VSS nw_out[12] gf180mcu_as_sc_mcu7t3v3__tiel_4
XFILLER_221_804 VDD VDD VSS VSS gf180mcu_as_sc_mcu7t3v3__fill_1
XTAP_TAPCELL_ROW_201_2356 VDD VSS gf180mcu_as_sc_mcu7t3v3__tap_2
XFILLER_162_1119 VDD VDD VSS VSS gf180mcu_as_sc_mcu7t3v3__fillcap_16
XTAP_TAPCELL_ROW_201_2367 VDD VSS gf180mcu_as_sc_mcu7t3v3__tap_2
XTAP_TAPCELL_ROW_197_2282 VDD VSS gf180mcu_as_sc_mcu7t3v3__tap_2
XFILLER_186_730 VDD VDD VSS VSS gf180mcu_as_sc_mcu7t3v3__fillcap_4
XFILLER_220_358 VDD VDD VSS VSS gf180mcu_as_sc_mcu7t3v3__fill_2
XTAP_TAPCELL_ROW_197_2293 VDD VSS gf180mcu_as_sc_mcu7t3v3__tap_2
XFILLER_158_443 VDD VDD VSS VSS gf180mcu_as_sc_mcu7t3v3__fill_1
XFILLER_203_1116 VDD VDD VSS VSS gf180mcu_as_sc_mcu7t3v3__fillcap_4
XFILLER_203_1138 VDD VDD VSS VSS gf180mcu_as_sc_mcu7t3v3__fillcap_16
XFILLER_174_947 VDD VDD VSS VSS gf180mcu_as_sc_mcu7t3v3__fillcap_4
XTAP_TAPCELL_ROW_158_1587 VDD VSS gf180mcu_as_sc_mcu7t3v3__tap_2
X_3680_ VDD VDD VSS VSS _3805_/B _5689_/A _3681_/D gf180mcu_as_sc_mcu7t3v3__and2_2
XTAP_TAPCELL_ROW_175_1890 VDD VSS gf180mcu_as_sc_mcu7t3v3__tap_2
XFILLER_160_107 VDD VDD VSS VSS gf180mcu_as_sc_mcu7t3v3__fillcap_16
XFILLER_86_1245 VDD VDD VSS VSS gf180mcu_as_sc_mcu7t3v3__fillcap_16
X_5350_ VDD VDD VSS VSS _5350_/A _5350_/B _5350_/C _5659_/B _5350_/D gf180mcu_as_sc_mcu7t3v3__aoi211_2
X_5281_ VDD VDD VSS VSS _5918_/A _5306_/B _5281_/C _5281_/D _5282_/A gf180mcu_as_sc_mcu7t3v3__ao211_2
X_4301_ VDD VDD VSS VSS _6211_/Q _4399_/B _4399_/C _6212_/Q _4302_/C gf180mcu_as_sc_mcu7t3v3__ao22_2
X_4232_ VDD VDD VSS VSS _4335_/S _6103_/Q _6016_/Q _4234_/A gf180mcu_as_sc_mcu7t3v3__mux2_2
XTAP_TAPCELL_ROW_133_2_3048 VDD VSS gf180mcu_as_sc_mcu7t3v3__tap_2
XFILLER_228_414 VDD VDD VSS VSS gf180mcu_as_sc_mcu7t3v3__fill_1
X_4163_ VDD VDD VSS VSS _6194_/Q _4163_/B _4163_/C _4163_/D _4171_/A gf180mcu_as_sc_mcu7t3v3__nand4_2
X_4094_ VDD VDD VSS VSS _4098_/S _6715_/A _6154_/Q _6154_/D gf180mcu_as_sc_mcu7t3v3__mux2_2
X_3114_ VDD VDD VSS VSS _4539_/A _4579_/D _4471_/C gf180mcu_as_sc_mcu7t3v3__and2_2
XFILLER_110_1210 VDD VDD VSS VSS gf180mcu_as_sc_mcu7t3v3__fillcap_8
X_3045_ VDD VDD VSS VSS _3229_/A _6268_/Q gf180mcu_as_sc_mcu7t3v3__inv_2
XFILLER_12_909 VDD VDD VSS VSS gf180mcu_as_sc_mcu7t3v3__fillcap_16
XFILLER_208_1049 VDD VDD VSS VSS gf180mcu_as_sc_mcu7t3v3__fillcap_16
XPHY_EDGE_ROW_140_3_Right_220 VDD VSS gf180mcu_as_sc_mcu7t3v3__tap_2
X_4996_ VDD VDD VSS VSS _6493_/Q _5233_/C _4996_/C _4996_/D _5006_/D gf180mcu_as_sc_mcu7t3v3__ao22_2
XFILLER_149_410 VDD VDD VSS VSS gf180mcu_as_sc_mcu7t3v3__fillcap_8
XFILLER_23_27 VDD VDD VSS VSS gf180mcu_as_sc_mcu7t3v3__fillcap_16
X_3947_ VDD VDD VSS VSS _6051_/D _3947_/C _3948_/C _4028_/A gf180mcu_as_sc_mcu7t3v3__ao21b_2
XFILLER_149_432 VDD VDD VSS VSS gf180mcu_as_sc_mcu7t3v3__fillcap_8
XFILLER_139_38 VDD VDD VSS VSS gf180mcu_as_sc_mcu7t3v3__fillcap_8
XPHY_EDGE_ROW_79_2_Right_916 VDD VSS gf180mcu_as_sc_mcu7t3v3__tap_2
X_3878_ VDD VDD VSS VSS _3888_/B _5861_/A _3879_/D gf180mcu_as_sc_mcu7t3v3__and2_2
XFILLER_164_457 VDD VDD VSS VSS gf180mcu_as_sc_mcu7t3v3__fillcap_16
X_5617_ VDD VDD VSS VSS _5632_/B _5929_/A _5617_/A _5619_/C gf180mcu_as_sc_mcu7t3v3__mux2_2
XFILLER_145_660 VDD VDD VSS VSS gf180mcu_as_sc_mcu7t3v3__fill_2
XFILLER_152_619 VDD VDD VSS VSS gf180mcu_as_sc_mcu7t3v3__fill_1
XFILLER_180_928 VDD VDD VSS VSS gf180mcu_as_sc_mcu7t3v3__fillcap_4
X_5548_ VDD VDD VSS VSS _5853_/A _5637_/B _5639_/B _5856_/A _5551_/C gf180mcu_as_sc_mcu7t3v3__ao22_2
X_5479_ VDD VDD VSS VSS _5788_/A _5531_/B _5538_/B _5786_/A _5480_/D gf180mcu_as_sc_mcu7t3v3__ao22_2
XFILLER_59_666 VDD VDD VSS VSS gf180mcu_as_sc_mcu7t3v3__fill_1
Xfanout498 VDD VDD VSS VSS _4012_/B _4002_/B gf180mcu_as_sc_mcu7t3v3__buff_12
XTAP_TAPCELL_ROW_5_1104 VDD VSS gf180mcu_as_sc_mcu7t3v3__tap_2
XFILLER_228_970 VDD VDD VSS VSS gf180mcu_as_sc_mcu7t3v3__fill_2
XFILLER_64_45 VDD VDD VSS VSS gf180mcu_as_sc_mcu7t3v3__fillcap_4
XFILLER_187_516 VDD VDD VSS VSS gf180mcu_as_sc_mcu7t3v3__fill_1
XFILLER_14_279 VDD VDD VSS VSS gf180mcu_as_sc_mcu7t3v3__fillcap_16
XFILLER_80_33 VDD VDD VSS VSS gf180mcu_as_sc_mcu7t3v3__fill_2
XFILLER_126_1261 VDD VDD VSS VSS gf180mcu_as_sc_mcu7t3v3__fillcap_4
XFILLER_196_33 VDD VDD VSS VSS gf180mcu_as_sc_mcu7t3v3__fill_2
XFILLER_155_402 VDD VDD VSS VSS gf180mcu_as_sc_mcu7t3v3__fillcap_16
XFILLER_156_947 VDD VDD VSS VSS gf180mcu_as_sc_mcu7t3v3__fillcap_16
XFILLER_211_892 VDD VDD VSS VSS gf180mcu_as_sc_mcu7t3v3__fill_1
XFILLER_10_474 VDD VDD VSS VSS gf180mcu_as_sc_mcu7t3v3__fill_1
XFILLER_10_485 VDD VDD VSS VSS gf180mcu_as_sc_mcu7t3v3__fillcap_4
XFILLER_171_906 VDD VDD VSS VSS gf180mcu_as_sc_mcu7t3v3__fillcap_4
Xwire866 VDD VDD VSS VSS _3546_/Y _5649_/A gf180mcu_as_sc_mcu7t3v3__clkbuff_12
Xwire877 VDD VDD VSS VSS _3368_/Y _6719_/A gf180mcu_as_sc_mcu7t3v3__clkbuff_12
XTAP_TAPCELL_ROW_192_2190 VDD VSS gf180mcu_as_sc_mcu7t3v3__tap_2
XFILLER_155_468 VDD VDD VSS VSS gf180mcu_as_sc_mcu7t3v3__fillcap_16
XFILLER_164_980 VDD VDD VSS VSS gf180mcu_as_sc_mcu7t3v3__fillcap_16
XFILLER_89_42 VDD VDD VSS VSS gf180mcu_as_sc_mcu7t3v3__fillcap_8
XFILLER_170_438 VDD VDD VSS VSS gf180mcu_as_sc_mcu7t3v3__fillcap_4
XFILLER_182_298 VDD VDD VSS VSS gf180mcu_as_sc_mcu7t3v3__fill_2
XTAP_TAPCELL_ROW_153_1495 VDD VSS gf180mcu_as_sc_mcu7t3v3__tap_2
XFILLER_133_1210 VDD VDD VSS VSS gf180mcu_as_sc_mcu7t3v3__fillcap_16
XPHY_EDGE_ROW_41_2_Right_878 VDD VSS gf180mcu_as_sc_mcu7t3v3__tap_2
XFILLER_65_614 VDD VDD VSS VSS gf180mcu_as_sc_mcu7t3v3__fillcap_4
XFILLER_225_428 VDD VDD VSS VSS gf180mcu_as_sc_mcu7t3v3__fill_1
XTAP_TAPCELL_ROW_220_2710 VDD VSS gf180mcu_as_sc_mcu7t3v3__tap_2
XTAP_TAPCELL_ROW_199_2322 VDD VSS gf180mcu_as_sc_mcu7t3v3__tap_2
XTAP_TAPCELL_ROW_20_2_2878 VDD VSS gf180mcu_as_sc_mcu7t3v3__tap_2
XFILLER_205_152 VDD VDD VSS VSS gf180mcu_as_sc_mcu7t3v3__fillcap_8
X_4850_ VDD VDD VSS VSS _4850_/D _4889_/A _4850_/B _4850_/C _4854_/B gf180mcu_as_sc_mcu7t3v3__ao31_2
X_3801_ VDD VDD VSS VSS _3801_/B _3801_/A _4038_/B gf180mcu_as_sc_mcu7t3v3__and2_2
XFILLER_220_177 VDD VDD VSS VSS gf180mcu_as_sc_mcu7t3v3__fill_1
XTAP_TAPCELL_ROW_177_1930 VDD VSS gf180mcu_as_sc_mcu7t3v3__tap_2
X_6520_ VDD VDD VSS VSS _6520_/CLK _6520_/D _6520_/Q gf180mcu_as_sc_mcu7t3v3__dfxtp_2
X_4781_ VDD VDD VSS VSS _4837_/B _5789_/A _4782_/C gf180mcu_as_sc_mcu7t3v3__and2_2
X_3732_ VDD VDD VSS VSS _5736_/A _3867_/B _3732_/C _3732_/D _4029_/D gf180mcu_as_sc_mcu7t3v3__ao211_2
XTAP_TAPCELL_ROW_218_2672 VDD VSS gf180mcu_as_sc_mcu7t3v3__tap_2
XTAP_TAPCELL_ROW_218_2661 VDD VSS gf180mcu_as_sc_mcu7t3v3__tap_2
XFILLER_158_295 VDD VDD VSS VSS gf180mcu_as_sc_mcu7t3v3__fillcap_16
XTAP_TAPCELL_ROW_173_1849 VDD VSS gf180mcu_as_sc_mcu7t3v3__tap_2
X_6451_ VDD VDD VSS VSS clkload4/A _6451_/D _6451_/Q gf180mcu_as_sc_mcu7t3v3__dfxtp_2
Xclkload20 VDD VDD VSS VSS clkload20/Y _6125_/CLK gf180mcu_as_sc_mcu7t3v3__inv_2
X_3663_ VDD VDD VSS VSS _5678_/A _3892_/B _3663_/C _3663_/D _3664_/B gf180mcu_as_sc_mcu7t3v3__ao211_2
XFILLER_134_608 VDD VDD VSS VSS gf180mcu_as_sc_mcu7t3v3__fill_2
X_6382_ VDD VDD VSS VSS _6527_/CLK _6382_/D _6382_/Q gf180mcu_as_sc_mcu7t3v3__dfxtp_2
X_5402_ VDD VDD VSS VSS _5710_/A _5495_/B _5402_/C _5496_/B _5403_/B gf180mcu_as_sc_mcu7t3v3__ao211_2
XFILLER_177_1170 VDD VDD VSS VSS gf180mcu_as_sc_mcu7t3v3__fillcap_16
X_5333_ VDD VDD VSS VSS _5338_/C _5333_/B _5649_/D gf180mcu_as_sc_mcu7t3v3__nand2_2
X_3594_ VDD VDD VSS VSS _3595_/D _3595_/C _4979_/C gf180mcu_as_sc_mcu7t3v3__and2_2
XFILLER_177_1192 VDD VDD VSS VSS gf180mcu_as_sc_mcu7t3v3__fillcap_16
X_5264_ VDD VDD VSS VSS _5265_/C _5287_/C _5264_/B _5297_/A gf180mcu_as_sc_mcu7t3v3__aoi21_2
X_5195_ VDD VDD VSS VSS _5197_/C _5195_/B _5195_/A gf180mcu_as_sc_mcu7t3v3__nand2_2
X_4215_ VDD VDD VSS VSS _4217_/B _4215_/B _4215_/A gf180mcu_as_sc_mcu7t3v3__nor2_2
X_4146_ VDD VDD VSS VSS _4146_/S _4146_/B _6194_/Q _6194_/D gf180mcu_as_sc_mcu7t3v3__mux2_2
XFILLER_18_49 VDD VDD VSS VSS gf180mcu_as_sc_mcu7t3v3__fill_2
XFILLER_228_244 VDD VDD VSS VSS gf180mcu_as_sc_mcu7t3v3__fill_2
X_4077_ VDD VDD VSS VSS _4602_/C _4077_/B _4077_/C _6137_/D gf180mcu_as_sc_mcu7t3v3__nor3_2
XFILLER_221_50 VDD VDD VSS VSS gf180mcu_as_sc_mcu7t3v3__fillcap_16
XFILLER_225_962 VDD VDD VSS VSS gf180mcu_as_sc_mcu7t3v3__fillcap_16
XFILLER_3_1186 VDD VDD VSS VSS gf180mcu_as_sc_mcu7t3v3__fillcap_4
XTAP_TAPCELL_ROW_0_1001 VDD VSS gf180mcu_as_sc_mcu7t3v3__tap_2
X_3028_ VDD VDD VSS VSS _4634_/B _5953_/A gf180mcu_as_sc_mcu7t3v3__inv_2
XFILLER_221_72 VDD VDD VSS VSS gf180mcu_as_sc_mcu7t3v3__fillcap_16
XFILLER_34_37 VDD VDD VSS VSS gf180mcu_as_sc_mcu7t3v3__fillcap_8
XTAP_TAPCELL_ROW_0_1012 VDD VSS gf180mcu_as_sc_mcu7t3v3__tap_2
XFILLER_149_240 VDD VDD VSS VSS gf180mcu_as_sc_mcu7t3v3__fillcap_16
XFILLER_180_1049 VDD VDD VSS VSS gf180mcu_as_sc_mcu7t3v3__fillcap_16
XFILLER_211_155 VDD VDD VSS VSS gf180mcu_as_sc_mcu7t3v3__fillcap_16
XFILLER_212_667 VDD VDD VSS VSS gf180mcu_as_sc_mcu7t3v3__fillcap_4
XPHY_EDGE_ROW_119_2_Left_560 VDD VSS gf180mcu_as_sc_mcu7t3v3__tap_2
XPHY_EDGE_ROW_141_3_Right_221 VDD VSS gf180mcu_as_sc_mcu7t3v3__tap_2
X_4979_ VDD VDD VSS VSS _4979_/A _4979_/B _4979_/C _4982_/C _4979_/D gf180mcu_as_sc_mcu7t3v3__aoi31_2
XFILLER_221_1046 VDD VDD VSS VSS gf180mcu_as_sc_mcu7t3v3__fillcap_4
XPHY_EDGE_ROW_199_Left_427 VDD VSS gf180mcu_as_sc_mcu7t3v3__tap_2
X_6718_ VDD VDD VSS VSS _6718_/A _6718_/Y gf180mcu_as_sc_mcu7t3v3__buff_2
Xclkload3 VDD VDD VSS VSS clkload3/Y clkload3/A gf180mcu_as_sc_mcu7t3v3__inv_2
XFILLER_165_744 VDD VDD VSS VSS gf180mcu_as_sc_mcu7t3v3__fillcap_8
XFILLER_192_541 VDD VDD VSS VSS gf180mcu_as_sc_mcu7t3v3__fill_1
XFILLER_221_1068 VDD VDD VSS VSS gf180mcu_as_sc_mcu7t3v3__fillcap_16
XFILLER_164_243 VDD VDD VSS VSS gf180mcu_as_sc_mcu7t3v3__fill_2
XFILLER_165_766 VDD VDD VSS VSS gf180mcu_as_sc_mcu7t3v3__fillcap_4
XFILLER_4_927 VDD VDD VSS VSS gf180mcu_as_sc_mcu7t3v3__fillcap_16
XPHY_EDGE_ROW_131_3_Left_836 VDD VSS gf180mcu_as_sc_mcu7t3v3__tap_2
XFILLER_133_630 VDD VDD VSS VSS gf180mcu_as_sc_mcu7t3v3__fillcap_16
XFILLER_156_1221 VDD VDD VSS VSS gf180mcu_as_sc_mcu7t3v3__fillcap_4
XFILLER_117_1238 VDD VDD VSS VSS gf180mcu_as_sc_mcu7t3v3__fill_2
XFILLER_189_1030 VDD VDD VSS VSS gf180mcu_as_sc_mcu7t3v3__fillcap_16
XFILLER_189_1052 VDD VDD VSS VSS gf180mcu_as_sc_mcu7t3v3__fillcap_16
XFILLER_15_500 VDD VDD VSS VSS gf180mcu_as_sc_mcu7t3v3__fill_1
XFILLER_216_995 VDD VDD VSS VSS gf180mcu_as_sc_mcu7t3v3__fillcap_16
XFILLER_188_836 VDD VDD VSS VSS gf180mcu_as_sc_mcu7t3v3__fill_2
XTAP_TAPCELL_ROW_194_2230 VDD VSS gf180mcu_as_sc_mcu7t3v3__tap_2
XTAP_TAPCELL_ROW_194_2241 VDD VSS gf180mcu_as_sc_mcu7t3v3__tap_2
XFILLER_168_571 VDD VDD VSS VSS gf180mcu_as_sc_mcu7t3v3__fillcap_8
XFILLER_202_177 VDD VDD VSS VSS gf180mcu_as_sc_mcu7t3v3__fill_1
XFILLER_202_199 VDD VDD VSS VSS gf180mcu_as_sc_mcu7t3v3__fill_2
XFILLER_204_1255 VDD VDD VSS VSS gf180mcu_as_sc_mcu7t3v3__fillcap_8
XFILLER_11_772 VDD VDD VSS VSS gf180mcu_as_sc_mcu7t3v3__fill_1
XFILLER_156_733 VDD VDD VSS VSS gf180mcu_as_sc_mcu7t3v3__fill_2
XFILLER_183_530 VDD VDD VSS VSS gf180mcu_as_sc_mcu7t3v3__fillcap_4
XFILLER_200_1119 VDD VDD VSS VSS gf180mcu_as_sc_mcu7t3v3__fillcap_16
XTAP_TAPCELL_ROW_155_1524 VDD VSS gf180mcu_as_sc_mcu7t3v3__tap_2
XTAP_TAPCELL_ROW_155_1535 VDD VSS gf180mcu_as_sc_mcu7t3v3__tap_2
XFILLER_13_1250 VDD VDD VSS VSS gf180mcu_as_sc_mcu7t3v3__fillcap_8
XPHY_EDGE_ROW_40_2_Left_481 VDD VSS gf180mcu_as_sc_mcu7t3v3__tap_2
XPHY_EDGE_ROW_63_3_Left_768 VDD VSS gf180mcu_as_sc_mcu7t3v3__tap_2
XFILLER_155_276 VDD VDD VSS VSS gf180mcu_as_sc_mcu7t3v3__fillcap_4
XFILLER_155_298 VDD VDD VSS VSS gf180mcu_as_sc_mcu7t3v3__fillcap_16
XFILLER_7_798 VDD VDD VSS VSS gf180mcu_as_sc_mcu7t3v3__fillcap_8
XFILLER_171_769 VDD VDD VSS VSS gf180mcu_as_sc_mcu7t3v3__fill_1
XTAP_TAPCELL_ROW_213_2580 VDD VSS gf180mcu_as_sc_mcu7t3v3__tap_2
XFILLER_151_460 VDD VDD VSS VSS gf180mcu_as_sc_mcu7t3v3__fill_1
XFILLER_3_982 VDD VDD VSS VSS gf180mcu_as_sc_mcu7t3v3__fillcap_16
XPHY_EDGE_ROW_42_2_Right_879 VDD VSS gf180mcu_as_sc_mcu7t3v3__tap_2
X_4000_ VDD VDD VSS VSS _4038_/B _4002_/B _4002_/C _6088_/Q _6088_/D gf180mcu_as_sc_mcu7t3v3__ao22_2
XTAP_TAPCELL_ROW_14_1266 VDD VSS gf180mcu_as_sc_mcu7t3v3__tap_2
XFILLER_168_1103 VDD VDD VSS VSS gf180mcu_as_sc_mcu7t3v3__fillcap_16
XFILLER_20_1210 VDD VDD VSS VSS gf180mcu_as_sc_mcu7t3v3__fillcap_16
XFILLER_225_203 VDD VDD VSS VSS gf180mcu_as_sc_mcu7t3v3__fillcap_4
XFILLER_209_1100 VDD VDD VSS VSS gf180mcu_as_sc_mcu7t3v3__fillcap_16
XFILLER_213_409 VDD VDD VSS VSS gf180mcu_as_sc_mcu7t3v3__fill_1
X_5951_ VDD VDD VSS VSS _5951_/A _5951_/B _5951_/C _5952_/C _5951_/D gf180mcu_as_sc_mcu7t3v3__aoi211_2
XFILLER_209_1122 VDD VDD VSS VSS gf180mcu_as_sc_mcu7t3v3__fillcap_16
X_4902_ VDD VDD VSS VSS _4965_/S _4902_/B _5892_/A _4903_/B gf180mcu_as_sc_mcu7t3v3__mux2_2
XFILLER_222_943 VDD VDD VSS VSS gf180mcu_as_sc_mcu7t3v3__fill_2
XFILLER_61_661 VDD VDD VSS VSS gf180mcu_as_sc_mcu7t3v3__fill_1
XPHY_EDGE_ROW_104_1_Left_332 VDD VSS gf180mcu_as_sc_mcu7t3v3__tap_2
X_5882_ VDD VDD VSS VSS _5882_/A _5954_/B _5882_/C _5882_/D _5883_/B gf180mcu_as_sc_mcu7t3v3__ao211_2
X_4833_ VDD VDD VSS VSS _5833_/A _4955_/B _4833_/C _4833_/D _4834_/C gf180mcu_as_sc_mcu7t3v3__ao211_2
X_4764_ VDD VDD VSS VSS _4765_/C _4877_/B _5775_/A gf180mcu_as_sc_mcu7t3v3__nor2_2
XFILLER_193_349 VDD VDD VSS VSS gf180mcu_as_sc_mcu7t3v3__fill_1
XPHY_EDGE_ROW_159_Right_27 VDD VSS gf180mcu_as_sc_mcu7t3v3__tap_2
X_6503_ VDD VDD VSS VSS _6518_/CLK _6503_/D _6503_/Q gf180mcu_as_sc_mcu7t3v3__dfxtp_2
X_3715_ VDD VDD VSS VSS _6499_/Q _3897_/B _3887_/B _5728_/D _3717_/C gf180mcu_as_sc_mcu7t3v3__ao22_2
XFILLER_162_703 VDD VDD VSS VSS gf180mcu_as_sc_mcu7t3v3__fill_1
XFILLER_174_563 VDD VDD VSS VSS gf180mcu_as_sc_mcu7t3v3__fillcap_4
XPHY_EDGE_ROW_221_Left_449 VDD VSS gf180mcu_as_sc_mcu7t3v3__tap_2
X_6434_ VDD VDD VSS VSS _6437_/CLK _6434_/D _6434_/Q gf180mcu_as_sc_mcu7t3v3__dfxtp_2
X_4695_ VDD VDD VSS VSS _5710_/A _4795_/B _4695_/C _4695_/D _4696_/C gf180mcu_as_sc_mcu7t3v3__ao211_2
X_3646_ VDD VDD VSS VSS _5963_/A _5957_/C _3893_/C gf180mcu_as_sc_mcu7t3v3__or2_2
XFILLER_162_758 VDD VDD VSS VSS gf180mcu_as_sc_mcu7t3v3__fill_1
X_6365_ VDD VDD VSS VSS _6365_/CLK _6365_/D _6365_/Q gf180mcu_as_sc_mcu7t3v3__dfxtp_2
X_3577_ VDD VDD VSS VSS _3583_/A _3583_/B _3583_/C _5331_/S gf180mcu_as_sc_mcu7t3v3__nand3_2
XFILLER_130_600 VDD VDD VSS VSS gf180mcu_as_sc_mcu7t3v3__fill_1
Xmax_cap985 VDD VDD VSS VSS _5237_/B _5883_/A gf180mcu_as_sc_mcu7t3v3__clkbuff_12
X_6296_ VDD VDD VSS VSS clkload6/A _6296_/D _6296_/Q gf180mcu_as_sc_mcu7t3v3__dfxtp_2
X_5316_ VDD VDD VSS VSS _5316_/S _5955_/A _5316_/A _5317_/B gf180mcu_as_sc_mcu7t3v3__mux2_2
Xinput308 VDD VDD VSS VSS west_in[14] _5792_/A gf180mcu_as_sc_mcu7t3v3__buff_12
X_5247_ VDD VDD VSS VSS _5267_/S _5892_/A _5247_/A _5248_/B gf180mcu_as_sc_mcu7t3v3__mux2_2
XFILLER_130_666 VDD VDD VSS VSS gf180mcu_as_sc_mcu7t3v3__fill_1
XPHY_EDGE_ROW_168_Right_36 VDD VSS gf180mcu_as_sc_mcu7t3v3__tap_2
Xinput319 VDD VDD VSS VSS west_in[24] _5872_/A gf180mcu_as_sc_mcu7t3v3__buff_12
X_5178_ VDD VDD VSS VSS _6512_/Q _5296_/B _5178_/C _5178_/D _5180_/C gf180mcu_as_sc_mcu7t3v3__ao22_2
X_4129_ VDD VDD VSS VSS _4135_/S _6179_/Q _6178_/Q _6178_/D gf180mcu_as_sc_mcu7t3v3__mux2_2
XFILLER_216_247 VDD VDD VSS VSS gf180mcu_as_sc_mcu7t3v3__fill_1
XFILLER_44_639 VDD VDD VSS VSS gf180mcu_as_sc_mcu7t3v3__fill_1
XPHY_EDGE_ROW_36_1_Left_264 VDD VSS gf180mcu_as_sc_mcu7t3v3__tap_2
XTAP_TAPCELL_ROW_0_996 VDD VSS gf180mcu_as_sc_mcu7t3v3__tap_2
XTAP_TAPCELL_ROW_48_3_2921 VDD VSS gf180mcu_as_sc_mcu7t3v3__tap_2
XFILLER_213_998 VDD VDD VSS VSS gf180mcu_as_sc_mcu7t3v3__fillcap_16
XFILLER_185_839 VDD VDD VSS VSS gf180mcu_as_sc_mcu7t3v3__fill_1
XFILLER_197_699 VDD VDD VSS VSS gf180mcu_as_sc_mcu7t3v3__fill_1
XFILLER_36_1261 VDD VDD VSS VSS gf180mcu_as_sc_mcu7t3v3__fillcap_4
XFILLER_61_35 VDD VDD VSS VSS gf180mcu_as_sc_mcu7t3v3__fillcap_16
XPHY_EDGE_ROW_142_3_Right_222 VDD VSS gf180mcu_as_sc_mcu7t3v3__tap_2
XPHY_EDGE_ROW_177_Right_45 VDD VSS gf180mcu_as_sc_mcu7t3v3__tap_2
XFILLER_200_659 VDD VDD VSS VSS gf180mcu_as_sc_mcu7t3v3__fillcap_4
XFILLER_153_736 VDD VDD VSS VSS gf180mcu_as_sc_mcu7t3v3__fillcap_8
XFILLER_3_212 VDD VDD VSS VSS gf180mcu_as_sc_mcu7t3v3__fillcap_16
XTAP_TAPCELL_ROW_150_1443 VDD VSS gf180mcu_as_sc_mcu7t3v3__tap_2
XFILLER_106_663 VDD VDD VSS VSS gf180mcu_as_sc_mcu7t3v3__fillcap_4
XFILLER_152_279 VDD VDD VSS VSS gf180mcu_as_sc_mcu7t3v3__fillcap_16
XFILLER_193_67 VDD VDD VSS VSS gf180mcu_as_sc_mcu7t3v3__fill_2
XFILLER_10_94 VDD VDD VSS VSS gf180mcu_as_sc_mcu7t3v3__fillcap_8
XPHY_EDGE_ROW_186_Right_54 VDD VSS gf180mcu_as_sc_mcu7t3v3__tap_2
Xfanout1002 VDD VDD VSS VSS fanout1004/A _4725_/D gf180mcu_as_sc_mcu7t3v3__buff_12
XFILLER_121_666 VDD VDD VSS VSS gf180mcu_as_sc_mcu7t3v3__fill_1
XFILLER_43_1210 VDD VDD VSS VSS gf180mcu_as_sc_mcu7t3v3__fillcap_4
Xfanout1024 VDD VDD VSS VSS input1/Y _5319_/D gf180mcu_as_sc_mcu7t3v3__buff_12
XFILLER_0_985 VDD VDD VSS VSS gf180mcu_as_sc_mcu7t3v3__fill_1
XFILLER_207_225 VDD VDD VSS VSS gf180mcu_as_sc_mcu7t3v3__fill_1
XFILLER_208_737 VDD VDD VSS VSS gf180mcu_as_sc_mcu7t3v3__fill_2
XFILLER_222_217 VDD VDD VSS VSS gf180mcu_as_sc_mcu7t3v3__fill_2
XFILLER_228_1019 VDD VDD VSS VSS gf180mcu_as_sc_mcu7t3v3__fill_1
XFILLER_15_330 VDD VDD VSS VSS gf180mcu_as_sc_mcu7t3v3__fillcap_8
XFILLER_16_886 VDD VDD VSS VSS gf180mcu_as_sc_mcu7t3v3__fillcap_16
XPHY_EDGE_ROW_195_Right_63 VDD VSS gf180mcu_as_sc_mcu7t3v3__tap_2
XFILLER_187_154 VDD VDD VSS VSS gf180mcu_as_sc_mcu7t3v3__fillcap_4
XTAP_TAPCELL_ROW_215_2620 VDD VSS gf180mcu_as_sc_mcu7t3v3__tap_2
XTAP_TAPCELL_ROW_170_1808 VDD VSS gf180mcu_as_sc_mcu7t3v3__tap_2
X_3500_ VDD VDD VSS VSS _5340_/C _3500_/B _5339_/C _3500_/D _5654_/A gf180mcu_as_sc_mcu7t3v3__nand4_2
XFILLER_171_500 VDD VDD VSS VSS gf180mcu_as_sc_mcu7t3v3__fill_2
Xwire493 VDD VDD VSS VSS _3286_/Y wire493/Y gf180mcu_as_sc_mcu7t3v3__clkbuff_12
X_4480_ VDD VDD VSS VSS _4481_/C _6260_/Q _4480_/A gf180mcu_as_sc_mcu7t3v3__nand2_2
X_3431_ VDD VDD VSS VSS _3433_/B _3434_/B _6264_/Q _3432_/B gf180mcu_as_sc_mcu7t3v3__mux2_2
XTAP_TAPCELL_ROW_211_2539 VDD VSS gf180mcu_as_sc_mcu7t3v3__tap_2
XFILLER_174_1151 VDD VDD VSS VSS gf180mcu_as_sc_mcu7t3v3__fillcap_4
X_6150_ VDD VDD VSS VSS _6509_/CLK _6150_/D _6150_/Q gf180mcu_as_sc_mcu7t3v3__dfxtp_2
X_3362_ VDD VDD VSS VSS _3362_/A _3362_/B _3362_/C _4076_/B _3364_/C gf180mcu_as_sc_mcu7t3v3__ao22_2
XFILLER_174_1173 VDD VDD VSS VSS gf180mcu_as_sc_mcu7t3v3__fillcap_16
XTAP_TAPCELL_ROW_16_1306 VDD VSS gf180mcu_as_sc_mcu7t3v3__tap_2
XTAP_TAPCELL_ROW_16_1317 VDD VSS gf180mcu_as_sc_mcu7t3v3__tap_2
XTAP_TAPCELL_ROW_16_1328 VDD VSS gf180mcu_as_sc_mcu7t3v3__tap_2
X_5101_ VDD VDD VSS VSS _5764_/A _5183_/B _5222_/C _5767_/A _5103_/B gf180mcu_as_sc_mcu7t3v3__ao22_2
XTAP_TAPCELL_ROW_168_1759 VDD VSS gf180mcu_as_sc_mcu7t3v3__tap_2
Xhold1207 VDD VDD VSS VSS hold1230/Y _6544_/D gf180mcu_as_sc_mcu7t3v3__clkbuff_4
X_6081_ VDD VDD VSS VSS _6520_/CLK _6081_/D _6081_/Q gf180mcu_as_sc_mcu7t3v3__dfxtp_2
X_3293_ VDD VDD VSS VSS _6235_/Q _4448_/B _3360_/A _3293_/D _3295_/C gf180mcu_as_sc_mcu7t3v3__ao211_2
XFILLER_215_1170 VDD VDD VSS VSS gf180mcu_as_sc_mcu7t3v3__fillcap_16
XFILLER_215_1192 VDD VDD VSS VSS gf180mcu_as_sc_mcu7t3v3__fillcap_16
Xhold1218 VDD VDD VSS VSS _6528_/Q hold1218/Y gf180mcu_as_sc_mcu7t3v3__clkbuff_4
Xhold1229 VDD VDD VSS VSS _6548_/Q hold1229/Y gf180mcu_as_sc_mcu7t3v3__clkbuff_4
X_5032_ VDD VDD VSS VSS _5702_/A _5143_/B _5143_/C _5697_/A _5033_/D gf180mcu_as_sc_mcu7t3v3__ao22_2
XFILLER_226_534 VDD VDD VSS VSS gf180mcu_as_sc_mcu7t3v3__fill_2
XFILLER_199_909 VDD VDD VSS VSS gf180mcu_as_sc_mcu7t3v3__fill_1
XFILLER_0_1145 VDD VDD VSS VSS gf180mcu_as_sc_mcu7t3v3__fillcap_4
XFILLER_198_419 VDD VDD VSS VSS gf180mcu_as_sc_mcu7t3v3__fill_1
XFILLER_181_1100 VDD VDD VSS VSS gf180mcu_as_sc_mcu7t3v3__fillcap_16
XFILLER_202_85 VDD VDD VSS VSS gf180mcu_as_sc_mcu7t3v3__fillcap_16
X_5934_ VDD VDD VSS VSS _5948_/S _5934_/B _5934_/A _5935_/B gf180mcu_as_sc_mcu7t3v3__mux2_2
XFILLER_146_1242 VDD VDD VSS VSS gf180mcu_as_sc_mcu7t3v3__fill_1
XFILLER_181_1122 VDD VDD VSS VSS gf180mcu_as_sc_mcu7t3v3__fillcap_16
X_5865_ VDD VDD VSS VSS _5865_/A _5874_/B _5873_/B _5865_/D _5866_/D gf180mcu_as_sc_mcu7t3v3__ao22_2
X_4816_ VDD VDD VSS VSS _4883_/A _4816_/B _5819_/A _4817_/B gf180mcu_as_sc_mcu7t3v3__mux2_2
XFILLER_193_124 VDD VDD VSS VSS gf180mcu_as_sc_mcu7t3v3__fill_2
XFILLER_210_979 VDD VDD VSS VSS gf180mcu_as_sc_mcu7t3v3__fillcap_16
X_5796_ VDD VDD VSS VSS _5796_/B _5796_/A _6463_/D gf180mcu_as_sc_mcu7t3v3__and2_2
XFILLER_181_308 VDD VDD VSS VSS gf180mcu_as_sc_mcu7t3v3__fill_1
XFILLER_31_49 VDD VDD VSS VSS gf180mcu_as_sc_mcu7t3v3__fill_2
XTAP_TAPCELL_ROW_139_2_3057 VDD VSS gf180mcu_as_sc_mcu7t3v3__tap_2
X_4747_ VDD VDD VSS VSS _5757_/B _4860_/B _4747_/C _4747_/D _4748_/B gf180mcu_as_sc_mcu7t3v3__ao22_2
XFILLER_147_38 VDD VDD VSS VSS gf180mcu_as_sc_mcu7t3v3__fillcap_8
XFILLER_190_831 VDD VDD VSS VSS gf180mcu_as_sc_mcu7t3v3__fill_2
X_4678_ VDD VDD VSS VSS _4797_/S _4678_/B _5695_/A _4679_/B gf180mcu_as_sc_mcu7t3v3__mux2_2
XFILLER_162_555 VDD VDD VSS VSS gf180mcu_as_sc_mcu7t3v3__fillcap_8
XFILLER_179_1084 VDD VDD VSS VSS gf180mcu_as_sc_mcu7t3v3__fillcap_16
XFILLER_66_1210 VDD VDD VSS VSS gf180mcu_as_sc_mcu7t3v3__fillcap_4
X_6417_ VDD VDD VSS VSS _6422_/CLK _6417_/D _6417_/Q gf180mcu_as_sc_mcu7t3v3__dfxtp_2
X_3629_ VDD VDD VSS VSS _5354_/C _3629_/A _5662_/A gf180mcu_as_sc_mcu7t3v3__and2_2
XFILLER_150_728 VDD VDD VSS VSS gf180mcu_as_sc_mcu7t3v3__fillcap_4
XFILLER_1_716 VDD VDD VSS VSS gf180mcu_as_sc_mcu7t3v3__fill_1
X_6348_ VDD VDD VSS VSS _6365_/CLK _6348_/D _6348_/Q gf180mcu_as_sc_mcu7t3v3__dfxtp_2
XFILLER_153_1224 VDD VDD VSS VSS gf180mcu_as_sc_mcu7t3v3__fill_2
XFILLER_103_666 VDD VDD VSS VSS gf180mcu_as_sc_mcu7t3v3__fill_1
Xinput105 VDD VDD VSS VSS ne_in[27] _5899_/A gf180mcu_as_sc_mcu7t3v3__buff_12
Xinput116 VDD VDD VSS VSS ne_in[4] wire1022/A gf180mcu_as_sc_mcu7t3v3__buff_12
Xinput127 VDD VDD VSS VSS north_in[14] wire1020/A gf180mcu_as_sc_mcu7t3v3__buff_12
X_6279_ VDD VDD VSS VSS clkload5/A _6279_/D _6279_/Q gf180mcu_as_sc_mcu7t3v3__dfxtp_2
XFILLER_9_1170 VDD VDD VSS VSS gf180mcu_as_sc_mcu7t3v3__fillcap_16
XFILLER_9_1192 VDD VDD VSS VSS gf180mcu_as_sc_mcu7t3v3__fillcap_16
Xinput138 VDD VDD VSS VSS north_in[24] _5870_/B gf180mcu_as_sc_mcu7t3v3__buff_12
Xinput149 VDD VDD VSS VSS north_in[34] _4960_/D gf180mcu_as_sc_mcu7t3v3__buff_12
XFILLER_17_606 VDD VDD VSS VSS gf180mcu_as_sc_mcu7t3v3__fill_2
XFILLER_186_1011 VDD VDD VSS VSS gf180mcu_as_sc_mcu7t3v3__fillcap_4
XFILLER_186_1033 VDD VDD VSS VSS gf180mcu_as_sc_mcu7t3v3__fillcap_16
XFILLER_84_594 VDD VDD VSS VSS gf180mcu_as_sc_mcu7t3v3__fill_1
XFILLER_13_801 VDD VDD VSS VSS gf180mcu_as_sc_mcu7t3v3__fillcap_16
XFILLER_227_1030 VDD VDD VSS VSS gf180mcu_as_sc_mcu7t3v3__fillcap_16
XFILLER_12_311 VDD VDD VSS VSS gf180mcu_as_sc_mcu7t3v3__fillcap_4
XFILLER_197_441 VDD VDD VSS VSS gf180mcu_as_sc_mcu7t3v3__fill_2
XFILLER_227_1052 VDD VDD VSS VSS gf180mcu_as_sc_mcu7t3v3__fillcap_16
XFILLER_72_45 VDD VDD VSS VSS gf180mcu_as_sc_mcu7t3v3__fillcap_4
XFILLER_12_333 VDD VDD VSS VSS gf180mcu_as_sc_mcu7t3v3__fillcap_16
XFILLER_197_463 VDD VDD VSS VSS gf180mcu_as_sc_mcu7t3v3__fillcap_4
Xclkbuf_leaf_5_clk_regs VDD VDD VSS VSS clkbuf_3_1_0_clk_regs/Y _6551_/CLK gf180mcu_as_sc_mcu7t3v3__clkbuff_12
XFILLER_157_338 VDD VDD VSS VSS gf180mcu_as_sc_mcu7t3v3__fillcap_4
XFILLER_12_399 VDD VDD VSS VSS gf180mcu_as_sc_mcu7t3v3__fillcap_16
XFILLER_185_669 VDD VDD VSS VSS gf180mcu_as_sc_mcu7t3v3__fill_2
XPHY_EDGE_ROW_143_3_Right_223 VDD VSS gf180mcu_as_sc_mcu7t3v3__tap_2
XFILLER_193_691 VDD VDD VSS VSS gf180mcu_as_sc_mcu7t3v3__fillcap_8
XFILLER_158_1135 VDD VDD VSS VSS gf180mcu_as_sc_mcu7t3v3__fillcap_16
XFILLER_153_566 VDD VDD VSS VSS gf180mcu_as_sc_mcu7t3v3__fill_1
XFILLER_158_1157 VDD VDD VSS VSS gf180mcu_as_sc_mcu7t3v3__fillcap_16
XFILLER_97_20 VDD VDD VSS VSS gf180mcu_as_sc_mcu7t3v3__fillcap_4
XTAP_TAPCELL_ROW_189_2151 VDD VSS gf180mcu_as_sc_mcu7t3v3__tap_2
XTAP_TAPCELL_ROW_189_2140 VDD VSS gf180mcu_as_sc_mcu7t3v3__tap_2
XFILLER_223_18 VDD VDD VSS VSS gf180mcu_as_sc_mcu7t3v3__fillcap_16
XTAP_TAPCELL_ROW_11_1203 VDD VSS gf180mcu_as_sc_mcu7t3v3__tap_2
XTAP_TAPCELL_ROW_11_1214 VDD VSS gf180mcu_as_sc_mcu7t3v3__tap_2
XTAP_TAPCELL_ROW_208_2490 VDD VSS gf180mcu_as_sc_mcu7t3v3__tap_2
XFILLER_169_1264 VDD VDD VSS VSS gf180mcu_as_sc_mcu7t3v3__fill_1
XFILLER_208_567 VDD VDD VSS VSS gf180mcu_as_sc_mcu7t3v3__fill_2
XTAP_TAPCELL_ROW_163_1667 VDD VSS gf180mcu_as_sc_mcu7t3v3__tap_2
XTAP_TAPCELL_ROW_163_1678 VDD VSS gf180mcu_as_sc_mcu7t3v3__tap_2
X_3980_ VDD VDD VSS VSS _3980_/B _6073_/Q _3981_/D gf180mcu_as_sc_mcu7t3v3__and2_2
XTAP_TAPCELL_ROW_180_1981 VDD VSS gf180mcu_as_sc_mcu7t3v3__tap_2
XFILLER_189_942 VDD VDD VSS VSS gf180mcu_as_sc_mcu7t3v3__fill_2
XFILLER_204_762 VDD VDD VSS VSS gf180mcu_as_sc_mcu7t3v3__fill_2
XFILLER_206_1103 VDD VDD VSS VSS gf180mcu_as_sc_mcu7t3v3__fillcap_16
XFILLER_203_250 VDD VDD VSS VSS gf180mcu_as_sc_mcu7t3v3__fill_1
XFILLER_31_631 VDD VDD VSS VSS gf180mcu_as_sc_mcu7t3v3__fillcap_8
XFILLER_31_653 VDD VDD VSS VSS gf180mcu_as_sc_mcu7t3v3__fillcap_8
Xclkbuf_0_clk VDD VDD VSS VSS clkbuf_0_clk/A clkbuf_0_clk/Y gf180mcu_as_sc_mcu7t3v3__clkbuff_12
X_5650_ VDD VDD VSS VSS _5950_/C _5886_/B _5674_/A gf180mcu_as_sc_mcu7t3v3__nand2_2
XFILLER_188_496 VDD VDD VSS VSS gf180mcu_as_sc_mcu7t3v3__fill_1
XFILLER_31_664 VDD VDD VSS VSS gf180mcu_as_sc_mcu7t3v3__fill_2
X_4601_ VDD VDD VSS VSS _4601_/A _4601_/B _4601_/C _4601_/D _4602_/B gf180mcu_as_sc_mcu7t3v3__ao211_2
XFILLER_89_1210 VDD VDD VSS VSS gf180mcu_as_sc_mcu7t3v3__fill_2
X_5581_ VDD VDD VSS VSS _5887_/D _5615_/C _5581_/C _5604_/C _5583_/C gf180mcu_as_sc_mcu7t3v3__ao211_2
XFILLER_156_360 VDD VDD VSS VSS gf180mcu_as_sc_mcu7t3v3__fillcap_16
XFILLER_15_1186 VDD VDD VSS VSS gf180mcu_as_sc_mcu7t3v3__fillcap_4
XFILLER_191_628 VDD VDD VSS VSS gf180mcu_as_sc_mcu7t3v3__fill_2
XFILLER_8_871 VDD VDD VSS VSS gf180mcu_as_sc_mcu7t3v3__fillcap_4
X_4532_ VDD VDD VSS VSS _4538_/S _4532_/B _6143_/Q _6296_/D gf180mcu_as_sc_mcu7t3v3__mux2_2
XFILLER_190_138 VDD VDD VSS VSS gf180mcu_as_sc_mcu7t3v3__fillcap_4
XFILLER_8_893 VDD VDD VSS VSS gf180mcu_as_sc_mcu7t3v3__fillcap_16
X_4463_ VDD VDD VSS VSS _4465_/C _4466_/A _4468_/C _4464_/B gf180mcu_as_sc_mcu7t3v3__nor3_2
XFILLER_171_352 VDD VDD VSS VSS gf180mcu_as_sc_mcu7t3v3__fillcap_4
X_6202_ VDD VDD VSS VSS _6546_/CLK _6202_/D _6202_/Q gf180mcu_as_sc_mcu7t3v3__dfxtp_2
X_3414_ VDD VDD VSS VSS _3432_/A _4468_/B _3414_/B _3414_/C gf180mcu_as_sc_mcu7t3v3__ao21_2
XFILLER_98_631 VDD VDD VSS VSS gf180mcu_as_sc_mcu7t3v3__fill_1
XPHY_EDGE_ROW_15_Right_15 VDD VSS gf180mcu_as_sc_mcu7t3v3__tap_2
Xfanout806 VDD VDD VSS VSS _3868_/C _3886_/C gf180mcu_as_sc_mcu7t3v3__buff_12
X_4394_ VDD VDD VSS VSS _4394_/A _4394_/B _4394_/C _4395_/B _4408_/D gf180mcu_as_sc_mcu7t3v3__oai211_2
XTAP_TAPCELL_ROW_26_2_2887 VDD VSS gf180mcu_as_sc_mcu7t3v3__tap_2
Xfanout817 VDD VDD VSS VSS _4978_/Y _5186_/B gf180mcu_as_sc_mcu7t3v3__buff_12
Xfanout828 VDD VDD VSS VSS _5293_/B _5138_/B gf180mcu_as_sc_mcu7t3v3__buff_12
Xfanout839 VDD VDD VSS VSS _4838_/B _4858_/B gf180mcu_as_sc_mcu7t3v3__buff_12
X_6133_ VDD VDD VSS VSS _6490_/CLK _6133_/D _6133_/Q gf180mcu_as_sc_mcu7t3v3__dfxtp_2
X_3345_ VDD VDD VSS VSS _3345_/B _3353_/A _3346_/D gf180mcu_as_sc_mcu7t3v3__or2_2
X_6064_ VDD VDD VSS VSS _6486_/CLK _6064_/D _6064_/Q gf180mcu_as_sc_mcu7t3v3__dfxtp_2
X_3276_ VDD VDD VSS VSS _3278_/C _3276_/B _3290_/A gf180mcu_as_sc_mcu7t3v3__nand2_2
XTAP_TAPCELL_ROW_228_2866 VDD VSS gf180mcu_as_sc_mcu7t3v3__tap_2
XTAP_TAPCELL_ROW_228_2855 VDD VSS gf180mcu_as_sc_mcu7t3v3__tap_2
XTAP_TAPCELL_ROW_228_2844 VDD VSS gf180mcu_as_sc_mcu7t3v3__tap_2
X_5015_ VDD VDD VSS VSS _5686_/A _5144_/B _5015_/C _5015_/D _5016_/A gf180mcu_as_sc_mcu7t3v3__ao211_2
XFILLER_26_27 VDD VDD VSS VSS gf180mcu_as_sc_mcu7t3v3__fillcap_8
XFILLER_26_49 VDD VDD VSS VSS gf180mcu_as_sc_mcu7t3v3__fill_2
XPHY_EDGE_ROW_140_3_Left_845 VDD VSS gf180mcu_as_sc_mcu7t3v3__tap_2
XFILLER_198_249 VDD VDD VSS VSS gf180mcu_as_sc_mcu7t3v3__fill_1
XFILLER_201_209 VDD VDD VSS VSS gf180mcu_as_sc_mcu7t3v3__fill_1
X_5917_ VDD VDD VSS VSS _5917_/A _5926_/B _5917_/C _5917_/Y _5957_/C gf180mcu_as_sc_mcu7t3v3__aoi211_2
XFILLER_167_614 VDD VDD VSS VSS gf180mcu_as_sc_mcu7t3v3__fill_2
XFILLER_195_912 VDD VDD VSS VSS gf180mcu_as_sc_mcu7t3v3__fillcap_16
XFILLER_10_804 VDD VDD VSS VSS gf180mcu_as_sc_mcu7t3v3__fill_1
XFILLER_166_102 VDD VDD VSS VSS gf180mcu_as_sc_mcu7t3v3__fill_2
XFILLER_179_485 VDD VDD VSS VSS gf180mcu_as_sc_mcu7t3v3__fillcap_4
XFILLER_42_37 VDD VDD VSS VSS gf180mcu_as_sc_mcu7t3v3__fillcap_8
X_5848_ VDD VDD VSS VSS _5848_/A _5951_/D _5848_/C _5848_/D _5850_/C gf180mcu_as_sc_mcu7t3v3__ao211_2
XFILLER_158_37 VDD VDD VSS VSS gf180mcu_as_sc_mcu7t3v3__fillcap_16
XFILLER_167_658 VDD VDD VSS VSS gf180mcu_as_sc_mcu7t3v3__fill_1
X_5779_ VDD VDD VSS VSS _5875_/S _5779_/B _5779_/A _5780_/B gf180mcu_as_sc_mcu7t3v3__mux2_2
XFILLER_120_1245 VDD VDD VSS VSS gf180mcu_as_sc_mcu7t3v3__fillcap_16
XFILLER_175_680 VDD VDD VSS VSS gf180mcu_as_sc_mcu7t3v3__fill_1
XFILLER_194_488 VDD VDD VSS VSS gf180mcu_as_sc_mcu7t3v3__fillcap_4
XFILLER_163_842 VDD VDD VSS VSS gf180mcu_as_sc_mcu7t3v3__fillcap_4
XFILLER_174_69 VDD VDD VSS VSS gf180mcu_as_sc_mcu7t3v3__fillcap_16
XFILLER_192_1081 VDD VDD VSS VSS gf180mcu_as_sc_mcu7t3v3__fillcap_4
XFILLER_89_664 VDD VDD VSS VSS gf180mcu_as_sc_mcu7t3v3__fill_2
XTAP_TAPCELL_ROW_8_1157 VDD VSS gf180mcu_as_sc_mcu7t3v3__tap_2
XTAP_TAPCELL_ROW_36_3_2903 VDD VSS gf180mcu_as_sc_mcu7t3v3__tap_2
XFILLER_184_2 VDD VDD VSS VSS gf180mcu_as_sc_mcu7t3v3__fillcap_16
XFILLER_40_1235 VDD VDD VSS VSS gf180mcu_as_sc_mcu7t3v3__fillcap_8
XPHY_EDGE_ROW_72_3_Left_777 VDD VSS gf180mcu_as_sc_mcu7t3v3__tap_2
XFILLER_199_88 VDD VDD VSS VSS gf180mcu_as_sc_mcu7t3v3__fillcap_16
XFILLER_13_675 VDD VDD VSS VSS gf180mcu_as_sc_mcu7t3v3__fill_2
XFILLER_185_411 VDD VDD VSS VSS gf180mcu_as_sc_mcu7t3v3__fill_2
XFILLER_185_422 VDD VDD VSS VSS gf180mcu_as_sc_mcu7t3v3__fillcap_16
XFILLER_186_934 VDD VDD VSS VSS gf180mcu_as_sc_mcu7t3v3__fillcap_4
XFILLER_197_282 VDD VDD VSS VSS gf180mcu_as_sc_mcu7t3v3__fillcap_4
XFILLER_8_101 VDD VDD VSS VSS gf180mcu_as_sc_mcu7t3v3__fillcap_4
XFILLER_199_1224 VDD VDD VSS VSS gf180mcu_as_sc_mcu7t3v3__fillcap_8
XFILLER_201_776 VDD VDD VSS VSS gf180mcu_as_sc_mcu7t3v3__fill_2
XFILLER_8_123 VDD VDD VSS VSS gf180mcu_as_sc_mcu7t3v3__fillcap_16
XFILLER_218_18 VDD VDD VSS VSS gf180mcu_as_sc_mcu7t3v3__fillcap_16
XPHY_EDGE_ROW_144_3_Right_224 VDD VSS gf180mcu_as_sc_mcu7t3v3__tap_2
XFILLER_153_330 VDD VDD VSS VSS gf180mcu_as_sc_mcu7t3v3__fillcap_16
XFILLER_154_831 VDD VDD VSS VSS gf180mcu_as_sc_mcu7t3v3__fill_1
XFILLER_165_190 VDD VDD VSS VSS gf180mcu_as_sc_mcu7t3v3__fillcap_8
XFILLER_5_830 VDD VDD VSS VSS gf180mcu_as_sc_mcu7t3v3__fillcap_8
XFILLER_153_352 VDD VDD VSS VSS gf180mcu_as_sc_mcu7t3v3__fillcap_4
XFILLER_154_864 VDD VDD VSS VSS gf180mcu_as_sc_mcu7t3v3__fillcap_8
XFILLER_5_874 VDD VDD VSS VSS gf180mcu_as_sc_mcu7t3v3__fill_2
Xoutput409 VDD VDD VSS VSS _6374_/Q north_out[33] gf180mcu_as_sc_mcu7t3v3__buff_12
XFILLER_171_1154 VDD VDD VSS VSS gf180mcu_as_sc_mcu7t3v3__fillcap_16
XFILLER_95_634 VDD VDD VSS VSS gf180mcu_as_sc_mcu7t3v3__fill_2
XPHY_EDGE_ROW_113_1_Left_341 VDD VSS gf180mcu_as_sc_mcu7t3v3__tap_2
XTAP_TAPCELL_ROW_165_1707 VDD VSS gf180mcu_as_sc_mcu7t3v3__tap_2
X_3130_ VDD VDD VSS VSS _4523_/B _4481_/A _6278_/Q gf180mcu_as_sc_mcu7t3v3__nand2_2
XFILLER_227_117 VDD VDD VSS VSS gf180mcu_as_sc_mcu7t3v3__fill_1
XFILLER_228_618 VDD VDD VSS VSS gf180mcu_as_sc_mcu7t3v3__fill_2
XTAP_TAPCELL_ROW_165_1718 VDD VSS gf180mcu_as_sc_mcu7t3v3__tap_2
XFILLER_212_1151 VDD VDD VSS VSS gf180mcu_as_sc_mcu7t3v3__fillcap_4
XFILLER_212_1173 VDD VDD VSS VSS gf180mcu_as_sc_mcu7t3v3__fillcap_16
X_3061_ VDD VDD VSS VSS _4495_/D _6285_/Q gf180mcu_as_sc_mcu7t3v3__inv_2
XTAP_TAPCELL_ROW_206_2449 VDD VSS gf180mcu_as_sc_mcu7t3v3__tap_2
XTAP_TAPCELL_ROW_223_2763 VDD VSS gf180mcu_as_sc_mcu7t3v3__tap_2
XTAP_TAPCELL_ROW_223_2752 VDD VSS gf180mcu_as_sc_mcu7t3v3__tap_2
XFILLER_1_1240 VDD VDD VSS VSS gf180mcu_as_sc_mcu7t3v3__fillcap_16
XFILLER_224_857 VDD VDD VSS VSS gf180mcu_as_sc_mcu7t3v3__fillcap_4
XFILLER_1_1262 VDD VDD VSS VSS gf180mcu_as_sc_mcu7t3v3__fill_2
XFILLER_189_772 VDD VDD VSS VSS gf180mcu_as_sc_mcu7t3v3__fill_2
XFILLER_56_1264 VDD VDD VSS VSS gf180mcu_as_sc_mcu7t3v3__fill_1
X_3963_ VDD VDD VSS VSS _3963_/B _6063_/Q _3964_/D gf180mcu_as_sc_mcu7t3v3__and2_2
XFILLER_17_1226 VDD VDD VSS VSS gf180mcu_as_sc_mcu7t3v3__fillcap_8
X_5702_ VDD VDD VSS VSS _5702_/A _5802_/C _5702_/C _5702_/D _5703_/C gf180mcu_as_sc_mcu7t3v3__ao211_2
X_3894_ VDD VDD VSS VSS _3894_/B _3894_/A _4055_/B gf180mcu_as_sc_mcu7t3v3__and2_2
X_5633_ VDD VDD VSS VSS _5946_/D _5640_/B _5633_/C _5633_/D _5634_/D gf180mcu_as_sc_mcu7t3v3__ao211_2
XFILLER_128_18 VDD VDD VSS VSS gf180mcu_as_sc_mcu7t3v3__fillcap_16
XFILLER_157_680 VDD VDD VSS VSS gf180mcu_as_sc_mcu7t3v3__fillcap_4
X_5564_ VDD VDD VSS VSS _6517_/Q _5564_/B _5565_/B _5564_/D _5566_/C gf180mcu_as_sc_mcu7t3v3__ao211_2
XFILLER_176_1010 VDD VDD VSS VSS gf180mcu_as_sc_mcu7t3v3__fillcap_4
X_4515_ VDD VDD VSS VSS _4527_/S _6290_/Q _4515_/A _6290_/D gf180mcu_as_sc_mcu7t3v3__mux2_2
X_5495_ VDD VDD VSS VSS _5497_/C _5802_/D _5495_/B _5495_/C _5495_/D gf180mcu_as_sc_mcu7t3v3__aoi22_2
XFILLER_172_683 VDD VDD VSS VSS gf180mcu_as_sc_mcu7t3v3__fillcap_16
XFILLER_176_1065 VDD VDD VSS VSS gf180mcu_as_sc_mcu7t3v3__fillcap_16
XFILLER_176_1087 VDD VDD VSS VSS gf180mcu_as_sc_mcu7t3v3__fillcap_16
X_4446_ VDD VDD VSS VSS _6258_/Q _4446_/B _4446_/C _4446_/D _6258_/D gf180mcu_as_sc_mcu7t3v3__ao22_2
XPHY_EDGE_ROW_45_1_Left_273 VDD VSS gf180mcu_as_sc_mcu7t3v3__tap_2
Xfanout603 VDD VDD VSS VSS _4843_/B _4796_/B gf180mcu_as_sc_mcu7t3v3__buff_12
Xfanout614 VDD VDD VSS VSS _3931_/B _3911_/B gf180mcu_as_sc_mcu7t3v3__buff_12
X_4377_ VDD VDD VSS VSS _4398_/S _6064_/Q _6093_/Q _4380_/B gf180mcu_as_sc_mcu7t3v3__mux2_2
XFILLER_150_1205 VDD VDD VSS VSS gf180mcu_as_sc_mcu7t3v3__fillcap_16
XFILLER_217_1084 VDD VDD VSS VSS gf180mcu_as_sc_mcu7t3v3__fillcap_16
Xfanout625 VDD VDD VSS VSS _5667_/Y _5842_/B gf180mcu_as_sc_mcu7t3v3__buff_12
Xfanout636 VDD VDD VSS VSS _3854_/B _3807_/S gf180mcu_as_sc_mcu7t3v3__buff_12
Xfanout647 VDD VDD VSS VSS _6005_/B _6010_/B gf180mcu_as_sc_mcu7t3v3__buff_12
Xfanout658 VDD VDD VSS VSS _5951_/D _5864_/B gf180mcu_as_sc_mcu7t3v3__buff_12
X_6116_ VDD VDD VSS VSS _6371_/CLK _6116_/D _6116_/Q gf180mcu_as_sc_mcu7t3v3__dfxtp_2
X_3328_ VDD VDD VSS VSS _6198_/Q _4072_/B _4089_/S _6222_/Q _3330_/B gf180mcu_as_sc_mcu7t3v3__ao22_2
Xfanout669 VDD VDD VSS VSS _5535_/C _5492_/B gf180mcu_as_sc_mcu7t3v3__buff_12
XFILLER_6_1151 VDD VDD VSS VSS gf180mcu_as_sc_mcu7t3v3__fillcap_4
XFILLER_6_1173 VDD VDD VSS VSS gf180mcu_as_sc_mcu7t3v3__fillcap_16
X_6047_ VDD VDD VSS VSS _6506_/CLK _6047_/D _6047_/Q gf180mcu_as_sc_mcu7t3v3__dfxtp_2
X_3259_ VDD VDD VSS VSS _3259_/Y _3259_/C _3277_/C _3259_/A gf180mcu_as_sc_mcu7t3v3__aoi21b_2
XFILLER_214_356 VDD VDD VSS VSS gf180mcu_as_sc_mcu7t3v3__fill_2
XTAP_TAPCELL_ROW_127_2_3039 VDD VSS gf180mcu_as_sc_mcu7t3v3__tap_2
XTAP_TAPCELL_ROW_3_1076 VDD VSS gf180mcu_as_sc_mcu7t3v3__tap_2
XTAP_TAPCELL_ROW_3_1065 VDD VSS gf180mcu_as_sc_mcu7t3v3__tap_2
XFILLER_156_6 VDD VDD VSS VSS gf180mcu_as_sc_mcu7t3v3__fillcap_16
XFILLER_224_1011 VDD VDD VSS VSS gf180mcu_as_sc_mcu7t3v3__fillcap_4
XFILLER_10_601 VDD VDD VSS VSS gf180mcu_as_sc_mcu7t3v3__fill_1
XFILLER_179_282 VDD VDD VSS VSS gf180mcu_as_sc_mcu7t3v3__fillcap_16
XFILLER_224_1033 VDD VDD VSS VSS gf180mcu_as_sc_mcu7t3v3__fillcap_16
XPHY_EDGE_ROW_133_2_Right_970 VDD VSS gf180mcu_as_sc_mcu7t3v3__tap_2
XPHY_EDGE_ROW_180_Left_408 VDD VSS gf180mcu_as_sc_mcu7t3v3__tap_2
XFILLER_10_623 VDD VDD VSS VSS gf180mcu_as_sc_mcu7t3v3__fill_1
XFILLER_167_433 VDD VDD VSS VSS gf180mcu_as_sc_mcu7t3v3__fillcap_16
XFILLER_195_742 VDD VDD VSS VSS gf180mcu_as_sc_mcu7t3v3__fillcap_4
XFILLER_10_667 VDD VDD VSS VSS gf180mcu_as_sc_mcu7t3v3__fill_2
XFILLER_182_403 VDD VDD VSS VSS gf180mcu_as_sc_mcu7t3v3__fill_2
XFILLER_10_689 VDD VDD VSS VSS gf180mcu_as_sc_mcu7t3v3__fillcap_4
XFILLER_211_4 VDD VDD VSS VSS gf180mcu_as_sc_mcu7t3v3__fill_1
XFILLER_5_104 VDD VDD VSS VSS gf180mcu_as_sc_mcu7t3v3__fillcap_16
XFILLER_6_638 VDD VDD VSS VSS gf180mcu_as_sc_mcu7t3v3__fill_2
Xclkbuf_3_5_0_clk_regs VDD VDD VSS VSS clkbuf_0_clk_regs/Y clkload1/A gf180mcu_as_sc_mcu7t3v3__clkbuff_12
XFILLER_150_311 VDD VDD VSS VSS gf180mcu_as_sc_mcu7t3v3__fillcap_4
XFILLER_155_1116 VDD VDD VSS VSS gf180mcu_as_sc_mcu7t3v3__fillcap_4
XFILLER_162_171 VDD VDD VSS VSS gf180mcu_as_sc_mcu7t3v3__fillcap_4
XFILLER_190_480 VDD VDD VSS VSS gf180mcu_as_sc_mcu7t3v3__fill_1
XFILLER_150_333 VDD VDD VSS VSS gf180mcu_as_sc_mcu7t3v3__fillcap_4
XFILLER_155_1138 VDD VDD VSS VSS gf180mcu_as_sc_mcu7t3v3__fillcap_16
XFILLER_162_193 VDD VDD VSS VSS gf180mcu_as_sc_mcu7t3v3__fillcap_16
XFILLER_2_877 VDD VDD VSS VSS gf180mcu_as_sc_mcu7t3v3__fillcap_16
XTAP_TAPCELL_ROW_182_2018 VDD VSS gf180mcu_as_sc_mcu7t3v3__tap_2
XFILLER_209_117 VDD VDD VSS VSS gf180mcu_as_sc_mcu7t3v3__fillcap_8
XFILLER_224_109 VDD VDD VSS VSS gf180mcu_as_sc_mcu7t3v3__fill_1
Xmesh_tile_1068 VDD VDD VSS VSS ne_out[27] gf180mcu_as_sc_mcu7t3v3__tiel_4
Xmesh_tile_1057 VDD VDD VSS VSS ne_out[16] gf180mcu_as_sc_mcu7t3v3__tiel_4
Xmesh_tile_1046 VDD VDD VSS VSS ne_out[5] gf180mcu_as_sc_mcu7t3v3__tiel_4
XTAP_TAPCELL_ROW_160_1615 VDD VSS gf180mcu_as_sc_mcu7t3v3__tap_2
XTAP_TAPCELL_ROW_160_1626 VDD VSS gf180mcu_as_sc_mcu7t3v3__tap_2
Xmesh_tile_1079 VDD VDD VSS VSS nw_out[2] gf180mcu_as_sc_mcu7t3v3__tiel_4
XFILLER_206_857 VDD VDD VSS VSS gf180mcu_as_sc_mcu7t3v3__fill_1
XTAP_TAPCELL_ROW_201_2357 VDD VSS gf180mcu_as_sc_mcu7t3v3__tap_2
XFILLER_221_838 VDD VDD VSS VSS gf180mcu_as_sc_mcu7t3v3__fill_2
XTAP_TAPCELL_ROW_201_2368 VDD VSS gf180mcu_as_sc_mcu7t3v3__tap_2
XFILLER_159_945 VDD VDD VSS VSS gf180mcu_as_sc_mcu7t3v3__fill_1
XFILLER_198_580 VDD VDD VSS VSS gf180mcu_as_sc_mcu7t3v3__fill_2
XFILLER_207_1264 VDD VDD VSS VSS gf180mcu_as_sc_mcu7t3v3__fill_1
XTAP_TAPCELL_ROW_146_1_1394 VDD VSS gf180mcu_as_sc_mcu7t3v3__tap_2
XTAP_TAPCELL_ROW_197_2294 VDD VSS gf180mcu_as_sc_mcu7t3v3__tap_2
XTAP_TAPCELL_ROW_197_2283 VDD VSS gf180mcu_as_sc_mcu7t3v3__tap_2
XFILLER_13_472 VDD VDD VSS VSS gf180mcu_as_sc_mcu7t3v3__fill_2
XFILLER_14_995 VDD VDD VSS VSS gf180mcu_as_sc_mcu7t3v3__fillcap_16
XFILLER_159_978 VDD VDD VSS VSS gf180mcu_as_sc_mcu7t3v3__fill_2
XFILLER_201_562 VDD VDD VSS VSS gf180mcu_as_sc_mcu7t3v3__fillcap_16
XFILLER_146_639 VDD VDD VSS VSS gf180mcu_as_sc_mcu7t3v3__fill_1
XFILLER_158_488 VDD VDD VSS VSS gf180mcu_as_sc_mcu7t3v3__fill_1
XTAP_TAPCELL_ROW_158_1577 VDD VSS gf180mcu_as_sc_mcu7t3v3__tap_2
XTAP_TAPCELL_ROW_158_1588 VDD VSS gf180mcu_as_sc_mcu7t3v3__tap_2
XTAP_TAPCELL_ROW_175_1891 VDD VSS gf180mcu_as_sc_mcu7t3v3__tap_2
XPHY_EDGE_ROW_145_3_Right_225 VDD VSS gf180mcu_as_sc_mcu7t3v3__tap_2
XFILLER_12_1189 VDD VDD VSS VSS gf180mcu_as_sc_mcu7t3v3__fillcap_16
X_5280_ VDD VDD VSS VSS _5281_/D _5280_/C _5309_/B _5919_/A gf180mcu_as_sc_mcu7t3v3__aoi21b_2
X_4300_ VDD VDD VSS VSS _4321_/S _6053_/Q _6082_/Q _4303_/B gf180mcu_as_sc_mcu7t3v3__mux2_2
X_4231_ VDD VDD VSS VSS _4231_/S _4231_/B _6202_/Q _6202_/D gf180mcu_as_sc_mcu7t3v3__mux2_2
XFILLER_4_85 VDD VDD VSS VSS gf180mcu_as_sc_mcu7t3v3__fillcap_16
X_4162_ VDD VDD VSS VSS _4163_/D _6168_/Q _6193_/Q gf180mcu_as_sc_mcu7t3v3__nor2_2
XFILLER_228_448 VDD VDD VSS VSS gf180mcu_as_sc_mcu7t3v3__fill_1
X_4093_ VDD VDD VSS VSS _4093_/S _6722_/A _6153_/Q _6153_/D gf180mcu_as_sc_mcu7t3v3__mux2_2
X_3113_ VDD VDD VSS VSS _6530_/D _4411_/A _3113_/A gf180mcu_as_sc_mcu7t3v3__nor2b_2
XFILLER_83_659 VDD VDD VSS VSS gf180mcu_as_sc_mcu7t3v3__fill_2
X_3044_ VDD VDD VSS VSS _4471_/A _6306_/Q gf180mcu_as_sc_mcu7t3v3__inv_2
XFILLER_208_1017 VDD VDD VSS VSS gf180mcu_as_sc_mcu7t3v3__fillcap_16
XFILLER_208_194 VDD VDD VSS VSS gf180mcu_as_sc_mcu7t3v3__fillcap_8
XFILLER_223_142 VDD VDD VSS VSS gf180mcu_as_sc_mcu7t3v3__fillcap_4
X_4995_ VDD VDD VSS VSS _4995_/B _4995_/A _4995_/Y gf180mcu_as_sc_mcu7t3v3__and2_2
X_3946_ VDD VDD VSS VSS _3975_/C _6051_/Q _3947_/C gf180mcu_as_sc_mcu7t3v3__and2_2
XFILLER_149_444 VDD VDD VSS VSS gf180mcu_as_sc_mcu7t3v3__fillcap_4
XFILLER_210_85 VDD VDD VSS VSS gf180mcu_as_sc_mcu7t3v3__fillcap_16
XFILLER_220_871 VDD VDD VSS VSS gf180mcu_as_sc_mcu7t3v3__fillcap_4
XFILLER_165_937 VDD VDD VSS VSS gf180mcu_as_sc_mcu7t3v3__fill_1
XFILLER_176_263 VDD VDD VSS VSS gf180mcu_as_sc_mcu7t3v3__fillcap_8
XFILLER_192_712 VDD VDD VSS VSS gf180mcu_as_sc_mcu7t3v3__fillcap_16
X_3877_ VDD VDD VSS VSS _3879_/C _5863_/A _3887_/B _3877_/C gf180mcu_as_sc_mcu7t3v3__ao21_2
XFILLER_164_425 VDD VDD VSS VSS gf180mcu_as_sc_mcu7t3v3__fillcap_8
XFILLER_192_734 VDD VDD VSS VSS gf180mcu_as_sc_mcu7t3v3__fill_1
XFILLER_219_50 VDD VDD VSS VSS gf180mcu_as_sc_mcu7t3v3__fillcap_16
X_5616_ VDD VDD VSS VSS _5617_/A _5931_/A _5616_/B _5616_/C gf180mcu_as_sc_mcu7t3v3__ao21_2
XTAP_TAPCELL_ROW_96_1_1369 VDD VSS gf180mcu_as_sc_mcu7t3v3__tap_2
XFILLER_219_72 VDD VDD VSS VSS gf180mcu_as_sc_mcu7t3v3__fillcap_16
XFILLER_30_1245 VDD VDD VSS VSS gf180mcu_as_sc_mcu7t3v3__fillcap_16
X_5547_ VDD VDD VSS VSS _5547_/B _5578_/A _6434_/D gf180mcu_as_sc_mcu7t3v3__and2_2
XFILLER_155_38 VDD VDD VSS VSS gf180mcu_as_sc_mcu7t3v3__fillcap_16
XFILLER_172_480 VDD VDD VSS VSS gf180mcu_as_sc_mcu7t3v3__fillcap_4
XFILLER_191_299 VDD VDD VSS VSS gf180mcu_as_sc_mcu7t3v3__fillcap_8
XFILLER_2_107 VDD VDD VSS VSS gf180mcu_as_sc_mcu7t3v3__fillcap_16
X_5478_ VDD VDD VSS VSS _5480_/C _5785_/A _5535_/B _5478_/C gf180mcu_as_sc_mcu7t3v3__ao21_2
XFILLER_160_664 VDD VDD VSS VSS gf180mcu_as_sc_mcu7t3v3__fill_1
X_4429_ VDD VDD VSS VSS _6245_/Q _4446_/D _4446_/B _6244_/Q _6244_/D gf180mcu_as_sc_mcu7t3v3__ao22_2
XFILLER_189_1234 VDD VDD VSS VSS gf180mcu_as_sc_mcu7t3v3__fill_1
Xfanout499 VDD VDD VSS VSS _4014_/B _4012_/B gf180mcu_as_sc_mcu7t3v3__buff_12
XTAP_TAPCELL_ROW_5_1105 VDD VSS gf180mcu_as_sc_mcu7t3v3__tap_2
XFILLER_74_626 VDD VDD VSS VSS gf180mcu_as_sc_mcu7t3v3__fill_1
XFILLER_215_632 VDD VDD VSS VSS gf180mcu_as_sc_mcu7t3v3__fillcap_8
XFILLER_228_993 VDD VDD VSS VSS gf180mcu_as_sc_mcu7t3v3__fillcap_4
XFILLER_199_322 VDD VDD VSS VSS gf180mcu_as_sc_mcu7t3v3__fill_1
XFILLER_227_492 VDD VDD VSS VSS gf180mcu_as_sc_mcu7t3v3__fill_1
XFILLER_14_225 VDD VDD VSS VSS gf180mcu_as_sc_mcu7t3v3__fillcap_16
XFILLER_14_247 VDD VDD VSS VSS gf180mcu_as_sc_mcu7t3v3__fillcap_16
XFILLER_11_976 VDD VDD VSS VSS gf180mcu_as_sc_mcu7t3v3__fillcap_4
XFILLER_161_1186 VDD VDD VSS VSS gf180mcu_as_sc_mcu7t3v3__fillcap_4
XPHY_EDGE_ROW_103_3_Left_808 VDD VSS gf180mcu_as_sc_mcu7t3v3__tap_2
XPHY_EDGE_ROW_134_2_Right_971 VDD VSS gf180mcu_as_sc_mcu7t3v3__tap_2
Xwire834 VDD VDD VSS VSS _4990_/B _5183_/B gf180mcu_as_sc_mcu7t3v3__clkbuff_12
XFILLER_11_998 VDD VDD VSS VSS gf180mcu_as_sc_mcu7t3v3__fillcap_16
XFILLER_13_72 VDD VDD VSS VSS gf180mcu_as_sc_mcu7t3v3__fillcap_16
XFILLER_196_1205 VDD VDD VSS VSS gf180mcu_as_sc_mcu7t3v3__fillcap_16
XFILLER_196_1227 VDD VDD VSS VSS gf180mcu_as_sc_mcu7t3v3__fillcap_16
XTAP_TAPCELL_ROW_192_2191 VDD VSS gf180mcu_as_sc_mcu7t3v3__tap_2
XFILLER_182_244 VDD VDD VSS VSS gf180mcu_as_sc_mcu7t3v3__fill_1
XFILLER_6_457 VDD VDD VSS VSS gf180mcu_as_sc_mcu7t3v3__fill_1
Xwire878 VDD VDD VSS VSS _3367_/Y _6718_/A gf180mcu_as_sc_mcu7t3v3__clkbuff_12
Xwire889 VDD VDD VSS VSS _3099_/Y _6715_/A gf180mcu_as_sc_mcu7t3v3__clkbuff_12
XTAP_TAPCELL_ROW_153_1496 VDD VSS gf180mcu_as_sc_mcu7t3v3__tap_2
XFILLER_151_686 VDD VDD VSS VSS gf180mcu_as_sc_mcu7t3v3__fill_2
XFILLER_2_663 VDD VDD VSS VSS gf180mcu_as_sc_mcu7t3v3__fill_2
XFILLER_219_960 VDD VDD VSS VSS gf180mcu_as_sc_mcu7t3v3__fillcap_16
XFILLER_219_982 VDD VDD VSS VSS gf180mcu_as_sc_mcu7t3v3__fillcap_16
XTAP_TAPCELL_ROW_220_2700 VDD VSS gf180mcu_as_sc_mcu7t3v3__tap_2
XTAP_TAPCELL_ROW_199_2323 VDD VSS gf180mcu_as_sc_mcu7t3v3__tap_2
XFILLER_80_629 VDD VDD VSS VSS gf180mcu_as_sc_mcu7t3v3__fillcap_4
XFILLER_205_186 VDD VDD VSS VSS gf180mcu_as_sc_mcu7t3v3__fillcap_16
XFILLER_221_646 VDD VDD VSS VSS gf180mcu_as_sc_mcu7t3v3__fill_1
XFILLER_53_1212 VDD VDD VSS VSS gf180mcu_as_sc_mcu7t3v3__fill_1
XFILLER_92_1261 VDD VDD VSS VSS gf180mcu_as_sc_mcu7t3v3__fillcap_4
XTAP_TAPCELL_ROW_177_1920 VDD VSS gf180mcu_as_sc_mcu7t3v3__tap_2
X_4780_ VDD VDD VSS VSS _4780_/B _5978_/A _6354_/D gf180mcu_as_sc_mcu7t3v3__and2_2
X_3800_ VDD VDD VSS VSS _3801_/B _3922_/C _3810_/B _5795_/A gf180mcu_as_sc_mcu7t3v3__aoi21b_2
XTAP_TAPCELL_ROW_177_1931 VDD VSS gf180mcu_as_sc_mcu7t3v3__tap_2
X_3731_ VDD VDD VSS VSS _3873_/S _3731_/B _5735_/A _3732_/D gf180mcu_as_sc_mcu7t3v3__mux2_2
XFILLER_140_1226 VDD VDD VSS VSS gf180mcu_as_sc_mcu7t3v3__fillcap_16
XFILLER_158_241 VDD VDD VSS VSS gf180mcu_as_sc_mcu7t3v3__fillcap_4
XFILLER_158_263 VDD VDD VSS VSS gf180mcu_as_sc_mcu7t3v3__fillcap_16
XFILLER_159_786 VDD VDD VSS VSS gf180mcu_as_sc_mcu7t3v3__fill_1
XFILLER_159_797 VDD VDD VSS VSS gf180mcu_as_sc_mcu7t3v3__fillcap_16
XFILLER_201_370 VDD VDD VSS VSS gf180mcu_as_sc_mcu7t3v3__fill_2
XTAP_TAPCELL_ROW_218_2662 VDD VSS gf180mcu_as_sc_mcu7t3v3__tap_2
X_6450_ VDD VDD VSS VSS clkload4/A _6450_/D _6450_/Q gf180mcu_as_sc_mcu7t3v3__dfxtp_2
Xclkload10 VDD VDD VSS VSS clkload10/Y _6546_/CLK gf180mcu_as_sc_mcu7t3v3__inv_2
X_3662_ VDD VDD VSS VSS _5669_/A _3930_/B _3891_/B _5677_/A _3663_/D gf180mcu_as_sc_mcu7t3v3__ao22_2
XTAP_TAPCELL_ROW_218_2673 VDD VSS gf180mcu_as_sc_mcu7t3v3__tap_2
XFILLER_127_650 VDD VDD VSS VSS gf180mcu_as_sc_mcu7t3v3__fill_1
XFILLER_162_929 VDD VDD VSS VSS gf180mcu_as_sc_mcu7t3v3__fill_2
X_6381_ VDD VDD VSS VSS _6527_/CLK _6381_/D _6381_/Q gf180mcu_as_sc_mcu7t3v3__dfxtp_2
Xclkload21 VDD VDD VSS VSS clkload21/Y _6371_/CLK gf180mcu_as_sc_mcu7t3v3__inv_2
X_5401_ VDD VDD VSS VSS _5710_/D _5494_/B _5492_/B _5709_/A _5402_/C gf180mcu_as_sc_mcu7t3v3__ao22_2
X_3593_ VDD VDD VSS VSS _3595_/D _6522_/Q _4264_/A gf180mcu_as_sc_mcu7t3v3__nand2b_2
XPHY_EDGE_ROW_146_3_Right_226 VDD VSS gf180mcu_as_sc_mcu7t3v3__tap_2
XPHY_EDGE_ROW_97_3_Left_802 VDD VSS gf180mcu_as_sc_mcu7t3v3__tap_2
X_5332_ VDD VDD VSS VSS _5333_/B _5649_/D _5362_/B gf180mcu_as_sc_mcu7t3v3__and2_2
XFILLER_173_1068 VDD VDD VSS VSS gf180mcu_as_sc_mcu7t3v3__fillcap_16
X_5263_ VDD VDD VSS VSS _5904_/D _5263_/B _5302_/C _5263_/D _5264_/B gf180mcu_as_sc_mcu7t3v3__ao22_2
X_5194_ VDD VDD VSS VSS _5222_/B _5194_/B _5194_/C _5224_/B _5197_/B gf180mcu_as_sc_mcu7t3v3__ao211_2
X_4214_ VDD VDD VSS VSS _4215_/B _4223_/A _4214_/B _4214_/A gf180mcu_as_sc_mcu7t3v3__aoi21_2
XFILLER_214_1065 VDD VDD VSS VSS gf180mcu_as_sc_mcu7t3v3__fillcap_16
XFILLER_228_212 VDD VDD VSS VSS gf180mcu_as_sc_mcu7t3v3__fill_1
X_4145_ VDD VDD VSS VSS _4145_/D _6194_/Q _6271_/Q _4607_/A _4146_/B gf180mcu_as_sc_mcu7t3v3__ao31_2
XFILLER_214_1087 VDD VDD VSS VSS gf180mcu_as_sc_mcu7t3v3__fillcap_16
XFILLER_209_481 VDD VDD VSS VSS gf180mcu_as_sc_mcu7t3v3__fillcap_8
XFILLER_228_278 VDD VDD VSS VSS gf180mcu_as_sc_mcu7t3v3__fill_2
XFILLER_3_1154 VDD VDD VSS VSS gf180mcu_as_sc_mcu7t3v3__fillcap_16
XFILLER_71_607 VDD VDD VSS VSS gf180mcu_as_sc_mcu7t3v3__fillcap_4
X_4076_ VDD VDD VSS VSS _4077_/C _6137_/Q _4076_/B _6136_/Q gf180mcu_as_sc_mcu7t3v3__aoi21_2
XFILLER_209_492 VDD VDD VSS VSS gf180mcu_as_sc_mcu7t3v3__fillcap_4
X_3027_ VDD VDD VSS VSS _3463_/C _5946_/A gf180mcu_as_sc_mcu7t3v3__inv_2
XFILLER_34_27 VDD VDD VSS VSS gf180mcu_as_sc_mcu7t3v3__fillcap_8
XTAP_TAPCELL_ROW_0_1002 VDD VSS gf180mcu_as_sc_mcu7t3v3__tap_2
XTAP_TAPCELL_ROW_0_1013 VDD VSS gf180mcu_as_sc_mcu7t3v3__tap_2
XFILLER_180_1017 VDD VDD VSS VSS gf180mcu_as_sc_mcu7t3v3__fillcap_16
XFILLER_196_314 VDD VDD VSS VSS gf180mcu_as_sc_mcu7t3v3__fill_1
XFILLER_34_49 VDD VDD VSS VSS gf180mcu_as_sc_mcu7t3v3__fill_2
XFILLER_11_206 VDD VDD VSS VSS gf180mcu_as_sc_mcu7t3v3__fillcap_4
XFILLER_11_228 VDD VDD VSS VSS gf180mcu_as_sc_mcu7t3v3__fillcap_16
X_4978_ VDD VDD VSS VSS _4982_/B _4982_/A _4978_/Y gf180mcu_as_sc_mcu7t3v3__and2_2
XFILLER_221_1014 VDD VDD VSS VSS gf180mcu_as_sc_mcu7t3v3__fillcap_16
X_6717_ VDD VDD VSS VSS _6717_/A _6717_/Y gf180mcu_as_sc_mcu7t3v3__buff_2
Xclkload4 VDD VDD VSS VSS clkload4/Y clkload4/A gf180mcu_as_sc_mcu7t3v3__inv_6
X_3929_ VDD VDD VSS VSS _5905_/A _3929_/B _3929_/C _3929_/D _3931_/C gf180mcu_as_sc_mcu7t3v3__ao211_2
XFILLER_149_274 VDD VDD VSS VSS gf180mcu_as_sc_mcu7t3v3__fillcap_16
XFILLER_177_583 VDD VDD VSS VSS gf180mcu_as_sc_mcu7t3v3__fill_1
XFILLER_50_37 VDD VDD VSS VSS gf180mcu_as_sc_mcu7t3v3__fillcap_8
XFILLER_164_255 VDD VDD VSS VSS gf180mcu_as_sc_mcu7t3v3__fillcap_4
XFILLER_164_277 VDD VDD VSS VSS gf180mcu_as_sc_mcu7t3v3__fill_1
XFILLER_161_962 VDD VDD VSS VSS gf180mcu_as_sc_mcu7t3v3__fill_1
XFILLER_3_449 VDD VDD VSS VSS gf180mcu_as_sc_mcu7t3v3__fill_1
XPHY_EDGE_ROW_81_3_Left_786 VDD VSS gf180mcu_as_sc_mcu7t3v3__tap_2
XFILLER_133_664 VDD VDD VSS VSS gf180mcu_as_sc_mcu7t3v3__fill_2
XPHY_EDGE_ROW_88_2_Left_529 VDD VSS gf180mcu_as_sc_mcu7t3v3__tap_2
XFILLER_152_1119 VDD VDD VSS VSS gf180mcu_as_sc_mcu7t3v3__fillcap_16
XFILLER_8_1065 VDD VDD VSS VSS gf180mcu_as_sc_mcu7t3v3__fillcap_16
XFILLER_101_594 VDD VDD VSS VSS gf180mcu_as_sc_mcu7t3v3__fillcap_4
XFILLER_47_637 VDD VDD VSS VSS gf180mcu_as_sc_mcu7t3v3__fillcap_4
XFILLER_8_1087 VDD VDD VSS VSS gf180mcu_as_sc_mcu7t3v3__fillcap_16
XFILLER_216_963 VDD VDD VSS VSS gf180mcu_as_sc_mcu7t3v3__fillcap_16
XFILLER_62_629 VDD VDD VSS VSS gf180mcu_as_sc_mcu7t3v3__fill_1
XFILLER_215_451 VDD VDD VSS VSS gf180mcu_as_sc_mcu7t3v3__fill_2
XFILLER_76_1245 VDD VDD VSS VSS gf180mcu_as_sc_mcu7t3v3__fillcap_16
XFILLER_202_101 VDD VDD VSS VSS gf180mcu_as_sc_mcu7t3v3__fillcap_4
XTAP_TAPCELL_ROW_142_3_3062 VDD VSS gf180mcu_as_sc_mcu7t3v3__tap_2
XTAP_TAPCELL_ROW_194_2242 VDD VSS gf180mcu_as_sc_mcu7t3v3__tap_2
XTAP_TAPCELL_ROW_194_2231 VDD VSS gf180mcu_as_sc_mcu7t3v3__tap_2
XPHY_EDGE_ROW_122_1_Left_350 VDD VSS gf180mcu_as_sc_mcu7t3v3__tap_2
XFILLER_168_594 VDD VDD VSS VSS gf180mcu_as_sc_mcu7t3v3__fill_1
XPHY_EDGE_ROW_135_2_Right_972 VDD VSS gf180mcu_as_sc_mcu7t3v3__tap_2
XTAP_TAPCELL_ROW_155_1525 VDD VSS gf180mcu_as_sc_mcu7t3v3__tap_2
XTAP_TAPCELL_ROW_155_1536 VDD VSS gf180mcu_as_sc_mcu7t3v3__tap_2
XFILLER_100_1210 VDD VDD VSS VSS gf180mcu_as_sc_mcu7t3v3__fillcap_8
XFILLER_13_1262 VDD VDD VSS VSS gf180mcu_as_sc_mcu7t3v3__fill_2
XFILLER_155_244 VDD VDD VSS VSS gf180mcu_as_sc_mcu7t3v3__fillcap_16
XFILLER_7_744 VDD VDD VSS VSS gf180mcu_as_sc_mcu7t3v3__fill_2
XFILLER_171_726 VDD VDD VSS VSS gf180mcu_as_sc_mcu7t3v3__fillcap_4
XFILLER_124_642 VDD VDD VSS VSS gf180mcu_as_sc_mcu7t3v3__fillcap_4
XFILLER_124_653 VDD VDD VSS VSS gf180mcu_as_sc_mcu7t3v3__fillcap_8
XFILLER_170_247 VDD VDD VSS VSS gf180mcu_as_sc_mcu7t3v3__fillcap_16
XFILLER_226_18 VDD VDD VSS VSS gf180mcu_as_sc_mcu7t3v3__fillcap_16
XTAP_TAPCELL_ROW_213_2581 VDD VSS gf180mcu_as_sc_mcu7t3v3__tap_2
XTAP_TAPCELL_ROW_213_2570 VDD VSS gf180mcu_as_sc_mcu7t3v3__tap_2
XFILLER_151_472 VDD VDD VSS VSS gf180mcu_as_sc_mcu7t3v3__fill_2
XFILLER_152_995 VDD VDD VSS VSS gf180mcu_as_sc_mcu7t3v3__fillcap_16
XPHY_EDGE_ROW_70_3_Right_150 VDD VSS gf180mcu_as_sc_mcu7t3v3__tap_2
XTAP_TAPCELL_ROW_14_1267 VDD VSS gf180mcu_as_sc_mcu7t3v3__tap_2
XFILLER_20_1233 VDD VDD VSS VSS gf180mcu_as_sc_mcu7t3v3__fillcap_8
XFILLER_53_607 VDD VDD VSS VSS gf180mcu_as_sc_mcu7t3v3__fill_2
X_5950_ VDD VDD VSS VSS _6524_/Q _5950_/B _5950_/C _5950_/D _5951_/C gf180mcu_as_sc_mcu7t3v3__ao22_2
XFILLER_206_473 VDD VDD VSS VSS gf180mcu_as_sc_mcu7t3v3__fillcap_8
X_4901_ VDD VDD VSS VSS _4902_/B _5885_/A _4957_/B _4901_/C gf180mcu_as_sc_mcu7t3v3__ao21_2
XFILLER_178_314 VDD VDD VSS VSS gf180mcu_as_sc_mcu7t3v3__fill_1
X_5881_ VDD VDD VSS VSS _5881_/A _5946_/B _5946_/C _5881_/D _5882_/D gf180mcu_as_sc_mcu7t3v3__ao22_2
XPHY_EDGE_ROW_54_1_Left_282 VDD VSS gf180mcu_as_sc_mcu7t3v3__tap_2
X_4832_ VDD VDD VSS VSS _6512_/Q _4960_/B _4832_/C _4832_/D _4833_/D gf180mcu_as_sc_mcu7t3v3__ao22_2
XFILLER_194_829 VDD VDD VSS VSS gf180mcu_as_sc_mcu7t3v3__fill_2
Xclkbuf_leaf_29_clk_regs VDD VDD VSS VSS clkload2/A _6492_/CLK gf180mcu_as_sc_mcu7t3v3__clkbuff_12
X_4763_ VDD VDD VSS VSS _5776_/A _4875_/B _4763_/C _4867_/D _4766_/C gf180mcu_as_sc_mcu7t3v3__ao211_2
X_6502_ VDD VDD VSS VSS _6519_/CLK _6502_/D _6502_/Q gf180mcu_as_sc_mcu7t3v3__dfxtp_2
X_4694_ VDD VDD VSS VSS _4794_/S _4694_/B _6497_/Q _4695_/D gf180mcu_as_sc_mcu7t3v3__mux2_2
X_3714_ VDD VDD VSS VSS _6021_/Q _3904_/B _4026_/B _3904_/D _6021_/D gf180mcu_as_sc_mcu7t3v3__ao22_2
X_6433_ VDD VDD VSS VSS _6437_/CLK _6433_/D _6433_/Q gf180mcu_as_sc_mcu7t3v3__dfxtp_2
XFILLER_162_715 VDD VDD VSS VSS gf180mcu_as_sc_mcu7t3v3__fill_2
XFILLER_162_737 VDD VDD VSS VSS gf180mcu_as_sc_mcu7t3v3__fill_2
XFILLER_174_597 VDD VDD VSS VSS gf180mcu_as_sc_mcu7t3v3__fillcap_4
Xmax_cap931 VDD VDD VSS VSS _5586_/A _5506_/A gf180mcu_as_sc_mcu7t3v3__clkbuff_12
X_3645_ VDD VDD VSS VSS _3645_/Y _5963_/A _5972_/C gf180mcu_as_sc_mcu7t3v3__nor2_2
XFILLER_115_620 VDD VDD VSS VSS gf180mcu_as_sc_mcu7t3v3__fill_1
XFILLER_136_18 VDD VDD VSS VSS gf180mcu_as_sc_mcu7t3v3__fillcap_16
XFILLER_1_909 VDD VDD VSS VSS gf180mcu_as_sc_mcu7t3v3__fill_1
X_6364_ VDD VDD VSS VSS _6368_/CLK _6364_/D _6364_/Q gf180mcu_as_sc_mcu7t3v3__dfxtp_2
X_3576_ VDD VDD VSS VSS _3583_/C _5323_/A _5930_/D gf180mcu_as_sc_mcu7t3v3__nand2b_2
XFILLER_115_664 VDD VDD VSS VSS gf180mcu_as_sc_mcu7t3v3__fill_2
XPHY_EDGE_ROW_147_3_Right_227 VDD VSS gf180mcu_as_sc_mcu7t3v3__tap_2
X_6295_ VDD VDD VSS VSS clkload6/A _6295_/D _6295_/Q gf180mcu_as_sc_mcu7t3v3__dfxtp_2
X_5315_ VDD VDD VSS VSS _5953_/A _5315_/B _5315_/C _5315_/D _5316_/A gf180mcu_as_sc_mcu7t3v3__ao211_2
Xinput309 VDD VDD VSS VSS west_in[15] _5800_/A gf180mcu_as_sc_mcu7t3v3__buff_12
X_5246_ VDD VDD VSS VSS _5885_/A _5306_/B _5246_/C _5246_/D _5247_/A gf180mcu_as_sc_mcu7t3v3__ao211_2
XFILLER_29_27 VDD VDD VSS VSS gf180mcu_as_sc_mcu7t3v3__fillcap_16
XFILLER_116_1261 VDD VDD VSS VSS gf180mcu_as_sc_mcu7t3v3__fillcap_4
XFILLER_99_1212 VDD VDD VSS VSS gf180mcu_as_sc_mcu7t3v3__fill_1
X_5177_ VDD VDD VSS VSS _5178_/D _5296_/B _5295_/B _5177_/A gf180mcu_as_sc_mcu7t3v3__aoi21_2
XFILLER_29_659 VDD VDD VSS VSS gf180mcu_as_sc_mcu7t3v3__fill_2
X_4128_ VDD VDD VSS VSS _4143_/S _6178_/Q _6177_/Q _6177_/D gf180mcu_as_sc_mcu7t3v3__mux2_2
X_4059_ VDD VDD VSS VSS _5960_/C _4059_/B _6130_/Q _6130_/D gf180mcu_as_sc_mcu7t3v3__mux2_2
XFILLER_213_900 VDD VDD VSS VSS gf180mcu_as_sc_mcu7t3v3__fill_2
XFILLER_101_43 VDD VDD VSS VSS gf180mcu_as_sc_mcu7t3v3__fillcap_8
XFILLER_213_955 VDD VDD VSS VSS gf180mcu_as_sc_mcu7t3v3__fillcap_16
XFILLER_227_1256 VDD VDD VSS VSS gf180mcu_as_sc_mcu7t3v3__fillcap_4
XTAP_TAPCELL_ROW_0_986 VDD VSS gf180mcu_as_sc_mcu7t3v3__tap_2
XTAP_TAPCELL_ROW_0_997 VDD VSS gf180mcu_as_sc_mcu7t3v3__tap_2
XFILLER_12_504 VDD VDD VSS VSS gf180mcu_as_sc_mcu7t3v3__fillcap_4
XFILLER_212_454 VDD VDD VSS VSS gf180mcu_as_sc_mcu7t3v3__fill_1
XFILLER_123_1210 VDD VDD VSS VSS gf180mcu_as_sc_mcu7t3v3__fill_2
XFILLER_12_559 VDD VDD VSS VSS gf180mcu_as_sc_mcu7t3v3__fill_1
XFILLER_184_317 VDD VDD VSS VSS gf180mcu_as_sc_mcu7t3v3__fillcap_4
XFILLER_196_177 VDD VDD VSS VSS gf180mcu_as_sc_mcu7t3v3__fillcap_4
XFILLER_165_553 VDD VDD VSS VSS gf180mcu_as_sc_mcu7t3v3__fillcap_4
XFILLER_193_1208 VDD VDD VSS VSS gf180mcu_as_sc_mcu7t3v3__fillcap_16
XFILLER_152_225 VDD VDD VSS VSS gf180mcu_as_sc_mcu7t3v3__fillcap_16
XFILLER_152_247 VDD VDD VSS VSS gf180mcu_as_sc_mcu7t3v3__fillcap_16
XTAP_TAPCELL_ROW_150_1433 VDD VSS gf180mcu_as_sc_mcu7t3v3__tap_2
XFILLER_10_62 VDD VDD VSS VSS gf180mcu_as_sc_mcu7t3v3__fillcap_16
XTAP_TAPCELL_ROW_150_1444 VDD VSS gf180mcu_as_sc_mcu7t3v3__tap_2
XFILLER_161_792 VDD VDD VSS VSS gf180mcu_as_sc_mcu7t3v3__fillcap_4
Xclkbuf_regs_0_clk VDD VDD VSS VSS clk clkbuf_regs_0_clk/Y gf180mcu_as_sc_mcu7t3v3__clkbuff_12
XFILLER_86_33 VDD VDD VSS VSS gf180mcu_as_sc_mcu7t3v3__fill_2
Xfanout1025 VDD VDD VSS VSS input1/Y _4239_/A gf180mcu_as_sc_mcu7t3v3__buff_12
XFILLER_228_1009 VDD VDD VSS VSS gf180mcu_as_sc_mcu7t3v3__fillcap_4
XFILLER_204_922 VDD VDD VSS VSS gf180mcu_as_sc_mcu7t3v3__fillcap_16
XFILLER_167_1170 VDD VDD VSS VSS gf180mcu_as_sc_mcu7t3v3__fillcap_16
XFILLER_188_601 VDD VDD VSS VSS gf180mcu_as_sc_mcu7t3v3__fill_2
XFILLER_204_944 VDD VDD VSS VSS gf180mcu_as_sc_mcu7t3v3__fill_1
XFILLER_167_1192 VDD VDD VSS VSS gf180mcu_as_sc_mcu7t3v3__fillcap_16
XFILLER_188_667 VDD VDD VSS VSS gf180mcu_as_sc_mcu7t3v3__fillcap_8
XFILLER_203_443 VDD VDD VSS VSS gf180mcu_as_sc_mcu7t3v3__fillcap_4
XFILLER_175_306 VDD VDD VSS VSS gf180mcu_as_sc_mcu7t3v3__fillcap_4
XFILLER_198_1119 VDD VDD VSS VSS gf180mcu_as_sc_mcu7t3v3__fillcap_16
XTAP_TAPCELL_ROW_215_2610 VDD VSS gf180mcu_as_sc_mcu7t3v3__tap_2
XFILLER_168_391 VDD VDD VSS VSS gf180mcu_as_sc_mcu7t3v3__fill_2
XTAP_TAPCELL_ROW_170_1809 VDD VSS gf180mcu_as_sc_mcu7t3v3__tap_2
XPHY_EDGE_ROW_136_2_Right_973 VDD VSS gf180mcu_as_sc_mcu7t3v3__tap_2
Xwire494 VDD VDD VSS VSS _3259_/Y wire494/Y gf180mcu_as_sc_mcu7t3v3__clkbuff_12
XFILLER_183_394 VDD VDD VSS VSS gf180mcu_as_sc_mcu7t3v3__fillcap_16
X_3430_ VDD VDD VSS VSS _4456_/A _6283_/Q _6324_/Q _3434_/B gf180mcu_as_sc_mcu7t3v3__mux2_2
X_3361_ VDD VDD VSS VSS _6210_/Q _3361_/B _4101_/S _6218_/Q _3362_/C gf180mcu_as_sc_mcu7t3v3__ao22_2
XTAP_TAPCELL_ROW_16_1307 VDD VSS gf180mcu_as_sc_mcu7t3v3__tap_2
XTAP_TAPCELL_ROW_16_1318 VDD VSS gf180mcu_as_sc_mcu7t3v3__tap_2
X_6080_ VDD VDD VSS VSS _6518_/CLK _6080_/D _6080_/Q gf180mcu_as_sc_mcu7t3v3__dfxtp_2
X_5100_ VDD VDD VSS VSS _5100_/B _5229_/A _6387_/D gf180mcu_as_sc_mcu7t3v3__and2_2
XFILLER_170_1049 VDD VDD VSS VSS gf180mcu_as_sc_mcu7t3v3__fillcap_16
XPHY_EDGE_ROW_71_3_Right_151 VDD VSS gf180mcu_as_sc_mcu7t3v3__tap_2
XTAP_TAPCELL_ROW_16_1329 VDD VSS gf180mcu_as_sc_mcu7t3v3__tap_2
X_5031_ VDD VDD VSS VSS _5187_/S _5031_/B _6496_/Q _5033_/C gf180mcu_as_sc_mcu7t3v3__mux2_2
X_3292_ VDD VDD VSS VSS _3296_/B _6171_/Q _3293_/D gf180mcu_as_sc_mcu7t3v3__and2_2
Xhold1208 VDD VDD VSS VSS hold1234/Y _6542_/D gf180mcu_as_sc_mcu7t3v3__clkbuff_4
Xhold1219 VDD VDD VSS VSS hold1219/A _3197_/A gf180mcu_as_sc_mcu7t3v3__clkbuff_4
XFILLER_211_1046 VDD VDD VSS VSS gf180mcu_as_sc_mcu7t3v3__fillcap_4
XFILLER_211_1068 VDD VDD VSS VSS gf180mcu_as_sc_mcu7t3v3__fillcap_16
XFILLER_26_629 VDD VDD VSS VSS gf180mcu_as_sc_mcu7t3v3__fillcap_16
XFILLER_0_1113 VDD VDD VSS VSS gf180mcu_as_sc_mcu7t3v3__fillcap_4
XFILLER_0_1124 VDD VDD VSS VSS gf180mcu_as_sc_mcu7t3v3__fill_1
XFILLER_202_53 VDD VDD VSS VSS gf180mcu_as_sc_mcu7t3v3__fillcap_16
XFILLER_213_207 VDD VDD VSS VSS gf180mcu_as_sc_mcu7t3v3__fill_2
XFILLER_146_1210 VDD VDD VSS VSS gf180mcu_as_sc_mcu7t3v3__fillcap_16
XFILLER_34_662 VDD VDD VSS VSS gf180mcu_as_sc_mcu7t3v3__fillcap_4
X_5933_ VDD VDD VSS VSS _5933_/A _5953_/B _5933_/C _5933_/D _5934_/B gf180mcu_as_sc_mcu7t3v3__ao211_2
X_5864_ VDD VDD VSS VSS _5864_/A _5864_/B _5864_/C _5864_/D _5866_/C gf180mcu_as_sc_mcu7t3v3__ao211_2
XFILLER_210_936 VDD VDD VSS VSS gf180mcu_as_sc_mcu7t3v3__fillcap_8
XFILLER_210_947 VDD VDD VSS VSS gf180mcu_as_sc_mcu7t3v3__fillcap_16
X_4815_ VDD VDD VSS VSS _5818_/A _4872_/B _4815_/C _4815_/D _4816_/B gf180mcu_as_sc_mcu7t3v3__ao211_2
X_5795_ VDD VDD VSS VSS _5795_/S _5795_/B _5795_/A _5796_/B gf180mcu_as_sc_mcu7t3v3__mux2_2
XFILLER_179_1030 VDD VDD VSS VSS gf180mcu_as_sc_mcu7t3v3__fillcap_16
XFILLER_193_158 VDD VDD VSS VSS gf180mcu_as_sc_mcu7t3v3__fillcap_8
X_4746_ VDD VDD VSS VSS _4747_/D _4860_/B _4746_/B _5758_/A gf180mcu_as_sc_mcu7t3v3__aoi21b_2
XFILLER_179_1052 VDD VDD VSS VSS gf180mcu_as_sc_mcu7t3v3__fillcap_16
X_4677_ VDD VDD VSS VSS _5693_/A _4795_/B _4677_/C _4677_/D _4678_/B gf180mcu_as_sc_mcu7t3v3__ao211_2
X_6416_ VDD VDD VSS VSS _6422_/CLK _6416_/D _6416_/Q gf180mcu_as_sc_mcu7t3v3__dfxtp_2
X_3628_ VDD VDD VSS VSS _3628_/B _4648_/B _5354_/C gf180mcu_as_sc_mcu7t3v3__and2_2
XFILLER_227_72 VDD VDD VSS VSS gf180mcu_as_sc_mcu7t3v3__fillcap_4
X_6347_ VDD VDD VSS VSS _6546_/CLK _6347_/D _6347_/Q gf180mcu_as_sc_mcu7t3v3__dfxtp_2
XPHY_EDGE_ROW_148_3_Right_228 VDD VSS gf180mcu_as_sc_mcu7t3v3__tap_2
X_3559_ VDD VDD VSS VSS _3656_/A _3561_/C _5649_/A gf180mcu_as_sc_mcu7t3v3__nand2_2
Xinput106 VDD VDD VSS VSS ne_in[28] _5905_/A gf180mcu_as_sc_mcu7t3v3__buff_12
Xinput117 VDD VDD VSS VSS ne_in[5] wire1021/A gf180mcu_as_sc_mcu7t3v3__buff_12
X_6278_ VDD VDD VSS VSS clkload6/A _6278_/D _6278_/Q gf180mcu_as_sc_mcu7t3v3__dfxtp_2
Xinput128 VDD VDD VSS VSS north_in[15] wire1019/A gf180mcu_as_sc_mcu7t3v3__buff_12
Xinput139 VDD VDD VSS VSS north_in[25] _5878_/B gf180mcu_as_sc_mcu7t3v3__buff_12
X_5229_ VDD VDD VSS VSS _5229_/B _5229_/A _6401_/D gf180mcu_as_sc_mcu7t3v3__and2_2
XFILLER_5_1046 VDD VDD VSS VSS gf180mcu_as_sc_mcu7t3v3__fillcap_4
XPHY_EDGE_ROW_112_3_Left_817 VDD VSS gf180mcu_as_sc_mcu7t3v3__tap_2
XFILLER_17_618 VDD VDD VSS VSS gf180mcu_as_sc_mcu7t3v3__fillcap_16
XFILLER_217_557 VDD VDD VSS VSS gf180mcu_as_sc_mcu7t3v3__fill_2
XFILLER_5_1068 VDD VDD VSS VSS gf180mcu_as_sc_mcu7t3v3__fillcap_16
XFILLER_16_128 VDD VDD VSS VSS gf180mcu_as_sc_mcu7t3v3__fillcap_4
XFILLER_198_932 VDD VDD VSS VSS gf180mcu_as_sc_mcu7t3v3__fillcap_8
XFILLER_204_229 VDD VDD VSS VSS gf180mcu_as_sc_mcu7t3v3__fill_1
XFILLER_158_807 VDD VDD VSS VSS gf180mcu_as_sc_mcu7t3v3__fillcap_8
XFILLER_200_457 VDD VDD VSS VSS gf180mcu_as_sc_mcu7t3v3__fillcap_4
XFILLER_227_2 VDD VDD VSS VSS gf180mcu_as_sc_mcu7t3v3__fillcap_16
XFILLER_158_1103 VDD VDD VSS VSS gf180mcu_as_sc_mcu7t3v3__fillcap_16
XFILLER_166_873 VDD VDD VSS VSS gf180mcu_as_sc_mcu7t3v3__fill_2
XFILLER_10_1221 VDD VDD VSS VSS gf180mcu_as_sc_mcu7t3v3__fillcap_4
XFILLER_10_1243 VDD VDD VSS VSS gf180mcu_as_sc_mcu7t3v3__fillcap_16
XTAP_TAPCELL_ROW_189_2152 VDD VSS gf180mcu_as_sc_mcu7t3v3__tap_2
XTAP_TAPCELL_ROW_189_2141 VDD VSS gf180mcu_as_sc_mcu7t3v3__tap_2
XPHY_EDGE_ROW_21_2_Left_462 VDD VSS gf180mcu_as_sc_mcu7t3v3__tap_2
XPHY_EDGE_ROW_44_3_Left_749 VDD VSS gf180mcu_as_sc_mcu7t3v3__tap_2
XTAP_TAPCELL_ROW_11_1204 VDD VSS gf180mcu_as_sc_mcu7t3v3__tap_2
XTAP_TAPCELL_ROW_11_1215 VDD VSS gf180mcu_as_sc_mcu7t3v3__tap_2
XTAP_TAPCELL_ROW_130_3_3044 VDD VSS gf180mcu_as_sc_mcu7t3v3__tap_2
XTAP_TAPCELL_ROW_208_2491 VDD VSS gf180mcu_as_sc_mcu7t3v3__tap_2
XTAP_TAPCELL_ROW_208_2480 VDD VSS gf180mcu_as_sc_mcu7t3v3__tap_2
XTAP_TAPCELL_ROW_163_1668 VDD VSS gf180mcu_as_sc_mcu7t3v3__tap_2
XTAP_TAPCELL_ROW_163_1679 VDD VSS gf180mcu_as_sc_mcu7t3v3__tap_2
XFILLER_204_730 VDD VDD VSS VSS gf180mcu_as_sc_mcu7t3v3__fillcap_4
XTAP_TAPCELL_ROW_180_1982 VDD VSS gf180mcu_as_sc_mcu7t3v3__tap_2
XFILLER_188_420 VDD VDD VSS VSS gf180mcu_as_sc_mcu7t3v3__fill_1
XFILLER_203_240 VDD VDD VSS VSS gf180mcu_as_sc_mcu7t3v3__fillcap_8
XFILLER_31_610 VDD VDD VSS VSS gf180mcu_as_sc_mcu7t3v3__fill_1
XFILLER_149_818 VDD VDD VSS VSS gf180mcu_as_sc_mcu7t3v3__fillcap_4
XFILLER_189_998 VDD VDD VSS VSS gf180mcu_as_sc_mcu7t3v3__fillcap_16
XFILLER_31_643 VDD VDD VSS VSS gf180mcu_as_sc_mcu7t3v3__fill_2
XFILLER_176_637 VDD VDD VSS VSS gf180mcu_as_sc_mcu7t3v3__fill_2
XFILLER_203_284 VDD VDD VSS VSS gf180mcu_as_sc_mcu7t3v3__fill_1
X_4600_ VDD VDD VSS VSS _4601_/B _6337_/Q _6333_/Q gf180mcu_as_sc_mcu7t3v3__nand2b_2
XFILLER_15_1154 VDD VDD VSS VSS gf180mcu_as_sc_mcu7t3v3__fillcap_16
XFILLER_175_136 VDD VDD VSS VSS gf180mcu_as_sc_mcu7t3v3__fillcap_4
XFILLER_178_90 VDD VDD VSS VSS gf180mcu_as_sc_mcu7t3v3__fillcap_8
X_5580_ VDD VDD VSS VSS _5638_/B _5912_/A _5604_/C gf180mcu_as_sc_mcu7t3v3__and2_2
X_4531_ VDD VDD VSS VSS _4537_/S _6296_/Q _6297_/Q _4532_/B gf180mcu_as_sc_mcu7t3v3__mux2_2
XPHY_EDGE_ROW_137_2_Right_974 VDD VSS gf180mcu_as_sc_mcu7t3v3__tap_2
X_4462_ VDD VDD VSS VSS _4462_/B _4462_/A _4468_/C gf180mcu_as_sc_mcu7t3v3__and2_2
X_6201_ VDD VDD VSS VSS _6365_/CLK _6201_/D _6201_/Q gf180mcu_as_sc_mcu7t3v3__dfxtp_2
X_3413_ VDD VDD VSS VSS _3413_/D _3413_/A _3413_/B _4562_/B _3414_/C gf180mcu_as_sc_mcu7t3v3__ao31_2
Xfanout807 VDD VDD VSS VSS _3868_/C _3927_/B gf180mcu_as_sc_mcu7t3v3__buff_12
X_4393_ VDD VDD VSS VSS _4395_/A _4393_/C _4400_/B _6143_/Q gf180mcu_as_sc_mcu7t3v3__aoi21_2
XFILLER_98_665 VDD VDD VSS VSS gf180mcu_as_sc_mcu7t3v3__fill_2
Xfanout818 VDD VDD VSS VSS _5195_/B _5224_/B gf180mcu_as_sc_mcu7t3v3__buff_12
Xfanout829 VDD VDD VSS VSS _4974_/Y _5293_/B gf180mcu_as_sc_mcu7t3v3__buff_12
X_6132_ VDD VDD VSS VSS _6490_/CLK _6132_/D _6132_/Q gf180mcu_as_sc_mcu7t3v3__dfxtp_2
X_3344_ VDD VDD VSS VSS _6200_/Q _4072_/B _4093_/S _6224_/Q _3345_/B gf180mcu_as_sc_mcu7t3v3__ao22_2
X_6063_ VDD VDD VSS VSS _6370_/CLK _6063_/D _6063_/Q gf180mcu_as_sc_mcu7t3v3__dfxtp_2
X_3275_ VDD VDD VSS VSS _4072_/A _3275_/B _3275_/A _3276_/B gf180mcu_as_sc_mcu7t3v3__mux2_2
XTAP_TAPCELL_ROW_228_2867 VDD VSS gf180mcu_as_sc_mcu7t3v3__tap_2
XTAP_TAPCELL_ROW_228_2856 VDD VSS gf180mcu_as_sc_mcu7t3v3__tap_2
XTAP_TAPCELL_ROW_228_2845 VDD VSS gf180mcu_as_sc_mcu7t3v3__tap_2
XFILLER_26_1261 VDD VDD VSS VSS gf180mcu_as_sc_mcu7t3v3__fillcap_4
XPHY_EDGE_ROW_72_3_Right_152 VDD VSS gf180mcu_as_sc_mcu7t3v3__tap_2
X_5014_ VDD VDD VSS VSS _5685_/A _5143_/B _5143_/C _5685_/D _5015_/D gf180mcu_as_sc_mcu7t3v3__ao22_2
XFILLER_214_527 VDD VDD VSS VSS gf180mcu_as_sc_mcu7t3v3__fill_2
XFILLER_226_387 VDD VDD VSS VSS gf180mcu_as_sc_mcu7t3v3__fillcap_4
XPHY_EDGE_ROW_90_3_Left_795 VDD VSS gf180mcu_as_sc_mcu7t3v3__tap_2
X_5916_ VDD VDD VSS VSS _5916_/A _5947_/B _5916_/C _5917_/C _5926_/B gf180mcu_as_sc_mcu7t3v3__aoi211_2
XFILLER_224_1259 VDD VDD VSS VSS gf180mcu_as_sc_mcu7t3v3__fillcap_4
XFILLER_22_665 VDD VDD VSS VSS gf180mcu_as_sc_mcu7t3v3__fill_2
XFILLER_33_1210 VDD VDD VSS VSS gf180mcu_as_sc_mcu7t3v3__fillcap_4
XFILLER_42_27 VDD VDD VSS VSS gf180mcu_as_sc_mcu7t3v3__fillcap_8
XFILLER_42_49 VDD VDD VSS VSS gf180mcu_as_sc_mcu7t3v3__fill_2
XPHY_EDGE_ROW_97_2_Left_538 VDD VSS gf180mcu_as_sc_mcu7t3v3__tap_2
X_5847_ VDD VDD VSS VSS _5847_/A _5871_/B _5847_/C _5871_/D _5848_/D gf180mcu_as_sc_mcu7t3v3__ao22_2
XFILLER_182_607 VDD VDD VSS VSS gf180mcu_as_sc_mcu7t3v3__fillcap_4
X_5778_ VDD VDD VSS VSS _5779_/B _5778_/A _5869_/B _5778_/C gf180mcu_as_sc_mcu7t3v3__ao21_2
X_4729_ VDD VDD VSS VSS _5741_/B _4860_/B _4729_/C _4729_/D _4730_/B gf180mcu_as_sc_mcu7t3v3__ao22_2
XFILLER_190_640 VDD VDD VSS VSS gf180mcu_as_sc_mcu7t3v3__fillcap_8
XFILLER_174_37 VDD VDD VSS VSS gf180mcu_as_sc_mcu7t3v3__fillcap_16
XFILLER_162_375 VDD VDD VSS VSS gf180mcu_as_sc_mcu7t3v3__fillcap_8
XFILLER_1_558 VDD VDD VSS VSS gf180mcu_as_sc_mcu7t3v3__fill_2
XTAP_TAPCELL_ROW_184_2060 VDD VSS gf180mcu_as_sc_mcu7t3v3__tap_2
XFILLER_190_69 VDD VDD VSS VSS gf180mcu_as_sc_mcu7t3v3__fillcap_4
XFILLER_218_844 VDD VDD VSS VSS gf180mcu_as_sc_mcu7t3v3__fillcap_4
XTAP_TAPCELL_ROW_8_1158 VDD VSS gf180mcu_as_sc_mcu7t3v3__tap_2
XFILLER_16_61 VDD VDD VSS VSS gf180mcu_as_sc_mcu7t3v3__fillcap_4
XFILLER_199_67 VDD VDD VSS VSS gf180mcu_as_sc_mcu7t3v3__fill_2
XFILLER_13_632 VDD VDD VSS VSS gf180mcu_as_sc_mcu7t3v3__fillcap_4
XFILLER_164_1151 VDD VDD VSS VSS gf180mcu_as_sc_mcu7t3v3__fillcap_4
XFILLER_198_773 VDD VDD VSS VSS gf180mcu_as_sc_mcu7t3v3__fill_1
XFILLER_213_582 VDD VDD VSS VSS gf180mcu_as_sc_mcu7t3v3__fillcap_4
XFILLER_164_1173 VDD VDD VSS VSS gf180mcu_as_sc_mcu7t3v3__fillcap_16
XFILLER_197_261 VDD VDD VSS VSS gf180mcu_as_sc_mcu7t3v3__fillcap_4
XFILLER_200_221 VDD VDD VSS VSS gf180mcu_as_sc_mcu7t3v3__fillcap_4
XFILLER_157_136 VDD VDD VSS VSS gf180mcu_as_sc_mcu7t3v3__fillcap_4
XFILLER_157_158 VDD VDD VSS VSS gf180mcu_as_sc_mcu7t3v3__fillcap_16
XFILLER_186_979 VDD VDD VSS VSS gf180mcu_as_sc_mcu7t3v3__fillcap_16
XFILLER_200_243 VDD VDD VSS VSS gf180mcu_as_sc_mcu7t3v3__fill_2
XFILLER_205_1170 VDD VDD VSS VSS gf180mcu_as_sc_mcu7t3v3__fillcap_16
XFILLER_166_670 VDD VDD VSS VSS gf180mcu_as_sc_mcu7t3v3__fillcap_8
XFILLER_173_629 VDD VDD VSS VSS gf180mcu_as_sc_mcu7t3v3__fill_1
XFILLER_205_1192 VDD VDD VSS VSS gf180mcu_as_sc_mcu7t3v3__fillcap_16
XFILLER_172_139 VDD VDD VSS VSS gf180mcu_as_sc_mcu7t3v3__fillcap_16
XFILLER_5_842 VDD VDD VSS VSS gf180mcu_as_sc_mcu7t3v3__fill_2
XFILLER_136_1242 VDD VDD VSS VSS gf180mcu_as_sc_mcu7t3v3__fill_1
XFILLER_171_1100 VDD VDD VSS VSS gf180mcu_as_sc_mcu7t3v3__fillcap_16
XFILLER_171_1122 VDD VDD VSS VSS gf180mcu_as_sc_mcu7t3v3__fillcap_16
XTAP_TAPCELL_ROW_165_1708 VDD VSS gf180mcu_as_sc_mcu7t3v3__tap_2
XFILLER_0_580 VDD VDD VSS VSS gf180mcu_as_sc_mcu7t3v3__fill_1
XPHY_EDGE_ROW_63_1_Left_291 VDD VSS gf180mcu_as_sc_mcu7t3v3__tap_2
XTAP_TAPCELL_ROW_148_3_3071 VDD VSS gf180mcu_as_sc_mcu7t3v3__tap_2
XTAP_TAPCELL_ROW_165_1719 VDD VSS gf180mcu_as_sc_mcu7t3v3__tap_2
X_3060_ VDD VDD VSS VSS _4493_/D _6284_/Q gf180mcu_as_sc_mcu7t3v3__inv_2
XTAP_TAPCELL_ROW_223_2764 VDD VSS gf180mcu_as_sc_mcu7t3v3__tap_2
XTAP_TAPCELL_ROW_223_2753 VDD VSS gf180mcu_as_sc_mcu7t3v3__tap_2
XFILLER_169_1084 VDD VDD VSS VSS gf180mcu_as_sc_mcu7t3v3__fillcap_16
XPHY_EDGE_ROW_11_Left_240 VDD VSS gf180mcu_as_sc_mcu7t3v3__tap_2
XFILLER_211_508 VDD VDD VSS VSS gf180mcu_as_sc_mcu7t3v3__fillcap_4
XFILLER_56_1210 VDD VDD VSS VSS gf180mcu_as_sc_mcu7t3v3__fill_1
X_5701_ VDD VDD VSS VSS _5701_/A _5800_/B _5701_/C _5701_/D _5702_/D gf180mcu_as_sc_mcu7t3v3__ao211_2
X_3962_ VDD VDD VSS VSS _3962_/D _4043_/A _4043_/B _3962_/C _6062_/D gf180mcu_as_sc_mcu7t3v3__ao31_2
XFILLER_17_1238 VDD VDD VSS VSS gf180mcu_as_sc_mcu7t3v3__fill_2
X_3893_ VDD VDD VSS VSS _3894_/B _3893_/C _3912_/B _5875_/A gf180mcu_as_sc_mcu7t3v3__aoi21b_2
XFILLER_177_979 VDD VDD VSS VSS gf180mcu_as_sc_mcu7t3v3__fill_1
X_5632_ VDD VDD VSS VSS _5944_/A _5632_/B _5632_/C _5945_/A _5633_/D gf180mcu_as_sc_mcu7t3v3__ao22_2
X_5563_ VDD VDD VSS VSS _5871_/A _5563_/B _5563_/C _5870_/B _5564_/D gf180mcu_as_sc_mcu7t3v3__ao22_2
XFILLER_157_692 VDD VDD VSS VSS gf180mcu_as_sc_mcu7t3v3__fillcap_8
XFILLER_191_459 VDD VDD VSS VSS gf180mcu_as_sc_mcu7t3v3__fillcap_16
X_4514_ VDD VDD VSS VSS _4520_/S _6717_/A _6291_/Q _4515_/A gf180mcu_as_sc_mcu7t3v3__mux2_2
XFILLER_176_1033 VDD VDD VSS VSS gf180mcu_as_sc_mcu7t3v3__fillcap_16
XFILLER_7_190 VDD VDD VSS VSS gf180mcu_as_sc_mcu7t3v3__fillcap_16
X_5494_ VDD VDD VSS VSS _5495_/D _5494_/B _5801_/B gf180mcu_as_sc_mcu7t3v3__nand2b_2
XFILLER_208_85 VDD VDD VSS VSS gf180mcu_as_sc_mcu7t3v3__fillcap_16
XPHY_EDGE_ROW_138_2_Right_975 VDD VSS gf180mcu_as_sc_mcu7t3v3__tap_2
X_4445_ VDD VDD VSS VSS _4445_/S _4445_/B _4445_/A _4446_/C gf180mcu_as_sc_mcu7t3v3__mux2_2
XFILLER_217_1030 VDD VDD VSS VSS gf180mcu_as_sc_mcu7t3v3__fillcap_16
XFILLER_217_1052 VDD VDD VSS VSS gf180mcu_as_sc_mcu7t3v3__fillcap_16
Xfanout604 VDD VDD VSS VSS _4964_/B _4872_/B gf180mcu_as_sc_mcu7t3v3__buff_12
Xfanout615 VDD VDD VSS VSS _3867_/B _3931_/B gf180mcu_as_sc_mcu7t3v3__buff_12
X_4376_ VDD VDD VSS VSS _4398_/S _6122_/Q _4376_/C _4404_/D _4380_/C gf180mcu_as_sc_mcu7t3v3__ao211_2
Xfanout626 VDD VDD VSS VSS _5188_/B _5143_/B gf180mcu_as_sc_mcu7t3v3__buff_12
Xfanout637 VDD VDD VSS VSS _3929_/B _3891_/B gf180mcu_as_sc_mcu7t3v3__buff_12
Xfanout648 VDD VDD VSS VSS _6005_/B _6011_/B gf180mcu_as_sc_mcu7t3v3__buff_12
X_6115_ VDD VDD VSS VSS _6506_/CLK _6115_/D _6115_/Q gf180mcu_as_sc_mcu7t3v3__dfxtp_2
X_3327_ VDD VDD VSS VSS _3327_/B _3343_/A _3332_/C gf180mcu_as_sc_mcu7t3v3__or2_2
Xfanout659 VDD VDD VSS VSS _5951_/D _5952_/B gf180mcu_as_sc_mcu7t3v3__buff_12
XFILLER_37_27 VDD VDD VSS VSS gf180mcu_as_sc_mcu7t3v3__fillcap_16
XPHY_EDGE_ROW_73_3_Right_153 VDD VSS gf180mcu_as_sc_mcu7t3v3__tap_2
X_6046_ VDD VDD VSS VSS _6125_/CLK _6046_/D _6046_/Q gf180mcu_as_sc_mcu7t3v3__dfxtp_2
X_3258_ VDD VDD VSS VSS _3259_/C _3258_/C _3258_/B _3353_/A gf180mcu_as_sc_mcu7t3v3__aoi21b_2
X_3189_ VDD VDD VSS VSS _4585_/A _6339_/Q _6340_/Q _3326_/S _3216_/D gf180mcu_as_sc_mcu7t3v3__ao22_2
XFILLER_2_1049 VDD VDD VSS VSS gf180mcu_as_sc_mcu7t3v3__fillcap_16
XFILLER_14_407 VDD VDD VSS VSS gf180mcu_as_sc_mcu7t3v3__fill_2
XFILLER_183_1048 VDD VDD VSS VSS gf180mcu_as_sc_mcu7t3v3__fill_2
XFILLER_54_598 VDD VDD VSS VSS gf180mcu_as_sc_mcu7t3v3__fill_2
XTAP_TAPCELL_ROW_3_1066 VDD VSS gf180mcu_as_sc_mcu7t3v3__tap_2
XFILLER_149_6 VDD VDD VSS VSS gf180mcu_as_sc_mcu7t3v3__fillcap_16
XFILLER_228_1192 VDD VDD VSS VSS gf180mcu_as_sc_mcu7t3v3__fillcap_4
XFILLER_195_754 VDD VDD VSS VSS gf180mcu_as_sc_mcu7t3v3__fillcap_16
XFILLER_10_657 VDD VDD VSS VSS gf180mcu_as_sc_mcu7t3v3__fill_1
XFILLER_183_916 VDD VDD VSS VSS gf180mcu_as_sc_mcu7t3v3__fill_2
XFILLER_154_139 VDD VDD VSS VSS gf180mcu_as_sc_mcu7t3v3__fillcap_16
XFILLER_159_1253 VDD VDD VSS VSS gf180mcu_as_sc_mcu7t3v3__fill_2
XFILLER_159_1264 VDD VDD VSS VSS gf180mcu_as_sc_mcu7t3v3__fill_1
XFILLER_191_982 VDD VDD VSS VSS gf180mcu_as_sc_mcu7t3v3__fillcap_16
XFILLER_2_834 VDD VDD VSS VSS gf180mcu_as_sc_mcu7t3v3__fillcap_16
XFILLER_2_856 VDD VDD VSS VSS gf180mcu_as_sc_mcu7t3v3__fill_1
XFILLER_150_389 VDD VDD VSS VSS gf180mcu_as_sc_mcu7t3v3__fill_1
XTAP_TAPCELL_ROW_182_2019 VDD VSS gf180mcu_as_sc_mcu7t3v3__tap_2
XFILLER_209_129 VDD VDD VSS VSS gf180mcu_as_sc_mcu7t3v3__fill_2
XFILLER_79_1210 VDD VDD VSS VSS gf180mcu_as_sc_mcu7t3v3__fill_1
Xmesh_tile_1069 VDD VDD VSS VSS ne_out[28] gf180mcu_as_sc_mcu7t3v3__tiel_4
Xmesh_tile_1058 VDD VDD VSS VSS ne_out[17] gf180mcu_as_sc_mcu7t3v3__tiel_4
Xmesh_tile_1047 VDD VDD VSS VSS ne_out[6] gf180mcu_as_sc_mcu7t3v3__tiel_4
XTAP_TAPCELL_ROW_160_1616 VDD VSS gf180mcu_as_sc_mcu7t3v3__tap_2
XTAP_TAPCELL_ROW_160_1627 VDD VSS gf180mcu_as_sc_mcu7t3v3__tap_2
XFILLER_206_869 VDD VDD VSS VSS gf180mcu_as_sc_mcu7t3v3__fillcap_4
XFILLER_14_941 VDD VDD VSS VSS gf180mcu_as_sc_mcu7t3v3__fillcap_4
XFILLER_177_209 VDD VDD VSS VSS gf180mcu_as_sc_mcu7t3v3__fill_1
XFILLER_45_598 VDD VDD VSS VSS gf180mcu_as_sc_mcu7t3v3__fill_2
XTAP_TAPCELL_ROW_201_2358 VDD VSS gf180mcu_as_sc_mcu7t3v3__tap_2
XFILLER_14_963 VDD VDD VSS VSS gf180mcu_as_sc_mcu7t3v3__fillcap_16
XFILLER_207_1232 VDD VDD VSS VSS gf180mcu_as_sc_mcu7t3v3__fill_2
XFILLER_213_390 VDD VDD VSS VSS gf180mcu_as_sc_mcu7t3v3__fill_1
XTAP_TAPCELL_ROW_197_2295 VDD VSS gf180mcu_as_sc_mcu7t3v3__tap_2
XTAP_TAPCELL_ROW_197_2284 VDD VSS gf180mcu_as_sc_mcu7t3v3__tap_2
XFILLER_9_433 VDD VDD VSS VSS gf180mcu_as_sc_mcu7t3v3__fillcap_4
XFILLER_146_629 VDD VDD VSS VSS gf180mcu_as_sc_mcu7t3v3__fillcap_8
XFILLER_16_1260 VDD VDD VSS VSS gf180mcu_as_sc_mcu7t3v3__fillcap_4
XFILLER_186_787 VDD VDD VSS VSS gf180mcu_as_sc_mcu7t3v3__fill_1
XTAP_TAPCELL_ROW_158_1578 VDD VSS gf180mcu_as_sc_mcu7t3v3__tap_2
XTAP_TAPCELL_ROW_158_1589 VDD VSS gf180mcu_as_sc_mcu7t3v3__tap_2
XFILLER_12_1135 VDD VDD VSS VSS gf180mcu_as_sc_mcu7t3v3__fillcap_16
XFILLER_185_286 VDD VDD VSS VSS gf180mcu_as_sc_mcu7t3v3__fill_2
XTAP_TAPCELL_ROW_175_1892 VDD VSS gf180mcu_as_sc_mcu7t3v3__tap_2
XFILLER_12_1157 VDD VDD VSS VSS gf180mcu_as_sc_mcu7t3v3__fillcap_16
XFILLER_154_662 VDD VDD VSS VSS gf180mcu_as_sc_mcu7t3v3__fill_2
XFILLER_173_459 VDD VDD VSS VSS gf180mcu_as_sc_mcu7t3v3__fillcap_4
XFILLER_182_982 VDD VDD VSS VSS gf180mcu_as_sc_mcu7t3v3__fillcap_16
XFILLER_181_492 VDD VDD VSS VSS gf180mcu_as_sc_mcu7t3v3__fillcap_16
XFILLER_4_193 VDD VDD VSS VSS gf180mcu_as_sc_mcu7t3v3__fillcap_16
X_4230_ VDD VDD VSS VSS _4230_/A _4230_/B _4337_/B _6722_/A _4231_/B gf180mcu_as_sc_mcu7t3v3__ao22_2
XFILLER_4_53 VDD VDD VSS VSS gf180mcu_as_sc_mcu7t3v3__fillcap_16
X_4161_ VDD VDD VSS VSS _6172_/Q _6171_/Q _4161_/C _4163_/C gf180mcu_as_sc_mcu7t3v3__nor3_2
X_4092_ VDD VDD VSS VSS _4093_/S _6721_/A _6152_/Q _6152_/D gf180mcu_as_sc_mcu7t3v3__mux2_2
X_3112_ VDD VDD VSS VSS _3113_/A _6530_/Q _6227_/Q _3423_/A gf180mcu_as_sc_mcu7t3v3__maj3_2
X_3043_ VDD VDD VSS VSS _4557_/D _6164_/Q gf180mcu_as_sc_mcu7t3v3__inv_2
XFILLER_110_1245 VDD VDD VSS VSS gf180mcu_as_sc_mcu7t3v3__fillcap_16
XFILLER_209_696 VDD VDD VSS VSS gf180mcu_as_sc_mcu7t3v3__fillcap_4
XPHY_EDGE_ROW_109_2_Left_550 VDD VSS gf180mcu_as_sc_mcu7t3v3__tap_2
X_4994_ VDD VDD VSS VSS _4996_/D _5233_/C _5224_/B _4994_/A gf180mcu_as_sc_mcu7t3v3__aoi21_2
XFILLER_210_53 VDD VDD VSS VSS gf180mcu_as_sc_mcu7t3v3__fillcap_16
X_3945_ VDD VDD VSS VSS _3945_/D _4051_/A _4026_/B _3974_/D _6050_/D gf180mcu_as_sc_mcu7t3v3__ao31_2
XFILLER_182_1081 VDD VDD VSS VSS gf180mcu_as_sc_mcu7t3v3__fillcap_4
XFILLER_149_478 VDD VDD VSS VSS gf180mcu_as_sc_mcu7t3v3__fill_1
X_5615_ VDD VDD VSS VSS _5930_/A _5638_/B _5615_/C _5930_/D _5616_/C gf180mcu_as_sc_mcu7t3v3__ao22_2
X_3876_ VDD VDD VSS VSS _6516_/Q _3925_/B _3886_/C _5862_/B _3877_/C gf180mcu_as_sc_mcu7t3v3__ao22_2
XFILLER_191_212 VDD VDD VSS VSS gf180mcu_as_sc_mcu7t3v3__fillcap_4
XPHY_EDGE_ROW_121_3_Left_826 VDD VSS gf180mcu_as_sc_mcu7t3v3__tap_2
XFILLER_191_256 VDD VDD VSS VSS gf180mcu_as_sc_mcu7t3v3__fillcap_16
X_5546_ VDD VDD VSS VSS _5849_/A _5585_/B _5546_/C _5546_/D _5547_/B gf180mcu_as_sc_mcu7t3v3__ao211_2
XFILLER_173_982 VDD VDD VSS VSS gf180mcu_as_sc_mcu7t3v3__fill_2
X_5477_ VDD VDD VSS VSS _5784_/A _5492_/B _5477_/C _5477_/D _5478_/C gf180mcu_as_sc_mcu7t3v3__ao22_2
XPHY_EDGE_ROW_139_2_Right_976 VDD VSS gf180mcu_as_sc_mcu7t3v3__tap_2
X_4428_ VDD VDD VSS VSS _6244_/Q _4428_/B _4583_/D _6243_/Q _6243_/D gf180mcu_as_sc_mcu7t3v3__ao22_2
XFILLER_48_37 VDD VDD VSS VSS gf180mcu_as_sc_mcu7t3v3__fillcap_8
X_4359_ VDD VDD VSS VSS _4360_/D _6219_/Q _4359_/B _4359_/C gf180mcu_as_sc_mcu7t3v3__ao21_2
XFILLER_171_38 VDD VDD VSS VSS gf180mcu_as_sc_mcu7t3v3__fillcap_16
XFILLER_189_1224 VDD VDD VSS VSS gf180mcu_as_sc_mcu7t3v3__fillcap_8
XFILLER_228_972 VDD VDD VSS VSS gf180mcu_as_sc_mcu7t3v3__fill_1
X_6029_ VDD VDD VSS VSS _6371_/CLK _6029_/D _6029_/Q gf180mcu_as_sc_mcu7t3v3__dfxtp_2
XTAP_TAPCELL_ROW_5_1106 VDD VSS gf180mcu_as_sc_mcu7t3v3__tap_2
XPHY_EDGE_ROW_74_3_Right_154 VDD VSS gf180mcu_as_sc_mcu7t3v3__tap_2
XFILLER_199_356 VDD VDD VSS VSS gf180mcu_as_sc_mcu7t3v3__fill_1
XFILLER_214_165 VDD VDD VSS VSS gf180mcu_as_sc_mcu7t3v3__fill_2
XFILLER_27_598 VDD VDD VSS VSS gf180mcu_as_sc_mcu7t3v3__fill_2
XFILLER_202_349 VDD VDD VSS VSS gf180mcu_as_sc_mcu7t3v3__fill_2
XFILLER_126_1241 VDD VDD VSS VSS gf180mcu_as_sc_mcu7t3v3__fill_2
XFILLER_11_944 VDD VDD VSS VSS gf180mcu_as_sc_mcu7t3v3__fillcap_16
XFILLER_128_629 VDD VDD VSS VSS gf180mcu_as_sc_mcu7t3v3__fillcap_16
XFILLER_161_1154 VDD VDD VSS VSS gf180mcu_as_sc_mcu7t3v3__fillcap_16
XFILLER_183_702 VDD VDD VSS VSS gf180mcu_as_sc_mcu7t3v3__fill_2
XFILLER_195_562 VDD VDD VSS VSS gf180mcu_as_sc_mcu7t3v3__fill_2
XPHY_EDGE_ROW_53_3_Left_758 VDD VSS gf180mcu_as_sc_mcu7t3v3__tap_2
XFILLER_182_212 VDD VDD VSS VSS gf180mcu_as_sc_mcu7t3v3__fill_1
XFILLER_202_1151 VDD VDD VSS VSS gf180mcu_as_sc_mcu7t3v3__fillcap_4
XPHY_EDGE_ROW_30_2_Left_471 VDD VSS gf180mcu_as_sc_mcu7t3v3__tap_2
XTAP_TAPCELL_ROW_192_2192 VDD VSS gf180mcu_as_sc_mcu7t3v3__tap_2
XFILLER_202_1173 VDD VDD VSS VSS gf180mcu_as_sc_mcu7t3v3__fillcap_16
XFILLER_89_33 VDD VDD VSS VSS gf180mcu_as_sc_mcu7t3v3__fill_2
Xwire879 VDD VDD VSS VSS _3366_/Y _6717_/A gf180mcu_as_sc_mcu7t3v3__clkbuff_12
XFILLER_151_632 VDD VDD VSS VSS gf180mcu_as_sc_mcu7t3v3__fill_1
XFILLER_163_492 VDD VDD VSS VSS gf180mcu_as_sc_mcu7t3v3__fillcap_8
XTAP_TAPCELL_ROW_153_1497 VDD VSS gf180mcu_as_sc_mcu7t3v3__tap_2
XFILLER_133_1234 VDD VDD VSS VSS gf180mcu_as_sc_mcu7t3v3__fillcap_4
Xfanout990 VDD VDD VSS VSS _6528_/D _3294_/B gf180mcu_as_sc_mcu7t3v3__buff_12
XFILLER_206_622 VDD VDD VSS VSS gf180mcu_as_sc_mcu7t3v3__fill_2
XFILLER_218_482 VDD VDD VSS VSS gf180mcu_as_sc_mcu7t3v3__fill_2
XTAP_TAPCELL_ROW_220_2701 VDD VSS gf180mcu_as_sc_mcu7t3v3__tap_2
XTAP_TAPCELL_ROW_199_2324 VDD VSS gf180mcu_as_sc_mcu7t3v3__tap_2
XFILLER_166_1065 VDD VDD VSS VSS gf180mcu_as_sc_mcu7t3v3__fillcap_16
XFILLER_18_598 VDD VDD VSS VSS gf180mcu_as_sc_mcu7t3v3__fill_2
XFILLER_166_1087 VDD VDD VSS VSS gf180mcu_as_sc_mcu7t3v3__fillcap_16
XTAP_TAPCELL_ROW_177_1921 VDD VSS gf180mcu_as_sc_mcu7t3v3__tap_2
XTAP_TAPCELL_ROW_177_1932 VDD VSS gf180mcu_as_sc_mcu7t3v3__tap_2
X_3730_ VDD VDD VSS VSS _5735_/D _3872_/B _3730_/C _3730_/D _3731_/B gf180mcu_as_sc_mcu7t3v3__ao211_2
XFILLER_207_1084 VDD VDD VSS VSS gf180mcu_as_sc_mcu7t3v3__fillcap_16
XTAP_TAPCELL_ROW_218_2663 VDD VSS gf180mcu_as_sc_mcu7t3v3__tap_2
XFILLER_173_212 VDD VDD VSS VSS gf180mcu_as_sc_mcu7t3v3__fill_1
X_3661_ VDD VDD VSS VSS _5675_/D _3887_/B _3661_/C _3661_/D _3663_/C gf180mcu_as_sc_mcu7t3v3__ao211_2
XTAP_TAPCELL_ROW_218_2674 VDD VSS gf180mcu_as_sc_mcu7t3v3__tap_2
XFILLER_16_1090 VDD VDD VSS VSS gf180mcu_as_sc_mcu7t3v3__fillcap_16
X_6380_ VDD VDD VSS VSS _6527_/CLK _6380_/D _6380_/Q gf180mcu_as_sc_mcu7t3v3__dfxtp_2
Xclkload11 VDD VDD VSS VSS clkload11/Y _6365_/CLK gf180mcu_as_sc_mcu7t3v3__inv_6
Xclkload22 VDD VDD VSS VSS clkload22/Y _6490_/CLK gf180mcu_as_sc_mcu7t3v3__inv_2
X_5400_ VDD VDD VSS VSS _5484_/B _5706_/A _5400_/A _5403_/A gf180mcu_as_sc_mcu7t3v3__mux2_2
X_3592_ VDD VDD VSS VSS _3595_/C _4977_/A _6524_/Q gf180mcu_as_sc_mcu7t3v3__nand2b_2
XFILLER_155_982 VDD VDD VSS VSS gf180mcu_as_sc_mcu7t3v3__fillcap_16
XPHY_EDGE_ROW_80_1_Right_652 VDD VSS gf180mcu_as_sc_mcu7t3v3__tap_2
XTAP_TAPCELL_ROW_136_3_3053 VDD VSS gf180mcu_as_sc_mcu7t3v3__tap_2
X_5331_ VDD VDD VSS VSS _5331_/S _5331_/B _5331_/A _5333_/B gf180mcu_as_sc_mcu7t3v3__mux2_2
XFILLER_154_481 VDD VDD VSS VSS gf180mcu_as_sc_mcu7t3v3__fillcap_4
XFILLER_173_1025 VDD VDD VSS VSS gf180mcu_as_sc_mcu7t3v3__fillcap_16
XFILLER_142_665 VDD VDD VSS VSS gf180mcu_as_sc_mcu7t3v3__fill_2
XFILLER_170_974 VDD VDD VSS VSS gf180mcu_as_sc_mcu7t3v3__fill_1
X_5262_ VDD VDD VSS VSS _5294_/A _5906_/D _5904_/A _5263_/D gf180mcu_as_sc_mcu7t3v3__mux2_2
XFILLER_214_1011 VDD VDD VSS VSS gf180mcu_as_sc_mcu7t3v3__fillcap_4
XFILLER_214_1033 VDD VDD VSS VSS gf180mcu_as_sc_mcu7t3v3__fillcap_16
X_5193_ VDD VDD VSS VSS _5221_/B _5847_/A _5194_/C gf180mcu_as_sc_mcu7t3v3__and2_2
X_4213_ VDD VDD VSS VSS _6198_/D _4213_/C _4223_/B _4214_/A gf180mcu_as_sc_mcu7t3v3__aoi21_2
X_4144_ VDD VDD VSS VSS _4144_/S _6194_/Q _6193_/Q _6193_/D gf180mcu_as_sc_mcu7t3v3__mux2_2
XFILLER_228_246 VDD VDD VSS VSS gf180mcu_as_sc_mcu7t3v3__fill_1
XFILLER_3_1100 VDD VDD VSS VSS gf180mcu_as_sc_mcu7t3v3__fillcap_16
XFILLER_209_460 VDD VDD VSS VSS gf180mcu_as_sc_mcu7t3v3__fill_2
XFILLER_3_1122 VDD VDD VSS VSS gf180mcu_as_sc_mcu7t3v3__fillcap_16
X_4075_ VDD VDD VSS VSS _6136_/D _4075_/B _4602_/C gf180mcu_as_sc_mcu7t3v3__nor2_2
XPHY_EDGE_ROW_26_1_Left_254 VDD VSS gf180mcu_as_sc_mcu7t3v3__tap_2
X_3026_ VDD VDD VSS VSS _3463_/B _5939_/A gf180mcu_as_sc_mcu7t3v3__inv_2
XFILLER_169_507 VDD VDD VSS VSS gf180mcu_as_sc_mcu7t3v3__fill_2
XTAP_TAPCELL_ROW_0_1003 VDD VSS gf180mcu_as_sc_mcu7t3v3__tap_2
XTAP_TAPCELL_ROW_0_1014 VDD VSS gf180mcu_as_sc_mcu7t3v3__tap_2
XFILLER_169_529 VDD VDD VSS VSS gf180mcu_as_sc_mcu7t3v3__fillcap_4
X_6716_ VDD VDD VSS VSS _6716_/A _6716_/Y gf180mcu_as_sc_mcu7t3v3__buff_2
X_4977_ VDD VDD VSS VSS _4977_/A _5312_/A _4977_/C _4982_/B _4977_/D gf180mcu_as_sc_mcu7t3v3__aoi211_2
XFILLER_165_702 VDD VDD VSS VSS gf180mcu_as_sc_mcu7t3v3__fillcap_4
Xclkload5 VDD VDD VSS VSS clkload5/Y clkload5/A gf180mcu_as_sc_mcu7t3v3__inv_4
X_3928_ VDD VDD VSS VSS _3928_/B _5903_/A _3929_/D gf180mcu_as_sc_mcu7t3v3__and2_2
XFILLER_164_201 VDD VDD VSS VSS gf180mcu_as_sc_mcu7t3v3__fillcap_4
XFILLER_50_27 VDD VDD VSS VSS gf180mcu_as_sc_mcu7t3v3__fillcap_8
XFILLER_50_49 VDD VDD VSS VSS gf180mcu_as_sc_mcu7t3v3__fill_2
X_3859_ VDD VDD VSS VSS _3888_/B _5845_/A _3860_/D gf180mcu_as_sc_mcu7t3v3__and2_2
XFILLER_153_908 VDD VDD VSS VSS gf180mcu_as_sc_mcu7t3v3__fill_2
XFILLER_164_289 VDD VDD VSS VSS gf180mcu_as_sc_mcu7t3v3__fillcap_16
XFILLER_192_576 VDD VDD VSS VSS gf180mcu_as_sc_mcu7t3v3__fillcap_4
X_5529_ VDD VDD VSS VSS _5835_/A _5628_/D _5529_/C _5529_/D _5530_/B gf180mcu_as_sc_mcu7t3v3__ao22_2
XFILLER_160_440 VDD VDD VSS VSS gf180mcu_as_sc_mcu7t3v3__fillcap_4
XFILLER_59_36 VDD VDD VSS VSS gf180mcu_as_sc_mcu7t3v3__fillcap_8
XFILLER_182_37 VDD VDD VSS VSS gf180mcu_as_sc_mcu7t3v3__fillcap_8
XFILLER_8_1011 VDD VDD VSS VSS gf180mcu_as_sc_mcu7t3v3__fillcap_4
XFILLER_8_1033 VDD VDD VSS VSS gf180mcu_as_sc_mcu7t3v3__fillcap_16
XFILLER_207_408 VDD VDD VSS VSS gf180mcu_as_sc_mcu7t3v3__fill_1
XFILLER_216_942 VDD VDD VSS VSS gf180mcu_as_sc_mcu7t3v3__fill_2
XPHY_EDGE_ROW_75_3_Right_155 VDD VSS gf180mcu_as_sc_mcu7t3v3__tap_2
XFILLER_199_142 VDD VDD VSS VSS gf180mcu_as_sc_mcu7t3v3__fillcap_16
XFILLER_203_636 VDD VDD VSS VSS gf180mcu_as_sc_mcu7t3v3__fill_2
XFILLER_215_496 VDD VDD VSS VSS gf180mcu_as_sc_mcu7t3v3__fill_2
XFILLER_91_45 VDD VDD VSS VSS gf180mcu_as_sc_mcu7t3v3__fillcap_4
XFILLER_163_1249 VDD VDD VSS VSS gf180mcu_as_sc_mcu7t3v3__fillcap_4
XFILLER_199_197 VDD VDD VSS VSS gf180mcu_as_sc_mcu7t3v3__fill_2
XTAP_TAPCELL_ROW_194_2232 VDD VSS gf180mcu_as_sc_mcu7t3v3__tap_2
XFILLER_155_212 VDD VDD VSS VSS gf180mcu_as_sc_mcu7t3v3__fillcap_16
XFILLER_210_190 VDD VDD VSS VSS gf180mcu_as_sc_mcu7t3v3__fill_1
XTAP_TAPCELL_ROW_155_1526 VDD VSS gf180mcu_as_sc_mcu7t3v3__tap_2
XTAP_TAPCELL_ROW_155_1537 VDD VSS gf180mcu_as_sc_mcu7t3v3__tap_2
XFILLER_109_651 VDD VDD VSS VSS gf180mcu_as_sc_mcu7t3v3__fill_1
XFILLER_10_295 VDD VDD VSS VSS gf180mcu_as_sc_mcu7t3v3__fillcap_16
XTAP_TAPCELL_ROW_172_1840 VDD VSS gf180mcu_as_sc_mcu7t3v3__tap_2
XFILLER_164_790 VDD VDD VSS VSS gf180mcu_as_sc_mcu7t3v3__fillcap_4
XTAP_TAPCELL_ROW_213_2582 VDD VSS gf180mcu_as_sc_mcu7t3v3__tap_2
XTAP_TAPCELL_ROW_213_2571 VDD VSS gf180mcu_as_sc_mcu7t3v3__tap_2
XFILLER_124_665 VDD VDD VSS VSS gf180mcu_as_sc_mcu7t3v3__fill_2
XFILLER_152_963 VDD VDD VSS VSS gf180mcu_as_sc_mcu7t3v3__fillcap_16
XFILLER_3_962 VDD VDD VSS VSS gf180mcu_as_sc_mcu7t3v3__fillcap_16
XFILLER_2_494 VDD VDD VSS VSS gf180mcu_as_sc_mcu7t3v3__fillcap_4
XPHY_EDGE_ROW_91_1_Left_319 VDD VSS gf180mcu_as_sc_mcu7t3v3__tap_2
XTAP_TAPCELL_ROW_14_1257 VDD VSS gf180mcu_as_sc_mcu7t3v3__tap_2
XTAP_TAPCELL_ROW_14_1268 VDD VSS gf180mcu_as_sc_mcu7t3v3__tap_2
XFILLER_1_43 VDD VDD VSS VSS gf180mcu_as_sc_mcu7t3v3__fillcap_16
XTAP_TAPCELL_ROW_134_1_1388 VDD VSS gf180mcu_as_sc_mcu7t3v3__tap_2
XFILLER_20_1245 VDD VDD VSS VSS gf180mcu_as_sc_mcu7t3v3__fillcap_16
X_5880_ VDD VDD VSS VSS _5880_/A _5951_/D _5880_/C _5880_/D _5882_/C gf180mcu_as_sc_mcu7t3v3__ao211_2
X_4900_ VDD VDD VSS VSS _5891_/A _4955_/B _4900_/C _4900_/D _4901_/C gf180mcu_as_sc_mcu7t3v3__ao211_2
XFILLER_179_838 VDD VDD VSS VSS gf180mcu_as_sc_mcu7t3v3__fill_2
X_4831_ VDD VDD VSS VSS _5177_/A _4888_/B _4831_/C _4832_/D _4960_/B gf180mcu_as_sc_mcu7t3v3__aoi211_2
XFILLER_14_590 VDD VDD VSS VSS gf180mcu_as_sc_mcu7t3v3__fillcap_4
XFILLER_159_562 VDD VDD VSS VSS gf180mcu_as_sc_mcu7t3v3__fillcap_4
X_4762_ VDD VDD VSS VSS _4876_/B _5773_/A _4763_/C gf180mcu_as_sc_mcu7t3v3__and2_2
XFILLER_186_381 VDD VDD VSS VSS gf180mcu_as_sc_mcu7t3v3__fillcap_4
XFILLER_193_329 VDD VDD VSS VSS gf180mcu_as_sc_mcu7t3v3__fill_1
X_6501_ VDD VDD VSS VSS _6518_/CLK _6501_/D _6501_/Q gf180mcu_as_sc_mcu7t3v3__dfxtp_2
X_4693_ VDD VDD VSS VSS _4694_/B _5706_/A _4932_/A _4693_/C gf180mcu_as_sc_mcu7t3v3__ao21_2
X_3713_ VDD VDD VSS VSS _4026_/B _5721_/A _3810_/B _3713_/C gf180mcu_as_sc_mcu7t3v3__ao21_2
XFILLER_14_1049 VDD VDD VSS VSS gf180mcu_as_sc_mcu7t3v3__fillcap_16
X_6432_ VDD VDD VSS VSS _6448_/CLK _6432_/D _6432_/Q gf180mcu_as_sc_mcu7t3v3__dfxtp_2
X_3644_ VDD VDD VSS VSS _3655_/A _3653_/D _3644_/B _3644_/C _5963_/A gf180mcu_as_sc_mcu7t3v3__ao31_2
XFILLER_220_1081 VDD VDD VSS VSS gf180mcu_as_sc_mcu7t3v3__fillcap_4
Xmax_cap921 VDD VDD VSS VSS fanout920/Y _4293_/S gf180mcu_as_sc_mcu7t3v3__clkbuff_12
XFILLER_115_632 VDD VDD VSS VSS gf180mcu_as_sc_mcu7t3v3__fill_1
X_6363_ VDD VDD VSS VSS _6368_/CLK _6363_/D _6363_/Q gf180mcu_as_sc_mcu7t3v3__dfxtp_2
Xmax_cap943 VDD VDD VSS VSS wire942/A fanout935/A gf180mcu_as_sc_mcu7t3v3__clkbuff_12
X_3575_ VDD VDD VSS VSS _3583_/B _3598_/B _5921_/D gf180mcu_as_sc_mcu7t3v3__nand2b_2
XPHY_EDGE_ROW_81_1_Right_653 VDD VSS gf180mcu_as_sc_mcu7t3v3__tap_2
X_6294_ VDD VDD VSS VSS clkload5/A _6294_/D _6294_/Q gf180mcu_as_sc_mcu7t3v3__dfxtp_2
X_5314_ VDD VDD VSS VSS _5314_/S _5953_/D _5314_/A _5315_/D gf180mcu_as_sc_mcu7t3v3__mux2_2
XFILLER_130_624 VDD VDD VSS VSS gf180mcu_as_sc_mcu7t3v3__fill_2
X_5245_ VDD VDD VSS VSS _5296_/C _5890_/A _5245_/A _5246_/D gf180mcu_as_sc_mcu7t3v3__mux2_2
XFILLER_152_18 VDD VDD VSS VSS gf180mcu_as_sc_mcu7t3v3__fillcap_16
XFILLER_216_85 VDD VDD VSS VSS gf180mcu_as_sc_mcu7t3v3__fillcap_16
X_5176_ VDD VDD VSS VSS _5178_/C _5829_/A _5242_/B _5176_/C gf180mcu_as_sc_mcu7t3v3__ao21_2
XFILLER_151_1186 VDD VDD VSS VSS gf180mcu_as_sc_mcu7t3v3__fillcap_4
XFILLER_186_1205 VDD VDD VSS VSS gf180mcu_as_sc_mcu7t3v3__fillcap_16
XPHY_EDGE_ROW_3_Left_232 VDD VSS gf180mcu_as_sc_mcu7t3v3__tap_2
X_4127_ VDD VDD VSS VSS _4143_/S _6177_/Q _6176_/Q _6176_/D gf180mcu_as_sc_mcu7t3v3__mux2_2
XFILLER_186_1227 VDD VDD VSS VSS gf180mcu_as_sc_mcu7t3v3__fillcap_8
XFILLER_44_619 VDD VDD VSS VSS gf180mcu_as_sc_mcu7t3v3__fillcap_8
X_4058_ VDD VDD VSS VSS _5960_/C _4058_/B _6129_/Q _6129_/D gf180mcu_as_sc_mcu7t3v3__mux2_2
X_3009_ VDD VDD VSS VSS _5339_/A _5319_/D gf180mcu_as_sc_mcu7t3v3__inv_2
XFILLER_196_101 VDD VDD VSS VSS gf180mcu_as_sc_mcu7t3v3__fillcap_4
XFILLER_227_1224 VDD VDD VSS VSS gf180mcu_as_sc_mcu7t3v3__fillcap_16
XFILLER_52_663 VDD VDD VSS VSS gf180mcu_as_sc_mcu7t3v3__fillcap_4
XTAP_TAPCELL_ROW_0_987 VDD VSS gf180mcu_as_sc_mcu7t3v3__tap_2
XTAP_TAPCELL_ROW_0_998 VDD VSS gf180mcu_as_sc_mcu7t3v3__tap_2
XFILLER_12_527 VDD VDD VSS VSS gf180mcu_as_sc_mcu7t3v3__fillcap_16
XFILLER_169_348 VDD VDD VSS VSS gf180mcu_as_sc_mcu7t3v3__fill_2
XFILLER_212_488 VDD VDD VSS VSS gf180mcu_as_sc_mcu7t3v3__fill_1
XFILLER_177_392 VDD VDD VSS VSS gf180mcu_as_sc_mcu7t3v3__fillcap_4
XFILLER_193_863 VDD VDD VSS VSS gf180mcu_as_sc_mcu7t3v3__fill_1
XTAP_TAPCELL_ROW_150_1434 VDD VSS gf180mcu_as_sc_mcu7t3v3__tap_2
XFILLER_121_602 VDD VDD VSS VSS gf180mcu_as_sc_mcu7t3v3__fillcap_4
XFILLER_193_69 VDD VDD VSS VSS gf180mcu_as_sc_mcu7t3v3__fill_1
XTAP_TAPCELL_ROW_150_1445 VDD VSS gf180mcu_as_sc_mcu7t3v3__tap_2
Xfanout1004 VDD VDD VSS VSS fanout1004/A _5843_/D gf180mcu_as_sc_mcu7t3v3__buff_12
XFILLER_82_1261 VDD VDD VSS VSS gf180mcu_as_sc_mcu7t3v3__fillcap_4
XFILLER_86_45 VDD VDD VSS VSS gf180mcu_as_sc_mcu7t3v3__fillcap_4
Xoutput390 VDD VDD VSS VSS _6357_/Q north_out[16] gf180mcu_as_sc_mcu7t3v3__buff_12
XFILLER_130_1226 VDD VDD VSS VSS gf180mcu_as_sc_mcu7t3v3__fillcap_16
XFILLER_16_800 VDD VDD VSS VSS gf180mcu_as_sc_mcu7t3v3__fillcap_16
XTAP_TAPCELL_ROW_118_1_1380 VDD VSS gf180mcu_as_sc_mcu7t3v3__tap_2
XFILLER_16_822 VDD VDD VSS VSS gf180mcu_as_sc_mcu7t3v3__fillcap_16
XFILLER_203_422 VDD VDD VSS VSS gf180mcu_as_sc_mcu7t3v3__fill_2
XFILLER_215_282 VDD VDD VSS VSS gf180mcu_as_sc_mcu7t3v3__fillcap_4
XFILLER_222_219 VDD VDD VSS VSS gf180mcu_as_sc_mcu7t3v3__fill_1
XPHY_EDGE_ROW_76_3_Right_156 VDD VSS gf180mcu_as_sc_mcu7t3v3__tap_2
XFILLER_163_1046 VDD VDD VSS VSS gf180mcu_as_sc_mcu7t3v3__fillcap_4
XFILLER_163_1068 VDD VDD VSS VSS gf180mcu_as_sc_mcu7t3v3__fillcap_16
XFILLER_176_819 VDD VDD VSS VSS gf180mcu_as_sc_mcu7t3v3__fill_1
XFILLER_168_381 VDD VDD VSS VSS gf180mcu_as_sc_mcu7t3v3__fillcap_4
XTAP_TAPCELL_ROW_215_2611 VDD VSS gf180mcu_as_sc_mcu7t3v3__tap_2
XFILLER_11_582 VDD VDD VSS VSS gf180mcu_as_sc_mcu7t3v3__fill_2
XFILLER_204_1065 VDD VDD VSS VSS gf180mcu_as_sc_mcu7t3v3__fillcap_16
XFILLER_204_1087 VDD VDD VSS VSS gf180mcu_as_sc_mcu7t3v3__fillcap_16
Xwire495 VDD VDD VSS VSS _5307_/Y _6410_/D gf180mcu_as_sc_mcu7t3v3__clkbuff_12
X_3360_ VDD VDD VSS VSS _3360_/B _3360_/A _3362_/B gf180mcu_as_sc_mcu7t3v3__or2_2
XTAP_TAPCELL_ROW_16_1308 VDD VSS gf180mcu_as_sc_mcu7t3v3__tap_2
XTAP_TAPCELL_ROW_16_1319 VDD VSS gf180mcu_as_sc_mcu7t3v3__tap_2
XFILLER_170_1017 VDD VDD VSS VSS gf180mcu_as_sc_mcu7t3v3__fillcap_16
XFILLER_183_80 VDD VDD VSS VSS gf180mcu_as_sc_mcu7t3v3__fillcap_4
X_5030_ VDD VDD VSS VSS _5699_/B _5141_/B _5030_/C _5030_/D _5031_/B gf180mcu_as_sc_mcu7t3v3__ao22_2
X_3291_ VDD VDD VSS VSS _3291_/Y _3291_/C _3291_/B _3291_/A gf180mcu_as_sc_mcu7t3v3__aoi21b_2
XFILLER_211_1014 VDD VDD VSS VSS gf180mcu_as_sc_mcu7t3v3__fillcap_16
Xhold1209 VDD VDD VSS VSS hold1233/Y _6548_/D gf180mcu_as_sc_mcu7t3v3__clkbuff_4
XFILLER_226_536 VDD VDD VSS VSS gf180mcu_as_sc_mcu7t3v3__fill_1
XFILLER_207_761 VDD VDD VSS VSS gf180mcu_as_sc_mcu7t3v3__fill_2
XFILLER_207_772 VDD VDD VSS VSS gf180mcu_as_sc_mcu7t3v3__fill_2
XPHY_EDGE_ROW_130_3_Left_835 VDD VSS gf180mcu_as_sc_mcu7t3v3__tap_2
X_5932_ VDD VDD VSS VSS _5932_/A _5953_/C _5932_/C _5932_/D _5933_/D gf180mcu_as_sc_mcu7t3v3__ao211_2
XFILLER_0_1169 VDD VDD VSS VSS gf180mcu_as_sc_mcu7t3v3__fillcap_4
XTAP_TAPCELL_ROW_68_1_1355 VDD VSS gf180mcu_as_sc_mcu7t3v3__tap_2
XFILLER_178_123 VDD VDD VSS VSS gf180mcu_as_sc_mcu7t3v3__fillcap_8
X_5863_ VDD VDD VSS VSS _5863_/A _5871_/B _5863_/C _5871_/D _5864_/D gf180mcu_as_sc_mcu7t3v3__ao22_2
XFILLER_222_797 VDD VDD VSS VSS gf180mcu_as_sc_mcu7t3v3__fillcap_8
XTAP_TAPCELL_ROW_124_3_3035 VDD VSS gf180mcu_as_sc_mcu7t3v3__tap_2
X_5794_ VDD VDD VSS VSS _5794_/A _5802_/B _5794_/C _5794_/D _5795_/B gf180mcu_as_sc_mcu7t3v3__ao211_2
X_4814_ VDD VDD VSS VSS _5817_/A _4871_/B _4871_/C _5817_/D _4815_/D gf180mcu_as_sc_mcu7t3v3__ao22_2
XFILLER_166_329 VDD VDD VSS VSS gf180mcu_as_sc_mcu7t3v3__fillcap_8
X_4745_ VDD VDD VSS VSS _5761_/D _4858_/B _4745_/C _4746_/B _4747_/C gf180mcu_as_sc_mcu7t3v3__ao211_2
XFILLER_174_340 VDD VDD VSS VSS gf180mcu_as_sc_mcu7t3v3__fill_2
XFILLER_31_18 VDD VDD VSS VSS gf180mcu_as_sc_mcu7t3v3__fill_2
X_4676_ VDD VDD VSS VSS _5694_/A _4796_/B _4676_/C _4794_/S _4677_/D gf180mcu_as_sc_mcu7t3v3__ao22_2
XFILLER_190_833 VDD VDD VSS VSS gf180mcu_as_sc_mcu7t3v3__fill_1
X_6415_ VDD VDD VSS VSS _6422_/CLK _6415_/D _6415_/Q gf180mcu_as_sc_mcu7t3v3__dfxtp_2
X_3627_ VDD VDD VSS VSS _3639_/A _5940_/A _4648_/C _3628_/B _4648_/A gf180mcu_as_sc_mcu7t3v3__aoi211_2
X_6346_ VDD VDD VSS VSS _6517_/CLK _6346_/D _6346_/Q gf180mcu_as_sc_mcu7t3v3__dfxtp_2
X_3558_ VDD VDD VSS VSS _3558_/B _3558_/A _5328_/B gf180mcu_as_sc_mcu7t3v3__or2_2
XTAP_TAPCELL_ROW_41_2_2910 VDD VSS gf180mcu_as_sc_mcu7t3v3__tap_2
XFILLER_0_206 VDD VDD VSS VSS gf180mcu_as_sc_mcu7t3v3__fillcap_4
XFILLER_66_1245 VDD VDD VSS VSS gf180mcu_as_sc_mcu7t3v3__fillcap_16
XPHY_EDGE_ROW_82_1_Right_654 VDD VSS gf180mcu_as_sc_mcu7t3v3__tap_2
Xinput107 VDD VDD VSS VSS ne_in[29] _5914_/D gf180mcu_as_sc_mcu7t3v3__buff_12
Xinput118 VDD VDD VSS VSS ne_in[6] _5723_/A gf180mcu_as_sc_mcu7t3v3__buff_12
X_6277_ VDD VDD VSS VSS _6552_/CLK _6277_/D _6277_/Q gf180mcu_as_sc_mcu7t3v3__dfxtp_2
X_3489_ VDD VDD VSS VSS _3638_/A _5953_/D _3489_/C _3492_/C _3489_/D gf180mcu_as_sc_mcu7t3v3__oai211_2
XFILLER_5_1014 VDD VDD VSS VSS gf180mcu_as_sc_mcu7t3v3__fillcap_16
Xinput129 VDD VDD VSS VSS north_in[16] _5806_/B gf180mcu_as_sc_mcu7t3v3__buff_12
X_5228_ VDD VDD VSS VSS _5228_/S _5875_/A _5228_/A _5229_/B gf180mcu_as_sc_mcu7t3v3__mux2_2
XFILLER_56_37 VDD VDD VSS VSS gf180mcu_as_sc_mcu7t3v3__fillcap_8
X_5159_ VDD VDD VSS VSS _5160_/D _5234_/B _5195_/B _5159_/A gf180mcu_as_sc_mcu7t3v3__aoi21_2
XTAP_TAPCELL_ROW_40_1_1341 VDD VSS gf180mcu_as_sc_mcu7t3v3__tap_2
XPHY_EDGE_ROW_62_3_Left_767 VDD VSS gf180mcu_as_sc_mcu7t3v3__tap_2
XFILLER_198_900 VDD VDD VSS VSS gf180mcu_as_sc_mcu7t3v3__fillcap_16
XFILLER_198_944 VDD VDD VSS VSS gf180mcu_as_sc_mcu7t3v3__fill_1
XFILLER_13_858 VDD VDD VSS VSS gf180mcu_as_sc_mcu7t3v3__fillcap_16
XFILLER_197_443 VDD VDD VSS VSS gf180mcu_as_sc_mcu7t3v3__fill_1
XFILLER_40_633 VDD VDD VSS VSS gf180mcu_as_sc_mcu7t3v3__fill_1
XFILLER_184_115 VDD VDD VSS VSS gf180mcu_as_sc_mcu7t3v3__fillcap_4
XFILLER_40_655 VDD VDD VSS VSS gf180mcu_as_sc_mcu7t3v3__fillcap_8
XFILLER_8_317 VDD VDD VSS VSS gf180mcu_as_sc_mcu7t3v3__fillcap_16
XFILLER_184_159 VDD VDD VSS VSS gf180mcu_as_sc_mcu7t3v3__fillcap_8
XFILLER_181_822 VDD VDD VSS VSS gf180mcu_as_sc_mcu7t3v3__fillcap_4
XFILLER_197_1186 VDD VDD VSS VSS gf180mcu_as_sc_mcu7t3v3__fillcap_4
XTAP_TAPCELL_ROW_210_2530 VDD VSS gf180mcu_as_sc_mcu7t3v3__tap_2
XTAP_TAPCELL_ROW_189_2142 VDD VSS gf180mcu_as_sc_mcu7t3v3__tap_2
XPHY_EDGE_ROW_103_1_Left_331 VDD VSS gf180mcu_as_sc_mcu7t3v3__tap_2
XFILLER_153_72 VDD VDD VSS VSS gf180mcu_as_sc_mcu7t3v3__fillcap_16
XTAP_TAPCELL_ROW_11_1205 VDD VSS gf180mcu_as_sc_mcu7t3v3__tap_2
XTAP_TAPCELL_ROW_11_1216 VDD VSS gf180mcu_as_sc_mcu7t3v3__tap_2
XTAP_TAPCELL_ROW_167_1750 VDD VSS gf180mcu_as_sc_mcu7t3v3__tap_2
XTAP_TAPCELL_ROW_208_2492 VDD VSS gf180mcu_as_sc_mcu7t3v3__tap_2
XTAP_TAPCELL_ROW_208_2481 VDD VSS gf180mcu_as_sc_mcu7t3v3__tap_2
XFILLER_208_569 VDD VDD VSS VSS gf180mcu_as_sc_mcu7t3v3__fill_1
XTAP_TAPCELL_ROW_163_1669 VDD VSS gf180mcu_as_sc_mcu7t3v3__tap_2
XTAP_TAPCELL_ROW_180_1983 VDD VSS gf180mcu_as_sc_mcu7t3v3__tap_2
XFILLER_188_432 VDD VDD VSS VSS gf180mcu_as_sc_mcu7t3v3__fillcap_8
XFILLER_189_944 VDD VDD VSS VSS gf180mcu_as_sc_mcu7t3v3__fill_1
XFILLER_204_764 VDD VDD VSS VSS gf180mcu_as_sc_mcu7t3v3__fill_1
XPHY_EDGE_ROW_77_3_Right_157 VDD VSS gf180mcu_as_sc_mcu7t3v3__tap_2
XFILLER_15_1100 VDD VDD VSS VSS gf180mcu_as_sc_mcu7t3v3__fillcap_16
XFILLER_15_1122 VDD VDD VSS VSS gf180mcu_as_sc_mcu7t3v3__fillcap_16
XFILLER_175_104 VDD VDD VSS VSS gf180mcu_as_sc_mcu7t3v3__fillcap_16
XFILLER_31_666 VDD VDD VSS VSS gf180mcu_as_sc_mcu7t3v3__fill_1
XFILLER_106_1261 VDD VDD VSS VSS gf180mcu_as_sc_mcu7t3v3__fillcap_4
XFILLER_89_1212 VDD VDD VSS VSS gf180mcu_as_sc_mcu7t3v3__fill_1
XFILLER_190_107 VDD VDD VSS VSS gf180mcu_as_sc_mcu7t3v3__fillcap_4
X_4530_ VDD VDD VSS VSS _4538_/S _4530_/B _6142_/Q _6295_/D gf180mcu_as_sc_mcu7t3v3__mux2_2
XFILLER_156_384 VDD VDD VSS VSS gf180mcu_as_sc_mcu7t3v3__fill_1
X_4461_ VDD VDD VSS VSS _4546_/B _6721_/A _6271_/Q _6271_/D gf180mcu_as_sc_mcu7t3v3__mux2_2
XFILLER_176_1259 VDD VDD VSS VSS gf180mcu_as_sc_mcu7t3v3__fill_2
XPHY_EDGE_ROW_35_1_Left_263 VDD VSS gf180mcu_as_sc_mcu7t3v3__tap_2
X_6200_ VDD VDD VSS VSS _6526_/CLK _6200_/D _6200_/Q gf180mcu_as_sc_mcu7t3v3__dfxtp_2
X_3412_ VDD VDD VSS VSS _3413_/D _6272_/Q _4466_/A _3412_/C gf180mcu_as_sc_mcu7t3v3__ao21_2
X_6131_ VDD VDD VSS VSS _6486_/CLK _6131_/D _6131_/Q gf180mcu_as_sc_mcu7t3v3__dfxtp_2
X_4392_ VDD VDD VSS VSS _6224_/Q _4399_/B _4399_/C _6225_/Q _4393_/C gf180mcu_as_sc_mcu7t3v3__ao22_2
XFILLER_217_1256 VDD VDD VSS VSS gf180mcu_as_sc_mcu7t3v3__fillcap_4
Xfanout808 VDD VDD VSS VSS _3658_/Y _3868_/C gf180mcu_as_sc_mcu7t3v3__buff_12
Xfanout819 VDD VDD VSS VSS _5205_/B _5195_/B gf180mcu_as_sc_mcu7t3v3__buff_12
X_3343_ VDD VDD VSS VSS _3343_/B _3343_/A _3346_/C gf180mcu_as_sc_mcu7t3v3__or2_2
XPHY_EDGE_ROW_209_Left_437 VDD VSS gf180mcu_as_sc_mcu7t3v3__tap_2
X_6062_ VDD VDD VSS VSS _6519_/CLK _6062_/D _6062_/Q gf180mcu_as_sc_mcu7t3v3__dfxtp_2
X_3274_ VDD VDD VSS VSS _3275_/B _3274_/A gf180mcu_as_sc_mcu7t3v3__inv_2
XTAP_TAPCELL_ROW_228_2868 VDD VSS gf180mcu_as_sc_mcu7t3v3__tap_2
XTAP_TAPCELL_ROW_228_2857 VDD VSS gf180mcu_as_sc_mcu7t3v3__tap_2
XTAP_TAPCELL_ROW_228_2846 VDD VSS gf180mcu_as_sc_mcu7t3v3__tap_2
XFILLER_113_1210 VDD VDD VSS VSS gf180mcu_as_sc_mcu7t3v3__fillcap_4
XFILLER_227_812 VDD VDD VSS VSS gf180mcu_as_sc_mcu7t3v3__fill_1
X_5013_ VDD VDD VSS VSS _6494_/Q _5086_/B _5013_/C _5013_/D _5015_/C gf180mcu_as_sc_mcu7t3v3__ao22_2
XFILLER_226_366 VDD VDD VSS VSS gf180mcu_as_sc_mcu7t3v3__fillcap_4
XFILLER_183_1208 VDD VDD VSS VSS gf180mcu_as_sc_mcu7t3v3__fillcap_16
XFILLER_226_399 VDD VDD VSS VSS gf180mcu_as_sc_mcu7t3v3__fill_2
XPHY_EDGE_ROW_5_Right_5 VDD VSS gf180mcu_as_sc_mcu7t3v3__tap_2
X_5915_ VDD VDD VSS VSS _5915_/A _5952_/B _5915_/C _5915_/D _5916_/C gf180mcu_as_sc_mcu7t3v3__ao211_2
XFILLER_224_1205 VDD VDD VSS VSS gf180mcu_as_sc_mcu7t3v3__fillcap_16
XFILLER_224_1227 VDD VDD VSS VSS gf180mcu_as_sc_mcu7t3v3__fillcap_16
XPHY_EDGE_ROW_218_Left_446 VDD VSS gf180mcu_as_sc_mcu7t3v3__tap_2
X_5846_ VDD VDD VSS VSS _5878_/S _5846_/B _6514_/Q _5847_/C gf180mcu_as_sc_mcu7t3v3__mux2_2
XFILLER_166_104 VDD VDD VSS VSS gf180mcu_as_sc_mcu7t3v3__fill_1
XFILLER_167_627 VDD VDD VSS VSS gf180mcu_as_sc_mcu7t3v3__fill_2
XFILLER_210_734 VDD VDD VSS VSS gf180mcu_as_sc_mcu7t3v3__fill_1
XFILLER_10_839 VDD VDD VSS VSS gf180mcu_as_sc_mcu7t3v3__fillcap_16
XFILLER_194_435 VDD VDD VSS VSS gf180mcu_as_sc_mcu7t3v3__fill_2
XFILLER_194_457 VDD VDD VSS VSS gf180mcu_as_sc_mcu7t3v3__fillcap_4
Xclkbuf_leaf_13_clk_regs VDD VDD VSS VSS clkbuf_3_2_0_clk_regs/Y _6546_/CLK gf180mcu_as_sc_mcu7t3v3__clkbuff_12
X_5777_ VDD VDD VSS VSS _5777_/A _5874_/B _5777_/C _5777_/D _5778_/C gf180mcu_as_sc_mcu7t3v3__ao211_2
X_4728_ VDD VDD VSS VSS _4729_/D _4860_/B _4746_/B _5742_/A gf180mcu_as_sc_mcu7t3v3__aoi21b_2
X_4659_ VDD VDD VSS VSS _6012_/A _4659_/A _4883_/A _4659_/C _4660_/C gf180mcu_as_sc_mcu7t3v3__ao31_2
XFILLER_162_354 VDD VDD VSS VSS gf180mcu_as_sc_mcu7t3v3__fillcap_4
XFILLER_150_527 VDD VDD VSS VSS gf180mcu_as_sc_mcu7t3v3__fillcap_4
XFILLER_162_398 VDD VDD VSS VSS gf180mcu_as_sc_mcu7t3v3__fillcap_16
XPHY_EDGE_ROW_227_Left_455 VDD VSS gf180mcu_as_sc_mcu7t3v3__tap_2
XFILLER_107_43 VDD VDD VSS VSS gf180mcu_as_sc_mcu7t3v3__fillcap_8
XFILLER_157_1170 VDD VDD VSS VSS gf180mcu_as_sc_mcu7t3v3__fillcap_16
XFILLER_157_1192 VDD VDD VSS VSS gf180mcu_as_sc_mcu7t3v3__fillcap_16
XFILLER_89_666 VDD VDD VSS VSS gf180mcu_as_sc_mcu7t3v3__fill_1
X_6329_ VDD VDD VSS VSS _6552_/CLK _6329_/D _6329_/Q gf180mcu_as_sc_mcu7t3v3__dfxtp_2
XPHY_EDGE_ROW_83_1_Right_655 VDD VSS gf180mcu_as_sc_mcu7t3v3__tap_2
XTAP_TAPCELL_ROW_184_2050 VDD VSS gf180mcu_as_sc_mcu7t3v3__tap_2
XFILLER_190_37 VDD VDD VSS VSS gf180mcu_as_sc_mcu7t3v3__fillcap_16
XTAP_TAPCELL_ROW_184_2061 VDD VSS gf180mcu_as_sc_mcu7t3v3__tap_2
XFILLER_188_1119 VDD VDD VSS VSS gf180mcu_as_sc_mcu7t3v3__fillcap_16
XFILLER_217_311 VDD VDD VSS VSS gf180mcu_as_sc_mcu7t3v3__fill_1
XTAP_TAPCELL_ROW_8_1159 VDD VSS gf180mcu_as_sc_mcu7t3v3__tap_2
XFILLER_83_24 VDD VDD VSS VSS gf180mcu_as_sc_mcu7t3v3__fillcap_8
XFILLER_16_95 VDD VDD VSS VSS gf180mcu_as_sc_mcu7t3v3__fillcap_4
XFILLER_198_741 VDD VDD VSS VSS gf180mcu_as_sc_mcu7t3v3__fill_2
XFILLER_13_655 VDD VDD VSS VSS gf180mcu_as_sc_mcu7t3v3__fillcap_8
XFILLER_13_677 VDD VDD VSS VSS gf180mcu_as_sc_mcu7t3v3__fill_1
XFILLER_157_104 VDD VDD VSS VSS gf180mcu_as_sc_mcu7t3v3__fillcap_16
XFILLER_186_947 VDD VDD VSS VSS gf180mcu_as_sc_mcu7t3v3__fillcap_16
XFILLER_213_594 VDD VDD VSS VSS gf180mcu_as_sc_mcu7t3v3__fillcap_4
XFILLER_13_688 VDD VDD VSS VSS gf180mcu_as_sc_mcu7t3v3__fill_1
XFILLER_160_1049 VDD VDD VSS VSS gf180mcu_as_sc_mcu7t3v3__fillcap_16
XFILLER_185_446 VDD VDD VSS VSS gf180mcu_as_sc_mcu7t3v3__fill_1
XFILLER_201_767 VDD VDD VSS VSS gf180mcu_as_sc_mcu7t3v3__fill_2
XFILLER_201_778 VDD VDD VSS VSS gf180mcu_as_sc_mcu7t3v3__fill_1
XFILLER_9_648 VDD VDD VSS VSS gf180mcu_as_sc_mcu7t3v3__fill_1
XFILLER_172_107 VDD VDD VSS VSS gf180mcu_as_sc_mcu7t3v3__fillcap_16
XFILLER_201_1046 VDD VDD VSS VSS gf180mcu_as_sc_mcu7t3v3__fillcap_4
XFILLER_201_1068 VDD VDD VSS VSS gf180mcu_as_sc_mcu7t3v3__fillcap_16
XFILLER_180_140 VDD VDD VSS VSS gf180mcu_as_sc_mcu7t3v3__fillcap_8
XFILLER_136_1210 VDD VDD VSS VSS gf180mcu_as_sc_mcu7t3v3__fillcap_8
XFILLER_4_364 VDD VDD VSS VSS gf180mcu_as_sc_mcu7t3v3__fill_2
XFILLER_5_876 VDD VDD VSS VSS gf180mcu_as_sc_mcu7t3v3__fill_1
XFILLER_136_1232 VDD VDD VSS VSS gf180mcu_as_sc_mcu7t3v3__fillcap_8
XFILLER_95_647 VDD VDD VSS VSS gf180mcu_as_sc_mcu7t3v3__fillcap_4
XTAP_TAPCELL_ROW_165_1709 VDD VSS gf180mcu_as_sc_mcu7t3v3__tap_2
XFILLER_208_300 VDD VDD VSS VSS gf180mcu_as_sc_mcu7t3v3__fill_2
XFILLER_209_856 VDD VDD VSS VSS gf180mcu_as_sc_mcu7t3v3__fill_2
XTAP_TAPCELL_ROW_223_2754 VDD VSS gf180mcu_as_sc_mcu7t3v3__tap_2
XFILLER_169_1052 VDD VDD VSS VSS gf180mcu_as_sc_mcu7t3v3__fillcap_16
XFILLER_16_460 VDD VDD VSS VSS gf180mcu_as_sc_mcu7t3v3__fillcap_16
XFILLER_1_1264 VDD VDD VSS VSS gf180mcu_as_sc_mcu7t3v3__fill_1
XFILLER_223_336 VDD VDD VSS VSS gf180mcu_as_sc_mcu7t3v3__fill_2
X_3961_ VDD VDD VSS VSS _3975_/C _6062_/Q _3962_/D gf180mcu_as_sc_mcu7t3v3__and2_2
XFILLER_16_482 VDD VDD VSS VSS gf180mcu_as_sc_mcu7t3v3__fill_2
XFILLER_189_774 VDD VDD VSS VSS gf180mcu_as_sc_mcu7t3v3__fill_1
X_5700_ VDD VDD VSS VSS _5700_/A _5799_/B _5700_/C _5799_/D _5701_/D gf180mcu_as_sc_mcu7t3v3__ao22_2
XFILLER_176_413 VDD VDD VSS VSS gf180mcu_as_sc_mcu7t3v3__fillcap_8
XPHY_EDGE_ROW_78_3_Right_158 VDD VSS gf180mcu_as_sc_mcu7t3v3__tap_2
X_3892_ VDD VDD VSS VSS _5869_/A _3892_/B _3912_/B _3892_/D _3894_/A gf180mcu_as_sc_mcu7t3v3__ao211_2
XFILLER_143_1258 VDD VDD VSS VSS gf180mcu_as_sc_mcu7t3v3__fill_2
XFILLER_176_457 VDD VDD VSS VSS gf180mcu_as_sc_mcu7t3v3__fillcap_16
XFILLER_85_2 VDD VDD VSS VSS gf180mcu_as_sc_mcu7t3v3__fillcap_16
X_5631_ VDD VDD VSS VSS _6523_/Q _5631_/B _5638_/C _5943_/D _5633_/C gf180mcu_as_sc_mcu7t3v3__ao22_2
XFILLER_192_928 VDD VDD VSS VSS gf180mcu_as_sc_mcu7t3v3__fillcap_16
X_5562_ VDD VDD VSS VSS _5562_/B _5562_/A _6436_/D gf180mcu_as_sc_mcu7t3v3__and2_2
XFILLER_8_681 VDD VDD VSS VSS gf180mcu_as_sc_mcu7t3v3__fillcap_4
X_4513_ VDD VDD VSS VSS _4527_/S _6289_/Q _4513_/A _6289_/D gf180mcu_as_sc_mcu7t3v3__mux2_2
XFILLER_160_803 VDD VDD VSS VSS gf180mcu_as_sc_mcu7t3v3__fill_2
X_5493_ VDD VDD VSS VSS _5797_/A _5534_/S _5493_/C _5494_/B _5495_/C gf180mcu_as_sc_mcu7t3v3__ao211_2
XFILLER_208_53 VDD VDD VSS VSS gf180mcu_as_sc_mcu7t3v3__fillcap_16
X_4444_ VDD VDD VSS VSS _4445_/A _4444_/B _4444_/A gf180mcu_as_sc_mcu7t3v3__nor2_2
Xfanout605 VDD VDD VSS VSS _4964_/B _4957_/B gf180mcu_as_sc_mcu7t3v3__buff_12
X_4375_ VDD VDD VSS VSS _4376_/C _4398_/S _6035_/Q gf180mcu_as_sc_mcu7t3v3__nor2b_2
Xfanout616 VDD VDD VSS VSS _3649_/Y _3867_/B gf180mcu_as_sc_mcu7t3v3__buff_12
Xfanout627 VDD VDD VSS VSS _5315_/B _5217_/S gf180mcu_as_sc_mcu7t3v3__buff_12
Xfanout638 VDD VDD VSS VSS _3872_/B _3929_/B gf180mcu_as_sc_mcu7t3v3__buff_12
Xfanout649 VDD VDD VSS VSS _6525_/D _6006_/B gf180mcu_as_sc_mcu7t3v3__buff_12
X_6114_ VDD VDD VSS VSS _6370_/CLK _6114_/D _6114_/Q gf180mcu_as_sc_mcu7t3v3__dfxtp_2
X_3326_ VDD VDD VSS VSS _3326_/S _6536_/Q _6545_/Q _3327_/B gf180mcu_as_sc_mcu7t3v3__mux2_2
X_6045_ VDD VDD VSS VSS _6125_/CLK _6045_/D _6045_/Q gf180mcu_as_sc_mcu7t3v3__dfxtp_2
X_3257_ VDD VDD VSS VSS _3277_/B _3257_/B _3257_/C _3277_/C _3258_/C gf180mcu_as_sc_mcu7t3v3__ao211_2
XFILLER_160_18 VDD VDD VSS VSS gf180mcu_as_sc_mcu7t3v3__fillcap_16
XFILLER_2_1017 VDD VDD VSS VSS gf180mcu_as_sc_mcu7t3v3__fillcap_16
XTAP_TAPCELL_ROW_112_3_3017 VDD VSS gf180mcu_as_sc_mcu7t3v3__tap_2
X_3188_ VDD VDD VSS VSS _4158_/B _4281_/B _3212_/A gf180mcu_as_sc_mcu7t3v3__or2_2
XFILLER_199_527 VDD VDD VSS VSS gf180mcu_as_sc_mcu7t3v3__fillcap_4
XTAP_TAPCELL_ROW_3_1067 VDD VSS gf180mcu_as_sc_mcu7t3v3__tap_2
XFILLER_169_38 VDD VDD VSS VSS gf180mcu_as_sc_mcu7t3v3__fillcap_16
XFILLER_168_969 VDD VDD VSS VSS gf180mcu_as_sc_mcu7t3v3__fill_1
X_5829_ VDD VDD VSS VSS _5861_/B _5829_/A _5832_/C gf180mcu_as_sc_mcu7t3v3__and2_2
XFILLER_154_107 VDD VDD VSS VSS gf180mcu_as_sc_mcu7t3v3__fillcap_16
XFILLER_194_243 VDD VDD VSS VSS gf180mcu_as_sc_mcu7t3v3__fill_2
XFILLER_210_597 VDD VDD VSS VSS gf180mcu_as_sc_mcu7t3v3__fillcap_4
XFILLER_151_825 VDD VDD VSS VSS gf180mcu_as_sc_mcu7t3v3__fill_2
XPHY_EDGE_ROW_205_Right_73 VDD VSS gf180mcu_as_sc_mcu7t3v3__tap_2
XFILLER_151_858 VDD VDD VSS VSS gf180mcu_as_sc_mcu7t3v3__fill_2
XFILLER_190_1009 VDD VDD VSS VSS gf180mcu_as_sc_mcu7t3v3__fillcap_4
XFILLER_194_1189 VDD VDD VSS VSS gf180mcu_as_sc_mcu7t3v3__fillcap_16
XTAP_TAPCELL_ROW_182_2009 VDD VSS gf180mcu_as_sc_mcu7t3v3__tap_2
XPHY_EDGE_ROW_84_1_Right_656 VDD VSS gf180mcu_as_sc_mcu7t3v3__tap_2
XFILLER_94_45 VDD VDD VSS VSS gf180mcu_as_sc_mcu7t3v3__fillcap_4
Xmesh_tile_1059 VDD VDD VSS VSS ne_out[18] gf180mcu_as_sc_mcu7t3v3__tiel_4
Xmesh_tile_1048 VDD VDD VSS VSS ne_out[7] gf180mcu_as_sc_mcu7t3v3__tiel_4
XTAP_TAPCELL_ROW_205_2440 VDD VSS gf180mcu_as_sc_mcu7t3v3__tap_2
XTAP_TAPCELL_ROW_160_1617 VDD VSS gf180mcu_as_sc_mcu7t3v3__tap_2
XTAP_TAPCELL_ROW_160_1628 VDD VSS gf180mcu_as_sc_mcu7t3v3__tap_2
XPHY_EDGE_ROW_214_Right_82 VDD VSS gf180mcu_as_sc_mcu7t3v3__tap_2
XTAP_TAPCELL_ROW_201_2359 VDD VSS gf180mcu_as_sc_mcu7t3v3__tap_2
XFILLER_158_413 VDD VDD VSS VSS gf180mcu_as_sc_mcu7t3v3__fillcap_4
XFILLER_198_582 VDD VDD VSS VSS gf180mcu_as_sc_mcu7t3v3__fill_1
XTAP_TAPCELL_ROW_197_2296 VDD VSS gf180mcu_as_sc_mcu7t3v3__tap_2
XTAP_TAPCELL_ROW_197_2285 VDD VSS gf180mcu_as_sc_mcu7t3v3__tap_2
XFILLER_13_474 VDD VDD VSS VSS gf180mcu_as_sc_mcu7t3v3__fill_1
XFILLER_13_485 VDD VDD VSS VSS gf180mcu_as_sc_mcu7t3v3__fillcap_4
XFILLER_12_1103 VDD VDD VSS VSS gf180mcu_as_sc_mcu7t3v3__fillcap_16
XFILLER_139_660 VDD VDD VSS VSS gf180mcu_as_sc_mcu7t3v3__fill_2
XFILLER_158_468 VDD VDD VSS VSS gf180mcu_as_sc_mcu7t3v3__fillcap_16
XFILLER_186_799 VDD VDD VSS VSS gf180mcu_as_sc_mcu7t3v3__fillcap_4
XFILLER_201_586 VDD VDD VSS VSS gf180mcu_as_sc_mcu7t3v3__fillcap_4
XTAP_TAPCELL_ROW_158_1579 VDD VSS gf180mcu_as_sc_mcu7t3v3__tap_2
XTAP_TAPCELL_ROW_175_1893 VDD VSS gf180mcu_as_sc_mcu7t3v3__tap_2
XPHY_EDGE_ROW_223_Right_91 VDD VSS gf180mcu_as_sc_mcu7t3v3__tap_2
XFILLER_181_460 VDD VDD VSS VSS gf180mcu_as_sc_mcu7t3v3__fill_2
X_4160_ VDD VDD VSS VSS _6169_/Q _6170_/Q _4161_/C gf180mcu_as_sc_mcu7t3v3__or2_2
XFILLER_214_1259 VDD VDD VSS VSS gf180mcu_as_sc_mcu7t3v3__fillcap_4
X_3111_ VDD VDD VSS VSS _6227_/Q _6530_/Q _3423_/B gf180mcu_as_sc_mcu7t3v3__xnor2_2
XFILLER_23_1210 VDD VDD VSS VSS gf180mcu_as_sc_mcu7t3v3__fillcap_4
X_4091_ VDD VDD VSS VSS _4093_/S _6720_/A _6151_/Q _6151_/D gf180mcu_as_sc_mcu7t3v3__mux2_2
Xinput290 VDD VDD VSS VSS sw_in[30] _5612_/A gf180mcu_as_sc_mcu7t3v3__buff_12
X_3042_ VDD VDD VSS VSS _4480_/A _4509_/B gf180mcu_as_sc_mcu7t3v3__inv_2
XFILLER_208_163 VDD VDD VSS VSS gf180mcu_as_sc_mcu7t3v3__fillcap_4
XFILLER_224_678 VDD VDD VSS VSS gf180mcu_as_sc_mcu7t3v3__fillcap_4
X_4993_ VDD VDD VSS VSS _4996_/C _5676_/D _5242_/B _4993_/C gf180mcu_as_sc_mcu7t3v3__ao21_2
XFILLER_16_290 VDD VDD VSS VSS gf180mcu_as_sc_mcu7t3v3__fill_2
X_3944_ VDD VDD VSS VSS _3974_/B _6050_/Q _3945_/D gf180mcu_as_sc_mcu7t3v3__and2_2
XFILLER_177_755 VDD VDD VSS VSS gf180mcu_as_sc_mcu7t3v3__fillcap_4
XFILLER_221_1208 VDD VDD VSS VSS gf180mcu_as_sc_mcu7t3v3__fillcap_16
XPHY_EDGE_ROW_79_3_Right_159 VDD VSS gf180mcu_as_sc_mcu7t3v3__tap_2
X_3875_ VDD VDD VSS VSS _6038_/Q _3904_/B _4053_/B _3904_/D _6038_/D gf180mcu_as_sc_mcu7t3v3__ao22_2
X_5614_ VDD VDD VSS VSS _5614_/B _5643_/A _6443_/D gf180mcu_as_sc_mcu7t3v3__and2_2
XPHY_EDGE_ROW_71_3_Left_776 VDD VSS gf180mcu_as_sc_mcu7t3v3__tap_2
X_5545_ VDD VDD VSS VSS _5851_/A _5568_/B _5568_/C _5850_/A _5546_/D gf180mcu_as_sc_mcu7t3v3__ao22_2
X_5476_ VDD VDD VSS VSS _5477_/D _5534_/S _5781_/A gf180mcu_as_sc_mcu7t3v3__nand2b_2
XFILLER_160_633 VDD VDD VSS VSS gf180mcu_as_sc_mcu7t3v3__fill_2
XPHY_EDGE_ROW_78_2_Left_519 VDD VSS gf180mcu_as_sc_mcu7t3v3__tap_2
X_4427_ VDD VDD VSS VSS _6243_/Q _4428_/B _4583_/D _6242_/Q _6242_/D gf180mcu_as_sc_mcu7t3v3__ao22_2
XFILLER_154_1151 VDD VDD VSS VSS gf180mcu_as_sc_mcu7t3v3__fillcap_4
XFILLER_154_1173 VDD VDD VSS VSS gf180mcu_as_sc_mcu7t3v3__fillcap_16
XFILLER_48_27 VDD VDD VSS VSS gf180mcu_as_sc_mcu7t3v3__fillcap_8
XFILLER_48_49 VDD VDD VSS VSS gf180mcu_as_sc_mcu7t3v3__fill_2
X_4358_ VDD VDD VSS VSS _6138_/Q _4407_/B _4406_/C _6220_/Q _4359_/C gf180mcu_as_sc_mcu7t3v3__ao22_2
XFILLER_8_1259 VDD VDD VSS VSS gf180mcu_as_sc_mcu7t3v3__fillcap_4
X_4289_ VDD VDD VSS VSS _4366_/A _4289_/B _4289_/C _4290_/B _4366_/D gf180mcu_as_sc_mcu7t3v3__oai211_2
X_3309_ VDD VDD VSS VSS _3310_/D _3364_/A _3355_/B _3309_/A gf180mcu_as_sc_mcu7t3v3__aoi21b_2
XFILLER_228_951 VDD VDD VSS VSS gf180mcu_as_sc_mcu7t3v3__fill_1
X_6028_ VDD VDD VSS VSS _6368_/CLK _6028_/D _6028_/Q gf180mcu_as_sc_mcu7t3v3__dfxtp_2
XTAP_TAPCELL_ROW_5_1107 VDD VSS gf180mcu_as_sc_mcu7t3v3__tap_2
XFILLER_161_6 VDD VDD VSS VSS gf180mcu_as_sc_mcu7t3v3__fillcap_16
XFILLER_64_37 VDD VDD VSS VSS gf180mcu_as_sc_mcu7t3v3__fillcap_8
XFILLER_226_1119 VDD VDD VSS VSS gf180mcu_as_sc_mcu7t3v3__fillcap_16
XPHY_EDGE_ROW_169_Left_397 VDD VSS gf180mcu_as_sc_mcu7t3v3__tap_2
XFILLER_161_1100 VDD VDD VSS VSS gf180mcu_as_sc_mcu7t3v3__fillcap_16
XFILLER_214_177 VDD VDD VSS VSS gf180mcu_as_sc_mcu7t3v3__fill_2
XFILLER_10_400 VDD VDD VSS VSS gf180mcu_as_sc_mcu7t3v3__fillcap_4
XFILLER_11_912 VDD VDD VSS VSS gf180mcu_as_sc_mcu7t3v3__fillcap_16
XFILLER_161_1122 VDD VDD VSS VSS gf180mcu_as_sc_mcu7t3v3__fillcap_16
XFILLER_80_47 VDD VDD VSS VSS gf180mcu_as_sc_mcu7t3v3__fillcap_4
XPHY_EDGE_ROW_112_1_Left_340 VDD VSS gf180mcu_as_sc_mcu7t3v3__tap_2
XFILLER_168_766 VDD VDD VSS VSS gf180mcu_as_sc_mcu7t3v3__fill_1
XFILLER_13_52 VDD VDD VSS VSS gf180mcu_as_sc_mcu7t3v3__fillcap_16
XFILLER_155_438 VDD VDD VSS VSS gf180mcu_as_sc_mcu7t3v3__fill_2
XFILLER_195_596 VDD VDD VSS VSS gf180mcu_as_sc_mcu7t3v3__fill_1
XFILLER_196_69 VDD VDD VSS VSS gf180mcu_as_sc_mcu7t3v3__fillcap_16
XTAP_TAPCELL_ROW_192_2193 VDD VSS gf180mcu_as_sc_mcu7t3v3__tap_2
XFILLER_164_961 VDD VDD VSS VSS gf180mcu_as_sc_mcu7t3v3__fill_2
XFILLER_163_471 VDD VDD VSS VSS gf180mcu_as_sc_mcu7t3v3__fill_1
XFILLER_159_1084 VDD VDD VSS VSS gf180mcu_as_sc_mcu7t3v3__fillcap_16
XTAP_TAPCELL_ROW_153_1487 VDD VSS gf180mcu_as_sc_mcu7t3v3__tap_2
XTAP_TAPCELL_ROW_153_1498 VDD VSS gf180mcu_as_sc_mcu7t3v3__tap_2
XFILLER_1_142 VDD VDD VSS VSS gf180mcu_as_sc_mcu7t3v3__fillcap_16
XFILLER_151_699 VDD VDD VSS VSS gf180mcu_as_sc_mcu7t3v3__fill_1
XPHY_EDGE_ROW_85_1_Right_657 VDD VSS gf180mcu_as_sc_mcu7t3v3__tap_2
Xfanout991 VDD VDD VSS VSS _3277_/B _6528_/D gf180mcu_as_sc_mcu7t3v3__buff_12
XFILLER_161_72 VDD VDD VSS VSS gf180mcu_as_sc_mcu7t3v3__fillcap_16
XTAP_TAPCELL_ROW_220_2702 VDD VSS gf180mcu_as_sc_mcu7t3v3__tap_2
XTAP_TAPCELL_ROW_199_2325 VDD VSS gf180mcu_as_sc_mcu7t3v3__tap_2
XFILLER_166_1033 VDD VDD VSS VSS gf180mcu_as_sc_mcu7t3v3__fillcap_16
XFILLER_207_1030 VDD VDD VSS VSS gf180mcu_as_sc_mcu7t3v3__fillcap_16
XPHY_EDGE_ROW_44_1_Left_272 VDD VSS gf180mcu_as_sc_mcu7t3v3__tap_2
XTAP_TAPCELL_ROW_82_2_2971 VDD VSS gf180mcu_as_sc_mcu7t3v3__tap_2
XFILLER_13_260 VDD VDD VSS VSS gf180mcu_as_sc_mcu7t3v3__fillcap_16
XFILLER_202_862 VDD VDD VSS VSS gf180mcu_as_sc_mcu7t3v3__fill_2
XFILLER_207_1052 VDD VDD VSS VSS gf180mcu_as_sc_mcu7t3v3__fillcap_16
XTAP_TAPCELL_ROW_177_1922 VDD VSS gf180mcu_as_sc_mcu7t3v3__tap_2
XTAP_TAPCELL_ROW_177_1933 VDD VSS gf180mcu_as_sc_mcu7t3v3__tap_2
XFILLER_13_282 VDD VDD VSS VSS gf180mcu_as_sc_mcu7t3v3__fillcap_16
XFILLER_201_372 VDD VDD VSS VSS gf180mcu_as_sc_mcu7t3v3__fill_1
XFILLER_202_884 VDD VDD VSS VSS gf180mcu_as_sc_mcu7t3v3__fill_2
X_3660_ VDD VDD VSS VSS _5676_/A _3889_/B _3888_/B _5676_/D _3661_/D gf180mcu_as_sc_mcu7t3v3__ao22_2
XTAP_TAPCELL_ROW_218_2664 VDD VSS gf180mcu_as_sc_mcu7t3v3__tap_2
XFILLER_220_1263 VDD VDD VSS VSS gf180mcu_as_sc_mcu7t3v3__fill_2
Xclkload12 VDD VDD VSS VSS clkload12/Y _6517_/CLK gf180mcu_as_sc_mcu7t3v3__inv_6
Xclkload23 VDD VDD VSS VSS _6448_/CLK clkload23/Y gf180mcu_as_sc_mcu7t3v3__clkbuff_12
X_3591_ VDD VDD VSS VSS _4612_/C _6524_/Q _3591_/A gf180mcu_as_sc_mcu7t3v3__nor2_2
XFILLER_173_279 VDD VDD VSS VSS gf180mcu_as_sc_mcu7t3v3__fill_1
X_5330_ VDD VDD VSS VSS _5649_/C _5331_/B _5331_/S gf180mcu_as_sc_mcu7t3v3__nor2b_2
X_5261_ VDD VDD VSS VSS _5287_/C _5930_/A _5296_/B _5309_/B gf180mcu_as_sc_mcu7t3v3__ao21_2
X_4212_ VDD VDD VSS VSS _4213_/C _4212_/C _4212_/B _4366_/D gf180mcu_as_sc_mcu7t3v3__aoi21_2
X_5192_ VDD VDD VSS VSS _5845_/A _5292_/B _5222_/C _5848_/A _5194_/B gf180mcu_as_sc_mcu7t3v3__ao22_2
XFILLER_205_43 VDD VDD VSS VSS gf180mcu_as_sc_mcu7t3v3__fillcap_16
X_4143_ VDD VDD VSS VSS _4143_/S _6193_/Q _6192_/Q _6192_/D gf180mcu_as_sc_mcu7t3v3__mux2_2
X_4074_ VDD VDD VSS VSS _4076_/B _6136_/Q _4075_/B gf180mcu_as_sc_mcu7t3v3__xnor2_2
X_3025_ VDD VDD VSS VSS _4984_/A _5346_/A gf180mcu_as_sc_mcu7t3v3__inv_2
XFILLER_225_998 VDD VDD VSS VSS gf180mcu_as_sc_mcu7t3v3__fillcap_16
XTAP_TAPCELL_ROW_0_1004 VDD VSS gf180mcu_as_sc_mcu7t3v3__tap_2
XTAP_TAPCELL_ROW_0_1015 VDD VSS gf180mcu_as_sc_mcu7t3v3__tap_2
XFILLER_180_1008 VDD VDD VSS VSS gf180mcu_as_sc_mcu7t3v3__fillcap_4
XFILLER_212_659 VDD VDD VSS VSS gf180mcu_as_sc_mcu7t3v3__fillcap_4
X_6715_ VDD VDD VSS VSS _6715_/A _6715_/Y gf180mcu_as_sc_mcu7t3v3__buff_2
X_4976_ VDD VDD VSS VSS _4976_/A _4976_/B _4976_/C _4976_/D _5252_/A gf180mcu_as_sc_mcu7t3v3__ao22_2
X_3927_ VDD VDD VSS VSS _5904_/D _3927_/B _3927_/C _3927_/D _3929_/C gf180mcu_as_sc_mcu7t3v3__ao211_2
Xclkload6 VDD VDD VSS VSS clkload6/Y clkload6/A gf180mcu_as_sc_mcu7t3v3__inv_6
X_3858_ VDD VDD VSS VSS _6514_/Q _3897_/B _3887_/B _5847_/A _3860_/C gf180mcu_as_sc_mcu7t3v3__ao22_2
XFILLER_164_235 VDD VDD VSS VSS gf180mcu_as_sc_mcu7t3v3__fillcap_8
XFILLER_69_1210 VDD VDD VSS VSS gf180mcu_as_sc_mcu7t3v3__fill_2
X_3789_ VDD VDD VSS VSS _3790_/D _3849_/B _5786_/A gf180mcu_as_sc_mcu7t3v3__nand2b_2
XFILLER_180_717 VDD VDD VSS VSS gf180mcu_as_sc_mcu7t3v3__fill_1
X_5528_ VDD VDD VSS VSS _5529_/D _5634_/B _5834_/A gf180mcu_as_sc_mcu7t3v3__nand2b_2
XFILLER_195_1262 VDD VDD VSS VSS gf180mcu_as_sc_mcu7t3v3__fill_2
XFILLER_133_666 VDD VDD VSS VSS gf180mcu_as_sc_mcu7t3v3__fill_1
XFILLER_182_27 VDD VDD VSS VSS gf180mcu_as_sc_mcu7t3v3__fillcap_8
XFILLER_59_48 VDD VDD VSS VSS gf180mcu_as_sc_mcu7t3v3__fill_2
X_5459_ VDD VDD VSS VSS _6504_/Q _5564_/B _5563_/B _5766_/A _5460_/C gf180mcu_as_sc_mcu7t3v3__ao22_2
XFILLER_115_43 VDD VDD VSS VSS gf180mcu_as_sc_mcu7t3v3__fillcap_8
XFILLER_228_781 VDD VDD VSS VSS gf180mcu_as_sc_mcu7t3v3__fill_1
XPHY_EDGE_ROW_177_Left_405 VDD VSS gf180mcu_as_sc_mcu7t3v3__tap_2
XFILLER_199_121 VDD VDD VSS VSS gf180mcu_as_sc_mcu7t3v3__fillcap_16
XFILLER_152_2 VDD VDD VSS VSS gf180mcu_as_sc_mcu7t3v3__fillcap_16
XFILLER_187_338 VDD VDD VSS VSS gf180mcu_as_sc_mcu7t3v3__fill_2
XFILLER_202_147 VDD VDD VSS VSS gf180mcu_as_sc_mcu7t3v3__fillcap_16
XTAP_TAPCELL_ROW_194_2233 VDD VSS gf180mcu_as_sc_mcu7t3v3__tap_2
XFILLER_156_703 VDD VDD VSS VSS gf180mcu_as_sc_mcu7t3v3__fillcap_4
XFILLER_196_850 VDD VDD VSS VSS gf180mcu_as_sc_mcu7t3v3__fillcap_4
XFILLER_196_872 VDD VDD VSS VSS gf180mcu_as_sc_mcu7t3v3__fill_2
XFILLER_10_241 VDD VDD VSS VSS gf180mcu_as_sc_mcu7t3v3__fillcap_4
XFILLER_7_702 VDD VDD VSS VSS gf180mcu_as_sc_mcu7t3v3__fill_2
XTAP_TAPCELL_ROW_155_1527 VDD VSS gf180mcu_as_sc_mcu7t3v3__tap_2
XFILLER_10_263 VDD VDD VSS VSS gf180mcu_as_sc_mcu7t3v3__fillcap_16
XFILLER_7_746 VDD VDD VSS VSS gf180mcu_as_sc_mcu7t3v3__fill_1
XFILLER_7_768 VDD VDD VSS VSS gf180mcu_as_sc_mcu7t3v3__fill_2
XPHY_EDGE_ROW_186_Left_414 VDD VSS gf180mcu_as_sc_mcu7t3v3__tap_2
XTAP_TAPCELL_ROW_155_1538 VDD VSS gf180mcu_as_sc_mcu7t3v3__tap_2
XTAP_TAPCELL_ROW_172_1830 VDD VSS gf180mcu_as_sc_mcu7t3v3__tap_2
XTAP_TAPCELL_ROW_172_1841 VDD VSS gf180mcu_as_sc_mcu7t3v3__tap_2
XFILLER_124_600 VDD VDD VSS VSS gf180mcu_as_sc_mcu7t3v3__fill_1
XFILLER_13_1264 VDD VDD VSS VSS gf180mcu_as_sc_mcu7t3v3__fill_1
XFILLER_100_1245 VDD VDD VSS VSS gf180mcu_as_sc_mcu7t3v3__fillcap_16
XFILLER_152_942 VDD VDD VSS VSS gf180mcu_as_sc_mcu7t3v3__fill_2
XTAP_TAPCELL_ROW_213_2583 VDD VSS gf180mcu_as_sc_mcu7t3v3__tap_2
XTAP_TAPCELL_ROW_213_2572 VDD VSS gf180mcu_as_sc_mcu7t3v3__tap_2
XFILLER_151_485 VDD VDD VSS VSS gf180mcu_as_sc_mcu7t3v3__fillcap_4
XFILLER_172_1081 VDD VDD VSS VSS gf180mcu_as_sc_mcu7t3v3__fillcap_4
XTAP_TAPCELL_ROW_14_1258 VDD VSS gf180mcu_as_sc_mcu7t3v3__tap_2
XPHY_EDGE_ROW_195_Left_423 VDD VSS gf180mcu_as_sc_mcu7t3v3__tap_2
XPHY_EDGE_ROW_86_1_Right_658 VDD VSS gf180mcu_as_sc_mcu7t3v3__tap_2
XTAP_TAPCELL_ROW_14_1269 VDD VSS gf180mcu_as_sc_mcu7t3v3__tap_2
XFILLER_1_88 VDD VDD VSS VSS gf180mcu_as_sc_mcu7t3v3__fill_2
XFILLER_207_976 VDD VDD VSS VSS gf180mcu_as_sc_mcu7t3v3__fillcap_4
XFILLER_207_998 VDD VDD VSS VSS gf180mcu_as_sc_mcu7t3v3__fillcap_16
XFILLER_61_664 VDD VDD VSS VSS gf180mcu_as_sc_mcu7t3v3__fill_2
X_4830_ VDD VDD VSS VSS _4831_/C _4887_/B _5831_/A gf180mcu_as_sc_mcu7t3v3__nor2_2
XFILLER_222_979 VDD VDD VSS VSS gf180mcu_as_sc_mcu7t3v3__fillcap_16
X_4761_ VDD VDD VSS VSS _4761_/B _4826_/A _6352_/D gf180mcu_as_sc_mcu7t3v3__and2_2
XFILLER_14_1017 VDD VDD VSS VSS gf180mcu_as_sc_mcu7t3v3__fillcap_16
XFILLER_159_596 VDD VDD VSS VSS gf180mcu_as_sc_mcu7t3v3__fill_1
XFILLER_202_681 VDD VDD VSS VSS gf180mcu_as_sc_mcu7t3v3__fillcap_4
X_6500_ VDD VDD VSS VSS _6518_/CLK _6500_/D _6500_/Q gf180mcu_as_sc_mcu7t3v3__dfxtp_2
X_4692_ VDD VDD VSS VSS _5710_/D _4795_/C _4924_/B _5709_/A _4695_/C gf180mcu_as_sc_mcu7t3v3__ao22_2
X_3712_ VDD VDD VSS VSS _5720_/A _3809_/B _3712_/C _3712_/D _3713_/C gf180mcu_as_sc_mcu7t3v3__ao211_2
XFILLER_179_1224 VDD VDD VSS VSS gf180mcu_as_sc_mcu7t3v3__fillcap_16
X_6431_ VDD VDD VSS VSS _6437_/CLK _6431_/D _6431_/Q gf180mcu_as_sc_mcu7t3v3__dfxtp_2
X_3643_ VDD VDD VSS VSS _3650_/C _3651_/A _3644_/C gf180mcu_as_sc_mcu7t3v3__and2_2
XFILLER_162_717 VDD VDD VSS VSS gf180mcu_as_sc_mcu7t3v3__fill_1
XFILLER_162_728 VDD VDD VSS VSS gf180mcu_as_sc_mcu7t3v3__fillcap_4
XFILLER_162_739 VDD VDD VSS VSS gf180mcu_as_sc_mcu7t3v3__fill_1
X_6362_ VDD VDD VSS VSS _6368_/CLK _6362_/D _6362_/Q gf180mcu_as_sc_mcu7t3v3__dfxtp_2
XFILLER_155_780 VDD VDD VSS VSS gf180mcu_as_sc_mcu7t3v3__fill_2
X_5313_ VDD VDD VSS VSS _6524_/Q _5313_/B _5313_/C _5313_/D _5314_/A gf180mcu_as_sc_mcu7t3v3__ao211_2
X_3574_ VDD VDD VSS VSS _3583_/A _4239_/A _5912_/D gf180mcu_as_sc_mcu7t3v3__nand2b_2
XFILLER_115_666 VDD VDD VSS VSS gf180mcu_as_sc_mcu7t3v3__fill_1
XFILLER_170_761 VDD VDD VSS VSS gf180mcu_as_sc_mcu7t3v3__fillcap_4
Xmax_cap966 VDD VDD VSS VSS fanout965/Y _3542_/B gf180mcu_as_sc_mcu7t3v3__clkbuff_12
X_6293_ VDD VDD VSS VSS clkload5/A _6293_/D _6293_/Q gf180mcu_as_sc_mcu7t3v3__dfxtp_2
XFILLER_216_53 VDD VDD VSS VSS gf180mcu_as_sc_mcu7t3v3__fillcap_16
X_5244_ VDD VDD VSS VSS _5912_/A _5296_/B _5244_/C _5244_/D _5245_/A gf180mcu_as_sc_mcu7t3v3__ao22_2
X_5175_ VDD VDD VSS VSS _5175_/D _5832_/A _5294_/A _5292_/C _5176_/C gf180mcu_as_sc_mcu7t3v3__ao31_2
XFILLER_151_1154 VDD VDD VSS VSS gf180mcu_as_sc_mcu7t3v3__fillcap_16
XPHY_EDGE_ROW_102_3_Left_807 VDD VSS gf180mcu_as_sc_mcu7t3v3__tap_2
X_4126_ VDD VDD VSS VSS _4143_/S _6176_/Q _6175_/Q _6175_/D gf180mcu_as_sc_mcu7t3v3__mux2_2
XFILLER_29_639 VDD VDD VSS VSS gf180mcu_as_sc_mcu7t3v3__fillcap_16
XFILLER_186_1239 VDD VDD VSS VSS gf180mcu_as_sc_mcu7t3v3__fill_1
X_4057_ VDD VDD VSS VSS _4057_/D _4061_/A _4057_/B _4057_/C _6128_/D gf180mcu_as_sc_mcu7t3v3__ao31_2
XFILLER_213_902 VDD VDD VSS VSS gf180mcu_as_sc_mcu7t3v3__fill_1
XFILLER_225_762 VDD VDD VSS VSS gf180mcu_as_sc_mcu7t3v3__fillcap_8
X_3008_ VDD VDD VSS VSS _3591_/A _4977_/A gf180mcu_as_sc_mcu7t3v3__inv_2
XFILLER_149_1072 VDD VDD VSS VSS gf180mcu_as_sc_mcu7t3v3__fillcap_16
XFILLER_197_603 VDD VDD VSS VSS gf180mcu_as_sc_mcu7t3v3__fillcap_4
XTAP_TAPCELL_ROW_0_988 VDD VSS gf180mcu_as_sc_mcu7t3v3__tap_2
XTAP_TAPCELL_ROW_0_999 VDD VSS gf180mcu_as_sc_mcu7t3v3__tap_2
XFILLER_213_979 VDD VDD VSS VSS gf180mcu_as_sc_mcu7t3v3__fill_1
XFILLER_123_1212 VDD VDD VSS VSS gf180mcu_as_sc_mcu7t3v3__fill_1
XFILLER_197_669 VDD VDD VSS VSS gf180mcu_as_sc_mcu7t3v3__fill_2
XFILLER_200_629 VDD VDD VSS VSS gf180mcu_as_sc_mcu7t3v3__fillcap_4
X_4959_ VDD VDD VSS VSS _4959_/B _5310_/A _4961_/C gf180mcu_as_sc_mcu7t3v3__and2_2
XFILLER_177_38 VDD VDD VSS VSS gf180mcu_as_sc_mcu7t3v3__fillcap_16
XPHY_EDGE_ROW_48_1_Right_620 VDD VSS gf180mcu_as_sc_mcu7t3v3__tap_2
XFILLER_193_842 VDD VDD VSS VSS gf180mcu_as_sc_mcu7t3v3__fill_1
XFILLER_20_594 VDD VDD VSS VSS gf180mcu_as_sc_mcu7t3v3__fillcap_4
XFILLER_161_750 VDD VDD VSS VSS gf180mcu_as_sc_mcu7t3v3__fillcap_4
XFILLER_193_59 VDD VDD VSS VSS gf180mcu_as_sc_mcu7t3v3__fillcap_8
XTAP_TAPCELL_ROW_118_3_3026 VDD VSS gf180mcu_as_sc_mcu7t3v3__tap_2
XTAP_TAPCELL_ROW_150_1435 VDD VSS gf180mcu_as_sc_mcu7t3v3__tap_2
XTAP_TAPCELL_ROW_150_1446 VDD VSS gf180mcu_as_sc_mcu7t3v3__tap_2
XFILLER_0_911 VDD VDD VSS VSS gf180mcu_as_sc_mcu7t3v3__fill_2
XFILLER_121_614 VDD VDD VSS VSS gf180mcu_as_sc_mcu7t3v3__fillcap_16
XFILLER_156_1065 VDD VDD VSS VSS gf180mcu_as_sc_mcu7t3v3__fillcap_16
XPHY_EDGE_ROW_34_3_Left_739 VDD VSS gf180mcu_as_sc_mcu7t3v3__tap_2
Xoutput380 VDD VDD VSS VSS _6420_/Q east_out[7] gf180mcu_as_sc_mcu7t3v3__buff_12
XFILLER_156_1087 VDD VDD VSS VSS gf180mcu_as_sc_mcu7t3v3__fillcap_16
Xfanout1005 VDD VDD VSS VSS _6015_/A _5972_/C gf180mcu_as_sc_mcu7t3v3__buff_12
Xoutput391 VDD VDD VSS VSS _6358_/Q north_out[17] gf180mcu_as_sc_mcu7t3v3__buff_12
XFILLER_0_977 VDD VDD VSS VSS gf180mcu_as_sc_mcu7t3v3__fillcap_4
XFILLER_0_988 VDD VDD VSS VSS gf180mcu_as_sc_mcu7t3v3__fill_1
XFILLER_142_30 VDD VDD VSS VSS gf180mcu_as_sc_mcu7t3v3__fillcap_4
XFILLER_208_729 VDD VDD VSS VSS gf180mcu_as_sc_mcu7t3v3__fillcap_4
XFILLER_87_594 VDD VDD VSS VSS gf180mcu_as_sc_mcu7t3v3__fill_2
XPHY_EDGE_ROW_155_Right_23 VDD VSS gf180mcu_as_sc_mcu7t3v3__tap_2
XTAP_TAPCELL_ROW_35_2_2901 VDD VSS gf180mcu_as_sc_mcu7t3v3__tap_2
XPHY_EDGE_ROW_96_3_Left_801 VDD VSS gf180mcu_as_sc_mcu7t3v3__tap_2
XFILLER_15_344 VDD VDD VSS VSS gf180mcu_as_sc_mcu7t3v3__fillcap_4
XFILLER_188_603 VDD VDD VSS VSS gf180mcu_as_sc_mcu7t3v3__fill_1
XFILLER_163_1014 VDD VDD VSS VSS gf180mcu_as_sc_mcu7t3v3__fillcap_16
XFILLER_204_979 VDD VDD VSS VSS gf180mcu_as_sc_mcu7t3v3__fillcap_16
XFILLER_43_664 VDD VDD VSS VSS gf180mcu_as_sc_mcu7t3v3__fill_2
XFILLER_204_1011 VDD VDD VSS VSS gf180mcu_as_sc_mcu7t3v3__fillcap_4
XFILLER_204_1033 VDD VDD VSS VSS gf180mcu_as_sc_mcu7t3v3__fillcap_16
XFILLER_195_190 VDD VDD VSS VSS gf180mcu_as_sc_mcu7t3v3__fillcap_16
XPHY_EDGE_ROW_164_Right_32 VDD VSS gf180mcu_as_sc_mcu7t3v3__tap_2
XTAP_TAPCELL_ROW_215_2612 VDD VSS gf180mcu_as_sc_mcu7t3v3__tap_2
XFILLER_183_352 VDD VDD VSS VSS gf180mcu_as_sc_mcu7t3v3__fill_1
XFILLER_183_363 VDD VDD VSS VSS gf180mcu_as_sc_mcu7t3v3__fill_2
XFILLER_171_536 VDD VDD VSS VSS gf180mcu_as_sc_mcu7t3v3__fill_1
XFILLER_7_598 VDD VDD VSS VSS gf180mcu_as_sc_mcu7t3v3__fillcap_4
Xwire496 VDD VDD VSS VSS _5275_/Y _6406_/D gf180mcu_as_sc_mcu7t3v3__clkbuff_12
XFILLER_151_260 VDD VDD VSS VSS gf180mcu_as_sc_mcu7t3v3__fillcap_16
XTAP_TAPCELL_ROW_16_1309 VDD VSS gf180mcu_as_sc_mcu7t3v3__tap_2
X_3290_ VDD VDD VSS VSS _3291_/C _3290_/C _3290_/B _3290_/A gf180mcu_as_sc_mcu7t3v3__aoi21_2
XFILLER_151_282 VDD VDD VSS VSS gf180mcu_as_sc_mcu7t3v3__fillcap_16
XPHY_EDGE_ROW_173_Right_41 VDD VSS gf180mcu_as_sc_mcu7t3v3__tap_2
XTAP_TAPCELL_ROW_70_2_2953 VDD VSS gf180mcu_as_sc_mcu7t3v3__tap_2
XPHY_EDGE_ROW_87_1_Right_659 VDD VSS gf180mcu_as_sc_mcu7t3v3__tap_2
X_5931_ VDD VDD VSS VSS _5931_/A _5931_/B _5931_/C _5931_/D _5932_/D gf180mcu_as_sc_mcu7t3v3__ao211_2
XFILLER_0_1137 VDD VDD VSS VSS gf180mcu_as_sc_mcu7t3v3__fillcap_4
XFILLER_213_209 VDD VDD VSS VSS gf180mcu_as_sc_mcu7t3v3__fill_1
XPHY_EDGE_ROW_80_3_Left_785 VDD VSS gf180mcu_as_sc_mcu7t3v3__tap_2
XFILLER_146_1245 VDD VDD VSS VSS gf180mcu_as_sc_mcu7t3v3__fillcap_16
XFILLER_178_102 VDD VDD VSS VSS gf180mcu_as_sc_mcu7t3v3__fill_2
XPHY_EDGE_ROW_87_2_Left_528 VDD VSS gf180mcu_as_sc_mcu7t3v3__tap_2
X_5862_ VDD VDD VSS VSS _5862_/S _5862_/B _6516_/Q _5863_/C gf180mcu_as_sc_mcu7t3v3__mux2_2
X_5793_ VDD VDD VSS VSS _5793_/A _5802_/C _5801_/S _5793_/D _5794_/D gf180mcu_as_sc_mcu7t3v3__ao22_2
X_4813_ VDD VDD VSS VSS _6510_/Q _4851_/B _4813_/C _4813_/D _4815_/C gf180mcu_as_sc_mcu7t3v3__ao22_2
XFILLER_166_308 VDD VDD VSS VSS gf180mcu_as_sc_mcu7t3v3__fillcap_4
XFILLER_221_297 VDD VDD VSS VSS gf180mcu_as_sc_mcu7t3v3__fill_2
XPHY_EDGE_ROW_182_Right_50 VDD VSS gf180mcu_as_sc_mcu7t3v3__tap_2
X_4744_ VDD VDD VSS VSS _4857_/B _5759_/A _4745_/C gf180mcu_as_sc_mcu7t3v3__and2_2
XFILLER_162_503 VDD VDD VSS VSS gf180mcu_as_sc_mcu7t3v3__fill_2
X_4675_ VDD VDD VSS VSS _6495_/Q _4841_/B _4795_/C _5693_/D _4677_/C gf180mcu_as_sc_mcu7t3v3__ao22_2
X_6414_ VDD VDD VSS VSS _6422_/CLK _6414_/D _6414_/Q gf180mcu_as_sc_mcu7t3v3__dfxtp_2
X_6552__1185 VDD VDD VSS VSS _6552_/D gf180mcu_as_sc_mcu7t3v3__tiel_4
X_3626_ VDD VDD VSS VSS _4648_/B _3637_/A _5947_/A _5954_/A _3638_/A gf180mcu_as_sc_mcu7t3v3__aoi22_2
XFILLER_192_1221 VDD VDD VSS VSS gf180mcu_as_sc_mcu7t3v3__fillcap_4
X_6345_ VDD VDD VSS VSS _6520_/CLK _6345_/D _6345_/Q gf180mcu_as_sc_mcu7t3v3__dfxtp_2
X_3557_ VDD VDD VSS VSS _3561_/C _3558_/B _3558_/A gf180mcu_as_sc_mcu7t3v3__nor2_2
X_6276_ VDD VDD VSS VSS _6552_/CLK _6276_/D _6276_/Q gf180mcu_as_sc_mcu7t3v3__dfxtp_2
XFILLER_153_1249 VDD VDD VSS VSS gf180mcu_as_sc_mcu7t3v3__fillcap_4
Xinput108 VDD VDD VSS VSS ne_in[2] wire1023/A gf180mcu_as_sc_mcu7t3v3__buff_12
X_5227_ VDD VDD VSS VSS _5869_/A _5308_/B _5227_/C _5227_/D _5228_/A gf180mcu_as_sc_mcu7t3v3__ao211_2
X_3488_ VDD VDD VSS VSS _4632_/A _3489_/D _3489_/C gf180mcu_as_sc_mcu7t3v3__nand2_2
Xinput119 VDD VDD VSS VSS ne_in[7] _5735_/D gf180mcu_as_sc_mcu7t3v3__buff_12
XFILLER_217_504 VDD VDD VSS VSS gf180mcu_as_sc_mcu7t3v3__fill_1
XFILLER_69_594 VDD VDD VSS VSS gf180mcu_as_sc_mcu7t3v3__fillcap_4
X_5158_ VDD VDD VSS VSS _5160_/C _5813_/A _5242_/B _5158_/C gf180mcu_as_sc_mcu7t3v3__ao21_2
XFILLER_56_49 VDD VDD VSS VSS gf180mcu_as_sc_mcu7t3v3__fill_2
X_5089_ VDD VDD VSS VSS _5753_/A _5144_/B _5089_/C _5316_/S _5091_/A gf180mcu_as_sc_mcu7t3v3__ao211_2
X_4109_ VDD VDD VSS VSS _4607_/A _4146_/S _4444_/B _4115_/S gf180mcu_as_sc_mcu7t3v3__mux2_2
XFILLER_217_559 VDD VDD VSS VSS gf180mcu_as_sc_mcu7t3v3__fill_1
XFILLER_197_433 VDD VDD VSS VSS gf180mcu_as_sc_mcu7t3v3__fillcap_8
XFILLER_25_664 VDD VDD VSS VSS gf180mcu_as_sc_mcu7t3v3__fill_2
XFILLER_72_37 VDD VDD VSS VSS gf180mcu_as_sc_mcu7t3v3__fillcap_8
XFILLER_13_837 VDD VDD VSS VSS gf180mcu_as_sc_mcu7t3v3__fill_2
XFILLER_188_37 VDD VDD VSS VSS gf180mcu_as_sc_mcu7t3v3__fillcap_4
XFILLER_197_455 VDD VDD VSS VSS gf180mcu_as_sc_mcu7t3v3__fillcap_8
XFILLER_201_938 VDD VDD VSS VSS gf180mcu_as_sc_mcu7t3v3__fillcap_16
XFILLER_213_776 VDD VDD VSS VSS gf180mcu_as_sc_mcu7t3v3__fill_1
XPHY_EDGE_ROW_49_1_Right_621 VDD VSS gf180mcu_as_sc_mcu7t3v3__tap_2
XFILLER_153_525 VDD VDD VSS VSS gf180mcu_as_sc_mcu7t3v3__fill_1
XFILLER_165_396 VDD VDD VSS VSS gf180mcu_as_sc_mcu7t3v3__fillcap_16
XFILLER_197_1154 VDD VDD VSS VSS gf180mcu_as_sc_mcu7t3v3__fillcap_16
XTAP_TAPCELL_ROW_210_2520 VDD VSS gf180mcu_as_sc_mcu7t3v3__tap_2
XTAP_TAPCELL_ROW_189_2143 VDD VSS gf180mcu_as_sc_mcu7t3v3__tap_2
XPHY_EDGE_ROW_53_1_Left_281 VDD VSS gf180mcu_as_sc_mcu7t3v3__tap_2
XTAP_TAPCELL_ROW_167_1740 VDD VSS gf180mcu_as_sc_mcu7t3v3__tap_2
XTAP_TAPCELL_ROW_11_1206 VDD VSS gf180mcu_as_sc_mcu7t3v3__tap_2
XTAP_TAPCELL_ROW_167_1751 VDD VSS gf180mcu_as_sc_mcu7t3v3__tap_2
XTAP_TAPCELL_ROW_11_1217 VDD VSS gf180mcu_as_sc_mcu7t3v3__tap_2
XTAP_TAPCELL_ROW_208_2493 VDD VSS gf180mcu_as_sc_mcu7t3v3__tap_2
XTAP_TAPCELL_ROW_208_2482 VDD VSS gf180mcu_as_sc_mcu7t3v3__tap_2
XFILLER_189_912 VDD VDD VSS VSS gf180mcu_as_sc_mcu7t3v3__fillcap_4
XFILLER_204_710 VDD VDD VSS VSS gf180mcu_as_sc_mcu7t3v3__fillcap_8
XFILLER_210_1081 VDD VDD VSS VSS gf180mcu_as_sc_mcu7t3v3__fillcap_4
XTAP_TAPCELL_ROW_180_1984 VDD VSS gf180mcu_as_sc_mcu7t3v3__tap_2
XTAP_TAPCELL_ROW_180_1973 VDD VSS gf180mcu_as_sc_mcu7t3v3__tap_2
XFILLER_149_809 VDD VDD VSS VSS gf180mcu_as_sc_mcu7t3v3__fillcap_4
XFILLER_15_174 VDD VDD VSS VSS gf180mcu_as_sc_mcu7t3v3__fillcap_16
XFILLER_189_978 VDD VDD VSS VSS gf180mcu_as_sc_mcu7t3v3__fill_2
XFILLER_31_645 VDD VDD VSS VSS gf180mcu_as_sc_mcu7t3v3__fill_1
XFILLER_176_639 VDD VDD VSS VSS gf180mcu_as_sc_mcu7t3v3__fill_1
XFILLER_157_842 VDD VDD VSS VSS gf180mcu_as_sc_mcu7t3v3__fillcap_4
XFILLER_7_43 VDD VDD VSS VSS gf180mcu_as_sc_mcu7t3v3__fillcap_16
XFILLER_171_311 VDD VDD VSS VSS gf180mcu_as_sc_mcu7t3v3__fill_2
XFILLER_176_1205 VDD VDD VSS VSS gf180mcu_as_sc_mcu7t3v3__fillcap_16
XFILLER_176_1227 VDD VDD VSS VSS gf180mcu_as_sc_mcu7t3v3__fillcap_16
X_4460_ VDD VDD VSS VSS _4520_/S _6717_/A _6270_/Q _6270_/D gf180mcu_as_sc_mcu7t3v3__mux2_2
X_4391_ VDD VDD VSS VSS _4405_/S _6066_/Q _6095_/Q _4394_/B gf180mcu_as_sc_mcu7t3v3__mux2_2
X_3411_ VDD VDD VSS VSS _6274_/Q _4468_/A _4462_/A _6134_/Q _3414_/B gf180mcu_as_sc_mcu7t3v3__ao22_2
XFILLER_217_1224 VDD VDD VSS VSS gf180mcu_as_sc_mcu7t3v3__fillcap_16
X_6130_ VDD VDD VSS VSS _6376_/CLK _6130_/D _6130_/Q gf180mcu_as_sc_mcu7t3v3__dfxtp_2
X_3342_ VDD VDD VSS VSS _3357_/S _6538_/Q _6547_/Q _3343_/B gf180mcu_as_sc_mcu7t3v3__mux2_2
X_6061_ VDD VDD VSS VSS _6506_/CLK _6061_/D _6061_/Q gf180mcu_as_sc_mcu7t3v3__dfxtp_2
X_3273_ VDD VDD VSS VSS _3296_/B _6168_/Q _6232_/Q _3274_/A gf180mcu_as_sc_mcu7t3v3__mux2_2
XTAP_TAPCELL_ROW_228_2858 VDD VSS gf180mcu_as_sc_mcu7t3v3__tap_2
XTAP_TAPCELL_ROW_228_2847 VDD VSS gf180mcu_as_sc_mcu7t3v3__tap_2
X_5012_ VDD VDD VSS VSS _5013_/D _5086_/B _5141_/B _5682_/B gf180mcu_as_sc_mcu7t3v3__aoi21b_2
XTAP_TAPCELL_ROW_88_2_2980 VDD VSS gf180mcu_as_sc_mcu7t3v3__tap_2
XTAP_TAPCELL_ROW_228_2869 VDD VSS gf180mcu_as_sc_mcu7t3v3__tap_2
XFILLER_213_43 VDD VDD VSS VSS gf180mcu_as_sc_mcu7t3v3__fillcap_16
XFILLER_227_846 VDD VDD VSS VSS gf180mcu_as_sc_mcu7t3v3__fill_2
XFILLER_214_529 VDD VDD VSS VSS gf180mcu_as_sc_mcu7t3v3__fill_1
XFILLER_4_1081 VDD VDD VSS VSS gf180mcu_as_sc_mcu7t3v3__fillcap_4
XFILLER_179_422 VDD VDD VSS VSS gf180mcu_as_sc_mcu7t3v3__fillcap_4
X_5914_ VDD VDD VSS VSS _5914_/A _5953_/B _5953_/C _5914_/D _5915_/D gf180mcu_as_sc_mcu7t3v3__ao22_2
XFILLER_195_904 VDD VDD VSS VSS gf180mcu_as_sc_mcu7t3v3__fillcap_4
X_5845_ VDD VDD VSS VSS _5861_/B _5845_/A _5848_/C gf180mcu_as_sc_mcu7t3v3__and2_2
XFILLER_10_807 VDD VDD VSS VSS gf180mcu_as_sc_mcu7t3v3__fillcap_16
XFILLER_179_477 VDD VDD VSS VSS gf180mcu_as_sc_mcu7t3v3__fillcap_8
XFILLER_72_1261 VDD VDD VSS VSS gf180mcu_as_sc_mcu7t3v3__fillcap_4
X_5776_ VDD VDD VSS VSS _5776_/A _5864_/B _5776_/C _5776_/D _5777_/D gf180mcu_as_sc_mcu7t3v3__ao211_2
XFILLER_120_1226 VDD VDD VSS VSS gf180mcu_as_sc_mcu7t3v3__fillcap_16
XFILLER_159_190 VDD VDD VSS VSS gf180mcu_as_sc_mcu7t3v3__fillcap_16
X_4727_ VDD VDD VSS VSS _5743_/A _4858_/B _4727_/C _4746_/B _4729_/C gf180mcu_as_sc_mcu7t3v3__ao211_2
XFILLER_162_311 VDD VDD VSS VSS gf180mcu_as_sc_mcu7t3v3__fillcap_4
X_4658_ VDD VDD VSS VSS _4659_/C _4658_/C _4872_/B _5678_/A gf180mcu_as_sc_mcu7t3v3__aoi21_2
Xinput90 VDD VDD VSS VSS ne_in[13] _5785_/A gf180mcu_as_sc_mcu7t3v3__buff_12
X_3609_ VDD VDD VSS VSS _3658_/B _5646_/A _3850_/B gf180mcu_as_sc_mcu7t3v3__and2_2
X_4589_ VDD VDD VSS VSS _6333_/Q _4602_/A _4598_/B _6333_/D gf180mcu_as_sc_mcu7t3v3__nor3_2
X_6328_ VDD VDD VSS VSS _6551_/CLK _6328_/D _6328_/Q gf180mcu_as_sc_mcu7t3v3__dfxtp_2
XFILLER_153_1046 VDD VDD VSS VSS gf180mcu_as_sc_mcu7t3v3__fillcap_4
X_6259_ VDD VDD VSS VSS clkload9/A _6259_/D _6259_/Q gf180mcu_as_sc_mcu7t3v3__dfxtp_2
XFILLER_153_1068 VDD VDD VSS VSS gf180mcu_as_sc_mcu7t3v3__fillcap_16
XFILLER_190_27 VDD VDD VSS VSS gf180mcu_as_sc_mcu7t3v3__fillcap_8
XTAP_TAPCELL_ROW_184_2062 VDD VSS gf180mcu_as_sc_mcu7t3v3__tap_2
XTAP_TAPCELL_ROW_184_2051 VDD VSS gf180mcu_as_sc_mcu7t3v3__tap_2
XFILLER_123_43 VDD VDD VSS VSS gf180mcu_as_sc_mcu7t3v3__fillcap_8
XTAP_TAPCELL_ROW_8_1149 VDD VSS gf180mcu_as_sc_mcu7t3v3__tap_2
XFILLER_83_36 VDD VDD VSS VSS gf180mcu_as_sc_mcu7t3v3__fill_1
XFILLER_83_47 VDD VDD VSS VSS gf180mcu_as_sc_mcu7t3v3__fillcap_4
XPHY_EDGE_ROW_150_Left_378 VDD VSS gf180mcu_as_sc_mcu7t3v3__tap_2
XFILLER_199_69 VDD VDD VSS VSS gf180mcu_as_sc_mcu7t3v3__fill_1
XPHY_EDGE_ROW_11_Right_11 VDD VSS gf180mcu_as_sc_mcu7t3v3__tap_2
XTAP_TAPCELL_ROW_203_2390 VDD VSS gf180mcu_as_sc_mcu7t3v3__tap_2
XFILLER_160_1017 VDD VDD VSS VSS gf180mcu_as_sc_mcu7t3v3__fillcap_16
XFILLER_186_926 VDD VDD VSS VSS gf180mcu_as_sc_mcu7t3v3__fillcap_8
XFILLER_12_155 VDD VDD VSS VSS gf180mcu_as_sc_mcu7t3v3__fillcap_16
XFILLER_12_177 VDD VDD VSS VSS gf180mcu_as_sc_mcu7t3v3__fillcap_16
XFILLER_200_256 VDD VDD VSS VSS gf180mcu_as_sc_mcu7t3v3__fill_1
XTAP_TAPCELL_ROW_106_3_3008 VDD VSS gf180mcu_as_sc_mcu7t3v3__tap_2
XFILLER_166_650 VDD VDD VSS VSS gf180mcu_as_sc_mcu7t3v3__fillcap_4
XFILLER_201_1014 VDD VDD VSS VSS gf180mcu_as_sc_mcu7t3v3__fillcap_16
XFILLER_154_823 VDD VDD VSS VSS gf180mcu_as_sc_mcu7t3v3__fillcap_8
XFILLER_4_321 VDD VDD VSS VSS gf180mcu_as_sc_mcu7t3v3__fill_2
XFILLER_5_844 VDD VDD VSS VSS gf180mcu_as_sc_mcu7t3v3__fill_1
XFILLER_136_1222 VDD VDD VSS VSS gf180mcu_as_sc_mcu7t3v3__fill_2
XFILLER_49_1263 VDD VDD VSS VSS gf180mcu_as_sc_mcu7t3v3__fill_2
XFILLER_4_387 VDD VDD VSS VSS gf180mcu_as_sc_mcu7t3v3__fillcap_4
XTAP_TAPCELL_ROW_106_1_1374 VDD VSS gf180mcu_as_sc_mcu7t3v3__tap_2
XTAP_TAPCELL_ROW_223_2755 VDD VSS gf180mcu_as_sc_mcu7t3v3__tap_2
X_3960_ VDD VDD VSS VSS _3960_/D _4043_/A _4041_/B _3962_/C _6061_/D gf180mcu_as_sc_mcu7t3v3__ao31_2
XFILLER_143_1226 VDD VDD VSS VSS gf180mcu_as_sc_mcu7t3v3__fillcap_16
XFILLER_149_628 VDD VDD VSS VSS gf180mcu_as_sc_mcu7t3v3__fillcap_16
X_3891_ VDD VDD VSS VSS _5873_/A _3891_/B _3891_/C _3891_/D _3892_/D gf180mcu_as_sc_mcu7t3v3__ao211_2
XFILLER_176_425 VDD VDD VSS VSS gf180mcu_as_sc_mcu7t3v3__fill_1
X_5630_ VDD VDD VSS VSS _5630_/B _5946_/A _5634_/C gf180mcu_as_sc_mcu7t3v3__and2_2
XFILLER_191_406 VDD VDD VSS VSS gf180mcu_as_sc_mcu7t3v3__fill_2
XFILLER_78_2 VDD VDD VSS VSS gf180mcu_as_sc_mcu7t3v3__fillcap_8
XPHY_EDGE_ROW_111_3_Left_816 VDD VSS gf180mcu_as_sc_mcu7t3v3__tap_2
X_5561_ VDD VDD VSS VSS _5584_/B _5867_/A _5561_/A _5562_/B gf180mcu_as_sc_mcu7t3v3__mux2_2
XFILLER_156_171 VDD VDD VSS VSS gf180mcu_as_sc_mcu7t3v3__fillcap_4
X_5492_ VDD VDD VSS VSS _5800_/A _5492_/B _5492_/C _5492_/D _5493_/C gf180mcu_as_sc_mcu7t3v3__ao211_2
X_4512_ VDD VDD VSS VSS _4512_/S _6716_/A _6290_/Q _4513_/A gf180mcu_as_sc_mcu7t3v3__mux2_2
XFILLER_156_193 VDD VDD VSS VSS gf180mcu_as_sc_mcu7t3v3__fillcap_16
XFILLER_172_664 VDD VDD VSS VSS gf180mcu_as_sc_mcu7t3v3__fill_1
XFILLER_160_815 VDD VDD VSS VSS gf180mcu_as_sc_mcu7t3v3__fill_1
XFILLER_171_174 VDD VDD VSS VSS gf180mcu_as_sc_mcu7t3v3__fillcap_16
X_4443_ VDD VDD VSS VSS _6314_/Q _4443_/B _4443_/A _4445_/B gf180mcu_as_sc_mcu7t3v3__mux2_2
Xfanout606 VDD VDD VSS VSS _4863_/B _4964_/B gf180mcu_as_sc_mcu7t3v3__buff_12
X_4374_ VDD VDD VSS VSS _6221_/D _4374_/B _4374_/A gf180mcu_as_sc_mcu7t3v3__nand2_2
Xfanout628 VDD VDD VSS VSS _5315_/B _5304_/B gf180mcu_as_sc_mcu7t3v3__buff_12
Xfanout639 VDD VDD VSS VSS _3854_/B _3872_/B gf180mcu_as_sc_mcu7t3v3__buff_12
X_6113_ VDD VDD VSS VSS _6519_/CLK _6113_/D _6113_/Q gf180mcu_as_sc_mcu7t3v3__dfxtp_2
X_3325_ VDD VDD VSS VSS _3356_/A _3325_/B _3325_/C _3325_/D _3325_/Y gf180mcu_as_sc_mcu7t3v3__ao22_2
XFILLER_140_594 VDD VDD VSS VSS gf180mcu_as_sc_mcu7t3v3__fillcap_8
XFILLER_224_53 VDD VDD VSS VSS gf180mcu_as_sc_mcu7t3v3__fill_2
X_6044_ VDD VDD VSS VSS _6486_/CLK _6044_/D _6044_/Q gf180mcu_as_sc_mcu7t3v3__dfxtp_2
X_3256_ VDD VDD VSS VSS _3296_/B _6166_/Q _6230_/Q _3258_/B gf180mcu_as_sc_mcu7t3v3__mux2_2
XTAP_TAPCELL_ROW_56_1_1349 VDD VSS gf180mcu_as_sc_mcu7t3v3__tap_2
XFILLER_227_643 VDD VDD VSS VSS gf180mcu_as_sc_mcu7t3v3__fillcap_4
X_3187_ VDD VDD VSS VSS _6315_/Q _4579_/D _4480_/A _3187_/D _4158_/B gf180mcu_as_sc_mcu7t3v3__nand4_2
XFILLER_215_838 VDD VDD VSS VSS gf180mcu_as_sc_mcu7t3v3__fill_2
XFILLER_227_687 VDD VDD VSS VSS gf180mcu_as_sc_mcu7t3v3__fill_1
XFILLER_14_409 VDD VDD VSS VSS gf180mcu_as_sc_mcu7t3v3__fill_1
XFILLER_183_1028 VDD VDD VSS VSS gf180mcu_as_sc_mcu7t3v3__fillcap_16
XFILLER_187_1186 VDD VDD VSS VSS gf180mcu_as_sc_mcu7t3v3__fillcap_4
XTAP_TAPCELL_ROW_3_1068 VDD VSS gf180mcu_as_sc_mcu7t3v3__tap_2
XFILLER_167_414 VDD VDD VSS VSS gf180mcu_as_sc_mcu7t3v3__fillcap_4
XFILLER_179_263 VDD VDD VSS VSS gf180mcu_as_sc_mcu7t3v3__fill_2
XFILLER_210_543 VDD VDD VSS VSS gf180mcu_as_sc_mcu7t3v3__fillcap_16
XPHY_EDGE_ROW_20_2_Left_461 VDD VSS gf180mcu_as_sc_mcu7t3v3__tap_2
XPHY_EDGE_ROW_43_3_Left_748 VDD VSS gf180mcu_as_sc_mcu7t3v3__tap_2
X_5828_ VDD VDD VSS VSS _5828_/B _5836_/A _6467_/D gf180mcu_as_sc_mcu7t3v3__and2_2
XTAP_TAPCELL_ROW_98_1_1370 VDD VSS gf180mcu_as_sc_mcu7t3v3__tap_2
X_5759_ VDD VDD VSS VSS _5759_/A _5853_/B _5759_/C _5759_/D _5760_/C gf180mcu_as_sc_mcu7t3v3__ao211_2
XFILLER_182_439 VDD VDD VSS VSS gf180mcu_as_sc_mcu7t3v3__fillcap_4
XFILLER_185_27 VDD VDD VSS VSS gf180mcu_as_sc_mcu7t3v3__fillcap_4
XFILLER_159_1233 VDD VDD VSS VSS gf180mcu_as_sc_mcu7t3v3__fillcap_16
XFILLER_159_1255 VDD VDD VSS VSS gf180mcu_as_sc_mcu7t3v3__fill_1
XFILLER_194_1135 VDD VDD VSS VSS gf180mcu_as_sc_mcu7t3v3__fillcap_16
XFILLER_194_1157 VDD VDD VSS VSS gf180mcu_as_sc_mcu7t3v3__fillcap_16
Xmesh_tile_1049 VDD VDD VSS VSS ne_out[8] gf180mcu_as_sc_mcu7t3v3__tiel_4
XTAP_TAPCELL_ROW_205_2430 VDD VSS gf180mcu_as_sc_mcu7t3v3__tap_2
XFILLER_150_30 VDD VDD VSS VSS gf180mcu_as_sc_mcu7t3v3__fillcap_4
XFILLER_217_142 VDD VDD VSS VSS gf180mcu_as_sc_mcu7t3v3__fill_2
XTAP_TAPCELL_ROW_160_1618 VDD VSS gf180mcu_as_sc_mcu7t3v3__tap_2
XTAP_TAPCELL_ROW_160_1629 VDD VSS gf180mcu_as_sc_mcu7t3v3__tap_2
XFILLER_150_85 VDD VDD VSS VSS gf180mcu_as_sc_mcu7t3v3__fillcap_16
XFILLER_166_1259 VDD VDD VSS VSS gf180mcu_as_sc_mcu7t3v3__fill_2
XFILLER_207_1234 VDD VDD VSS VSS gf180mcu_as_sc_mcu7t3v3__fill_1
XFILLER_220_329 VDD VDD VSS VSS gf180mcu_as_sc_mcu7t3v3__fillcap_4
XTAP_TAPCELL_ROW_197_2286 VDD VSS gf180mcu_as_sc_mcu7t3v3__tap_2
XFILLER_13_464 VDD VDD VSS VSS gf180mcu_as_sc_mcu7t3v3__fillcap_8
XFILLER_186_734 VDD VDD VSS VSS gf180mcu_as_sc_mcu7t3v3__fill_1
XFILLER_198_594 VDD VDD VSS VSS gf180mcu_as_sc_mcu7t3v3__fill_1
XTAP_TAPCELL_ROW_141_2_3060 VDD VSS gf180mcu_as_sc_mcu7t3v3__tap_2
XFILLER_103_1210 VDD VDD VSS VSS gf180mcu_as_sc_mcu7t3v3__fillcap_4
XFILLER_159_72 VDD VDD VSS VSS gf180mcu_as_sc_mcu7t3v3__fillcap_16
XFILLER_185_255 VDD VDD VSS VSS gf180mcu_as_sc_mcu7t3v3__fill_2
XFILLER_199_1046 VDD VDD VSS VSS gf180mcu_as_sc_mcu7t3v3__fillcap_4
XFILLER_166_480 VDD VDD VSS VSS gf180mcu_as_sc_mcu7t3v3__fill_2
XFILLER_185_288 VDD VDD VSS VSS gf180mcu_as_sc_mcu7t3v3__fill_1
XFILLER_199_1068 VDD VDD VSS VSS gf180mcu_as_sc_mcu7t3v3__fillcap_16
XTAP_TAPCELL_ROW_175_1883 VDD VSS gf180mcu_as_sc_mcu7t3v3__tap_2
XTAP_TAPCELL_ROW_175_1894 VDD VSS gf180mcu_as_sc_mcu7t3v3__tap_2
XFILLER_154_664 VDD VDD VSS VSS gf180mcu_as_sc_mcu7t3v3__fill_1
XFILLER_154_675 VDD VDD VSS VSS gf180mcu_as_sc_mcu7t3v3__fillcap_4
XFILLER_173_1208 VDD VDD VSS VSS gf180mcu_as_sc_mcu7t3v3__fillcap_16
XFILLER_153_174 VDD VDD VSS VSS gf180mcu_as_sc_mcu7t3v3__fillcap_16
XFILLER_214_1205 VDD VDD VSS VSS gf180mcu_as_sc_mcu7t3v3__fillcap_16
XFILLER_122_594 VDD VDD VSS VSS gf180mcu_as_sc_mcu7t3v3__fillcap_8
XFILLER_214_1227 VDD VDD VSS VSS gf180mcu_as_sc_mcu7t3v3__fillcap_16
XFILLER_68_626 VDD VDD VSS VSS gf180mcu_as_sc_mcu7t3v3__fill_1
XPHY_EDGE_ROW_96_2_Left_537 VDD VSS gf180mcu_as_sc_mcu7t3v3__tap_2
X_3110_ VDD VDD VSS VSS _4468_/A _6312_/Q _3423_/A gf180mcu_as_sc_mcu7t3v3__and2_2
XFILLER_0_390 VDD VDD VSS VSS gf180mcu_as_sc_mcu7t3v3__fillcap_16
X_4090_ VDD VDD VSS VSS _4093_/S _6719_/A _6150_/Q _6150_/D gf180mcu_as_sc_mcu7t3v3__mux2_2
XFILLER_209_632 VDD VDD VSS VSS gf180mcu_as_sc_mcu7t3v3__fillcap_16
Xinput280 VDD VDD VSS VSS sw_in[21] _5851_/A gf180mcu_as_sc_mcu7t3v3__buff_12
X_3041_ VDD VDD VSS VSS _4579_/D _4509_/A gf180mcu_as_sc_mcu7t3v3__inv_2
Xinput291 VDD VDD VSS VSS sw_in[31] _5934_/A gf180mcu_as_sc_mcu7t3v3__buff_12
XFILLER_1_1084 VDD VDD VSS VSS gf180mcu_as_sc_mcu7t3v3__fillcap_16
X_4992_ VDD VDD VSS VSS _4992_/D _5676_/A _5222_/B _5222_/C _4993_/C gf180mcu_as_sc_mcu7t3v3__ao31_2
XFILLER_189_550 VDD VDD VSS VSS gf180mcu_as_sc_mcu7t3v3__fill_2
XFILLER_204_370 VDD VDD VSS VSS gf180mcu_as_sc_mcu7t3v3__fill_1
X_3943_ VDD VDD VSS VSS _6049_/Q _3963_/B _3948_/C _4024_/D _6049_/D gf180mcu_as_sc_mcu7t3v3__ao22_2
XFILLER_189_594 VDD VDD VSS VSS gf180mcu_as_sc_mcu7t3v3__fillcap_16
X_3874_ VDD VDD VSS VSS _5859_/A _3874_/B _3874_/C _3874_/D _4053_/B gf180mcu_as_sc_mcu7t3v3__ao211_2
X_5613_ VDD VDD VSS VSS _5924_/A _5630_/B _5613_/C _5613_/D _5614_/B gf180mcu_as_sc_mcu7t3v3__ao211_2
XFILLER_178_1119 VDD VDD VSS VSS gf180mcu_as_sc_mcu7t3v3__fillcap_16
X_5544_ VDD VDD VSS VSS _5848_/A _5566_/B _5544_/C _5544_/D _5546_/C gf180mcu_as_sc_mcu7t3v3__ao211_2
XFILLER_145_664 VDD VDD VSS VSS gf180mcu_as_sc_mcu7t3v3__fill_2
XFILLER_160_601 VDD VDD VSS VSS gf180mcu_as_sc_mcu7t3v3__fill_2
XFILLER_172_472 VDD VDD VSS VSS gf180mcu_as_sc_mcu7t3v3__fillcap_8
XFILLER_219_1116 VDD VDD VSS VSS gf180mcu_as_sc_mcu7t3v3__fillcap_4
X_5475_ VDD VDD VSS VSS _5782_/B _5491_/C _5534_/S _5475_/D _5477_/C gf180mcu_as_sc_mcu7t3v3__ao211_2
XTAP_TAPCELL_ROW_76_2_2962 VDD VSS gf180mcu_as_sc_mcu7t3v3__tap_2
XFILLER_219_1138 VDD VDD VSS VSS gf180mcu_as_sc_mcu7t3v3__fillcap_16
X_4426_ VDD VDD VSS VSS _6242_/Q _4428_/B _4583_/D _6241_/Q _6241_/D gf180mcu_as_sc_mcu7t3v3__ao22_2
XFILLER_160_667 VDD VDD VSS VSS gf180mcu_as_sc_mcu7t3v3__fillcap_16
XFILLER_8_1205 VDD VDD VSS VSS gf180mcu_as_sc_mcu7t3v3__fillcap_16
XFILLER_8_1227 VDD VDD VSS VSS gf180mcu_as_sc_mcu7t3v3__fillcap_16
X_4357_ VDD VDD VSS VSS _4357_/B _4366_/A _4360_/C gf180mcu_as_sc_mcu7t3v3__or2_2
XFILLER_113_594 VDD VDD VSS VSS gf180mcu_as_sc_mcu7t3v3__fillcap_8
XFILLER_150_1049 VDD VDD VSS VSS gf180mcu_as_sc_mcu7t3v3__fillcap_16
X_4288_ VDD VDD VSS VSS _4290_/A _4288_/C _4407_/B _6160_/Q gf180mcu_as_sc_mcu7t3v3__aoi21_2
X_3308_ VDD VDD VSS VSS _4076_/B _3308_/B _3308_/C _3308_/D _3310_/C gf180mcu_as_sc_mcu7t3v3__ao22_2
XFILLER_104_45 VDD VDD VSS VSS gf180mcu_as_sc_mcu7t3v3__fillcap_4
X_6027_ VDD VDD VSS VSS _6370_/CLK _6027_/D _6027_/Q gf180mcu_as_sc_mcu7t3v3__dfxtp_2
X_3239_ VDD VDD VSS VSS _6300_/Q _3326_/S _4462_/B _3240_/C gf180mcu_as_sc_mcu7t3v3__nor3_2
XTAP_TAPCELL_ROW_5_1108 VDD VSS gf180mcu_as_sc_mcu7t3v3__tap_2
XFILLER_228_985 VDD VDD VSS VSS gf180mcu_as_sc_mcu7t3v3__fill_1
XFILLER_15_718 VDD VDD VSS VSS gf180mcu_as_sc_mcu7t3v3__fill_2
XFILLER_214_101 VDD VDD VSS VSS gf180mcu_as_sc_mcu7t3v3__fillcap_4
XFILLER_214_123 VDD VDD VSS VSS gf180mcu_as_sc_mcu7t3v3__fill_2
XFILLER_64_49 VDD VDD VSS VSS gf180mcu_as_sc_mcu7t3v3__fill_2
XFILLER_215_668 VDD VDD VSS VSS gf180mcu_as_sc_mcu7t3v3__fillcap_4
XFILLER_126_1210 VDD VDD VSS VSS gf180mcu_as_sc_mcu7t3v3__fillcap_16
XFILLER_154_6 VDD VDD VSS VSS gf180mcu_as_sc_mcu7t3v3__fillcap_16
XFILLER_214_167 VDD VDD VSS VSS gf180mcu_as_sc_mcu7t3v3__fill_1
XFILLER_168_734 VDD VDD VSS VSS gf180mcu_as_sc_mcu7t3v3__fill_1
XFILLER_80_37 VDD VDD VSS VSS gf180mcu_as_sc_mcu7t3v3__fill_2
XFILLER_195_564 VDD VDD VSS VSS gf180mcu_as_sc_mcu7t3v3__fill_1
XFILLER_196_37 VDD VDD VSS VSS gf180mcu_as_sc_mcu7t3v3__fillcap_16
XFILLER_7_906 VDD VDD VSS VSS gf180mcu_as_sc_mcu7t3v3__fillcap_4
XPHY_EDGE_ROW_62_1_Left_290 VDD VSS gf180mcu_as_sc_mcu7t3v3__tap_2
XFILLER_149_970 VDD VDD VSS VSS gf180mcu_as_sc_mcu7t3v3__fillcap_16
XFILLER_7_928 VDD VDD VSS VSS gf180mcu_as_sc_mcu7t3v3__fillcap_16
XTAP_TAPCELL_ROW_192_2194 VDD VSS gf180mcu_as_sc_mcu7t3v3__tap_2
XFILLER_10_489 VDD VDD VSS VSS gf180mcu_as_sc_mcu7t3v3__fill_1
XFILLER_182_247 VDD VDD VSS VSS gf180mcu_as_sc_mcu7t3v3__fillcap_16
XFILLER_151_601 VDD VDD VSS VSS gf180mcu_as_sc_mcu7t3v3__fill_2
XFILLER_159_1030 VDD VDD VSS VSS gf180mcu_as_sc_mcu7t3v3__fillcap_16
XFILLER_159_1052 VDD VDD VSS VSS gf180mcu_as_sc_mcu7t3v3__fillcap_16
XFILLER_11_1170 VDD VDD VSS VSS gf180mcu_as_sc_mcu7t3v3__fillcap_16
XFILLER_11_1192 VDD VDD VSS VSS gf180mcu_as_sc_mcu7t3v3__fillcap_16
XFILLER_163_483 VDD VDD VSS VSS gf180mcu_as_sc_mcu7t3v3__fillcap_4
XTAP_TAPCELL_ROW_153_1488 VDD VSS gf180mcu_as_sc_mcu7t3v3__tap_2
XTAP_TAPCELL_ROW_153_1499 VDD VSS gf180mcu_as_sc_mcu7t3v3__tap_2
XFILLER_150_155 VDD VDD VSS VSS gf180mcu_as_sc_mcu7t3v3__fillcap_16
XPHY_EDGE_ROW_81_1_Left_309 VDD VSS gf180mcu_as_sc_mcu7t3v3__tap_2
Xload_slew809 VDD VDD VSS VSS _3658_/Y _3850_/C gf180mcu_as_sc_mcu7t3v3__clkbuff_12
XFILLER_150_177 VDD VDD VSS VSS gf180mcu_as_sc_mcu7t3v3__fillcap_16
XFILLER_172_1263 VDD VDD VSS VSS gf180mcu_as_sc_mcu7t3v3__fill_2
XFILLER_104_594 VDD VDD VSS VSS gf180mcu_as_sc_mcu7t3v3__fill_2
Xfanout970 VDD VDD VSS VSS _3299_/A _3291_/B gf180mcu_as_sc_mcu7t3v3__buff_12
Xfanout992 VDD VDD VSS VSS _3363_/B _3277_/B gf180mcu_as_sc_mcu7t3v3__buff_12
XTAP_TAPCELL_ROW_220_2703 VDD VSS gf180mcu_as_sc_mcu7t3v3__tap_2
XTAP_TAPCELL_ROW_199_2315 VDD VSS gf180mcu_as_sc_mcu7t3v3__tap_2
XFILLER_206_624 VDD VDD VSS VSS gf180mcu_as_sc_mcu7t3v3__fill_1
XFILLER_218_484 VDD VDD VSS VSS gf180mcu_as_sc_mcu7t3v3__fill_1
Xhold1190 VDD VDD VSS VSS _3200_/Y hold1190/Y gf180mcu_as_sc_mcu7t3v3__clkbuff_4
XTAP_TAPCELL_ROW_199_2326 VDD VSS gf180mcu_as_sc_mcu7t3v3__tap_2
XFILLER_159_712 VDD VDD VSS VSS gf180mcu_as_sc_mcu7t3v3__fill_2
XFILLER_205_178 VDD VDD VSS VSS gf180mcu_as_sc_mcu7t3v3__fill_1
XFILLER_186_531 VDD VDD VSS VSS gf180mcu_as_sc_mcu7t3v3__fill_1
XFILLER_198_391 VDD VDD VSS VSS gf180mcu_as_sc_mcu7t3v3__fill_2
XFILLER_199_892 VDD VDD VSS VSS gf180mcu_as_sc_mcu7t3v3__fill_1
XTAP_TAPCELL_ROW_177_1923 VDD VSS gf180mcu_as_sc_mcu7t3v3__tap_2
XTAP_TAPCELL_ROW_177_1934 VDD VSS gf180mcu_as_sc_mcu7t3v3__tap_2
XFILLER_186_586 VDD VDD VSS VSS gf180mcu_as_sc_mcu7t3v3__fill_2
XFILLER_186_597 VDD VDD VSS VSS gf180mcu_as_sc_mcu7t3v3__fillcap_16
XFILLER_201_384 VDD VDD VSS VSS gf180mcu_as_sc_mcu7t3v3__fillcap_4
XFILLER_9_276 VDD VDD VSS VSS gf180mcu_as_sc_mcu7t3v3__fillcap_4
XTAP_TAPCELL_ROW_218_2665 VDD VSS gf180mcu_as_sc_mcu7t3v3__tap_2
XFILLER_127_642 VDD VDD VSS VSS gf180mcu_as_sc_mcu7t3v3__fillcap_8
XFILLER_173_225 VDD VDD VSS VSS gf180mcu_as_sc_mcu7t3v3__fillcap_4
XFILLER_9_298 VDD VDD VSS VSS gf180mcu_as_sc_mcu7t3v3__fillcap_8
Xclkload13 VDD VDD VSS VSS clkload13/Y _6552_/CLK gf180mcu_as_sc_mcu7t3v3__inv_6
Xclkload24 VDD VDD VSS VSS clkload24/Y _6422_/CLK gf180mcu_as_sc_mcu7t3v3__inv_6
X_3590_ VDD VDD VSS VSS _3595_/B _3595_/A _4979_/B gf180mcu_as_sc_mcu7t3v3__and2_2
XFILLER_127_664 VDD VDD VSS VSS gf180mcu_as_sc_mcu7t3v3__fill_2
XFILLER_154_450 VDD VDD VSS VSS gf180mcu_as_sc_mcu7t3v3__fillcap_4
X_5260_ VDD VDD VSS VSS _5907_/A _5304_/B _5296_/C _5905_/A _5266_/C gf180mcu_as_sc_mcu7t3v3__ao22_2
XFILLER_173_1049 VDD VDD VSS VSS gf180mcu_as_sc_mcu7t3v3__fill_1
X_4211_ VDD VDD VSS VSS _6718_/A _4337_/B _4211_/C _4223_/B _4212_/C gf180mcu_as_sc_mcu7t3v3__ao211_2
X_5191_ VDD VDD VSS VSS _5191_/B _5229_/A _6397_/D gf180mcu_as_sc_mcu7t3v3__and2_2
X_4142_ VDD VDD VSS VSS _4143_/S _6192_/Q _6191_/Q _6191_/D gf180mcu_as_sc_mcu7t3v3__mux2_2
XFILLER_205_88 VDD VDD VSS VSS gf180mcu_as_sc_mcu7t3v3__fill_2
X_4073_ VDD VDD VSS VSS _4077_/B _4581_/A _6135_/D gf180mcu_as_sc_mcu7t3v3__and2_2
Xclkbuf_3_4_0_clk_regs VDD VDD VSS VSS clkbuf_0_clk_regs/Y clkbuf_3_4_0_clk_regs/Y
+ gf180mcu_as_sc_mcu7t3v3__clkbuff_12
X_3024_ VDD VDD VSS VSS _3477_/C _5923_/A gf180mcu_as_sc_mcu7t3v3__inv_2
XFILLER_64_640 VDD VDD VSS VSS gf180mcu_as_sc_mcu7t3v3__fill_2
XFILLER_224_443 VDD VDD VSS VSS gf180mcu_as_sc_mcu7t3v3__fillcap_4
XTAP_TAPCELL_ROW_0_1005 VDD VSS gf180mcu_as_sc_mcu7t3v3__tap_2
XTAP_TAPCELL_ROW_0_1016 VDD VSS gf180mcu_as_sc_mcu7t3v3__tap_2
XFILLER_184_1189 VDD VDD VSS VSS gf180mcu_as_sc_mcu7t3v3__fillcap_16
XFILLER_196_317 VDD VDD VSS VSS gf180mcu_as_sc_mcu7t3v3__fillcap_4
XFILLER_197_818 VDD VDD VSS VSS gf180mcu_as_sc_mcu7t3v3__fill_1
X_4975_ VDD VDD VSS VSS _5122_/A _4976_/C _4976_/D gf180mcu_as_sc_mcu7t3v3__nand2_2
XFILLER_149_222 VDD VDD VSS VSS gf180mcu_as_sc_mcu7t3v3__fillcap_16
X_3926_ VDD VDD VSS VSS _3926_/B _5906_/D _3927_/D gf180mcu_as_sc_mcu7t3v3__and2_2
XFILLER_225_1186 VDD VDD VSS VSS gf180mcu_as_sc_mcu7t3v3__fillcap_4
Xclkload7 VDD VDD VSS VSS clkload7/Y clkload7/A gf180mcu_as_sc_mcu7t3v3__inv_4
X_3857_ VDD VDD VSS VSS _6036_/Q _3904_/B _4049_/B _3904_/D _6036_/D gf180mcu_as_sc_mcu7t3v3__ao22_2
XFILLER_164_247 VDD VDD VSS VSS gf180mcu_as_sc_mcu7t3v3__fillcap_8
X_3788_ VDD VDD VSS VSS _5786_/D _3808_/B _3788_/C _3849_/B _3790_/C gf180mcu_as_sc_mcu7t3v3__ao211_2
X_5527_ VDD VDD VSS VSS _5527_/B _5527_/A _5529_/C gf180mcu_as_sc_mcu7t3v3__or2_2
XFILLER_160_420 VDD VDD VSS VSS gf180mcu_as_sc_mcu7t3v3__fill_1
XFILLER_191_1116 VDD VDD VSS VSS gf180mcu_as_sc_mcu7t3v3__fillcap_4
XFILLER_191_1138 VDD VDD VSS VSS gf180mcu_as_sc_mcu7t3v3__fillcap_16
X_5458_ VDD VDD VSS VSS _5567_/B _5768_/D _5462_/C gf180mcu_as_sc_mcu7t3v3__and2_2
XFILLER_160_475 VDD VDD VSS VSS gf180mcu_as_sc_mcu7t3v3__fillcap_4
XFILLER_161_998 VDD VDD VSS VSS gf180mcu_as_sc_mcu7t3v3__fillcap_16
X_5389_ VDD VDD VSS VSS _6496_/Q _5490_/B _5491_/B _5700_/A _5390_/D gf180mcu_as_sc_mcu7t3v3__ao22_2
X_4409_ VDD VDD VSS VSS _6226_/D _4409_/B _4409_/A gf180mcu_as_sc_mcu7t3v3__nand2_2
XFILLER_216_944 VDD VDD VSS VSS gf180mcu_as_sc_mcu7t3v3__fill_1
XFILLER_131_43 VDD VDD VSS VSS gf180mcu_as_sc_mcu7t3v3__fillcap_8
XFILLER_76_1237 VDD VDD VSS VSS gf180mcu_as_sc_mcu7t3v3__fillcap_4
XFILLER_199_166 VDD VDD VSS VSS gf180mcu_as_sc_mcu7t3v3__fill_1
XFILLER_202_115 VDD VDD VSS VSS gf180mcu_as_sc_mcu7t3v3__fillcap_4
XFILLER_70_643 VDD VDD VSS VSS gf180mcu_as_sc_mcu7t3v3__fill_1
XFILLER_199_199 VDD VDD VSS VSS gf180mcu_as_sc_mcu7t3v3__fill_1
XTAP_TAPCELL_ROW_194_2234 VDD VSS gf180mcu_as_sc_mcu7t3v3__tap_2
XFILLER_156_737 VDD VDD VSS VSS gf180mcu_as_sc_mcu7t3v3__fillcap_4
XFILLER_168_597 VDD VDD VSS VSS gf180mcu_as_sc_mcu7t3v3__fillcap_16
XFILLER_196_884 VDD VDD VSS VSS gf180mcu_as_sc_mcu7t3v3__fillcap_16
XTAP_TAPCELL_ROW_155_1528 VDD VSS gf180mcu_as_sc_mcu7t3v3__tap_2
Xclkbuf_leaf_8_clk_regs VDD VDD VSS VSS clkload0/A _6531_/CLK gf180mcu_as_sc_mcu7t3v3__clkbuff_12
XFILLER_11_798 VDD VDD VSS VSS gf180mcu_as_sc_mcu7t3v3__fillcap_16
XFILLER_183_534 VDD VDD VSS VSS gf180mcu_as_sc_mcu7t3v3__fill_1
XFILLER_195_394 VDD VDD VSS VSS gf180mcu_as_sc_mcu7t3v3__fill_1
XTAP_TAPCELL_ROW_155_1539 VDD VSS gf180mcu_as_sc_mcu7t3v3__tap_2
XTAP_TAPCELL_ROW_172_1831 VDD VSS gf180mcu_as_sc_mcu7t3v3__tap_2
XFILLER_109_664 VDD VDD VSS VSS gf180mcu_as_sc_mcu7t3v3__fill_2
XFILLER_152_910 VDD VDD VSS VSS gf180mcu_as_sc_mcu7t3v3__fillcap_4
XFILLER_171_718 VDD VDD VSS VSS gf180mcu_as_sc_mcu7t3v3__fillcap_8
XFILLER_196_1049 VDD VDD VSS VSS gf180mcu_as_sc_mcu7t3v3__fillcap_16
XTAP_TAPCELL_ROW_172_1842 VDD VSS gf180mcu_as_sc_mcu7t3v3__tap_2
XFILLER_6_279 VDD VDD VSS VSS gf180mcu_as_sc_mcu7t3v3__fillcap_16
XTAP_TAPCELL_ROW_213_2584 VDD VSS gf180mcu_as_sc_mcu7t3v3__tap_2
XTAP_TAPCELL_ROW_213_2573 VDD VSS gf180mcu_as_sc_mcu7t3v3__tap_2
XFILLER_211_1208 VDD VDD VSS VSS gf180mcu_as_sc_mcu7t3v3__fillcap_16
XFILLER_38_629 VDD VDD VSS VSS gf180mcu_as_sc_mcu7t3v3__fillcap_16
XTAP_TAPCELL_ROW_14_1259 VDD VSS gf180mcu_as_sc_mcu7t3v3__tap_2
XFILLER_225_207 VDD VDD VSS VSS gf180mcu_as_sc_mcu7t3v3__fill_2
XFILLER_1_67 VDD VDD VSS VSS gf180mcu_as_sc_mcu7t3v3__fill_2
XFILLER_207_944 VDD VDD VSS VSS gf180mcu_as_sc_mcu7t3v3__fillcap_16
XPHY_EDGE_ROW_120_3_Left_825 VDD VSS gf180mcu_as_sc_mcu7t3v3__tap_2
XFILLER_222_947 VDD VDD VSS VSS gf180mcu_as_sc_mcu7t3v3__fillcap_16
X_4760_ VDD VDD VSS VSS _4883_/A _4760_/B _5770_/A _4761_/B gf180mcu_as_sc_mcu7t3v3__mux2_2
XFILLER_187_895 VDD VDD VSS VSS gf180mcu_as_sc_mcu7t3v3__fill_1
X_4691_ VDD VDD VSS VSS _5707_/B _4784_/B _4774_/C _5708_/A _4693_/C gf180mcu_as_sc_mcu7t3v3__ao22_2
X_3711_ VDD VDD VSS VSS _3808_/B _5719_/A _3712_/D gf180mcu_as_sc_mcu7t3v3__and2_2
X_6430_ VDD VDD VSS VSS _6437_/CLK _6430_/D _6430_/Q gf180mcu_as_sc_mcu7t3v3__dfxtp_2
X_3642_ VDD VDD VSS VSS _4652_/A _5321_/A _5003_/B _3650_/C gf180mcu_as_sc_mcu7t3v3__nand3_2
XFILLER_161_206 VDD VDD VSS VSS gf180mcu_as_sc_mcu7t3v3__fillcap_4
XFILLER_174_567 VDD VDD VSS VSS gf180mcu_as_sc_mcu7t3v3__fill_1
X_6361_ VDD VDD VSS VSS _6368_/CLK _6361_/D _6361_/Q gf180mcu_as_sc_mcu7t3v3__dfxtp_2
XFILLER_161_228 VDD VDD VSS VSS gf180mcu_as_sc_mcu7t3v3__fillcap_16
X_5312_ VDD VDD VSS VSS _5312_/A _5312_/B _5313_/B _5313_/D _5312_/D gf180mcu_as_sc_mcu7t3v3__aoi211_2
X_3573_ VDD VDD VSS VSS _3573_/A _4620_/A _3573_/C _3573_/D _3658_/C gf180mcu_as_sc_mcu7t3v3__nand4_2
XFILLER_115_656 VDD VDD VSS VSS gf180mcu_as_sc_mcu7t3v3__fillcap_4
XFILLER_216_1119 VDD VDD VSS VSS gf180mcu_as_sc_mcu7t3v3__fillcap_16
X_6292_ VDD VDD VSS VSS clkload5/A _6292_/D _6292_/Q gf180mcu_as_sc_mcu7t3v3__dfxtp_2
XFILLER_130_626 VDD VDD VSS VSS gf180mcu_as_sc_mcu7t3v3__fill_1
X_5243_ VDD VDD VSS VSS _5244_/D _5296_/B _5263_/B _5887_/D gf180mcu_as_sc_mcu7t3v3__aoi21b_2
XFILLER_116_1242 VDD VDD VSS VSS gf180mcu_as_sc_mcu7t3v3__fill_1
XFILLER_151_1100 VDD VDD VSS VSS gf180mcu_as_sc_mcu7t3v3__fillcap_16
XFILLER_151_1122 VDD VDD VSS VSS gf180mcu_as_sc_mcu7t3v3__fillcap_16
X_5174_ VDD VDD VSS VSS _5175_/D _5831_/A _5310_/B _5295_/B gf180mcu_as_sc_mcu7t3v3__ao21_2
XFILLER_5_1208 VDD VDD VSS VSS gf180mcu_as_sc_mcu7t3v3__fillcap_16
XPHY_EDGE_ROW_52_3_Left_757 VDD VSS gf180mcu_as_sc_mcu7t3v3__tap_2
X_4125_ VDD VDD VSS VSS _4143_/S _6175_/Q _6174_/Q _6174_/D gf180mcu_as_sc_mcu7t3v3__mux2_2
XFILLER_45_18 VDD VDD VSS VSS gf180mcu_as_sc_mcu7t3v3__fillcap_8
X_4056_ VDD VDD VSS VSS _4060_/B _6128_/Q _4057_/D gf180mcu_as_sc_mcu7t3v3__and2_2
X_3007_ VDD VDD VSS VSS _3637_/A _5943_/D gf180mcu_as_sc_mcu7t3v3__inv_2
XFILLER_149_1051 VDD VDD VSS VSS gf180mcu_as_sc_mcu7t3v3__fill_2
XFILLER_212_402 VDD VDD VSS VSS gf180mcu_as_sc_mcu7t3v3__fill_2
XTAP_TAPCELL_ROW_0_989 VDD VSS gf180mcu_as_sc_mcu7t3v3__tap_2
XFILLER_197_626 VDD VDD VSS VSS gf180mcu_as_sc_mcu7t3v3__fillcap_4
XFILLER_212_446 VDD VDD VSS VSS gf180mcu_as_sc_mcu7t3v3__fillcap_8
XFILLER_212_457 VDD VDD VSS VSS gf180mcu_as_sc_mcu7t3v3__fillcap_16
XFILLER_36_1210 VDD VDD VSS VSS gf180mcu_as_sc_mcu7t3v3__fillcap_8
X_4958_ VDD VDD VSS VSS _5307_/A _4958_/B _4958_/C _6374_/D _5957_/C gf180mcu_as_sc_mcu7t3v3__aoi211_2
XTAP_TAPCELL_ROW_64_2_2944 VDD VSS gf180mcu_as_sc_mcu7t3v3__tap_2
X_4889_ VDD VDD VSS VSS _4889_/D _4889_/A _4889_/B _4889_/C _4893_/B gf180mcu_as_sc_mcu7t3v3__ao31_2
X_3909_ VDD VDD VSS VSS _3929_/B _5890_/A _3909_/A _3910_/C gf180mcu_as_sc_mcu7t3v3__mux2_2
XFILLER_165_589 VDD VDD VSS VSS gf180mcu_as_sc_mcu7t3v3__fillcap_8
XFILLER_4_717 VDD VDD VSS VSS gf180mcu_as_sc_mcu7t3v3__fillcap_4
XFILLER_193_27 VDD VDD VSS VSS gf180mcu_as_sc_mcu7t3v3__fillcap_16
XFILLER_156_1011 VDD VDD VSS VSS gf180mcu_as_sc_mcu7t3v3__fillcap_4
XFILLER_156_1033 VDD VDD VSS VSS gf180mcu_as_sc_mcu7t3v3__fillcap_16
XTAP_TAPCELL_ROW_150_1436 VDD VSS gf180mcu_as_sc_mcu7t3v3__tap_2
XTAP_TAPCELL_ROW_150_1447 VDD VSS gf180mcu_as_sc_mcu7t3v3__tap_2
XFILLER_161_784 VDD VDD VSS VSS gf180mcu_as_sc_mcu7t3v3__fillcap_8
Xoutput370 VDD VDD VSS VSS _6443_/Q east_out[30] gf180mcu_as_sc_mcu7t3v3__buff_12
XFILLER_43_1214 VDD VDD VSS VSS gf180mcu_as_sc_mcu7t3v3__fill_1
Xfanout1006 VDD VDD VSS VSS _5925_/D _5957_/C gf180mcu_as_sc_mcu7t3v3__buff_12
Xoutput392 VDD VDD VSS VSS _6359_/Q north_out[18] gf180mcu_as_sc_mcu7t3v3__buff_12
Xoutput381 VDD VDD VSS VSS _6421_/Q east_out[8] gf180mcu_as_sc_mcu7t3v3__buff_12
XFILLER_16_846 VDD VDD VSS VSS gf180mcu_as_sc_mcu7t3v3__fillcap_4
XFILLER_16_868 VDD VDD VSS VSS gf180mcu_as_sc_mcu7t3v3__fillcap_16
XFILLER_15_367 VDD VDD VSS VSS gf180mcu_as_sc_mcu7t3v3__fill_2
XFILLER_203_435 VDD VDD VSS VSS gf180mcu_as_sc_mcu7t3v3__fillcap_8
XFILLER_204_947 VDD VDD VSS VSS gf180mcu_as_sc_mcu7t3v3__fillcap_16
XFILLER_11_540 VDD VDD VSS VSS gf180mcu_as_sc_mcu7t3v3__fill_2
XFILLER_156_501 VDD VDD VSS VSS gf180mcu_as_sc_mcu7t3v3__fill_2
XFILLER_11_584 VDD VDD VSS VSS gf180mcu_as_sc_mcu7t3v3__fill_1
XFILLER_184_832 VDD VDD VSS VSS gf180mcu_as_sc_mcu7t3v3__fillcap_4
XTAP_TAPCELL_ROW_215_2613 VDD VSS gf180mcu_as_sc_mcu7t3v3__tap_2
XFILLER_156_589 VDD VDD VSS VSS gf180mcu_as_sc_mcu7t3v3__fillcap_4
XFILLER_167_72 VDD VDD VSS VSS gf180mcu_as_sc_mcu7t3v3__fillcap_16
XFILLER_13_1084 VDD VDD VSS VSS gf180mcu_as_sc_mcu7t3v3__fillcap_16
XPHY_EDGE_ROW_25_1_Left_253 VDD VSS gf180mcu_as_sc_mcu7t3v3__tap_2
XFILLER_171_559 VDD VDD VSS VSS gf180mcu_as_sc_mcu7t3v3__fill_1
XFILLER_112_615 VDD VDD VSS VSS gf180mcu_as_sc_mcu7t3v3__fill_1
XFILLER_170_1008 VDD VDD VSS VSS gf180mcu_as_sc_mcu7t3v3__fillcap_4
XFILLER_0_1105 VDD VDD VSS VSS gf180mcu_as_sc_mcu7t3v3__fillcap_4
XFILLER_4_1263 VDD VDD VSS VSS gf180mcu_as_sc_mcu7t3v3__fill_2
XFILLER_59_1210 VDD VDD VSS VSS gf180mcu_as_sc_mcu7t3v3__fill_1
X_5930_ VDD VDD VSS VSS _5930_/A _5936_/B _5930_/C _5930_/D _5931_/D gf180mcu_as_sc_mcu7t3v3__ao22_2
XFILLER_185_1262 VDD VDD VSS VSS gf180mcu_as_sc_mcu7t3v3__fill_2
XFILLER_222_744 VDD VDD VSS VSS gf180mcu_as_sc_mcu7t3v3__fill_1
XFILLER_34_654 VDD VDD VSS VSS gf180mcu_as_sc_mcu7t3v3__fillcap_8
X_5861_ VDD VDD VSS VSS _5861_/B _5861_/A _5864_/C gf180mcu_as_sc_mcu7t3v3__and2_2
XFILLER_15_890 VDD VDD VSS VSS gf180mcu_as_sc_mcu7t3v3__fillcap_16
XFILLER_194_607 VDD VDD VSS VSS gf180mcu_as_sc_mcu7t3v3__fillcap_4
X_5792_ VDD VDD VSS VSS _5792_/A _5800_/B _5792_/C _5792_/D _5794_/C gf180mcu_as_sc_mcu7t3v3__ao211_2
X_4812_ VDD VDD VSS VSS _5159_/A _4878_/B _4812_/C _4813_/D _4851_/B gf180mcu_as_sc_mcu7t3v3__aoi211_2
XFILLER_159_372 VDD VDD VSS VSS gf180mcu_as_sc_mcu7t3v3__fillcap_4
X_4743_ VDD VDD VSS VSS _4743_/B _5978_/A _6350_/D gf180mcu_as_sc_mcu7t3v3__and2_2
XFILLER_187_692 VDD VDD VSS VSS gf180mcu_as_sc_mcu7t3v3__fillcap_8
XFILLER_222_1189 VDD VDD VSS VSS gf180mcu_as_sc_mcu7t3v3__fillcap_16
X_6413_ VDD VDD VSS VSS _6437_/CLK _6413_/D _6413_/Q gf180mcu_as_sc_mcu7t3v3__dfxtp_2
X_4674_ VDD VDD VSS VSS _5690_/B _4784_/B _4674_/C _4674_/D _4676_/C gf180mcu_as_sc_mcu7t3v3__ao22_2
X_3625_ VDD VDD VSS VSS _5936_/D _3625_/B _3625_/C _5943_/D _4648_/A gf180mcu_as_sc_mcu7t3v3__ao22_2
XFILLER_66_1214 VDD VDD VSS VSS gf180mcu_as_sc_mcu7t3v3__fill_2
X_6344_ VDD VDD VSS VSS _6526_/CLK _6344_/D _6344_/Q gf180mcu_as_sc_mcu7t3v3__dfxtp_2
Xmax_cap753 VDD VDD VSS VSS _5741_/S _5798_/S gf180mcu_as_sc_mcu7t3v3__clkbuff_12
X_3556_ VDD VDD VSS VSS _3556_/A _3556_/B _3556_/C _3556_/D _3558_/B gf180mcu_as_sc_mcu7t3v3__nand4_2
X_6275_ VDD VDD VSS VSS _6552_/CLK _6275_/D _6275_/Q gf180mcu_as_sc_mcu7t3v3__dfxtp_2
XFILLER_170_592 VDD VDD VSS VSS gf180mcu_as_sc_mcu7t3v3__fill_2
Xinput109 VDD VDD VSS VSS ne_in[30] _5923_/A gf180mcu_as_sc_mcu7t3v3__buff_12
X_5226_ VDD VDD VSS VSS _5874_/A _5315_/B _5226_/C _5873_/A _5227_/D gf180mcu_as_sc_mcu7t3v3__ao22_2
X_3487_ VDD VDD VSS VSS _4632_/C _5953_/D _3638_/A gf180mcu_as_sc_mcu7t3v3__nor2_2
X_5157_ VDD VDD VSS VSS _5157_/D _5816_/A _5222_/B _5222_/C _5158_/C gf180mcu_as_sc_mcu7t3v3__ao31_2
X_5088_ VDD VDD VSS VSS _5143_/B _5752_/A _5088_/A _5089_/C gf180mcu_as_sc_mcu7t3v3__mux2_2
X_4108_ VDD VDD VSS VSS _4468_/A _4108_/A _4444_/B gf180mcu_as_sc_mcu7t3v3__and2_2
XFILLER_25_610 VDD VDD VSS VSS gf180mcu_as_sc_mcu7t3v3__fill_2
X_4039_ VDD VDD VSS VSS _4055_/S _4039_/B _6118_/Q _6118_/D gf180mcu_as_sc_mcu7t3v3__mux2_2
XFILLER_112_45 VDD VDD VSS VSS gf180mcu_as_sc_mcu7t3v3__fillcap_4
XFILLER_197_401 VDD VDD VSS VSS gf180mcu_as_sc_mcu7t3v3__fillcap_4
XFILLER_72_49 VDD VDD VSS VSS gf180mcu_as_sc_mcu7t3v3__fill_2
XFILLER_169_136 VDD VDD VSS VSS gf180mcu_as_sc_mcu7t3v3__fillcap_4
XFILLER_169_158 VDD VDD VSS VSS gf180mcu_as_sc_mcu7t3v3__fillcap_16
XFILLER_188_27 VDD VDD VSS VSS gf180mcu_as_sc_mcu7t3v3__fillcap_8
XFILLER_198_979 VDD VDD VSS VSS gf180mcu_as_sc_mcu7t3v3__fillcap_16
XFILLER_197_478 VDD VDD VSS VSS gf180mcu_as_sc_mcu7t3v3__fill_2
XPHY_EDGE_ROW_90_1_Left_318 VDD VSS gf180mcu_as_sc_mcu7t3v3__tap_2
XFILLER_162_1081 VDD VDD VSS VSS gf180mcu_as_sc_mcu7t3v3__fillcap_4
XFILLER_197_1100 VDD VDD VSS VSS gf180mcu_as_sc_mcu7t3v3__fillcap_16
XFILLER_197_1122 VDD VDD VSS VSS gf180mcu_as_sc_mcu7t3v3__fillcap_16
XFILLER_192_161 VDD VDD VSS VSS gf180mcu_as_sc_mcu7t3v3__fillcap_4
XFILLER_153_548 VDD VDD VSS VSS gf180mcu_as_sc_mcu7t3v3__fill_1
XTAP_TAPCELL_ROW_210_2521 VDD VSS gf180mcu_as_sc_mcu7t3v3__tap_2
XTAP_TAPCELL_ROW_189_2144 VDD VSS gf180mcu_as_sc_mcu7t3v3__tap_2
XFILLER_4_569 VDD VDD VSS VSS gf180mcu_as_sc_mcu7t3v3__fill_1
XFILLER_97_24 VDD VDD VSS VSS gf180mcu_as_sc_mcu7t3v3__fill_2
XTAP_TAPCELL_ROW_11_1207 VDD VSS gf180mcu_as_sc_mcu7t3v3__tap_2
XTAP_TAPCELL_ROW_167_1741 VDD VSS gf180mcu_as_sc_mcu7t3v3__tap_2
XTAP_TAPCELL_ROW_167_1752 VDD VSS gf180mcu_as_sc_mcu7t3v3__tap_2
XFILLER_169_1224 VDD VDD VSS VSS gf180mcu_as_sc_mcu7t3v3__fillcap_16
XFILLER_208_527 VDD VDD VSS VSS gf180mcu_as_sc_mcu7t3v3__fillcap_16
XTAP_TAPCELL_ROW_11_1218 VDD VSS gf180mcu_as_sc_mcu7t3v3__tap_2
XTAP_TAPCELL_ROW_208_2483 VDD VSS gf180mcu_as_sc_mcu7t3v3__tap_2
XTAP_TAPCELL_ROW_208_2494 VDD VSS gf180mcu_as_sc_mcu7t3v3__tap_2
XFILLER_16_621 VDD VDD VSS VSS gf180mcu_as_sc_mcu7t3v3__fillcap_4
XFILLER_223_508 VDD VDD VSS VSS gf180mcu_as_sc_mcu7t3v3__fill_2
XTAP_TAPCELL_ROW_180_1985 VDD VSS gf180mcu_as_sc_mcu7t3v3__tap_2
XTAP_TAPCELL_ROW_180_1974 VDD VSS gf180mcu_as_sc_mcu7t3v3__tap_2
XFILLER_15_120 VDD VDD VSS VSS gf180mcu_as_sc_mcu7t3v3__fillcap_16
XFILLER_15_142 VDD VDD VSS VSS gf180mcu_as_sc_mcu7t3v3__fillcap_16
XFILLER_16_698 VDD VDD VSS VSS gf180mcu_as_sc_mcu7t3v3__fillcap_16
XFILLER_188_478 VDD VDD VSS VSS gf180mcu_as_sc_mcu7t3v3__fillcap_4
XFILLER_12_871 VDD VDD VSS VSS gf180mcu_as_sc_mcu7t3v3__fillcap_4
XFILLER_12_893 VDD VDD VSS VSS gf180mcu_as_sc_mcu7t3v3__fillcap_16
XFILLER_7_330 VDD VDD VSS VSS gf180mcu_as_sc_mcu7t3v3__fillcap_8
XFILLER_7_352 VDD VDD VSS VSS gf180mcu_as_sc_mcu7t3v3__fill_1
XFILLER_7_88 VDD VDD VSS VSS gf180mcu_as_sc_mcu7t3v3__fillcap_16
XFILLER_171_356 VDD VDD VSS VSS gf180mcu_as_sc_mcu7t3v3__fill_1
X_4390_ VDD VDD VSS VSS _4405_/S _6124_/Q _4390_/C _4404_/D _4394_/C gf180mcu_as_sc_mcu7t3v3__ao211_2
X_3410_ VDD VDD VSS VSS _3410_/B _3413_/A _4466_/A gf180mcu_as_sc_mcu7t3v3__and2_2
X_3341_ VDD VDD VSS VSS _6208_/Q _3361_/B _4098_/S _6216_/Q _3346_/B gf180mcu_as_sc_mcu7t3v3__ao22_2
X_6060_ VDD VDD VSS VSS _6371_/CLK _6060_/D _6060_/Q gf180mcu_as_sc_mcu7t3v3__dfxtp_2
X_3272_ VDD VDD VSS VSS _3281_/D _3272_/B _6303_/Q _3275_/A gf180mcu_as_sc_mcu7t3v3__mux2_2
XTAP_TAPCELL_ROW_228_2859 VDD VSS gf180mcu_as_sc_mcu7t3v3__tap_2
XTAP_TAPCELL_ROW_228_2848 VDD VSS gf180mcu_as_sc_mcu7t3v3__tap_2
XTAP_TAPCELL_ROW_228_2837 VDD VSS gf180mcu_as_sc_mcu7t3v3__tap_2
XFILLER_100_629 VDD VDD VSS VSS gf180mcu_as_sc_mcu7t3v3__fillcap_4
X_5011_ VDD VDD VSS VSS _5013_/C _5681_/A _5140_/B _5011_/C gf180mcu_as_sc_mcu7t3v3__ao21_2
XFILLER_213_88 VDD VDD VSS VSS gf180mcu_as_sc_mcu7t3v3__fillcap_16
XFILLER_214_519 VDD VDD VSS VSS gf180mcu_as_sc_mcu7t3v3__fillcap_4
X_5913_ VDD VDD VSS VSS _5913_/A _5922_/B _5913_/C _5913_/D _5915_/C gf180mcu_as_sc_mcu7t3v3__ao211_2
X_5844_ VDD VDD VSS VSS _6469_/D _5844_/C _5844_/B _5844_/A gf180mcu_as_sc_mcu7t3v3__aoi21b_2
XFILLER_167_629 VDD VDD VSS VSS gf180mcu_as_sc_mcu7t3v3__fill_1
XFILLER_179_489 VDD VDD VSS VSS gf180mcu_as_sc_mcu7t3v3__fill_1
XFILLER_22_657 VDD VDD VSS VSS gf180mcu_as_sc_mcu7t3v3__fillcap_8
XFILLER_166_139 VDD VDD VSS VSS gf180mcu_as_sc_mcu7t3v3__fillcap_16
X_5775_ VDD VDD VSS VSS _5775_/A _5871_/B _5775_/C _5871_/D _5776_/D gf180mcu_as_sc_mcu7t3v3__ao22_2
X_4726_ VDD VDD VSS VSS _4857_/B _5740_/A _4727_/C gf180mcu_as_sc_mcu7t3v3__and2_2
XFILLER_163_846 VDD VDD VSS VSS gf180mcu_as_sc_mcu7t3v3__fill_1
X_4657_ VDD VDD VSS VSS _4658_/C _5669_/A _4871_/B _4657_/C gf180mcu_as_sc_mcu7t3v3__ao21_2
Xinput80 VDD VDD VSS VSS east_in[4] _5706_/A gf180mcu_as_sc_mcu7t3v3__buff_12
Xinput91 VDD VDD VSS VSS ne_in[14] _5793_/D gf180mcu_as_sc_mcu7t3v3__buff_12
X_3608_ VDD VDD VSS VSS _3655_/A _3608_/B _3608_/C _3658_/B gf180mcu_as_sc_mcu7t3v3__nor3_2
XFILLER_190_698 VDD VDD VSS VSS gf180mcu_as_sc_mcu7t3v3__fillcap_4
X_6327_ VDD VDD VSS VSS _6551_/CLK _6327_/D _6327_/Q gf180mcu_as_sc_mcu7t3v3__dfxtp_2
X_4588_ VDD VDD VSS VSS _6316_/Q _6135_/Q _4602_/C _4601_/C _4598_/B gf180mcu_as_sc_mcu7t3v3__ao211_2
XFILLER_153_1014 VDD VDD VSS VSS gf180mcu_as_sc_mcu7t3v3__fillcap_16
X_3539_ VDD VDD VSS VSS _4617_/A _3543_/B _5310_/A gf180mcu_as_sc_mcu7t3v3__nand2b_2
XFILLER_67_27 VDD VDD VSS VSS gf180mcu_as_sc_mcu7t3v3__fillcap_16
Xclkbuf_leaf_22_clk_regs VDD VDD VSS VSS clkbuf_3_4_0_clk_regs/Y _6520_/CLK gf180mcu_as_sc_mcu7t3v3__clkbuff_12
X_6258_ VDD VDD VSS VSS _6313_/CLK _6258_/D _6258_/Q gf180mcu_as_sc_mcu7t3v3__dfxtp_2
X_6189_ VDD VDD VSS VSS _6490_/CLK _6189_/D _6189_/Q gf180mcu_as_sc_mcu7t3v3__dfxtp_2
X_5209_ VDD VDD VSS VSS _5267_/S _5859_/A _5209_/A _5210_/B gf180mcu_as_sc_mcu7t3v3__mux2_2
XTAP_TAPCELL_ROW_184_2052 VDD VSS gf180mcu_as_sc_mcu7t3v3__tap_2
XTAP_TAPCELL_ROW_52_2_2926 VDD VSS gf180mcu_as_sc_mcu7t3v3__tap_2
XFILLER_189_209 VDD VDD VSS VSS gf180mcu_as_sc_mcu7t3v3__fill_1
XTAP_TAPCELL_ROW_162_1660 VDD VSS gf180mcu_as_sc_mcu7t3v3__tap_2
XFILLER_16_31 VDD VDD VSS VSS gf180mcu_as_sc_mcu7t3v3__fill_2
XFILLER_199_59 VDD VDD VSS VSS gf180mcu_as_sc_mcu7t3v3__fillcap_8
XFILLER_198_743 VDD VDD VSS VSS gf180mcu_as_sc_mcu7t3v3__fill_1
XTAP_TAPCELL_ROW_203_2391 VDD VSS gf180mcu_as_sc_mcu7t3v3__tap_2
XFILLER_12_123 VDD VDD VSS VSS gf180mcu_as_sc_mcu7t3v3__fillcap_16
XFILLER_186_938 VDD VDD VSS VSS gf180mcu_as_sc_mcu7t3v3__fill_1
XFILLER_213_574 VDD VDD VSS VSS gf180mcu_as_sc_mcu7t3v3__fillcap_8
XFILLER_197_286 VDD VDD VSS VSS gf180mcu_as_sc_mcu7t3v3__fill_2
XFILLER_201_769 VDD VDD VSS VSS gf180mcu_as_sc_mcu7t3v3__fill_1
XFILLER_225_2 VDD VDD VSS VSS gf180mcu_as_sc_mcu7t3v3__fillcap_16
XFILLER_181_632 VDD VDD VSS VSS gf180mcu_as_sc_mcu7t3v3__fill_1
XFILLER_193_492 VDD VDD VSS VSS gf180mcu_as_sc_mcu7t3v3__fill_2
XFILLER_10_1065 VDD VDD VSS VSS gf180mcu_as_sc_mcu7t3v3__fillcap_16
XFILLER_153_356 VDD VDD VSS VSS gf180mcu_as_sc_mcu7t3v3__fill_1
XFILLER_10_1087 VDD VDD VSS VSS gf180mcu_as_sc_mcu7t3v3__fillcap_16
XFILLER_136_1245 VDD VDD VSS VSS gf180mcu_as_sc_mcu7t3v3__fillcap_16
XFILLER_208_302 VDD VDD VSS VSS gf180mcu_as_sc_mcu7t3v3__fill_1
XTAP_TAPCELL_ROW_223_2756 VDD VSS gf180mcu_as_sc_mcu7t3v3__tap_2
XFILLER_223_338 VDD VDD VSS VSS gf180mcu_as_sc_mcu7t3v3__fill_1
XFILLER_182_1221 VDD VDD VSS VSS gf180mcu_as_sc_mcu7t3v3__fillcap_4
XPHY_EDGE_ROW_49_2_Left_490 VDD VSS gf180mcu_as_sc_mcu7t3v3__tap_2
XFILLER_188_242 VDD VDD VSS VSS gf180mcu_as_sc_mcu7t3v3__fill_2
X_3890_ VDD VDD VSS VSS _3910_/B _5874_/A _3891_/D gf180mcu_as_sc_mcu7t3v3__and2_2
XFILLER_223_1240 VDD VDD VSS VSS gf180mcu_as_sc_mcu7t3v3__fillcap_16
XFILLER_223_1262 VDD VDD VSS VSS gf180mcu_as_sc_mcu7t3v3__fill_2
X_5560_ VDD VDD VSS VSS _5584_/C _5866_/A _5560_/A _5561_/A gf180mcu_as_sc_mcu7t3v3__mux2_2
XFILLER_157_684 VDD VDD VSS VSS gf180mcu_as_sc_mcu7t3v3__fill_1
XFILLER_185_982 VDD VDD VSS VSS gf180mcu_as_sc_mcu7t3v3__fillcap_16
XFILLER_191_429 VDD VDD VSS VSS gf180mcu_as_sc_mcu7t3v3__fill_2
XPHY_EDGE_ROW_61_3_Left_766 VDD VSS gf180mcu_as_sc_mcu7t3v3__tap_2
X_5491_ VDD VDD VSS VSS _5799_/A _5491_/B _5491_/C _5798_/B _5492_/D gf180mcu_as_sc_mcu7t3v3__ao22_2
X_4511_ VDD VDD VSS VSS _4511_/D _4511_/A _4582_/A _4539_/C _4527_/S gf180mcu_as_sc_mcu7t3v3__ao31_2
XFILLER_171_120 VDD VDD VSS VSS gf180mcu_as_sc_mcu7t3v3__fillcap_16
XFILLER_176_1014 VDD VDD VSS VSS gf180mcu_as_sc_mcu7t3v3__fill_1
XPHY_EDGE_ROW_68_2_Left_509 VDD VSS gf180mcu_as_sc_mcu7t3v3__tap_2
X_4442_ VDD VDD VSS VSS _6258_/Q _4442_/B _4442_/C _6257_/Q _6257_/D gf180mcu_as_sc_mcu7t3v3__ao22_2
XFILLER_171_142 VDD VDD VSS VSS gf180mcu_as_sc_mcu7t3v3__fillcap_16
XTAP_TAPCELL_ROW_135_2_3051 VDD VSS gf180mcu_as_sc_mcu7t3v3__tap_2
X_4373_ VDD VDD VSS VSS _4394_/A _4373_/B _4373_/C _4374_/B _4373_/D gf180mcu_as_sc_mcu7t3v3__oai211_2
Xfanout607 VDD VDD VSS VSS _4843_/B _4863_/B gf180mcu_as_sc_mcu7t3v3__buff_12
Xfanout618 VDD VDD VSS VSS _3360_/A _3353_/A gf180mcu_as_sc_mcu7t3v3__buff_12
Xfanout629 VDD VDD VSS VSS _5207_/B _5315_/B gf180mcu_as_sc_mcu7t3v3__buff_12
X_6112_ VDD VDD VSS VSS _6371_/CLK _6112_/D _6112_/Q gf180mcu_as_sc_mcu7t3v3__dfxtp_2
X_3324_ VDD VDD VSS VSS _3325_/D _3356_/A _3355_/B _3324_/A gf180mcu_as_sc_mcu7t3v3__aoi21b_2
X_6043_ VDD VDD VSS VSS _6376_/CLK _6043_/D _6043_/Q gf180mcu_as_sc_mcu7t3v3__dfxtp_2
X_3255_ VDD VDD VSS VSS _3257_/C _3255_/B _3343_/A gf180mcu_as_sc_mcu7t3v3__nor2_2
X_3186_ VDD VDD VSS VSS _4558_/A _4571_/C _3187_/D gf180mcu_as_sc_mcu7t3v3__and2_2
XFILLER_187_1154 VDD VDD VSS VSS gf180mcu_as_sc_mcu7t3v3__fillcap_16
XFILLER_227_699 VDD VDD VSS VSS gf180mcu_as_sc_mcu7t3v3__fill_1
XTAP_TAPCELL_ROW_3_1069 VDD VSS gf180mcu_as_sc_mcu7t3v3__tap_2
XFILLER_228_1162 VDD VDD VSS VSS gf180mcu_as_sc_mcu7t3v3__fill_2
XPHY_EDGE_ROW_102_1_Left_330 VDD VSS gf180mcu_as_sc_mcu7t3v3__tap_2
XFILLER_195_713 VDD VDD VSS VSS gf180mcu_as_sc_mcu7t3v3__fill_2
XFILLER_194_223 VDD VDD VSS VSS gf180mcu_as_sc_mcu7t3v3__fillcap_4
XFILLER_195_746 VDD VDD VSS VSS gf180mcu_as_sc_mcu7t3v3__fill_1
X_5827_ VDD VDD VSS VSS _5875_/S _5827_/B _5827_/A _5828_/B gf180mcu_as_sc_mcu7t3v3__mux2_2
XFILLER_183_908 VDD VDD VSS VSS gf180mcu_as_sc_mcu7t3v3__fill_2
X_5758_ VDD VDD VSS VSS _5758_/A _5931_/B _5758_/C _5855_/D _5759_/D gf180mcu_as_sc_mcu7t3v3__ao22_2
X_4709_ VDD VDD VSS VSS _5726_/A _4875_/B _4709_/C _4867_/D _4713_/B gf180mcu_as_sc_mcu7t3v3__ao211_2
XFILLER_194_1103 VDD VDD VSS VSS gf180mcu_as_sc_mcu7t3v3__fillcap_16
X_5689_ VDD VDD VSS VSS _5797_/B _5689_/A _5692_/C gf180mcu_as_sc_mcu7t3v3__and2_2
XFILLER_151_805 VDD VDD VSS VSS gf180mcu_as_sc_mcu7t3v3__fillcap_16
XFILLER_190_451 VDD VDD VSS VSS gf180mcu_as_sc_mcu7t3v3__fillcap_4
XFILLER_200_1081 VDD VDD VSS VSS gf180mcu_as_sc_mcu7t3v3__fillcap_4
XFILLER_2_804 VDD VDD VSS VSS gf180mcu_as_sc_mcu7t3v3__fill_1
XFILLER_150_337 VDD VDD VSS VSS gf180mcu_as_sc_mcu7t3v3__fill_2
XFILLER_78_37 VDD VDD VSS VSS gf180mcu_as_sc_mcu7t3v3__fillcap_4
XFILLER_2_859 VDD VDD VSS VSS gf180mcu_as_sc_mcu7t3v3__fillcap_16
XTAP_TAPCELL_ROW_164_1700 VDD VSS gf180mcu_as_sc_mcu7t3v3__tap_2
XTAP_TAPCELL_ROW_205_2431 VDD VSS gf180mcu_as_sc_mcu7t3v3__tap_2
XFILLER_166_1205 VDD VDD VSS VSS gf180mcu_as_sc_mcu7t3v3__fillcap_16
XFILLER_206_828 VDD VDD VSS VSS gf180mcu_as_sc_mcu7t3v3__fill_2
XTAP_TAPCELL_ROW_160_1619 VDD VSS gf180mcu_as_sc_mcu7t3v3__tap_2
XFILLER_150_53 VDD VDD VSS VSS gf180mcu_as_sc_mcu7t3v3__fillcap_16
XFILLER_166_1227 VDD VDD VSS VSS gf180mcu_as_sc_mcu7t3v3__fillcap_16
XPHY_EDGE_ROW_34_1_Left_262 VDD VSS gf180mcu_as_sc_mcu7t3v3__tap_2
XFILLER_13_432 VDD VDD VSS VSS gf180mcu_as_sc_mcu7t3v3__fillcap_16
XFILLER_207_1224 VDD VDD VSS VSS gf180mcu_as_sc_mcu7t3v3__fillcap_8
XTAP_TAPCELL_ROW_197_2287 VDD VSS gf180mcu_as_sc_mcu7t3v3__tap_2
XFILLER_201_555 VDD VDD VSS VSS gf180mcu_as_sc_mcu7t3v3__fillcap_4
XFILLER_16_1230 VDD VDD VSS VSS gf180mcu_as_sc_mcu7t3v3__fill_2
XFILLER_199_1014 VDD VDD VSS VSS gf180mcu_as_sc_mcu7t3v3__fillcap_16
XTAP_TAPCELL_ROW_175_1884 VDD VSS gf180mcu_as_sc_mcu7t3v3__tap_2
XFILLER_153_120 VDD VDD VSS VSS gf180mcu_as_sc_mcu7t3v3__fillcap_16
XTAP_TAPCELL_ROW_175_1895 VDD VSS gf180mcu_as_sc_mcu7t3v3__tap_2
XFILLER_153_142 VDD VDD VSS VSS gf180mcu_as_sc_mcu7t3v3__fillcap_16
XFILLER_181_462 VDD VDD VSS VSS gf180mcu_as_sc_mcu7t3v3__fill_1
XFILLER_154_698 VDD VDD VSS VSS gf180mcu_as_sc_mcu7t3v3__fillcap_16
XFILLER_175_72 VDD VDD VSS VSS gf180mcu_as_sc_mcu7t3v3__fillcap_16
XFILLER_4_174 VDD VDD VSS VSS gf180mcu_as_sc_mcu7t3v3__fill_1
XFILLER_5_697 VDD VDD VSS VSS gf180mcu_as_sc_mcu7t3v3__fill_2
XPHY_EDGE_ROW_120_2_Right_957 VDD VSS gf180mcu_as_sc_mcu7t3v3__tap_2
XFILLER_150_871 VDD VDD VSS VSS gf180mcu_as_sc_mcu7t3v3__fillcap_4
XFILLER_62_1261 VDD VDD VSS VSS gf180mcu_as_sc_mcu7t3v3__fillcap_4
XFILLER_209_622 VDD VDD VSS VSS gf180mcu_as_sc_mcu7t3v3__fillcap_8
Xinput270 VDD VDD VSS VSS sw_in[12] wire987/A gf180mcu_as_sc_mcu7t3v3__buff_12
Xinput281 VDD VDD VSS VSS sw_in[22] _5859_/A gf180mcu_as_sc_mcu7t3v3__buff_12
X_3040_ VDD VDD VSS VSS _3040_/Y _3178_/A gf180mcu_as_sc_mcu7t3v3__inv_2
Xinput292 VDD VDD VSS VSS sw_in[32] _5941_/A gf180mcu_as_sc_mcu7t3v3__buff_12
XTAP_TAPCELL_ROW_22_2_2881 VDD VSS gf180mcu_as_sc_mcu7t3v3__tap_2
XFILLER_1_1030 VDD VDD VSS VSS gf180mcu_as_sc_mcu7t3v3__fillcap_16
XFILLER_1_1052 VDD VDD VSS VSS gf180mcu_as_sc_mcu7t3v3__fillcap_16
XFILLER_223_146 VDD VDD VSS VSS gf180mcu_as_sc_mcu7t3v3__fill_2
X_4991_ VDD VDD VSS VSS _4992_/D _5675_/D _5221_/B _5224_/B gf180mcu_as_sc_mcu7t3v3__ao21_2
XFILLER_16_292 VDD VDD VSS VSS gf180mcu_as_sc_mcu7t3v3__fill_1
XFILLER_189_562 VDD VDD VSS VSS gf180mcu_as_sc_mcu7t3v3__fillcap_16
X_3942_ VDD VDD VSS VSS _4023_/B _3974_/D _3974_/B _6048_/Q _6048_/D gf180mcu_as_sc_mcu7t3v3__ao22_2
X_3873_ VDD VDD VSS VSS _3873_/S _3873_/B _5857_/A _3874_/D gf180mcu_as_sc_mcu7t3v3__mux2_2
XFILLER_149_448 VDD VDD VSS VSS gf180mcu_as_sc_mcu7t3v3__fill_2
X_5612_ VDD VDD VSS VSS _5612_/A _5628_/D _5634_/B _5918_/A _5613_/D gf180mcu_as_sc_mcu7t3v3__ao22_2
XFILLER_158_971 VDD VDD VSS VSS gf180mcu_as_sc_mcu7t3v3__fillcap_4
X_5543_ VDD VDD VSS VSS _5565_/B _5845_/A _5543_/A _5544_/D gf180mcu_as_sc_mcu7t3v3__mux2_2
XFILLER_157_492 VDD VDD VSS VSS gf180mcu_as_sc_mcu7t3v3__fill_2
XFILLER_173_963 VDD VDD VSS VSS gf180mcu_as_sc_mcu7t3v3__fill_2
X_5474_ VDD VDD VSS VSS _6506_/Q _5490_/B _5491_/B _5783_/A _5475_/D gf180mcu_as_sc_mcu7t3v3__ao22_2
XFILLER_172_484 VDD VDD VSS VSS gf180mcu_as_sc_mcu7t3v3__fill_2
X_4425_ VDD VDD VSS VSS _6241_/Q _4428_/B _4425_/C _6240_/Q _6240_/D gf180mcu_as_sc_mcu7t3v3__ao22_2
X_4356_ VDD VDD VSS VSS _4363_/S _6061_/Q _6090_/Q _4357_/B gf180mcu_as_sc_mcu7t3v3__mux2_2
X_3307_ VDD VDD VSS VSS _3307_/B _3353_/A _3308_/D gf180mcu_as_sc_mcu7t3v3__or2_2
XFILLER_150_1017 VDD VDD VSS VSS gf180mcu_as_sc_mcu7t3v3__fillcap_16
X_4287_ VDD VDD VSS VSS _6209_/Q _4406_/B _4406_/C _6210_/Q _4288_/C gf180mcu_as_sc_mcu7t3v3__ao22_2
XTAP_TAPCELL_ROW_181_2000 VDD VSS gf180mcu_as_sc_mcu7t3v3__tap_2
X_6026_ VDD VDD VSS VSS _6519_/CLK _6026_/D _6026_/Q gf180mcu_as_sc_mcu7t3v3__dfxtp_2
X_3238_ VDD VDD VSS VSS _3238_/B _4462_/B _3240_/B gf180mcu_as_sc_mcu7t3v3__or2_2
XTAP_TAPCELL_ROW_5_1109 VDD VSS gf180mcu_as_sc_mcu7t3v3__tap_2
X_3169_ VDD VDD VSS VSS _6324_/Q _6532_/Q _3174_/B _4525_/A _3175_/A gf180mcu_as_sc_mcu7t3v3__nand4_2
XFILLER_120_34 VDD VDD VSS VSS gf180mcu_as_sc_mcu7t3v3__fill_1
XFILLER_120_45 VDD VDD VSS VSS gf180mcu_as_sc_mcu7t3v3__fillcap_4
XFILLER_214_179 VDD VDD VSS VSS gf180mcu_as_sc_mcu7t3v3__fill_1
XTAP_TAPCELL_ROW_200_2350 VDD VSS gf180mcu_as_sc_mcu7t3v3__tap_2
XFILLER_126_1233 VDD VDD VSS VSS gf180mcu_as_sc_mcu7t3v3__fillcap_8
XFILLER_147_6 VDD VDD VSS VSS gf180mcu_as_sc_mcu7t3v3__fillcap_8
XFILLER_167_212 VDD VDD VSS VSS gf180mcu_as_sc_mcu7t3v3__fillcap_4
XFILLER_10_468 VDD VDD VSS VSS gf180mcu_as_sc_mcu7t3v3__fillcap_4
XFILLER_155_418 VDD VDD VSS VSS gf180mcu_as_sc_mcu7t3v3__fill_2
XFILLER_129_43 VDD VDD VSS VSS gf180mcu_as_sc_mcu7t3v3__fillcap_8
XTAP_TAPCELL_ROW_157_1570 VDD VSS gf180mcu_as_sc_mcu7t3v3__tap_2
XTAP_TAPCELL_ROW_192_2195 VDD VSS gf180mcu_as_sc_mcu7t3v3__tap_2
XFILLER_150_101 VDD VDD VSS VSS gf180mcu_as_sc_mcu7t3v3__fillcap_4
XFILLER_164_996 VDD VDD VSS VSS gf180mcu_as_sc_mcu7t3v3__fillcap_16
XTAP_TAPCELL_ROW_153_1489 VDD VSS gf180mcu_as_sc_mcu7t3v3__tap_2
XFILLER_150_123 VDD VDD VSS VSS gf180mcu_as_sc_mcu7t3v3__fillcap_16
XTAP_TAPCELL_ROW_40_2_2908 VDD VSS gf180mcu_as_sc_mcu7t3v3__tap_2
XFILLER_46_1245 VDD VDD VSS VSS gf180mcu_as_sc_mcu7t3v3__fillcap_16
XFILLER_133_1226 VDD VDD VSS VSS gf180mcu_as_sc_mcu7t3v3__fillcap_8
Xfanout971 VDD VDD VSS VSS _3332_/A _3299_/A gf180mcu_as_sc_mcu7t3v3__buff_12
Xfanout982 VDD VDD VSS VSS _5323_/A _5340_/A gf180mcu_as_sc_mcu7t3v3__buff_12
Xfanout993 VDD VDD VSS VSS _3363_/B _3355_/B gf180mcu_as_sc_mcu7t3v3__buff_12
XTAP_TAPCELL_ROW_199_2316 VDD VSS gf180mcu_as_sc_mcu7t3v3__tap_2
Xhold1191 VDD VDD VSS VSS _6237_/Q _3194_/A gf180mcu_as_sc_mcu7t3v3__clkbuff_4
XTAP_TAPCELL_ROW_220_2704 VDD VSS gf180mcu_as_sc_mcu7t3v3__tap_2
XTAP_TAPCELL_ROW_199_2327 VDD VSS gf180mcu_as_sc_mcu7t3v3__tap_2
XFILLER_92_1210 VDD VDD VSS VSS gf180mcu_as_sc_mcu7t3v3__fillcap_8
XFILLER_14_741 VDD VDD VSS VSS gf180mcu_as_sc_mcu7t3v3__fill_1
XFILLER_199_860 VDD VDD VSS VSS gf180mcu_as_sc_mcu7t3v3__fill_1
XTAP_TAPCELL_ROW_177_1924 VDD VSS gf180mcu_as_sc_mcu7t3v3__tap_2
XTAP_TAPCELL_ROW_177_1935 VDD VSS gf180mcu_as_sc_mcu7t3v3__tap_2
XFILLER_159_768 VDD VDD VSS VSS gf180mcu_as_sc_mcu7t3v3__fill_2
XFILLER_202_864 VDD VDD VSS VSS gf180mcu_as_sc_mcu7t3v3__fill_1
XFILLER_202_886 VDD VDD VSS VSS gf180mcu_as_sc_mcu7t3v3__fill_1
XFILLER_53_1238 VDD VDD VSS VSS gf180mcu_as_sc_mcu7t3v3__fill_2
XFILLER_127_610 VDD VDD VSS VSS gf180mcu_as_sc_mcu7t3v3__fillcap_16
XFILLER_16_1060 VDD VDD VSS VSS gf180mcu_as_sc_mcu7t3v3__fillcap_16
XFILLER_220_1221 VDD VDD VSS VSS gf180mcu_as_sc_mcu7t3v3__fillcap_4
XFILLER_9_244 VDD VDD VSS VSS gf180mcu_as_sc_mcu7t3v3__fillcap_16
XTAP_TAPCELL_ROW_218_2666 VDD VSS gf180mcu_as_sc_mcu7t3v3__tap_2
XFILLER_220_1243 VDD VDD VSS VSS gf180mcu_as_sc_mcu7t3v3__fillcap_16
Xclkload14 VDD VDD VSS VSS _6313_/CLK clkload14/Y gf180mcu_as_sc_mcu7t3v3__clkbuff_4
Xclkload25 VDD VDD VSS VSS clkload25/Y _6412_/CLK gf180mcu_as_sc_mcu7t3v3__inv_6
XFILLER_154_473 VDD VDD VSS VSS gf180mcu_as_sc_mcu7t3v3__fillcap_8
XFILLER_6_995 VDD VDD VSS VSS gf180mcu_as_sc_mcu7t3v3__fillcap_16
XFILLER_177_1186 VDD VDD VSS VSS gf180mcu_as_sc_mcu7t3v3__fillcap_4
XPHY_EDGE_ROW_121_2_Right_958 VDD VSS gf180mcu_as_sc_mcu7t3v3__tap_2
X_4210_ VDD VDD VSS VSS _4404_/D _4210_/B _4210_/A _4212_/B gf180mcu_as_sc_mcu7t3v3__mux2_2
X_5190_ VDD VDD VSS VSS _5190_/S _5844_/A _5190_/A _5191_/B gf180mcu_as_sc_mcu7t3v3__mux2_2
X_4141_ VDD VDD VSS VSS _4143_/S _6191_/Q _6190_/Q _6190_/D gf180mcu_as_sc_mcu7t3v3__mux2_2
XFILLER_205_67 VDD VDD VSS VSS gf180mcu_as_sc_mcu7t3v3__fill_2
X_4072_ VDD VDD VSS VSS _4072_/B _4072_/A _4077_/B gf180mcu_as_sc_mcu7t3v3__and2_2
XFILLER_209_452 VDD VDD VSS VSS gf180mcu_as_sc_mcu7t3v3__fillcap_8
X_3023_ VDD VDD VSS VSS _3477_/B _5914_/D gf180mcu_as_sc_mcu7t3v3__inv_2
XFILLER_209_496 VDD VDD VSS VSS gf180mcu_as_sc_mcu7t3v3__fill_1
XFILLER_149_1233 VDD VDD VSS VSS gf180mcu_as_sc_mcu7t3v3__fillcap_16
XFILLER_184_1135 VDD VDD VSS VSS gf180mcu_as_sc_mcu7t3v3__fillcap_16
XFILLER_221_66 VDD VDD VSS VSS gf180mcu_as_sc_mcu7t3v3__fillcap_4
XFILLER_225_978 VDD VDD VSS VSS gf180mcu_as_sc_mcu7t3v3__fill_2
XTAP_TAPCELL_ROW_0_1006 VDD VSS gf180mcu_as_sc_mcu7t3v3__tap_2
XTAP_TAPCELL_ROW_0_1017 VDD VSS gf180mcu_as_sc_mcu7t3v3__tap_2
XFILLER_184_1157 VDD VDD VSS VSS gf180mcu_as_sc_mcu7t3v3__fillcap_16
XFILLER_221_88 VDD VDD VSS VSS gf180mcu_as_sc_mcu7t3v3__fill_2
X_4974_ VDD VDD VSS VSS _4976_/C _4976_/D _4974_/Y gf180mcu_as_sc_mcu7t3v3__and2_2
XFILLER_149_201 VDD VDD VSS VSS gf180mcu_as_sc_mcu7t3v3__fill_2
XFILLER_205_680 VDD VDD VSS VSS gf180mcu_as_sc_mcu7t3v3__fill_1
XFILLER_225_1154 VDD VDD VSS VSS gf180mcu_as_sc_mcu7t3v3__fillcap_16
X_3925_ VDD VDD VSS VSS _5930_/A _3925_/B _3925_/C _5904_/A _3927_/C gf180mcu_as_sc_mcu7t3v3__ao22_2
XFILLER_149_256 VDD VDD VSS VSS gf180mcu_as_sc_mcu7t3v3__fillcap_16
XTAP_TAPCELL_ROW_123_2_3033 VDD VSS gf180mcu_as_sc_mcu7t3v3__tap_2
Xclkload8 VDD VDD VSS VSS clkload8/A clkload8/Y gf180mcu_as_sc_mcu7t3v3__clkbuff_4
X_3856_ VDD VDD VSS VSS _5844_/A _3856_/B _3856_/C _3856_/D _4049_/B gf180mcu_as_sc_mcu7t3v3__ao211_2
XFILLER_192_535 VDD VDD VSS VSS gf180mcu_as_sc_mcu7t3v3__fillcap_4
X_3787_ VDD VDD VSS VSS _3807_/S _5785_/A _3787_/A _3788_/C gf180mcu_as_sc_mcu7t3v3__mux2_2
XFILLER_118_665 VDD VDD VSS VSS gf180mcu_as_sc_mcu7t3v3__fill_2
XFILLER_164_259 VDD VDD VSS VSS gf180mcu_as_sc_mcu7t3v3__fill_2
XFILLER_3_409 VDD VDD VSS VSS gf180mcu_as_sc_mcu7t3v3__fillcap_4
XFILLER_69_1212 VDD VDD VSS VSS gf180mcu_as_sc_mcu7t3v3__fill_1
XPHY_EDGE_ROW_83_2_Right_920 VDD VSS gf180mcu_as_sc_mcu7t3v3__tap_2
X_5526_ VDD VDD VSS VSS _5833_/A _5569_/B _5526_/C _5584_/C _5527_/B gf180mcu_as_sc_mcu7t3v3__ao211_2
XFILLER_195_1264 VDD VDD VSS VSS gf180mcu_as_sc_mcu7t3v3__fill_1
X_5457_ VDD VDD VSS VSS _6423_/D _5457_/B _5843_/D gf180mcu_as_sc_mcu7t3v3__nor2_2
XFILLER_133_646 VDD VDD VSS VSS gf180mcu_as_sc_mcu7t3v3__fillcap_16
XFILLER_160_432 VDD VDD VSS VSS gf180mcu_as_sc_mcu7t3v3__fillcap_8
XPHY_EDGE_ROW_24_3_Left_729 VDD VSS gf180mcu_as_sc_mcu7t3v3__tap_2
X_4408_ VDD VDD VSS VSS _6133_/Q _4408_/B _4408_/C _4409_/B _4408_/D gf180mcu_as_sc_mcu7t3v3__oai211_2
XFILLER_160_465 VDD VDD VSS VSS gf180mcu_as_sc_mcu7t3v3__fill_2
X_5388_ VDD VDD VSS VSS _5494_/B _5697_/A _5393_/C gf180mcu_as_sc_mcu7t3v3__and2_2
X_4339_ VDD VDD VSS VSS _6216_/D _4339_/B _4339_/A gf180mcu_as_sc_mcu7t3v3__nand2_2
XFILLER_101_598 VDD VDD VSS VSS gf180mcu_as_sc_mcu7t3v3__fill_1
XFILLER_189_1046 VDD VDD VSS VSS gf180mcu_as_sc_mcu7t3v3__fillcap_4
X_6009_ VDD VDD VSS VSS _6010_/B _6200_/Q _6522_/D gf180mcu_as_sc_mcu7t3v3__and2_2
XFILLER_189_1068 VDD VDD VSS VSS gf180mcu_as_sc_mcu7t3v3__fillcap_16
XFILLER_227_282 VDD VDD VSS VSS gf180mcu_as_sc_mcu7t3v3__fillcap_16
XFILLER_15_505 VDD VDD VSS VSS gf180mcu_as_sc_mcu7t3v3__fillcap_4
XTAP_TAPCELL_ROW_86_1_1364 VDD VSS gf180mcu_as_sc_mcu7t3v3__tap_2
XFILLER_163_1208 VDD VDD VSS VSS gf180mcu_as_sc_mcu7t3v3__fillcap_16
XFILLER_203_628 VDD VDD VSS VSS gf180mcu_as_sc_mcu7t3v3__fill_2
XFILLER_70_666 VDD VDD VSS VSS gf180mcu_as_sc_mcu7t3v3__fill_1
XTAP_TAPCELL_ROW_159_1610 VDD VSS gf180mcu_as_sc_mcu7t3v3__tap_2
XTAP_TAPCELL_ROW_194_2235 VDD VSS gf180mcu_as_sc_mcu7t3v3__tap_2
XFILLER_11_722 VDD VDD VSS VSS gf180mcu_as_sc_mcu7t3v3__fill_2
XFILLER_204_1205 VDD VDD VSS VSS gf180mcu_as_sc_mcu7t3v3__fillcap_16
XFILLER_204_1227 VDD VDD VSS VSS gf180mcu_as_sc_mcu7t3v3__fillcap_16
XFILLER_11_755 VDD VDD VSS VSS gf180mcu_as_sc_mcu7t3v3__fill_1
XFILLER_11_766 VDD VDD VSS VSS gf180mcu_as_sc_mcu7t3v3__fillcap_4
XFILLER_196_874 VDD VDD VSS VSS gf180mcu_as_sc_mcu7t3v3__fill_1
XFILLER_196_1017 VDD VDD VSS VSS gf180mcu_as_sc_mcu7t3v3__fillcap_16
XFILLER_6_225 VDD VDD VSS VSS gf180mcu_as_sc_mcu7t3v3__fillcap_16
XTAP_TAPCELL_ROW_155_1529 VDD VSS gf180mcu_as_sc_mcu7t3v3__tap_2
XTAP_TAPCELL_ROW_172_1832 VDD VSS gf180mcu_as_sc_mcu7t3v3__tap_2
XFILLER_156_30 VDD VDD VSS VSS gf180mcu_as_sc_mcu7t3v3__fillcap_4
XFILLER_6_247 VDD VDD VSS VSS gf180mcu_as_sc_mcu7t3v3__fillcap_16
XTAP_TAPCELL_ROW_172_1843 VDD VSS gf180mcu_as_sc_mcu7t3v3__tap_2
XFILLER_124_624 VDD VDD VSS VSS gf180mcu_as_sc_mcu7t3v3__fill_2
XFILLER_152_944 VDD VDD VSS VSS gf180mcu_as_sc_mcu7t3v3__fill_1
XFILLER_164_771 VDD VDD VSS VSS gf180mcu_as_sc_mcu7t3v3__fill_1
XFILLER_170_229 VDD VDD VSS VSS gf180mcu_as_sc_mcu7t3v3__fillcap_4
XTAP_TAPCELL_ROW_213_2574 VDD VSS gf180mcu_as_sc_mcu7t3v3__tap_2
XFILLER_156_85 VDD VDD VSS VSS gf180mcu_as_sc_mcu7t3v3__fillcap_16
XTAP_TAPCELL_ROW_58_2_2935 VDD VSS gf180mcu_as_sc_mcu7t3v3__tap_2
XFILLER_2_453 VDD VDD VSS VSS gf180mcu_as_sc_mcu7t3v3__fill_2
XFILLER_3_998 VDD VDD VSS VSS gf180mcu_as_sc_mcu7t3v3__fillcap_16
XFILLER_207_912 VDD VDD VSS VSS gf180mcu_as_sc_mcu7t3v3__fillcap_16
Xfanout790 VDD VDD VSS VSS fanout791/Y _4861_/B gf180mcu_as_sc_mcu7t3v3__buff_12
XFILLER_168_1119 VDD VDD VSS VSS gf180mcu_as_sc_mcu7t3v3__fillcap_16
XPHY_EDGE_ROW_70_3_Left_775 VDD VSS gf180mcu_as_sc_mcu7t3v3__tap_2
XFILLER_209_1116 VDD VDD VSS VSS gf180mcu_as_sc_mcu7t3v3__fillcap_4
XFILLER_209_1138 VDD VDD VSS VSS gf180mcu_as_sc_mcu7t3v3__fillcap_16
XPHY_EDGE_ROW_77_2_Left_518 VDD VSS gf180mcu_as_sc_mcu7t3v3__tap_2
XFILLER_178_329 VDD VDD VSS VSS gf180mcu_as_sc_mcu7t3v3__fillcap_4
XFILLER_61_666 VDD VDD VSS VSS gf180mcu_as_sc_mcu7t3v3__fill_1
XFILLER_109_1261 VDD VDD VSS VSS gf180mcu_as_sc_mcu7t3v3__fillcap_4
XFILLER_159_543 VDD VDD VSS VSS gf180mcu_as_sc_mcu7t3v3__fillcap_4
X_3710_ VDD VDD VSS VSS _5714_/A _3807_/S _3710_/C _3710_/D _3712_/C gf180mcu_as_sc_mcu7t3v3__ao211_2
X_4690_ VDD VDD VSS VSS _4774_/C _4896_/A _4959_/B gf180mcu_as_sc_mcu7t3v3__and2_2
XFILLER_201_193 VDD VDD VSS VSS gf180mcu_as_sc_mcu7t3v3__fillcap_16
X_3641_ VDD VDD VSS VSS _5321_/B _5003_/B _4652_/A gf180mcu_as_sc_mcu7t3v3__nand2_2
X_6360_ VDD VDD VSS VSS _6368_/CLK _6360_/D _6360_/Q gf180mcu_as_sc_mcu7t3v3__dfxtp_2
X_3572_ VDD VDD VSS VSS _4977_/C _3572_/B _3572_/C _5649_/D gf180mcu_as_sc_mcu7t3v3__nor3_2
XFILLER_115_602 VDD VDD VSS VSS gf180mcu_as_sc_mcu7t3v3__fillcap_4
XFILLER_155_782 VDD VDD VSS VSS gf180mcu_as_sc_mcu7t3v3__fill_1
XFILLER_155_793 VDD VDD VSS VSS gf180mcu_as_sc_mcu7t3v3__fillcap_4
XFILLER_53_2 VDD VDD VSS VSS gf180mcu_as_sc_mcu7t3v3__fill_1
X_5311_ VDD VDD VSS VSS _5312_/D _5311_/C _5311_/B _5951_/A gf180mcu_as_sc_mcu7t3v3__aoi21_2
Xmax_cap957 VDD VDD VSS VSS fanout956/Y _3543_/B gf180mcu_as_sc_mcu7t3v3__clkbuff_12
X_6291_ VDD VDD VSS VSS clkload5/A _6291_/D _6291_/Q gf180mcu_as_sc_mcu7t3v3__dfxtp_2
XTAP_TAPCELL_ROW_28_1_1335 VDD VSS gf180mcu_as_sc_mcu7t3v3__tap_2
X_5242_ VDD VDD VSS VSS _5889_/D _5242_/B _5242_/C _5242_/D _5244_/C gf180mcu_as_sc_mcu7t3v3__ao211_2
XFILLER_116_1210 VDD VDD VSS VSS gf180mcu_as_sc_mcu7t3v3__fillcap_16
XPHY_EDGE_ROW_122_2_Right_959 VDD VSS gf180mcu_as_sc_mcu7t3v3__tap_2
X_5173_ VDD VDD VSS VSS _5173_/B _5229_/A _6395_/D gf180mcu_as_sc_mcu7t3v3__and2_2
X_4124_ VDD VDD VSS VSS _4143_/S _6174_/Q _6173_/Q _6173_/D gf180mcu_as_sc_mcu7t3v3__mux2_2
Xinput1 VDD VDD VSS VSS TILE_ID[0] input1/Y gf180mcu_as_sc_mcu7t3v3__buff_12
X_4055_ VDD VDD VSS VSS _4055_/S _4055_/B _6127_/Q _6127_/D gf180mcu_as_sc_mcu7t3v3__mux2_2
X_3006_ VDD VDD VSS VSS _4946_/A _6522_/Q gf180mcu_as_sc_mcu7t3v3__inv_2
XFILLER_12_508 VDD VDD VSS VSS gf180mcu_as_sc_mcu7t3v3__fill_1
X_4957_ VDD VDD VSS VSS _5947_/A _4957_/B _4957_/C _4958_/C _4958_/B gf180mcu_as_sc_mcu7t3v3__aoi211_2
XFILLER_178_874 VDD VDD VSS VSS gf180mcu_as_sc_mcu7t3v3__fill_1
X_4888_ VDD VDD VSS VSS _5233_/A _4888_/B _4888_/C _4953_/B _4889_/D gf180mcu_as_sc_mcu7t3v3__ao211_2
X_3908_ VDD VDD VSS VSS _3928_/B _5889_/A _3908_/A _3909_/A gf180mcu_as_sc_mcu7t3v3__mux2_2
XFILLER_165_524 VDD VDD VSS VSS gf180mcu_as_sc_mcu7t3v3__fillcap_16
XFILLER_177_384 VDD VDD VSS VSS gf180mcu_as_sc_mcu7t3v3__fill_1
X_3839_ VDD VDD VSS VSS _6034_/Q _3895_/B _4045_/B _3895_/D _6034_/D gf180mcu_as_sc_mcu7t3v3__ao22_2
XFILLER_165_557 VDD VDD VSS VSS gf180mcu_as_sc_mcu7t3v3__fill_2
XFILLER_180_527 VDD VDD VSS VSS gf180mcu_as_sc_mcu7t3v3__fillcap_4
XFILLER_3_206 VDD VDD VSS VSS gf180mcu_as_sc_mcu7t3v3__fillcap_4
XPHY_EDGE_ROW_108_1_Right_680 VDD VSS gf180mcu_as_sc_mcu7t3v3__tap_2
XPHY_EDGE_ROW_84_2_Right_921 VDD VSS gf180mcu_as_sc_mcu7t3v3__tap_2
XFILLER_3_228 VDD VDD VSS VSS gf180mcu_as_sc_mcu7t3v3__fill_1
XTAP_TAPCELL_ROW_150_1437 VDD VSS gf180mcu_as_sc_mcu7t3v3__tap_2
XTAP_TAPCELL_ROW_150_1448 VDD VSS gf180mcu_as_sc_mcu7t3v3__tap_2
X_6489_ VDD VDD VSS VSS _6490_/CLK _6489_/D _6489_/Q gf180mcu_as_sc_mcu7t3v3__dfxtp_2
X_5509_ VDD VDD VSS VSS _5510_/D _5814_/B _5563_/C _5509_/C gf180mcu_as_sc_mcu7t3v3__ao21_2
XFILLER_0_913 VDD VDD VSS VSS gf180mcu_as_sc_mcu7t3v3__fill_1
XFILLER_161_796 VDD VDD VSS VSS gf180mcu_as_sc_mcu7t3v3__fill_2
XPHY_EDGE_ROW_43_1_Left_271 VDD VSS gf180mcu_as_sc_mcu7t3v3__tap_2
Xoutput371 VDD VDD VSS VSS _6444_/Q east_out[31] gf180mcu_as_sc_mcu7t3v3__buff_12
Xoutput360 VDD VDD VSS VSS _6434_/Q east_out[21] gf180mcu_as_sc_mcu7t3v3__buff_12
XFILLER_160_295 VDD VDD VSS VSS gf180mcu_as_sc_mcu7t3v3__fillcap_16
XFILLER_82_1242 VDD VDD VSS VSS gf180mcu_as_sc_mcu7t3v3__fill_1
XFILLER_86_37 VDD VDD VSS VSS gf180mcu_as_sc_mcu7t3v3__fillcap_8
Xfanout1007 VDD VDD VSS VSS _5925_/D _6015_/A gf180mcu_as_sc_mcu7t3v3__buff_12
Xoutput393 VDD VDD VSS VSS _6360_/Q north_out[19] gf180mcu_as_sc_mcu7t3v3__buff_12
Xoutput382 VDD VDD VSS VSS _6422_/Q east_out[9] gf180mcu_as_sc_mcu7t3v3__buff_12
XFILLER_87_596 VDD VDD VSS VSS gf180mcu_as_sc_mcu7t3v3__fill_1
XFILLER_207_208 VDD VDD VSS VSS gf180mcu_as_sc_mcu7t3v3__fill_2
XFILLER_228_580 VDD VDD VSS VSS gf180mcu_as_sc_mcu7t3v3__fillcap_4
XFILLER_43_666 VDD VDD VSS VSS gf180mcu_as_sc_mcu7t3v3__fill_1
XFILLER_196_671 VDD VDD VSS VSS gf180mcu_as_sc_mcu7t3v3__fill_2
XFILLER_156_524 VDD VDD VSS VSS gf180mcu_as_sc_mcu7t3v3__fill_1
XTAP_TAPCELL_ROW_215_2614 VDD VSS gf180mcu_as_sc_mcu7t3v3__tap_2
XTAP_TAPCELL_ROW_215_2603 VDD VSS gf180mcu_as_sc_mcu7t3v3__tap_2
XFILLER_11_596 VDD VDD VSS VSS gf180mcu_as_sc_mcu7t3v3__fillcap_16
XFILLER_13_1030 VDD VDD VSS VSS gf180mcu_as_sc_mcu7t3v3__fillcap_16
XFILLER_13_1052 VDD VDD VSS VSS gf180mcu_as_sc_mcu7t3v3__fillcap_16
XFILLER_7_534 VDD VDD VSS VSS gf180mcu_as_sc_mcu7t3v3__fill_1
XFILLER_139_1210 VDD VDD VSS VSS gf180mcu_as_sc_mcu7t3v3__fillcap_4
XFILLER_152_752 VDD VDD VSS VSS gf180mcu_as_sc_mcu7t3v3__fill_1
XFILLER_174_1189 VDD VDD VSS VSS gf180mcu_as_sc_mcu7t3v3__fillcap_16
XFILLER_183_72 VDD VDD VSS VSS gf180mcu_as_sc_mcu7t3v3__fillcap_8
XFILLER_215_1186 VDD VDD VSS VSS gf180mcu_as_sc_mcu7t3v3__fillcap_4
X_5860_ VDD VDD VSS VSS _5860_/B _5893_/A _6471_/D gf180mcu_as_sc_mcu7t3v3__and2_2
XFILLER_178_104 VDD VDD VSS VSS gf180mcu_as_sc_mcu7t3v3__fill_1
XFILLER_181_1116 VDD VDD VSS VSS gf180mcu_as_sc_mcu7t3v3__fillcap_4
XFILLER_34_666 VDD VDD VSS VSS gf180mcu_as_sc_mcu7t3v3__fill_1
X_4811_ VDD VDD VSS VSS _4812_/C _4877_/B _5815_/A gf180mcu_as_sc_mcu7t3v3__nor2_2
XFILLER_181_1138 VDD VDD VSS VSS gf180mcu_as_sc_mcu7t3v3__fillcap_16
X_5791_ VDD VDD VSS VSS _5791_/A _5799_/B _5791_/C _5799_/D _5792_/D gf180mcu_as_sc_mcu7t3v3__ao22_2
XFILLER_175_800 VDD VDD VSS VSS gf180mcu_as_sc_mcu7t3v3__fill_1
XFILLER_221_299 VDD VDD VSS VSS gf180mcu_as_sc_mcu7t3v3__fill_1
XFILLER_222_1135 VDD VDD VSS VSS gf180mcu_as_sc_mcu7t3v3__fillcap_16
X_4742_ VDD VDD VSS VSS _4797_/S _4742_/B _5754_/A _4743_/B gf180mcu_as_sc_mcu7t3v3__mux2_2
XFILLER_186_181 VDD VDD VSS VSS gf180mcu_as_sc_mcu7t3v3__fill_1
XFILLER_222_1157 VDD VDD VSS VSS gf180mcu_as_sc_mcu7t3v3__fillcap_16
X_4673_ VDD VDD VSS VSS _4674_/D _4784_/B _4792_/B _5691_/A gf180mcu_as_sc_mcu7t3v3__aoi21b_2
XFILLER_162_505 VDD VDD VSS VSS gf180mcu_as_sc_mcu7t3v3__fill_1
XFILLER_174_332 VDD VDD VSS VSS gf180mcu_as_sc_mcu7t3v3__fillcap_8
X_6412_ VDD VDD VSS VSS _6412_/CLK _6412_/D _6412_/Q gf180mcu_as_sc_mcu7t3v3__dfxtp_2
X_3624_ VDD VDD VSS VSS _4648_/C _5954_/A _3638_/A gf180mcu_as_sc_mcu7t3v3__nor2_2
XFILLER_162_538 VDD VDD VSS VSS gf180mcu_as_sc_mcu7t3v3__fillcap_4
XFILLER_174_387 VDD VDD VSS VSS gf180mcu_as_sc_mcu7t3v3__fillcap_16
X_6343_ VDD VDD VSS VSS _6509_/CLK _6343_/D _6343_/Q gf180mcu_as_sc_mcu7t3v3__dfxtp_2
X_3555_ VDD VDD VSS VSS _3556_/D _5913_/A _5319_/D gf180mcu_as_sc_mcu7t3v3__nand2b_2
XTAP_TAPCELL_ROW_28_2_2890 VDD VSS gf180mcu_as_sc_mcu7t3v3__tap_2
XFILLER_227_76 VDD VDD VSS VSS gf180mcu_as_sc_mcu7t3v3__fill_2
X_6274_ VDD VDD VSS VSS _6313_/CLK _6274_/D _6274_/Q gf180mcu_as_sc_mcu7t3v3__dfxtp_2
X_3486_ VDD VDD VSS VSS _3489_/D _4272_/A _5946_/D gf180mcu_as_sc_mcu7t3v3__nand2b_2
X_5225_ VDD VDD VSS VSS _6517_/Q _5233_/C _5225_/C _5225_/D _5227_/C gf180mcu_as_sc_mcu7t3v3__ao22_2
XFILLER_111_660 VDD VDD VSS VSS gf180mcu_as_sc_mcu7t3v3__fill_2
XFILLER_56_29 VDD VDD VSS VSS gf180mcu_as_sc_mcu7t3v3__fillcap_4
XFILLER_9_1186 VDD VDD VSS VSS gf180mcu_as_sc_mcu7t3v3__fillcap_4
X_5156_ VDD VDD VSS VSS _5157_/D _5815_/A _5221_/B _5195_/B gf180mcu_as_sc_mcu7t3v3__ao21_2
X_5087_ VDD VDD VSS VSS _5087_/D _5187_/S _5087_/B _5087_/C _5088_/A gf180mcu_as_sc_mcu7t3v3__ao31_2
X_4107_ VDD VDD VSS VSS _4571_/C _6162_/Q _4556_/B _6162_/D gf180mcu_as_sc_mcu7t3v3__mux2_2
X_4038_ VDD VDD VSS VSS _4055_/S _4038_/B _6117_/Q _6117_/D gf180mcu_as_sc_mcu7t3v3__mux2_2
XFILLER_186_1049 VDD VDD VSS VSS gf180mcu_as_sc_mcu7t3v3__fillcap_16
XTAP_TAPCELL_ROW_111_2_3015 VDD VSS gf180mcu_as_sc_mcu7t3v3__tap_2
XFILLER_13_817 VDD VDD VSS VSS gf180mcu_as_sc_mcu7t3v3__fillcap_16
XFILLER_169_104 VDD VDD VSS VSS gf180mcu_as_sc_mcu7t3v3__fillcap_16
XFILLER_198_947 VDD VDD VSS VSS gf180mcu_as_sc_mcu7t3v3__fillcap_16
XFILLER_227_1046 VDD VDD VSS VSS gf180mcu_as_sc_mcu7t3v3__fillcap_4
XFILLER_25_666 VDD VDD VSS VSS gf180mcu_as_sc_mcu7t3v3__fill_1
XFILLER_13_839 VDD VDD VSS VSS gf180mcu_as_sc_mcu7t3v3__fill_1
XFILLER_227_1068 VDD VDD VSS VSS gf180mcu_as_sc_mcu7t3v3__fillcap_16
XFILLER_40_625 VDD VDD VSS VSS gf180mcu_as_sc_mcu7t3v3__fill_2
X_5989_ VDD VDD VSS VSS _6006_/B _6212_/Q _6502_/D gf180mcu_as_sc_mcu7t3v3__and2_2
XFILLER_12_349 VDD VDD VSS VSS gf180mcu_as_sc_mcu7t3v3__fillcap_16
XFILLER_184_107 VDD VDD VSS VSS gf180mcu_as_sc_mcu7t3v3__fillcap_8
XANTENNA_50 VDD VDD VSS VSS _5884_/B gf180mcu_as_sc_mcu7t3v3__diode_2
XFILLER_201_1208 VDD VDD VSS VSS gf180mcu_as_sc_mcu7t3v3__fillcap_16
XFILLER_166_877 VDD VDD VSS VSS gf180mcu_as_sc_mcu7t3v3__fill_2
XFILLER_165_387 VDD VDD VSS VSS gf180mcu_as_sc_mcu7t3v3__fill_2
XFILLER_21_43 VDD VDD VSS VSS gf180mcu_as_sc_mcu7t3v3__fillcap_8
XFILLER_137_43 VDD VDD VSS VSS gf180mcu_as_sc_mcu7t3v3__fillcap_8
XTAP_TAPCELL_ROW_210_2522 VDD VSS gf180mcu_as_sc_mcu7t3v3__tap_2
XTAP_TAPCELL_ROW_189_2145 VDD VSS gf180mcu_as_sc_mcu7t3v3__tap_2
XPHY_EDGE_ROW_109_1_Right_681 VDD VSS gf180mcu_as_sc_mcu7t3v3__tap_2
XPHY_EDGE_ROW_85_2_Right_922 VDD VSS gf180mcu_as_sc_mcu7t3v3__tap_2
XFILLER_161_593 VDD VDD VSS VSS gf180mcu_as_sc_mcu7t3v3__fill_2
XTAP_TAPCELL_ROW_167_1742 VDD VSS gf180mcu_as_sc_mcu7t3v3__tap_2
XTAP_TAPCELL_ROW_167_1753 VDD VSS gf180mcu_as_sc_mcu7t3v3__tap_2
XTAP_TAPCELL_ROW_11_1208 VDD VSS gf180mcu_as_sc_mcu7t3v3__tap_2
XTAP_TAPCELL_ROW_11_1219 VDD VSS gf180mcu_as_sc_mcu7t3v3__tap_2
XTAP_TAPCELL_ROW_208_2484 VDD VSS gf180mcu_as_sc_mcu7t3v3__tap_2
XTAP_TAPCELL_ROW_180_1975 VDD VSS gf180mcu_as_sc_mcu7t3v3__tap_2
XFILLER_16_677 VDD VDD VSS VSS gf180mcu_as_sc_mcu7t3v3__fill_2
XFILLER_204_734 VDD VDD VSS VSS gf180mcu_as_sc_mcu7t3v3__fill_1
XFILLER_216_583 VDD VDD VSS VSS gf180mcu_as_sc_mcu7t3v3__fill_1
XTAP_TAPCELL_ROW_180_1986 VDD VSS gf180mcu_as_sc_mcu7t3v3__tap_2
XFILLER_206_1119 VDD VDD VSS VSS gf180mcu_as_sc_mcu7t3v3__fillcap_16
XFILLER_157_800 VDD VDD VSS VSS gf180mcu_as_sc_mcu7t3v3__fill_2
XFILLER_169_671 VDD VDD VSS VSS gf180mcu_as_sc_mcu7t3v3__fill_1
XFILLER_176_608 VDD VDD VSS VSS gf180mcu_as_sc_mcu7t3v3__fillcap_4
XFILLER_106_1242 VDD VDD VSS VSS gf180mcu_as_sc_mcu7t3v3__fill_1
XFILLER_157_833 VDD VDD VSS VSS gf180mcu_as_sc_mcu7t3v3__fillcap_4
XPHY_EDGE_ROW_101_3_Left_806 VDD VSS gf180mcu_as_sc_mcu7t3v3__tap_2
XTAP_TAPCELL_ROW_46_2_2917 VDD VSS gf180mcu_as_sc_mcu7t3v3__tap_2
XFILLER_11_360 VDD VDD VSS VSS gf180mcu_as_sc_mcu7t3v3__fill_2
XFILLER_200_995 VDD VDD VSS VSS gf180mcu_as_sc_mcu7t3v3__fillcap_16
XFILLER_7_342 VDD VDD VSS VSS gf180mcu_as_sc_mcu7t3v3__fill_1
XFILLER_156_376 VDD VDD VSS VSS gf180mcu_as_sc_mcu7t3v3__fillcap_8
XFILLER_156_387 VDD VDD VSS VSS gf180mcu_as_sc_mcu7t3v3__fillcap_4
XFILLER_7_67 VDD VDD VSS VSS gf180mcu_as_sc_mcu7t3v3__fill_2
XPHY_EDGE_ROW_20_3_Right_100 VDD VSS gf180mcu_as_sc_mcu7t3v3__tap_2
XFILLER_98_614 VDD VDD VSS VSS gf180mcu_as_sc_mcu7t3v3__fill_2
X_3340_ VDD VDD VSS VSS _3364_/A _3340_/B _3340_/C _3340_/D _3340_/Y gf180mcu_as_sc_mcu7t3v3__ao22_2
XFILLER_152_593 VDD VDD VSS VSS gf180mcu_as_sc_mcu7t3v3__fill_2
XFILLER_26_1210 VDD VDD VSS VSS gf180mcu_as_sc_mcu7t3v3__fillcap_8
X_5010_ VDD VDD VSS VSS _5010_/D _5684_/A _5139_/B _5139_/C _5011_/C gf180mcu_as_sc_mcu7t3v3__ao31_2
X_3271_ VDD VDD VSS VSS _3280_/B _6298_/Q _6286_/Q _3272_/B gf180mcu_as_sc_mcu7t3v3__mux2_2
XTAP_TAPCELL_ROW_228_2849 VDD VSS gf180mcu_as_sc_mcu7t3v3__tap_2
XTAP_TAPCELL_ROW_228_2838 VDD VSS gf180mcu_as_sc_mcu7t3v3__tap_2
XFILLER_226_314 VDD VDD VSS VSS gf180mcu_as_sc_mcu7t3v3__fill_1
XFILLER_227_848 VDD VDD VSS VSS gf180mcu_as_sc_mcu7t3v3__fill_1
XFILLER_213_67 VDD VDD VSS VSS gf180mcu_as_sc_mcu7t3v3__fill_2
X_5912_ VDD VDD VSS VSS _5912_/A _5936_/B _5930_/C _5912_/D _5913_/D gf180mcu_as_sc_mcu7t3v3__ao22_2
XFILLER_222_531 VDD VDD VSS VSS gf180mcu_as_sc_mcu7t3v3__fill_2
XPHY_EDGE_ROW_33_3_Left_738 VDD VSS gf180mcu_as_sc_mcu7t3v3__tap_2
X_5843_ VDD VDD VSS VSS _5843_/D _5859_/S _5843_/B _5843_/C _5844_/C gf180mcu_as_sc_mcu7t3v3__ao31_2
XFILLER_166_107 VDD VDD VSS VSS gf180mcu_as_sc_mcu7t3v3__fillcap_16
XFILLER_195_928 VDD VDD VSS VSS gf180mcu_as_sc_mcu7t3v3__fillcap_16
XFILLER_210_737 VDD VDD VSS VSS gf180mcu_as_sc_mcu7t3v3__fill_2
XFILLER_194_427 VDD VDD VSS VSS gf180mcu_as_sc_mcu7t3v3__fillcap_8
XFILLER_33_1214 VDD VDD VSS VSS gf180mcu_as_sc_mcu7t3v3__fill_1
X_5774_ VDD VDD VSS VSS _5862_/S _5774_/B _6505_/Q _5775_/C gf180mcu_as_sc_mcu7t3v3__mux2_2
X_4725_ VDD VDD VSS VSS _5072_/A _4725_/B _4725_/C _6348_/D _4725_/D gf180mcu_as_sc_mcu7t3v3__aoi211_2
X_4656_ VDD VDD VSS VSS _6493_/Q _4880_/B _4871_/C _5677_/A _4657_/C gf180mcu_as_sc_mcu7t3v3__ao22_2
XPHY_EDGE_ROW_95_3_Left_800 VDD VSS gf180mcu_as_sc_mcu7t3v3__tap_2
Xinput70 VDD VDD VSS VSS east_in[28] _5906_/D gf180mcu_as_sc_mcu7t3v3__buff_12
Xinput81 VDD VDD VSS VSS east_in[5] _5715_/A gf180mcu_as_sc_mcu7t3v3__buff_12
X_4587_ VDD VDD VSS VSS _4603_/A _4587_/A _6332_/D gf180mcu_as_sc_mcu7t3v3__and2_2
X_3607_ VDD VDD VSS VSS _3607_/A _3607_/B _3607_/C _3607_/D _3608_/C gf180mcu_as_sc_mcu7t3v3__nand4_2
Xinput92 VDD VDD VSS VSS ne_in[15] _5801_/B gf180mcu_as_sc_mcu7t3v3__buff_12
X_6326_ VDD VDD VSS VSS _6551_/CLK _6326_/D _6326_/Q gf180mcu_as_sc_mcu7t3v3__dfxtp_2
X_3538_ VDD VDD VSS VSS _3540_/D _5310_/A _3543_/B gf180mcu_as_sc_mcu7t3v3__nor2b_2
X_6257_ VDD VDD VSS VSS _6313_/CLK _6257_/D _6257_/Q gf180mcu_as_sc_mcu7t3v3__dfxtp_2
X_3469_ VDD VDD VSS VSS _3474_/C _5319_/D _3470_/B _3470_/C _5319_/A gf180mcu_as_sc_mcu7t3v3__aoi22_2
XFILLER_218_804 VDD VDD VSS VSS gf180mcu_as_sc_mcu7t3v3__fill_1
X_6188_ VDD VDD VSS VSS _6490_/CLK _6188_/D _6188_/Q gf180mcu_as_sc_mcu7t3v3__dfxtp_2
X_5208_ VDD VDD VSS VSS _5858_/A _5306_/B _5208_/C _5208_/D _5209_/A gf180mcu_as_sc_mcu7t3v3__ao211_2
XTAP_TAPCELL_ROW_184_2053 VDD VSS gf180mcu_as_sc_mcu7t3v3__tap_2
X_5139_ VDD VDD VSS VSS _5139_/D _5800_/A _5139_/B _5139_/C _5140_/C gf180mcu_as_sc_mcu7t3v3__ao31_2
XTAP_TAPCELL_ROW_129_2_3042 VDD VSS gf180mcu_as_sc_mcu7t3v3__tap_2
XFILLER_177_6 VDD VDD VSS VSS gf180mcu_as_sc_mcu7t3v3__fillcap_16
XTAP_TAPCELL_ROW_162_1650 VDD VSS gf180mcu_as_sc_mcu7t3v3__tap_2
XTAP_TAPCELL_ROW_162_1661 VDD VSS gf180mcu_as_sc_mcu7t3v3__tap_2
XFILLER_198_711 VDD VDD VSS VSS gf180mcu_as_sc_mcu7t3v3__fillcap_16
XFILLER_199_27 VDD VDD VSS VSS gf180mcu_as_sc_mcu7t3v3__fillcap_16
XFILLER_12_102 VDD VDD VSS VSS gf180mcu_as_sc_mcu7t3v3__fill_2
XFILLER_13_603 VDD VDD VSS VSS gf180mcu_as_sc_mcu7t3v3__fill_2
XFILLER_13_625 VDD VDD VSS VSS gf180mcu_as_sc_mcu7t3v3__fillcap_4
XFILLER_16_65 VDD VDD VSS VSS gf180mcu_as_sc_mcu7t3v3__fill_2
XTAP_TAPCELL_ROW_203_2392 VDD VSS gf180mcu_as_sc_mcu7t3v3__tap_2
XFILLER_13_636 VDD VDD VSS VSS gf180mcu_as_sc_mcu7t3v3__fill_1
XFILLER_197_265 VDD VDD VSS VSS gf180mcu_as_sc_mcu7t3v3__fill_1
XFILLER_213_586 VDD VDD VSS VSS gf180mcu_as_sc_mcu7t3v3__fill_1
XFILLER_185_438 VDD VDD VSS VSS gf180mcu_as_sc_mcu7t3v3__fillcap_8
XFILLER_200_247 VDD VDD VSS VSS gf180mcu_as_sc_mcu7t3v3__fill_2
XPHY_EDGE_ROW_205_Left_433 VDD VSS gf180mcu_as_sc_mcu7t3v3__tap_2
XFILLER_200_269 VDD VDD VSS VSS gf180mcu_as_sc_mcu7t3v3__fillcap_4
XFILLER_8_139 VDD VDD VSS VSS gf180mcu_as_sc_mcu7t3v3__fillcap_16
XFILLER_120_2 VDD VDD VSS VSS gf180mcu_as_sc_mcu7t3v3__fillcap_16
XFILLER_218_2 VDD VDD VSS VSS gf180mcu_as_sc_mcu7t3v3__fillcap_16
XFILLER_10_1011 VDD VDD VSS VSS gf180mcu_as_sc_mcu7t3v3__fillcap_4
XFILLER_10_1033 VDD VDD VSS VSS gf180mcu_as_sc_mcu7t3v3__fillcap_16
XFILLER_153_346 VDD VDD VSS VSS gf180mcu_as_sc_mcu7t3v3__fillcap_4
XFILLER_49_1210 VDD VDD VSS VSS gf180mcu_as_sc_mcu7t3v3__fillcap_8
XFILLER_4_323 VDD VDD VSS VSS gf180mcu_as_sc_mcu7t3v3__fill_1
XFILLER_175_1240 VDD VDD VSS VSS gf180mcu_as_sc_mcu7t3v3__fillcap_16
XFILLER_49_1243 VDD VDD VSS VSS gf180mcu_as_sc_mcu7t3v3__fillcap_16
XFILLER_136_1224 VDD VDD VSS VSS gf180mcu_as_sc_mcu7t3v3__fill_1
XFILLER_175_1262 VDD VDD VSS VSS gf180mcu_as_sc_mcu7t3v3__fill_2
XFILLER_181_699 VDD VDD VSS VSS gf180mcu_as_sc_mcu7t3v3__fill_1
XPHY_EDGE_ROW_86_2_Left_527 VDD VSS gf180mcu_as_sc_mcu7t3v3__tap_2
XPHY_EDGE_ROW_86_2_Right_923 VDD VSS gf180mcu_as_sc_mcu7t3v3__tap_2
XFILLER_164_85 VDD VDD VSS VSS gf180mcu_as_sc_mcu7t3v3__fillcap_16
XPHY_EDGE_ROW_214_Left_442 VDD VSS gf180mcu_as_sc_mcu7t3v3__tap_2
XFILLER_209_837 VDD VDD VSS VSS gf180mcu_as_sc_mcu7t3v3__fill_2
XFILLER_212_1189 VDD VDD VSS VSS gf180mcu_as_sc_mcu7t3v3__fillcap_16
XTAP_TAPCELL_ROW_223_2757 VDD VSS gf180mcu_as_sc_mcu7t3v3__tap_2
XFILLER_1_1256 VDD VDD VSS VSS gf180mcu_as_sc_mcu7t3v3__fillcap_4
XFILLER_16_496 VDD VDD VSS VSS gf180mcu_as_sc_mcu7t3v3__fill_2
XFILLER_204_597 VDD VDD VSS VSS gf180mcu_as_sc_mcu7t3v3__fillcap_8
XPHY_EDGE_ROW_223_Left_451 VDD VSS gf180mcu_as_sc_mcu7t3v3__tap_2
XFILLER_191_408 VDD VDD VSS VSS gf180mcu_as_sc_mcu7t3v3__fill_1
XFILLER_11_190 VDD VDD VSS VSS gf180mcu_as_sc_mcu7t3v3__fillcap_16
XFILLER_8_662 VDD VDD VSS VSS gf180mcu_as_sc_mcu7t3v3__fill_2
X_5490_ VDD VDD VSS VSS _5490_/B _6508_/Q _5492_/C gf180mcu_as_sc_mcu7t3v3__and2_2
X_4510_ VDD VDD VSS VSS _4558_/B _6259_/Q _4539_/C gf180mcu_as_sc_mcu7t3v3__and2_2
XFILLER_172_622 VDD VDD VSS VSS gf180mcu_as_sc_mcu7t3v3__fill_2
X_4441_ VDD VDD VSS VSS _6257_/Q _4442_/B _4442_/C _6256_/Q _6256_/D gf180mcu_as_sc_mcu7t3v3__ao22_2
XFILLER_208_34 VDD VDD VSS VSS gf180mcu_as_sc_mcu7t3v3__fill_1
XPHY_EDGE_ROW_21_3_Right_101 VDD VSS gf180mcu_as_sc_mcu7t3v3__tap_2
XPHY_EDGE_ROW_9_Right_9 VDD VSS gf180mcu_as_sc_mcu7t3v3__tap_2
XFILLER_172_699 VDD VDD VSS VSS gf180mcu_as_sc_mcu7t3v3__fillcap_16
X_6111_ VDD VDD VSS VSS _6370_/CLK _6111_/D _6111_/Q gf180mcu_as_sc_mcu7t3v3__dfxtp_2
X_4372_ VDD VDD VSS VSS _4374_/A _4372_/C _4407_/B _6140_/Q gf180mcu_as_sc_mcu7t3v3__aoi21_2
Xfanout608 VDD VDD VSS VSS _4373_/D _4366_/D gf180mcu_as_sc_mcu7t3v3__buff_12
Xfanout619 VDD VDD VSS VSS _3192_/Y _3360_/A gf180mcu_as_sc_mcu7t3v3__buff_12
X_3323_ VDD VDD VSS VSS _3323_/A _3323_/B _3323_/C _4076_/B _3325_/C gf180mcu_as_sc_mcu7t3v3__ao22_2
X_6042_ VDD VDD VSS VSS _6486_/CLK _6042_/D _6042_/Q gf180mcu_as_sc_mcu7t3v3__dfxtp_2
X_3254_ VDD VDD VSS VSS _3281_/D _3254_/B _3254_/A _3255_/B gf180mcu_as_sc_mcu7t3v3__mux2_2
XFILLER_152_1081 VDD VDD VSS VSS gf180mcu_as_sc_mcu7t3v3__fillcap_4
XFILLER_187_1100 VDD VDD VSS VSS gf180mcu_as_sc_mcu7t3v3__fillcap_16
XFILLER_187_1122 VDD VDD VSS VSS gf180mcu_as_sc_mcu7t3v3__fillcap_16
XFILLER_6_1189 VDD VDD VSS VSS gf180mcu_as_sc_mcu7t3v3__fillcap_16
X_3185_ VDD VDD VSS VSS _4558_/A _3433_/B _6164_/Q _3434_/A _6163_/Q gf180mcu_as_sc_mcu7t3v3__aoi22_2
XTAP_TAPCELL_ROW_7_1140 VDD VSS gf180mcu_as_sc_mcu7t3v3__tap_2
XFILLER_214_317 VDD VDD VSS VSS gf180mcu_as_sc_mcu7t3v3__fill_1
XFILLER_226_177 VDD VDD VSS VSS gf180mcu_as_sc_mcu7t3v3__fillcap_4
XTAP_TAPCELL_ROW_3_1059 VDD VSS gf180mcu_as_sc_mcu7t3v3__tap_2
XFILLER_228_1185 VDD VDD VSS VSS gf180mcu_as_sc_mcu7t3v3__fill_1
XFILLER_228_1196 VDD VDD VSS VSS gf180mcu_as_sc_mcu7t3v3__fill_1
XPHY_EDGE_ROW_52_1_Left_280 VDD VSS gf180mcu_as_sc_mcu7t3v3__tap_2
XFILLER_179_298 VDD VDD VSS VSS gf180mcu_as_sc_mcu7t3v3__fill_1
XFILLER_224_1049 VDD VDD VSS VSS gf180mcu_as_sc_mcu7t3v3__fillcap_16
X_5826_ VDD VDD VSS VSS _5826_/A _5869_/B _5826_/C _5826_/D _5827_/B gf180mcu_as_sc_mcu7t3v3__ao211_2
XFILLER_167_449 VDD VDD VSS VSS gf180mcu_as_sc_mcu7t3v3__fillcap_16
XFILLER_194_235 VDD VDD VSS VSS gf180mcu_as_sc_mcu7t3v3__fillcap_8
X_5757_ VDD VDD VSS VSS _5854_/S _5757_/B _6503_/Q _5758_/C gf180mcu_as_sc_mcu7t3v3__mux2_2
X_4708_ VDD VDD VSS VSS _4876_/B _5725_/A _4709_/C gf180mcu_as_sc_mcu7t3v3__and2_2
XFILLER_159_1224 VDD VDD VSS VSS gf180mcu_as_sc_mcu7t3v3__fill_2
X_5688_ VDD VDD VSS VSS _5688_/B _5796_/A _6450_/D gf180mcu_as_sc_mcu7t3v3__and2_2
XFILLER_118_45 VDD VDD VSS VSS gf180mcu_as_sc_mcu7t3v3__fillcap_4
X_4639_ VDD VDD VSS VSS _4639_/Y _4945_/B _4639_/A gf180mcu_as_sc_mcu7t3v3__nor2b_2
XFILLER_163_699 VDD VDD VSS VSS gf180mcu_as_sc_mcu7t3v3__fill_1
XFILLER_190_474 VDD VDD VSS VSS gf180mcu_as_sc_mcu7t3v3__fillcap_4
X_6309_ VDD VDD VSS VSS _6531_/CLK _6309_/D _6309_/Q gf180mcu_as_sc_mcu7t3v3__dfxtp_2
XTAP_TAPCELL_ROW_164_1701 VDD VSS gf180mcu_as_sc_mcu7t3v3__tap_2
XFILLER_218_634 VDD VDD VSS VSS gf180mcu_as_sc_mcu7t3v3__fillcap_4
XFILLER_94_37 VDD VDD VSS VSS gf180mcu_as_sc_mcu7t3v3__fillcap_8
XFILLER_218_667 VDD VDD VSS VSS gf180mcu_as_sc_mcu7t3v3__fill_2
XTAP_TAPCELL_ROW_205_2432 VDD VSS gf180mcu_as_sc_mcu7t3v3__tap_2
XFILLER_168_2 VDD VDD VSS VSS gf180mcu_as_sc_mcu7t3v3__fillcap_16
XFILLER_158_405 VDD VDD VSS VSS gf180mcu_as_sc_mcu7t3v3__fillcap_8
XFILLER_213_361 VDD VDD VSS VSS gf180mcu_as_sc_mcu7t3v3__fill_1
XTAP_TAPCELL_ROW_197_2288 VDD VSS gf180mcu_as_sc_mcu7t3v3__tap_2
XFILLER_185_257 VDD VDD VSS VSS gf180mcu_as_sc_mcu7t3v3__fill_1
XFILLER_201_578 VDD VDD VSS VSS gf180mcu_as_sc_mcu7t3v3__fillcap_8
XFILLER_9_437 VDD VDD VSS VSS gf180mcu_as_sc_mcu7t3v3__fill_2
XFILLER_16_1264 VDD VDD VSS VSS gf180mcu_as_sc_mcu7t3v3__fill_1
XFILLER_173_408 VDD VDD VSS VSS gf180mcu_as_sc_mcu7t3v3__fill_1
XFILLER_5_632 VDD VDD VSS VSS gf180mcu_as_sc_mcu7t3v3__fill_2
XTAP_TAPCELL_ROW_175_1885 VDD VSS gf180mcu_as_sc_mcu7t3v3__tap_2
XTAP_TAPCELL_ROW_175_1896 VDD VSS gf180mcu_as_sc_mcu7t3v3__tap_2
XFILLER_150_861 VDD VDD VSS VSS gf180mcu_as_sc_mcu7t3v3__fill_2
XPHY_EDGE_ROW_87_2_Right_924 VDD VSS gf180mcu_as_sc_mcu7t3v3__tap_2
XFILLER_191_72 VDD VDD VSS VSS gf180mcu_as_sc_mcu7t3v3__fillcap_16
XFILLER_76_661 VDD VDD VSS VSS gf180mcu_as_sc_mcu7t3v3__fillcap_4
Xinput260 VDD VDD VSS VSS south_in[3] _5700_/A gf180mcu_as_sc_mcu7t3v3__buff_12
Xinput271 VDD VDD VSS VSS sw_in[13] _5788_/A gf180mcu_as_sc_mcu7t3v3__buff_12
XFILLER_208_155 VDD VDD VSS VSS gf180mcu_as_sc_mcu7t3v3__fillcap_8
XFILLER_209_656 VDD VDD VSS VSS gf180mcu_as_sc_mcu7t3v3__fill_1
Xinput282 VDD VDD VSS VSS sw_in[23] _5867_/A gf180mcu_as_sc_mcu7t3v3__buff_12
Xinput293 VDD VDD VSS VSS sw_in[33] _5948_/A gf180mcu_as_sc_mcu7t3v3__buff_12
XFILLER_208_177 VDD VDD VSS VSS gf180mcu_as_sc_mcu7t3v3__fill_2
XFILLER_224_648 VDD VDD VSS VSS gf180mcu_as_sc_mcu7t3v3__fillcap_4
XFILLER_91_664 VDD VDD VSS VSS gf180mcu_as_sc_mcu7t3v3__fill_2
X_4990_ VDD VDD VSS VSS _4990_/Y _4990_/B _5250_/A gf180mcu_as_sc_mcu7t3v3__nor2_2
XFILLER_16_271 VDD VDD VSS VSS gf180mcu_as_sc_mcu7t3v3__fill_1
XFILLER_189_552 VDD VDD VSS VSS gf180mcu_as_sc_mcu7t3v3__fill_1
X_3941_ VDD VDD VSS VSS _6047_/Q _3963_/B _3948_/C _4022_/D _6047_/D gf180mcu_as_sc_mcu7t3v3__ao22_2
X_3872_ VDD VDD VSS VSS _5857_/D _3872_/B _3872_/C _3872_/D _3873_/B gf180mcu_as_sc_mcu7t3v3__ao211_2
XFILLER_83_2 VDD VDD VSS VSS gf180mcu_as_sc_mcu7t3v3__fillcap_8
X_5611_ VDD VDD VSS VSS _5923_/A _5640_/B _5611_/C _5611_/D _5613_/C gf180mcu_as_sc_mcu7t3v3__ao211_2
XFILLER_191_216 VDD VDD VSS VSS gf180mcu_as_sc_mcu7t3v3__fill_2
XFILLER_192_728 VDD VDD VSS VSS gf180mcu_as_sc_mcu7t3v3__fillcap_4
XFILLER_9_960 VDD VDD VSS VSS gf180mcu_as_sc_mcu7t3v3__fillcap_16
X_5542_ VDD VDD VSS VSS _5543_/A _5846_/B _5563_/C _5542_/C gf180mcu_as_sc_mcu7t3v3__ao21_2
XFILLER_145_644 VDD VDD VSS VSS gf180mcu_as_sc_mcu7t3v3__fillcap_16
XFILLER_219_66 VDD VDD VSS VSS gf180mcu_as_sc_mcu7t3v3__fillcap_4
XFILLER_9_982 VDD VDD VSS VSS gf180mcu_as_sc_mcu7t3v3__fillcap_16
XFILLER_145_666 VDD VDD VSS VSS gf180mcu_as_sc_mcu7t3v3__fill_1
XFILLER_219_88 VDD VDD VSS VSS gf180mcu_as_sc_mcu7t3v3__fill_2
X_5473_ VDD VDD VSS VSS _5473_/B _5473_/A _6425_/D gf180mcu_as_sc_mcu7t3v3__and2_2
XFILLER_172_496 VDD VDD VSS VSS gf180mcu_as_sc_mcu7t3v3__fillcap_16
X_4424_ VDD VDD VSS VSS _6240_/Q _4428_/B _4583_/D _6239_/Q _6239_/D gf180mcu_as_sc_mcu7t3v3__ao22_2
XFILLER_193_1170 VDD VDD VSS VSS gf180mcu_as_sc_mcu7t3v3__fillcap_16
XPHY_EDGE_ROW_22_3_Right_102 VDD VSS gf180mcu_as_sc_mcu7t3v3__tap_2
X_4355_ VDD VDD VSS VSS _4363_/S _6119_/Q _4355_/C _4362_/D _4360_/B gf180mcu_as_sc_mcu7t3v3__ao211_2
XFILLER_193_1192 VDD VDD VSS VSS gf180mcu_as_sc_mcu7t3v3__fillcap_16
X_3306_ VDD VDD VSS VSS _6195_/Q _4085_/S _4089_/S _6219_/Q _3307_/B gf180mcu_as_sc_mcu7t3v3__ao22_2
X_4286_ VDD VDD VSS VSS _4362_/A _6051_/Q _6080_/Q _4289_/B gf180mcu_as_sc_mcu7t3v3__mux2_2
XTAP_TAPCELL_ROW_181_2001 VDD VSS gf180mcu_as_sc_mcu7t3v3__tap_2
X_6025_ VDD VDD VSS VSS _6371_/CLK _6025_/D _6025_/Q gf180mcu_as_sc_mcu7t3v3__dfxtp_2
X_3237_ VDD VDD VSS VSS _3237_/D _4610_/A _3237_/B _3237_/C _3241_/B gf180mcu_as_sc_mcu7t3v3__ao31_2
X_3168_ VDD VDD VSS VSS _4525_/A _4579_/A _4569_/D gf180mcu_as_sc_mcu7t3v3__nand2_2
XFILLER_214_125 VDD VDD VSS VSS gf180mcu_as_sc_mcu7t3v3__fill_1
X_3099_ VDD VDD VSS VSS _6527_/Q _3099_/B _3099_/A _3099_/Y gf180mcu_as_sc_mcu7t3v3__mux2_2
XFILLER_202_309 VDD VDD VSS VSS gf180mcu_as_sc_mcu7t3v3__fillcap_4
XTAP_TAPCELL_ROW_200_2340 VDD VSS gf180mcu_as_sc_mcu7t3v3__tap_2
XFILLER_126_1245 VDD VDD VSS VSS gf180mcu_as_sc_mcu7t3v3__fillcap_16
XFILLER_223_681 VDD VDD VSS VSS gf180mcu_as_sc_mcu7t3v3__fillcap_4
XFILLER_80_39 VDD VDD VSS VSS gf180mcu_as_sc_mcu7t3v3__fill_1
XFILLER_195_555 VDD VDD VSS VSS gf180mcu_as_sc_mcu7t3v3__fillcap_4
XFILLER_50_594 VDD VDD VSS VSS gf180mcu_as_sc_mcu7t3v3__fillcap_4
Xsram2048.u_bank1_1040 VDD VDD VSS VSS sram2048.u_bank1/WEN[6] gf180mcu_as_sc_mcu7t3v3__tiel_4
X_5809_ VDD VDD VSS VSS _5811_/B _5809_/C _5946_/B _5809_/A gf180mcu_as_sc_mcu7t3v3__aoi21_2
XFILLER_183_739 VDD VDD VSS VSS gf180mcu_as_sc_mcu7t3v3__fillcap_4
XFILLER_210_397 VDD VDD VSS VSS gf180mcu_as_sc_mcu7t3v3__fillcap_4
XTAP_TAPCELL_ROW_157_1560 VDD VSS gf180mcu_as_sc_mcu7t3v3__tap_2
XFILLER_13_88 VDD VDD VSS VSS gf180mcu_as_sc_mcu7t3v3__fillcap_16
XFILLER_182_238 VDD VDD VSS VSS gf180mcu_as_sc_mcu7t3v3__fillcap_4
XTAP_TAPCELL_ROW_157_1571 VDD VSS gf180mcu_as_sc_mcu7t3v3__tap_2
XTAP_TAPCELL_ROW_192_2196 VDD VSS gf180mcu_as_sc_mcu7t3v3__tap_2
XFILLER_151_603 VDD VDD VSS VSS gf180mcu_as_sc_mcu7t3v3__fill_1
XFILLER_198_1081 VDD VDD VSS VSS gf180mcu_as_sc_mcu7t3v3__fillcap_4
XFILLER_190_282 VDD VDD VSS VSS gf180mcu_as_sc_mcu7t3v3__fill_2
XFILLER_172_1221 VDD VDD VSS VSS gf180mcu_as_sc_mcu7t3v3__fillcap_4
XTAP_TAPCELL_ROW_170_1793 VDD VSS gf180mcu_as_sc_mcu7t3v3__tap_2
XFILLER_172_1243 VDD VDD VSS VSS gf180mcu_as_sc_mcu7t3v3__fillcap_16
XFILLER_2_679 VDD VDD VSS VSS gf180mcu_as_sc_mcu7t3v3__fill_2
XFILLER_46_1235 VDD VDD VSS VSS gf180mcu_as_sc_mcu7t3v3__fillcap_8
XTAP_TAPCELL_ROW_117_2_3024 VDD VSS gf180mcu_as_sc_mcu7t3v3__tap_2
XFILLER_133_1238 VDD VDD VSS VSS gf180mcu_as_sc_mcu7t3v3__fill_2
XFILLER_213_1240 VDD VDD VSS VSS gf180mcu_as_sc_mcu7t3v3__fillcap_16
XFILLER_213_1262 VDD VDD VSS VSS gf180mcu_as_sc_mcu7t3v3__fill_2
XPHY_EDGE_ROW_110_3_Left_815 VDD VSS gf180mcu_as_sc_mcu7t3v3__tap_2
Xfanout972 VDD VDD VSS VSS input39/Y _3332_/A gf180mcu_as_sc_mcu7t3v3__buff_12
Xfanout983 VDD VDD VSS VSS input3/Y _5323_/A gf180mcu_as_sc_mcu7t3v3__buff_12
XFILLER_219_976 VDD VDD VSS VSS gf180mcu_as_sc_mcu7t3v3__fillcap_4
XFILLER_219_998 VDD VDD VSS VSS gf180mcu_as_sc_mcu7t3v3__fillcap_16
XFILLER_73_653 VDD VDD VSS VSS gf180mcu_as_sc_mcu7t3v3__fill_2
Xhold1192 VDD VDD VSS VSS _3194_/Y _3196_/C gf180mcu_as_sc_mcu7t3v3__clkbuff_4
XTAP_TAPCELL_ROW_220_2705 VDD VSS gf180mcu_as_sc_mcu7t3v3__tap_2
XTAP_TAPCELL_ROW_199_2328 VDD VSS gf180mcu_as_sc_mcu7t3v3__tap_2
XTAP_TAPCELL_ROW_199_2317 VDD VSS gf180mcu_as_sc_mcu7t3v3__tap_2
XFILLER_73_664 VDD VDD VSS VSS gf180mcu_as_sc_mcu7t3v3__fill_2
XPHY_EDGE_ROW_156_Left_384 VDD VSS gf180mcu_as_sc_mcu7t3v3__tap_2
XTAP_TAPCELL_ROW_177_1925 VDD VSS gf180mcu_as_sc_mcu7t3v3__tap_2
XFILLER_41_594 VDD VDD VSS VSS gf180mcu_as_sc_mcu7t3v3__fillcap_4
XFILLER_9_212 VDD VDD VSS VSS gf180mcu_as_sc_mcu7t3v3__fillcap_16
XTAP_TAPCELL_ROW_177_1936 VDD VSS gf180mcu_as_sc_mcu7t3v3__tap_2
XFILLER_158_279 VDD VDD VSS VSS gf180mcu_as_sc_mcu7t3v3__fillcap_16
XFILLER_174_706 VDD VDD VSS VSS gf180mcu_as_sc_mcu7t3v3__fillcap_4
XTAP_TAPCELL_ROW_218_2667 VDD VSS gf180mcu_as_sc_mcu7t3v3__tap_2
Xclkload15 VDD VDD VSS VSS clkload15/Y _6531_/CLK gf180mcu_as_sc_mcu7t3v3__inv_2
Xclkload26 VDD VDD VSS VSS clkload26/Y _6525_/CLK gf180mcu_as_sc_mcu7t3v3__inv_4
XFILLER_127_666 VDD VDD VSS VSS gf180mcu_as_sc_mcu7t3v3__fill_1
XFILLER_155_975 VDD VDD VSS VSS gf180mcu_as_sc_mcu7t3v3__fillcap_4
XFILLER_6_963 VDD VDD VSS VSS gf180mcu_as_sc_mcu7t3v3__fillcap_16
XFILLER_154_485 VDD VDD VSS VSS gf180mcu_as_sc_mcu7t3v3__fill_2
XFILLER_177_1154 VDD VDD VSS VSS gf180mcu_as_sc_mcu7t3v3__fillcap_16
XFILLER_181_282 VDD VDD VSS VSS gf180mcu_as_sc_mcu7t3v3__fillcap_16
XFILLER_218_1151 VDD VDD VSS VSS gf180mcu_as_sc_mcu7t3v3__fillcap_4
XFILLER_218_1173 VDD VDD VSS VSS gf180mcu_as_sc_mcu7t3v3__fillcap_16
XPHY_EDGE_ROW_165_Left_393 VDD VSS gf180mcu_as_sc_mcu7t3v3__tap_2
X_4140_ VDD VDD VSS VSS _4140_/S _4140_/B _6189_/Q _6189_/D gf180mcu_as_sc_mcu7t3v3__mux2_2
XFILLER_228_206 VDD VDD VSS VSS gf180mcu_as_sc_mcu7t3v3__fillcap_4
XPHY_EDGE_ROW_42_3_Left_747 VDD VSS gf180mcu_as_sc_mcu7t3v3__tap_2
XPHY_EDGE_ROW_88_2_Right_925 VDD VSS gf180mcu_as_sc_mcu7t3v3__tap_2
XFILLER_7_1240 VDD VDD VSS VSS gf180mcu_as_sc_mcu7t3v3__fillcap_16
XFILLER_7_1262 VDD VDD VSS VSS gf180mcu_as_sc_mcu7t3v3__fill_2
X_4071_ VDD VDD VSS VSS _6134_/D _4071_/B _4071_/A gf180mcu_as_sc_mcu7t3v3__nor2_2
X_3022_ VDD VDD VSS VSS _4625_/C _4968_/A gf180mcu_as_sc_mcu7t3v3__inv_2
XFILLER_184_1103 VDD VDD VSS VSS gf180mcu_as_sc_mcu7t3v3__fillcap_16
XFILLER_224_401 VDD VDD VSS VSS gf180mcu_as_sc_mcu7t3v3__fill_1
XFILLER_221_34 VDD VDD VSS VSS gf180mcu_as_sc_mcu7t3v3__fillcap_16
XTAP_TAPCELL_ROW_0_1007 VDD VSS gf180mcu_as_sc_mcu7t3v3__tap_2
XFILLER_225_1100 VDD VDD VSS VSS gf180mcu_as_sc_mcu7t3v3__fillcap_16
XTAP_TAPCELL_ROW_0_1018 VDD VSS gf180mcu_as_sc_mcu7t3v3__tap_2
X_4973_ VDD VDD VSS VSS _4976_/C _4973_/C _4973_/B _4973_/A gf180mcu_as_sc_mcu7t3v3__aoi21_2
XFILLER_211_139 VDD VDD VSS VSS gf180mcu_as_sc_mcu7t3v3__fill_1
XFILLER_225_1122 VDD VDD VSS VSS gf180mcu_as_sc_mcu7t3v3__fillcap_16
X_3924_ VDD VDD VSS VSS _6043_/Q _3933_/B _4059_/B _3933_/D _6043_/D gf180mcu_as_sc_mcu7t3v3__ao22_2
XFILLER_32_594 VDD VDD VSS VSS gf180mcu_as_sc_mcu7t3v3__fillcap_16
XFILLER_164_205 VDD VDD VSS VSS gf180mcu_as_sc_mcu7t3v3__fill_2
XFILLER_165_706 VDD VDD VSS VSS gf180mcu_as_sc_mcu7t3v3__fill_1
Xclkload9 VDD VDD VSS VSS clkload9/Y clkload9/A gf180mcu_as_sc_mcu7t3v3__inv_6
X_3855_ VDD VDD VSS VSS _3873_/S _3855_/B _5841_/A _3856_/D gf180mcu_as_sc_mcu7t3v3__mux2_2
X_3786_ VDD VDD VSS VSS _3806_/S _5784_/A _3786_/A _3787_/A gf180mcu_as_sc_mcu7t3v3__mux2_2
XFILLER_195_1232 VDD VDD VSS VSS gf180mcu_as_sc_mcu7t3v3__fill_2
X_5525_ VDD VDD VSS VSS _5833_/D _5583_/B _5574_/C _5832_/A _5526_/C gf180mcu_as_sc_mcu7t3v3__ao22_2
XFILLER_156_1205 VDD VDD VSS VSS gf180mcu_as_sc_mcu7t3v3__fillcap_16
X_5456_ VDD VDD VSS VSS _5457_/B _5763_/A _5456_/B _5456_/C _5456_/D gf180mcu_as_sc_mcu7t3v3__aoi22_2
XFILLER_156_1227 VDD VDD VSS VSS gf180mcu_as_sc_mcu7t3v3__fill_1
XFILLER_161_978 VDD VDD VSS VSS gf180mcu_as_sc_mcu7t3v3__fill_2
X_4407_ VDD VDD VSS VSS _4409_/A _4407_/C _4407_/B _6145_/Q gf180mcu_as_sc_mcu7t3v3__aoi21_2
XPHY_EDGE_ROW_23_3_Right_103 VDD VSS gf180mcu_as_sc_mcu7t3v3__tap_2
X_5387_ VDD VDD VSS VSS _5387_/B _5396_/A _6415_/D gf180mcu_as_sc_mcu7t3v3__and2_2
XFILLER_99_594 VDD VDD VSS VSS gf180mcu_as_sc_mcu7t3v3__fillcap_4
X_4338_ VDD VDD VSS VSS _4394_/A _4338_/B _4338_/C _4339_/B _4408_/D gf180mcu_as_sc_mcu7t3v3__oai211_2
XFILLER_189_1014 VDD VDD VSS VSS gf180mcu_as_sc_mcu7t3v3__fillcap_16
X_4269_ VDD VDD VSS VSS _4342_/S _6049_/Q _6078_/Q _4270_/B gf180mcu_as_sc_mcu7t3v3__mux2_2
X_6008_ VDD VDD VSS VSS _6525_/D _6199_/Q _6521_/D gf180mcu_as_sc_mcu7t3v3__and2_2
XFILLER_215_434 VDD VDD VSS VSS gf180mcu_as_sc_mcu7t3v3__fill_1
XFILLER_216_979 VDD VDD VSS VSS gf180mcu_as_sc_mcu7t3v3__fillcap_16
XFILLER_55_664 VDD VDD VSS VSS gf180mcu_as_sc_mcu7t3v3__fill_2
XFILLER_215_467 VDD VDD VSS VSS gf180mcu_as_sc_mcu7t3v3__fill_2
XFILLER_91_49 VDD VDD VSS VSS gf180mcu_as_sc_mcu7t3v3__fill_2
XPHY_EDGE_ROW_50_2_Right_887 VDD VSS gf180mcu_as_sc_mcu7t3v3__tap_2
XTAP_TAPCELL_ROW_159_1600 VDD VSS gf180mcu_as_sc_mcu7t3v3__tap_2
XTAP_TAPCELL_ROW_159_1611 VDD VSS gf180mcu_as_sc_mcu7t3v3__tap_2
XTAP_TAPCELL_ROW_194_2236 VDD VSS gf180mcu_as_sc_mcu7t3v3__tap_2
XTAP_TAPCELL_ROW_194_2225 VDD VSS gf180mcu_as_sc_mcu7t3v3__tap_2
XFILLER_168_522 VDD VDD VSS VSS gf180mcu_as_sc_mcu7t3v3__fill_2
XPHY_EDGE_ROW_95_2_Left_536 VDD VSS gf180mcu_as_sc_mcu7t3v3__tap_2
XFILLER_156_717 VDD VDD VSS VSS gf180mcu_as_sc_mcu7t3v3__fillcap_16
XFILLER_210_172 VDD VDD VSS VSS gf180mcu_as_sc_mcu7t3v3__fill_2
XFILLER_23_594 VDD VDD VSS VSS gf180mcu_as_sc_mcu7t3v3__fillcap_8
XFILLER_13_1234 VDD VDD VSS VSS gf180mcu_as_sc_mcu7t3v3__fillcap_16
XFILLER_109_666 VDD VDD VSS VSS gf180mcu_as_sc_mcu7t3v3__fill_1
XFILLER_183_569 VDD VDD VSS VSS gf180mcu_as_sc_mcu7t3v3__fillcap_4
XTAP_TAPCELL_ROW_172_1833 VDD VSS gf180mcu_as_sc_mcu7t3v3__tap_2
XTAP_TAPCELL_ROW_172_1844 VDD VSS gf180mcu_as_sc_mcu7t3v3__tap_2
XFILLER_156_53 VDD VDD VSS VSS gf180mcu_as_sc_mcu7t3v3__fillcap_16
XFILLER_164_794 VDD VDD VSS VSS gf180mcu_as_sc_mcu7t3v3__fill_1
XFILLER_200_2 VDD VDD VSS VSS gf180mcu_as_sc_mcu7t3v3__fill_2
XTAP_TAPCELL_ROW_213_2575 VDD VSS gf180mcu_as_sc_mcu7t3v3__tap_2
XFILLER_151_422 VDD VDD VSS VSS gf180mcu_as_sc_mcu7t3v3__fillcap_4
XFILLER_163_282 VDD VDD VSS VSS gf180mcu_as_sc_mcu7t3v3__fillcap_16
XFILLER_172_30 VDD VDD VSS VSS gf180mcu_as_sc_mcu7t3v3__fillcap_4
XFILLER_172_85 VDD VDD VSS VSS gf180mcu_as_sc_mcu7t3v3__fillcap_16
Xfanout780 VDD VDD VSS VSS _5313_/B _5234_/B gf180mcu_as_sc_mcu7t3v3__buff_12
Xfanout791 VDD VDD VSS VSS _4613_/Y fanout791/Y gf180mcu_as_sc_mcu7t3v3__buff_12
XFILLER_1_69 VDD VDD VSS VSS gf180mcu_as_sc_mcu7t3v3__fill_1
XFILLER_225_209 VDD VDD VSS VSS gf180mcu_as_sc_mcu7t3v3__fill_1
XFILLER_206_434 VDD VDD VSS VSS gf180mcu_as_sc_mcu7t3v3__fillcap_8
XFILLER_222_927 VDD VDD VSS VSS gf180mcu_as_sc_mcu7t3v3__fillcap_16
XFILLER_159_522 VDD VDD VSS VSS gf180mcu_as_sc_mcu7t3v3__fill_2
XFILLER_14_594 VDD VDD VSS VSS gf180mcu_as_sc_mcu7t3v3__fill_1
XFILLER_159_566 VDD VDD VSS VSS gf180mcu_as_sc_mcu7t3v3__fill_1
XFILLER_174_514 VDD VDD VSS VSS gf180mcu_as_sc_mcu7t3v3__fill_1
X_3640_ VDD VDD VSS VSS _3640_/B _4651_/B _5003_/B gf180mcu_as_sc_mcu7t3v3__and2_2
XFILLER_155_750 VDD VDD VSS VSS gf180mcu_as_sc_mcu7t3v3__fillcap_8
X_3571_ VDD VDD VSS VSS _3572_/C _3572_/B _4982_/A gf180mcu_as_sc_mcu7t3v3__or2_2
XFILLER_115_614 VDD VDD VSS VSS gf180mcu_as_sc_mcu7t3v3__fillcap_4
XFILLER_155_772 VDD VDD VSS VSS gf180mcu_as_sc_mcu7t3v3__fillcap_8
XFILLER_170_720 VDD VDD VSS VSS gf180mcu_as_sc_mcu7t3v3__fill_1
XPHY_EDGE_ROW_173_Left_401 VDD VSS gf180mcu_as_sc_mcu7t3v3__tap_2
Xmax_cap936 VDD VDD VSS VSS fanout935/Y _4912_/A gf180mcu_as_sc_mcu7t3v3__clkbuff_12
X_6290_ VDD VDD VSS VSS clkload5/A _6290_/D _6290_/Q gf180mcu_as_sc_mcu7t3v3__dfxtp_2
X_5310_ VDD VDD VSS VSS _5311_/C _5310_/A _5310_/B _5312_/B gf180mcu_as_sc_mcu7t3v3__ao21_2
XTAP_TAPCELL_ROW_93_2_2988 VDD VSS gf180mcu_as_sc_mcu7t3v3__tap_2
XFILLER_170_753 VDD VDD VSS VSS gf180mcu_as_sc_mcu7t3v3__fillcap_8
Xmax_cap947 VDD VDD VSS VSS _3570_/A _3639_/A gf180mcu_as_sc_mcu7t3v3__clkbuff_12
XFILLER_216_34 VDD VDD VSS VSS gf180mcu_as_sc_mcu7t3v3__fill_1
X_5241_ VDD VDD VSS VSS _5263_/B _5889_/A _5294_/A _5292_/C _5242_/D gf180mcu_as_sc_mcu7t3v3__ao31_2
XFILLER_190_1151 VDD VDD VSS VSS gf180mcu_as_sc_mcu7t3v3__fillcap_4
X_5172_ VDD VDD VSS VSS _5190_/S _5827_/A _5172_/A _5173_/B gf180mcu_as_sc_mcu7t3v3__mux2_2
XFILLER_190_1173 VDD VDD VSS VSS gf180mcu_as_sc_mcu7t3v3__fillcap_16
X_4123_ VDD VDD VSS VSS _4144_/S _6173_/Q _6172_/Q _6172_/D gf180mcu_as_sc_mcu7t3v3__mux2_2
XPHY_EDGE_ROW_89_2_Right_926 VDD VSS gf180mcu_as_sc_mcu7t3v3__tap_2
Xinput2 VDD VDD VSS VSS TILE_ID[1] input2/Y gf180mcu_as_sc_mcu7t3v3__buff_12
X_4054_ VDD VDD VSS VSS _4054_/A _4057_/C _4060_/B _6126_/Q _6126_/D gf180mcu_as_sc_mcu7t3v3__ao22_2
X_3005_ VDD VDD VSS VSS _3570_/A _4264_/A gf180mcu_as_sc_mcu7t3v3__inv_2
XFILLER_209_294 VDD VDD VSS VSS gf180mcu_as_sc_mcu7t3v3__fillcap_4
XFILLER_37_664 VDD VDD VSS VSS gf180mcu_as_sc_mcu7t3v3__fill_2
XPHY_EDGE_ROW_182_Left_410 VDD VSS gf180mcu_as_sc_mcu7t3v3__tap_2
XFILLER_149_1053 VDD VDD VSS VSS gf180mcu_as_sc_mcu7t3v3__fill_1
XFILLER_212_404 VDD VDD VSS VSS gf180mcu_as_sc_mcu7t3v3__fill_1
XFILLER_52_623 VDD VDD VSS VSS gf180mcu_as_sc_mcu7t3v3__fillcap_4
XPHY_EDGE_ROW_80_1_Left_308 VDD VSS gf180mcu_as_sc_mcu7t3v3__tap_2
XFILLER_36_1245 VDD VDD VSS VSS gf180mcu_as_sc_mcu7t3v3__fillcap_16
X_4956_ VDD VDD VSS VSS _5945_/A _4961_/B _4956_/C _4956_/D _4957_/C gf180mcu_as_sc_mcu7t3v3__ao211_2
XFILLER_177_352 VDD VDD VSS VSS gf180mcu_as_sc_mcu7t3v3__fillcap_16
XFILLER_221_971 VDD VDD VSS VSS gf180mcu_as_sc_mcu7t3v3__fillcap_8
XFILLER_221_982 VDD VDD VSS VSS gf180mcu_as_sc_mcu7t3v3__fillcap_16
X_4887_ VDD VDD VSS VSS _4888_/C _4887_/B _5879_/A gf180mcu_as_sc_mcu7t3v3__nor2_2
X_3907_ VDD VDD VSS VSS _5889_/D _3926_/B _3907_/C _3907_/D _3908_/A gf180mcu_as_sc_mcu7t3v3__ao211_2
X_3838_ VDD VDD VSS VSS _5827_/A _3865_/B _3838_/C _3838_/D _4045_/B gf180mcu_as_sc_mcu7t3v3__ao211_2
XFILLER_180_506 VDD VDD VSS VSS gf180mcu_as_sc_mcu7t3v3__fill_2
Xclkbuf_leaf_16_clk_regs VDD VDD VSS VSS clkload1/A _6368_/CLK gf180mcu_as_sc_mcu7t3v3__clkbuff_12
X_5508_ VDD VDD VSS VSS _6510_/Q _5564_/B _5563_/B _5815_/A _5509_/C gf180mcu_as_sc_mcu7t3v3__ao22_2
X_3769_ VDD VDD VSS VSS _3881_/B _3769_/B _5768_/A _3770_/D gf180mcu_as_sc_mcu7t3v3__mux2_2
XFILLER_106_647 VDD VDD VSS VSS gf180mcu_as_sc_mcu7t3v3__fillcap_16
XFILLER_161_742 VDD VDD VSS VSS gf180mcu_as_sc_mcu7t3v3__fillcap_8
XTAP_TAPCELL_ROW_150_1438 VDD VSS gf180mcu_as_sc_mcu7t3v3__tap_2
XTAP_TAPCELL_ROW_150_1449 VDD VSS gf180mcu_as_sc_mcu7t3v3__tap_2
X_6488_ VDD VDD VSS VSS _6492_/CLK _6488_/D _6488_/Q gf180mcu_as_sc_mcu7t3v3__dfxtp_2
XFILLER_10_78 VDD VDD VSS VSS gf180mcu_as_sc_mcu7t3v3__fillcap_16
XFILLER_121_606 VDD VDD VSS VSS gf180mcu_as_sc_mcu7t3v3__fill_1
XFILLER_126_45 VDD VDD VSS VSS gf180mcu_as_sc_mcu7t3v3__fillcap_4
XFILLER_160_241 VDD VDD VSS VSS gf180mcu_as_sc_mcu7t3v3__fillcap_4
XFILLER_160_263 VDD VDD VSS VSS gf180mcu_as_sc_mcu7t3v3__fillcap_16
XFILLER_195_1084 VDD VDD VSS VSS gf180mcu_as_sc_mcu7t3v3__fillcap_16
XFILLER_82_1210 VDD VDD VSS VSS gf180mcu_as_sc_mcu7t3v3__fill_2
Xoutput361 VDD VDD VSS VSS _6435_/Q east_out[22] gf180mcu_as_sc_mcu7t3v3__buff_12
Xoutput350 VDD VDD VSS VSS _6425_/Q east_out[12] gf180mcu_as_sc_mcu7t3v3__buff_12
X_5439_ VDD VDD VSS VSS _5439_/B _5506_/A _6421_/D gf180mcu_as_sc_mcu7t3v3__and2_2
Xfanout1008 VDD VDD VSS VSS _6012_/A _5925_/D gf180mcu_as_sc_mcu7t3v3__buff_12
Xoutput394 VDD VDD VSS VSS _6342_/Q north_out[1] gf180mcu_as_sc_mcu7t3v3__buff_12
Xoutput383 VDD VDD VSS VSS _6341_/Q north_out[0] gf180mcu_as_sc_mcu7t3v3__buff_12
Xoutput372 VDD VDD VSS VSS _6445_/Q east_out[32] gf180mcu_as_sc_mcu7t3v3__buff_12
XFILLER_86_49 VDD VDD VSS VSS gf180mcu_as_sc_mcu7t3v3__fill_2
XPHY_EDGE_ROW_24_3_Right_104 VDD VSS gf180mcu_as_sc_mcu7t3v3__tap_2
XFILLER_142_22 VDD VDD VSS VSS gf180mcu_as_sc_mcu7t3v3__fillcap_8
XFILLER_19_43 VDD VDD VSS VSS gf180mcu_as_sc_mcu7t3v3__fillcap_4
XFILLER_210_1221 VDD VDD VSS VSS gf180mcu_as_sc_mcu7t3v3__fillcap_4
XTAP_TAPCELL_ROW_13_1250 VDD VSS gf180mcu_as_sc_mcu7t3v3__tap_2
XFILLER_15_314 VDD VDD VSS VSS gf180mcu_as_sc_mcu7t3v3__fillcap_16
XFILLER_167_1186 VDD VDD VSS VSS gf180mcu_as_sc_mcu7t3v3__fillcap_4
XFILLER_204_938 VDD VDD VSS VSS gf180mcu_as_sc_mcu7t3v3__fillcap_4
XFILLER_187_127 VDD VDD VSS VSS gf180mcu_as_sc_mcu7t3v3__fillcap_4
XPHY_EDGE_ROW_51_2_Right_888 VDD VSS gf180mcu_as_sc_mcu7t3v3__tap_2
XFILLER_184_801 VDD VDD VSS VSS gf180mcu_as_sc_mcu7t3v3__fillcap_4
XFILLER_211_492 VDD VDD VSS VSS gf180mcu_as_sc_mcu7t3v3__fillcap_4
XTAP_TAPCELL_ROW_215_2615 VDD VSS gf180mcu_as_sc_mcu7t3v3__tap_2
XTAP_TAPCELL_ROW_215_2604 VDD VSS gf180mcu_as_sc_mcu7t3v3__tap_2
XFILLER_167_63 VDD VDD VSS VSS gf180mcu_as_sc_mcu7t3v3__fillcap_4
XFILLER_183_333 VDD VDD VSS VSS gf180mcu_as_sc_mcu7t3v3__fill_1
XTAP_TAPCELL_ROW_105_2_3006 VDD VSS gf180mcu_as_sc_mcu7t3v3__tap_2
XFILLER_152_731 VDD VDD VSS VSS gf180mcu_as_sc_mcu7t3v3__fillcap_4
XFILLER_174_1135 VDD VDD VSS VSS gf180mcu_as_sc_mcu7t3v3__fillcap_16
XFILLER_174_1157 VDD VDD VSS VSS gf180mcu_as_sc_mcu7t3v3__fillcap_16
XFILLER_183_84 VDD VDD VSS VSS gf180mcu_as_sc_mcu7t3v3__fill_2
XFILLER_215_1154 VDD VDD VSS VSS gf180mcu_as_sc_mcu7t3v3__fillcap_16
XFILLER_120_661 VDD VDD VSS VSS gf180mcu_as_sc_mcu7t3v3__fillcap_4
XFILLER_4_1221 VDD VDD VSS VSS gf180mcu_as_sc_mcu7t3v3__fillcap_4
XFILLER_4_1243 VDD VDD VSS VSS gf180mcu_as_sc_mcu7t3v3__fillcap_16
XFILLER_19_664 VDD VDD VSS VSS gf180mcu_as_sc_mcu7t3v3__fill_2
XFILLER_98_1261 VDD VDD VSS VSS gf180mcu_as_sc_mcu7t3v3__fillcap_4
XFILLER_0_1129 VDD VDD VSS VSS gf180mcu_as_sc_mcu7t3v3__fillcap_4
XFILLER_146_1226 VDD VDD VSS VSS gf180mcu_as_sc_mcu7t3v3__fillcap_16
XFILLER_185_1264 VDD VDD VSS VSS gf180mcu_as_sc_mcu7t3v3__fill_1
XFILLER_202_69 VDD VDD VSS VSS gf180mcu_as_sc_mcu7t3v3__fillcap_16
X_4810_ VDD VDD VSS VSS _5816_/A _4875_/B _4810_/C _4867_/D _4813_/C gf180mcu_as_sc_mcu7t3v3__ao211_2
XFILLER_203_960 VDD VDD VSS VSS gf180mcu_as_sc_mcu7t3v3__fillcap_16
X_5790_ VDD VDD VSS VSS _5798_/S _5790_/B _6507_/Q _5791_/C gf180mcu_as_sc_mcu7t3v3__mux2_2
XFILLER_159_330 VDD VDD VSS VSS gf180mcu_as_sc_mcu7t3v3__fillcap_16
XFILLER_159_352 VDD VDD VSS VSS gf180mcu_as_sc_mcu7t3v3__fill_2
XFILLER_202_470 VDD VDD VSS VSS gf180mcu_as_sc_mcu7t3v3__fill_2
XFILLER_203_982 VDD VDD VSS VSS gf180mcu_as_sc_mcu7t3v3__fillcap_16
XFILLER_222_1103 VDD VDD VSS VSS gf180mcu_as_sc_mcu7t3v3__fillcap_16
X_4741_ VDD VDD VSS VSS _5753_/A _4796_/B _4741_/C _4741_/D _4742_/B gf180mcu_as_sc_mcu7t3v3__ao211_2
XPHY_EDGE_ROW_30_1_Right_602 VDD VSS gf180mcu_as_sc_mcu7t3v3__tap_2
XTAP_TAPCELL_ROW_140_2_3058 VDD VSS gf180mcu_as_sc_mcu7t3v3__tap_2
X_4672_ VDD VDD VSS VSS _5692_/A _4838_/B _4672_/C _4792_/B _4674_/C gf180mcu_as_sc_mcu7t3v3__ao211_2
X_6411_ VDD VDD VSS VSS _6412_/CLK _6411_/D _6411_/Q gf180mcu_as_sc_mcu7t3v3__dfxtp_2
X_3623_ VDD VDD VSS VSS _3629_/A _5661_/A _5353_/B gf180mcu_as_sc_mcu7t3v3__nor2_2
XFILLER_162_517 VDD VDD VSS VSS gf180mcu_as_sc_mcu7t3v3__fillcap_8
XFILLER_179_1046 VDD VDD VSS VSS gf180mcu_as_sc_mcu7t3v3__fillcap_4
XFILLER_179_1068 VDD VDD VSS VSS gf180mcu_as_sc_mcu7t3v3__fillcap_16
X_6342_ VDD VDD VSS VSS _6509_/CLK _6342_/D _6342_/Q gf180mcu_as_sc_mcu7t3v3__dfxtp_2
X_3554_ VDD VDD VSS VSS _3631_/A _5922_/A _5931_/A _3631_/D _3558_/A gf180mcu_as_sc_mcu7t3v3__ao22_2
XFILLER_192_1235 VDD VDD VSS VSS gf180mcu_as_sc_mcu7t3v3__fillcap_4
XTAP_TAPCELL_ROW_124_1_1383 VDD VSS gf180mcu_as_sc_mcu7t3v3__tap_2
X_6273_ VDD VDD VSS VSS _6313_/CLK _6273_/D _6273_/Q gf180mcu_as_sc_mcu7t3v3__dfxtp_2
X_3485_ VDD VDD VSS VSS _3489_/C _4264_/A _5939_/D gf180mcu_as_sc_mcu7t3v3__nand2b_2
XFILLER_153_1208 VDD VDD VSS VSS gf180mcu_as_sc_mcu7t3v3__fillcap_16
XFILLER_170_594 VDD VDD VSS VSS gf180mcu_as_sc_mcu7t3v3__fill_1
X_5224_ VDD VDD VSS VSS _5225_/D _5233_/C _5224_/B _5224_/A gf180mcu_as_sc_mcu7t3v3__aoi21_2
XFILLER_9_1154 VDD VDD VSS VSS gf180mcu_as_sc_mcu7t3v3__fillcap_16
X_5155_ VDD VDD VSS VSS _5155_/B _5164_/A _6393_/D gf180mcu_as_sc_mcu7t3v3__and2_2
X_5086_ VDD VDD VSS VSS _6502_/Q _5086_/B _5143_/C _5752_/D _5087_/D gf180mcu_as_sc_mcu7t3v3__ao22_2
X_4106_ VDD VDD VSS VSS _4106_/A _4106_/B _4106_/C _4106_/D _4556_/B gf180mcu_as_sc_mcu7t3v3__ao22_2
XFILLER_186_1017 VDD VDD VSS VSS gf180mcu_as_sc_mcu7t3v3__fillcap_16
X_4037_ VDD VDD VSS VSS _4055_/S _4037_/B _6116_/Q _6116_/D gf180mcu_as_sc_mcu7t3v3__mux2_2
XFILLER_227_1014 VDD VDD VSS VSS gf180mcu_as_sc_mcu7t3v3__fillcap_16
XFILLER_25_623 VDD VDD VSS VSS gf180mcu_as_sc_mcu7t3v3__fillcap_16
XFILLER_72_29 VDD VDD VSS VSS gf180mcu_as_sc_mcu7t3v3__fillcap_4
XFILLER_12_317 VDD VDD VSS VSS gf180mcu_as_sc_mcu7t3v3__fillcap_16
XFILLER_213_768 VDD VDD VSS VSS gf180mcu_as_sc_mcu7t3v3__fill_2
XFILLER_40_604 VDD VDD VSS VSS gf180mcu_as_sc_mcu7t3v3__fill_1
X_5988_ VDD VDD VSS VSS _6010_/B _6211_/Q _6501_/D gf180mcu_as_sc_mcu7t3v3__and2_2
XFILLER_200_407 VDD VDD VSS VSS gf180mcu_as_sc_mcu7t3v3__fillcap_4
X_4939_ VDD VDD VSS VSS _5929_/A _4963_/B _4939_/C _4940_/C _4939_/D gf180mcu_as_sc_mcu7t3v3__aoi211_2
XANTENNA_40 VDD VDD VSS VSS _4798_/B gf180mcu_as_sc_mcu7t3v3__diode_2
XFILLER_184_119 VDD VDD VSS VSS gf180mcu_as_sc_mcu7t3v3__fill_2
XANTENNA_51 VDD VDD VSS VSS _5302_/A gf180mcu_as_sc_mcu7t3v3__diode_2
XFILLER_165_333 VDD VDD VSS VSS gf180mcu_as_sc_mcu7t3v3__fillcap_4
XFILLER_153_506 VDD VDD VSS VSS gf180mcu_as_sc_mcu7t3v3__fillcap_4
XFILLER_158_1119 VDD VDD VSS VSS gf180mcu_as_sc_mcu7t3v3__fillcap_16
XFILLER_180_303 VDD VDD VSS VSS gf180mcu_as_sc_mcu7t3v3__fillcap_4
XFILLER_193_675 VDD VDD VSS VSS gf180mcu_as_sc_mcu7t3v3__fillcap_16
XPHY_EDGE_ROW_19_3_Right_99 VDD VSS gf180mcu_as_sc_mcu7t3v3__tap_2
XFILLER_10_1259 VDD VDD VSS VSS gf180mcu_as_sc_mcu7t3v3__fillcap_4
XTAP_TAPCELL_ROW_210_2523 VDD VSS gf180mcu_as_sc_mcu7t3v3__tap_2
XTAP_TAPCELL_ROW_189_2135 VDD VSS gf180mcu_as_sc_mcu7t3v3__tap_2
XTAP_TAPCELL_ROW_189_2146 VDD VSS gf180mcu_as_sc_mcu7t3v3__tap_2
XTAP_TAPCELL_ROW_74_1_1358 VDD VSS gf180mcu_as_sc_mcu7t3v3__tap_2
XFILLER_102_661 VDD VDD VSS VSS gf180mcu_as_sc_mcu7t3v3__fillcap_4
XFILLER_153_54 VDD VDD VSS VSS gf180mcu_as_sc_mcu7t3v3__fillcap_16
XPHY_EDGE_ROW_25_3_Right_105 VDD VSS gf180mcu_as_sc_mcu7t3v3__tap_2
XTAP_TAPCELL_ROW_167_1743 VDD VSS gf180mcu_as_sc_mcu7t3v3__tap_2
XTAP_TAPCELL_ROW_167_1754 VDD VSS gf180mcu_as_sc_mcu7t3v3__tap_2
XTAP_TAPCELL_ROW_11_1209 VDD VSS gf180mcu_as_sc_mcu7t3v3__tap_2
XTAP_TAPCELL_ROW_208_2485 VDD VSS gf180mcu_as_sc_mcu7t3v3__tap_2
XPHY_EDGE_ROW_39_2_Left_480 VDD VSS gf180mcu_as_sc_mcu7t3v3__tap_2
XTAP_TAPCELL_ROW_180_1976 VDD VSS gf180mcu_as_sc_mcu7t3v3__tap_2
XFILLER_16_645 VDD VDD VSS VSS gf180mcu_as_sc_mcu7t3v3__fill_1
XFILLER_16_667 VDD VDD VSS VSS gf180mcu_as_sc_mcu7t3v3__fill_1
XFILLER_203_212 VDD VDD VSS VSS gf180mcu_as_sc_mcu7t3v3__fill_2
XTAP_TAPCELL_ROW_180_1987 VDD VSS gf180mcu_as_sc_mcu7t3v3__tap_2
XFILLER_106_1210 VDD VDD VSS VSS gf180mcu_as_sc_mcu7t3v3__fillcap_16
XFILLER_203_278 VDD VDD VSS VSS gf180mcu_as_sc_mcu7t3v3__fill_2
XPHY_EDGE_ROW_52_2_Right_889 VDD VSS gf180mcu_as_sc_mcu7t3v3__tap_2
XFILLER_156_311 VDD VDD VSS VSS gf180mcu_as_sc_mcu7t3v3__fillcap_4
XFILLER_168_171 VDD VDD VSS VSS gf180mcu_as_sc_mcu7t3v3__fillcap_4
XPHY_EDGE_ROW_51_3_Left_756 VDD VSS gf180mcu_as_sc_mcu7t3v3__tap_2
XFILLER_156_333 VDD VDD VSS VSS gf180mcu_as_sc_mcu7t3v3__fillcap_16
XFILLER_168_193 VDD VDD VSS VSS gf180mcu_as_sc_mcu7t3v3__fillcap_4
XFILLER_200_963 VDD VDD VSS VSS gf180mcu_as_sc_mcu7t3v3__fillcap_16
XFILLER_8_855 VDD VDD VSS VSS gf180mcu_as_sc_mcu7t3v3__fillcap_16
XFILLER_8_877 VDD VDD VSS VSS gf180mcu_as_sc_mcu7t3v3__fillcap_16
X_3270_ VDD VDD VSS VSS _3291_/B _3270_/B _3270_/C _3270_/D _3270_/Y gf180mcu_as_sc_mcu7t3v3__ao22_2
XFILLER_65_1260 VDD VDD VSS VSS gf180mcu_as_sc_mcu7t3v3__fillcap_4
XTAP_TAPCELL_ROW_228_2839 VDD VSS gf180mcu_as_sc_mcu7t3v3__tap_2
XFILLER_113_1214 VDD VDD VSS VSS gf180mcu_as_sc_mcu7t3v3__fill_1
XPHY_EDGE_ROW_0_Left_229 VDD VSS gf180mcu_as_sc_mcu7t3v3__tap_2
X_5911_ VDD VDD VSS VSS _5951_/B _5911_/A _5913_/C gf180mcu_as_sc_mcu7t3v3__and2_2
X_5842_ VDD VDD VSS VSS _5843_/C _5842_/A _5842_/B _5842_/C _5842_/D gf180mcu_as_sc_mcu7t3v3__aoi22_2
XFILLER_22_637 VDD VDD VSS VSS gf180mcu_as_sc_mcu7t3v3__fill_2
X_5773_ VDD VDD VSS VSS _5861_/B _5773_/A _5776_/C gf180mcu_as_sc_mcu7t3v3__and2_2
X_4724_ VDD VDD VSS VSS _4725_/C _4724_/C _4862_/B _5735_/A gf180mcu_as_sc_mcu7t3v3__aoi21_2
XPHY_EDGE_ROW_31_1_Right_603 VDD VSS gf180mcu_as_sc_mcu7t3v3__tap_2
XFILLER_190_612 VDD VDD VSS VSS gf180mcu_as_sc_mcu7t3v3__fill_1
X_4655_ VDD VDD VSS VSS _4843_/B _4655_/B _4655_/A gf180mcu_as_sc_mcu7t3v3__nor2b_2
Xinput60 VDD VDD VSS VSS east_in[19] _5829_/A gf180mcu_as_sc_mcu7t3v3__buff_12
Xinput71 VDD VDD VSS VSS east_in[29] _5911_/A gf180mcu_as_sc_mcu7t3v3__buff_12
Xinput82 VDD VDD VSS VSS east_in[6] wire948/A gf180mcu_as_sc_mcu7t3v3__buff_12
X_4586_ VDD VDD VSS VSS _4586_/B _6550_/D _6331_/D gf180mcu_as_sc_mcu7t3v3__and2_2
X_3606_ VDD VDD VSS VSS _5325_/B _3606_/B _5323_/C gf180mcu_as_sc_mcu7t3v3__nor2_2
XFILLER_162_358 VDD VDD VSS VSS gf180mcu_as_sc_mcu7t3v3__fill_2
XFILLER_190_667 VDD VDD VSS VSS gf180mcu_as_sc_mcu7t3v3__fillcap_16
Xinput93 VDD VDD VSS VSS ne_in[16] _5808_/A gf180mcu_as_sc_mcu7t3v3__buff_12
X_6325_ VDD VDD VSS VSS _6551_/CLK _6325_/D _6325_/Q gf180mcu_as_sc_mcu7t3v3__dfxtp_2
X_3537_ VDD VDD VSS VSS _4615_/B _3542_/B _5301_/A gf180mcu_as_sc_mcu7t3v3__nand2b_2
XFILLER_143_594 VDD VDD VSS VSS gf180mcu_as_sc_mcu7t3v3__fillcap_8
XFILLER_192_1065 VDD VDD VSS VSS gf180mcu_as_sc_mcu7t3v3__fillcap_16
Xmax_cap574 VDD VDD VSS VSS _3893_/C _3922_/C gf180mcu_as_sc_mcu7t3v3__clkbuff_12
XFILLER_192_1087 VDD VDD VSS VSS gf180mcu_as_sc_mcu7t3v3__fillcap_16
X_6256_ VDD VDD VSS VSS _6313_/CLK _6256_/D _6256_/Q gf180mcu_as_sc_mcu7t3v3__dfxtp_2
X_3468_ VDD VDD VSS VSS _5350_/A _3631_/A _5924_/A _5933_/A _3631_/D gf180mcu_as_sc_mcu7t3v3__aoi22_2
X_6187_ VDD VDD VSS VSS _6490_/CLK _6187_/D _6187_/Q gf180mcu_as_sc_mcu7t3v3__dfxtp_2
X_5207_ VDD VDD VSS VSS _5857_/A _5207_/B _5207_/C _5857_/D _5208_/D gf180mcu_as_sc_mcu7t3v3__ao22_2
X_3399_ VDD VDD VSS VSS _3399_/B _4569_/A _3426_/C gf180mcu_as_sc_mcu7t3v3__and2_2
XTAP_TAPCELL_ROW_58_1_1350 VDD VSS gf180mcu_as_sc_mcu7t3v3__tap_2
XTAP_TAPCELL_ROW_184_2054 VDD VSS gf180mcu_as_sc_mcu7t3v3__tap_2
X_5138_ VDD VDD VSS VSS _5139_/D _5799_/A _5138_/B _5141_/B gf180mcu_as_sc_mcu7t3v3__ao21_2
XFILLER_226_871 VDD VDD VSS VSS gf180mcu_as_sc_mcu7t3v3__fillcap_4
XFILLER_83_39 VDD VDD VSS VSS gf180mcu_as_sc_mcu7t3v3__fillcap_8
XPHY_EDGE_ROW_24_1_Left_252 VDD VSS gf180mcu_as_sc_mcu7t3v3__tap_2
XTAP_TAPCELL_ROW_162_1651 VDD VSS gf180mcu_as_sc_mcu7t3v3__tap_2
X_5069_ VDD VDD VSS VSS _5069_/D _5303_/S _5069_/B _5069_/C _5070_/A gf180mcu_as_sc_mcu7t3v3__ao31_2
XFILLER_129_1210 VDD VDD VSS VSS gf180mcu_as_sc_mcu7t3v3__fillcap_4
XFILLER_16_33 VDD VDD VSS VSS gf180mcu_as_sc_mcu7t3v3__fill_1
XTAP_TAPCELL_ROW_162_1662 VDD VSS gf180mcu_as_sc_mcu7t3v3__tap_2
XTAP_TAPCELL_ROW_203_2393 VDD VSS gf180mcu_as_sc_mcu7t3v3__tap_2
XFILLER_160_1009 VDD VDD VSS VSS gf180mcu_as_sc_mcu7t3v3__fillcap_4
XFILLER_16_99 VDD VDD VSS VSS gf180mcu_as_sc_mcu7t3v3__fill_2
Xclkbuf_leaf_31_clk_regs VDD VDD VSS VSS clkbuf_3_6_0_clk_regs/Y _6437_/CLK gf180mcu_as_sc_mcu7t3v3__clkbuff_12
XFILLER_164_1189 VDD VDD VSS VSS gf180mcu_as_sc_mcu7t3v3__fillcap_16
XFILLER_199_1208 VDD VDD VSS VSS gf180mcu_as_sc_mcu7t3v3__fillcap_16
XFILLER_8_107 VDD VDD VSS VSS gf180mcu_as_sc_mcu7t3v3__fillcap_16
XFILLER_148_32 VDD VDD VSS VSS gf180mcu_as_sc_mcu7t3v3__fill_2
XFILLER_166_642 VDD VDD VSS VSS gf180mcu_as_sc_mcu7t3v3__fillcap_8
XFILLER_194_940 VDD VDD VSS VSS gf180mcu_as_sc_mcu7t3v3__fillcap_4
XFILLER_205_1186 VDD VDD VSS VSS gf180mcu_as_sc_mcu7t3v3__fillcap_4
XFILLER_194_995 VDD VDD VSS VSS gf180mcu_as_sc_mcu7t3v3__fillcap_16
XFILLER_153_314 VDD VDD VSS VSS gf180mcu_as_sc_mcu7t3v3__fillcap_16
XFILLER_165_174 VDD VDD VSS VSS gf180mcu_as_sc_mcu7t3v3__fillcap_16
XFILLER_193_494 VDD VDD VSS VSS gf180mcu_as_sc_mcu7t3v3__fill_1
XFILLER_164_31 VDD VDD VSS VSS gf180mcu_as_sc_mcu7t3v3__fillcap_4
XFILLER_180_177 VDD VDD VSS VSS gf180mcu_as_sc_mcu7t3v3__fillcap_4
XFILLER_164_53 VDD VDD VSS VSS gf180mcu_as_sc_mcu7t3v3__fillcap_16
XFILLER_171_1116 VDD VDD VSS VSS gf180mcu_as_sc_mcu7t3v3__fillcap_4
XFILLER_171_1138 VDD VDD VSS VSS gf180mcu_as_sc_mcu7t3v3__fillcap_16
XFILLER_212_1135 VDD VDD VSS VSS gf180mcu_as_sc_mcu7t3v3__fillcap_16
XPHY_EDGE_ROW_26_3_Right_106 VDD VSS gf180mcu_as_sc_mcu7t3v3__tap_2
XFILLER_180_41 VDD VDD VSS VSS gf180mcu_as_sc_mcu7t3v3__fill_2
XFILLER_212_1157 VDD VDD VSS VSS gf180mcu_as_sc_mcu7t3v3__fillcap_16
XFILLER_169_1034 VDD VDD VSS VSS gf180mcu_as_sc_mcu7t3v3__fillcap_16
XFILLER_1_1224 VDD VDD VSS VSS gf180mcu_as_sc_mcu7t3v3__fillcap_16
XTAP_TAPCELL_ROW_223_2758 VDD VSS gf180mcu_as_sc_mcu7t3v3__tap_2
XTAP_TAPCELL_ROW_223_2747 VDD VSS gf180mcu_as_sc_mcu7t3v3__tap_2
XFILLER_188_244 VDD VDD VSS VSS gf180mcu_as_sc_mcu7t3v3__fill_1
XFILLER_189_72 VDD VDD VSS VSS gf180mcu_as_sc_mcu7t3v3__fill_2
XFILLER_223_1264 VDD VDD VSS VSS gf180mcu_as_sc_mcu7t3v3__fill_1
XFILLER_8_685 VDD VDD VSS VSS gf180mcu_as_sc_mcu7t3v3__fill_2
X_4440_ VDD VDD VSS VSS _6256_/Q _4442_/B _4442_/C _6255_/Q _6255_/D gf180mcu_as_sc_mcu7t3v3__ao22_2
XFILLER_160_807 VDD VDD VSS VSS gf180mcu_as_sc_mcu7t3v3__fillcap_8
XFILLER_172_667 VDD VDD VSS VSS gf180mcu_as_sc_mcu7t3v3__fillcap_16
XFILLER_176_1049 VDD VDD VSS VSS gf180mcu_as_sc_mcu7t3v3__fillcap_16
XFILLER_153_870 VDD VDD VSS VSS gf180mcu_as_sc_mcu7t3v3__fillcap_8
X_6110_ VDD VDD VSS VSS _6520_/CLK _6110_/D _6110_/Q gf180mcu_as_sc_mcu7t3v3__dfxtp_2
X_4371_ VDD VDD VSS VSS _6221_/Q _4399_/B _4399_/C _6222_/Q _4372_/C gf180mcu_as_sc_mcu7t3v3__ao22_2
XFILLER_125_594 VDD VDD VSS VSS gf180mcu_as_sc_mcu7t3v3__fillcap_4
XFILLER_217_1046 VDD VDD VSS VSS gf180mcu_as_sc_mcu7t3v3__fillcap_4
XFILLER_217_1068 VDD VDD VSS VSS gf180mcu_as_sc_mcu7t3v3__fillcap_16
Xfanout609 VDD VDD VSS VSS _4373_/D _4408_/D gf180mcu_as_sc_mcu7t3v3__buff_12
X_3322_ VDD VDD VSS VSS _6205_/Q _3361_/B _4101_/S _6213_/Q _3323_/C gf180mcu_as_sc_mcu7t3v3__ao22_2
XFILLER_224_34 VDD VDD VSS VSS gf180mcu_as_sc_mcu7t3v3__fill_1
X_6041_ VDD VDD VSS VSS _6486_/CLK _6041_/D _6041_/Q gf180mcu_as_sc_mcu7t3v3__dfxtp_2
X_3253_ VDD VDD VSS VSS _3280_/B _3253_/B _6284_/Q _3254_/B gf180mcu_as_sc_mcu7t3v3__mux2_2
XFILLER_6_1135 VDD VDD VSS VSS gf180mcu_as_sc_mcu7t3v3__fillcap_16
X_3184_ VDD VDD VSS VSS _6194_/Q _6193_/Q _4281_/B gf180mcu_as_sc_mcu7t3v3__or2_2
XFILLER_6_1157 VDD VDD VSS VSS gf180mcu_as_sc_mcu7t3v3__fillcap_16
XTAP_TAPCELL_ROW_7_1141 VDD VSS gf180mcu_as_sc_mcu7t3v3__tap_2
XFILLER_228_1153 VDD VDD VSS VSS gf180mcu_as_sc_mcu7t3v3__fill_2
XFILLER_224_1017 VDD VDD VSS VSS gf180mcu_as_sc_mcu7t3v3__fillcap_16
XFILLER_228_1164 VDD VDD VSS VSS gf180mcu_as_sc_mcu7t3v3__fill_1
X_5825_ VDD VDD VSS VSS _5825_/A _5874_/B _5873_/B _5825_/D _5826_/D gf180mcu_as_sc_mcu7t3v3__ao22_2
XTAP_TAPCELL_ROW_99_2_2997 VDD VSS gf180mcu_as_sc_mcu7t3v3__tap_2
XFILLER_179_277 VDD VDD VSS VSS gf180mcu_as_sc_mcu7t3v3__fill_2
XFILLER_194_247 VDD VDD VSS VSS gf180mcu_as_sc_mcu7t3v3__fill_2
XFILLER_210_579 VDD VDD VSS VSS gf180mcu_as_sc_mcu7t3v3__fillcap_4
X_5756_ VDD VDD VSS VSS _5857_/C _5756_/A _5759_/C gf180mcu_as_sc_mcu7t3v3__and2_2
XFILLER_148_653 VDD VDD VSS VSS gf180mcu_as_sc_mcu7t3v3__fillcap_4
X_5687_ VDD VDD VSS VSS _5795_/S _5687_/B _5687_/A _5688_/B gf180mcu_as_sc_mcu7t3v3__mux2_2
X_4707_ VDD VDD VSS VSS _4707_/B _4826_/A _6346_/D gf180mcu_as_sc_mcu7t3v3__and2_2
XFILLER_191_954 VDD VDD VSS VSS gf180mcu_as_sc_mcu7t3v3__fill_1
XPHY_EDGE_ROW_32_1_Right_604 VDD VSS gf180mcu_as_sc_mcu7t3v3__tap_2
X_4638_ VDD VDD VSS VSS _4984_/A _4638_/B _5346_/D _4638_/Y gf180mcu_as_sc_mcu7t3v3__nor3_2
XFILLER_162_155 VDD VDD VSS VSS gf180mcu_as_sc_mcu7t3v3__fillcap_16
XFILLER_190_442 VDD VDD VSS VSS gf180mcu_as_sc_mcu7t3v3__fill_2
XFILLER_150_317 VDD VDD VSS VSS gf180mcu_as_sc_mcu7t3v3__fillcap_16
XFILLER_162_177 VDD VDD VSS VSS gf180mcu_as_sc_mcu7t3v3__fillcap_16
XFILLER_191_998 VDD VDD VSS VSS gf180mcu_as_sc_mcu7t3v3__fillcap_16
X_4569_ VDD VDD VSS VSS _4569_/A _4569_/B _4569_/C _4569_/D _4573_/B gf180mcu_as_sc_mcu7t3v3__ao22_2
XFILLER_116_594 VDD VDD VSS VSS gf180mcu_as_sc_mcu7t3v3__fillcap_8
XFILLER_150_339 VDD VDD VSS VSS gf180mcu_as_sc_mcu7t3v3__fill_1
X_6308_ VDD VDD VSS VSS _6313_/CLK _6308_/D _6308_/Q gf180mcu_as_sc_mcu7t3v3__dfxtp_2
X_6239_ VDD VDD VSS VSS _6316_/CLK _6239_/D _6239_/Q gf180mcu_as_sc_mcu7t3v3__dfxtp_2
XFILLER_134_45 VDD VDD VSS VSS gf180mcu_as_sc_mcu7t3v3__fillcap_4
XTAP_TAPCELL_ROW_164_1702 VDD VSS gf180mcu_as_sc_mcu7t3v3__tap_2
XFILLER_94_49 VDD VDD VSS VSS gf180mcu_as_sc_mcu7t3v3__fill_2
XFILLER_150_22 VDD VDD VSS VSS gf180mcu_as_sc_mcu7t3v3__fillcap_8
XFILLER_27_43 VDD VDD VSS VSS gf180mcu_as_sc_mcu7t3v3__fillcap_8
XTAP_TAPCELL_ROW_205_2433 VDD VSS gf180mcu_as_sc_mcu7t3v3__tap_2
XFILLER_213_340 VDD VDD VSS VSS gf180mcu_as_sc_mcu7t3v3__fill_1
XFILLER_214_885 VDD VDD VSS VSS gf180mcu_as_sc_mcu7t3v3__fill_2
XTAP_TAPCELL_ROW_197_2289 VDD VSS gf180mcu_as_sc_mcu7t3v3__tap_2
XFILLER_14_979 VDD VDD VSS VSS gf180mcu_as_sc_mcu7t3v3__fillcap_16
XFILLER_13_489 VDD VDD VSS VSS gf180mcu_as_sc_mcu7t3v3__fill_1
XFILLER_158_439 VDD VDD VSS VSS gf180mcu_as_sc_mcu7t3v3__fillcap_4
XFILLER_16_1232 VDD VDD VSS VSS gf180mcu_as_sc_mcu7t3v3__fill_1
XFILLER_139_664 VDD VDD VSS VSS gf180mcu_as_sc_mcu7t3v3__fill_2
XFILLER_194_781 VDD VDD VSS VSS gf180mcu_as_sc_mcu7t3v3__fill_2
XTAP_TAPCELL_ROW_175_1886 VDD VSS gf180mcu_as_sc_mcu7t3v3__tap_2
XTAP_TAPCELL_ROW_175_1897 VDD VSS gf180mcu_as_sc_mcu7t3v3__tap_2
XFILLER_154_667 VDD VDD VSS VSS gf180mcu_as_sc_mcu7t3v3__fillcap_8
XFILLER_193_291 VDD VDD VSS VSS gf180mcu_as_sc_mcu7t3v3__fill_1
XFILLER_182_998 VDD VDD VSS VSS gf180mcu_as_sc_mcu7t3v3__fillcap_16
XFILLER_5_699 VDD VDD VSS VSS gf180mcu_as_sc_mcu7t3v3__fill_1
XFILLER_107_594 VDD VDD VSS VSS gf180mcu_as_sc_mcu7t3v3__fillcap_8
XFILLER_1_850 VDD VDD VSS VSS gf180mcu_as_sc_mcu7t3v3__fillcap_4
XFILLER_4_69 VDD VDD VSS VSS gf180mcu_as_sc_mcu7t3v3__fillcap_16
XFILLER_23_1214 VDD VDD VSS VSS gf180mcu_as_sc_mcu7t3v3__fill_1
XFILLER_208_101 VDD VDD VSS VSS gf180mcu_as_sc_mcu7t3v3__fillcap_4
Xinput250 VDD VDD VSS VSS south_in[27] _5898_/A gf180mcu_as_sc_mcu7t3v3__buff_12
Xinput261 VDD VDD VSS VSS south_in[4] _5708_/A gf180mcu_as_sc_mcu7t3v3__buff_12
Xinput272 VDD VDD VSS VSS sw_in[14] _5795_/A gf180mcu_as_sc_mcu7t3v3__buff_12
XFILLER_208_123 VDD VDD VSS VSS gf180mcu_as_sc_mcu7t3v3__fillcap_16
XPHY_EDGE_ROW_27_3_Right_107 VDD VSS gf180mcu_as_sc_mcu7t3v3__tap_2
Xinput283 VDD VDD VSS VSS sw_in[24] wire986/A gf180mcu_as_sc_mcu7t3v3__buff_12
Xinput294 VDD VDD VSS VSS sw_in[34] _5955_/A gf180mcu_as_sc_mcu7t3v3__buff_12
XFILLER_208_167 VDD VDD VSS VSS gf180mcu_as_sc_mcu7t3v3__fill_1
XFILLER_223_148 VDD VDD VSS VSS gf180mcu_as_sc_mcu7t3v3__fill_1
X_3940_ VDD VDD VSS VSS _6046_/D _3940_/C _3948_/C _4021_/A gf180mcu_as_sc_mcu7t3v3__ao21b_2
XFILLER_210_69 VDD VDD VSS VSS gf180mcu_as_sc_mcu7t3v3__fillcap_16
XFILLER_90_4 VDD VDD VSS VSS gf180mcu_as_sc_mcu7t3v3__fillcap_4
X_3871_ VDD VDD VSS VSS _3871_/B _5856_/A _3872_/D gf180mcu_as_sc_mcu7t3v3__and2_2
XFILLER_176_247 VDD VDD VSS VSS gf180mcu_as_sc_mcu7t3v3__fillcap_16
X_5610_ VDD VDD VSS VSS _5611_/D _5922_/A _5616_/B _5610_/C gf180mcu_as_sc_mcu7t3v3__ao21_2
XFILLER_157_461 VDD VDD VSS VSS gf180mcu_as_sc_mcu7t3v3__fillcap_4
XFILLER_164_409 VDD VDD VSS VSS gf180mcu_as_sc_mcu7t3v3__fillcap_16
XFILLER_219_34 VDD VDD VSS VSS gf180mcu_as_sc_mcu7t3v3__fillcap_16
X_5541_ VDD VDD VSS VSS _6514_/Q _5564_/B _5563_/B _5847_/A _5542_/C gf180mcu_as_sc_mcu7t3v3__ao22_2
XFILLER_145_612 VDD VDD VSS VSS gf180mcu_as_sc_mcu7t3v3__fillcap_4
XFILLER_158_995 VDD VDD VSS VSS gf180mcu_as_sc_mcu7t3v3__fillcap_16
XFILLER_172_420 VDD VDD VSS VSS gf180mcu_as_sc_mcu7t3v3__fill_2
XFILLER_173_965 VDD VDD VSS VSS gf180mcu_as_sc_mcu7t3v3__fill_1
X_5472_ VDD VDD VSS VSS _5473_/B _5909_/D _5568_/B _5779_/A gf180mcu_as_sc_mcu7t3v3__aoi21b_2
X_4423_ VDD VDD VSS VSS _6239_/Q _4428_/B _4583_/D _6238_/Q _6238_/D gf180mcu_as_sc_mcu7t3v3__ao22_2
X_4354_ VDD VDD VSS VSS _4355_/C _4363_/S _6032_/Q gf180mcu_as_sc_mcu7t3v3__nor2b_2
XPHY_EDGE_ROW_139_3_Left_844 VDD VSS gf180mcu_as_sc_mcu7t3v3__tap_2
X_3305_ VDD VDD VSS VSS _3305_/Y _6136_/Q _6137_/Q gf180mcu_as_sc_mcu7t3v3__nor2b_2
XFILLER_228_911 VDD VDD VSS VSS gf180mcu_as_sc_mcu7t3v3__fill_2
X_6024_ VDD VDD VSS VSS _6368_/CLK _6024_/D _6024_/Q gf180mcu_as_sc_mcu7t3v3__dfxtp_2
X_4285_ VDD VDD VSS VSS _4362_/A _6109_/Q _4285_/C _4362_/D _4289_/C gf180mcu_as_sc_mcu7t3v3__ao211_2
XTAP_TAPCELL_ROW_181_2002 VDD VSS gf180mcu_as_sc_mcu7t3v3__tap_2
X_3236_ VDD VDD VSS VSS _3237_/D _3280_/B _6283_/Q gf180mcu_as_sc_mcu7t3v3__nor2_2
XFILLER_104_37 VDD VDD VSS VSS gf180mcu_as_sc_mcu7t3v3__fillcap_8
XFILLER_228_977 VDD VDD VSS VSS gf180mcu_as_sc_mcu7t3v3__fillcap_4
XFILLER_228_988 VDD VDD VSS VSS gf180mcu_as_sc_mcu7t3v3__fill_1
XTAP_TAPCELL_ROW_146_2_3067 VDD VSS gf180mcu_as_sc_mcu7t3v3__tap_2
X_3167_ VDD VDD VSS VSS _3174_/B _6260_/Q _4509_/A gf180mcu_as_sc_mcu7t3v3__nand2_2
X_3098_ VDD VDD VSS VSS _4499_/A _6140_/Q gf180mcu_as_sc_mcu7t3v3__inv_2
XFILLER_14_209 VDD VDD VSS VSS gf180mcu_as_sc_mcu7t3v3__fillcap_16
XFILLER_39_1210 VDD VDD VSS VSS gf180mcu_as_sc_mcu7t3v3__fillcap_4
XFILLER_82_665 VDD VDD VSS VSS gf180mcu_as_sc_mcu7t3v3__fill_2
XTAP_TAPCELL_ROW_200_2341 VDD VSS gf180mcu_as_sc_mcu7t3v3__tap_2
XFILLER_165_1262 VDD VDD VSS VSS gf180mcu_as_sc_mcu7t3v3__fill_2
XFILLER_168_737 VDD VDD VSS VSS gf180mcu_as_sc_mcu7t3v3__fillcap_4
XFILLER_210_321 VDD VDD VSS VSS gf180mcu_as_sc_mcu7t3v3__fill_1
XFILLER_80_29 VDD VDD VSS VSS gf180mcu_as_sc_mcu7t3v3__fillcap_4
XFILLER_10_404 VDD VDD VSS VSS gf180mcu_as_sc_mcu7t3v3__fill_1
XFILLER_149_951 VDD VDD VSS VSS gf180mcu_as_sc_mcu7t3v3__fill_1
Xsram2048.u_bank1_1041 VDD VDD VSS VSS sram2048.u_bank1/WEN[7] gf180mcu_as_sc_mcu7t3v3__tiel_4
X_5808_ VDD VDD VSS VSS _5808_/A _5946_/C _5808_/C _5808_/D _5809_/C gf180mcu_as_sc_mcu7t3v3__ao211_2
XFILLER_210_387 VDD VDD VSS VSS gf180mcu_as_sc_mcu7t3v3__fill_1
X_5739_ VDD VDD VSS VSS _5801_/S _5739_/A _5744_/C gf180mcu_as_sc_mcu7t3v3__and2_2
XTAP_TAPCELL_ROW_157_1561 VDD VSS gf180mcu_as_sc_mcu7t3v3__tap_2
XTAP_TAPCELL_ROW_157_1572 VDD VSS gf180mcu_as_sc_mcu7t3v3__tap_2
XTAP_TAPCELL_ROW_192_2197 VDD VSS gf180mcu_as_sc_mcu7t3v3__tap_2
XFILLER_202_1189 VDD VDD VSS VSS gf180mcu_as_sc_mcu7t3v3__fillcap_16
XPHY_EDGE_ROW_33_1_Right_605 VDD VSS gf180mcu_as_sc_mcu7t3v3__tap_2
XFILLER_151_626 VDD VDD VSS VSS gf180mcu_as_sc_mcu7t3v3__fillcap_4
XFILLER_85_1263 VDD VDD VSS VSS gf180mcu_as_sc_mcu7t3v3__fill_2
XTAP_TAPCELL_ROW_170_1794 VDD VSS gf180mcu_as_sc_mcu7t3v3__tap_2
Xfanout940 VDD VDD VSS VSS wire942/Y _5977_/A gf180mcu_as_sc_mcu7t3v3__buff_12
XFILLER_219_944 VDD VDD VSS VSS gf180mcu_as_sc_mcu7t3v3__fillcap_16
XFILLER_58_640 VDD VDD VSS VSS gf180mcu_as_sc_mcu7t3v3__fill_2
XPHY_EDGE_ROW_189_Right_57 VDD VSS gf180mcu_as_sc_mcu7t3v3__tap_2
Xfanout973 VDD VDD VSS VSS _3364_/A _3356_/A gf180mcu_as_sc_mcu7t3v3__buff_12
XFILLER_161_54 VDD VDD VSS VSS gf180mcu_as_sc_mcu7t3v3__fillcap_16
XPHY_EDGE_ROW_60_3_Left_765 VDD VSS gf180mcu_as_sc_mcu7t3v3__tap_2
XFILLER_206_605 VDD VDD VSS VSS gf180mcu_as_sc_mcu7t3v3__fill_1
XPHY_EDGE_ROW_67_2_Left_508 VDD VSS gf180mcu_as_sc_mcu7t3v3__tap_2
Xhold1193 VDD VDD VSS VSS _6013_/B _3200_/A gf180mcu_as_sc_mcu7t3v3__clkbuff_4
XTAP_TAPCELL_ROW_220_2706 VDD VSS gf180mcu_as_sc_mcu7t3v3__tap_2
XTAP_TAPCELL_ROW_199_2329 VDD VSS gf180mcu_as_sc_mcu7t3v3__tap_2
XTAP_TAPCELL_ROW_199_2318 VDD VSS gf180mcu_as_sc_mcu7t3v3__tap_2
XFILLER_220_129 VDD VDD VSS VSS gf180mcu_as_sc_mcu7t3v3__fill_2
XFILLER_92_1245 VDD VDD VSS VSS gf180mcu_as_sc_mcu7t3v3__fillcap_16
XTAP_TAPCELL_ROW_177_1926 VDD VSS gf180mcu_as_sc_mcu7t3v3__tap_2
XFILLER_158_225 VDD VDD VSS VSS gf180mcu_as_sc_mcu7t3v3__fillcap_16
XFILLER_158_247 VDD VDD VSS VSS gf180mcu_as_sc_mcu7t3v3__fillcap_16
XFILLER_159_748 VDD VDD VSS VSS gf180mcu_as_sc_mcu7t3v3__fill_1
XFILLER_198_383 VDD VDD VSS VSS gf180mcu_as_sc_mcu7t3v3__fill_2
XPHY_EDGE_ROW_198_Right_66 VDD VSS gf180mcu_as_sc_mcu7t3v3__tap_2
XTAP_TAPCELL_ROW_218_2668 VDD VSS gf180mcu_as_sc_mcu7t3v3__tap_2
XTAP_TAPCELL_ROW_218_2657 VDD VSS gf180mcu_as_sc_mcu7t3v3__tap_2
XFILLER_16_1084 VDD VDD VSS VSS gf180mcu_as_sc_mcu7t3v3__fillcap_4
XFILLER_177_1100 VDD VDD VSS VSS gf180mcu_as_sc_mcu7t3v3__fillcap_16
Xclkload16 VDD VDD VSS VSS clkload16/Y _6509_/CLK gf180mcu_as_sc_mcu7t3v3__inv_6
XFILLER_177_1122 VDD VDD VSS VSS gf180mcu_as_sc_mcu7t3v3__fillcap_16
XFILLER_186_84 VDD VDD VSS VSS gf180mcu_as_sc_mcu7t3v3__fill_2
XFILLER_6_942 VDD VDD VSS VSS gf180mcu_as_sc_mcu7t3v3__fill_2
Xclkload27 VDD VDD VSS VSS _6376_/CLK clkload27/Y gf180mcu_as_sc_mcu7t3v3__clkbuff_12
XFILLER_155_998 VDD VDD VSS VSS gf180mcu_as_sc_mcu7t3v3__fillcap_16
XFILLER_142_637 VDD VDD VSS VSS gf180mcu_as_sc_mcu7t3v3__fill_1
XFILLER_214_1049 VDD VDD VSS VSS gf180mcu_as_sc_mcu7t3v3__fillcap_16
XFILLER_205_69 VDD VDD VSS VSS gf180mcu_as_sc_mcu7t3v3__fill_1
X_4070_ VDD VDD VSS VSS _4462_/B _4462_/A _4070_/B _4070_/C _4071_/B gf180mcu_as_sc_mcu7t3v3__ao31_2
XFILLER_3_1116 VDD VDD VSS VSS gf180mcu_as_sc_mcu7t3v3__fillcap_4
X_3021_ VDD VDD VSS VSS _5340_/B _5928_/A gf180mcu_as_sc_mcu7t3v3__inv_2
XFILLER_3_1138 VDD VDD VSS VSS gf180mcu_as_sc_mcu7t3v3__fillcap_16
XPHY_EDGE_ROW_28_3_Right_108 VDD VSS gf180mcu_as_sc_mcu7t3v3__tap_2
XFILLER_149_1257 VDD VDD VSS VSS gf180mcu_as_sc_mcu7t3v3__fill_1
XFILLER_224_435 VDD VDD VSS VSS gf180mcu_as_sc_mcu7t3v3__fillcap_8
XTAP_TAPCELL_ROW_0_1008 VDD VSS gf180mcu_as_sc_mcu7t3v3__tap_2
XFILLER_224_457 VDD VDD VSS VSS gf180mcu_as_sc_mcu7t3v3__fillcap_4
XTAP_TAPCELL_ROW_0_1019 VDD VSS gf180mcu_as_sc_mcu7t3v3__tap_2
X_4972_ VDD VDD VSS VSS _4976_/B _4976_/A _5292_/B gf180mcu_as_sc_mcu7t3v3__and2_2
XFILLER_149_203 VDD VDD VSS VSS gf180mcu_as_sc_mcu7t3v3__fill_1
X_3923_ VDD VDD VSS VSS _3923_/B _3923_/A _4059_/B gf180mcu_as_sc_mcu7t3v3__and2_2
X_3854_ VDD VDD VSS VSS _5837_/A _3854_/B _3854_/C _3854_/D _3855_/B gf180mcu_as_sc_mcu7t3v3__ao211_2
X_3785_ VDD VDD VSS VSS _5781_/A _3805_/B _3785_/C _3785_/D _3786_/A gf180mcu_as_sc_mcu7t3v3__ao211_2
XFILLER_173_751 VDD VDD VSS VSS gf180mcu_as_sc_mcu7t3v3__fill_1
X_5524_ VDD VDD VSS VSS _5573_/S _5829_/A _5524_/A _5527_/A gf180mcu_as_sc_mcu7t3v3__mux2_2
XFILLER_160_401 VDD VDD VSS VSS gf180mcu_as_sc_mcu7t3v3__fill_1
XPHY_EDGE_ROW_33_1_Left_261 VDD VSS gf180mcu_as_sc_mcu7t3v3__tap_2
X_5455_ VDD VDD VSS VSS _5756_/A _5551_/B _5455_/C _5641_/B _5456_/D gf180mcu_as_sc_mcu7t3v3__ao211_2
XTAP_TAPCELL_ROW_152_1480 VDD VSS gf180mcu_as_sc_mcu7t3v3__tap_2
X_4406_ VDD VDD VSS VSS _6226_/Q _4406_/B _4406_/C _6195_/Q _4407_/C gf180mcu_as_sc_mcu7t3v3__ao22_2
XFILLER_160_467 VDD VDD VSS VSS gf180mcu_as_sc_mcu7t3v3__fill_1
XPHY_EDGE_ROW_143_2_Right_980 VDD VSS gf180mcu_as_sc_mcu7t3v3__tap_2
X_5386_ VDD VDD VSS VSS _5693_/A _5495_/B _5386_/C _5386_/D _5387_/B gf180mcu_as_sc_mcu7t3v3__ao211_2
XFILLER_8_1049 VDD VDD VSS VSS gf180mcu_as_sc_mcu7t3v3__fillcap_16
X_4337_ VDD VDD VSS VSS _4339_/A _4337_/C _4337_/B _6151_/Q gf180mcu_as_sc_mcu7t3v3__aoi21_2
X_4268_ VDD VDD VSS VSS _4362_/A _6107_/Q _6020_/Q _4270_/A gf180mcu_as_sc_mcu7t3v3__mux2_2
XFILLER_132_1261 VDD VDD VSS VSS gf180mcu_as_sc_mcu7t3v3__fillcap_4
XFILLER_228_741 VDD VDD VSS VSS gf180mcu_as_sc_mcu7t3v3__fillcap_4
X_6007_ VDD VDD VSS VSS _6525_/D _6198_/Q _6520_/D gf180mcu_as_sc_mcu7t3v3__and2_2
X_3219_ VDD VDD VSS VSS _3220_/D _3291_/B _6528_/D input7/Y gf180mcu_as_sc_mcu7t3v3__aoi21b_2
XTAP_TAPCELL_ROW_87_2_2979 VDD VSS gf180mcu_as_sc_mcu7t3v3__tap_2
XPHY_EDGE_ROW_211_Right_79 VDD VSS gf180mcu_as_sc_mcu7t3v3__tap_2
X_4199_ VDD VDD VSS VSS _4349_/S _6129_/Q _6042_/Q _4201_/A gf180mcu_as_sc_mcu7t3v3__mux2_2
XFILLER_216_947 VDD VDD VSS VSS gf180mcu_as_sc_mcu7t3v3__fillcap_16
XFILLER_199_158 VDD VDD VSS VSS gf180mcu_as_sc_mcu7t3v3__fill_1
XFILLER_187_309 VDD VDD VSS VSS gf180mcu_as_sc_mcu7t3v3__fillcap_4
XFILLER_202_107 VDD VDD VSS VSS gf180mcu_as_sc_mcu7t3v3__fillcap_8
XTAP_TAPCELL_ROW_159_1601 VDD VSS gf180mcu_as_sc_mcu7t3v3__tap_2
XTAP_TAPCELL_ROW_159_1612 VDD VSS gf180mcu_as_sc_mcu7t3v3__tap_2
XTAP_TAPCELL_ROW_194_2237 VDD VSS gf180mcu_as_sc_mcu7t3v3__tap_2
XTAP_TAPCELL_ROW_194_2226 VDD VSS gf180mcu_as_sc_mcu7t3v3__tap_2
XFILLER_11_702 VDD VDD VSS VSS gf180mcu_as_sc_mcu7t3v3__fill_2
XFILLER_11_735 VDD VDD VSS VSS gf180mcu_as_sc_mcu7t3v3__fill_1
XFILLER_156_707 VDD VDD VSS VSS gf180mcu_as_sc_mcu7t3v3__fill_2
XFILLER_13_1224 VDD VDD VSS VSS gf180mcu_as_sc_mcu7t3v3__fill_2
XFILLER_149_781 VDD VDD VSS VSS gf180mcu_as_sc_mcu7t3v3__fill_1
XFILLER_155_206 VDD VDD VSS VSS gf180mcu_as_sc_mcu7t3v3__fillcap_4
XFILLER_155_228 VDD VDD VSS VSS gf180mcu_as_sc_mcu7t3v3__fillcap_16
XFILLER_210_184 VDD VDD VSS VSS gf180mcu_as_sc_mcu7t3v3__fillcap_4
XPHY_EDGE_ROW_220_Right_88 VDD VSS gf180mcu_as_sc_mcu7t3v3__tap_2
XTAP_TAPCELL_ROW_172_1834 VDD VSS gf180mcu_as_sc_mcu7t3v3__tap_2
XTAP_TAPCELL_ROW_172_1845 VDD VSS gf180mcu_as_sc_mcu7t3v3__tap_2
XFILLER_124_626 VDD VDD VSS VSS gf180mcu_as_sc_mcu7t3v3__fill_1
XFILLER_151_401 VDD VDD VSS VSS gf180mcu_as_sc_mcu7t3v3__fill_2
XPHY_EDGE_ROW_34_1_Right_606 VDD VSS gf180mcu_as_sc_mcu7t3v3__tap_2
XTAP_TAPCELL_ROW_213_2576 VDD VSS gf180mcu_as_sc_mcu7t3v3__tap_2
XFILLER_152_979 VDD VDD VSS VSS gf180mcu_as_sc_mcu7t3v3__fillcap_16
XFILLER_3_978 VDD VDD VSS VSS gf180mcu_as_sc_mcu7t3v3__fill_2
XFILLER_151_489 VDD VDD VSS VSS gf180mcu_as_sc_mcu7t3v3__fill_1
XFILLER_172_53 VDD VDD VSS VSS gf180mcu_as_sc_mcu7t3v3__fillcap_16
XPHY_EDGE_ROW_17_2_Right_854 VDD VSS gf180mcu_as_sc_mcu7t3v3__tap_2
Xfanout770 VDD VDD VSS VSS _5311_/B _5242_/B gf180mcu_as_sc_mcu7t3v3__buff_12
Xfanout781 VDD VDD VSS VSS _5313_/B _5296_/B gf180mcu_as_sc_mcu7t3v3__buff_12
XFILLER_1_59 VDD VDD VSS VSS gf180mcu_as_sc_mcu7t3v3__fillcap_8
XFILLER_206_457 VDD VDD VSS VSS gf180mcu_as_sc_mcu7t3v3__fill_2
XFILLER_14_551 VDD VDD VSS VSS gf180mcu_as_sc_mcu7t3v3__fill_1
XFILLER_183_1170 VDD VDD VSS VSS gf180mcu_as_sc_mcu7t3v3__fillcap_16
XFILLER_183_1192 VDD VDD VSS VSS gf180mcu_as_sc_mcu7t3v3__fillcap_16
XFILLER_199_681 VDD VDD VSS VSS gf180mcu_as_sc_mcu7t3v3__fillcap_16
XFILLER_221_449 VDD VDD VSS VSS gf180mcu_as_sc_mcu7t3v3__fill_2
XFILLER_197_72 VDD VDD VSS VSS gf180mcu_as_sc_mcu7t3v3__fillcap_16
XFILLER_201_162 VDD VDD VSS VSS gf180mcu_as_sc_mcu7t3v3__fill_2
XFILLER_202_663 VDD VDD VSS VSS gf180mcu_as_sc_mcu7t3v3__fill_2
XFILLER_202_696 VDD VDD VSS VSS gf180mcu_as_sc_mcu7t3v3__fill_2
X_3570_ VDD VDD VSS VSS _3570_/A _3570_/B _4619_/C _4619_/D _3572_/C gf180mcu_as_sc_mcu7t3v3__ao211_2
XFILLER_170_732 VDD VDD VSS VSS gf180mcu_as_sc_mcu7t3v3__fill_2
XFILLER_182_592 VDD VDD VSS VSS gf180mcu_as_sc_mcu7t3v3__fill_2
XFILLER_5_260 VDD VDD VSS VSS gf180mcu_as_sc_mcu7t3v3__fillcap_16
XFILLER_5_282 VDD VDD VSS VSS gf180mcu_as_sc_mcu7t3v3__fillcap_8
X_5240_ VDD VDD VSS VSS _5310_/B _5888_/B _5242_/C gf180mcu_as_sc_mcu7t3v3__and2_2
XFILLER_170_765 VDD VDD VSS VSS gf180mcu_as_sc_mcu7t3v3__fill_2
XFILLER_130_629 VDD VDD VSS VSS gf180mcu_as_sc_mcu7t3v3__fill_2
XFILLER_155_1250 VDD VDD VSS VSS gf180mcu_as_sc_mcu7t3v3__fillcap_4
X_5171_ VDD VDD VSS VSS _5826_/A _5218_/B _5171_/C _5171_/D _5172_/A gf180mcu_as_sc_mcu7t3v3__ao211_2
XFILLER_116_1245 VDD VDD VSS VSS gf180mcu_as_sc_mcu7t3v3__fillcap_16
X_4122_ VDD VDD VSS VSS _4144_/S _6172_/Q _6171_/Q _6171_/D gf180mcu_as_sc_mcu7t3v3__mux2_2
X_4053_ VDD VDD VSS VSS _4053_/D _4053_/A _4053_/B _4057_/C _6125_/D gf180mcu_as_sc_mcu7t3v3__ao31_2
Xinput3 VDD VDD VSS VSS TILE_ID[2] input3/Y gf180mcu_as_sc_mcu7t3v3__buff_12
X_3004_ VDD VDD VSS VSS _3154_/A _6315_/Q gf180mcu_as_sc_mcu7t3v3__inv_2
Xmesh_tile_1180 VDD VDD VSS VSS sw_out[31] gf180mcu_as_sc_mcu7t3v3__tiel_4
XFILLER_188_1081 VDD VDD VSS VSS gf180mcu_as_sc_mcu7t3v3__fillcap_4
XPHY_EDGE_ROW_29_3_Right_109 VDD VSS gf180mcu_as_sc_mcu7t3v3__tap_2
XFILLER_101_27 VDD VDD VSS VSS gf180mcu_as_sc_mcu7t3v3__fillcap_16
XFILLER_197_607 VDD VDD VSS VSS gf180mcu_as_sc_mcu7t3v3__fill_2
XFILLER_213_939 VDD VDD VSS VSS gf180mcu_as_sc_mcu7t3v3__fillcap_16
X_4955_ VDD VDD VSS VSS _5946_/A _4955_/B _4955_/C _5946_/D _4956_/D gf180mcu_as_sc_mcu7t3v3__ao22_2
XFILLER_162_1221 VDD VDD VSS VSS gf180mcu_as_sc_mcu7t3v3__fillcap_4
XFILLER_162_1243 VDD VDD VSS VSS gf180mcu_as_sc_mcu7t3v3__fillcap_16
X_3906_ VDD VDD VSS VSS _5912_/A _3925_/B _3927_/B _5887_/D _3907_/D gf180mcu_as_sc_mcu7t3v3__ao22_2
XFILLER_177_342 VDD VDD VSS VSS gf180mcu_as_sc_mcu7t3v3__fillcap_8
X_4886_ VDD VDD VSS VSS _4889_/C _4945_/B _5877_/A gf180mcu_as_sc_mcu7t3v3__nand2_2
X_3837_ VDD VDD VSS VSS _3881_/B _3837_/B _5825_/A _3838_/D gf180mcu_as_sc_mcu7t3v3__mux2_2
XFILLER_165_559 VDD VDD VSS VSS gf180mcu_as_sc_mcu7t3v3__fill_1
XFILLER_203_1262 VDD VDD VSS VSS gf180mcu_as_sc_mcu7t3v3__fill_2
XTAP_TAPCELL_ROW_154_1520 VDD VSS gf180mcu_as_sc_mcu7t3v3__tap_2
X_3768_ VDD VDD VSS VSS _5768_/D _3891_/B _3768_/C _3768_/D _3769_/B gf180mcu_as_sc_mcu7t3v3__ao211_2
XFILLER_152_209 VDD VDD VSS VSS gf180mcu_as_sc_mcu7t3v3__fillcap_16
XFILLER_195_1030 VDD VDD VSS VSS gf180mcu_as_sc_mcu7t3v3__fillcap_16
X_5507_ VDD VDD VSS VSS _5813_/A _5565_/B _5566_/B _5816_/A _5510_/C gf180mcu_as_sc_mcu7t3v3__ao22_2
XFILLER_195_1052 VDD VDD VSS VSS gf180mcu_as_sc_mcu7t3v3__fillcap_16
XTAP_TAPCELL_ROW_150_1439 VDD VSS gf180mcu_as_sc_mcu7t3v3__tap_2
X_6487_ VDD VDD VSS VSS _6490_/CLK _6487_/D _6487_/Q gf180mcu_as_sc_mcu7t3v3__dfxtp_2
X_3699_ VDD VDD VSS VSS _3805_/B _5706_/A _3700_/D gf180mcu_as_sc_mcu7t3v3__and2_2
XFILLER_161_754 VDD VDD VSS VSS gf180mcu_as_sc_mcu7t3v3__fill_2
XTAP_TAPCELL_ROW_134_2_3049 VDD VSS gf180mcu_as_sc_mcu7t3v3__tap_2
Xoutput362 VDD VDD VSS VSS _6436_/Q east_out[23] gf180mcu_as_sc_mcu7t3v3__buff_12
Xoutput351 VDD VDD VSS VSS _6426_/Q east_out[13] gf180mcu_as_sc_mcu7t3v3__buff_12
Xoutput340 VDD VDD VSS VSS _6716_/Y dft_rdata[1] gf180mcu_as_sc_mcu7t3v3__buff_12
X_5438_ VDD VDD VSS VSS _5746_/A _5456_/B _5438_/C _5438_/D _5439_/B gf180mcu_as_sc_mcu7t3v3__ao211_2
Xfanout1009 VDD VDD VSS VSS _6012_/A _5909_/D gf180mcu_as_sc_mcu7t3v3__buff_12
Xoutput395 VDD VDD VSS VSS _6361_/Q north_out[20] gf180mcu_as_sc_mcu7t3v3__buff_12
Xoutput384 VDD VDD VSS VSS _6351_/Q north_out[10] gf180mcu_as_sc_mcu7t3v3__buff_12
Xoutput373 VDD VDD VSS VSS _6446_/Q east_out[33] gf180mcu_as_sc_mcu7t3v3__buff_12
X_5369_ VDD VDD VSS VSS _5369_/B _5369_/A _5536_/B gf180mcu_as_sc_mcu7t3v3__and2_2
XPHY_EDGE_ROW_144_2_Right_981 VDD VSS gf180mcu_as_sc_mcu7t3v3__tap_2
XFILLER_142_34 VDD VDD VSS VSS gf180mcu_as_sc_mcu7t3v3__fill_1
XFILLER_142_45 VDD VDD VSS VSS gf180mcu_as_sc_mcu7t3v3__fillcap_4
XTAP_TAPCELL_ROW_13_1240 VDD VSS gf180mcu_as_sc_mcu7t3v3__tap_2
XTAP_TAPCELL_ROW_13_1251 VDD VSS gf180mcu_as_sc_mcu7t3v3__tap_2
XFILLER_167_1154 VDD VDD VSS VSS gf180mcu_as_sc_mcu7t3v3__fillcap_16
XFILLER_16_838 VDD VDD VSS VSS gf180mcu_as_sc_mcu7t3v3__fillcap_8
XFILLER_204_906 VDD VDD VSS VSS gf180mcu_as_sc_mcu7t3v3__fillcap_16
XFILLER_43_613 VDD VDD VSS VSS gf180mcu_as_sc_mcu7t3v3__fill_2
XFILLER_15_348 VDD VDD VSS VSS gf180mcu_as_sc_mcu7t3v3__fill_2
XFILLER_15_359 VDD VDD VSS VSS gf180mcu_as_sc_mcu7t3v3__fillcap_8
XFILLER_208_1151 VDD VDD VSS VSS gf180mcu_as_sc_mcu7t3v3__fillcap_4
XFILLER_196_651 VDD VDD VSS VSS gf180mcu_as_sc_mcu7t3v3__fill_1
XFILLER_208_1173 VDD VDD VSS VSS gf180mcu_as_sc_mcu7t3v3__fillcap_16
XFILLER_183_301 VDD VDD VSS VSS gf180mcu_as_sc_mcu7t3v3__fill_1
XTAP_TAPCELL_ROW_215_2616 VDD VSS gf180mcu_as_sc_mcu7t3v3__tap_2
XTAP_TAPCELL_ROW_215_2605 VDD VSS gf180mcu_as_sc_mcu7t3v3__tap_2
Xclkbuf_3_3_0_clk_regs VDD VDD VSS VSS clkbuf_0_clk_regs/Y clkload0/A gf180mcu_as_sc_mcu7t3v3__clkbuff_12
XFILLER_174_1103 VDD VDD VSS VSS gf180mcu_as_sc_mcu7t3v3__fillcap_16
XPHY_EDGE_ROW_35_1_Right_607 VDD VSS gf180mcu_as_sc_mcu7t3v3__tap_2
XFILLER_112_629 VDD VDD VSS VSS gf180mcu_as_sc_mcu7t3v3__fill_2
XFILLER_215_1100 VDD VDD VSS VSS gf180mcu_as_sc_mcu7t3v3__fillcap_16
XFILLER_215_1122 VDD VDD VSS VSS gf180mcu_as_sc_mcu7t3v3__fillcap_16
XFILLER_2_263 VDD VDD VSS VSS gf180mcu_as_sc_mcu7t3v3__fill_2
XFILLER_76_50 VDD VDD VSS VSS gf180mcu_as_sc_mcu7t3v3__fill_1
XFILLER_19_621 VDD VDD VSS VSS gf180mcu_as_sc_mcu7t3v3__fillcap_16
XPHY_EDGE_ROW_18_2_Right_855 VDD VSS gf180mcu_as_sc_mcu7t3v3__tap_2
XFILLER_185_1232 VDD VDD VSS VSS gf180mcu_as_sc_mcu7t3v3__fill_2
XFILLER_202_37 VDD VDD VSS VSS gf180mcu_as_sc_mcu7t3v3__fillcap_16
XFILLER_221_202 VDD VDD VSS VSS gf180mcu_as_sc_mcu7t3v3__fill_1
XPHY_EDGE_ROW_23_3_Left_728 VDD VSS gf180mcu_as_sc_mcu7t3v3__tap_2
XFILLER_14_381 VDD VDD VSS VSS gf180mcu_as_sc_mcu7t3v3__fillcap_4
XPHY_EDGE_ROW_148_3_Left_853 VDD VSS gf180mcu_as_sc_mcu7t3v3__tap_2
X_4740_ VDD VDD VSS VSS _5752_/A _4795_/B _4795_/C _5752_/D _4741_/D gf180mcu_as_sc_mcu7t3v3__ao22_2
XFILLER_159_364 VDD VDD VSS VSS gf180mcu_as_sc_mcu7t3v3__fillcap_8
XFILLER_174_301 VDD VDD VSS VSS gf180mcu_as_sc_mcu7t3v3__fillcap_8
X_4671_ VDD VDD VSS VSS _4837_/B _5689_/A _4672_/C gf180mcu_as_sc_mcu7t3v3__and2_2
XFILLER_179_1014 VDD VDD VSS VSS gf180mcu_as_sc_mcu7t3v3__fillcap_16
X_6410_ VDD VDD VSS VSS _6412_/CLK _6410_/D _6410_/Q gf180mcu_as_sc_mcu7t3v3__dfxtp_2
X_3622_ VDD VDD VSS VSS _5661_/A _3622_/B _5353_/A gf180mcu_as_sc_mcu7t3v3__nand2_2
X_6341_ VDD VDD VSS VSS _6517_/CLK _6341_/D _6341_/Q gf180mcu_as_sc_mcu7t3v3__dfxtp_2
XFILLER_155_570 VDD VDD VSS VSS gf180mcu_as_sc_mcu7t3v3__fill_1
X_3553_ VDD VDD VSS VSS _5327_/B _3631_/A _5922_/A _5931_/A _3631_/D gf180mcu_as_sc_mcu7t3v3__aoi22_2
XFILLER_227_78 VDD VDD VSS VSS gf180mcu_as_sc_mcu7t3v3__fill_1
X_6272_ VDD VDD VSS VSS _6313_/CLK _6272_/D _6272_/Q gf180mcu_as_sc_mcu7t3v3__dfxtp_2
X_3484_ VDD VDD VSS VSS _5344_/B _5345_/A _5346_/B gf180mcu_as_sc_mcu7t3v3__or2_2
XFILLER_9_1100 VDD VDD VSS VSS gf180mcu_as_sc_mcu7t3v3__fillcap_16
XFILLER_9_1122 VDD VDD VSS VSS gf180mcu_as_sc_mcu7t3v3__fillcap_16
X_5223_ VDD VDD VSS VSS _5225_/C _5872_/D _5242_/B _5223_/C gf180mcu_as_sc_mcu7t3v3__ao21_2
X_5154_ VDD VDD VSS VSS _5228_/S _5812_/A _5154_/A _5155_/B gf180mcu_as_sc_mcu7t3v3__mux2_2
X_4105_ VDD VDD VSS VSS _4106_/C _4105_/B _4106_/A gf180mcu_as_sc_mcu7t3v3__nor2_2
XFILLER_42_1261 VDD VDD VSS VSS gf180mcu_as_sc_mcu7t3v3__fillcap_4
XFILLER_69_598 VDD VDD VSS VSS gf180mcu_as_sc_mcu7t3v3__fill_1
X_5085_ VDD VDD VSS VSS _5087_/C _5141_/B _5749_/B gf180mcu_as_sc_mcu7t3v3__nand2b_2
X_4036_ VDD VDD VSS VSS _4036_/D _4043_/A _4036_/B _4061_/C _6115_/D gf180mcu_as_sc_mcu7t3v3__ao31_2
XFILLER_112_37 VDD VDD VSS VSS gf180mcu_as_sc_mcu7t3v3__fillcap_8
XFILLER_198_916 VDD VDD VSS VSS gf180mcu_as_sc_mcu7t3v3__fillcap_16
XFILLER_201_909 VDD VDD VSS VSS gf180mcu_as_sc_mcu7t3v3__fill_1
X_5987_ VDD VDD VSS VSS _6006_/B _6210_/Q _6500_/D gf180mcu_as_sc_mcu7t3v3__and2_2
XFILLER_178_651 VDD VDD VSS VSS gf180mcu_as_sc_mcu7t3v3__fill_2
X_4938_ VDD VDD VSS VSS _5931_/A _4959_/B _4953_/C _5930_/D _4939_/D gf180mcu_as_sc_mcu7t3v3__ao22_2
XANTENNA_30 VDD VDD VSS VSS _5771_/B gf180mcu_as_sc_mcu7t3v3__diode_2
XANTENNA_41 VDD VDD VSS VSS _5219_/A gf180mcu_as_sc_mcu7t3v3__diode_2
X_4869_ VDD VDD VSS VSS _5214_/A _4888_/B _4869_/C _4870_/D _4960_/B gf180mcu_as_sc_mcu7t3v3__aoi211_2
XANTENNA_52 VDD VDD VSS VSS _5720_/A gf180mcu_as_sc_mcu7t3v3__diode_2
XFILLER_193_632 VDD VDD VSS VSS gf180mcu_as_sc_mcu7t3v3__fillcap_4
XFILLER_10_1205 VDD VDD VSS VSS gf180mcu_as_sc_mcu7t3v3__fillcap_16
XFILLER_10_1227 VDD VDD VSS VSS gf180mcu_as_sc_mcu7t3v3__fillcap_16
X_6539_ VDD VDD VSS VSS clkload9/A _6539_/D _6539_/Q gf180mcu_as_sc_mcu7t3v3__dfxtp_2
XTAP_TAPCELL_ROW_210_2513 VDD VSS gf180mcu_as_sc_mcu7t3v3__tap_2
XTAP_TAPCELL_ROW_189_2136 VDD VSS gf180mcu_as_sc_mcu7t3v3__tap_2
XPHY_EDGE_ROW_76_2_Left_517 VDD VSS gf180mcu_as_sc_mcu7t3v3__tap_2
XTAP_TAPCELL_ROW_210_2524 VDD VSS gf180mcu_as_sc_mcu7t3v3__tap_2
XTAP_TAPCELL_ROW_189_2147 VDD VSS gf180mcu_as_sc_mcu7t3v3__tap_2
XFILLER_161_562 VDD VDD VSS VSS gf180mcu_as_sc_mcu7t3v3__fillcap_4
XFILLER_153_22 VDD VDD VSS VSS gf180mcu_as_sc_mcu7t3v3__fillcap_16
XPHY_EDGE_ROW_145_2_Right_982 VDD VSS gf180mcu_as_sc_mcu7t3v3__tap_2
XTAP_TAPCELL_ROW_167_1744 VDD VSS gf180mcu_as_sc_mcu7t3v3__tap_2
XTAP_TAPCELL_ROW_167_1755 VDD VSS gf180mcu_as_sc_mcu7t3v3__tap_2
XFILLER_153_88 VDD VDD VSS VSS gf180mcu_as_sc_mcu7t3v3__fillcap_16
XTAP_TAPCELL_ROW_208_2486 VDD VSS gf180mcu_as_sc_mcu7t3v3__tap_2
XFILLER_189_916 VDD VDD VSS VSS gf180mcu_as_sc_mcu7t3v3__fill_1
XTAP_TAPCELL_ROW_180_1988 VDD VSS gf180mcu_as_sc_mcu7t3v3__tap_2
XTAP_TAPCELL_ROW_180_1977 VDD VSS gf180mcu_as_sc_mcu7t3v3__tap_2
XFILLER_16_679 VDD VDD VSS VSS gf180mcu_as_sc_mcu7t3v3__fill_1
XFILLER_19_1230 VDD VDD VSS VSS gf180mcu_as_sc_mcu7t3v3__fillcap_8
XFILLER_203_224 VDD VDD VSS VSS gf180mcu_as_sc_mcu7t3v3__fillcap_16
XFILLER_204_758 VDD VDD VSS VSS gf180mcu_as_sc_mcu7t3v3__fillcap_4
XPHY_EDGE_ROW_80_3_Right_160 VDD VSS gf180mcu_as_sc_mcu7t3v3__tap_2
XFILLER_157_802 VDD VDD VSS VSS gf180mcu_as_sc_mcu7t3v3__fill_1
XFILLER_178_30 VDD VDD VSS VSS gf180mcu_as_sc_mcu7t3v3__fillcap_4
XFILLER_197_960 VDD VDD VSS VSS gf180mcu_as_sc_mcu7t3v3__fillcap_16
XFILLER_15_1116 VDD VDD VSS VSS gf180mcu_as_sc_mcu7t3v3__fillcap_4
XFILLER_180_1151 VDD VDD VSS VSS gf180mcu_as_sc_mcu7t3v3__fillcap_4
XFILLER_180_1173 VDD VDD VSS VSS gf180mcu_as_sc_mcu7t3v3__fillcap_16
XFILLER_197_982 VDD VDD VSS VSS gf180mcu_as_sc_mcu7t3v3__fillcap_16
XFILLER_8_823 VDD VDD VSS VSS gf180mcu_as_sc_mcu7t3v3__fillcap_16
XFILLER_11_362 VDD VDD VSS VSS gf180mcu_as_sc_mcu7t3v3__fill_1
XFILLER_11_373 VDD VDD VSS VSS gf180mcu_as_sc_mcu7t3v3__fill_1
XFILLER_157_846 VDD VDD VSS VSS gf180mcu_as_sc_mcu7t3v3__fill_2
XFILLER_15_1138 VDD VDD VSS VSS gf180mcu_as_sc_mcu7t3v3__fillcap_16
XFILLER_183_142 VDD VDD VSS VSS gf180mcu_as_sc_mcu7t3v3__fillcap_4
XFILLER_221_1170 VDD VDD VSS VSS gf180mcu_as_sc_mcu7t3v3__fillcap_16
XFILLER_7_69 VDD VDD VSS VSS gf180mcu_as_sc_mcu7t3v3__fill_1
XFILLER_183_186 VDD VDD VSS VSS gf180mcu_as_sc_mcu7t3v3__fill_2
XFILLER_221_1192 VDD VDD VSS VSS gf180mcu_as_sc_mcu7t3v3__fillcap_16
XFILLER_152_540 VDD VDD VSS VSS gf180mcu_as_sc_mcu7t3v3__fillcap_8
XFILLER_171_348 VDD VDD VSS VSS gf180mcu_as_sc_mcu7t3v3__fill_2
XPHY_EDGE_ROW_36_1_Right_608 VDD VSS gf180mcu_as_sc_mcu7t3v3__tap_2
XFILLER_26_1245 VDD VDD VSS VSS gf180mcu_as_sc_mcu7t3v3__fillcap_16
Xclkbuf_leaf_1_clk_regs VDD VDD VSS VSS clkbuf_3_0_0_clk_regs/Y _6484_/CLK gf180mcu_as_sc_mcu7t3v3__clkbuff_12
XFILLER_213_69 VDD VDD VSS VSS gf180mcu_as_sc_mcu7t3v3__fill_1
XPHY_EDGE_ROW_19_2_Right_856 VDD VSS gf180mcu_as_sc_mcu7t3v3__tap_2
XFILLER_207_552 VDD VDD VSS VSS gf180mcu_as_sc_mcu7t3v3__fillcap_8
X_5910_ VDD VDD VSS VSS _6477_/D _5910_/C _5926_/B _5910_/A gf180mcu_as_sc_mcu7t3v3__aoi21b_2
XFILLER_179_415 VDD VDD VSS VSS gf180mcu_as_sc_mcu7t3v3__fillcap_4
XFILLER_179_426 VDD VDD VSS VSS gf180mcu_as_sc_mcu7t3v3__fill_1
XFILLER_185_1084 VDD VDD VSS VSS gf180mcu_as_sc_mcu7t3v3__fillcap_16
XPHY_EDGE_ROW_42_1_Left_270 VDD VSS gf180mcu_as_sc_mcu7t3v3__tap_2
X_5841_ VDD VDD VSS VSS _5843_/B _5841_/C _5841_/B _5841_/A gf180mcu_as_sc_mcu7t3v3__aoi21_2
XFILLER_179_448 VDD VDD VSS VSS gf180mcu_as_sc_mcu7t3v3__fill_2
XFILLER_195_908 VDD VDD VSS VSS gf180mcu_as_sc_mcu7t3v3__fill_2
XFILLER_72_1210 VDD VDD VSS VSS gf180mcu_as_sc_mcu7t3v3__fillcap_4
X_5772_ VDD VDD VSS VSS _5873_/B _5772_/A _5777_/C gf180mcu_as_sc_mcu7t3v3__and2_2
XFILLER_226_1081 VDD VDD VSS VSS gf180mcu_as_sc_mcu7t3v3__fillcap_4
X_4723_ VDD VDD VSS VSS _5736_/A _4863_/B _4723_/C _4725_/B _4724_/C gf180mcu_as_sc_mcu7t3v3__ao211_2
XFILLER_187_492 VDD VDD VSS VSS gf180mcu_as_sc_mcu7t3v3__fill_1
XFILLER_200_1221 VDD VDD VSS VSS gf180mcu_as_sc_mcu7t3v3__fillcap_4
X_4654_ VDD VDD VSS VSS _4654_/Y _4967_/A _4967_/B gf180mcu_as_sc_mcu7t3v3__nand2_2
Xinput50 VDD VDD VSS VSS east_in[0] wire962/A gf180mcu_as_sc_mcu7t3v3__buff_12
Xinput61 VDD VDD VSS VSS east_in[1] _5681_/A gf180mcu_as_sc_mcu7t3v3__buff_12
Xinput72 VDD VDD VSS VSS east_in[2] _5689_/A gf180mcu_as_sc_mcu7t3v3__buff_12
X_4585_ VDD VDD VSS VSS _4586_/B _4585_/A _6323_/D gf180mcu_as_sc_mcu7t3v3__and2_2
X_3605_ VDD VDD VSS VSS _3606_/B _3607_/D _3607_/C gf180mcu_as_sc_mcu7t3v3__nand2_2
Xinput83 VDD VDD VSS VSS east_in[7] _5731_/A gf180mcu_as_sc_mcu7t3v3__buff_12
Xinput94 VDD VDD VSS VSS ne_in[17] _5817_/D gf180mcu_as_sc_mcu7t3v3__buff_12
Xmax_cap553 VDD VDD VSS VSS _5306_/D _5275_/B gf180mcu_as_sc_mcu7t3v3__clkbuff_12
X_6324_ VDD VDD VSS VSS clkload6/A _6324_/D _6324_/Q gf180mcu_as_sc_mcu7t3v3__dfxtp_2
X_3536_ VDD VDD VSS VSS _3540_/C _5301_/A _3542_/B gf180mcu_as_sc_mcu7t3v3__nor2b_2
XFILLER_192_1033 VDD VDD VSS VSS gf180mcu_as_sc_mcu7t3v3__fillcap_16
X_6255_ VDD VDD VSS VSS _6313_/CLK _6255_/D _6255_/Q gf180mcu_as_sc_mcu7t3v3__dfxtp_2
XFILLER_157_1186 VDD VDD VSS VSS gf180mcu_as_sc_mcu7t3v3__fillcap_4
XFILLER_170_381 VDD VDD VSS VSS gf180mcu_as_sc_mcu7t3v3__fillcap_4
X_5206_ VDD VDD VSS VSS _5208_/C _6515_/Q _5206_/B _5206_/C gf180mcu_as_sc_mcu7t3v3__ao21_2
X_3467_ VDD VDD VSS VSS _5351_/A _3474_/B _3474_/A gf180mcu_as_sc_mcu7t3v3__nand2_2
XTAP_TAPCELL_ROW_149_1430 VDD VSS gf180mcu_as_sc_mcu7t3v3__tap_2
X_6186_ VDD VDD VSS VSS _6490_/CLK _6186_/D _6186_/Q gf180mcu_as_sc_mcu7t3v3__dfxtp_2
X_3398_ VDD VDD VSS VSS _3398_/D _6162_/Q _4104_/B _4569_/B _3399_/B gf180mcu_as_sc_mcu7t3v3__ao31_2
XTAP_TAPCELL_ROW_184_2055 VDD VSS gf180mcu_as_sc_mcu7t3v3__tap_2
XTAP_TAPCELL_ROW_114_3_3020 VDD VSS gf180mcu_as_sc_mcu7t3v3__tap_2
X_5137_ VDD VDD VSS VSS _5137_/B _5291_/A _6391_/D gf180mcu_as_sc_mcu7t3v3__and2_2
X_5068_ VDD VDD VSS VSS _6500_/Q _5206_/B _5207_/C _5735_/D _5069_/D gf180mcu_as_sc_mcu7t3v3__ao22_2
XTAP_TAPCELL_ROW_162_1652 VDD VSS gf180mcu_as_sc_mcu7t3v3__tap_2
X_4019_ VDD VDD VSS VSS _4061_/C _5977_/A _4029_/C gf180mcu_as_sc_mcu7t3v3__and2_2
XTAP_TAPCELL_ROW_162_1663 VDD VSS gf180mcu_as_sc_mcu7t3v3__tap_2
XFILLER_13_605 VDD VDD VSS VSS gf180mcu_as_sc_mcu7t3v3__fill_1
XFILLER_164_1135 VDD VDD VSS VSS gf180mcu_as_sc_mcu7t3v3__fillcap_16
XFILLER_16_67 VDD VDD VSS VSS gf180mcu_as_sc_mcu7t3v3__fill_1
XFILLER_213_522 VDD VDD VSS VSS gf180mcu_as_sc_mcu7t3v3__fillcap_8
XPHY_EDGE_ROW_0_Right_0 VDD VSS gf180mcu_as_sc_mcu7t3v3__tap_2
XTAP_TAPCELL_ROW_203_2394 VDD VSS gf180mcu_as_sc_mcu7t3v3__tap_2
XFILLER_12_104 VDD VDD VSS VSS gf180mcu_as_sc_mcu7t3v3__fill_1
XFILLER_164_1157 VDD VDD VSS VSS gf180mcu_as_sc_mcu7t3v3__fillcap_16
XFILLER_197_245 VDD VDD VSS VSS gf180mcu_as_sc_mcu7t3v3__fillcap_4
XFILLER_200_205 VDD VDD VSS VSS gf180mcu_as_sc_mcu7t3v3__fillcap_16
XFILLER_179_982 VDD VDD VSS VSS gf180mcu_as_sc_mcu7t3v3__fillcap_16
XFILLER_185_407 VDD VDD VSS VSS gf180mcu_as_sc_mcu7t3v3__fillcap_4
XPHY_EDGE_ROW_161_Right_29 VDD VSS gf180mcu_as_sc_mcu7t3v3__tap_2
XFILLER_165_120 VDD VDD VSS VSS gf180mcu_as_sc_mcu7t3v3__fillcap_16
XFILLER_178_492 VDD VDD VSS VSS gf180mcu_as_sc_mcu7t3v3__fill_2
XFILLER_205_1154 VDD VDD VSS VSS gf180mcu_as_sc_mcu7t3v3__fillcap_16
XFILLER_165_142 VDD VDD VSS VSS gf180mcu_as_sc_mcu7t3v3__fillcap_16
XFILLER_193_440 VDD VDD VSS VSS gf180mcu_as_sc_mcu7t3v3__fill_1
XFILLER_194_963 VDD VDD VSS VSS gf180mcu_as_sc_mcu7t3v3__fillcap_16
XFILLER_88_1261 VDD VDD VSS VSS gf180mcu_as_sc_mcu7t3v3__fillcap_4
XFILLER_175_1264 VDD VDD VSS VSS gf180mcu_as_sc_mcu7t3v3__fill_1
XPHY_EDGE_ROW_170_Right_38 VDD VSS gf180mcu_as_sc_mcu7t3v3__tap_2
XFILLER_212_1103 VDD VDD VSS VSS gf180mcu_as_sc_mcu7t3v3__fillcap_16
XFILLER_169_1002 VDD VDD VSS VSS gf180mcu_as_sc_mcu7t3v3__fillcap_16
XFILLER_209_839 VDD VDD VSS VSS gf180mcu_as_sc_mcu7t3v3__fill_1
XPHY_EDGE_ROW_146_2_Right_983 VDD VSS gf180mcu_as_sc_mcu7t3v3__tap_2
XFILLER_95_1210 VDD VDD VSS VSS gf180mcu_as_sc_mcu7t3v3__fill_1
XTAP_TAPCELL_ROW_223_2759 VDD VSS gf180mcu_as_sc_mcu7t3v3__tap_2
XTAP_TAPCELL_ROW_223_2748 VDD VSS gf180mcu_as_sc_mcu7t3v3__tap_2
XFILLER_169_1068 VDD VDD VSS VSS gf180mcu_as_sc_mcu7t3v3__fillcap_16
XFILLER_189_702 VDD VDD VSS VSS gf180mcu_as_sc_mcu7t3v3__fillcap_4
XFILLER_182_1235 VDD VDD VSS VSS gf180mcu_as_sc_mcu7t3v3__fillcap_4
XPHY_EDGE_ROW_81_3_Right_161 VDD VSS gf180mcu_as_sc_mcu7t3v3__tap_2
XFILLER_157_643 VDD VDD VSS VSS gf180mcu_as_sc_mcu7t3v3__fill_1
XFILLER_197_790 VDD VDD VSS VSS gf180mcu_as_sc_mcu7t3v3__fill_1
XFILLER_185_974 VDD VDD VSS VSS gf180mcu_as_sc_mcu7t3v3__fillcap_4
XFILLER_8_664 VDD VDD VSS VSS gf180mcu_as_sc_mcu7t3v3__fill_1
XFILLER_176_1017 VDD VDD VSS VSS gf180mcu_as_sc_mcu7t3v3__fillcap_16
XFILLER_184_473 VDD VDD VSS VSS gf180mcu_as_sc_mcu7t3v3__fillcap_4
XFILLER_7_174 VDD VDD VSS VSS gf180mcu_as_sc_mcu7t3v3__fillcap_16
X_4370_ VDD VDD VSS VSS _4370_/S _6063_/Q _6092_/Q _4373_/B gf180mcu_as_sc_mcu7t3v3__mux2_2
XFILLER_208_69 VDD VDD VSS VSS gf180mcu_as_sc_mcu7t3v3__fillcap_16
XFILLER_217_1014 VDD VDD VSS VSS gf180mcu_as_sc_mcu7t3v3__fillcap_16
X_3321_ VDD VDD VSS VSS _3321_/B _3353_/A _3323_/B gf180mcu_as_sc_mcu7t3v3__or2_2
XFILLER_6_1103 VDD VDD VSS VSS gf180mcu_as_sc_mcu7t3v3__fillcap_16
XPHY_EDGE_ROW_37_1_Right_609 VDD VSS gf180mcu_as_sc_mcu7t3v3__tap_2
X_6040_ VDD VDD VSS VSS _6370_/CLK _6040_/D _6040_/Q gf180mcu_as_sc_mcu7t3v3__dfxtp_2
X_3252_ VDD VDD VSS VSS _6296_/Q _3280_/C _3252_/C _4465_/C _3253_/B gf180mcu_as_sc_mcu7t3v3__ao211_2
X_3183_ VDD VDD VSS VSS _4280_/D _6194_/Q _6193_/Q gf180mcu_as_sc_mcu7t3v3__nor2_2
XFILLER_227_647 VDD VDD VSS VSS gf180mcu_as_sc_mcu7t3v3__fill_2
XTAP_TAPCELL_ROW_7_1142 VDD VSS gf180mcu_as_sc_mcu7t3v3__tap_2
XTAP_TAPCELL_ROW_7_1131 VDD VSS gf180mcu_as_sc_mcu7t3v3__tap_2
XFILLER_208_861 VDD VDD VSS VSS gf180mcu_as_sc_mcu7t3v3__fillcap_8
XFILLER_226_135 VDD VDD VSS VSS gf180mcu_as_sc_mcu7t3v3__fill_2
XFILLER_228_1121 VDD VDD VSS VSS gf180mcu_as_sc_mcu7t3v3__fill_1
X_5824_ VDD VDD VSS VSS _5824_/A _5864_/B _5824_/C _5824_/D _5826_/C gf180mcu_as_sc_mcu7t3v3__ao211_2
XFILLER_167_418 VDD VDD VSS VSS gf180mcu_as_sc_mcu7t3v3__fill_2
XFILLER_194_215 VDD VDD VSS VSS gf180mcu_as_sc_mcu7t3v3__fillcap_8
XTAP_TAPCELL_ROW_112_1_1377 VDD VSS gf180mcu_as_sc_mcu7t3v3__tap_2
X_5755_ VDD VDD VSS VSS _5755_/B _5836_/A _6458_/D gf180mcu_as_sc_mcu7t3v3__and2_2
X_5686_ VDD VDD VSS VSS _5686_/A _5802_/B _5686_/C _5686_/D _5687_/B gf180mcu_as_sc_mcu7t3v3__ao211_2
X_4706_ VDD VDD VSS VSS _4797_/S _4706_/B _5721_/A _4707_/B gf180mcu_as_sc_mcu7t3v3__mux2_2
XFILLER_162_101 VDD VDD VSS VSS gf180mcu_as_sc_mcu7t3v3__fillcap_4
XFILLER_163_613 VDD VDD VSS VSS gf180mcu_as_sc_mcu7t3v3__fill_2
XFILLER_191_922 VDD VDD VSS VSS gf180mcu_as_sc_mcu7t3v3__fillcap_16
X_4637_ VDD VDD VSS VSS _4842_/B _4647_/A _4647_/B gf180mcu_as_sc_mcu7t3v3__nor2_2
XFILLER_162_123 VDD VDD VSS VSS gf180mcu_as_sc_mcu7t3v3__fillcap_16
X_4568_ VDD VDD VSS VSS _4568_/B _4583_/B _6309_/D gf180mcu_as_sc_mcu7t3v3__and2_2
X_6307_ VDD VDD VSS VSS _6531_/CLK _6307_/D _6307_/Q gf180mcu_as_sc_mcu7t3v3__dfxtp_2
X_4499_ VDD VDD VSS VSS _4499_/A _4512_/S _4499_/C _4499_/D _4500_/C gf180mcu_as_sc_mcu7t3v3__ao22_2
X_3519_ VDD VDD VSS VSS _4627_/D _5950_/D _5951_/A gf180mcu_as_sc_mcu7t3v3__nor2b_2
X_6238_ VDD VDD VSS VSS _6316_/CLK _6238_/D _6238_/Q gf180mcu_as_sc_mcu7t3v3__dfxtp_2
XPHY_EDGE_ROW_100_3_Left_805 VDD VSS gf180mcu_as_sc_mcu7t3v3__tap_2
X_6169_ VDD VDD VSS VSS _6526_/CLK _6169_/D _6169_/Q gf180mcu_as_sc_mcu7t3v3__dfxtp_2
XFILLER_217_135 VDD VDD VSS VSS gf180mcu_as_sc_mcu7t3v3__fillcap_4
XFILLER_218_669 VDD VDD VSS VSS gf180mcu_as_sc_mcu7t3v3__fill_1
XTAP_TAPCELL_ROW_205_2434 VDD VSS gf180mcu_as_sc_mcu7t3v3__tap_2
XTAP_TAPCELL_ROW_205_2423 VDD VSS gf180mcu_as_sc_mcu7t3v3__tap_2
XFILLER_150_34 VDD VDD VSS VSS gf180mcu_as_sc_mcu7t3v3__fill_1
XFILLER_14_925 VDD VDD VSS VSS gf180mcu_as_sc_mcu7t3v3__fillcap_16
XFILLER_14_947 VDD VDD VSS VSS gf180mcu_as_sc_mcu7t3v3__fillcap_16
XFILLER_198_543 VDD VDD VSS VSS gf180mcu_as_sc_mcu7t3v3__fillcap_4
XTAP_TAPCELL_ROW_197_2279 VDD VSS gf180mcu_as_sc_mcu7t3v3__tap_2
XFILLER_198_576 VDD VDD VSS VSS gf180mcu_as_sc_mcu7t3v3__fillcap_4
XFILLER_43_43 VDD VDD VSS VSS gf180mcu_as_sc_mcu7t3v3__fillcap_8
XFILLER_139_610 VDD VDD VSS VSS gf180mcu_as_sc_mcu7t3v3__fill_2
XFILLER_159_54 VDD VDD VSS VSS gf180mcu_as_sc_mcu7t3v3__fillcap_16
XFILLER_201_547 VDD VDD VSS VSS gf180mcu_as_sc_mcu7t3v3__fillcap_8
XFILLER_103_1214 VDD VDD VSS VSS gf180mcu_as_sc_mcu7t3v3__fill_1
XFILLER_12_1119 VDD VDD VSS VSS gf180mcu_as_sc_mcu7t3v3__fillcap_16
XFILLER_223_2 VDD VDD VSS VSS gf180mcu_as_sc_mcu7t3v3__fillcap_16
XFILLER_154_613 VDD VDD VSS VSS gf180mcu_as_sc_mcu7t3v3__fillcap_8
XFILLER_167_996 VDD VDD VSS VSS gf180mcu_as_sc_mcu7t3v3__fillcap_16
XTAP_TAPCELL_ROW_175_1887 VDD VSS gf180mcu_as_sc_mcu7t3v3__tap_2
XTAP_TAPCELL_ROW_175_1898 VDD VSS gf180mcu_as_sc_mcu7t3v3__tap_2
XFILLER_154_646 VDD VDD VSS VSS gf180mcu_as_sc_mcu7t3v3__fillcap_16
XFILLER_181_432 VDD VDD VSS VSS gf180mcu_as_sc_mcu7t3v3__fillcap_16
XFILLER_5_634 VDD VDD VSS VSS gf180mcu_as_sc_mcu7t3v3__fill_1
XFILLER_154_679 VDD VDD VSS VSS gf180mcu_as_sc_mcu7t3v3__fill_1
XFILLER_4_166 VDD VDD VSS VSS gf180mcu_as_sc_mcu7t3v3__fillcap_8
XFILLER_4_177 VDD VDD VSS VSS gf180mcu_as_sc_mcu7t3v3__fillcap_16
XFILLER_4_37 VDD VDD VSS VSS gf180mcu_as_sc_mcu7t3v3__fillcap_16
XPHY_EDGE_ROW_32_3_Left_737 VDD VSS gf180mcu_as_sc_mcu7t3v3__tap_2
XTAP_TAPCELL_ROW_90_3_2984 VDD VSS gf180mcu_as_sc_mcu7t3v3__tap_2
XFILLER_150_863 VDD VDD VSS VSS gf180mcu_as_sc_mcu7t3v3__fill_1
Xinput240 VDD VDD VSS VSS south_in[18] _5823_/A gf180mcu_as_sc_mcu7t3v3__buff_12
Xinput251 VDD VDD VSS VSS south_in[28] _5904_/A gf180mcu_as_sc_mcu7t3v3__buff_12
Xinput262 VDD VDD VSS VSS south_in[5] _5717_/A gf180mcu_as_sc_mcu7t3v3__buff_12
XFILLER_84_50 VDD VDD VSS VSS gf180mcu_as_sc_mcu7t3v3__fill_1
XPHY_EDGE_ROW_147_2_Right_984 VDD VSS gf180mcu_as_sc_mcu7t3v3__tap_2
Xinput273 VDD VDD VSS VSS sw_in[15] _5145_/B gf180mcu_as_sc_mcu7t3v3__buff_12
Xinput284 VDD VDD VSS VSS sw_in[25] _5237_/B gf180mcu_as_sc_mcu7t3v3__buff_12
Xinput295 VDD VDD VSS VSS sw_in[35] _4652_/A gf180mcu_as_sc_mcu7t3v3__buff_12
XFILLER_208_179 VDD VDD VSS VSS gf180mcu_as_sc_mcu7t3v3__fill_1
XFILLER_16_240 VDD VDD VSS VSS gf180mcu_as_sc_mcu7t3v3__fillcap_8
XFILLER_91_666 VDD VDD VSS VSS gf180mcu_as_sc_mcu7t3v3__fill_1
XFILLER_210_37 VDD VDD VSS VSS gf180mcu_as_sc_mcu7t3v3__fillcap_16
XTAP_TAPCELL_ROW_2_1050 VDD VSS gf180mcu_as_sc_mcu7t3v3__tap_2
XFILLER_182_1065 VDD VDD VSS VSS gf180mcu_as_sc_mcu7t3v3__fillcap_16
X_3870_ VDD VDD VSS VSS _5855_/A _3925_/C _3870_/C _3870_/D _3872_/C gf180mcu_as_sc_mcu7t3v3__ao211_2
XFILLER_182_1087 VDD VDD VSS VSS gf180mcu_as_sc_mcu7t3v3__fillcap_16
XPHY_EDGE_ROW_82_3_Right_162 VDD VSS gf180mcu_as_sc_mcu7t3v3__tap_2
XFILLER_223_1084 VDD VDD VSS VSS gf180mcu_as_sc_mcu7t3v3__fillcap_16
X_5540_ VDD VDD VSS VSS _5567_/B _5849_/D _5544_/C gf180mcu_as_sc_mcu7t3v3__and2_2
XFILLER_184_270 VDD VDD VSS VSS gf180mcu_as_sc_mcu7t3v3__fillcap_4
XFILLER_191_229 VDD VDD VSS VSS gf180mcu_as_sc_mcu7t3v3__fill_2
X_5471_ VDD VDD VSS VSS _5778_/A _5568_/C _5471_/C _5568_/B _5473_/A gf180mcu_as_sc_mcu7t3v3__ao211_2
X_4422_ VDD VDD VSS VSS _6238_/Q _4422_/B _4422_/C _6237_/Q _6237_/D gf180mcu_as_sc_mcu7t3v3__ao22_2
XFILLER_119_1210 VDD VDD VSS VSS gf180mcu_as_sc_mcu7t3v3__fillcap_16
X_4353_ VDD VDD VSS VSS _6218_/D _4353_/B _4353_/A gf180mcu_as_sc_mcu7t3v3__nand2_2
XPHY_EDGE_ROW_89_3_Left_794 VDD VSS gf180mcu_as_sc_mcu7t3v3__tap_2
X_4284_ VDD VDD VSS VSS _4285_/C _4362_/A _6022_/Q gf180mcu_as_sc_mcu7t3v3__nor2b_2
X_3304_ VDD VDD VSS VSS _6136_/Q _6137_/Q _3304_/Y gf180mcu_as_sc_mcu7t3v3__and2_2
XFILLER_154_1189 VDD VDD VSS VSS gf180mcu_as_sc_mcu7t3v3__fillcap_16
X_6023_ VDD VDD VSS VSS _6520_/CLK _6023_/D _6023_/Q gf180mcu_as_sc_mcu7t3v3__dfxtp_2
X_3235_ VDD VDD VSS VSS _3237_/C _3261_/A _3280_/C _6295_/Q gf180mcu_as_sc_mcu7t3v3__aoi21_2
XTAP_TAPCELL_ROW_181_2003 VDD VSS gf180mcu_as_sc_mcu7t3v3__tap_2
XFILLER_104_27 VDD VDD VSS VSS gf180mcu_as_sc_mcu7t3v3__fillcap_8
XFILLER_189_1208 VDD VDD VSS VSS gf180mcu_as_sc_mcu7t3v3__fillcap_16
XFILLER_104_49 VDD VDD VSS VSS gf180mcu_as_sc_mcu7t3v3__fill_2
X_3166_ VDD VDD VSS VSS _6531_/D _4411_/A _3166_/A gf180mcu_as_sc_mcu7t3v3__nor2b_2
XFILLER_215_617 VDD VDD VSS VSS gf180mcu_as_sc_mcu7t3v3__fill_2
XPHY_EDGE_ROW_148_2_Left_589 VDD VSS gf180mcu_as_sc_mcu7t3v3__tap_2
X_3097_ VDD VDD VSS VSS _4497_/A _6139_/Q gf180mcu_as_sc_mcu7t3v3__inv_2
XFILLER_120_37 VDD VDD VSS VSS gf180mcu_as_sc_mcu7t3v3__fillcap_8
XFILLER_165_1230 VDD VDD VSS VSS gf180mcu_as_sc_mcu7t3v3__fill_1
XPHY_EDGE_ROW_85_2_Left_526 VDD VSS gf180mcu_as_sc_mcu7t3v3__tap_2
XTAP_TAPCELL_ROW_200_2342 VDD VSS gf180mcu_as_sc_mcu7t3v3__tap_2
XFILLER_11_906 VDD VDD VSS VSS gf180mcu_as_sc_mcu7t3v3__fillcap_4
XFILLER_161_1116 VDD VDD VSS VSS gf180mcu_as_sc_mcu7t3v3__fillcap_4
XFILLER_11_928 VDD VDD VSS VSS gf180mcu_as_sc_mcu7t3v3__fillcap_16
XFILLER_149_941 VDD VDD VSS VSS gf180mcu_as_sc_mcu7t3v3__fillcap_8
XFILLER_161_1138 VDD VDD VSS VSS gf180mcu_as_sc_mcu7t3v3__fillcap_16
X_5807_ VDD VDD VSS VSS _5807_/A _5861_/B _5807_/C _5871_/D _5808_/D gf180mcu_as_sc_mcu7t3v3__ao22_2
X_3999_ VDD VDD VSS VSS _4037_/B _4012_/B _4012_/C _6087_/Q _6087_/D gf180mcu_as_sc_mcu7t3v3__ao22_2
XFILLER_10_438 VDD VDD VSS VSS gf180mcu_as_sc_mcu7t3v3__fill_2
X_5738_ VDD VDD VSS VSS _5738_/B _5836_/A _6456_/D gf180mcu_as_sc_mcu7t3v3__and2_2
XFILLER_13_68 VDD VDD VSS VSS gf180mcu_as_sc_mcu7t3v3__fill_2
XFILLER_202_1135 VDD VDD VSS VSS gf180mcu_as_sc_mcu7t3v3__fillcap_16
XFILLER_202_1157 VDD VDD VSS VSS gf180mcu_as_sc_mcu7t3v3__fillcap_16
XTAP_TAPCELL_ROW_157_1562 VDD VSS gf180mcu_as_sc_mcu7t3v3__tap_2
XTAP_TAPCELL_ROW_157_1573 VDD VSS gf180mcu_as_sc_mcu7t3v3__tap_2
XTAP_TAPCELL_ROW_192_2198 VDD VSS gf180mcu_as_sc_mcu7t3v3__tap_2
X_5669_ VDD VDD VSS VSS _5874_/B _5669_/A _5678_/C gf180mcu_as_sc_mcu7t3v3__and2_2
XTAP_TAPCELL_ROW_46_1_1344 VDD VSS gf180mcu_as_sc_mcu7t3v3__tap_2
XFILLER_163_487 VDD VDD VSS VSS gf180mcu_as_sc_mcu7t3v3__fill_2
XFILLER_190_262 VDD VDD VSS VSS gf180mcu_as_sc_mcu7t3v3__fillcap_4
XTAP_TAPCELL_ROW_102_3_3002 VDD VSS gf180mcu_as_sc_mcu7t3v3__tap_2
XFILLER_145_45 VDD VDD VSS VSS gf180mcu_as_sc_mcu7t3v3__fillcap_4
XFILLER_190_284 VDD VDD VSS VSS gf180mcu_as_sc_mcu7t3v3__fill_1
XFILLER_2_648 VDD VDD VSS VSS gf180mcu_as_sc_mcu7t3v3__fill_2
XTAP_TAPCELL_ROW_170_1795 VDD VSS gf180mcu_as_sc_mcu7t3v3__tap_2
XFILLER_1_158 VDD VDD VSS VSS gf180mcu_as_sc_mcu7t3v3__fill_2
Xfanout930 VDD VDD VSS VSS wire942/Y _5586_/A gf180mcu_as_sc_mcu7t3v3__buff_12
Xfanout941 VDD VDD VSS VSS _3040_/Y wire942/A gf180mcu_as_sc_mcu7t3v3__buff_12
XFILLER_161_22 VDD VDD VSS VSS gf180mcu_as_sc_mcu7t3v3__fillcap_16
XFILLER_219_912 VDD VDD VSS VSS gf180mcu_as_sc_mcu7t3v3__fillcap_16
Xfanout963 VDD VDD VSS VSS _5943_/D _4272_/A gf180mcu_as_sc_mcu7t3v3__buff_12
Xfanout974 VDD VDD VSS VSS _3277_/C _3364_/A gf180mcu_as_sc_mcu7t3v3__buff_12
XFILLER_213_1264 VDD VDD VSS VSS gf180mcu_as_sc_mcu7t3v3__fill_1
XTAP_TAPCELL_ROW_16_1293 VDD VSS gf180mcu_as_sc_mcu7t3v3__tap_2
XFILLER_161_88 VDD VDD VSS VSS gf180mcu_as_sc_mcu7t3v3__fillcap_16
Xhold1194 VDD VDD VSS VSS _3199_/Y hold1194/Y gf180mcu_as_sc_mcu7t3v3__clkbuff_4
XTAP_TAPCELL_ROW_220_2707 VDD VSS gf180mcu_as_sc_mcu7t3v3__tap_2
XTAP_TAPCELL_ROW_199_2319 VDD VSS gf180mcu_as_sc_mcu7t3v3__tap_2
XFILLER_73_666 VDD VDD VSS VSS gf180mcu_as_sc_mcu7t3v3__fill_1
XFILLER_14_733 VDD VDD VSS VSS gf180mcu_as_sc_mcu7t3v3__fill_2
XFILLER_166_1049 VDD VDD VSS VSS gf180mcu_as_sc_mcu7t3v3__fillcap_16
XFILLER_159_727 VDD VDD VSS VSS gf180mcu_as_sc_mcu7t3v3__fill_1
XFILLER_186_513 VDD VDD VSS VSS gf180mcu_as_sc_mcu7t3v3__fillcap_4
XFILLER_207_1046 VDD VDD VSS VSS gf180mcu_as_sc_mcu7t3v3__fillcap_4
XFILLER_13_276 VDD VDD VSS VSS gf180mcu_as_sc_mcu7t3v3__fillcap_4
XFILLER_207_1068 VDD VDD VSS VSS gf180mcu_as_sc_mcu7t3v3__fillcap_16
XTAP_TAPCELL_ROW_177_1927 VDD VSS gf180mcu_as_sc_mcu7t3v3__tap_2
XFILLER_13_298 VDD VDD VSS VSS gf180mcu_as_sc_mcu7t3v3__fillcap_16
XFILLER_201_388 VDD VDD VSS VSS gf180mcu_as_sc_mcu7t3v3__fill_2
XTAP_TAPCELL_ROW_218_2669 VDD VSS gf180mcu_as_sc_mcu7t3v3__tap_2
XTAP_TAPCELL_ROW_218_2658 VDD VSS gf180mcu_as_sc_mcu7t3v3__tap_2
XFILLER_173_207 VDD VDD VSS VSS gf180mcu_as_sc_mcu7t3v3__fill_2
XFILLER_173_229 VDD VDD VSS VSS gf180mcu_as_sc_mcu7t3v3__fill_2
Xclkload17 VDD VDD VSS VSS _6506_/CLK clkload17/Y gf180mcu_as_sc_mcu7t3v3__clkbuff_4
Xclkload28 VDD VDD VSS VSS clkload28/Y _6492_/CLK gf180mcu_as_sc_mcu7t3v3__inv_6
XFILLER_154_454 VDD VDD VSS VSS gf180mcu_as_sc_mcu7t3v3__fill_1
XFILLER_142_649 VDD VDD VSS VSS gf180mcu_as_sc_mcu7t3v3__fillcap_16
XFILLER_173_1009 VDD VDD VSS VSS gf180mcu_as_sc_mcu7t3v3__fillcap_16
XFILLER_214_1017 VDD VDD VSS VSS gf180mcu_as_sc_mcu7t3v3__fillcap_16
XFILLER_205_59 VDD VDD VSS VSS gf180mcu_as_sc_mcu7t3v3__fillcap_8
XFILLER_209_422 VDD VDD VSS VSS gf180mcu_as_sc_mcu7t3v3__fill_2
XFILLER_7_1264 VDD VDD VSS VSS gf180mcu_as_sc_mcu7t3v3__fill_1
X_3020_ VDD VDD VSS VSS _4971_/C _5652_/C gf180mcu_as_sc_mcu7t3v3__inv_2
XFILLER_188_1263 VDD VDD VSS VSS gf180mcu_as_sc_mcu7t3v3__fill_2
XFILLER_224_447 VDD VDD VSS VSS gf180mcu_as_sc_mcu7t3v3__fill_1
XPHY_EDGE_ROW_148_2_Right_985 VDD VSS gf180mcu_as_sc_mcu7t3v3__tap_2
XTAP_TAPCELL_ROW_0_1009 VDD VSS gf180mcu_as_sc_mcu7t3v3__tap_2
X_4971_ VDD VDD VSS VSS _4976_/B _4971_/C _5336_/B _5336_/A gf180mcu_as_sc_mcu7t3v3__aoi21_2
X_3922_ VDD VDD VSS VSS _3923_/B _3922_/C _3932_/B _5901_/A gf180mcu_as_sc_mcu7t3v3__aoi21b_2
X_3853_ VDD VDD VSS VSS _3853_/B _5842_/D _3854_/D gf180mcu_as_sc_mcu7t3v3__and2_2
XFILLER_177_557 VDD VDD VSS VSS gf180mcu_as_sc_mcu7t3v3__fill_2
XFILLER_220_675 VDD VDD VSS VSS gf180mcu_as_sc_mcu7t3v3__fill_2
XTAP_TAPCELL_ROW_33_2_2898 VDD VSS gf180mcu_as_sc_mcu7t3v3__tap_2
XFILLER_118_602 VDD VDD VSS VSS gf180mcu_as_sc_mcu7t3v3__fill_1
XFILLER_164_207 VDD VDD VSS VSS gf180mcu_as_sc_mcu7t3v3__fill_1
XFILLER_192_527 VDD VDD VSS VSS gf180mcu_as_sc_mcu7t3v3__fillcap_8
XPHY_EDGE_ROW_83_3_Right_163 VDD VSS gf180mcu_as_sc_mcu7t3v3__tap_2
X_3784_ VDD VDD VSS VSS _6506_/Q _3804_/B _3804_/C _5782_/B _3785_/D gf180mcu_as_sc_mcu7t3v3__ao22_2
XFILLER_118_657 VDD VDD VSS VSS gf180mcu_as_sc_mcu7t3v3__fillcap_8
X_5523_ VDD VDD VSS VSS _5524_/A _5830_/B _5572_/B _5523_/C gf180mcu_as_sc_mcu7t3v3__ao21_2
XFILLER_195_1234 VDD VDD VSS VSS gf180mcu_as_sc_mcu7t3v3__fill_1
X_5454_ VDD VDD VSS VSS _5760_/A _5640_/C _5454_/C _5454_/D _5455_/C gf180mcu_as_sc_mcu7t3v3__ao22_2
XFILLER_161_958 VDD VDD VSS VSS gf180mcu_as_sc_mcu7t3v3__fillcap_4
XTAP_TAPCELL_ROW_152_1470 VDD VSS gf180mcu_as_sc_mcu7t3v3__tap_2
XTAP_TAPCELL_ROW_152_1481 VDD VSS gf180mcu_as_sc_mcu7t3v3__tap_2
X_5385_ VDD VDD VSS VSS _5695_/A _5497_/B _5496_/B _5694_/A _5386_/D gf180mcu_as_sc_mcu7t3v3__ao22_2
X_4405_ VDD VDD VSS VSS _4405_/S _6068_/Q _6097_/Q _4408_/B gf180mcu_as_sc_mcu7t3v3__mux2_2
XFILLER_160_457 VDD VDD VSS VSS gf180mcu_as_sc_mcu7t3v3__fillcap_8
XFILLER_160_479 VDD VDD VSS VSS gf180mcu_as_sc_mcu7t3v3__fill_2
X_4336_ VDD VDD VSS VSS _6216_/Q _4336_/B _4336_/C _6217_/Q _4337_/C gf180mcu_as_sc_mcu7t3v3__ao22_2
XFILLER_8_1017 VDD VDD VSS VSS gf180mcu_as_sc_mcu7t3v3__fillcap_16
X_4267_ VDD VDD VSS VSS _4267_/D _4283_/A _4267_/B _4267_/C _6206_/D gf180mcu_as_sc_mcu7t3v3__ao31_2
X_6006_ VDD VDD VSS VSS _6006_/B _6197_/Q _6519_/D gf180mcu_as_sc_mcu7t3v3__and2_2
X_4198_ VDD VDD VSS VSS _4198_/B _4230_/B _4202_/C gf180mcu_as_sc_mcu7t3v3__and2_2
X_3218_ VDD VDD VSS VSS _6136_/Q _4072_/A _3218_/C _6528_/D _3220_/C gf180mcu_as_sc_mcu7t3v3__ao211_2
XFILLER_216_926 VDD VDD VSS VSS gf180mcu_as_sc_mcu7t3v3__fillcap_16
XFILLER_227_263 VDD VDD VSS VSS gf180mcu_as_sc_mcu7t3v3__fillcap_4
XFILLER_228_775 VDD VDD VSS VSS gf180mcu_as_sc_mcu7t3v3__fillcap_4
XFILLER_55_644 VDD VDD VSS VSS gf180mcu_as_sc_mcu7t3v3__fillcap_4
X_3149_ VDD VDD VSS VSS _4572_/A _3433_/B _4480_/A gf180mcu_as_sc_mcu7t3v3__nor2_2
XFILLER_199_104 VDD VDD VSS VSS gf180mcu_as_sc_mcu7t3v3__fillcap_4
XFILLER_55_666 VDD VDD VSS VSS gf180mcu_as_sc_mcu7t3v3__fill_1
XFILLER_199_137 VDD VDD VSS VSS gf180mcu_as_sc_mcu7t3v3__fill_2
XFILLER_91_29 VDD VDD VSS VSS gf180mcu_as_sc_mcu7t3v3__fillcap_16
XFILLER_196_811 VDD VDD VSS VSS gf180mcu_as_sc_mcu7t3v3__fill_2
XFILLER_202_119 VDD VDD VSS VSS gf180mcu_as_sc_mcu7t3v3__fill_1
XTAP_TAPCELL_ROW_159_1602 VDD VSS gf180mcu_as_sc_mcu7t3v3__tap_2
XTAP_TAPCELL_ROW_194_2227 VDD VSS gf180mcu_as_sc_mcu7t3v3__tap_2
XFILLER_168_524 VDD VDD VSS VSS gf180mcu_as_sc_mcu7t3v3__fill_1
XFILLER_24_45 VDD VDD VSS VSS gf180mcu_as_sc_mcu7t3v3__fillcap_4
XTAP_TAPCELL_ROW_194_2238 VDD VSS gf180mcu_as_sc_mcu7t3v3__tap_2
XFILLER_11_747 VDD VDD VSS VSS gf180mcu_as_sc_mcu7t3v3__fillcap_8
XFILLER_168_579 VDD VDD VSS VSS gf180mcu_as_sc_mcu7t3v3__fillcap_4
XFILLER_195_365 VDD VDD VSS VSS gf180mcu_as_sc_mcu7t3v3__fillcap_4
XFILLER_210_152 VDD VDD VSS VSS gf180mcu_as_sc_mcu7t3v3__fillcap_16
XFILLER_210_174 VDD VDD VSS VSS gf180mcu_as_sc_mcu7t3v3__fill_1
XFILLER_10_279 VDD VDD VSS VSS gf180mcu_as_sc_mcu7t3v3__fillcap_16
XFILLER_13_1258 VDD VDD VSS VSS gf180mcu_as_sc_mcu7t3v3__fill_2
XTAP_TAPCELL_ROW_172_1835 VDD VSS gf180mcu_as_sc_mcu7t3v3__tap_2
XTAP_TAPCELL_ROW_172_1846 VDD VSS gf180mcu_as_sc_mcu7t3v3__tap_2
XFILLER_152_914 VDD VDD VSS VSS gf180mcu_as_sc_mcu7t3v3__fill_2
XFILLER_156_22 VDD VDD VSS VSS gf180mcu_as_sc_mcu7t3v3__fillcap_8
XFILLER_163_251 VDD VDD VSS VSS gf180mcu_as_sc_mcu7t3v3__fillcap_16
XFILLER_200_4 VDD VDD VSS VSS gf180mcu_as_sc_mcu7t3v3__fill_1
XFILLER_152_947 VDD VDD VSS VSS gf180mcu_as_sc_mcu7t3v3__fillcap_16
XTAP_TAPCELL_ROW_213_2577 VDD VSS gf180mcu_as_sc_mcu7t3v3__tap_2
Xfanout760 VDD VDD VSS VSS _5571_/B _5564_/B gf180mcu_as_sc_mcu7t3v3__buff_12
XFILLER_1_27 VDD VDD VSS VSS gf180mcu_as_sc_mcu7t3v3__fillcap_16
Xfanout771 VDD VDD VSS VSS _5140_/B _5311_/B gf180mcu_as_sc_mcu7t3v3__buff_12
Xfanout782 VDD VDD VSS VSS _5206_/B _5313_/B gf180mcu_as_sc_mcu7t3v3__buff_12
Xfanout793 VDD VDD VSS VSS _4446_/B _4442_/C gf180mcu_as_sc_mcu7t3v3__buff_12
XFILLER_46_666 VDD VDD VSS VSS gf180mcu_as_sc_mcu7t3v3__fill_1
XFILLER_109_1220 VDD VDD VSS VSS gf180mcu_as_sc_mcu7t3v3__fill_1
XFILLER_109_1253 VDD VDD VSS VSS gf180mcu_as_sc_mcu7t3v3__fillcap_8
XFILLER_14_574 VDD VDD VSS VSS gf180mcu_as_sc_mcu7t3v3__fillcap_16
XFILLER_159_535 VDD VDD VSS VSS gf180mcu_as_sc_mcu7t3v3__fillcap_8
XFILLER_186_310 VDD VDD VSS VSS gf180mcu_as_sc_mcu7t3v3__fillcap_4
XFILLER_187_822 VDD VDD VSS VSS gf180mcu_as_sc_mcu7t3v3__fillcap_4
XFILLER_198_170 VDD VDD VSS VSS gf180mcu_as_sc_mcu7t3v3__fillcap_4
XFILLER_186_365 VDD VDD VSS VSS gf180mcu_as_sc_mcu7t3v3__fill_2
XFILLER_186_387 VDD VDD VSS VSS gf180mcu_as_sc_mcu7t3v3__fillcap_4
XFILLER_186_398 VDD VDD VSS VSS gf180mcu_as_sc_mcu7t3v3__fillcap_8
XFILLER_220_1065 VDD VDD VSS VSS gf180mcu_as_sc_mcu7t3v3__fillcap_16
XFILLER_220_1087 VDD VDD VSS VSS gf180mcu_as_sc_mcu7t3v3__fillcap_16
XFILLER_154_295 VDD VDD VSS VSS gf180mcu_as_sc_mcu7t3v3__fillcap_16
XFILLER_29_1210 VDD VDD VSS VSS gf180mcu_as_sc_mcu7t3v3__fillcap_4
XFILLER_155_1262 VDD VDD VSS VSS gf180mcu_as_sc_mcu7t3v3__fill_2
XFILLER_216_69 VDD VDD VSS VSS gf180mcu_as_sc_mcu7t3v3__fillcap_16
X_5170_ VDD VDD VSS VSS _5825_/A _5217_/S _5296_/C _5825_/D _5171_/D gf180mcu_as_sc_mcu7t3v3__ao22_2
X_4121_ VDD VDD VSS VSS _4146_/S _6171_/Q _6170_/Q _6170_/D gf180mcu_as_sc_mcu7t3v3__mux2_2
X_4052_ VDD VDD VSS VSS _4060_/B _6125_/Q _4053_/D gf180mcu_as_sc_mcu7t3v3__and2_2
XFILLER_37_622 VDD VDD VSS VSS gf180mcu_as_sc_mcu7t3v3__fillcap_16
Xinput4 VDD VDD VSS VSS TILE_ID[3] input4/Y gf180mcu_as_sc_mcu7t3v3__buff_12
X_3003_ VDD VDD VSS VSS _5958_/A _6485_/Q gf180mcu_as_sc_mcu7t3v3__inv_2
XFILLER_37_666 VDD VDD VSS VSS gf180mcu_as_sc_mcu7t3v3__fill_1
Xmesh_tile_1181 VDD VDD VSS VSS sw_out[32] gf180mcu_as_sc_mcu7t3v3__tiel_4
Xmesh_tile_1170 VDD VDD VSS VSS sw_out[21] gf180mcu_as_sc_mcu7t3v3__tiel_4
XFILLER_227_1208 VDD VDD VSS VSS gf180mcu_as_sc_mcu7t3v3__fillcap_16
XFILLER_196_107 VDD VDD VSS VSS gf180mcu_as_sc_mcu7t3v3__fillcap_8
X_4954_ VDD VDD VSS VSS _5944_/A _4963_/B _4954_/C _4954_/D _4956_/C gf180mcu_as_sc_mcu7t3v3__ao211_2
X_3905_ VDD VDD VSS VSS _3905_/A _3905_/B _3905_/C _3907_/C gf180mcu_as_sc_mcu7t3v3__nor3_2
X_4885_ VDD VDD VSS VSS _4889_/B _4885_/B _5880_/A gf180mcu_as_sc_mcu7t3v3__nand2_2
XFILLER_193_836 VDD VDD VSS VSS gf180mcu_as_sc_mcu7t3v3__fillcap_4
X_3836_ VDD VDD VSS VSS _5825_/D _3891_/B _3836_/C _3836_/D _3837_/B gf180mcu_as_sc_mcu7t3v3__ao211_2
XPHY_EDGE_ROW_84_3_Right_164 VDD VSS gf180mcu_as_sc_mcu7t3v3__tap_2
XTAP_TAPCELL_ROW_154_1510 VDD VSS gf180mcu_as_sc_mcu7t3v3__tap_2
XTAP_TAPCELL_ROW_154_1521 VDD VSS gf180mcu_as_sc_mcu7t3v3__tap_2
X_3767_ VDD VDD VSS VSS _3889_/B _5767_/A _3768_/D gf180mcu_as_sc_mcu7t3v3__and2_2
XFILLER_192_368 VDD VDD VSS VSS gf180mcu_as_sc_mcu7t3v3__fillcap_4
X_5506_ VDD VDD VSS VSS _5506_/B _5506_/A _6429_/D gf180mcu_as_sc_mcu7t3v3__and2_2
X_6486_ VDD VDD VSS VSS _6486_/CLK _6486_/D _6486_/Q gf180mcu_as_sc_mcu7t3v3__dfxtp_2
X_3698_ VDD VDD VSS VSS _6497_/Q _3804_/B _3804_/C _5707_/B _3700_/C gf180mcu_as_sc_mcu7t3v3__ao22_2
XFILLER_82_1212 VDD VDD VSS VSS gf180mcu_as_sc_mcu7t3v3__fill_1
Xoutput352 VDD VDD VSS VSS _6427_/Q east_out[14] gf180mcu_as_sc_mcu7t3v3__buff_12
Xoutput341 VDD VDD VSS VSS _6717_/Y dft_rdata[2] gf180mcu_as_sc_mcu7t3v3__buff_12
X_5437_ VDD VDD VSS VSS _5641_/B _5745_/A _5438_/D gf180mcu_as_sc_mcu7t3v3__and2_2
XFILLER_82_1245 VDD VDD VSS VSS gf180mcu_as_sc_mcu7t3v3__fillcap_16
XFILLER_86_29 VDD VDD VSS VSS gf180mcu_as_sc_mcu7t3v3__fillcap_4
Xoutput396 VDD VDD VSS VSS _6362_/Q north_out[21] gf180mcu_as_sc_mcu7t3v3__buff_12
Xoutput385 VDD VDD VSS VSS _6352_/Q north_out[11] gf180mcu_as_sc_mcu7t3v3__buff_12
Xoutput374 VDD VDD VSS VSS _6447_/Q east_out[34] gf180mcu_as_sc_mcu7t3v3__buff_12
Xoutput363 VDD VDD VSS VSS _6437_/Q east_out[24] gf180mcu_as_sc_mcu7t3v3__buff_12
X_5368_ VDD VDD VSS VSS _5676_/A _5566_/B _5368_/C _5368_/D _5370_/C gf180mcu_as_sc_mcu7t3v3__ao211_2
XFILLER_0_949 VDD VDD VSS VSS gf180mcu_as_sc_mcu7t3v3__fill_2
X_5299_ VDD VDD VSS VSS _5940_/A _5306_/B _5299_/C _5300_/C _5306_/D gf180mcu_as_sc_mcu7t3v3__aoi211_2
X_4319_ VDD VDD VSS VSS _4320_/C _4321_/S _6027_/Q gf180mcu_as_sc_mcu7t3v3__nor2b_2
Xclkbuf_leaf_25_clk_regs VDD VDD VSS VSS clkload1/A _6371_/CLK gf180mcu_as_sc_mcu7t3v3__clkbuff_12
XTAP_TAPCELL_ROW_13_1241 VDD VSS gf180mcu_as_sc_mcu7t3v3__tap_2
XTAP_TAPCELL_ROW_13_1252 VDD VSS gf180mcu_as_sc_mcu7t3v3__tap_2
XFILLER_167_1100 VDD VDD VSS VSS gf180mcu_as_sc_mcu7t3v3__fillcap_16
XFILLER_28_666 VDD VDD VSS VSS gf180mcu_as_sc_mcu7t3v3__fill_1
XPHY_EDGE_ROW_29_2_Left_470 VDD VSS gf180mcu_as_sc_mcu7t3v3__tap_2
XFILLER_167_1122 VDD VDD VSS VSS gf180mcu_as_sc_mcu7t3v3__fillcap_16
XFILLER_15_338 VDD VDD VSS VSS gf180mcu_as_sc_mcu7t3v3__fillcap_4
XPHY_EDGE_ROW_128_1_Right_700 VDD VSS gf180mcu_as_sc_mcu7t3v3__tap_2
XFILLER_196_663 VDD VDD VSS VSS gf180mcu_as_sc_mcu7t3v3__fill_2
XFILLER_51_10 VDD VDD VSS VSS gf180mcu_as_sc_mcu7t3v3__fillcap_4
XPHY_EDGE_ROW_41_3_Left_746 VDD VSS gf180mcu_as_sc_mcu7t3v3__tap_2
XFILLER_136_2 VDD VDD VSS VSS gf180mcu_as_sc_mcu7t3v3__fillcap_16
XFILLER_156_527 VDD VDD VSS VSS gf180mcu_as_sc_mcu7t3v3__fill_1
XFILLER_168_365 VDD VDD VSS VSS gf180mcu_as_sc_mcu7t3v3__fillcap_16
XFILLER_168_387 VDD VDD VSS VSS gf180mcu_as_sc_mcu7t3v3__fillcap_4
XFILLER_204_1049 VDD VDD VSS VSS gf180mcu_as_sc_mcu7t3v3__fillcap_16
XFILLER_211_483 VDD VDD VSS VSS gf180mcu_as_sc_mcu7t3v3__fillcap_4
XFILLER_212_995 VDD VDD VSS VSS gf180mcu_as_sc_mcu7t3v3__fillcap_16
XTAP_TAPCELL_ROW_215_2617 VDD VSS gf180mcu_as_sc_mcu7t3v3__tap_2
XTAP_TAPCELL_ROW_215_2606 VDD VSS gf180mcu_as_sc_mcu7t3v3__tap_2
XFILLER_183_346 VDD VDD VSS VSS gf180mcu_as_sc_mcu7t3v3__fillcap_4
XFILLER_152_711 VDD VDD VSS VSS gf180mcu_as_sc_mcu7t3v3__fill_2
XFILLER_164_571 VDD VDD VSS VSS gf180mcu_as_sc_mcu7t3v3__fillcap_4
XFILLER_152_766 VDD VDD VSS VSS gf180mcu_as_sc_mcu7t3v3__fill_2
XFILLER_151_276 VDD VDD VSS VSS gf180mcu_as_sc_mcu7t3v3__fillcap_4
XFILLER_151_298 VDD VDD VSS VSS gf180mcu_as_sc_mcu7t3v3__fillcap_16
XFILLER_183_86 VDD VDD VSS VSS gf180mcu_as_sc_mcu7t3v3__fill_1
Xfanout590 VDD VDD VSS VSS _5536_/B _5640_/C gf180mcu_as_sc_mcu7t3v3__buff_12
XFILLER_19_666 VDD VDD VSS VSS gf180mcu_as_sc_mcu7t3v3__fill_1
XFILLER_206_211 VDD VDD VSS VSS gf180mcu_as_sc_mcu7t3v3__fill_2
XPHY_EDGE_ROW_90_1_Right_662 VDD VSS gf180mcu_as_sc_mcu7t3v3__tap_2
XFILLER_202_27 VDD VDD VSS VSS gf180mcu_as_sc_mcu7t3v3__fillcap_8
XFILLER_178_107 VDD VDD VSS VSS gf180mcu_as_sc_mcu7t3v3__fillcap_16
XPHY_EDGE_ROW_14_Left_243 VDD VSS gf180mcu_as_sc_mcu7t3v3__tap_2
XFILLER_226_1263 VDD VDD VSS VSS gf180mcu_as_sc_mcu7t3v3__fill_2
XFILLER_159_376 VDD VDD VSS VSS gf180mcu_as_sc_mcu7t3v3__fill_2
XFILLER_202_472 VDD VDD VSS VSS gf180mcu_as_sc_mcu7t3v3__fill_1
X_4670_ VDD VDD VSS VSS _4670_/A _4725_/B _4670_/C _4670_/Y _5804_/D gf180mcu_as_sc_mcu7t3v3__aoi211_2
XTAP_TAPCELL_ROW_96_3_2993 VDD VSS gf180mcu_as_sc_mcu7t3v3__tap_2
X_3621_ VDD VDD VSS VSS _3622_/B _5353_/C _5916_/A _5339_/A gf180mcu_as_sc_mcu7t3v3__aoi21_2
XFILLER_122_1261 VDD VDD VSS VSS gf180mcu_as_sc_mcu7t3v3__fillcap_4
Xwire980 VDD VDD VSS VSS wire980/A _5919_/A gf180mcu_as_sc_mcu7t3v3__clkbuff_12
X_6340_ VDD VDD VSS VSS _6551_/CLK _6340_/D _6340_/Q gf180mcu_as_sc_mcu7t3v3__dfxtp_2
X_3552_ VDD VDD VSS VSS _5327_/A _3556_/B _3556_/A gf180mcu_as_sc_mcu7t3v3__nand2_2
XFILLER_51_2 VDD VDD VSS VSS gf180mcu_as_sc_mcu7t3v3__fillcap_8
X_6271_ VDD VDD VSS VSS clkload7/A _6271_/D _6271_/Q gf180mcu_as_sc_mcu7t3v3__dfxtp_2
X_3483_ VDD VDD VSS VSS _3483_/A _3483_/B _5344_/A _3483_/D _5344_/B gf180mcu_as_sc_mcu7t3v3__nand4_2
X_5222_ VDD VDD VSS VSS _5222_/D _5872_/A _5222_/B _5222_/C _5223_/C gf180mcu_as_sc_mcu7t3v3__ao31_2
XPHY_EDGE_ROW_94_2_Left_535 VDD VSS gf180mcu_as_sc_mcu7t3v3__tap_2
X_5153_ VDD VDD VSS VSS _5810_/A _5218_/B _5153_/C _5153_/D _5154_/A gf180mcu_as_sc_mcu7t3v3__ao211_2
X_4104_ VDD VDD VSS VSS _4105_/B _4104_/B _6162_/Q gf180mcu_as_sc_mcu7t3v3__nor2_2
X_5084_ VDD VDD VSS VSS _5139_/B _5084_/B _5084_/C _5141_/B _5087_/B gf180mcu_as_sc_mcu7t3v3__ao211_2
X_4035_ VDD VDD VSS VSS _4044_/B _6115_/Q _4036_/D gf180mcu_as_sc_mcu7t3v3__and2_2
XFILLER_112_27 VDD VDD VSS VSS gf180mcu_as_sc_mcu7t3v3__fillcap_8
XFILLER_112_49 VDD VDD VSS VSS gf180mcu_as_sc_mcu7t3v3__fill_2
XFILLER_197_405 VDD VDD VSS VSS gf180mcu_as_sc_mcu7t3v3__fill_2
XFILLER_25_647 VDD VDD VSS VSS gf180mcu_as_sc_mcu7t3v3__fill_2
XFILLER_212_236 VDD VDD VSS VSS gf180mcu_as_sc_mcu7t3v3__fill_2
X_5986_ VDD VDD VSS VSS _6011_/B _6209_/Q _6499_/D gf180mcu_as_sc_mcu7t3v3__and2_2
XFILLER_212_258 VDD VDD VSS VSS gf180mcu_as_sc_mcu7t3v3__fillcap_4
X_4937_ VDD VDD VSS VSS _5933_/A _4955_/B _4955_/C _5932_/A _4941_/C gf180mcu_as_sc_mcu7t3v3__ao22_2
XANTENNA_20 VDD VDD VSS VSS _5007_/A gf180mcu_as_sc_mcu7t3v3__diode_2
XANTENNA_31 VDD VDD VSS VSS _5893_/B gf180mcu_as_sc_mcu7t3v3__diode_2
X_4868_ VDD VDD VSS VSS _4869_/C _4877_/B _5863_/A gf180mcu_as_sc_mcu7t3v3__nor2_2
XANTENNA_42 VDD VDD VSS VSS _5219_/A gf180mcu_as_sc_mcu7t3v3__diode_2
XFILLER_192_121 VDD VDD VSS VSS gf180mcu_as_sc_mcu7t3v3__fill_1
XFILLER_220_291 VDD VDD VSS VSS gf180mcu_as_sc_mcu7t3v3__fillcap_8
X_3819_ VDD VDD VSS VSS _5810_/A _3931_/B _3819_/C _3819_/D _3820_/C gf180mcu_as_sc_mcu7t3v3__ao211_2
XFILLER_165_379 VDD VDD VSS VSS gf180mcu_as_sc_mcu7t3v3__fillcap_8
XFILLER_192_165 VDD VDD VSS VSS gf180mcu_as_sc_mcu7t3v3__fill_2
X_4799_ VDD VDD VSS VSS _4871_/C _5808_/A _4805_/C gf180mcu_as_sc_mcu7t3v3__and2_2
XFILLER_193_699 VDD VDD VSS VSS gf180mcu_as_sc_mcu7t3v3__fill_1
XPHY_EDGE_ROW_85_3_Right_165 VDD VSS gf180mcu_as_sc_mcu7t3v3__tap_2
X_6538_ VDD VDD VSS VSS clkload9/A _6538_/D _6538_/Q gf180mcu_as_sc_mcu7t3v3__dfxtp_2
XTAP_TAPCELL_ROW_210_2514 VDD VSS gf180mcu_as_sc_mcu7t3v3__tap_2
X_6469_ VDD VDD VSS VSS _6474_/CLK _6469_/D _6469_/Q gf180mcu_as_sc_mcu7t3v3__dfxtp_2
XTAP_TAPCELL_ROW_210_2525 VDD VSS gf180mcu_as_sc_mcu7t3v3__tap_2
XTAP_TAPCELL_ROW_189_2148 VDD VSS gf180mcu_as_sc_mcu7t3v3__tap_2
XTAP_TAPCELL_ROW_189_2137 VDD VSS gf180mcu_as_sc_mcu7t3v3__tap_2
XFILLER_173_1170 VDD VDD VSS VSS gf180mcu_as_sc_mcu7t3v3__fillcap_16
XFILLER_173_1192 VDD VDD VSS VSS gf180mcu_as_sc_mcu7t3v3__fillcap_16
XTAP_TAPCELL_ROW_167_1745 VDD VSS gf180mcu_as_sc_mcu7t3v3__tap_2
XTAP_TAPCELL_ROW_167_1756 VDD VSS gf180mcu_as_sc_mcu7t3v3__tap_2
XFILLER_228_380 VDD VDD VSS VSS gf180mcu_as_sc_mcu7t3v3__fill_1
XTAP_TAPCELL_ROW_208_2487 VDD VSS gf180mcu_as_sc_mcu7t3v3__tap_2
XTAP_TAPCELL_ROW_225_2790 VDD VSS gf180mcu_as_sc_mcu7t3v3__tap_2
XTAP_TAPCELL_ROW_180_1989 VDD VSS gf180mcu_as_sc_mcu7t3v3__tap_2
XTAP_TAPCELL_ROW_180_1978 VDD VSS gf180mcu_as_sc_mcu7t3v3__tap_2
XFILLER_216_597 VDD VDD VSS VSS gf180mcu_as_sc_mcu7t3v3__fillcap_4
XFILLER_31_639 VDD VDD VSS VSS gf180mcu_as_sc_mcu7t3v3__fillcap_4
XFILLER_62_31 VDD VDD VSS VSS gf180mcu_as_sc_mcu7t3v3__fillcap_4
XTAP_TAPCELL_ROW_108_3_3011 VDD VSS gf180mcu_as_sc_mcu7t3v3__tap_2
XFILLER_106_1245 VDD VDD VSS VSS gf180mcu_as_sc_mcu7t3v3__fillcap_16
XFILLER_11_330 VDD VDD VSS VSS gf180mcu_as_sc_mcu7t3v3__fillcap_16
XFILLER_157_825 VDD VDD VSS VSS gf180mcu_as_sc_mcu7t3v3__fillcap_8
XFILLER_200_943 VDD VDD VSS VSS gf180mcu_as_sc_mcu7t3v3__fill_2
XFILLER_8_802 VDD VDD VSS VSS gf180mcu_as_sc_mcu7t3v3__fill_2
XPHY_EDGE_ROW_129_1_Right_701 VDD VSS gf180mcu_as_sc_mcu7t3v3__tap_2
XFILLER_11_352 VDD VDD VSS VSS gf180mcu_as_sc_mcu7t3v3__fillcap_8
XFILLER_7_59 VDD VDD VSS VSS gf180mcu_as_sc_mcu7t3v3__fillcap_8
XFILLER_178_1081 VDD VDD VSS VSS gf180mcu_as_sc_mcu7t3v3__fillcap_4
XFILLER_194_85 VDD VDD VSS VSS gf180mcu_as_sc_mcu7t3v3__fillcap_16
XFILLER_3_551 VDD VDD VSS VSS gf180mcu_as_sc_mcu7t3v3__fill_2
XFILLER_3_562 VDD VDD VSS VSS gf180mcu_as_sc_mcu7t3v3__fillcap_4
XFILLER_152_1221 VDD VDD VSS VSS gf180mcu_as_sc_mcu7t3v3__fillcap_4
XFILLER_152_1243 VDD VDD VSS VSS gf180mcu_as_sc_mcu7t3v3__fillcap_16
XFILLER_226_306 VDD VDD VSS VSS gf180mcu_as_sc_mcu7t3v3__fillcap_8
XFILLER_213_59 VDD VDD VSS VSS gf180mcu_as_sc_mcu7t3v3__fillcap_8
XFILLER_185_1030 VDD VDD VSS VSS gf180mcu_as_sc_mcu7t3v3__fillcap_16
XFILLER_185_1052 VDD VDD VSS VSS gf180mcu_as_sc_mcu7t3v3__fillcap_16
XPHY_EDGE_ROW_91_1_Right_663 VDD VSS gf180mcu_as_sc_mcu7t3v3__tap_2
X_5840_ VDD VDD VSS VSS _5840_/A _5840_/B _5840_/C _5840_/D _5841_/C gf180mcu_as_sc_mcu7t3v3__ao211_2
X_5771_ VDD VDD VSS VSS _5771_/B _5836_/A _6460_/D gf180mcu_as_sc_mcu7t3v3__and2_2
XFILLER_188_972 VDD VDD VSS VSS gf180mcu_as_sc_mcu7t3v3__fillcap_16
X_4722_ VDD VDD VSS VSS _4723_/C _4896_/A _4722_/B _4722_/C gf180mcu_as_sc_mcu7t3v3__ao21_2
XFILLER_30_661 VDD VDD VSS VSS gf180mcu_as_sc_mcu7t3v3__fillcap_4
Xinput40 VDD VDD VSS VSS dft_mode _3178_/B gf180mcu_as_sc_mcu7t3v3__buff_12
X_4653_ VDD VDD VSS VSS _4967_/A _4967_/B _4653_/Y gf180mcu_as_sc_mcu7t3v3__and2_2
XFILLER_175_699 VDD VDD VSS VSS gf180mcu_as_sc_mcu7t3v3__fill_1
Xinput51 VDD VDD VSS VSS east_in[10] _5759_/A gf180mcu_as_sc_mcu7t3v3__buff_12
Xinput62 VDD VDD VSS VSS east_in[20] _5840_/A gf180mcu_as_sc_mcu7t3v3__buff_12
Xinput73 VDD VDD VSS VSS east_in[30] _5920_/A gf180mcu_as_sc_mcu7t3v3__buff_12
X_4584_ VDD VDD VSS VSS _6722_/A _4584_/A _4586_/B gf180mcu_as_sc_mcu7t3v3__and2_2
X_3604_ VDD VDD VSS VSS _3607_/D _6519_/Q _4239_/A gf180mcu_as_sc_mcu7t3v3__nand2b_2
XFILLER_7_890 VDD VDD VSS VSS gf180mcu_as_sc_mcu7t3v3__fillcap_16
Xinput84 VDD VDD VSS VSS east_in[8] _5740_/A gf180mcu_as_sc_mcu7t3v3__buff_12
Xinput95 VDD VDD VSS VSS ne_in[18] _5825_/D gf180mcu_as_sc_mcu7t3v3__buff_12
X_6323_ VDD VDD VSS VSS _6552_/CLK _6323_/D _6323_/Q gf180mcu_as_sc_mcu7t3v3__dfxtp_2
X_3535_ VDD VDD VSS VSS _4615_/A _3540_/A _5293_/A gf180mcu_as_sc_mcu7t3v3__nand2b_2
XFILLER_107_27 VDD VDD VSS VSS gf180mcu_as_sc_mcu7t3v3__fillcap_16
XFILLER_157_1154 VDD VDD VSS VSS gf180mcu_as_sc_mcu7t3v3__fillcap_16
X_6254_ VDD VDD VSS VSS _6313_/CLK _6254_/D _6254_/Q gf180mcu_as_sc_mcu7t3v3__dfxtp_2
X_3466_ VDD VDD VSS VSS _3466_/B _4634_/D _3474_/B gf180mcu_as_sc_mcu7t3v3__and2_2
X_5205_ VDD VDD VSS VSS _5205_/A _5205_/B _5206_/B _5206_/C _5205_/D gf180mcu_as_sc_mcu7t3v3__aoi211_2
XTAP_TAPCELL_ROW_149_1420 VDD VSS gf180mcu_as_sc_mcu7t3v3__tap_2
XTAP_TAPCELL_ROW_149_1431 VDD VSS gf180mcu_as_sc_mcu7t3v3__tap_2
X_6185_ VDD VDD VSS VSS _6490_/CLK _6185_/D _6185_/Q gf180mcu_as_sc_mcu7t3v3__dfxtp_2
X_3397_ VDD VDD VSS VSS _4456_/A _3397_/B _3397_/C _3427_/B _3398_/D gf180mcu_as_sc_mcu7t3v3__ao211_2
XTAP_TAPCELL_ROW_184_2056 VDD VSS gf180mcu_as_sc_mcu7t3v3__tap_2
XTAP_TAPCELL_ROW_184_2045 VDD VSS gf180mcu_as_sc_mcu7t3v3__tap_2
X_5136_ VDD VDD VSS VSS _5237_/S _5795_/A _5136_/A _5137_/B gf180mcu_as_sc_mcu7t3v3__mux2_2
XTAP_TAPCELL_ROW_10_1200 VDD VSS gf180mcu_as_sc_mcu7t3v3__tap_2
X_5067_ VDD VDD VSS VSS _5069_/C _5205_/B _5732_/B gf180mcu_as_sc_mcu7t3v3__nand2b_2
X_4018_ VDD VDD VSS VSS _4055_/S _4018_/B _6103_/Q _6103_/D gf180mcu_as_sc_mcu7t3v3__mux2_2
XTAP_TAPCELL_ROW_162_1653 VDD VSS gf180mcu_as_sc_mcu7t3v3__tap_2
XTAP_TAPCELL_ROW_162_1664 VDD VSS gf180mcu_as_sc_mcu7t3v3__tap_2
XFILLER_13_617 VDD VDD VSS VSS gf180mcu_as_sc_mcu7t3v3__fillcap_8
XFILLER_164_1103 VDD VDD VSS VSS gf180mcu_as_sc_mcu7t3v3__fillcap_16
XTAP_TAPCELL_ROW_203_2395 VDD VSS gf180mcu_as_sc_mcu7t3v3__tap_2
XFILLER_205_1100 VDD VDD VSS VSS gf180mcu_as_sc_mcu7t3v3__fillcap_16
X_5969_ VDD VDD VSS VSS _6489_/Q _6490_/Q _5975_/C gf180mcu_as_sc_mcu7t3v3__and2_2
XFILLER_205_1122 VDD VDD VSS VSS gf180mcu_as_sc_mcu7t3v3__fillcap_16
XFILLER_200_239 VDD VDD VSS VSS gf180mcu_as_sc_mcu7t3v3__fillcap_4
XFILLER_21_661 VDD VDD VSS VSS gf180mcu_as_sc_mcu7t3v3__fill_1
XFILLER_32_45 VDD VDD VSS VSS gf180mcu_as_sc_mcu7t3v3__fillcap_4
XFILLER_148_34 VDD VDD VSS VSS gf180mcu_as_sc_mcu7t3v3__fill_1
XFILLER_148_45 VDD VDD VSS VSS gf180mcu_as_sc_mcu7t3v3__fillcap_4
XFILLER_193_463 VDD VDD VSS VSS gf180mcu_as_sc_mcu7t3v3__fill_2
XFILLER_5_838 VDD VDD VSS VSS gf180mcu_as_sc_mcu7t3v3__fill_2
XPHY_EDGE_ROW_86_3_Right_166 VDD VSS gf180mcu_as_sc_mcu7t3v3__tap_2
XTAP_TAPCELL_ROW_227_2830 VDD VSS gf180mcu_as_sc_mcu7t3v3__tap_2
XFILLER_180_43 VDD VDD VSS VSS gf180mcu_as_sc_mcu7t3v3__fill_1
XFILLER_208_317 VDD VDD VSS VSS gf180mcu_as_sc_mcu7t3v3__fill_2
XTAP_TAPCELL_ROW_223_2749 VDD VSS gf180mcu_as_sc_mcu7t3v3__tap_2
XFILLER_16_444 VDD VDD VSS VSS gf180mcu_as_sc_mcu7t3v3__fillcap_4
XFILLER_189_63 VDD VDD VSS VSS gf180mcu_as_sc_mcu7t3v3__fill_2
XFILLER_189_74 VDD VDD VSS VSS gf180mcu_as_sc_mcu7t3v3__fill_1
XFILLER_7_120 VDD VDD VSS VSS gf180mcu_as_sc_mcu7t3v3__fillcap_16
XFILLER_32_1261 VDD VDD VSS VSS gf180mcu_as_sc_mcu7t3v3__fillcap_4
XFILLER_7_142 VDD VDD VSS VSS gf180mcu_as_sc_mcu7t3v3__fillcap_16
XFILLER_8_687 VDD VDD VSS VSS gf180mcu_as_sc_mcu7t3v3__fill_1
XFILLER_208_37 VDD VDD VSS VSS gf180mcu_as_sc_mcu7t3v3__fillcap_16
XPHY_EDGE_ROW_129_3_Left_834 VDD VSS gf180mcu_as_sc_mcu7t3v3__tap_2
X_3320_ VDD VDD VSS VSS _6197_/Q _4072_/B _4089_/S _6221_/Q _3321_/B gf180mcu_as_sc_mcu7t3v3__ao22_2
XFILLER_3_381 VDD VDD VSS VSS gf180mcu_as_sc_mcu7t3v3__fill_1
XFILLER_4_893 VDD VDD VSS VSS gf180mcu_as_sc_mcu7t3v3__fillcap_4
X_3251_ VDD VDD VSS VSS _3251_/B _6268_/Q _4465_/C gf180mcu_as_sc_mcu7t3v3__and2_2
X_3182_ VDD VDD VSS VSS _3182_/Y _4603_/A _6316_/Q gf180mcu_as_sc_mcu7t3v3__nand2_2
XFILLER_94_631 VDD VDD VSS VSS gf180mcu_as_sc_mcu7t3v3__fill_1
XTAP_TAPCELL_ROW_7_1143 VDD VSS gf180mcu_as_sc_mcu7t3v3__tap_2
XTAP_TAPCELL_ROW_7_1132 VDD VSS gf180mcu_as_sc_mcu7t3v3__tap_2
XPHY_EDGE_ROW_18_3_Right_98 VDD VSS gf180mcu_as_sc_mcu7t3v3__tap_2
XFILLER_208_873 VDD VDD VSS VSS gf180mcu_as_sc_mcu7t3v3__fill_2
XTAP_TAPCELL_ROW_84_3_2975 VDD VSS gf180mcu_as_sc_mcu7t3v3__tap_2
XPHY_EDGE_ROW_92_1_Right_664 VDD VSS gf180mcu_as_sc_mcu7t3v3__tap_2
XFILLER_179_224 VDD VDD VSS VSS gf180mcu_as_sc_mcu7t3v3__fillcap_4
XFILLER_228_1155 VDD VDD VSS VSS gf180mcu_as_sc_mcu7t3v3__fill_1
XFILLER_228_1177 VDD VDD VSS VSS gf180mcu_as_sc_mcu7t3v3__fillcap_4
XFILLER_62_594 VDD VDD VSS VSS gf180mcu_as_sc_mcu7t3v3__fill_1
X_5823_ VDD VDD VSS VSS _5823_/A _5922_/B _5823_/C _5879_/D _5824_/D gf180mcu_as_sc_mcu7t3v3__ao22_2
XFILLER_179_279 VDD VDD VSS VSS gf180mcu_as_sc_mcu7t3v3__fill_1
XFILLER_210_515 VDD VDD VSS VSS gf180mcu_as_sc_mcu7t3v3__fill_2
XFILLER_194_227 VDD VDD VSS VSS gf180mcu_as_sc_mcu7t3v3__fill_1
XFILLER_194_249 VDD VDD VSS VSS gf180mcu_as_sc_mcu7t3v3__fill_1
XFILLER_210_559 VDD VDD VSS VSS gf180mcu_as_sc_mcu7t3v3__fill_2
X_5754_ VDD VDD VSS VSS _5795_/S _5754_/B _5754_/A _5755_/B gf180mcu_as_sc_mcu7t3v3__mux2_2
XFILLER_198_1221 VDD VDD VSS VSS gf180mcu_as_sc_mcu7t3v3__fillcap_4
X_5685_ VDD VDD VSS VSS _5685_/A _5802_/C _5801_/S _5685_/D _5686_/D gf180mcu_as_sc_mcu7t3v3__ao22_2
X_4705_ VDD VDD VSS VSS _5720_/A _4796_/B _4705_/C _4705_/D _4706_/B gf180mcu_as_sc_mcu7t3v3__ao211_2
XFILLER_175_474 VDD VDD VSS VSS gf180mcu_as_sc_mcu7t3v3__fill_2
XFILLER_190_411 VDD VDD VSS VSS gf180mcu_as_sc_mcu7t3v3__fillcap_4
X_4636_ VDD VDD VSS VSS _4647_/A _4987_/A _4986_/A gf180mcu_as_sc_mcu7t3v3__nand2_2
XFILLER_118_37 VDD VDD VSS VSS gf180mcu_as_sc_mcu7t3v3__fillcap_8
XFILLER_159_1249 VDD VDD VSS VSS gf180mcu_as_sc_mcu7t3v3__fillcap_4
XFILLER_190_466 VDD VDD VSS VSS gf180mcu_as_sc_mcu7t3v3__fillcap_8
X_6306_ VDD VDD VSS VSS _6552_/CLK _6306_/D _6306_/Q gf180mcu_as_sc_mcu7t3v3__dfxtp_2
X_4567_ VDD VDD VSS VSS _4567_/B _6309_/Q _4568_/B gf180mcu_as_sc_mcu7t3v3__or2_2
XFILLER_171_691 VDD VDD VSS VSS gf180mcu_as_sc_mcu7t3v3__fill_2
X_4498_ VDD VDD VSS VSS _6285_/D _4498_/C _4503_/C _6285_/Q gf180mcu_as_sc_mcu7t3v3__aoi21b_2
X_3518_ VDD VDD VSS VSS _4626_/C _5944_/A _5943_/D gf180mcu_as_sc_mcu7t3v3__nand2b_2
X_6237_ VDD VDD VSS VSS _6316_/CLK _6237_/D _6237_/Q gf180mcu_as_sc_mcu7t3v3__dfxtp_2
X_3449_ VDD VDD VSS VSS _6720_/A _4584_/A _3457_/B gf180mcu_as_sc_mcu7t3v3__and2_2
XFILLER_170_1151 VDD VDD VSS VSS gf180mcu_as_sc_mcu7t3v3__fillcap_4
XPHY_EDGE_ROW_50_3_Left_755 VDD VSS gf180mcu_as_sc_mcu7t3v3__tap_2
X_6168_ VDD VDD VSS VSS _6526_/CLK _6168_/D _6168_/Q gf180mcu_as_sc_mcu7t3v3__dfxtp_2
XFILLER_170_1173 VDD VDD VSS VSS gf180mcu_as_sc_mcu7t3v3__fillcap_16
X_5119_ VDD VDD VSS VSS _5119_/B _5164_/A _6389_/D gf180mcu_as_sc_mcu7t3v3__and2_2
XFILLER_85_664 VDD VDD VSS VSS gf180mcu_as_sc_mcu7t3v3__fill_2
X_6099_ VDD VDD VSS VSS _6486_/CLK _6099_/D _6099_/Q gf180mcu_as_sc_mcu7t3v3__dfxtp_2
XTAP_TAPCELL_ROW_205_2435 VDD VSS gf180mcu_as_sc_mcu7t3v3__tap_2
XTAP_TAPCELL_ROW_205_2424 VDD VSS gf180mcu_as_sc_mcu7t3v3__tap_2
XFILLER_175_6 VDD VDD VSS VSS gf180mcu_as_sc_mcu7t3v3__fillcap_16
XFILLER_211_1170 VDD VDD VSS VSS gf180mcu_as_sc_mcu7t3v3__fillcap_16
XFILLER_211_1192 VDD VDD VSS VSS gf180mcu_as_sc_mcu7t3v3__fillcap_16
XFILLER_214_865 VDD VDD VSS VSS gf180mcu_as_sc_mcu7t3v3__fill_2
XFILLER_53_594 VDD VDD VSS VSS gf180mcu_as_sc_mcu7t3v3__fill_2
XFILLER_159_22 VDD VDD VSS VSS gf180mcu_as_sc_mcu7t3v3__fillcap_16
XFILLER_9_407 VDD VDD VSS VSS gf180mcu_as_sc_mcu7t3v3__fill_2
XFILLER_142_1242 VDD VDD VSS VSS gf180mcu_as_sc_mcu7t3v3__fill_1
XFILLER_185_216 VDD VDD VSS VSS gf180mcu_as_sc_mcu7t3v3__fill_2
XFILLER_201_559 VDD VDD VSS VSS gf180mcu_as_sc_mcu7t3v3__fill_1
XFILLER_139_666 VDD VDD VSS VSS gf180mcu_as_sc_mcu7t3v3__fill_1
XFILLER_159_88 VDD VDD VSS VSS gf180mcu_as_sc_mcu7t3v3__fillcap_16
XFILLER_216_2 VDD VDD VSS VSS gf180mcu_as_sc_mcu7t3v3__fillcap_16
XTAP_TAPCELL_ROW_175_1888 VDD VSS gf180mcu_as_sc_mcu7t3v3__tap_2
XTAP_TAPCELL_ROW_175_1899 VDD VSS gf180mcu_as_sc_mcu7t3v3__tap_2
XFILLER_193_282 VDD VDD VSS VSS gf180mcu_as_sc_mcu7t3v3__fill_2
XFILLER_4_101 VDD VDD VSS VSS gf180mcu_as_sc_mcu7t3v3__fillcap_4
XFILLER_4_123 VDD VDD VSS VSS gf180mcu_as_sc_mcu7t3v3__fillcap_16
XFILLER_175_54 VDD VDD VSS VSS gf180mcu_as_sc_mcu7t3v3__fillcap_16
XPHY_EDGE_ROW_87_3_Right_167 VDD VSS gf180mcu_as_sc_mcu7t3v3__tap_2
XFILLER_4_27 VDD VDD VSS VSS gf180mcu_as_sc_mcu7t3v3__fillcap_8
XFILLER_150_853 VDD VDD VSS VSS gf180mcu_as_sc_mcu7t3v3__fillcap_8
XFILLER_161_190 VDD VDD VSS VSS gf180mcu_as_sc_mcu7t3v3__fillcap_16
XFILLER_175_1084 VDD VDD VSS VSS gf180mcu_as_sc_mcu7t3v3__fillcap_16
XFILLER_62_1210 VDD VDD VSS VSS gf180mcu_as_sc_mcu7t3v3__fill_1
XFILLER_216_1081 VDD VDD VSS VSS gf180mcu_as_sc_mcu7t3v3__fillcap_4
XFILLER_0_384 VDD VDD VSS VSS gf180mcu_as_sc_mcu7t3v3__fillcap_4
Xinput230 VDD VDD VSS VSS se_in[9] _5753_/A gf180mcu_as_sc_mcu7t3v3__buff_12
Xinput241 VDD VDD VSS VSS south_in[19] _5831_/A gf180mcu_as_sc_mcu7t3v3__buff_12
Xinput252 VDD VDD VSS VSS south_in[29] wire997/A gf180mcu_as_sc_mcu7t3v3__buff_12
Xinput263 VDD VDD VSS VSS south_in[6] wire989/A gf180mcu_as_sc_mcu7t3v3__buff_12
XFILLER_209_648 VDD VDD VSS VSS gf180mcu_as_sc_mcu7t3v3__fillcap_8
Xinput274 VDD VDD VSS VSS sw_in[16] _5812_/A gf180mcu_as_sc_mcu7t3v3__buff_12
Xinput285 VDD VDD VSS VSS sw_in[26] _5892_/A gf180mcu_as_sc_mcu7t3v3__buff_12
Xinput296 VDD VDD VSS VSS sw_in[3] _5704_/A gf180mcu_as_sc_mcu7t3v3__buff_12
XFILLER_5_1170 VDD VDD VSS VSS gf180mcu_as_sc_mcu7t3v3__fillcap_16
XFILLER_5_1192 VDD VDD VSS VSS gf180mcu_as_sc_mcu7t3v3__fillcap_16
XFILLER_16_252 VDD VDD VSS VSS gf180mcu_as_sc_mcu7t3v3__fill_2
XFILLER_16_274 VDD VDD VSS VSS gf180mcu_as_sc_mcu7t3v3__fillcap_16
XFILLER_182_1033 VDD VDD VSS VSS gf180mcu_as_sc_mcu7t3v3__fillcap_16
XFILLER_210_27 VDD VDD VSS VSS gf180mcu_as_sc_mcu7t3v3__fillcap_8
XTAP_TAPCELL_ROW_2_1051 VDD VSS gf180mcu_as_sc_mcu7t3v3__tap_2
XFILLER_158_920 VDD VDD VSS VSS gf180mcu_as_sc_mcu7t3v3__fill_1
XFILLER_158_942 VDD VDD VSS VSS gf180mcu_as_sc_mcu7t3v3__fill_2
XFILLER_223_1030 VDD VDD VSS VSS gf180mcu_as_sc_mcu7t3v3__fillcap_16
XFILLER_223_1052 VDD VDD VSS VSS gf180mcu_as_sc_mcu7t3v3__fillcap_16
XFILLER_200_592 VDD VDD VSS VSS gf180mcu_as_sc_mcu7t3v3__fill_2
X_5470_ VDD VDD VSS VSS _5471_/C _5777_/A _5569_/B _5470_/C gf180mcu_as_sc_mcu7t3v3__ao21_2
XFILLER_172_433 VDD VDD VSS VSS gf180mcu_as_sc_mcu7t3v3__fillcap_4
XPHY_EDGE_ROW_23_1_Left_251 VDD VSS gf180mcu_as_sc_mcu7t3v3__tap_2
X_4421_ VDD VDD VSS VSS _6237_/Q _4422_/B _4425_/C _6236_/Q _6236_/D gf180mcu_as_sc_mcu7t3v3__ao22_2
XFILLER_158_1260 VDD VDD VSS VSS gf180mcu_as_sc_mcu7t3v3__fill_1
X_4352_ VDD VDD VSS VSS _4394_/A _4352_/B _4352_/C _4353_/B _4373_/D gf180mcu_as_sc_mcu7t3v3__oai211_2
XFILLER_154_1135 VDD VDD VSS VSS gf180mcu_as_sc_mcu7t3v3__fillcap_16
XFILLER_154_1157 VDD VDD VSS VSS gf180mcu_as_sc_mcu7t3v3__fillcap_16
X_4283_ VDD VDD VSS VSS _4283_/D _4283_/A _4283_/B _4283_/C _6208_/D gf180mcu_as_sc_mcu7t3v3__ao31_2
X_3303_ VDD VDD VSS VSS _3303_/B _3343_/A _3308_/C gf180mcu_as_sc_mcu7t3v3__or2_2
X_6022_ VDD VDD VSS VSS _6519_/CLK _6022_/D _6022_/Q gf180mcu_as_sc_mcu7t3v3__dfxtp_2
X_3234_ VDD VDD VSS VSS _4610_/B _3238_/B _3237_/B gf180mcu_as_sc_mcu7t3v3__or2_2
XTAP_TAPCELL_ROW_181_2004 VDD VSS gf180mcu_as_sc_mcu7t3v3__tap_2
XFILLER_228_913 VDD VDD VSS VSS gf180mcu_as_sc_mcu7t3v3__fill_1
XFILLER_67_664 VDD VDD VSS VSS gf180mcu_as_sc_mcu7t3v3__fill_2
X_3165_ VDD VDD VSS VSS _3166_/A _6531_/Q _3165_/B _3165_/C gf180mcu_as_sc_mcu7t3v3__maj3_2
XPHY_EDGE_ROW_6_Left_235 VDD VSS gf180mcu_as_sc_mcu7t3v3__tap_2
X_3096_ VDD VDD VSS VSS _4495_/A _6138_/Q gf180mcu_as_sc_mcu7t3v3__inv_2
XFILLER_78_1261 VDD VDD VSS VSS gf180mcu_as_sc_mcu7t3v3__fillcap_4
XTAP_TAPCELL_ROW_200_2343 VDD VSS gf180mcu_as_sc_mcu7t3v3__tap_2
XFILLER_120_49 VDD VDD VSS VSS gf180mcu_as_sc_mcu7t3v3__fill_2
XFILLER_165_1264 VDD VDD VSS VSS gf180mcu_as_sc_mcu7t3v3__fill_1
XFILLER_168_717 VDD VDD VSS VSS gf180mcu_as_sc_mcu7t3v3__fill_2
XPHY_EDGE_ROW_93_1_Right_665 VDD VSS gf180mcu_as_sc_mcu7t3v3__tap_2
XFILLER_149_920 VDD VDD VSS VSS gf180mcu_as_sc_mcu7t3v3__fillcap_8
XFILLER_195_547 VDD VDD VSS VSS gf180mcu_as_sc_mcu7t3v3__fill_1
X_5806_ VDD VDD VSS VSS _5862_/S _5806_/B _6509_/Q _5807_/C gf180mcu_as_sc_mcu7t3v3__mux2_2
X_3998_ VDD VDD VSS VSS _4036_/B _4002_/B _4002_/C _6086_/Q _6086_/D gf180mcu_as_sc_mcu7t3v3__ao22_2
XFILLER_202_1103 VDD VDD VSS VSS gf180mcu_as_sc_mcu7t3v3__fillcap_16
X_5737_ VDD VDD VSS VSS _5795_/S _5737_/B _5737_/A _5738_/B gf180mcu_as_sc_mcu7t3v3__mux2_2
XFILLER_182_208 VDD VDD VSS VSS gf180mcu_as_sc_mcu7t3v3__fillcap_4
XTAP_TAPCELL_ROW_157_1563 VDD VSS gf180mcu_as_sc_mcu7t3v3__tap_2
XTAP_TAPCELL_ROW_157_1574 VDD VSS gf180mcu_as_sc_mcu7t3v3__tap_2
XTAP_TAPCELL_ROW_192_2199 VDD VSS gf180mcu_as_sc_mcu7t3v3__tap_2
XFILLER_136_658 VDD VDD VSS VSS gf180mcu_as_sc_mcu7t3v3__fill_2
XFILLER_163_422 VDD VDD VSS VSS gf180mcu_as_sc_mcu7t3v3__fill_2
XFILLER_89_29 VDD VDD VSS VSS gf180mcu_as_sc_mcu7t3v3__fillcap_4
X_5668_ VDD VDD VSS VSS _5668_/B _5668_/A _5668_/Y gf180mcu_as_sc_mcu7t3v3__and2_2
XFILLER_159_1046 VDD VDD VSS VSS gf180mcu_as_sc_mcu7t3v3__fillcap_4
XFILLER_159_1068 VDD VDD VSS VSS gf180mcu_as_sc_mcu7t3v3__fillcap_16
XFILLER_163_455 VDD VDD VSS VSS gf180mcu_as_sc_mcu7t3v3__fill_2
XFILLER_85_1210 VDD VDD VSS VSS gf180mcu_as_sc_mcu7t3v3__fill_1
X_5599_ VDD VDD VSS VSS _5634_/B _5908_/A _5600_/D gf180mcu_as_sc_mcu7t3v3__and2_2
X_4619_ VDD VDD VSS VSS _4619_/A _4619_/B _4619_/C _4619_/D _4620_/B gf180mcu_as_sc_mcu7t3v3__ao211_2
XFILLER_11_1186 VDD VDD VSS VSS gf180mcu_as_sc_mcu7t3v3__fillcap_4
XFILLER_190_274 VDD VDD VSS VSS gf180mcu_as_sc_mcu7t3v3__fillcap_8
XTAP_TAPCELL_ROW_170_1796 VDD VSS gf180mcu_as_sc_mcu7t3v3__tap_2
XTAP_TAPCELL_ROW_27_2_2889 VDD VSS gf180mcu_as_sc_mcu7t3v3__tap_2
Xfanout920 VDD VDD VSS VSS _6132_/Q fanout920/Y gf180mcu_as_sc_mcu7t3v3__buff_12
Xfanout964 VDD VDD VSS VSS fanout965/Y _5943_/D gf180mcu_as_sc_mcu7t3v3__buff_12
Xfanout975 VDD VDD VSS VSS input39/Y _3277_/C gf180mcu_as_sc_mcu7t3v3__buff_12
XPHY_EDGE_ROW_99_1_Left_327 VDD VSS gf180mcu_as_sc_mcu7t3v3__tap_2
XTAP_TAPCELL_ROW_16_1294 VDD VSS gf180mcu_as_sc_mcu7t3v3__tap_2
XFILLER_206_618 VDD VDD VSS VSS gf180mcu_as_sc_mcu7t3v3__fillcap_4
XTAP_TAPCELL_ROW_220_2708 VDD VSS gf180mcu_as_sc_mcu7t3v3__tap_2
XFILLER_166_1017 VDD VDD VSS VSS gf180mcu_as_sc_mcu7t3v3__fillcap_16
XFILLER_205_128 VDD VDD VSS VSS gf180mcu_as_sc_mcu7t3v3__fillcap_4
XFILLER_205_139 VDD VDD VSS VSS gf180mcu_as_sc_mcu7t3v3__fill_1
Xhold1195 VDD VDD VSS VSS hold1220/Y _6540_/D gf180mcu_as_sc_mcu7t3v3__clkbuff_4
XFILLER_199_842 VDD VDD VSS VSS gf180mcu_as_sc_mcu7t3v3__fill_1
XFILLER_207_1014 VDD VDD VSS VSS gf180mcu_as_sc_mcu7t3v3__fillcap_16
XFILLER_26_594 VDD VDD VSS VSS gf180mcu_as_sc_mcu7t3v3__fillcap_16
XFILLER_13_244 VDD VDD VSS VSS gf180mcu_as_sc_mcu7t3v3__fillcap_16
XFILLER_159_739 VDD VDD VSS VSS gf180mcu_as_sc_mcu7t3v3__fill_2
XTAP_TAPCELL_ROW_177_1928 VDD VSS gf180mcu_as_sc_mcu7t3v3__tap_2
XTAP_TAPCELL_ROW_218_2659 VDD VSS gf180mcu_as_sc_mcu7t3v3__tap_2
XFILLER_154_411 VDD VDD VSS VSS gf180mcu_as_sc_mcu7t3v3__fillcap_16
XFILLER_167_772 VDD VDD VSS VSS gf180mcu_as_sc_mcu7t3v3__fillcap_4
XFILLER_10_995 VDD VDD VSS VSS gf180mcu_as_sc_mcu7t3v3__fillcap_16
XFILLER_194_591 VDD VDD VSS VSS gf180mcu_as_sc_mcu7t3v3__fillcap_4
XFILLER_6_944 VDD VDD VSS VSS gf180mcu_as_sc_mcu7t3v3__fill_1
Xclkload18 VDD VDD VSS VSS _6520_/CLK clkload18/Y gf180mcu_as_sc_mcu7t3v3__clkbuff_12
XFILLER_181_263 VDD VDD VSS VSS gf180mcu_as_sc_mcu7t3v3__fillcap_4
XPHY_EDGE_ROW_88_3_Right_168 VDD VSS gf180mcu_as_sc_mcu7t3v3__tap_2
XFILLER_150_661 VDD VDD VSS VSS gf180mcu_as_sc_mcu7t3v3__fillcap_4
XFILLER_150_683 VDD VDD VSS VSS gf180mcu_as_sc_mcu7t3v3__fill_2
XFILLER_205_27 VDD VDD VSS VSS gf180mcu_as_sc_mcu7t3v3__fillcap_16
XFILLER_49_664 VDD VDD VSS VSS gf180mcu_as_sc_mcu7t3v3__fill_2
XFILLER_209_489 VDD VDD VSS VSS gf180mcu_as_sc_mcu7t3v3__fill_1
X_4970_ VDD VDD VSS VSS _4970_/B _4970_/A _5250_/A gf180mcu_as_sc_mcu7t3v3__or2_2
XFILLER_17_594 VDD VDD VSS VSS gf180mcu_as_sc_mcu7t3v3__fillcap_8
XFILLER_189_352 VDD VDD VSS VSS gf180mcu_as_sc_mcu7t3v3__fillcap_4
X_3921_ VDD VDD VSS VSS _5894_/A _3931_/B _3932_/B _3921_/D _3923_/A gf180mcu_as_sc_mcu7t3v3__ao211_2
X_3852_ VDD VDD VSS VSS _5839_/A _3852_/B _3852_/C _3852_/D _3854_/C gf180mcu_as_sc_mcu7t3v3__ao211_2
XFILLER_81_2 VDD VDD VSS VSS gf180mcu_as_sc_mcu7t3v3__fillcap_8
XFILLER_118_614 VDD VDD VSS VSS gf180mcu_as_sc_mcu7t3v3__fill_1
XFILLER_157_260 VDD VDD VSS VSS gf180mcu_as_sc_mcu7t3v3__fillcap_16
XFILLER_192_539 VDD VDD VSS VSS gf180mcu_as_sc_mcu7t3v3__fill_2
X_5522_ VDD VDD VSS VSS _6512_/Q _5571_/B _5571_/C _5831_/A _5523_/C gf180mcu_as_sc_mcu7t3v3__ao22_2
X_3783_ VDD VDD VSS VSS _4774_/D _3905_/B _3905_/C _3785_/C gf180mcu_as_sc_mcu7t3v3__nor3_2
XFILLER_157_282 VDD VDD VSS VSS gf180mcu_as_sc_mcu7t3v3__fillcap_16
XFILLER_172_263 VDD VDD VSS VSS gf180mcu_as_sc_mcu7t3v3__fill_1
XFILLER_195_1224 VDD VDD VSS VSS gf180mcu_as_sc_mcu7t3v3__fillcap_8
X_5453_ VDD VDD VSS VSS _5454_/D _5551_/B _5639_/B _5761_/D gf180mcu_as_sc_mcu7t3v3__aoi21b_2
XTAP_TAPCELL_ROW_152_1471 VDD VSS gf180mcu_as_sc_mcu7t3v3__tap_2
X_5384_ VDD VDD VSS VSS _5693_/D _5494_/B _5384_/C _5384_/D _5386_/C gf180mcu_as_sc_mcu7t3v3__ao211_2
X_4404_ VDD VDD VSS VSS _4405_/S _6126_/Q _4404_/C _4404_/D _4408_/C gf180mcu_as_sc_mcu7t3v3__ao211_2
XFILLER_141_650 VDD VDD VSS VSS gf180mcu_as_sc_mcu7t3v3__fillcap_8
XTAP_TAPCELL_ROW_152_1482 VDD VSS gf180mcu_as_sc_mcu7t3v3__tap_2
X_4335_ VDD VDD VSS VSS _4335_/S _6058_/Q _6087_/Q _4338_/B gf180mcu_as_sc_mcu7t3v3__mux2_2
XFILLER_115_27 VDD VDD VSS VSS gf180mcu_as_sc_mcu7t3v3__fillcap_16
XTAP_TAPCELL_ROW_72_3_2957 VDD VSS gf180mcu_as_sc_mcu7t3v3__tap_2
XPHY_EDGE_ROW_152_Left_380 VDD VSS gf180mcu_as_sc_mcu7t3v3__tap_2
X_4266_ VDD VDD VSS VSS _6206_/Q _4406_/B _4406_/C _6207_/Q _4267_/D gf180mcu_as_sc_mcu7t3v3__ao22_2
X_6005_ VDD VDD VSS VSS _6005_/B _6196_/Q _6518_/D gf180mcu_as_sc_mcu7t3v3__and2_2
X_4197_ VDD VDD VSS VSS _4215_/A _6198_/Q _4197_/A _4198_/B gf180mcu_as_sc_mcu7t3v3__mux2_2
X_3217_ VDD VDD VSS VSS _3218_/C _3217_/B _4072_/A gf180mcu_as_sc_mcu7t3v3__nor2_2
X_3148_ VDD VDD VSS VSS _6315_/Q _4579_/D _4471_/A _3161_/B _4571_/C gf180mcu_as_sc_mcu7t3v3__aoi31_2
X_3079_ VDD VDD VSS VSS _5168_/A _5822_/B gf180mcu_as_sc_mcu7t3v3__inv_2
XTAP_TAPCELL_ROW_159_1603 VDD VSS gf180mcu_as_sc_mcu7t3v3__tap_2
XTAP_TAPCELL_ROW_194_2228 VDD VSS gf180mcu_as_sc_mcu7t3v3__tap_2
XFILLER_211_632 VDD VDD VSS VSS gf180mcu_as_sc_mcu7t3v3__fill_1
XFILLER_211_92 VDD VDD VSS VSS gf180mcu_as_sc_mcu7t3v3__fill_1
XFILLER_223_492 VDD VDD VSS VSS gf180mcu_as_sc_mcu7t3v3__fillcap_4
XPHY_EDGE_ROW_94_1_Right_666 VDD VSS gf180mcu_as_sc_mcu7t3v3__tap_2
XTAP_TAPCELL_ROW_194_2239 VDD VSS gf180mcu_as_sc_mcu7t3v3__tap_2
XFILLER_10_225 VDD VDD VSS VSS gf180mcu_as_sc_mcu7t3v3__fillcap_16
XFILLER_138_6 VDD VDD VSS VSS gf180mcu_as_sc_mcu7t3v3__fillcap_16
XFILLER_149_750 VDD VDD VSS VSS gf180mcu_as_sc_mcu7t3v3__fillcap_4
XFILLER_156_709 VDD VDD VSS VSS gf180mcu_as_sc_mcu7t3v3__fill_1
XFILLER_10_247 VDD VDD VSS VSS gf180mcu_as_sc_mcu7t3v3__fillcap_16
XFILLER_13_1226 VDD VDD VSS VSS gf180mcu_as_sc_mcu7t3v3__fill_1
Xwire617 VDD VDD VSS VSS _3649_/Y wire617/Y gf180mcu_as_sc_mcu7t3v3__clkbuff_12
XFILLER_40_45 VDD VDD VSS VSS gf180mcu_as_sc_mcu7t3v3__fillcap_4
XTAP_TAPCELL_ROW_172_1836 VDD VSS gf180mcu_as_sc_mcu7t3v3__tap_2
XFILLER_156_34 VDD VDD VSS VSS gf180mcu_as_sc_mcu7t3v3__fill_1
XFILLER_164_753 VDD VDD VSS VSS gf180mcu_as_sc_mcu7t3v3__fillcap_16
XTAP_TAPCELL_ROW_142_1_1392 VDD VSS gf180mcu_as_sc_mcu7t3v3__tap_2
XFILLER_151_403 VDD VDD VSS VSS gf180mcu_as_sc_mcu7t3v3__fill_1
XTAP_TAPCELL_ROW_213_2578 VDD VSS gf180mcu_as_sc_mcu7t3v3__tap_2
XTAP_TAPCELL_ROW_213_2567 VDD VSS gf180mcu_as_sc_mcu7t3v3__tap_2
XFILLER_151_447 VDD VDD VSS VSS gf180mcu_as_sc_mcu7t3v3__fill_1
XFILLER_172_22 VDD VDD VSS VSS gf180mcu_as_sc_mcu7t3v3__fillcap_8
XFILLER_172_1065 VDD VDD VSS VSS gf180mcu_as_sc_mcu7t3v3__fillcap_16
XFILLER_172_1087 VDD VDD VSS VSS gf180mcu_as_sc_mcu7t3v3__fillcap_16
XPHY_EDGE_ROW_70_2_Right_907 VDD VSS gf180mcu_as_sc_mcu7t3v3__tap_2
Xfanout750 VDD VDD VSS VSS _3656_/Y _3869_/B gf180mcu_as_sc_mcu7t3v3__buff_12
Xfanout761 VDD VDD VSS VSS _5631_/B _5571_/B gf180mcu_as_sc_mcu7t3v3__buff_12
Xfanout772 VDD VDD VSS VSS _4989_/Y _5140_/B gf180mcu_as_sc_mcu7t3v3__buff_12
Xfanout783 VDD VDD VSS VSS _4980_/Y _5206_/B gf180mcu_as_sc_mcu7t3v3__buff_12
Xfanout794 VDD VDD VSS VSS _4422_/C _4446_/B gf180mcu_as_sc_mcu7t3v3__buff_12
XFILLER_206_404 VDD VDD VSS VSS gf180mcu_as_sc_mcu7t3v3__fill_2
XFILLER_213_1084 VDD VDD VSS VSS gf180mcu_as_sc_mcu7t3v3__fillcap_16
XFILLER_46_612 VDD VDD VSS VSS gf180mcu_as_sc_mcu7t3v3__fill_2
XFILLER_218_297 VDD VDD VSS VSS gf180mcu_as_sc_mcu7t3v3__fillcap_4
XFILLER_206_459 VDD VDD VSS VSS gf180mcu_as_sc_mcu7t3v3__fill_1
XFILLER_2_1151 VDD VDD VSS VSS gf180mcu_as_sc_mcu7t3v3__fillcap_4
XFILLER_2_1173 VDD VDD VSS VSS gf180mcu_as_sc_mcu7t3v3__fillcap_16
XFILLER_109_1210 VDD VDD VSS VSS gf180mcu_as_sc_mcu7t3v3__fillcap_8
XFILLER_215_971 VDD VDD VSS VSS gf180mcu_as_sc_mcu7t3v3__fillcap_8
XFILLER_215_982 VDD VDD VSS VSS gf180mcu_as_sc_mcu7t3v3__fillcap_16
XPHY_EDGE_ROW_138_3_Left_843 VDD VSS gf180mcu_as_sc_mcu7t3v3__tap_2
XFILLER_14_597 VDD VDD VSS VSS gf180mcu_as_sc_mcu7t3v3__fillcap_8
XFILLER_159_547 VDD VDD VSS VSS gf180mcu_as_sc_mcu7t3v3__fill_2
XFILLER_201_142 VDD VDD VSS VSS gf180mcu_as_sc_mcu7t3v3__fillcap_16
XFILLER_179_1208 VDD VDD VSS VSS gf180mcu_as_sc_mcu7t3v3__fillcap_16
XFILLER_197_96 VDD VDD VSS VSS gf180mcu_as_sc_mcu7t3v3__fill_1
XFILLER_201_164 VDD VDD VSS VSS gf180mcu_as_sc_mcu7t3v3__fill_1
XFILLER_220_1011 VDD VDD VSS VSS gf180mcu_as_sc_mcu7t3v3__fillcap_4
Xmax_cap1012 VDD VDD VSS VSS input194/Y fanout1004/A gf180mcu_as_sc_mcu7t3v3__clkbuff_12
XFILLER_220_1033 VDD VDD VSS VSS gf180mcu_as_sc_mcu7t3v3__fillcap_16
XFILLER_115_606 VDD VDD VSS VSS gf180mcu_as_sc_mcu7t3v3__fill_1
XFILLER_154_241 VDD VDD VSS VSS gf180mcu_as_sc_mcu7t3v3__fillcap_4
XFILLER_6_741 VDD VDD VSS VSS gf180mcu_as_sc_mcu7t3v3__fill_2
XFILLER_154_263 VDD VDD VSS VSS gf180mcu_as_sc_mcu7t3v3__fillcap_16
XFILLER_155_797 VDD VDD VSS VSS gf180mcu_as_sc_mcu7t3v3__fill_1
XFILLER_170_734 VDD VDD VSS VSS gf180mcu_as_sc_mcu7t3v3__fill_1
XFILLER_182_594 VDD VDD VSS VSS gf180mcu_as_sc_mcu7t3v3__fill_1
XFILLER_216_37 VDD VDD VSS VSS gf180mcu_as_sc_mcu7t3v3__fillcap_16
XFILLER_123_661 VDD VDD VSS VSS gf180mcu_as_sc_mcu7t3v3__fill_1
XPHY_EDGE_ROW_89_3_Right_169 VDD VSS gf180mcu_as_sc_mcu7t3v3__tap_2
XTAP_TAPCELL_ROW_92_1_1367 VDD VSS gf180mcu_as_sc_mcu7t3v3__tap_2
XFILLER_151_1116 VDD VDD VSS VSS gf180mcu_as_sc_mcu7t3v3__fillcap_4
XFILLER_151_1138 VDD VDD VSS VSS gf180mcu_as_sc_mcu7t3v3__fillcap_16
X_4120_ VDD VDD VSS VSS _4146_/S _6170_/Q _6169_/Q _6169_/D gf180mcu_as_sc_mcu7t3v3__mux2_2
X_4051_ VDD VDD VSS VSS _4051_/D _4051_/A _4051_/B _4057_/C _6124_/D gf180mcu_as_sc_mcu7t3v3__ao31_2
XFILLER_225_702 VDD VDD VSS VSS gf180mcu_as_sc_mcu7t3v3__fill_1
XFILLER_7_1084 VDD VDD VSS VSS gf180mcu_as_sc_mcu7t3v3__fillcap_16
Xinput5 VDD VDD VSS VSS TILE_ID[4] input5/Y gf180mcu_as_sc_mcu7t3v3__buff_12
X_3002_ VDD VDD VSS VSS _5960_/A _6486_/Q gf180mcu_as_sc_mcu7t3v3__inv_2
Xmesh_tile_1171 VDD VDD VSS VSS sw_out[22] gf180mcu_as_sc_mcu7t3v3__tiel_4
Xmesh_tile_1160 VDD VDD VSS VSS sw_out[11] gf180mcu_as_sc_mcu7t3v3__tiel_4
XFILLER_149_1056 VDD VDD VSS VSS gf180mcu_as_sc_mcu7t3v3__fillcap_16
Xmesh_tile_1182 VDD VDD VSS VSS sw_out[33] gf180mcu_as_sc_mcu7t3v3__tiel_4
X_4953_ VDD VDD VSS VSS _6523_/Q _4953_/B _4953_/C _5302_/A _4954_/D gf180mcu_as_sc_mcu7t3v3__ao22_2
XFILLER_189_171 VDD VDD VSS VSS gf180mcu_as_sc_mcu7t3v3__fillcap_16
XFILLER_205_492 VDD VDD VSS VSS gf180mcu_as_sc_mcu7t3v3__fillcap_4
X_3904_ VDD VDD VSS VSS _6041_/Q _3904_/B _4057_/B _3904_/D _6041_/D gf180mcu_as_sc_mcu7t3v3__ao22_2
X_4884_ VDD VDD VSS VSS _6365_/D _4884_/C _4950_/D _5875_/A gf180mcu_as_sc_mcu7t3v3__aoi21b_2
X_3835_ VDD VDD VSS VSS _3928_/B _5824_/A _3836_/D gf180mcu_as_sc_mcu7t3v3__and2_2
XFILLER_203_1264 VDD VDD VSS VSS gf180mcu_as_sc_mcu7t3v3__fill_1
XTAP_TAPCELL_ROW_154_1511 VDD VSS gf180mcu_as_sc_mcu7t3v3__tap_2
XTAP_TAPCELL_ROW_154_1522 VDD VSS gf180mcu_as_sc_mcu7t3v3__tap_2
X_3766_ VDD VDD VSS VSS _5765_/B _3886_/C _3766_/C _3766_/D _3768_/C gf180mcu_as_sc_mcu7t3v3__ao211_2
X_6485_ VDD VDD VSS VSS _6486_/CLK _6485_/D _6485_/Q gf180mcu_as_sc_mcu7t3v3__dfxtp_2
X_5505_ VDD VDD VSS VSS _5812_/A _5568_/B _5505_/C _5505_/D _5506_/B gf180mcu_as_sc_mcu7t3v3__ao211_2
XPHY_EDGE_ROW_66_2_Left_507 VDD VSS gf180mcu_as_sc_mcu7t3v3__tap_2
X_5436_ VDD VDD VSS VSS _5744_/A _5640_/C _5436_/C _5436_/D _5438_/C gf180mcu_as_sc_mcu7t3v3__ao22_2
X_3697_ VDD VDD VSS VSS _6019_/Q _3933_/B _4023_/B _3904_/D _6019_/D gf180mcu_as_sc_mcu7t3v3__ao22_2
XFILLER_126_37 VDD VDD VSS VSS gf180mcu_as_sc_mcu7t3v3__fillcap_8
XFILLER_156_1049 VDD VDD VSS VSS gf180mcu_as_sc_mcu7t3v3__fillcap_16
XFILLER_161_767 VDD VDD VSS VSS gf180mcu_as_sc_mcu7t3v3__fill_2
Xoutput353 VDD VDD VSS VSS _6428_/Q east_out[15] gf180mcu_as_sc_mcu7t3v3__buff_12
Xoutput342 VDD VDD VSS VSS _6718_/Y dft_rdata[3] gf180mcu_as_sc_mcu7t3v3__buff_12
Xoutput386 VDD VDD VSS VSS _6353_/Q north_out[12] gf180mcu_as_sc_mcu7t3v3__buff_12
Xoutput375 VDD VDD VSS VSS _6448_/Q east_out[35] gf180mcu_as_sc_mcu7t3v3__buff_12
Xoutput364 VDD VDD VSS VSS _6438_/Q east_out[25] gf180mcu_as_sc_mcu7t3v3__buff_12
X_5367_ VDD VDD VSS VSS _5367_/A _5654_/C _5367_/C _5367_/Y gf180mcu_as_sc_mcu7t3v3__nor3_2
Xoutput397 VDD VDD VSS VSS _6363_/Q north_out[22] gf180mcu_as_sc_mcu7t3v3__buff_12
X_5298_ VDD VDD VSS VSS _5304_/B _5939_/A _5298_/A _5299_/C gf180mcu_as_sc_mcu7t3v3__mux2_2
X_4318_ VDD VDD VSS VSS _6213_/D _4318_/B _4318_/A gf180mcu_as_sc_mcu7t3v3__nand2_2
X_4249_ VDD VDD VSS VSS _4281_/B _6155_/Q _4251_/C gf180mcu_as_sc_mcu7t3v3__or2_2
XFILLER_210_1235 VDD VDD VSS VSS gf180mcu_as_sc_mcu7t3v3__fillcap_4
XTAP_TAPCELL_ROW_13_1242 VDD VSS gf180mcu_as_sc_mcu7t3v3__tap_2
XTAP_TAPCELL_ROW_13_1253 VDD VSS gf180mcu_as_sc_mcu7t3v3__tap_2
XFILLER_228_584 VDD VDD VSS VSS gf180mcu_as_sc_mcu7t3v3__fill_2
XFILLER_28_645 VDD VDD VSS VSS gf180mcu_as_sc_mcu7t3v3__fill_2
XFILLER_215_278 VDD VDD VSS VSS gf180mcu_as_sc_mcu7t3v3__fill_2
XFILLER_35_45 VDD VDD VSS VSS gf180mcu_as_sc_mcu7t3v3__fillcap_4
XFILLER_187_119 VDD VDD VSS VSS gf180mcu_as_sc_mcu7t3v3__fillcap_8
XFILLER_168_344 VDD VDD VSS VSS gf180mcu_as_sc_mcu7t3v3__fill_1
XFILLER_204_1017 VDD VDD VSS VSS gf180mcu_as_sc_mcu7t3v3__fillcap_16
XFILLER_212_963 VDD VDD VSS VSS gf180mcu_as_sc_mcu7t3v3__fillcap_16
XTAP_TAPCELL_ROW_34_1_1338 VDD VSS gf180mcu_as_sc_mcu7t3v3__tap_2
XFILLER_7_505 VDD VDD VSS VSS gf180mcu_as_sc_mcu7t3v3__fillcap_4
XPHY_EDGE_ROW_95_1_Right_667 VDD VSS gf180mcu_as_sc_mcu7t3v3__tap_2
XTAP_TAPCELL_ROW_215_2618 VDD VSS gf180mcu_as_sc_mcu7t3v3__tap_2
XTAP_TAPCELL_ROW_215_2607 VDD VSS gf180mcu_as_sc_mcu7t3v3__tap_2
XFILLER_149_580 VDD VDD VSS VSS gf180mcu_as_sc_mcu7t3v3__fillcap_4
XFILLER_167_22 VDD VDD VSS VSS gf180mcu_as_sc_mcu7t3v3__fillcap_16
XFILLER_167_88 VDD VDD VSS VSS gf180mcu_as_sc_mcu7t3v3__fillcap_16
XFILLER_139_1214 VDD VDD VSS VSS gf180mcu_as_sc_mcu7t3v3__fill_1
XFILLER_151_244 VDD VDD VSS VSS gf180mcu_as_sc_mcu7t3v3__fillcap_16
XFILLER_105_661 VDD VDD VSS VSS gf180mcu_as_sc_mcu7t3v3__fill_1
XPHY_EDGE_ROW_71_2_Right_908 VDD VSS gf180mcu_as_sc_mcu7t3v3__tap_2
Xfanout580 VDD VDD VSS VSS _5841_/B _5802_/C gf180mcu_as_sc_mcu7t3v3__buff_12
Xfanout591 VDD VDD VSS VSS wire597/Y _5496_/B gf180mcu_as_sc_mcu7t3v3__buff_12
XFILLER_19_645 VDD VDD VSS VSS gf180mcu_as_sc_mcu7t3v3__fillcap_4
XFILLER_185_1234 VDD VDD VSS VSS gf180mcu_as_sc_mcu7t3v3__fill_1
XPHY_EDGE_ROW_32_1_Left_260 VDD VSS gf180mcu_as_sc_mcu7t3v3__tap_2
XFILLER_221_226 VDD VDD VSS VSS gf180mcu_as_sc_mcu7t3v3__fill_2
XFILLER_174_314 VDD VDD VSS VSS gf180mcu_as_sc_mcu7t3v3__fill_1
X_3620_ VDD VDD VSS VSS _5319_/D _3620_/B _3620_/C _5319_/A _5353_/B gf180mcu_as_sc_mcu7t3v3__ao22_2
XFILLER_174_369 VDD VDD VSS VSS gf180mcu_as_sc_mcu7t3v3__fillcap_16
X_3551_ VDD VDD VSS VSS _3556_/C _5340_/A _5931_/A gf180mcu_as_sc_mcu7t3v3__nand2b_2
XFILLER_155_594 VDD VDD VSS VSS gf180mcu_as_sc_mcu7t3v3__fillcap_8
XFILLER_192_1205 VDD VDD VSS VSS gf180mcu_as_sc_mcu7t3v3__fillcap_16
Xwire981 VDD VDD VSS VSS wire981/A _5915_/A gf180mcu_as_sc_mcu7t3v3__clkbuff_12
XFILLER_170_520 VDD VDD VSS VSS gf180mcu_as_sc_mcu7t3v3__fillcap_4
XFILLER_170_531 VDD VDD VSS VSS gf180mcu_as_sc_mcu7t3v3__fill_2
XFILLER_182_391 VDD VDD VSS VSS gf180mcu_as_sc_mcu7t3v3__fill_1
XFILLER_192_1227 VDD VDD VSS VSS gf180mcu_as_sc_mcu7t3v3__fillcap_8
X_6270_ VDD VDD VSS VSS _6551_/CLK _6270_/D _6270_/Q gf180mcu_as_sc_mcu7t3v3__dfxtp_2
X_3482_ VDD VDD VSS VSS _3483_/D _5914_/D _4239_/A gf180mcu_as_sc_mcu7t3v3__nand2b_2
X_5221_ VDD VDD VSS VSS _5222_/D _5871_/A _5221_/B _5224_/B gf180mcu_as_sc_mcu7t3v3__ao21_2
XFILLER_170_597 VDD VDD VSS VSS gf180mcu_as_sc_mcu7t3v3__fillcap_4
X_5152_ VDD VDD VSS VSS _5809_/A _5217_/S _5226_/C _5808_/A _5153_/D gf180mcu_as_sc_mcu7t3v3__ao22_2
XFILLER_111_664 VDD VDD VSS VSS gf180mcu_as_sc_mcu7t3v3__fill_2
X_4103_ VDD VDD VSS VSS _4103_/B _4103_/A _4106_/B gf180mcu_as_sc_mcu7t3v3__xnor2_2
X_5083_ VDD VDD VSS VSS _5138_/B _5750_/A _5084_/C gf180mcu_as_sc_mcu7t3v3__and2_2
X_4034_ VDD VDD VSS VSS _4055_/S _4034_/B _6114_/Q _6114_/D gf180mcu_as_sc_mcu7t3v3__mux2_2
X_5985_ VDD VDD VSS VSS _6011_/B _5985_/A _6498_/D gf180mcu_as_sc_mcu7t3v3__and2_2
XFILLER_40_629 VDD VDD VSS VSS gf180mcu_as_sc_mcu7t3v3__fillcap_4
X_4936_ VDD VDD VSS VSS _5926_/A _4950_/D _4936_/C _6371_/D _5925_/D gf180mcu_as_sc_mcu7t3v3__aoi211_2
XTAP_TAPCELL_ROW_18_1_1330 VDD VSS gf180mcu_as_sc_mcu7t3v3__tap_2
XANTENNA_10 VDD VDD VSS VSS _6013_/B gf180mcu_as_sc_mcu7t3v3__diode_2
XANTENNA_21 VDD VDD VSS VSS _5063_/A gf180mcu_as_sc_mcu7t3v3__diode_2
XANTENNA_32 VDD VDD VSS VSS _5821_/A gf180mcu_as_sc_mcu7t3v3__diode_2
XFILLER_177_163 VDD VDD VSS VSS gf180mcu_as_sc_mcu7t3v3__fillcap_4
X_4867_ VDD VDD VSS VSS _5864_/A _4885_/B _4867_/C _4867_/D _4870_/C gf180mcu_as_sc_mcu7t3v3__ao211_2
XANTENNA_43 VDD VDD VSS VSS _5868_/B gf180mcu_as_sc_mcu7t3v3__diode_2
XFILLER_165_325 VDD VDD VSS VSS gf180mcu_as_sc_mcu7t3v3__fillcap_8
XFILLER_197_1116 VDD VDD VSS VSS gf180mcu_as_sc_mcu7t3v3__fillcap_4
X_3818_ VDD VDD VSS VSS _3930_/B _5809_/A _3819_/D gf180mcu_as_sc_mcu7t3v3__and2_2
XFILLER_192_133 VDD VDD VSS VSS gf180mcu_as_sc_mcu7t3v3__fillcap_4
XFILLER_197_1138 VDD VDD VSS VSS gf180mcu_as_sc_mcu7t3v3__fillcap_16
X_6537_ VDD VDD VSS VSS _6546_/CLK _6537_/D _6537_/Q gf180mcu_as_sc_mcu7t3v3__dfxtp_2
X_4798_ VDD VDD VSS VSS _4798_/B _5978_/A _6356_/D gf180mcu_as_sc_mcu7t3v3__and2_2
XTAP_TAPCELL_ROW_60_3_2939 VDD VSS gf180mcu_as_sc_mcu7t3v3__tap_2
X_3749_ VDD VDD VSS VSS _5752_/D _3807_/S _3749_/C _3749_/D _3750_/B gf180mcu_as_sc_mcu7t3v3__ao211_2
XFILLER_146_594 VDD VDD VSS VSS gf180mcu_as_sc_mcu7t3v3__fillcap_8
X_6468_ VDD VDD VSS VSS _6474_/CLK _6468_/D _6468_/Q gf180mcu_as_sc_mcu7t3v3__dfxtp_2
XTAP_TAPCELL_ROW_210_2526 VDD VSS gf180mcu_as_sc_mcu7t3v3__tap_2
XTAP_TAPCELL_ROW_210_2515 VDD VSS gf180mcu_as_sc_mcu7t3v3__tap_2
XTAP_TAPCELL_ROW_189_2149 VDD VSS gf180mcu_as_sc_mcu7t3v3__tap_2
XTAP_TAPCELL_ROW_189_2138 VDD VSS gf180mcu_as_sc_mcu7t3v3__tap_2
XPHY_EDGE_ROW_208_Right_76 VDD VSS gf180mcu_as_sc_mcu7t3v3__tap_2
X_6399_ VDD VDD VSS VSS _6412_/CLK _6399_/D _6399_/Q gf180mcu_as_sc_mcu7t3v3__dfxtp_2
X_5419_ VDD VDD VSS VSS _5723_/A _5567_/B _5419_/C _5419_/D _5420_/C gf180mcu_as_sc_mcu7t3v3__ao22_2
XTAP_TAPCELL_ROW_167_1746 VDD VSS gf180mcu_as_sc_mcu7t3v3__tap_2
XFILLER_228_370 VDD VDD VSS VSS gf180mcu_as_sc_mcu7t3v3__fillcap_4
XFILLER_46_33 VDD VDD VSS VSS gf180mcu_as_sc_mcu7t3v3__fill_2
XTAP_TAPCELL_ROW_208_2488 VDD VSS gf180mcu_as_sc_mcu7t3v3__tap_2
XTAP_TAPCELL_ROW_208_2477 VDD VSS gf180mcu_as_sc_mcu7t3v3__tap_2
XFILLER_210_1065 VDD VDD VSS VSS gf180mcu_as_sc_mcu7t3v3__fillcap_16
XFILLER_210_1087 VDD VDD VSS VSS gf180mcu_as_sc_mcu7t3v3__fillcap_16
XTAP_TAPCELL_ROW_225_2791 VDD VSS gf180mcu_as_sc_mcu7t3v3__tap_2
XFILLER_16_637 VDD VDD VSS VSS gf180mcu_as_sc_mcu7t3v3__fillcap_8
XFILLER_16_659 VDD VDD VSS VSS gf180mcu_as_sc_mcu7t3v3__fillcap_8
XTAP_TAPCELL_ROW_180_1979 VDD VSS gf180mcu_as_sc_mcu7t3v3__tap_2
XFILLER_15_136 VDD VDD VSS VSS gf180mcu_as_sc_mcu7t3v3__fillcap_4
XFILLER_15_158 VDD VDD VSS VSS gf180mcu_as_sc_mcu7t3v3__fillcap_16
XPHY_EDGE_ROW_217_Right_85 VDD VSS gf180mcu_as_sc_mcu7t3v3__tap_2
XFILLER_145_1251 VDD VDD VSS VSS gf180mcu_as_sc_mcu7t3v3__fillcap_8
XFILLER_203_248 VDD VDD VSS VSS gf180mcu_as_sc_mcu7t3v3__fill_2
XFILLER_157_837 VDD VDD VSS VSS gf180mcu_as_sc_mcu7t3v3__fill_2
XFILLER_178_98 VDD VDD VSS VSS gf180mcu_as_sc_mcu7t3v3__fillcap_4
XFILLER_7_27 VDD VDD VSS VSS gf180mcu_as_sc_mcu7t3v3__fillcap_16
XPHY_EDGE_ROW_96_1_Right_668 VDD VSS gf180mcu_as_sc_mcu7t3v3__tap_2
XFILLER_172_807 VDD VDD VSS VSS gf180mcu_as_sc_mcu7t3v3__fill_1
XFILLER_137_594 VDD VDD VSS VSS gf180mcu_as_sc_mcu7t3v3__fill_2
XFILLER_194_53 VDD VDD VSS VSS gf180mcu_as_sc_mcu7t3v3__fillcap_16
XFILLER_217_1208 VDD VDD VSS VSS gf180mcu_as_sc_mcu7t3v3__fillcap_16
XPHY_EDGE_ROW_226_Right_94 VDD VSS gf180mcu_as_sc_mcu7t3v3__tap_2
XFILLER_98_629 VDD VDD VSS VSS gf180mcu_as_sc_mcu7t3v3__fill_2
XFILLER_152_597 VDD VDD VSS VSS gf180mcu_as_sc_mcu7t3v3__fillcap_16
XFILLER_227_808 VDD VDD VSS VSS gf180mcu_as_sc_mcu7t3v3__fillcap_4
XFILLER_213_27 VDD VDD VSS VSS gf180mcu_as_sc_mcu7t3v3__fillcap_16
XPHY_EDGE_ROW_72_2_Right_909 VDD VSS gf180mcu_as_sc_mcu7t3v3__tap_2
XFILLER_4_1065 VDD VDD VSS VSS gf180mcu_as_sc_mcu7t3v3__fillcap_16
XFILLER_4_1087 VDD VDD VSS VSS gf180mcu_as_sc_mcu7t3v3__fillcap_16
XFILLER_188_940 VDD VDD VSS VSS gf180mcu_as_sc_mcu7t3v3__fill_1
XFILLER_22_629 VDD VDD VSS VSS gf180mcu_as_sc_mcu7t3v3__fillcap_8
X_5770_ VDD VDD VSS VSS _5875_/S _5770_/B _5770_/A _5771_/B gf180mcu_as_sc_mcu7t3v3__mux2_2
XFILLER_72_1245 VDD VDD VSS VSS gf180mcu_as_sc_mcu7t3v3__fillcap_16
X_4721_ VDD VDD VSS VSS _6500_/Q _4861_/B _4856_/B _5735_/D _4722_/C gf180mcu_as_sc_mcu7t3v3__ao22_2
XFILLER_159_174 VDD VDD VSS VSS gf180mcu_as_sc_mcu7t3v3__fillcap_16
X_4652_ VDD VDD VSS VSS _5003_/C _4652_/A _4967_/A gf180mcu_as_sc_mcu7t3v3__and2_2
XFILLER_175_678 VDD VDD VSS VSS gf180mcu_as_sc_mcu7t3v3__fill_2
Xinput30 VDD VDD VSS VSS dft_addr[1] _3227_/B gf180mcu_as_sc_mcu7t3v3__buff_12
X_3603_ VDD VDD VSS VSS _3607_/C _5323_/A _6521_/Q gf180mcu_as_sc_mcu7t3v3__nand2b_2
XFILLER_162_317 VDD VDD VSS VSS gf180mcu_as_sc_mcu7t3v3__fillcap_8
XFILLER_174_166 VDD VDD VSS VSS gf180mcu_as_sc_mcu7t3v3__fill_2
Xinput41 VDD VDD VSS VSS dft_wdata[0] _3310_/B gf180mcu_as_sc_mcu7t3v3__buff_12
Xinput52 VDD VDD VSS VSS east_in[11] wire961/A gf180mcu_as_sc_mcu7t3v3__buff_12
Xinput63 VDD VDD VSS VSS east_in[21] wire953/A gf180mcu_as_sc_mcu7t3v3__buff_12
X_4583_ VDD VDD VSS VSS _6316_/D _4583_/A _4583_/B _4583_/C _4583_/D gf180mcu_as_sc_mcu7t3v3__aoi22_2
XFILLER_128_594 VDD VDD VSS VSS gf180mcu_as_sc_mcu7t3v3__fillcap_16
XFILLER_157_1100 VDD VDD VSS VSS gf180mcu_as_sc_mcu7t3v3__fillcap_16
XFILLER_157_1122 VDD VDD VSS VSS gf180mcu_as_sc_mcu7t3v3__fillcap_16
XFILLER_190_648 VDD VDD VSS VSS gf180mcu_as_sc_mcu7t3v3__fill_2
XFILLER_192_1013 VDD VDD VSS VSS gf180mcu_as_sc_mcu7t3v3__fill_2
Xinput74 VDD VDD VSS VSS east_in[31] _5929_/A gf180mcu_as_sc_mcu7t3v3__buff_12
Xinput85 VDD VDD VSS VSS east_in[9] _5748_/A gf180mcu_as_sc_mcu7t3v3__buff_12
Xinput96 VDD VDD VSS VSS ne_in[19] _5833_/D gf180mcu_as_sc_mcu7t3v3__buff_12
X_6322_ VDD VDD VSS VSS _6552_/CLK _6322_/D _6322_/Q gf180mcu_as_sc_mcu7t3v3__dfxtp_2
X_3534_ VDD VDD VSS VSS _5652_/C _3615_/A _5652_/D _3534_/D _3656_/D gf180mcu_as_sc_mcu7t3v3__nand4_2
X_6253_ VDD VDD VSS VSS _6313_/CLK _6253_/D _6253_/Q gf180mcu_as_sc_mcu7t3v3__dfxtp_2
X_3465_ VDD VDD VSS VSS _3466_/B _3639_/A _5939_/A _4634_/B _5950_/D gf180mcu_as_sc_mcu7t3v3__aoi22_2
X_5204_ VDD VDD VSS VSS _5205_/D _5204_/C _5311_/B _5853_/A gf180mcu_as_sc_mcu7t3v3__aoi21_2
XPHY_EDGE_ROW_58_1_Right_630 VDD VSS gf180mcu_as_sc_mcu7t3v3__tap_2
XTAP_TAPCELL_ROW_149_1410 VDD VSS gf180mcu_as_sc_mcu7t3v3__tap_2
XTAP_TAPCELL_ROW_149_1421 VDD VSS gf180mcu_as_sc_mcu7t3v3__tap_2
XTAP_TAPCELL_ROW_149_1432 VDD VSS gf180mcu_as_sc_mcu7t3v3__tap_2
X_6184_ VDD VDD VSS VSS _6490_/CLK _6184_/D _6184_/Q gf180mcu_as_sc_mcu7t3v3__dfxtp_2
X_3396_ VDD VDD VSS VSS _3396_/D _3433_/B _6324_/Q _4230_/A _3397_/B gf180mcu_as_sc_mcu7t3v3__ao31_2
XTAP_TAPCELL_ROW_184_2057 VDD VSS gf180mcu_as_sc_mcu7t3v3__tap_2
XTAP_TAPCELL_ROW_184_2046 VDD VSS gf180mcu_as_sc_mcu7t3v3__tap_2
X_5135_ VDD VDD VSS VSS _5794_/A _5144_/B _5135_/C _5135_/D _5136_/A gf180mcu_as_sc_mcu7t3v3__ao211_2
XFILLER_123_27 VDD VDD VSS VSS gf180mcu_as_sc_mcu7t3v3__fillcap_16
XTAP_TAPCELL_ROW_10_1201 VDD VSS gf180mcu_as_sc_mcu7t3v3__tap_2
X_5066_ VDD VDD VSS VSS _5301_/S _5066_/B _5066_/C _5205_/B _5069_/B gf180mcu_as_sc_mcu7t3v3__ao211_2
X_4017_ VDD VDD VSS VSS _4057_/C _5925_/D _5960_/C gf180mcu_as_sc_mcu7t3v3__or2_2
XTAP_TAPCELL_ROW_162_1654 VDD VSS gf180mcu_as_sc_mcu7t3v3__tap_2
XTAP_TAPCELL_ROW_162_1665 VDD VSS gf180mcu_as_sc_mcu7t3v3__tap_2
XFILLER_198_737 VDD VDD VSS VSS gf180mcu_as_sc_mcu7t3v3__fillcap_4
XTAP_TAPCELL_ROW_203_2396 VDD VSS gf180mcu_as_sc_mcu7t3v3__tap_2
XFILLER_13_629 VDD VDD VSS VSS gf180mcu_as_sc_mcu7t3v3__fill_1
XFILLER_213_557 VDD VDD VSS VSS gf180mcu_as_sc_mcu7t3v3__fill_2
X_5968_ VDD VDD VSS VSS _6490_/Q _5971_/A _5971_/B _5972_/A gf180mcu_as_sc_mcu7t3v3__nand3_2
XFILLER_12_139 VDD VDD VSS VSS gf180mcu_as_sc_mcu7t3v3__fillcap_16
X_4919_ VDD VDD VSS VSS _5908_/A _4957_/B _4919_/C _4919_/D _4920_/B gf180mcu_as_sc_mcu7t3v3__ao211_2
XFILLER_178_472 VDD VDD VSS VSS gf180mcu_as_sc_mcu7t3v3__fillcap_16
XFILLER_194_932 VDD VDD VSS VSS gf180mcu_as_sc_mcu7t3v3__fillcap_8
X_5899_ VDD VDD VSS VSS _5899_/A _5953_/C _5899_/C _5899_/D _5900_/D gf180mcu_as_sc_mcu7t3v3__ao211_2
XFILLER_148_24 VDD VDD VSS VSS gf180mcu_as_sc_mcu7t3v3__fillcap_8
XFILLER_14_1151 VDD VDD VSS VSS gf180mcu_as_sc_mcu7t3v3__fillcap_4
XFILLER_154_807 VDD VDD VSS VSS gf180mcu_as_sc_mcu7t3v3__fillcap_16
XFILLER_166_667 VDD VDD VSS VSS gf180mcu_as_sc_mcu7t3v3__fill_1
XFILLER_166_678 VDD VDD VSS VSS gf180mcu_as_sc_mcu7t3v3__fill_2
XTAP_TAPCELL_ROW_78_3_2966 VDD VSS gf180mcu_as_sc_mcu7t3v3__tap_2
XFILLER_14_1173 VDD VDD VSS VSS gf180mcu_as_sc_mcu7t3v3__fillcap_16
XFILLER_119_594 VDD VDD VSS VSS gf180mcu_as_sc_mcu7t3v3__fillcap_16
XFILLER_162_840 VDD VDD VSS VSS gf180mcu_as_sc_mcu7t3v3__fillcap_8
XFILLER_164_23 VDD VDD VSS VSS gf180mcu_as_sc_mcu7t3v3__fillcap_8
XPHY_EDGE_ROW_22_3_Left_727 VDD VSS gf180mcu_as_sc_mcu7t3v3__tap_2
XFILLER_216_1263 VDD VDD VSS VSS gf180mcu_as_sc_mcu7t3v3__fill_2
XPHY_EDGE_ROW_147_3_Left_852 VDD VSS gf180mcu_as_sc_mcu7t3v3__tap_2
XTAP_TAPCELL_ROW_227_2820 VDD VSS gf180mcu_as_sc_mcu7t3v3__tap_2
XTAP_TAPCELL_ROW_227_2831 VDD VSS gf180mcu_as_sc_mcu7t3v3__tap_2
XFILLER_112_1261 VDD VDD VSS VSS gf180mcu_as_sc_mcu7t3v3__fillcap_4
XFILLER_16_401 VDD VDD VSS VSS gf180mcu_as_sc_mcu7t3v3__fillcap_4
XPHY_EDGE_ROW_20_1_Right_592 VDD VSS gf180mcu_as_sc_mcu7t3v3__tap_2
XFILLER_16_478 VDD VDD VSS VSS gf180mcu_as_sc_mcu7t3v3__fillcap_4
XFILLER_188_247 VDD VDD VSS VSS gf180mcu_as_sc_mcu7t3v3__fill_2
XFILLER_12_662 VDD VDD VSS VSS gf180mcu_as_sc_mcu7t3v3__fill_2
XFILLER_169_483 VDD VDD VSS VSS gf180mcu_as_sc_mcu7t3v3__fillcap_4
XFILLER_223_1256 VDD VDD VSS VSS gf180mcu_as_sc_mcu7t3v3__fillcap_4
XFILLER_200_763 VDD VDD VSS VSS gf180mcu_as_sc_mcu7t3v3__fillcap_16
XFILLER_156_155 VDD VDD VSS VSS gf180mcu_as_sc_mcu7t3v3__fillcap_16
XFILLER_156_177 VDD VDD VSS VSS gf180mcu_as_sc_mcu7t3v3__fillcap_16
XFILLER_185_998 VDD VDD VSS VSS gf180mcu_as_sc_mcu7t3v3__fillcap_16
XPHY_EDGE_ROW_97_1_Right_669 VDD VSS gf180mcu_as_sc_mcu7t3v3__tap_2
XTAP_TAPCELL_ROW_30_3_2894 VDD VSS gf180mcu_as_sc_mcu7t3v3__tap_2
XFILLER_171_136 VDD VDD VSS VSS gf180mcu_as_sc_mcu7t3v3__fillcap_4
XFILLER_171_158 VDD VDD VSS VSS gf180mcu_as_sc_mcu7t3v3__fillcap_16
XFILLER_152_383 VDD VDD VSS VSS gf180mcu_as_sc_mcu7t3v3__fill_2
XPHY_EDGE_ROW_79_3_Left_784 VDD VSS gf180mcu_as_sc_mcu7t3v3__tap_2
X_3250_ VDD VDD VSS VSS _3250_/B _3404_/A _3252_/C gf180mcu_as_sc_mcu7t3v3__and2_2
XFILLER_224_37 VDD VDD VSS VSS gf180mcu_as_sc_mcu7t3v3__fillcap_16
X_3181_ VDD VDD VSS VSS _4603_/A _6316_/Q _4448_/B gf180mcu_as_sc_mcu7t3v3__and2_2
XPHY_EDGE_ROW_138_2_Left_579 VDD VSS gf180mcu_as_sc_mcu7t3v3__tap_2
XTAP_TAPCELL_ROW_7_1144 VDD VSS gf180mcu_as_sc_mcu7t3v3__tap_2
XTAP_TAPCELL_ROW_7_1133 VDD VSS gf180mcu_as_sc_mcu7t3v3__tap_2
XFILLER_226_137 VDD VDD VSS VSS gf180mcu_as_sc_mcu7t3v3__fill_1
XFILLER_227_649 VDD VDD VSS VSS gf180mcu_as_sc_mcu7t3v3__fill_1
XFILLER_179_203 VDD VDD VSS VSS gf180mcu_as_sc_mcu7t3v3__fillcap_4
XFILLER_222_321 VDD VDD VSS VSS gf180mcu_as_sc_mcu7t3v3__fill_2
XFILLER_228_1145 VDD VDD VSS VSS gf180mcu_as_sc_mcu7t3v3__fillcap_4
XPHY_EDGE_ROW_75_2_Left_516 VDD VSS gf180mcu_as_sc_mcu7t3v3__tap_2
X_5822_ VDD VDD VSS VSS _5862_/S _5822_/B _6511_/Q _5823_/C gf180mcu_as_sc_mcu7t3v3__mux2_2
XFILLER_179_269 VDD VDD VSS VSS gf180mcu_as_sc_mcu7t3v3__fillcap_8
XFILLER_210_527 VDD VDD VSS VSS gf180mcu_as_sc_mcu7t3v3__fillcap_16
X_5753_ VDD VDD VSS VSS _5753_/A _5802_/B _5753_/C _5753_/D _5754_/B gf180mcu_as_sc_mcu7t3v3__ao211_2
XFILLER_163_1170 VDD VDD VSS VSS gf180mcu_as_sc_mcu7t3v3__fillcap_16
XFILLER_163_1192 VDD VDD VSS VSS gf180mcu_as_sc_mcu7t3v3__fillcap_16
X_4704_ VDD VDD VSS VSS _4795_/B _5719_/A _4705_/D gf180mcu_as_sc_mcu7t3v3__and2_2
XFILLER_148_645 VDD VDD VSS VSS gf180mcu_as_sc_mcu7t3v3__fillcap_8
X_5684_ VDD VDD VSS VSS _5684_/A _5800_/B _5684_/C _5684_/D _5686_/C gf180mcu_as_sc_mcu7t3v3__ao211_2
XFILLER_163_626 VDD VDD VSS VSS gf180mcu_as_sc_mcu7t3v3__fillcap_4
X_4635_ VDD VDD VSS VSS _5351_/B _4635_/B _4986_/A gf180mcu_as_sc_mcu7t3v3__nand2_2
XFILLER_118_27 VDD VDD VSS VSS gf180mcu_as_sc_mcu7t3v3__fillcap_8
XFILLER_194_1119 VDD VDD VSS VSS gf180mcu_as_sc_mcu7t3v3__fillcap_16
X_4566_ VDD VDD VSS VSS _4603_/A _4566_/A _4583_/B gf180mcu_as_sc_mcu7t3v3__and2_2
XFILLER_118_49 VDD VDD VSS VSS gf180mcu_as_sc_mcu7t3v3__fill_2
XFILLER_190_478 VDD VDD VSS VSS gf180mcu_as_sc_mcu7t3v3__fill_2
X_6305_ VDD VDD VSS VSS clkload9/A _6305_/D _6305_/Q gf180mcu_as_sc_mcu7t3v3__dfxtp_2
X_3517_ VDD VDD VSS VSS _4627_/C _4272_/A _5944_/A gf180mcu_as_sc_mcu7t3v3__nor2b_2
X_4497_ VDD VDD VSS VSS _4497_/A _4512_/S _4499_/C _4497_/D _4498_/C gf180mcu_as_sc_mcu7t3v3__ao22_2
X_6236_ VDD VDD VSS VSS _6316_/CLK _6236_/D _6236_/Q gf180mcu_as_sc_mcu7t3v3__dfxtp_2
X_3448_ VDD VDD VSS VSS _6550_/D _3456_/B _6329_/Q _6328_/D gf180mcu_as_sc_mcu7t3v3__mux2_2
XFILLER_134_37 VDD VDD VSS VSS gf180mcu_as_sc_mcu7t3v3__fillcap_8
XPHY_EDGE_ROW_59_1_Right_631 VDD VSS gf180mcu_as_sc_mcu7t3v3__tap_2
X_6167_ VDD VDD VSS VSS _6526_/CLK _6167_/D _6167_/Q gf180mcu_as_sc_mcu7t3v3__dfxtp_2
X_3379_ VDD VDD VSS VSS _4539_/A _6271_/Q _3434_/A _4509_/A _3387_/C gf180mcu_as_sc_mcu7t3v3__ao211_2
XFILLER_217_104 VDD VDD VSS VSS gf180mcu_as_sc_mcu7t3v3__fillcap_4
X_5118_ VDD VDD VSS VSS _5228_/S _5779_/A _5118_/A _5119_/B gf180mcu_as_sc_mcu7t3v3__mux2_2
XFILLER_218_638 VDD VDD VSS VSS gf180mcu_as_sc_mcu7t3v3__fill_2
X_6098_ VDD VDD VSS VSS _6371_/CLK _6098_/D _6098_/Q gf180mcu_as_sc_mcu7t3v3__dfxtp_2
XTAP_TAPCELL_ROW_205_2436 VDD VSS gf180mcu_as_sc_mcu7t3v3__tap_2
XTAP_TAPCELL_ROW_205_2425 VDD VSS gf180mcu_as_sc_mcu7t3v3__tap_2
X_5049_ VDD VDD VSS VSS _6498_/Q _5086_/B _5049_/C _5049_/D _5051_/C gf180mcu_as_sc_mcu7t3v3__ao22_2
XFILLER_150_69 VDD VDD VSS VSS gf180mcu_as_sc_mcu7t3v3__fillcap_16
XFILLER_213_310 VDD VDD VSS VSS gf180mcu_as_sc_mcu7t3v3__fill_2
XFILLER_214_811 VDD VDD VSS VSS gf180mcu_as_sc_mcu7t3v3__fill_1
XFILLER_0_1260 VDD VDD VSS VSS gf180mcu_as_sc_mcu7t3v3__fillcap_4
XFILLER_168_1081 VDD VDD VSS VSS gf180mcu_as_sc_mcu7t3v3__fillcap_4
XFILLER_214_877 VDD VDD VSS VSS gf180mcu_as_sc_mcu7t3v3__fillcap_8
XFILLER_13_448 VDD VDD VSS VSS gf180mcu_as_sc_mcu7t3v3__fillcap_16
XFILLER_201_516 VDD VDD VSS VSS gf180mcu_as_sc_mcu7t3v3__fillcap_4
XFILLER_139_612 VDD VDD VSS VSS gf180mcu_as_sc_mcu7t3v3__fill_1
XFILLER_142_1210 VDD VDD VSS VSS gf180mcu_as_sc_mcu7t3v3__fillcap_16
XFILLER_185_239 VDD VDD VSS VSS gf180mcu_as_sc_mcu7t3v3__fillcap_16
XTAP_TAPCELL_ROW_179_1970 VDD VSS gf180mcu_as_sc_mcu7t3v3__tap_2
XFILLER_166_453 VDD VDD VSS VSS gf180mcu_as_sc_mcu7t3v3__fill_2
XFILLER_167_965 VDD VDD VSS VSS gf180mcu_as_sc_mcu7t3v3__fillcap_4
XFILLER_182_913 VDD VDD VSS VSS gf180mcu_as_sc_mcu7t3v3__fill_1
XTAP_TAPCELL_ROW_175_1889 VDD VSS gf180mcu_as_sc_mcu7t3v3__tap_2
XFILLER_153_136 VDD VDD VSS VSS gf180mcu_as_sc_mcu7t3v3__fillcap_4
XFILLER_175_22 VDD VDD VSS VSS gf180mcu_as_sc_mcu7t3v3__fillcap_16
XFILLER_153_158 VDD VDD VSS VSS gf180mcu_as_sc_mcu7t3v3__fillcap_16
XFILLER_175_1030 VDD VDD VSS VSS gf180mcu_as_sc_mcu7t3v3__fillcap_16
XFILLER_181_456 VDD VDD VSS VSS gf180mcu_as_sc_mcu7t3v3__fillcap_4
XPHY_EDGE_ROW_189_Left_417 VDD VSS gf180mcu_as_sc_mcu7t3v3__tap_2
XTAP_TAPCELL_ROW_42_2_2911 VDD VSS gf180mcu_as_sc_mcu7t3v3__tap_2
XFILLER_175_1052 VDD VDD VSS VSS gf180mcu_as_sc_mcu7t3v3__fillcap_16
XFILLER_175_88 VDD VDD VSS VSS gf180mcu_as_sc_mcu7t3v3__fillcap_16
XFILLER_1_842 VDD VDD VSS VSS gf180mcu_as_sc_mcu7t3v3__fillcap_8
XFILLER_191_43 VDD VDD VSS VSS gf180mcu_as_sc_mcu7t3v3__fillcap_16
Xinput220 VDD VDD VSS VSS se_in[32] _5940_/A gf180mcu_as_sc_mcu7t3v3__buff_12
Xinput231 VDD VDD VSS VSS south_in[0] _5675_/D gf180mcu_as_sc_mcu7t3v3__buff_12
Xinput242 VDD VDD VSS VSS south_in[1] _5683_/A gf180mcu_as_sc_mcu7t3v3__buff_12
Xinput253 VDD VDD VSS VSS south_in[2] _5691_/A gf180mcu_as_sc_mcu7t3v3__buff_12
XFILLER_76_665 VDD VDD VSS VSS gf180mcu_as_sc_mcu7t3v3__fill_2
Xinput264 VDD VDD VSS VSS south_in[7] _5733_/A gf180mcu_as_sc_mcu7t3v3__buff_12
Xinput275 VDD VDD VSS VSS sw_in[17] _5819_/A gf180mcu_as_sc_mcu7t3v3__buff_12
Xinput286 VDD VDD VSS VSS sw_in[27] _5901_/A gf180mcu_as_sc_mcu7t3v3__buff_12
Xinput297 VDD VDD VSS VSS sw_in[4] _5712_/A gf180mcu_as_sc_mcu7t3v3__buff_12
XPHY_EDGE_ROW_198_Left_426 VDD VSS gf180mcu_as_sc_mcu7t3v3__tap_2
XFILLER_189_512 VDD VDD VSS VSS gf180mcu_as_sc_mcu7t3v3__fillcap_4
XFILLER_1_1046 VDD VDD VSS VSS gf180mcu_as_sc_mcu7t3v3__fillcap_4
XFILLER_217_671 VDD VDD VSS VSS gf180mcu_as_sc_mcu7t3v3__fill_2
XFILLER_1_1068 VDD VDD VSS VSS gf180mcu_as_sc_mcu7t3v3__fillcap_16
XTAP_TAPCELL_ROW_2_1052 VDD VSS gf180mcu_as_sc_mcu7t3v3__tap_2
XTAP_TAPCELL_ROW_2_1041 VDD VSS gf180mcu_as_sc_mcu7t3v3__tap_2
XFILLER_189_578 VDD VDD VSS VSS gf180mcu_as_sc_mcu7t3v3__fillcap_16
XFILLER_205_888 VDD VDD VSS VSS gf180mcu_as_sc_mcu7t3v3__fillcap_16
XPHY_EDGE_ROW_21_1_Right_593 VDD VSS gf180mcu_as_sc_mcu7t3v3__tap_2
XFILLER_13_960 VDD VDD VSS VSS gf180mcu_as_sc_mcu7t3v3__fillcap_16
XFILLER_12_481 VDD VDD VSS VSS gf180mcu_as_sc_mcu7t3v3__fill_2
XFILLER_13_982 VDD VDD VSS VSS gf180mcu_as_sc_mcu7t3v3__fillcap_16
XFILLER_145_604 VDD VDD VSS VSS gf180mcu_as_sc_mcu7t3v3__fillcap_8
XFILLER_157_475 VDD VDD VSS VSS gf180mcu_as_sc_mcu7t3v3__fill_2
XFILLER_191_209 VDD VDD VSS VSS gf180mcu_as_sc_mcu7t3v3__fill_1
XFILLER_8_452 VDD VDD VSS VSS gf180mcu_as_sc_mcu7t3v3__fill_2
X_4420_ VDD VDD VSS VSS _6236_/Q _4422_/B _4425_/C _6235_/Q _6235_/D gf180mcu_as_sc_mcu7t3v3__ao22_2
XFILLER_119_1234 VDD VDD VSS VSS gf180mcu_as_sc_mcu7t3v3__fillcap_4
XFILLER_154_1103 VDD VDD VSS VSS gf180mcu_as_sc_mcu7t3v3__fillcap_16
XFILLER_158_1250 VDD VDD VSS VSS gf180mcu_as_sc_mcu7t3v3__fillcap_8
X_4351_ VDD VDD VSS VSS _4353_/A _4351_/C _4400_/B _6153_/Q gf180mcu_as_sc_mcu7t3v3__aoi21_2
X_4282_ VDD VDD VSS VSS _6208_/Q _4406_/B _4406_/C _6209_/Q _4283_/D gf180mcu_as_sc_mcu7t3v3__ao22_2
X_3302_ VDD VDD VSS VSS _3326_/S _6533_/Q _6542_/Q _3303_/B gf180mcu_as_sc_mcu7t3v3__mux2_2
X_6021_ VDD VDD VSS VSS _6525_/CLK _6021_/D _6021_/Q gf180mcu_as_sc_mcu7t3v3__dfxtp_2
X_3233_ VDD VDD VSS VSS _4445_/S _4610_/B _3280_/C gf180mcu_as_sc_mcu7t3v3__and2_2
XTAP_TAPCELL_ROW_181_2005 VDD VSS gf180mcu_as_sc_mcu7t3v3__tap_2
X_3164_ VDD VDD VSS VSS _3165_/C _3372_/B gf180mcu_as_sc_mcu7t3v3__inv_2
X_3095_ VDD VDD VSS VSS _4493_/A _6153_/Q gf180mcu_as_sc_mcu7t3v3__inv_2
XFILLER_214_107 VDD VDD VSS VSS gf180mcu_as_sc_mcu7t3v3__fillcap_16
XFILLER_223_652 VDD VDD VSS VSS gf180mcu_as_sc_mcu7t3v3__fill_2
XTAP_TAPCELL_ROW_200_2333 VDD VSS gf180mcu_as_sc_mcu7t3v3__tap_2
XFILLER_223_685 VDD VDD VSS VSS gf180mcu_as_sc_mcu7t3v3__fill_2
XTAP_TAPCELL_ROW_200_2344 VDD VSS gf180mcu_as_sc_mcu7t3v3__tap_2
X_5805_ VDD VDD VSS VSS _5864_/B _5805_/A _5808_/C gf180mcu_as_sc_mcu7t3v3__and2_2
X_3997_ VDD VDD VSS VSS _4034_/B _4002_/B _4002_/C _6085_/Q _6085_/D gf180mcu_as_sc_mcu7t3v3__ao22_2
XTAP_TAPCELL_ROW_196_2270 VDD VSS gf180mcu_as_sc_mcu7t3v3__tap_2
XFILLER_149_954 VDD VDD VSS VSS gf180mcu_as_sc_mcu7t3v3__fillcap_16
XFILLER_195_559 VDD VDD VSS VSS gf180mcu_as_sc_mcu7t3v3__fill_1
XFILLER_50_598 VDD VDD VSS VSS gf180mcu_as_sc_mcu7t3v3__fill_1
X_5736_ VDD VDD VSS VSS _5736_/A _5858_/B _5736_/C _5736_/D _5737_/B gf180mcu_as_sc_mcu7t3v3__ao211_2
XFILLER_136_626 VDD VDD VSS VSS gf180mcu_as_sc_mcu7t3v3__fill_1
XTAP_TAPCELL_ROW_157_1564 VDD VSS gf180mcu_as_sc_mcu7t3v3__tap_2
XTAP_TAPCELL_ROW_157_1575 VDD VSS gf180mcu_as_sc_mcu7t3v3__tap_2
X_5667_ VDD VDD VSS VSS _5667_/A _5668_/B _5667_/C _5667_/Y gf180mcu_as_sc_mcu7t3v3__nor3_2
XTAP_TAPCELL_ROW_192_2189 VDD VSS gf180mcu_as_sc_mcu7t3v3__tap_2
XFILLER_159_1014 VDD VDD VSS VSS gf180mcu_as_sc_mcu7t3v3__fillcap_16
X_4618_ VDD VDD VSS VSS _4619_/A _4619_/B _4619_/C _4977_/D _4619_/D gf180mcu_as_sc_mcu7t3v3__aoi211_2
XFILLER_11_1154 VDD VDD VSS VSS gf180mcu_as_sc_mcu7t3v3__fillcap_16
XFILLER_190_242 VDD VDD VSS VSS gf180mcu_as_sc_mcu7t3v3__fill_2
XPHY_EDGE_ROW_149_Right_17 VDD VSS gf180mcu_as_sc_mcu7t3v3__tap_2
Xclkbuf_leaf_19_clk_regs VDD VDD VSS VSS clkbuf_3_4_0_clk_regs/Y _6519_/CLK gf180mcu_as_sc_mcu7t3v3__clkbuff_12
X_5598_ VDD VDD VSS VSS _5907_/A _5630_/B _5598_/C _5598_/D _5600_/C gf180mcu_as_sc_mcu7t3v3__ao211_2
XFILLER_163_489 VDD VDD VSS VSS gf180mcu_as_sc_mcu7t3v3__fill_1
X_4549_ VDD VDD VSS VSS _6304_/Q _4552_/B _4551_/C _6303_/Q _4550_/C gf180mcu_as_sc_mcu7t3v3__ao22_2
XFILLER_150_139 VDD VDD VSS VSS gf180mcu_as_sc_mcu7t3v3__fillcap_16
XPHY_EDGE_ROW_211_Left_439 VDD VSS gf180mcu_as_sc_mcu7t3v3__tap_2
XTAP_TAPCELL_ROW_170_1797 VDD VSS gf180mcu_as_sc_mcu7t3v3__tap_2
Xfanout910 VDD VDD VSS VSS _4362_/A _4363_/S gf180mcu_as_sc_mcu7t3v3__buff_12
Xfanout932 VDD VDD VSS VSS fanout935/Y _5956_/A gf180mcu_as_sc_mcu7t3v3__buff_12
X_6219_ VDD VDD VSS VSS _6506_/CLK _6219_/D _6219_/Q gf180mcu_as_sc_mcu7t3v3__dfxtp_2
XFILLER_38_45 VDD VDD VSS VSS gf180mcu_as_sc_mcu7t3v3__fillcap_4
Xfanout954 VDD VDD VSS VSS _5950_/D _4977_/A gf180mcu_as_sc_mcu7t3v3__buff_12
Xfanout965 VDD VDD VSS VSS input5/Y fanout965/Y gf180mcu_as_sc_mcu7t3v3__buff_12
XFILLER_218_446 VDD VDD VSS VSS gf180mcu_as_sc_mcu7t3v3__fill_2
XTAP_TAPCELL_ROW_16_1295 VDD VSS gf180mcu_as_sc_mcu7t3v3__tap_2
XFILLER_22_1261 VDD VDD VSS VSS gf180mcu_as_sc_mcu7t3v3__fillcap_4
XTAP_TAPCELL_ROW_220_2709 VDD VSS gf180mcu_as_sc_mcu7t3v3__tap_2
XFILLER_166_1007 VDD VDD VSS VSS gf180mcu_as_sc_mcu7t3v3__fillcap_8
XPHY_EDGE_ROW_158_Right_26 VDD VSS gf180mcu_as_sc_mcu7t3v3__tap_2
Xhold1196 VDD VDD VSS VSS hold1221/Y _6546_/D gf180mcu_as_sc_mcu7t3v3__clkbuff_4
XFILLER_14_702 VDD VDD VSS VSS gf180mcu_as_sc_mcu7t3v3__fill_1
XFILLER_199_854 VDD VDD VSS VSS gf180mcu_as_sc_mcu7t3v3__fillcap_4
XFILLER_54_33 VDD VDD VSS VSS gf180mcu_as_sc_mcu7t3v3__fill_2
XPHY_EDGE_ROW_220_Left_448 VDD VSS gf180mcu_as_sc_mcu7t3v3__tap_2
XTAP_TAPCELL_ROW_66_3_2948 VDD VSS gf180mcu_as_sc_mcu7t3v3__tap_2
XFILLER_0_1090 VDD VDD VSS VSS gf180mcu_as_sc_mcu7t3v3__fill_2
XFILLER_13_212 VDD VDD VSS VSS gf180mcu_as_sc_mcu7t3v3__fillcap_16
XFILLER_14_768 VDD VDD VSS VSS gf180mcu_as_sc_mcu7t3v3__fill_1
XFILLER_9_205 VDD VDD VSS VSS gf180mcu_as_sc_mcu7t3v3__fillcap_4
XTAP_TAPCELL_ROW_177_1929 VDD VSS gf180mcu_as_sc_mcu7t3v3__tap_2
XFILLER_41_598 VDD VDD VSS VSS gf180mcu_as_sc_mcu7t3v3__fill_2
XFILLER_70_32 VDD VDD VSS VSS gf180mcu_as_sc_mcu7t3v3__fill_2
XFILLER_10_941 VDD VDD VSS VSS gf180mcu_as_sc_mcu7t3v3__fillcap_4
XFILLER_10_963 VDD VDD VSS VSS gf180mcu_as_sc_mcu7t3v3__fillcap_16
XFILLER_16_1076 VDD VDD VSS VSS gf180mcu_as_sc_mcu7t3v3__fillcap_8
XFILLER_173_209 VDD VDD VSS VSS gf180mcu_as_sc_mcu7t3v3__fill_1
XFILLER_127_626 VDD VDD VSS VSS gf180mcu_as_sc_mcu7t3v3__fillcap_16
XFILLER_220_1259 VDD VDD VSS VSS gf180mcu_as_sc_mcu7t3v3__fillcap_4
XFILLER_5_422 VDD VDD VSS VSS gf180mcu_as_sc_mcu7t3v3__fillcap_4
XFILLER_6_934 VDD VDD VSS VSS gf180mcu_as_sc_mcu7t3v3__fillcap_8
XPHY_EDGE_ROW_167_Right_35 VDD VSS gf180mcu_as_sc_mcu7t3v3__tap_2
Xclkload19 VDD VDD VSS VSS _6370_/CLK clkload19/Y gf180mcu_as_sc_mcu7t3v3__clkbuff_12
XFILLER_155_979 VDD VDD VSS VSS gf180mcu_as_sc_mcu7t3v3__fill_1
XFILLER_142_629 VDD VDD VSS VSS gf180mcu_as_sc_mcu7t3v3__fillcap_8
XFILLER_209_424 VDD VDD VSS VSS gf180mcu_as_sc_mcu7t3v3__fill_1
XFILLER_188_1221 VDD VDD VSS VSS gf180mcu_as_sc_mcu7t3v3__fillcap_4
XFILLER_188_1243 VDD VDD VSS VSS gf180mcu_as_sc_mcu7t3v3__fillcap_8
XFILLER_225_906 VDD VDD VSS VSS gf180mcu_as_sc_mcu7t3v3__fillcap_4
XPHY_EDGE_ROW_176_Right_44 VDD VSS gf180mcu_as_sc_mcu7t3v3__tap_2
XFILLER_149_1249 VDD VDD VSS VSS gf180mcu_as_sc_mcu7t3v3__fillcap_8
XFILLER_205_652 VDD VDD VSS VSS gf180mcu_as_sc_mcu7t3v3__fillcap_4
X_3920_ VDD VDD VSS VSS _5899_/A _3929_/B _3920_/C _3920_/D _3921_/D gf180mcu_as_sc_mcu7t3v3__ao211_2
XFILLER_149_206 VDD VDD VSS VSS gf180mcu_as_sc_mcu7t3v3__fillcap_16
XPHY_EDGE_ROW_22_1_Right_594 VDD VSS gf180mcu_as_sc_mcu7t3v3__tap_2
X_3851_ VDD VDD VSS VSS _3851_/B _5840_/A _3852_/D gf180mcu_as_sc_mcu7t3v3__and2_2
XFILLER_177_559 VDD VDD VSS VSS gf180mcu_as_sc_mcu7t3v3__fill_1
X_3782_ VDD VDD VSS VSS _6028_/Q _3895_/B _4036_/B _3895_/D _6028_/D gf180mcu_as_sc_mcu7t3v3__ao22_2
XFILLER_158_762 VDD VDD VSS VSS gf180mcu_as_sc_mcu7t3v3__fill_2
XFILLER_160_1151 VDD VDD VSS VSS gf180mcu_as_sc_mcu7t3v3__fillcap_4
XFILLER_160_1173 VDD VDD VSS VSS gf180mcu_as_sc_mcu7t3v3__fillcap_16
XFILLER_173_710 VDD VDD VSS VSS gf180mcu_as_sc_mcu7t3v3__fillcap_4
XFILLER_74_2 VDD VDD VSS VSS gf180mcu_as_sc_mcu7t3v3__fillcap_4
XFILLER_9_772 VDD VDD VSS VSS gf180mcu_as_sc_mcu7t3v3__fill_2
XPHY_EDGE_ROW_185_Right_53 VDD VSS gf180mcu_as_sc_mcu7t3v3__tap_2
X_5521_ VDD VDD VSS VSS _5521_/B _5643_/A _6431_/D gf180mcu_as_sc_mcu7t3v3__and2_2
XFILLER_118_637 VDD VDD VSS VSS gf180mcu_as_sc_mcu7t3v3__fill_2
XFILLER_201_1170 VDD VDD VSS VSS gf180mcu_as_sc_mcu7t3v3__fillcap_16
X_5452_ VDD VDD VSS VSS _5759_/A _5637_/B _5639_/B _5452_/D _5454_/C gf180mcu_as_sc_mcu7t3v3__ao211_2
XFILLER_201_1192 VDD VDD VSS VSS gf180mcu_as_sc_mcu7t3v3__fillcap_16
XTAP_TAPCELL_ROW_152_1472 VDD VSS gf180mcu_as_sc_mcu7t3v3__tap_2
X_5383_ VDD VDD VSS VSS _5384_/D _5691_/A _5491_/B _5383_/C gf180mcu_as_sc_mcu7t3v3__ao21_2
X_4403_ VDD VDD VSS VSS _4404_/C _4405_/S _6039_/Q gf180mcu_as_sc_mcu7t3v3__nor2b_2
XTAP_TAPCELL_ROW_152_1483 VDD VSS gf180mcu_as_sc_mcu7t3v3__tap_2
X_4334_ VDD VDD VSS VSS _4335_/S _6116_/Q _4334_/C _4348_/D _4338_/C gf180mcu_as_sc_mcu7t3v3__ao211_2
XFILLER_228_711 VDD VDD VSS VSS gf180mcu_as_sc_mcu7t3v3__fill_2
XFILLER_99_598 VDD VDD VSS VSS gf180mcu_as_sc_mcu7t3v3__fill_1
X_6004_ VDD VDD VSS VSS _6011_/B _6195_/Q _6517_/D gf180mcu_as_sc_mcu7t3v3__and2_2
X_4265_ VDD VDD VSS VSS _4281_/B _6157_/Q _4267_/C gf180mcu_as_sc_mcu7t3v3__or2_2
XFILLER_132_1242 VDD VDD VSS VSS gf180mcu_as_sc_mcu7t3v3__fill_1
XPHY_EDGE_ROW_194_Right_62 VDD VSS gf180mcu_as_sc_mcu7t3v3__tap_2
XPHY_EDGE_ROW_19_2_Left_460 VDD VSS gf180mcu_as_sc_mcu7t3v3__tap_2
X_4196_ VDD VDD VSS VSS _4196_/B _6197_/Q _4197_/A gf180mcu_as_sc_mcu7t3v3__xnor2_2
X_3216_ VDD VDD VSS VSS _6335_/Q _3281_/D _3216_/C _3216_/D _3217_/B gf180mcu_as_sc_mcu7t3v3__ao22_2
X_3147_ VDD VDD VSS VSS _4475_/B _6306_/Q _4462_/B gf180mcu_as_sc_mcu7t3v3__or2_2
XFILLER_131_27 VDD VDD VSS VSS gf180mcu_as_sc_mcu7t3v3__fillcap_16
XTAP_TAPCELL_ROW_198_2310 VDD VSS gf180mcu_as_sc_mcu7t3v3__tap_2
XFILLER_199_139 VDD VDD VSS VSS gf180mcu_as_sc_mcu7t3v3__fill_1
XFILLER_227_298 VDD VDD VSS VSS gf180mcu_as_sc_mcu7t3v3__fill_2
X_3078_ VDD VDD VSS VSS _5159_/A _5814_/B gf180mcu_as_sc_mcu7t3v3__inv_2
XPHY_EDGE_ROW_31_3_Left_736 VDD VSS gf180mcu_as_sc_mcu7t3v3__tap_2
XFILLER_165_1084 VDD VDD VSS VSS gf180mcu_as_sc_mcu7t3v3__fillcap_16
XTAP_TAPCELL_ROW_159_1604 VDD VSS gf180mcu_as_sc_mcu7t3v3__tap_2
XTAP_TAPCELL_ROW_194_2229 VDD VSS gf180mcu_as_sc_mcu7t3v3__tap_2
XFILLER_211_655 VDD VDD VSS VSS gf180mcu_as_sc_mcu7t3v3__fill_2
XFILLER_52_1210 VDD VDD VSS VSS gf180mcu_as_sc_mcu7t3v3__fillcap_8
XFILLER_109_615 VDD VDD VSS VSS gf180mcu_as_sc_mcu7t3v3__fill_2
XFILLER_206_1081 VDD VDD VSS VSS gf180mcu_as_sc_mcu7t3v3__fillcap_4
XTAP_TAPCELL_ROW_172_1837 VDD VSS gf180mcu_as_sc_mcu7t3v3__tap_2
X_5719_ VDD VDD VSS VSS _5719_/A _5802_/C _5719_/C _5719_/D _5720_/C gf180mcu_as_sc_mcu7t3v3__ao211_2
XFILLER_163_220 VDD VDD VSS VSS gf180mcu_as_sc_mcu7t3v3__fill_2
XFILLER_124_629 VDD VDD VSS VSS gf180mcu_as_sc_mcu7t3v3__fill_1
XFILLER_151_415 VDD VDD VSS VSS gf180mcu_as_sc_mcu7t3v3__fillcap_4
XFILLER_151_426 VDD VDD VSS VSS gf180mcu_as_sc_mcu7t3v3__fill_2
XFILLER_152_927 VDD VDD VSS VSS gf180mcu_as_sc_mcu7t3v3__fill_1
XFILLER_163_275 VDD VDD VSS VSS gf180mcu_as_sc_mcu7t3v3__fillcap_4
XTAP_TAPCELL_ROW_213_2579 VDD VSS gf180mcu_as_sc_mcu7t3v3__tap_2
XTAP_TAPCELL_ROW_213_2568 VDD VSS gf180mcu_as_sc_mcu7t3v3__tap_2
XFILLER_172_1033 VDD VDD VSS VSS gf180mcu_as_sc_mcu7t3v3__fillcap_16
XFILLER_2_469 VDD VDD VSS VSS gf180mcu_as_sc_mcu7t3v3__fillcap_16
XFILLER_160_993 VDD VDD VSS VSS gf180mcu_as_sc_mcu7t3v3__fillcap_16
XFILLER_172_34 VDD VDD VSS VSS gf180mcu_as_sc_mcu7t3v3__fill_1
Xfanout740 VDD VDD VSS VSS _5361_/Y _5549_/B gf180mcu_as_sc_mcu7t3v3__buff_12
XFILLER_213_1030 VDD VDD VSS VSS gf180mcu_as_sc_mcu7t3v3__fillcap_16
XFILLER_213_1052 VDD VDD VSS VSS gf180mcu_as_sc_mcu7t3v3__fillcap_16
Xfanout762 VDD VDD VSS VSS _5631_/B _5638_/B gf180mcu_as_sc_mcu7t3v3__buff_12
Xfanout773 VDD VDD VSS VSS _5303_/S _5297_/A gf180mcu_as_sc_mcu7t3v3__buff_12
Xfanout784 VDD VDD VSS VSS _4930_/B _4896_/A gf180mcu_as_sc_mcu7t3v3__buff_12
XFILLER_219_755 VDD VDD VSS VSS gf180mcu_as_sc_mcu7t3v3__fill_2
Xfanout795 VDD VDD VSS VSS _4425_/C _4583_/D gf180mcu_as_sc_mcu7t3v3__buff_12
XFILLER_207_928 VDD VDD VSS VSS gf180mcu_as_sc_mcu7t3v3__fillcap_16
XFILLER_14_521 VDD VDD VSS VSS gf180mcu_as_sc_mcu7t3v3__fillcap_4
XFILLER_14_543 VDD VDD VSS VSS gf180mcu_as_sc_mcu7t3v3__fillcap_8
XPHY_EDGE_ROW_88_3_Left_793 VDD VSS gf180mcu_as_sc_mcu7t3v3__tap_2
XFILLER_202_655 VDD VDD VSS VSS gf180mcu_as_sc_mcu7t3v3__fillcap_8
XFILLER_10_760 VDD VDD VSS VSS gf180mcu_as_sc_mcu7t3v3__fill_2
XFILLER_155_765 VDD VDD VSS VSS gf180mcu_as_sc_mcu7t3v3__fillcap_4
XFILLER_6_753 VDD VDD VSS VSS gf180mcu_as_sc_mcu7t3v3__fill_2
XPHY_EDGE_ROW_147_2_Left_588 VDD VSS gf180mcu_as_sc_mcu7t3v3__tap_2
XFILLER_115_618 VDD VDD VSS VSS gf180mcu_as_sc_mcu7t3v3__fill_2
XFILLER_68_1261 VDD VDD VSS VSS gf180mcu_as_sc_mcu7t3v3__fillcap_4
XPHY_EDGE_ROW_84_2_Left_525 VDD VSS gf180mcu_as_sc_mcu7t3v3__tap_2
XFILLER_151_982 VDD VDD VSS VSS gf180mcu_as_sc_mcu7t3v3__fillcap_16
XFILLER_155_1264 VDD VDD VSS VSS gf180mcu_as_sc_mcu7t3v3__fill_1
XFILLER_116_1226 VDD VDD VSS VSS gf180mcu_as_sc_mcu7t3v3__fillcap_16
XFILLER_7_1030 VDD VDD VSS VSS gf180mcu_as_sc_mcu7t3v3__fillcap_16
XFILLER_7_1052 VDD VDD VSS VSS gf180mcu_as_sc_mcu7t3v3__fillcap_16
X_4050_ VDD VDD VSS VSS _4060_/B _6124_/Q _4051_/D gf180mcu_as_sc_mcu7t3v3__and2_2
Xinput6 VDD VDD VSS VSS TILE_ID[5] input6/Y gf180mcu_as_sc_mcu7t3v3__buff_12
Xmesh_tile_1172 VDD VDD VSS VSS sw_out[23] gf180mcu_as_sc_mcu7t3v3__tiel_4
Xmesh_tile_1161 VDD VDD VSS VSS sw_out[12] gf180mcu_as_sc_mcu7t3v3__tiel_4
Xmesh_tile_1150 VDD VDD VSS VSS sw_out[1] gf180mcu_as_sc_mcu7t3v3__tiel_4
Xmesh_tile_1183 VDD VDD VSS VSS sw_out[34] gf180mcu_as_sc_mcu7t3v3__tiel_4
XFILLER_75_1210 VDD VDD VSS VSS gf180mcu_as_sc_mcu7t3v3__fill_2
X_4952_ VDD VDD VSS VSS _4959_/B _5301_/A _4954_/C gf180mcu_as_sc_mcu7t3v3__and2_2
XFILLER_205_482 VDD VDD VSS VSS gf180mcu_as_sc_mcu7t3v3__fillcap_8
X_4883_ VDD VDD VSS VSS _6012_/A _4883_/A _4883_/B _4883_/C _4884_/C gf180mcu_as_sc_mcu7t3v3__ao31_2
X_3903_ VDD VDD VSS VSS _5883_/A _3912_/B _3903_/C _3903_/D _4057_/B gf180mcu_as_sc_mcu7t3v3__ao211_2
X_3834_ VDD VDD VSS VSS _5823_/A _3925_/C _3834_/C _3834_/D _3836_/C gf180mcu_as_sc_mcu7t3v3__ao211_2
XFILLER_203_1232 VDD VDD VSS VSS gf180mcu_as_sc_mcu7t3v3__fill_2
XPHY_EDGE_ROW_23_1_Right_595 VDD VSS gf180mcu_as_sc_mcu7t3v3__tap_2
XTAP_TAPCELL_ROW_154_1512 VDD VSS gf180mcu_as_sc_mcu7t3v3__tap_2
X_3765_ VDD VDD VSS VSS _3888_/B _5764_/A _3766_/D gf180mcu_as_sc_mcu7t3v3__and2_2
X_6484_ VDD VDD VSS VSS _6484_/CLK _6484_/D _6484_/Q gf180mcu_as_sc_mcu7t3v3__dfxtp_2
X_5504_ VDD VDD VSS VSS _5568_/C _5810_/A _5505_/D gf180mcu_as_sc_mcu7t3v3__and2_2
X_3696_ VDD VDD VSS VSS _3696_/B _4053_/A _4023_/B gf180mcu_as_sc_mcu7t3v3__and2_2
XFILLER_106_629 VDD VDD VSS VSS gf180mcu_as_sc_mcu7t3v3__fillcap_8
XFILLER_10_27 VDD VDD VSS VSS gf180mcu_as_sc_mcu7t3v3__fillcap_8
XFILLER_161_702 VDD VDD VSS VSS gf180mcu_as_sc_mcu7t3v3__fillcap_16
XFILLER_173_562 VDD VDD VSS VSS gf180mcu_as_sc_mcu7t3v3__fillcap_8
X_5435_ VDD VDD VSS VSS _5436_/D _5551_/B _5739_/A gf180mcu_as_sc_mcu7t3v3__nand2b_2
XFILLER_126_27 VDD VDD VSS VSS gf180mcu_as_sc_mcu7t3v3__fillcap_8
XFILLER_156_1017 VDD VDD VSS VSS gf180mcu_as_sc_mcu7t3v3__fillcap_16
Xoutput343 VDD VDD VSS VSS _6719_/Y dft_rdata[4] gf180mcu_as_sc_mcu7t3v3__buff_12
XFILLER_126_49 VDD VDD VSS VSS gf180mcu_as_sc_mcu7t3v3__fill_2
Xoutput387 VDD VDD VSS VSS _6354_/Q north_out[13] gf180mcu_as_sc_mcu7t3v3__buff_12
Xoutput376 VDD VDD VSS VSS _6416_/Q east_out[3] gf180mcu_as_sc_mcu7t3v3__buff_12
Xoutput365 VDD VDD VSS VSS _6439_/Q east_out[26] gf180mcu_as_sc_mcu7t3v3__buff_12
Xoutput354 VDD VDD VSS VSS _6429_/Q east_out[16] gf180mcu_as_sc_mcu7t3v3__buff_12
X_5366_ VDD VDD VSS VSS _5676_/D _5565_/B _5366_/C _5366_/D _5368_/C gf180mcu_as_sc_mcu7t3v3__ao211_2
Xoutput398 VDD VDD VSS VSS _6364_/Q north_out[23] gf180mcu_as_sc_mcu7t3v3__buff_12
X_5297_ VDD VDD VSS VSS _5297_/D _5297_/A _5297_/B _5297_/C _5298_/A gf180mcu_as_sc_mcu7t3v3__ao31_2
X_4317_ VDD VDD VSS VSS _4366_/A _4317_/B _4317_/C _4318_/B _4366_/D gf180mcu_as_sc_mcu7t3v3__oai211_2
XTAP_TAPCELL_ROW_187_2099 VDD VSS gf180mcu_as_sc_mcu7t3v3__tap_2
X_4248_ VDD VDD VSS VSS _4248_/A _4280_/B _4248_/C _4280_/D _4251_/B gf180mcu_as_sc_mcu7t3v3__ao211_2
XFILLER_142_37 VDD VDD VSS VSS gf180mcu_as_sc_mcu7t3v3__fillcap_8
XFILLER_28_602 VDD VDD VSS VSS gf180mcu_as_sc_mcu7t3v3__fill_2
XTAP_TAPCELL_ROW_13_1243 VDD VSS gf180mcu_as_sc_mcu7t3v3__tap_2
XTAP_TAPCELL_ROW_13_1254 VDD VSS gf180mcu_as_sc_mcu7t3v3__tap_2
X_4179_ VDD VDD VSS VSS _5977_/B _4179_/B _4237_/B gf180mcu_as_sc_mcu7t3v3__nor2b_2
XFILLER_150_6 VDD VDD VSS VSS gf180mcu_as_sc_mcu7t3v3__fillcap_16
XFILLER_51_660 VDD VDD VSS VSS gf180mcu_as_sc_mcu7t3v3__fill_2
XFILLER_11_557 VDD VDD VSS VSS gf180mcu_as_sc_mcu7t3v3__fill_2
XFILLER_195_142 VDD VDD VSS VSS gf180mcu_as_sc_mcu7t3v3__fill_1
XFILLER_195_164 VDD VDD VSS VSS gf180mcu_as_sc_mcu7t3v3__fill_1
XPHY_EDGE_ROW_14_Right_14 VDD VSS gf180mcu_as_sc_mcu7t3v3__tap_2
Xclkbuf_leaf_34_clk_regs VDD VDD VSS VSS clkbuf_3_0_0_clk_regs/Y clkload3/A gf180mcu_as_sc_mcu7t3v3__clkbuff_12
XTAP_TAPCELL_ROW_215_2608 VDD VSS gf180mcu_as_sc_mcu7t3v3__tap_2
XFILLER_211_496 VDD VDD VSS VSS gf180mcu_as_sc_mcu7t3v3__fill_2
XTAP_TAPCELL_ROW_215_2619 VDD VSS gf180mcu_as_sc_mcu7t3v3__tap_2
XFILLER_13_1046 VDD VDD VSS VSS gf180mcu_as_sc_mcu7t3v3__fillcap_4
XFILLER_13_1068 VDD VDD VSS VSS gf180mcu_as_sc_mcu7t3v3__fillcap_16
XFILLER_167_67 VDD VDD VSS VSS gf180mcu_as_sc_mcu7t3v3__fill_2
XFILLER_151_212 VDD VDD VSS VSS gf180mcu_as_sc_mcu7t3v3__fillcap_16
XFILLER_120_610 VDD VDD VSS VSS gf180mcu_as_sc_mcu7t3v3__fillcap_16
XFILLER_120_665 VDD VDD VSS VSS gf180mcu_as_sc_mcu7t3v3__fill_2
XFILLER_19_602 VDD VDD VSS VSS gf180mcu_as_sc_mcu7t3v3__fill_1
XFILLER_98_1210 VDD VDD VSS VSS gf180mcu_as_sc_mcu7t3v3__fillcap_8
Xfanout570 VDD VDD VSS VSS _3932_/B _3912_/B gf180mcu_as_sc_mcu7t3v3__buff_12
Xfanout581 VDD VDD VSS VSS _5946_/B _5874_/B gf180mcu_as_sc_mcu7t3v3__buff_12
Xfanout592 VDD VDD VSS VSS wire597/Y _5538_/B gf180mcu_as_sc_mcu7t3v3__buff_12
XFILLER_19_657 VDD VDD VSS VSS gf180mcu_as_sc_mcu7t3v3__fill_1
XFILLER_185_1224 VDD VDD VSS VSS gf180mcu_as_sc_mcu7t3v3__fillcap_8
XFILLER_206_213 VDD VDD VSS VSS gf180mcu_as_sc_mcu7t3v3__fill_1
XPHY_EDGE_ROW_171_Left_399 VDD VSS gf180mcu_as_sc_mcu7t3v3__tap_2
XFILLER_15_830 VDD VDD VSS VSS gf180mcu_as_sc_mcu7t3v3__fillcap_8
XFILLER_226_1221 VDD VDD VSS VSS gf180mcu_as_sc_mcu7t3v3__fillcap_4
XFILLER_226_1243 VDD VDD VSS VSS gf180mcu_as_sc_mcu7t3v3__fillcap_16
XFILLER_15_874 VDD VDD VSS VSS gf180mcu_as_sc_mcu7t3v3__fillcap_16
XFILLER_199_492 VDD VDD VSS VSS gf180mcu_as_sc_mcu7t3v3__fillcap_8
XTAP_TAPCELL_ROW_48_2_2920 VDD VSS gf180mcu_as_sc_mcu7t3v3__tap_2
Xwire960 VDD VDD VSS VSS wire960/A _5773_/A gf180mcu_as_sc_mcu7t3v3__clkbuff_12
X_3550_ VDD VDD VSS VSS _5327_/C _5931_/A _3631_/D gf180mcu_as_sc_mcu7t3v3__nor2_2
XFILLER_155_562 VDD VDD VSS VSS gf180mcu_as_sc_mcu7t3v3__fillcap_8
X_5220_ VDD VDD VSS VSS _5220_/B _5238_/A _6400_/D gf180mcu_as_sc_mcu7t3v3__and2_2
X_3481_ VDD VDD VSS VSS _5344_/A _5340_/A _5932_/A gf180mcu_as_sc_mcu7t3v3__nand2b_2
XFILLER_192_1239 VDD VDD VSS VSS gf180mcu_as_sc_mcu7t3v3__fill_1
X_5151_ VDD VDD VSS VSS _6509_/Q _5234_/B _5151_/C _5151_/D _5153_/C gf180mcu_as_sc_mcu7t3v3__ao22_2
X_5082_ VDD VDD VSS VSS _5748_/A _5183_/B _5139_/C _5751_/A _5084_/B gf180mcu_as_sc_mcu7t3v3__ao22_2
X_4102_ VDD VDD VSS VSS _4102_/A _4102_/B _4102_/C _4102_/D _4103_/B gf180mcu_as_sc_mcu7t3v3__nand4_2
X_4033_ VDD VDD VSS VSS _4033_/D _4043_/A _4033_/B _4061_/C _6113_/D gf180mcu_as_sc_mcu7t3v3__ao31_2
XFILLER_197_418 VDD VDD VSS VSS gf180mcu_as_sc_mcu7t3v3__fill_2
X_5984_ VDD VDD VSS VSS _6011_/B _6207_/Q _6497_/D gf180mcu_as_sc_mcu7t3v3__and2_2
XFILLER_33_660 VDD VDD VSS VSS gf180mcu_as_sc_mcu7t3v3__fill_2
X_4935_ VDD VDD VSS VSS _4950_/D _4935_/B _4935_/C _4936_/C gf180mcu_as_sc_mcu7t3v3__nor3_2
XANTENNA_11 VDD VDD VSS VSS _4698_/B gf180mcu_as_sc_mcu7t3v3__diode_2
XANTENNA_22 VDD VDD VSS VSS _5063_/A gf180mcu_as_sc_mcu7t3v3__diode_2
XFILLER_162_1065 VDD VDD VSS VSS gf180mcu_as_sc_mcu7t3v3__fillcap_16
XFILLER_221_772 VDD VDD VSS VSS gf180mcu_as_sc_mcu7t3v3__fill_1
X_4866_ VDD VDD VSS VSS _4876_/B _5861_/A _4867_/C gf180mcu_as_sc_mcu7t3v3__and2_2
XANTENNA_33 VDD VDD VSS VSS _6410_/D gf180mcu_as_sc_mcu7t3v3__diode_2
XANTENNA_44 VDD VDD VSS VSS _6406_/D gf180mcu_as_sc_mcu7t3v3__diode_2
XFILLER_162_1087 VDD VDD VSS VSS gf180mcu_as_sc_mcu7t3v3__fillcap_16
XFILLER_192_101 VDD VDD VSS VSS gf180mcu_as_sc_mcu7t3v3__fillcap_4
XPHY_EDGE_ROW_24_1_Right_596 VDD VSS gf180mcu_as_sc_mcu7t3v3__tap_2
X_4797_ VDD VDD VSS VSS _4797_/S _4797_/B _5145_/B _4798_/B gf180mcu_as_sc_mcu7t3v3__mux2_2
X_3817_ VDD VDD VSS VSS _5808_/A _3929_/B _3817_/C _3817_/D _3819_/C gf180mcu_as_sc_mcu7t3v3__ao211_2
XFILLER_192_145 VDD VDD VSS VSS gf180mcu_as_sc_mcu7t3v3__fillcap_16
XFILLER_203_1084 VDD VDD VSS VSS gf180mcu_as_sc_mcu7t3v3__fillcap_16
X_6536_ VDD VDD VSS VSS _6546_/CLK _6536_/D _6536_/Q gf180mcu_as_sc_mcu7t3v3__dfxtp_2
X_3748_ VDD VDD VSS VSS _3806_/S _5751_/A _3749_/D gf180mcu_as_sc_mcu7t3v3__and2_2
XFILLER_180_307 VDD VDD VSS VSS gf180mcu_as_sc_mcu7t3v3__fill_1
XFILLER_192_167 VDD VDD VSS VSS gf180mcu_as_sc_mcu7t3v3__fill_1
X_6467_ VDD VDD VSS VSS _6474_/CLK _6467_/D _6467_/Q gf180mcu_as_sc_mcu7t3v3__dfxtp_2
X_3679_ VDD VDD VSS VSS _6495_/Q _3804_/B _3804_/C _5690_/B _3681_/C gf180mcu_as_sc_mcu7t3v3__ao22_2
XTAP_TAPCELL_ROW_210_2527 VDD VSS gf180mcu_as_sc_mcu7t3v3__tap_2
XTAP_TAPCELL_ROW_210_2516 VDD VSS gf180mcu_as_sc_mcu7t3v3__tap_2
XTAP_TAPCELL_ROW_189_2139 VDD VSS gf180mcu_as_sc_mcu7t3v3__tap_2
X_6398_ VDD VDD VSS VSS clkload3/A _6398_/D _6398_/Q gf180mcu_as_sc_mcu7t3v3__dfxtp_2
X_5418_ VDD VDD VSS VSS _5419_/D _5567_/B _5566_/B _5726_/A gf180mcu_as_sc_mcu7t3v3__aoi21b_2
X_5349_ VDD VDD VSS VSS _5358_/A _5359_/C _5349_/A gf180mcu_as_sc_mcu7t3v3__nand2_2
XTAP_TAPCELL_ROW_167_1747 VDD VSS gf180mcu_as_sc_mcu7t3v3__tap_2
XFILLER_102_665 VDD VDD VSS VSS gf180mcu_as_sc_mcu7t3v3__fill_2
XFILLER_169_1208 VDD VDD VSS VSS gf180mcu_as_sc_mcu7t3v3__fillcap_16
XFILLER_210_1011 VDD VDD VSS VSS gf180mcu_as_sc_mcu7t3v3__fillcap_4
XFILLER_210_1033 VDD VDD VSS VSS gf180mcu_as_sc_mcu7t3v3__fillcap_16
XTAP_TAPCELL_ROW_208_2489 VDD VSS gf180mcu_as_sc_mcu7t3v3__tap_2
XTAP_TAPCELL_ROW_208_2478 VDD VSS gf180mcu_as_sc_mcu7t3v3__tap_2
XFILLER_46_45 VDD VDD VSS VSS gf180mcu_as_sc_mcu7t3v3__fillcap_4
XTAP_TAPCELL_ROW_225_2792 VDD VSS gf180mcu_as_sc_mcu7t3v3__tap_2
XFILLER_15_104 VDD VDD VSS VSS gf180mcu_as_sc_mcu7t3v3__fillcap_16
XFILLER_188_407 VDD VDD VSS VSS gf180mcu_as_sc_mcu7t3v3__fill_1
XFILLER_188_418 VDD VDD VSS VSS gf180mcu_as_sc_mcu7t3v3__fill_2
XFILLER_12_800 VDD VDD VSS VSS gf180mcu_as_sc_mcu7t3v3__fillcap_4
XFILLER_178_22 VDD VDD VSS VSS gf180mcu_as_sc_mcu7t3v3__fillcap_8
XFILLER_212_750 VDD VDD VSS VSS gf180mcu_as_sc_mcu7t3v3__fill_2
XTAP_TAPCELL_ROW_130_1_1386 VDD VSS gf180mcu_as_sc_mcu7t3v3__tap_2
XFILLER_12_855 VDD VDD VSS VSS gf180mcu_as_sc_mcu7t3v3__fillcap_16
XFILLER_169_665 VDD VDD VSS VSS gf180mcu_as_sc_mcu7t3v3__fillcap_4
XFILLER_200_923 VDD VDD VSS VSS gf180mcu_as_sc_mcu7t3v3__fillcap_16
XFILLER_8_804 VDD VDD VSS VSS gf180mcu_as_sc_mcu7t3v3__fill_1
XFILLER_12_877 VDD VDD VSS VSS gf180mcu_as_sc_mcu7t3v3__fillcap_16
XFILLER_184_613 VDD VDD VSS VSS gf180mcu_as_sc_mcu7t3v3__fillcap_4
XFILLER_211_282 VDD VDD VSS VSS gf180mcu_as_sc_mcu7t3v3__fillcap_4
XFILLER_7_314 VDD VDD VSS VSS gf180mcu_as_sc_mcu7t3v3__fillcap_16
XFILLER_168_197 VDD VDD VSS VSS gf180mcu_as_sc_mcu7t3v3__fill_1
XFILLER_165_871 VDD VDD VSS VSS gf180mcu_as_sc_mcu7t3v3__fillcap_4
XFILLER_171_307 VDD VDD VSS VSS gf180mcu_as_sc_mcu7t3v3__fillcap_4
XFILLER_183_156 VDD VDD VSS VSS gf180mcu_as_sc_mcu7t3v3__fill_2
XFILLER_164_370 VDD VDD VSS VSS gf180mcu_as_sc_mcu7t3v3__fillcap_8
XPHY_EDGE_ROW_119_3_Left_824 VDD VSS gf180mcu_as_sc_mcu7t3v3__tap_2
XFILLER_180_874 VDD VDD VSS VSS gf180mcu_as_sc_mcu7t3v3__fill_1
XFILLER_65_1264 VDD VDD VSS VSS gf180mcu_as_sc_mcu7t3v3__fill_1
XFILLER_4_1011 VDD VDD VSS VSS gf180mcu_as_sc_mcu7t3v3__fillcap_4
XFILLER_4_1033 VDD VDD VSS VSS gf180mcu_as_sc_mcu7t3v3__fillcap_16
XFILLER_219_382 VDD VDD VSS VSS gf180mcu_as_sc_mcu7t3v3__fill_1
XFILLER_159_120 VDD VDD VSS VSS gf180mcu_as_sc_mcu7t3v3__fillcap_16
XFILLER_159_142 VDD VDD VSS VSS gf180mcu_as_sc_mcu7t3v3__fillcap_16
X_4720_ VDD VDD VSS VSS _5731_/A _4932_/A _4720_/C _4720_/D _4722_/B gf180mcu_as_sc_mcu7t3v3__ao211_2
XFILLER_174_101 VDD VDD VSS VSS gf180mcu_as_sc_mcu7t3v3__fillcap_4
X_4651_ VDD VDD VSS VSS _5003_/C _4651_/A _4651_/B _4651_/C gf180mcu_as_sc_mcu7t3v3__ao21_2
XFILLER_174_123 VDD VDD VSS VSS gf180mcu_as_sc_mcu7t3v3__fillcap_16
Xinput20 VDD VDD VSS VSS boot_data[2] _3324_/A gf180mcu_as_sc_mcu7t3v3__buff_12
Xinput31 VDD VDD VSS VSS dft_addr[2] _3246_/A gf180mcu_as_sc_mcu7t3v3__buff_12
X_3602_ VDD VDD VSS VSS _3631_/A _6520_/Q _5329_/A _6521_/Q _3608_/B gf180mcu_as_sc_mcu7t3v3__ao22_2
XFILLER_200_1235 VDD VDD VSS VSS gf180mcu_as_sc_mcu7t3v3__fillcap_4
Xinput42 VDD VDD VSS VSS dft_wdata[1] _3317_/B gf180mcu_as_sc_mcu7t3v3__buff_12
Xinput53 VDD VDD VSS VSS east_in[12] wire960/A gf180mcu_as_sc_mcu7t3v3__buff_12
Xinput64 VDD VDD VSS VSS east_in[22] _5853_/A gf180mcu_as_sc_mcu7t3v3__buff_12
X_4582_ VDD VDD VSS VSS _4583_/C _4583_/B _4582_/A gf180mcu_as_sc_mcu7t3v3__nand2_2
Xinput75 VDD VDD VSS VSS east_in[32] _5937_/A gf180mcu_as_sc_mcu7t3v3__buff_12
Xinput86 VDD VDD VSS VSS ne_in[0] _5677_/A gf180mcu_as_sc_mcu7t3v3__buff_12
Xinput97 VDD VDD VSS VSS ne_in[1] _5685_/D gf180mcu_as_sc_mcu7t3v3__buff_12
X_6321_ VDD VDD VSS VSS _6551_/CLK _6321_/D _6321_/Q gf180mcu_as_sc_mcu7t3v3__dfxtp_2
X_3533_ VDD VDD VSS VSS _4971_/C _4976_/A _5337_/C _3612_/B gf180mcu_as_sc_mcu7t3v3__nor3_2
XFILLER_6_391 VDD VDD VSS VSS gf180mcu_as_sc_mcu7t3v3__fill_1
X_6252_ VDD VDD VSS VSS _6313_/CLK _6252_/D _6252_/Q gf180mcu_as_sc_mcu7t3v3__dfxtp_2
X_3464_ VDD VDD VSS VSS _4634_/D _3637_/A _5946_/A _5953_/A _3638_/A gf180mcu_as_sc_mcu7t3v3__aoi22_2
X_6183_ VDD VDD VSS VSS _6490_/CLK _6183_/D _6183_/Q gf180mcu_as_sc_mcu7t3v3__dfxtp_2
X_5203_ VDD VDD VSS VSS _5203_/D _5856_/A _5301_/S _5203_/C _5204_/C gf180mcu_as_sc_mcu7t3v3__ao31_2
XPHY_EDGE_ROW_40_3_Left_745 VDD VSS gf180mcu_as_sc_mcu7t3v3__tap_2
XTAP_TAPCELL_ROW_149_1400 VDD VSS gf180mcu_as_sc_mcu7t3v3__tap_2
XTAP_TAPCELL_ROW_149_1411 VDD VSS gf180mcu_as_sc_mcu7t3v3__tap_2
XTAP_TAPCELL_ROW_149_1422 VDD VSS gf180mcu_as_sc_mcu7t3v3__tap_2
X_5134_ VDD VDD VSS VSS _5793_/A _5143_/B _5143_/C _5793_/D _5135_/D gf180mcu_as_sc_mcu7t3v3__ao22_2
X_3395_ VDD VDD VSS VSS _4570_/A _3433_/B _4569_/B gf180mcu_as_sc_mcu7t3v3__and2_2
XTAP_TAPCELL_ROW_184_2047 VDD VSS gf180mcu_as_sc_mcu7t3v3__tap_2
Xload_slew751 VDD VDD VSS VSS _3656_/Y _3851_/B gf180mcu_as_sc_mcu7t3v3__clkbuff_12
XTAP_TAPCELL_ROW_24_3_2885 VDD VSS gf180mcu_as_sc_mcu7t3v3__tap_2
XTAP_TAPCELL_ROW_184_2058 VDD VSS gf180mcu_as_sc_mcu7t3v3__tap_2
XTAP_TAPCELL_ROW_10_1202 VDD VSS gf180mcu_as_sc_mcu7t3v3__tap_2
Xclkbuf_3_2_0_clk_regs VDD VDD VSS VSS clkbuf_0_clk_regs/Y clkbuf_3_2_0_clk_regs/Y
+ gf180mcu_as_sc_mcu7t3v3__clkbuff_12
X_5065_ VDD VDD VSS VSS _5202_/B _5733_/A _5066_/C gf180mcu_as_sc_mcu7t3v3__and2_2
XFILLER_226_842 VDD VDD VSS VSS gf180mcu_as_sc_mcu7t3v3__fill_2
X_4016_ VDD VDD VSS VSS _4016_/Y _4057_/C _5925_/D gf180mcu_as_sc_mcu7t3v3__nor2_2
XFILLER_203_72 VDD VDD VSS VSS gf180mcu_as_sc_mcu7t3v3__fillcap_16
XFILLER_225_352 VDD VDD VSS VSS gf180mcu_as_sc_mcu7t3v3__fill_2
XTAP_TAPCELL_ROW_162_1655 VDD VSS gf180mcu_as_sc_mcu7t3v3__tap_2
XTAP_TAPCELL_ROW_162_1666 VDD VSS gf180mcu_as_sc_mcu7t3v3__tap_2
XFILLER_129_1214 VDD VDD VSS VSS gf180mcu_as_sc_mcu7t3v3__fill_1
XFILLER_198_727 VDD VDD VSS VSS gf180mcu_as_sc_mcu7t3v3__fillcap_8
XFILLER_12_107 VDD VDD VSS VSS gf180mcu_as_sc_mcu7t3v3__fillcap_16
X_5967_ VDD VDD VSS VSS _5967_/B _5967_/A _6489_/D gf180mcu_as_sc_mcu7t3v3__and2_2
XTAP_TAPCELL_ROW_203_2397 VDD VSS gf180mcu_as_sc_mcu7t3v3__tap_2
XFILLER_194_900 VDD VDD VSS VSS gf180mcu_as_sc_mcu7t3v3__fillcap_16
X_4918_ VDD VDD VSS VSS _4918_/B _4918_/A _4919_/D gf180mcu_as_sc_mcu7t3v3__and2_2
XFILLER_148_14 VDD VDD VSS VSS gf180mcu_as_sc_mcu7t3v3__fill_2
XFILLER_194_944 VDD VDD VSS VSS gf180mcu_as_sc_mcu7t3v3__fill_1
X_5898_ VDD VDD VSS VSS _5898_/A _5922_/B _5898_/C _5898_/D _5899_/D gf180mcu_as_sc_mcu7t3v3__ao211_2
X_4849_ VDD VDD VSS VSS _5195_/A _4878_/B _4849_/C _4880_/B _4850_/D gf180mcu_as_sc_mcu7t3v3__ao211_2
XPHY_EDGE_ROW_25_1_Right_597 VDD VSS gf180mcu_as_sc_mcu7t3v3__tap_2
XFILLER_10_1049 VDD VDD VSS VSS gf180mcu_as_sc_mcu7t3v3__fillcap_16
XFILLER_4_317 VDD VDD VSS VSS gf180mcu_as_sc_mcu7t3v3__fillcap_4
XFILLER_88_1242 VDD VDD VSS VSS gf180mcu_as_sc_mcu7t3v3__fill_1
X_6519_ VDD VDD VSS VSS _6519_/CLK _6519_/D _6519_/Q gf180mcu_as_sc_mcu7t3v3__dfxtp_2
XFILLER_49_1259 VDD VDD VSS VSS gf180mcu_as_sc_mcu7t3v3__fillcap_4
XFILLER_136_1218 VDD VDD VSS VSS gf180mcu_as_sc_mcu7t3v3__fillcap_4
XFILLER_161_384 VDD VDD VSS VSS gf180mcu_as_sc_mcu7t3v3__fill_1
XTAP_TAPCELL_ROW_101_2_3000 VDD VSS gf180mcu_as_sc_mcu7t3v3__tap_2
XTAP_TAPCELL_ROW_227_2821 VDD VSS gf180mcu_as_sc_mcu7t3v3__tap_2
XFILLER_57_22 VDD VDD VSS VSS gf180mcu_as_sc_mcu7t3v3__fill_2
XTAP_TAPCELL_ROW_227_2832 VDD VSS gf180mcu_as_sc_mcu7t3v3__tap_2
XFILLER_16_435 VDD VDD VSS VSS gf180mcu_as_sc_mcu7t3v3__fill_2
XFILLER_182_1205 VDD VDD VSS VSS gf180mcu_as_sc_mcu7t3v3__fillcap_16
XFILLER_182_1227 VDD VDD VSS VSS gf180mcu_as_sc_mcu7t3v3__fillcap_8
XFILLER_189_43 VDD VDD VSS VSS gf180mcu_as_sc_mcu7t3v3__fillcap_16
XFILLER_189_65 VDD VDD VSS VSS gf180mcu_as_sc_mcu7t3v3__fill_1
XFILLER_223_1224 VDD VDD VSS VSS gf180mcu_as_sc_mcu7t3v3__fillcap_16
XPHY_EDGE_ROW_93_2_Left_534 VDD VSS gf180mcu_as_sc_mcu7t3v3__tap_2
XFILLER_156_101 VDD VDD VSS VSS gf180mcu_as_sc_mcu7t3v3__fillcap_4
XFILLER_8_601 VDD VDD VSS VSS gf180mcu_as_sc_mcu7t3v3__fill_2
XFILLER_12_696 VDD VDD VSS VSS gf180mcu_as_sc_mcu7t3v3__fill_2
XFILLER_156_123 VDD VDD VSS VSS gf180mcu_as_sc_mcu7t3v3__fillcap_16
XFILLER_184_454 VDD VDD VSS VSS gf180mcu_as_sc_mcu7t3v3__fill_1
XTAP_TAPCELL_ROW_64_1_1353 VDD VSS gf180mcu_as_sc_mcu7t3v3__tap_2
XFILLER_171_104 VDD VDD VSS VSS gf180mcu_as_sc_mcu7t3v3__fillcap_16
XFILLER_184_465 VDD VDD VSS VSS gf180mcu_as_sc_mcu7t3v3__fill_1
XFILLER_184_487 VDD VDD VSS VSS gf180mcu_as_sc_mcu7t3v3__fillcap_4
XFILLER_8_667 VDD VDD VSS VSS gf180mcu_as_sc_mcu7t3v3__fillcap_4
XFILLER_172_649 VDD VDD VSS VSS gf180mcu_as_sc_mcu7t3v3__fillcap_4
XFILLER_125_598 VDD VDD VSS VSS gf180mcu_as_sc_mcu7t3v3__fill_1
XFILLER_4_873 VDD VDD VSS VSS gf180mcu_as_sc_mcu7t3v3__fill_2
X_3180_ VDD VDD VSS VSS _3180_/B _3294_/B _4602_/C gf180mcu_as_sc_mcu7t3v3__or2_2
XFILLER_227_628 VDD VDD VSS VSS gf180mcu_as_sc_mcu7t3v3__fill_2
XTAP_TAPCELL_ROW_7_1134 VDD VSS gf180mcu_as_sc_mcu7t3v3__tap_2
XFILLER_187_1116 VDD VDD VSS VSS gf180mcu_as_sc_mcu7t3v3__fillcap_4
XFILLER_187_1138 VDD VDD VSS VSS gf180mcu_as_sc_mcu7t3v3__fillcap_16
XTAP_TAPCELL_ROW_7_1145 VDD VSS gf180mcu_as_sc_mcu7t3v3__tap_2
XTAP_TAPCELL_ROW_36_2_2902 VDD VSS gf180mcu_as_sc_mcu7t3v3__tap_2
XFILLER_207_352 VDD VDD VSS VSS gf180mcu_as_sc_mcu7t3v3__fillcap_4
XFILLER_228_1113 VDD VDD VSS VSS gf180mcu_as_sc_mcu7t3v3__fillcap_4
XFILLER_228_1124 VDD VDD VSS VSS gf180mcu_as_sc_mcu7t3v3__fill_1
XFILLER_207_396 VDD VDD VSS VSS gf180mcu_as_sc_mcu7t3v3__fillcap_8
X_5821_ VDD VDD VSS VSS _5951_/B _5821_/A _5824_/C gf180mcu_as_sc_mcu7t3v3__and2_2
XFILLER_210_517 VDD VDD VSS VSS gf180mcu_as_sc_mcu7t3v3__fill_1
X_5752_ VDD VDD VSS VSS _5752_/A _5802_/C _5801_/S _5752_/D _5753_/D gf180mcu_as_sc_mcu7t3v3__ao22_2
X_4703_ VDD VDD VSS VSS _6498_/Q _4841_/B _4703_/C _4703_/D _4705_/C gf180mcu_as_sc_mcu7t3v3__ao211_2
XFILLER_148_657 VDD VDD VSS VSS gf180mcu_as_sc_mcu7t3v3__fill_2
XFILLER_176_944 VDD VDD VSS VSS gf180mcu_as_sc_mcu7t3v3__fill_1
X_5683_ VDD VDD VSS VSS _5683_/A _5799_/B _5683_/C _5799_/D _5684_/D gf180mcu_as_sc_mcu7t3v3__ao22_2
XFILLER_163_605 VDD VDD VSS VSS gf180mcu_as_sc_mcu7t3v3__fillcap_8
X_4634_ VDD VDD VSS VSS _5950_/D _4634_/B _4634_/C _4634_/D _4987_/A gf180mcu_as_sc_mcu7t3v3__ao22_2
XFILLER_200_1065 VDD VDD VSS VSS gf180mcu_as_sc_mcu7t3v3__fillcap_16
X_4565_ VDD VDD VSS VSS _4567_/B _4602_/C _4565_/C _6308_/D gf180mcu_as_sc_mcu7t3v3__nor3_2
XFILLER_190_457 VDD VDD VSS VSS gf180mcu_as_sc_mcu7t3v3__fill_2
XFILLER_200_1087 VDD VDD VSS VSS gf180mcu_as_sc_mcu7t3v3__fillcap_16
X_6304_ VDD VDD VSS VSS clkload7/A _6304_/D _6304_/Q gf180mcu_as_sc_mcu7t3v3__dfxtp_2
X_3516_ VDD VDD VSS VSS _4627_/A _4627_/B _4628_/A _5336_/A gf180mcu_as_sc_mcu7t3v3__nand3_2
XFILLER_171_671 VDD VDD VSS VSS gf180mcu_as_sc_mcu7t3v3__fillcap_16
XPHY_EDGE_ROW_4_Right_4 VDD VSS gf180mcu_as_sc_mcu7t3v3__tap_2
X_4496_ VDD VDD VSS VSS _6284_/D _4496_/C _4503_/C _6284_/Q gf180mcu_as_sc_mcu7t3v3__aoi21b_2
X_6235_ VDD VDD VSS VSS _6316_/CLK _6235_/D _6235_/Q gf180mcu_as_sc_mcu7t3v3__dfxtp_2
X_3447_ VDD VDD VSS VSS _6719_/A _4584_/A _3456_/B gf180mcu_as_sc_mcu7t3v3__and2_2
XFILLER_134_27 VDD VDD VSS VSS gf180mcu_as_sc_mcu7t3v3__fillcap_8
XFILLER_134_49 VDD VDD VSS VSS gf180mcu_as_sc_mcu7t3v3__fill_2
X_6166_ VDD VDD VSS VSS _6526_/CLK _6166_/D _6166_/Q gf180mcu_as_sc_mcu7t3v3__dfxtp_2
X_3378_ VDD VDD VSS VSS _4539_/A _6271_/Q _3434_/A _3437_/B _4509_/A gf180mcu_as_sc_mcu7t3v3__aoi211_2
XPHY_EDGE_ROW_89_1_Left_317 VDD VSS gf180mcu_as_sc_mcu7t3v3__tap_2
X_6097_ VDD VDD VSS VSS _6520_/CLK _6097_/D _6097_/Q gf180mcu_as_sc_mcu7t3v3__dfxtp_2
X_5117_ VDD VDD VSS VSS _5778_/A _5218_/B _5117_/C _5117_/D _5118_/A gf180mcu_as_sc_mcu7t3v3__ao211_2
XFILLER_85_666 VDD VDD VSS VSS gf180mcu_as_sc_mcu7t3v3__fill_1
X_5048_ VDD VDD VSS VSS _5049_/D _5086_/B _5132_/B _5716_/B gf180mcu_as_sc_mcu7t3v3__aoi21b_2
XTAP_TAPCELL_ROW_205_2437 VDD VSS gf180mcu_as_sc_mcu7t3v3__tap_2
XTAP_TAPCELL_ROW_205_2426 VDD VSS gf180mcu_as_sc_mcu7t3v3__tap_2
XFILLER_150_37 VDD VDD VSS VSS gf180mcu_as_sc_mcu7t3v3__fillcap_16
XFILLER_226_650 VDD VDD VSS VSS gf180mcu_as_sc_mcu7t3v3__fill_2
XPHY_EDGE_ROW_141_1_Left_369 VDD VSS gf180mcu_as_sc_mcu7t3v3__tap_2
XTAP_TAPCELL_ROW_222_2740 VDD VSS gf180mcu_as_sc_mcu7t3v3__tap_2
XFILLER_13_405 VDD VDD VSS VSS gf180mcu_as_sc_mcu7t3v3__fill_2
XFILLER_207_1208 VDD VDD VSS VSS gf180mcu_as_sc_mcu7t3v3__fillcap_16
XFILLER_214_867 VDD VDD VSS VSS gf180mcu_as_sc_mcu7t3v3__fill_1
XFILLER_185_218 VDD VDD VSS VSS gf180mcu_as_sc_mcu7t3v3__fill_1
XTAP_TAPCELL_ROW_179_1971 VDD VSS gf180mcu_as_sc_mcu7t3v3__tap_2
XTAP_TAPCELL_ROW_179_1960 VDD VSS gf180mcu_as_sc_mcu7t3v3__tap_2
XFILLER_139_646 VDD VDD VSS VSS gf180mcu_as_sc_mcu7t3v3__fill_2
XFILLER_166_476 VDD VDD VSS VSS gf180mcu_as_sc_mcu7t3v3__fillcap_4
XFILLER_5_604 VDD VDD VSS VSS gf180mcu_as_sc_mcu7t3v3__fill_1
XFILLER_153_104 VDD VDD VSS VSS gf180mcu_as_sc_mcu7t3v3__fillcap_16
XPHY_EDGE_ROW_26_1_Right_598 VDD VSS gf180mcu_as_sc_mcu7t3v3__tap_2
XFILLER_1_821 VDD VDD VSS VSS gf180mcu_as_sc_mcu7t3v3__fillcap_16
XFILLER_1_854 VDD VDD VSS VSS gf180mcu_as_sc_mcu7t3v3__fill_2
XFILLER_0_342 VDD VDD VSS VSS gf180mcu_as_sc_mcu7t3v3__fillcap_4
XFILLER_150_877 VDD VDD VSS VSS gf180mcu_as_sc_mcu7t3v3__fill_2
XFILLER_62_1245 VDD VDD VSS VSS gf180mcu_as_sc_mcu7t3v3__fillcap_16
Xinput210 VDD VDD VSS VSS se_in[23] _5866_/A gf180mcu_as_sc_mcu7t3v3__buff_12
XFILLER_191_88 VDD VDD VSS VSS gf180mcu_as_sc_mcu7t3v3__fillcap_16
Xinput221 VDD VDD VSS VSS se_in[33] _5947_/A gf180mcu_as_sc_mcu7t3v3__buff_12
Xinput232 VDD VDD VSS VSS south_in[10] _5758_/A gf180mcu_as_sc_mcu7t3v3__buff_12
Xinput243 VDD VDD VSS VSS south_in[20] _5839_/A gf180mcu_as_sc_mcu7t3v3__buff_12
Xinput254 VDD VDD VSS VSS south_in[30] wire996/A gf180mcu_as_sc_mcu7t3v3__buff_12
Xinput265 VDD VDD VSS VSS south_in[8] _5742_/A gf180mcu_as_sc_mcu7t3v3__buff_12
Xinput276 VDD VDD VSS VSS sw_in[18] _5827_/A gf180mcu_as_sc_mcu7t3v3__buff_12
Xinput287 VDD VDD VSS VSS sw_in[28] _5910_/A gf180mcu_as_sc_mcu7t3v3__buff_12
XFILLER_1_1014 VDD VDD VSS VSS gf180mcu_as_sc_mcu7t3v3__fillcap_16
XFILLER_224_609 VDD VDD VSS VSS gf180mcu_as_sc_mcu7t3v3__fill_1
Xinput298 VDD VDD VSS VSS sw_in[5] _5721_/A gf180mcu_as_sc_mcu7t3v3__buff_12
XFILLER_16_254 VDD VDD VSS VSS gf180mcu_as_sc_mcu7t3v3__fill_1
XFILLER_204_333 VDD VDD VSS VSS gf180mcu_as_sc_mcu7t3v3__fill_2
XTAP_TAPCELL_ROW_2_1053 VDD VSS gf180mcu_as_sc_mcu7t3v3__tap_2
XTAP_TAPCELL_ROW_2_1042 VDD VSS gf180mcu_as_sc_mcu7t3v3__tap_2
XFILLER_177_719 VDD VDD VSS VSS gf180mcu_as_sc_mcu7t3v3__fillcap_16
XFILLER_90_8 VDD VDD VSS VSS gf180mcu_as_sc_mcu7t3v3__fill_2
XFILLER_176_229 VDD VDD VSS VSS gf180mcu_as_sc_mcu7t3v3__fillcap_4
XFILLER_158_944 VDD VDD VSS VSS gf180mcu_as_sc_mcu7t3v3__fill_1
XFILLER_158_955 VDD VDD VSS VSS gf180mcu_as_sc_mcu7t3v3__fill_2
XFILLER_145_616 VDD VDD VSS VSS gf180mcu_as_sc_mcu7t3v3__fill_1
XFILLER_172_402 VDD VDD VSS VSS gf180mcu_as_sc_mcu7t3v3__fill_2
XFILLER_200_572 VDD VDD VSS VSS gf180mcu_as_sc_mcu7t3v3__fillcap_16
XFILLER_9_976 VDD VDD VSS VSS gf180mcu_as_sc_mcu7t3v3__fillcap_4
XFILLER_200_594 VDD VDD VSS VSS gf180mcu_as_sc_mcu7t3v3__fill_1
XFILLER_9_998 VDD VDD VSS VSS gf180mcu_as_sc_mcu7t3v3__fillcap_16
XFILLER_172_457 VDD VDD VSS VSS gf180mcu_as_sc_mcu7t3v3__fillcap_4
X_4350_ VDD VDD VSS VSS _6218_/Q _4406_/B _4406_/C _6219_/Q _4351_/C gf180mcu_as_sc_mcu7t3v3__ao22_2
X_3301_ VDD VDD VSS VSS _6203_/Q _3361_/B _4101_/S _6211_/Q _3308_/B gf180mcu_as_sc_mcu7t3v3__ao22_2
XFILLER_193_1186 VDD VDD VSS VSS gf180mcu_as_sc_mcu7t3v3__fillcap_4
XFILLER_3_180 VDD VDD VSS VSS gf180mcu_as_sc_mcu7t3v3__fill_1
X_4281_ VDD VDD VSS VSS _4281_/B _6159_/Q _4283_/C gf180mcu_as_sc_mcu7t3v3__or2_2
X_6020_ VDD VDD VSS VSS _6125_/CLK _6020_/D _6020_/Q gf180mcu_as_sc_mcu7t3v3__dfxtp_2
X_3232_ VDD VDD VSS VSS _4445_/S _3251_/B _6306_/Q gf180mcu_as_sc_mcu7t3v3__nor2_2
X_3163_ VDD VDD VSS VSS _6163_/Q _3163_/B _4146_/S _3372_/B _3163_/D gf180mcu_as_sc_mcu7t3v3__aoi31_2
XTAP_TAPCELL_ROW_181_2006 VDD VSS gf180mcu_as_sc_mcu7t3v3__tap_2
XFILLER_67_666 VDD VDD VSS VSS gf180mcu_as_sc_mcu7t3v3__fill_1
X_3094_ VDD VDD VSS VSS _3094_/Y _4394_/A gf180mcu_as_sc_mcu7t3v3__inv_2
XFILLER_120_18 VDD VDD VSS VSS gf180mcu_as_sc_mcu7t3v3__fillcap_16
XFILLER_39_1214 VDD VDD VSS VSS gf180mcu_as_sc_mcu7t3v3__fill_1
XTAP_TAPCELL_ROW_200_2334 VDD VSS gf180mcu_as_sc_mcu7t3v3__tap_2
XFILLER_168_719 VDD VDD VSS VSS gf180mcu_as_sc_mcu7t3v3__fill_1
X_5804_ VDD VDD VSS VSS _5804_/A _5844_/B _5804_/C _6464_/D _5804_/D gf180mcu_as_sc_mcu7t3v3__aoi211_2
XTAP_TAPCELL_ROW_200_2345 VDD VSS gf180mcu_as_sc_mcu7t3v3__tap_2
XFILLER_149_911 VDD VDD VSS VSS gf180mcu_as_sc_mcu7t3v3__fillcap_4
X_3996_ VDD VDD VSS VSS _4033_/B _4008_/B _4008_/C _6084_/Q _6084_/D gf180mcu_as_sc_mcu7t3v3__ao22_2
XTAP_TAPCELL_ROW_196_2271 VDD VSS gf180mcu_as_sc_mcu7t3v3__tap_2
Xsram2048.u_bank1_1034 VDD VDD VSS VSS sram2048.u_bank1/WEN[0] gf180mcu_as_sc_mcu7t3v3__tiel_4
X_5735_ VDD VDD VSS VSS _5735_/A _5857_/B _5857_/C _5735_/D _5736_/D gf180mcu_as_sc_mcu7t3v3__ao22_2
XFILLER_129_27 VDD VDD VSS VSS gf180mcu_as_sc_mcu7t3v3__fillcap_16
XFILLER_149_988 VDD VDD VSS VSS gf180mcu_as_sc_mcu7t3v3__fillcap_16
XTAP_TAPCELL_ROW_157_1565 VDD VSS gf180mcu_as_sc_mcu7t3v3__tap_2
XTAP_TAPCELL_ROW_157_1576 VDD VSS gf180mcu_as_sc_mcu7t3v3__tap_2
X_5666_ VDD VDD VSS VSS _5666_/Y _5957_/A _5957_/B gf180mcu_as_sc_mcu7t3v3__nand2_2
XFILLER_11_1100 VDD VDD VSS VSS gf180mcu_as_sc_mcu7t3v3__fillcap_16
XFILLER_11_1122 VDD VDD VSS VSS gf180mcu_as_sc_mcu7t3v3__fillcap_16
XFILLER_163_424 VDD VDD VSS VSS gf180mcu_as_sc_mcu7t3v3__fill_1
XFILLER_191_733 VDD VDD VSS VSS gf180mcu_as_sc_mcu7t3v3__fill_2
X_4617_ VDD VDD VSS VSS _4617_/Y _4973_/C _4617_/B _4617_/A gf180mcu_as_sc_mcu7t3v3__aoi21_2
XFILLER_102_1261 VDD VDD VSS VSS gf180mcu_as_sc_mcu7t3v3__fillcap_4
XFILLER_163_457 VDD VDD VSS VSS gf180mcu_as_sc_mcu7t3v3__fill_1
XFILLER_190_254 VDD VDD VSS VSS gf180mcu_as_sc_mcu7t3v3__fillcap_8
X_5597_ VDD VDD VSS VSS _5905_/A _5640_/B _5632_/C _5903_/A _5598_/D gf180mcu_as_sc_mcu7t3v3__ao22_2
XFILLER_150_107 VDD VDD VSS VSS gf180mcu_as_sc_mcu7t3v3__fillcap_16
X_4548_ VDD VDD VSS VSS _6302_/D _6147_/Q _4551_/B _4548_/C gf180mcu_as_sc_mcu7t3v3__ao21_2
XTAP_TAPCELL_ROW_170_1798 VDD VSS gf180mcu_as_sc_mcu7t3v3__tap_2
Xfanout900 VDD VDD VSS VSS _6519_/Q _5912_/A gf180mcu_as_sc_mcu7t3v3__buff_12
X_4479_ VDD VDD VSS VSS _4520_/S _6722_/A _6278_/Q _6278_/D gf180mcu_as_sc_mcu7t3v3__mux2_2
XFILLER_172_1259 VDD VDD VSS VSS gf180mcu_as_sc_mcu7t3v3__fillcap_4
Xfanout911 VDD VDD VSS VSS _4293_/S _4362_/A gf180mcu_as_sc_mcu7t3v3__buff_12
Xfanout922 VDD VDD VSS VSS _5229_/A _5164_/A gf180mcu_as_sc_mcu7t3v3__buff_12
Xfanout933 VDD VDD VSS VSS _4912_/A _5978_/A gf180mcu_as_sc_mcu7t3v3__buff_12
X_6218_ VDD VDD VSS VSS _6519_/CLK _6218_/D _6218_/Q gf180mcu_as_sc_mcu7t3v3__dfxtp_2
XFILLER_219_904 VDD VDD VSS VSS gf180mcu_as_sc_mcu7t3v3__fillcap_4
Xfanout944 VDD VDD VSS VSS _5329_/A _3631_/D gf180mcu_as_sc_mcu7t3v3__buff_12
Xfanout955 VDD VDD VSS VSS fanout956/Y _5950_/D gf180mcu_as_sc_mcu7t3v3__buff_12
XFILLER_213_1256 VDD VDD VSS VSS gf180mcu_as_sc_mcu7t3v3__fillcap_4
XTAP_TAPCELL_ROW_16_1296 VDD VSS gf180mcu_as_sc_mcu7t3v3__tap_2
Xfanout999 VDD VDD VSS VSS _4248_/A _5319_/A gf180mcu_as_sc_mcu7t3v3__buff_12
X_6149_ VDD VDD VSS VSS clkload8/A _6149_/D _6149_/Q gf180mcu_as_sc_mcu7t3v3__dfxtp_2
Xhold1197 VDD VDD VSS VSS hold1222/Y _6537_/D gf180mcu_as_sc_mcu7t3v3__clkbuff_4
XFILLER_54_45 VDD VDD VSS VSS gf180mcu_as_sc_mcu7t3v3__fillcap_4
XPHY_EDGE_ROW_128_3_Left_833 VDD VSS gf180mcu_as_sc_mcu7t3v3__tap_2
XFILLER_186_505 VDD VDD VSS VSS gf180mcu_as_sc_mcu7t3v3__fillcap_8
XFILLER_186_527 VDD VDD VSS VSS gf180mcu_as_sc_mcu7t3v3__fillcap_4
XFILLER_198_387 VDD VDD VSS VSS gf180mcu_as_sc_mcu7t3v3__fillcap_4
XFILLER_199_888 VDD VDD VSS VSS gf180mcu_as_sc_mcu7t3v3__fillcap_4
XTAP_TAPCELL_ROW_177_1919 VDD VSS gf180mcu_as_sc_mcu7t3v3__tap_2
XFILLER_16_1022 VDD VDD VSS VSS gf180mcu_as_sc_mcu7t3v3__fillcap_16
XFILLER_220_1205 VDD VDD VSS VSS gf180mcu_as_sc_mcu7t3v3__fillcap_16
XFILLER_9_228 VDD VDD VSS VSS gf180mcu_as_sc_mcu7t3v3__fillcap_16
XFILLER_210_881 VDD VDD VSS VSS gf180mcu_as_sc_mcu7t3v3__fill_2
XFILLER_220_1227 VDD VDD VSS VSS gf180mcu_as_sc_mcu7t3v3__fillcap_16
XFILLER_221_2 VDD VDD VSS VSS gf180mcu_as_sc_mcu7t3v3__fillcap_16
XFILLER_6_902 VDD VDD VSS VSS gf180mcu_as_sc_mcu7t3v3__fillcap_16
XFILLER_154_435 VDD VDD VSS VSS gf180mcu_as_sc_mcu7t3v3__fillcap_4
XPHY_EDGE_ROW_17_3_Right_97 VDD VSS gf180mcu_as_sc_mcu7t3v3__tap_2
XFILLER_154_457 VDD VDD VSS VSS gf180mcu_as_sc_mcu7t3v3__fillcap_16
XFILLER_6_979 VDD VDD VSS VSS gf180mcu_as_sc_mcu7t3v3__fillcap_16
XPHY_EDGE_ROW_27_1_Right_599 VDD VSS gf180mcu_as_sc_mcu7t3v3__tap_2
XFILLER_181_298 VDD VDD VSS VSS gf180mcu_as_sc_mcu7t3v3__fillcap_8
XFILLER_218_1189 VDD VDD VSS VSS gf180mcu_as_sc_mcu7t3v3__fillcap_16
XFILLER_0_172 VDD VDD VSS VSS gf180mcu_as_sc_mcu7t3v3__fillcap_4
XFILLER_150_696 VDD VDD VSS VSS gf180mcu_as_sc_mcu7t3v3__fillcap_16
XFILLER_153_1170 VDD VDD VSS VSS gf180mcu_as_sc_mcu7t3v3__fillcap_16
XFILLER_49_611 VDD VDD VSS VSS gf180mcu_as_sc_mcu7t3v3__fill_1
XFILLER_153_1192 VDD VDD VSS VSS gf180mcu_as_sc_mcu7t3v3__fillcap_16
XFILLER_49_666 VDD VDD VSS VSS gf180mcu_as_sc_mcu7t3v3__fill_1
XFILLER_7_1256 VDD VDD VSS VSS gf180mcu_as_sc_mcu7t3v3__fillcap_4
XFILLER_184_1119 VDD VDD VSS VSS gf180mcu_as_sc_mcu7t3v3__fillcap_16
XFILLER_188_1255 VDD VDD VSS VSS gf180mcu_as_sc_mcu7t3v3__fillcap_8
XFILLER_189_321 VDD VDD VSS VSS gf180mcu_as_sc_mcu7t3v3__fillcap_4
XFILLER_225_1116 VDD VDD VSS VSS gf180mcu_as_sc_mcu7t3v3__fillcap_4
XFILLER_220_612 VDD VDD VSS VSS gf180mcu_as_sc_mcu7t3v3__fill_1
XFILLER_225_1138 VDD VDD VSS VSS gf180mcu_as_sc_mcu7t3v3__fillcap_16
X_3850_ VDD VDD VSS VSS _6513_/Q _3850_/B _3850_/C _5838_/B _3852_/C gf180mcu_as_sc_mcu7t3v3__ao22_2
XFILLER_204_196 VDD VDD VSS VSS gf180mcu_as_sc_mcu7t3v3__fillcap_4
XFILLER_220_667 VDD VDD VSS VSS gf180mcu_as_sc_mcu7t3v3__fillcap_8
X_3781_ VDD VDD VSS VSS _4036_/B _5779_/A _3865_/B _3781_/C gf180mcu_as_sc_mcu7t3v3__ao21_2
X_5520_ VDD VDD VSS VSS _5520_/B _5520_/A _5521_/B gf180mcu_as_sc_mcu7t3v3__or2_2
XTAP_TAPCELL_ROW_95_2_2991 VDD VSS gf180mcu_as_sc_mcu7t3v3__tap_2
XFILLER_172_232 VDD VDD VSS VSS gf180mcu_as_sc_mcu7t3v3__fill_1
X_5451_ VDD VDD VSS VSS _5452_/D _5758_/A _5549_/B _5451_/C gf180mcu_as_sc_mcu7t3v3__ao21_2
XFILLER_154_991 VDD VDD VSS VSS gf180mcu_as_sc_mcu7t3v3__fillcap_16
X_5382_ VDD VDD VSS VSS _6495_/Q _5490_/B _5491_/C _5690_/B _5383_/C gf180mcu_as_sc_mcu7t3v3__ao22_2
X_4402_ VDD VDD VSS VSS _6225_/D _4402_/B _4402_/A gf180mcu_as_sc_mcu7t3v3__nand2_2
XFILLER_158_1081 VDD VDD VSS VSS gf180mcu_as_sc_mcu7t3v3__fillcap_4
XFILLER_5_72 VDD VDD VSS VSS gf180mcu_as_sc_mcu7t3v3__fillcap_16
XTAP_TAPCELL_ROW_152_1473 VDD VSS gf180mcu_as_sc_mcu7t3v3__tap_2
XTAP_TAPCELL_ROW_152_1484 VDD VSS gf180mcu_as_sc_mcu7t3v3__tap_2
X_4333_ VDD VDD VSS VSS _4334_/C _4335_/S _6029_/Q gf180mcu_as_sc_mcu7t3v3__nor2b_2
X_4264_ VDD VDD VSS VSS _4264_/A _4280_/B _4264_/C _4280_/D _4267_/B gf180mcu_as_sc_mcu7t3v3__ao211_2
XFILLER_132_1210 VDD VDD VSS VSS gf180mcu_as_sc_mcu7t3v3__fillcap_16
X_6003_ VDD VDD VSS VSS _6010_/B _6226_/Q _6516_/D gf180mcu_as_sc_mcu7t3v3__and2_2
X_3215_ VDD VDD VSS VSS _6335_/Q _6334_/Q _3216_/C gf180mcu_as_sc_mcu7t3v3__xnor2_2
XFILLER_228_745 VDD VDD VSS VSS gf180mcu_as_sc_mcu7t3v3__fill_2
X_4195_ VDD VDD VSS VSS _6196_/D _4195_/C _4223_/B _6196_/Q gf180mcu_as_sc_mcu7t3v3__aoi21b_2
X_3146_ VDD VDD VSS VSS _4610_/A _4475_/B _6306_/Q gf180mcu_as_sc_mcu7t3v3__nor2_2
X_3077_ VDD VDD VSS VSS _5150_/A _5806_/B gf180mcu_as_sc_mcu7t3v3__inv_2
XTAP_TAPCELL_ROW_198_2311 VDD VSS gf180mcu_as_sc_mcu7t3v3__tap_2
XTAP_TAPCELL_ROW_198_2300 VDD VSS gf180mcu_as_sc_mcu7t3v3__tap_2
XFILLER_165_1052 VDD VDD VSS VSS gf180mcu_as_sc_mcu7t3v3__fillcap_16
XFILLER_211_72 VDD VDD VSS VSS gf180mcu_as_sc_mcu7t3v3__fillcap_16
XFILLER_168_527 VDD VDD VSS VSS gf180mcu_as_sc_mcu7t3v3__fill_1
XFILLER_224_995 VDD VDD VSS VSS gf180mcu_as_sc_mcu7t3v3__fillcap_16
XFILLER_24_37 VDD VDD VSS VSS gf180mcu_as_sc_mcu7t3v3__fillcap_8
XTAP_TAPCELL_ROW_159_1605 VDD VSS gf180mcu_as_sc_mcu7t3v3__tap_2
XFILLER_210_188 VDD VDD VSS VSS gf180mcu_as_sc_mcu7t3v3__fill_2
X_5718_ VDD VDD VSS VSS _5718_/A _5800_/B _5718_/C _5718_/D _5719_/D gf180mcu_as_sc_mcu7t3v3__ao211_2
X_3979_ VDD VDD VSS VSS _4059_/B _3981_/C _3980_/B _6072_/Q _6072_/D gf180mcu_as_sc_mcu7t3v3__ao22_2
XTAP_TAPCELL_ROW_217_2650 VDD VSS gf180mcu_as_sc_mcu7t3v3__tap_2
XFILLER_164_722 VDD VDD VSS VSS gf180mcu_as_sc_mcu7t3v3__fill_2
XFILLER_6_209 VDD VDD VSS VSS gf180mcu_as_sc_mcu7t3v3__fillcap_16
XTAP_TAPCELL_ROW_172_1838 VDD VSS gf180mcu_as_sc_mcu7t3v3__tap_2
X_5649_ VDD VDD VSS VSS _5655_/B _5649_/A _5649_/B _5649_/C _5649_/D gf180mcu_as_sc_mcu7t3v3__aoi22_2
XFILLER_156_69 VDD VDD VSS VSS gf180mcu_as_sc_mcu7t3v3__fillcap_16
XTAP_TAPCELL_ROW_213_2569 VDD VSS gf180mcu_as_sc_mcu7t3v3__tap_2
XFILLER_163_298 VDD VDD VSS VSS gf180mcu_as_sc_mcu7t3v3__fillcap_16
Xfanout730 VDD VDD VSS VSS _5365_/Y _5637_/B gf180mcu_as_sc_mcu7t3v3__buff_12
Xfanout752 VDD VDD VSS VSS _5838_/S _5741_/S gf180mcu_as_sc_mcu7t3v3__buff_12
Xfanout763 VDD VDD VSS VSS _5324_/Y _5631_/B gf180mcu_as_sc_mcu7t3v3__buff_12
Xfanout774 VDD VDD VSS VSS _5187_/S _5303_/S gf180mcu_as_sc_mcu7t3v3__buff_12
Xfanout785 VDD VDD VSS VSS _4930_/B _4794_/S gf180mcu_as_sc_mcu7t3v3__buff_12
XFILLER_46_614 VDD VDD VSS VSS gf180mcu_as_sc_mcu7t3v3__fill_1
Xfanout796 VDD VDD VSS VSS _4422_/C _4425_/C gf180mcu_as_sc_mcu7t3v3__buff_12
XFILLER_206_406 VDD VDD VSS VSS gf180mcu_as_sc_mcu7t3v3__fill_1
XPHY_EDGE_ROW_22_1_Left_250 VDD VSS gf180mcu_as_sc_mcu7t3v3__tap_2
XPHY_EDGE_ROW_130_2_Right_967 VDD VSS gf180mcu_as_sc_mcu7t3v3__tap_2
XFILLER_148_1261 VDD VDD VSS VSS gf180mcu_as_sc_mcu7t3v3__fillcap_4
XFILLER_202_601 VDD VDD VSS VSS gf180mcu_as_sc_mcu7t3v3__fill_2
XFILLER_214_461 VDD VDD VSS VSS gf180mcu_as_sc_mcu7t3v3__fill_2
XFILLER_81_10 VDD VDD VSS VSS gf180mcu_as_sc_mcu7t3v3__fillcap_4
XFILLER_198_140 VDD VDD VSS VSS gf180mcu_as_sc_mcu7t3v3__fill_2
XFILLER_197_43 VDD VDD VSS VSS gf180mcu_as_sc_mcu7t3v3__fillcap_16
XFILLER_198_184 VDD VDD VSS VSS gf180mcu_as_sc_mcu7t3v3__fillcap_16
Xmax_cap1003 VDD VDD VSS VSS _4725_/D _5804_/D gf180mcu_as_sc_mcu7t3v3__clkbuff_12
XFILLER_10_794 VDD VDD VSS VSS gf180mcu_as_sc_mcu7t3v3__fillcap_8
XFILLER_6_798 VDD VDD VSS VSS gf180mcu_as_sc_mcu7t3v3__fillcap_4
XFILLER_155_1254 VDD VDD VSS VSS gf180mcu_as_sc_mcu7t3v3__fill_2
XFILLER_190_1189 VDD VDD VSS VSS gf180mcu_as_sc_mcu7t3v3__fillcap_16
XFILLER_1_492 VDD VDD VSS VSS gf180mcu_as_sc_mcu7t3v3__fill_2
Xclkbuf_leaf_4_clk_regs VDD VDD VSS VSS clkbuf_3_1_0_clk_regs/Y clkload6/A gf180mcu_as_sc_mcu7t3v3__clkbuff_12
Xinput7 VDD VDD VSS VSS boot_addr[0] input7/Y gf180mcu_as_sc_mcu7t3v3__buff_12
Xmesh_tile_1162 VDD VDD VSS VSS sw_out[13] gf180mcu_as_sc_mcu7t3v3__tiel_4
Xmesh_tile_1151 VDD VDD VSS VSS sw_out[2] gf180mcu_as_sc_mcu7t3v3__tiel_4
Xmesh_tile_1140 VDD VDD VSS VSS se_out[27] gf180mcu_as_sc_mcu7t3v3__tiel_4
XFILLER_149_1047 VDD VDD VSS VSS gf180mcu_as_sc_mcu7t3v3__fillcap_4
Xmesh_tile_1184 VDD VDD VSS VSS sw_out[35] gf180mcu_as_sc_mcu7t3v3__tiel_4
Xmesh_tile_1173 VDD VDD VSS VSS sw_out[24] gf180mcu_as_sc_mcu7t3v3__tiel_4
X_4951_ VDD VDD VSS VSS _5629_/A _4958_/B _4951_/C _6373_/D _5909_/D gf180mcu_as_sc_mcu7t3v3__aoi211_2
XFILLER_206_995 VDD VDD VSS VSS gf180mcu_as_sc_mcu7t3v3__fillcap_16
X_4882_ VDD VDD VSS VSS _4883_/C _4882_/C _4964_/B _5869_/A gf180mcu_as_sc_mcu7t3v3__aoi21_2
X_3902_ VDD VDD VSS VSS _3902_/S _3902_/B _5881_/A _3903_/D gf180mcu_as_sc_mcu7t3v3__mux2_2
XTAP_TAPCELL_ROW_142_2_3061 VDD VSS gf180mcu_as_sc_mcu7t3v3__tap_2
X_3833_ VDD VDD VSS VSS _3926_/B _5821_/A _3834_/D gf180mcu_as_sc_mcu7t3v3__and2_2
XFILLER_165_508 VDD VDD VSS VSS gf180mcu_as_sc_mcu7t3v3__fillcap_16
XFILLER_177_368 VDD VDD VSS VSS gf180mcu_as_sc_mcu7t3v3__fillcap_16
XFILLER_221_998 VDD VDD VSS VSS gf180mcu_as_sc_mcu7t3v3__fillcap_16
XFILLER_158_593 VDD VDD VSS VSS gf180mcu_as_sc_mcu7t3v3__fill_2
XPHY_EDGE_ROW_98_1_Left_326 VDD VSS gf180mcu_as_sc_mcu7t3v3__tap_2
XTAP_TAPCELL_ROW_154_1513 VDD VSS gf180mcu_as_sc_mcu7t3v3__tap_2
X_6552_ VDD VDD VSS VSS _6552_/CLK _6552_/D _6552_/Q gf180mcu_as_sc_mcu7t3v3__dfxtp_2
X_3764_ VDD VDD VSS VSS _6504_/Q _3897_/B _3887_/B _5766_/A _3766_/C gf180mcu_as_sc_mcu7t3v3__ao22_2
XFILLER_199_1170 VDD VDD VSS VSS gf180mcu_as_sc_mcu7t3v3__fillcap_16
XFILLER_199_1192 VDD VDD VSS VSS gf180mcu_as_sc_mcu7t3v3__fillcap_16
X_6483_ VDD VDD VSS VSS clkload5/A _6483_/D _6483_/Q gf180mcu_as_sc_mcu7t3v3__dfxtp_2
X_5503_ VDD VDD VSS VSS _5809_/A _5569_/B _5503_/C _5503_/D _5505_/C gf180mcu_as_sc_mcu7t3v3__ao211_2
X_3695_ VDD VDD VSS VSS _5704_/A _3810_/B _3695_/C _3695_/D _3696_/B gf180mcu_as_sc_mcu7t3v3__ao22_2
XFILLER_106_619 VDD VDD VSS VSS gf180mcu_as_sc_mcu7t3v3__fillcap_8
X_5434_ VDD VDD VSS VSS _5740_/A _5534_/S _5434_/C _5551_/B _5436_/C gf180mcu_as_sc_mcu7t3v3__ao211_2
XFILLER_161_769 VDD VDD VSS VSS gf180mcu_as_sc_mcu7t3v3__fill_1
Xoutput344 VDD VDD VSS VSS _6720_/Y dft_rdata[5] gf180mcu_as_sc_mcu7t3v3__buff_12
XFILLER_160_279 VDD VDD VSS VSS gf180mcu_as_sc_mcu7t3v3__fillcap_16
Xoutput377 VDD VDD VSS VSS _6417_/Q east_out[4] gf180mcu_as_sc_mcu7t3v3__buff_12
Xoutput366 VDD VDD VSS VSS _6440_/Q east_out[27] gf180mcu_as_sc_mcu7t3v3__buff_12
Xoutput355 VDD VDD VSS VSS _6430_/Q east_out[17] gf180mcu_as_sc_mcu7t3v3__buff_12
X_5365_ VDD VDD VSS VSS _5638_/B _5638_/C _5365_/C _5365_/Y gf180mcu_as_sc_mcu7t3v3__nor3_2
Xoutput399 VDD VDD VSS VSS _6365_/Q north_out[24] gf180mcu_as_sc_mcu7t3v3__buff_12
Xoutput388 VDD VDD VSS VSS _6355_/Q north_out[14] gf180mcu_as_sc_mcu7t3v3__buff_12
X_5296_ VDD VDD VSS VSS _6522_/Q _5296_/B _5296_/C _5939_/D _5297_/D gf180mcu_as_sc_mcu7t3v3__ao22_2
X_4316_ VDD VDD VSS VSS _4318_/A _4316_/C _4407_/B _6148_/Q gf180mcu_as_sc_mcu7t3v3__aoi21_2
X_4247_ VDD VDD VSS VSS _4247_/B _5977_/B _4248_/C gf180mcu_as_sc_mcu7t3v3__and2_2
XFILLER_142_49 VDD VDD VSS VSS gf180mcu_as_sc_mcu7t3v3__fill_2
XTAP_TAPCELL_ROW_13_1244 VDD VSS gf180mcu_as_sc_mcu7t3v3__tap_2
X_4178_ VDD VDD VSS VSS _4178_/A _4236_/B _4236_/C _4178_/D _4179_/B gf180mcu_as_sc_mcu7t3v3__nand4_2
XFILLER_228_586 VDD VDD VSS VSS gf180mcu_as_sc_mcu7t3v3__fill_1
XFILLER_28_647 VDD VDD VSS VSS gf180mcu_as_sc_mcu7t3v3__fill_1
XFILLER_28_658 VDD VDD VSS VSS gf180mcu_as_sc_mcu7t3v3__fillcap_8
XTAP_TAPCELL_ROW_13_1255 VDD VSS gf180mcu_as_sc_mcu7t3v3__tap_2
XFILLER_216_737 VDD VDD VSS VSS gf180mcu_as_sc_mcu7t3v3__fill_2
X_3129_ VDD VDD VSS VSS _4569_/D _4509_/B _4456_/A _4481_/A gf180mcu_as_sc_mcu7t3v3__nand3_2
XFILLER_212_943 VDD VDD VSS VSS gf180mcu_as_sc_mcu7t3v3__fill_2
XFILLER_143_6 VDD VDD VSS VSS gf180mcu_as_sc_mcu7t3v3__fillcap_16
XTAP_TAPCELL_ROW_215_2609 VDD VSS gf180mcu_as_sc_mcu7t3v3__tap_2
XFILLER_13_1014 VDD VDD VSS VSS gf180mcu_as_sc_mcu7t3v3__fillcap_16
XFILLER_178_1221 VDD VDD VSS VSS gf180mcu_as_sc_mcu7t3v3__fillcap_4
XFILLER_152_703 VDD VDD VSS VSS gf180mcu_as_sc_mcu7t3v3__fillcap_8
XFILLER_178_1243 VDD VDD VSS VSS gf180mcu_as_sc_mcu7t3v3__fillcap_16
XFILLER_219_1240 VDD VDD VSS VSS gf180mcu_as_sc_mcu7t3v3__fillcap_16
XFILLER_219_1262 VDD VDD VSS VSS gf180mcu_as_sc_mcu7t3v3__fill_2
XFILLER_160_791 VDD VDD VSS VSS gf180mcu_as_sc_mcu7t3v3__fillcap_8
XFILLER_183_67 VDD VDD VSS VSS gf180mcu_as_sc_mcu7t3v3__fill_2
Xfanout560 VDD VDD VSS VSS _4725_/B _4958_/B gf180mcu_as_sc_mcu7t3v3__buff_12
XFILLER_150_1151 VDD VDD VSS VSS gf180mcu_as_sc_mcu7t3v3__fillcap_4
Xfanout571 VDD VDD VSS VSS _3874_/B _3932_/B gf180mcu_as_sc_mcu7t3v3__buff_12
Xfanout582 VDD VDD VSS VSS _5946_/B _5953_/B gf180mcu_as_sc_mcu7t3v3__buff_12
Xfanout593 VDD VDD VSS VSS _5584_/C _5568_/C gf180mcu_as_sc_mcu7t3v3__buff_12
XFILLER_150_1173 VDD VDD VSS VSS gf180mcu_as_sc_mcu7t3v3__fillcap_16
XFILLER_4_1259 VDD VDD VSS VSS gf180mcu_as_sc_mcu7t3v3__fillcap_4
XFILLER_15_842 VDD VDD VSS VSS gf180mcu_as_sc_mcu7t3v3__fillcap_16
XPHY_EDGE_ROW_131_2_Right_968 VDD VSS gf180mcu_as_sc_mcu7t3v3__tap_2
XFILLER_202_431 VDD VDD VSS VSS gf180mcu_as_sc_mcu7t3v3__fill_2
XFILLER_203_976 VDD VDD VSS VSS gf180mcu_as_sc_mcu7t3v3__fillcap_4
XFILLER_159_346 VDD VDD VSS VSS gf180mcu_as_sc_mcu7t3v3__fillcap_4
XFILLER_187_677 VDD VDD VSS VSS gf180mcu_as_sc_mcu7t3v3__fillcap_4
XFILLER_203_998 VDD VDD VSS VSS gf180mcu_as_sc_mcu7t3v3__fillcap_16
XFILLER_222_1119 VDD VDD VSS VSS gf180mcu_as_sc_mcu7t3v3__fillcap_16
XFILLER_122_1231 VDD VDD VSS VSS gf180mcu_as_sc_mcu7t3v3__fillcap_8
Xwire950 VDD VDD VSS VSS wire950/A _5944_/A gf180mcu_as_sc_mcu7t3v3__clkbuff_12
Xwire961 VDD VDD VSS VSS wire961/A _5764_/A gf180mcu_as_sc_mcu7t3v3__clkbuff_12
XFILLER_155_552 VDD VDD VSS VSS gf180mcu_as_sc_mcu7t3v3__fillcap_8
XFILLER_170_500 VDD VDD VSS VSS gf180mcu_as_sc_mcu7t3v3__fill_2
Xwire994 VDD VDD VSS VSS wire994/A _5310_/A gf180mcu_as_sc_mcu7t3v3__clkbuff_12
X_3480_ VDD VDD VSS VSS _3483_/B _3483_/A _5345_/B gf180mcu_as_sc_mcu7t3v3__and2_2
XFILLER_170_533 VDD VDD VSS VSS gf180mcu_as_sc_mcu7t3v3__fill_1
XFILLER_151_791 VDD VDD VSS VSS gf180mcu_as_sc_mcu7t3v3__fillcap_4
X_5150_ VDD VDD VSS VSS _5151_/D _5234_/B _5195_/B _5150_/A gf180mcu_as_sc_mcu7t3v3__aoi21_2
XFILLER_155_1084 VDD VDD VSS VSS gf180mcu_as_sc_mcu7t3v3__fillcap_16
XFILLER_42_1210 VDD VDD VSS VSS gf180mcu_as_sc_mcu7t3v3__fillcap_8
X_5081_ VDD VDD VSS VSS _5081_/B _5229_/A _6385_/D gf180mcu_as_sc_mcu7t3v3__and2_2
X_4101_ VDD VDD VSS VSS _4101_/S _6722_/A _6161_/Q _6161_/D gf180mcu_as_sc_mcu7t3v3__mux2_2
XFILLER_111_666 VDD VDD VSS VSS gf180mcu_as_sc_mcu7t3v3__fill_1
X_4032_ VDD VDD VSS VSS _4044_/B _6113_/Q _4033_/D gf180mcu_as_sc_mcu7t3v3__and2_2
XPHY_EDGE_ROW_93_2_Right_930 VDD VSS gf180mcu_as_sc_mcu7t3v3__tap_2
XFILLER_25_639 VDD VDD VSS VSS gf180mcu_as_sc_mcu7t3v3__fillcap_8
XFILLER_92_594 VDD VDD VSS VSS gf180mcu_as_sc_mcu7t3v3__fill_1
X_5983_ VDD VDD VSS VSS _6006_/B _6206_/Q _6496_/D gf180mcu_as_sc_mcu7t3v3__and2_2
XFILLER_206_770 VDD VDD VSS VSS gf180mcu_as_sc_mcu7t3v3__fill_2
X_4934_ VDD VDD VSS VSS _5918_/A _4957_/B _4934_/C _4934_/D _4935_/C gf180mcu_as_sc_mcu7t3v3__ao22_2
XTAP_TAPCELL_ROW_83_2_2973 VDD VSS gf180mcu_as_sc_mcu7t3v3__tap_2
XFILLER_162_1033 VDD VDD VSS VSS gf180mcu_as_sc_mcu7t3v3__fillcap_16
XANTENNA_12 VDD VDD VSS VSS _4698_/B gf180mcu_as_sc_mcu7t3v3__diode_2
XANTENNA_23 VDD VDD VSS VSS _5163_/A gf180mcu_as_sc_mcu7t3v3__diode_2
XFILLER_193_603 VDD VDD VSS VSS gf180mcu_as_sc_mcu7t3v3__fill_2
XFILLER_220_261 VDD VDD VSS VSS gf180mcu_as_sc_mcu7t3v3__fill_2
X_4865_ VDD VDD VSS VSS _4865_/B _5978_/A _6363_/D gf180mcu_as_sc_mcu7t3v3__and2_2
XANTENNA_34 VDD VDD VSS VSS _6410_/D gf180mcu_as_sc_mcu7t3v3__diode_2
XANTENNA_45 VDD VDD VSS VSS _4924_/B gf180mcu_as_sc_mcu7t3v3__diode_2
XFILLER_177_187 VDD VDD VSS VSS gf180mcu_as_sc_mcu7t3v3__fillcap_8
XFILLER_193_636 VDD VDD VSS VSS gf180mcu_as_sc_mcu7t3v3__fill_1
XFILLER_203_1030 VDD VDD VSS VSS gf180mcu_as_sc_mcu7t3v3__fillcap_16
X_4796_ VDD VDD VSS VSS _5802_/A _4796_/B _4796_/C _4796_/D _4797_/B gf180mcu_as_sc_mcu7t3v3__ao211_2
X_3816_ VDD VDD VSS VSS _3889_/B _5805_/A _3817_/D gf180mcu_as_sc_mcu7t3v3__and2_2
XFILLER_165_349 VDD VDD VSS VSS gf180mcu_as_sc_mcu7t3v3__fill_1
XFILLER_203_1052 VDD VDD VSS VSS gf180mcu_as_sc_mcu7t3v3__fillcap_16
XFILLER_21_27 VDD VDD VSS VSS gf180mcu_as_sc_mcu7t3v3__fillcap_16
X_6535_ VDD VDD VSS VSS _6546_/CLK _6535_/D _6535_/Q gf180mcu_as_sc_mcu7t3v3__dfxtp_2
X_3747_ VDD VDD VSS VSS _5749_/B _3804_/C _3747_/C _3747_/D _3749_/C gf180mcu_as_sc_mcu7t3v3__ao211_2
XFILLER_137_27 VDD VDD VSS VSS gf180mcu_as_sc_mcu7t3v3__fillcap_16
XFILLER_173_360 VDD VDD VSS VSS gf180mcu_as_sc_mcu7t3v3__fill_1
X_6466_ VDD VDD VSS VSS _6474_/CLK _6466_/D _6466_/Q gf180mcu_as_sc_mcu7t3v3__dfxtp_2
X_3678_ VDD VDD VSS VSS _6017_/D _3678_/C _3830_/D _4021_/A gf180mcu_as_sc_mcu7t3v3__ao21b_2
XTAP_TAPCELL_ROW_210_2528 VDD VSS gf180mcu_as_sc_mcu7t3v3__tap_2
XTAP_TAPCELL_ROW_210_2517 VDD VSS gf180mcu_as_sc_mcu7t3v3__tap_2
XFILLER_161_544 VDD VDD VSS VSS gf180mcu_as_sc_mcu7t3v3__fillcap_16
XFILLER_161_566 VDD VDD VSS VSS gf180mcu_as_sc_mcu7t3v3__fill_1
X_6397_ VDD VDD VSS VSS clkload3/A _6397_/D _6397_/Q gf180mcu_as_sc_mcu7t3v3__dfxtp_2
X_5417_ VDD VDD VSS VSS _5725_/A _5565_/B _5566_/B _5417_/D _5419_/C gf180mcu_as_sc_mcu7t3v3__ao211_2
XPHY_EDGE_ROW_137_3_Left_842 VDD VSS gf180mcu_as_sc_mcu7t3v3__tap_2
X_5348_ VDD VDD VSS VSS _5359_/C _5349_/A _5369_/A gf180mcu_as_sc_mcu7t3v3__and2_2
XTAP_TAPCELL_ROW_167_1748 VDD VSS gf180mcu_as_sc_mcu7t3v3__tap_2
X_5279_ VDD VDD VSS VSS _5280_/C _5279_/C _5279_/B _5297_/A gf180mcu_as_sc_mcu7t3v3__aoi21_2
XTAP_TAPCELL_ROW_208_2479 VDD VSS gf180mcu_as_sc_mcu7t3v3__tap_2
XTAP_TAPCELL_ROW_225_2793 VDD VSS gf180mcu_as_sc_mcu7t3v3__tap_2
XFILLER_204_718 VDD VDD VSS VSS gf180mcu_as_sc_mcu7t3v3__fill_1
XFILLER_216_567 VDD VDD VSS VSS gf180mcu_as_sc_mcu7t3v3__fillcap_16
XFILLER_83_594 VDD VDD VSS VSS gf180mcu_as_sc_mcu7t3v3__fill_2
XFILLER_58_1261 VDD VDD VSS VSS gf180mcu_as_sc_mcu7t3v3__fillcap_4
XTAP_TAPCELL_ROW_18_3_2876 VDD VSS gf180mcu_as_sc_mcu7t3v3__tap_2
XFILLER_62_45 VDD VDD VSS VSS gf180mcu_as_sc_mcu7t3v3__fillcap_4
XFILLER_106_1226 VDD VDD VSS VSS gf180mcu_as_sc_mcu7t3v3__fillcap_16
XFILLER_12_823 VDD VDD VSS VSS gf180mcu_as_sc_mcu7t3v3__fillcap_16
XFILLER_178_34 VDD VDD VSS VSS gf180mcu_as_sc_mcu7t3v3__fill_1
XFILLER_178_45 VDD VDD VSS VSS gf180mcu_as_sc_mcu7t3v3__fillcap_4
XFILLER_157_839 VDD VDD VSS VSS gf180mcu_as_sc_mcu7t3v3__fill_1
XFILLER_156_349 VDD VDD VSS VSS gf180mcu_as_sc_mcu7t3v3__fill_1
XFILLER_183_146 VDD VDD VSS VSS gf180mcu_as_sc_mcu7t3v3__fill_2
XFILLER_200_979 VDD VDD VSS VSS gf180mcu_as_sc_mcu7t3v3__fillcap_16
XFILLER_194_33 VDD VDD VSS VSS gf180mcu_as_sc_mcu7t3v3__fill_2
XFILLER_137_596 VDD VDD VSS VSS gf180mcu_as_sc_mcu7t3v3__fill_1
XFILLER_152_522 VDD VDD VSS VSS gf180mcu_as_sc_mcu7t3v3__fill_2
XFILLER_164_382 VDD VDD VSS VSS gf180mcu_as_sc_mcu7t3v3__fill_2
XPHY_EDGE_ROW_69_3_Left_774 VDD VSS gf180mcu_as_sc_mcu7t3v3__tap_2
XFILLER_65_1210 VDD VDD VSS VSS gf180mcu_as_sc_mcu7t3v3__fillcap_4
XFILLER_3_587 VDD VDD VSS VSS gf180mcu_as_sc_mcu7t3v3__fill_2
XFILLER_65_1232 VDD VDD VSS VSS gf180mcu_as_sc_mcu7t3v3__fill_1
XFILLER_191_1262 VDD VDD VSS VSS gf180mcu_as_sc_mcu7t3v3__fill_2
XPHY_EDGE_ROW_128_2_Left_569 VDD VSS gf180mcu_as_sc_mcu7t3v3__tap_2
XPHY_EDGE_ROW_65_2_Left_506 VDD VSS gf180mcu_as_sc_mcu7t3v3__tap_2
XFILLER_179_419 VDD VDD VSS VSS gf180mcu_as_sc_mcu7t3v3__fill_1
XTAP_TAPCELL_ROW_5_1095 VDD VSS gf180mcu_as_sc_mcu7t3v3__tap_2
XFILLER_203_740 VDD VDD VSS VSS gf180mcu_as_sc_mcu7t3v3__fill_1
XFILLER_72_1214 VDD VDD VSS VSS gf180mcu_as_sc_mcu7t3v3__fill_2
XPHY_EDGE_ROW_132_2_Right_969 VDD VSS gf180mcu_as_sc_mcu7t3v3__tap_2
XFILLER_14_171 VDD VDD VSS VSS gf180mcu_as_sc_mcu7t3v3__fillcap_4
XFILLER_187_430 VDD VDD VSS VSS gf180mcu_as_sc_mcu7t3v3__fill_2
XFILLER_14_193 VDD VDD VSS VSS gf180mcu_as_sc_mcu7t3v3__fillcap_16
X_4650_ VDD VDD VSS VSS _4655_/B _4655_/A _4967_/B gf180mcu_as_sc_mcu7t3v3__and2_2
XFILLER_163_809 VDD VDD VSS VSS gf180mcu_as_sc_mcu7t3v3__fill_2
Xinput10 VDD VDD VSS VSS boot_addr[2] _3244_/B gf180mcu_as_sc_mcu7t3v3__buff_12
Xinput21 VDD VDD VSS VSS boot_data[3] _3093_/A gf180mcu_as_sc_mcu7t3v3__buff_12
X_3601_ VDD VDD VSS VSS _5325_/A _3631_/A _5921_/A _5329_/A _5930_/A gf180mcu_as_sc_mcu7t3v3__aoi22_2
XFILLER_156_850 VDD VDD VSS VSS gf180mcu_as_sc_mcu7t3v3__fillcap_8
Xinput32 VDD VDD VSS VSS dft_addr[3] _3259_/A gf180mcu_as_sc_mcu7t3v3__buff_12
Xinput43 VDD VDD VSS VSS dft_wdata[2] _3325_/B gf180mcu_as_sc_mcu7t3v3__buff_12
Xinput54 VDD VDD VSS VSS east_in[13] _5781_/A gf180mcu_as_sc_mcu7t3v3__buff_12
X_6320_ VDD VDD VSS VSS _6552_/CLK _6320_/D _6320_/Q gf180mcu_as_sc_mcu7t3v3__dfxtp_2
X_4581_ VDD VDD VSS VSS _4581_/A _4581_/B _4583_/B _6315_/Q _6315_/D gf180mcu_as_sc_mcu7t3v3__ao22_2
XFILLER_196_1151 VDD VDD VSS VSS gf180mcu_as_sc_mcu7t3v3__fillcap_4
XFILLER_196_1173 VDD VDD VSS VSS gf180mcu_as_sc_mcu7t3v3__fillcap_16
Xinput65 VDD VDD VSS VSS east_in[23] _5861_/A gf180mcu_as_sc_mcu7t3v3__buff_12
Xinput76 VDD VDD VSS VSS east_in[33] wire950/A gf180mcu_as_sc_mcu7t3v3__buff_12
Xinput87 VDD VDD VSS VSS ne_in[10] _5756_/A gf180mcu_as_sc_mcu7t3v3__buff_12
Xinput98 VDD VDD VSS VSS ne_in[20] _5837_/A gf180mcu_as_sc_mcu7t3v3__buff_12
X_3532_ VDD VDD VSS VSS _5339_/A _5911_/A _3532_/C _3532_/D _5337_/C gf180mcu_as_sc_mcu7t3v3__ao211_2
X_6251_ VDD VDD VSS VSS _6313_/CLK _6251_/D _6251_/Q gf180mcu_as_sc_mcu7t3v3__dfxtp_2
X_3463_ VDD VDD VSS VSS _5936_/D _3463_/B _3463_/C _5943_/D _4634_/C gf180mcu_as_sc_mcu7t3v3__ao22_2
X_6182_ VDD VDD VSS VSS _6490_/CLK _6182_/D _6182_/Q gf180mcu_as_sc_mcu7t3v3__dfxtp_2
X_5202_ VDD VDD VSS VSS _5203_/D _5855_/A _5202_/B _5205_/B gf180mcu_as_sc_mcu7t3v3__ao21_2
XTAP_TAPCELL_ROW_149_1401 VDD VSS gf180mcu_as_sc_mcu7t3v3__tap_2
XTAP_TAPCELL_ROW_149_1412 VDD VSS gf180mcu_as_sc_mcu7t3v3__tap_2
XTAP_TAPCELL_ROW_149_1423 VDD VSS gf180mcu_as_sc_mcu7t3v3__tap_2
Xload_slew741 VDD VDD VSS VSS _5361_/Y _5532_/C gf180mcu_as_sc_mcu7t3v3__clkbuff_12
X_5133_ VDD VDD VSS VSS _6507_/Q _5142_/B _5133_/C _5133_/D _5135_/C gf180mcu_as_sc_mcu7t3v3__ao22_2
X_3394_ VDD VDD VSS VSS _3396_/D _3394_/B _6264_/Q gf180mcu_as_sc_mcu7t3v3__nor2_2
XTAP_TAPCELL_ROW_184_2048 VDD VSS gf180mcu_as_sc_mcu7t3v3__tap_2
XFILLER_97_664 VDD VDD VSS VSS gf180mcu_as_sc_mcu7t3v3__fill_2
XTAP_TAPCELL_ROW_184_2059 VDD VSS gf180mcu_as_sc_mcu7t3v3__tap_2
X_5064_ VDD VDD VSS VSS _5731_/A _5183_/B _5203_/C _5734_/A _5066_/B gf180mcu_as_sc_mcu7t3v3__ao22_2
XPHY_EDGE_ROW_94_2_Right_931 VDD VSS gf180mcu_as_sc_mcu7t3v3__tap_2
XTAP_TAPCELL_ROW_130_2_3043 VDD VSS gf180mcu_as_sc_mcu7t3v3__tap_2
X_4015_ VDD VDD VSS VSS _5960_/A _5958_/A _5963_/A _4015_/Y gf180mcu_as_sc_mcu7t3v3__nor3_2
XFILLER_65_594 VDD VDD VSS VSS gf180mcu_as_sc_mcu7t3v3__fill_1
XPHY_EDGE_ROW_118_1_Right_690 VDD VSS gf180mcu_as_sc_mcu7t3v3__tap_2
XTAP_TAPCELL_ROW_162_1656 VDD VSS gf180mcu_as_sc_mcu7t3v3__tap_2
XFILLER_16_27 VDD VDD VSS VSS gf180mcu_as_sc_mcu7t3v3__fillcap_4
XFILLER_197_205 VDD VDD VSS VSS gf180mcu_as_sc_mcu7t3v3__fillcap_4
XTAP_TAPCELL_ROW_203_2387 VDD VSS gf180mcu_as_sc_mcu7t3v3__tap_2
XFILLER_213_559 VDD VDD VSS VSS gf180mcu_as_sc_mcu7t3v3__fill_1
X_5966_ VDD VDD VSS VSS _5967_/B _5972_/C _5966_/B _6489_/Q gf180mcu_as_sc_mcu7t3v3__aoi21_2
XTAP_TAPCELL_ROW_203_2398 VDD VSS gf180mcu_as_sc_mcu7t3v3__tap_2
X_5897_ VDD VDD VSS VSS _5921_/A _5936_/B _5930_/C _5897_/D _5898_/D gf180mcu_as_sc_mcu7t3v3__ao22_2
X_4917_ VDD VDD VSS VSS _4933_/B _5903_/A _4918_/B gf180mcu_as_sc_mcu7t3v3__or2_2
XFILLER_193_400 VDD VDD VSS VSS gf180mcu_as_sc_mcu7t3v3__fillcap_4
XFILLER_193_411 VDD VDD VSS VSS gf180mcu_as_sc_mcu7t3v3__fillcap_8
XFILLER_21_664 VDD VDD VSS VSS gf180mcu_as_sc_mcu7t3v3__fill_2
XFILLER_32_37 VDD VDD VSS VSS gf180mcu_as_sc_mcu7t3v3__fillcap_8
X_4848_ VDD VDD VSS VSS _4849_/C _4877_/B _5847_/A gf180mcu_as_sc_mcu7t3v3__nor2_2
XFILLER_148_37 VDD VDD VSS VSS gf180mcu_as_sc_mcu7t3v3__fillcap_8
XFILLER_193_422 VDD VDD VSS VSS gf180mcu_as_sc_mcu7t3v3__fillcap_16
XFILLER_88_1210 VDD VDD VSS VSS gf180mcu_as_sc_mcu7t3v3__fill_2
X_4779_ VDD VDD VSS VSS _4797_/S _4779_/B _5788_/A _4780_/B gf180mcu_as_sc_mcu7t3v3__mux2_2
XFILLER_10_1017 VDD VDD VSS VSS gf180mcu_as_sc_mcu7t3v3__fillcap_16
XFILLER_228_70 VDD VDD VSS VSS gf180mcu_as_sc_mcu7t3v3__fillcap_4
X_6518_ VDD VDD VSS VSS _6518_/CLK _6518_/D _6518_/Q gf180mcu_as_sc_mcu7t3v3__dfxtp_2
XFILLER_161_330 VDD VDD VSS VSS gf180mcu_as_sc_mcu7t3v3__fillcap_16
XFILLER_175_1224 VDD VDD VSS VSS gf180mcu_as_sc_mcu7t3v3__fillcap_16
X_6449_ VDD VDD VSS VSS clkload4/A _6449_/D _6449_/Q gf180mcu_as_sc_mcu7t3v3__dfxtp_2
XFILLER_216_1221 VDD VDD VSS VSS gf180mcu_as_sc_mcu7t3v3__fillcap_4
XFILLER_161_396 VDD VDD VSS VSS gf180mcu_as_sc_mcu7t3v3__fillcap_16
XFILLER_164_69 VDD VDD VSS VSS gf180mcu_as_sc_mcu7t3v3__fillcap_16
XFILLER_216_1243 VDD VDD VSS VSS gf180mcu_as_sc_mcu7t3v3__fillcap_16
XTAP_TAPCELL_ROW_227_2833 VDD VSS gf180mcu_as_sc_mcu7t3v3__tap_2
XTAP_TAPCELL_ROW_227_2822 VDD VSS gf180mcu_as_sc_mcu7t3v3__tap_2
XFILLER_217_832 VDD VDD VSS VSS gf180mcu_as_sc_mcu7t3v3__fill_1
XFILLER_56_594 VDD VDD VSS VSS gf180mcu_as_sc_mcu7t3v3__fillcap_4
XFILLER_182_1239 VDD VDD VSS VSS gf180mcu_as_sc_mcu7t3v3__fill_1
XFILLER_12_664 VDD VDD VSS VSS gf180mcu_as_sc_mcu7t3v3__fill_1
XFILLER_212_581 VDD VDD VSS VSS gf180mcu_as_sc_mcu7t3v3__fillcap_8
XFILLER_11_174 VDD VDD VSS VSS gf180mcu_as_sc_mcu7t3v3__fillcap_16
XFILLER_12_675 VDD VDD VSS VSS gf180mcu_as_sc_mcu7t3v3__fill_2
XFILLER_184_477 VDD VDD VSS VSS gf180mcu_as_sc_mcu7t3v3__fill_2
XFILLER_185_978 VDD VDD VSS VSS gf180mcu_as_sc_mcu7t3v3__fill_2
XFILLER_208_18 VDD VDD VSS VSS gf180mcu_as_sc_mcu7t3v3__fillcap_16
XFILLER_153_842 VDD VDD VSS VSS gf180mcu_as_sc_mcu7t3v3__fillcap_4
XFILLER_79_664 VDD VDD VSS VSS gf180mcu_as_sc_mcu7t3v3__fill_2
XFILLER_152_1065 VDD VDD VSS VSS gf180mcu_as_sc_mcu7t3v3__fillcap_16
XFILLER_152_1087 VDD VDD VSS VSS gf180mcu_as_sc_mcu7t3v3__fillcap_16
XTAP_TAPCELL_ROW_7_1135 VDD VSS gf180mcu_as_sc_mcu7t3v3__tap_2
XTAP_TAPCELL_ROW_7_1146 VDD VSS gf180mcu_as_sc_mcu7t3v3__tap_2
XFILLER_47_594 VDD VDD VSS VSS gf180mcu_as_sc_mcu7t3v3__fillcap_4
XFILLER_16_970 VDD VDD VSS VSS gf180mcu_as_sc_mcu7t3v3__fillcap_16
XFILLER_222_323 VDD VDD VSS VSS gf180mcu_as_sc_mcu7t3v3__fill_1
XFILLER_228_1169 VDD VDD VSS VSS gf180mcu_as_sc_mcu7t3v3__fillcap_4
X_5820_ VDD VDD VSS VSS _5820_/B _5836_/A _6466_/D gf180mcu_as_sc_mcu7t3v3__and2_2
X_5751_ VDD VDD VSS VSS _5751_/A _5800_/B _5751_/C _5751_/D _5753_/C gf180mcu_as_sc_mcu7t3v3__ao211_2
X_4702_ VDD VDD VSS VSS _5714_/A _4795_/C _4924_/B _5718_/A _4703_/D gf180mcu_as_sc_mcu7t3v3__ao22_2
XFILLER_175_422 VDD VDD VSS VSS gf180mcu_as_sc_mcu7t3v3__fillcap_16
XFILLER_187_282 VDD VDD VSS VSS gf180mcu_as_sc_mcu7t3v3__fill_2
X_5682_ VDD VDD VSS VSS _5798_/S _5682_/B _6494_/Q _5683_/C gf180mcu_as_sc_mcu7t3v3__mux2_2
XFILLER_159_1208 VDD VDD VSS VSS gf180mcu_as_sc_mcu7t3v3__fillcap_16
XFILLER_190_403 VDD VDD VSS VSS gf180mcu_as_sc_mcu7t3v3__fillcap_8
XFILLER_198_1235 VDD VDD VSS VSS gf180mcu_as_sc_mcu7t3v3__fillcap_4
XFILLER_200_1011 VDD VDD VSS VSS gf180mcu_as_sc_mcu7t3v3__fillcap_4
X_4633_ VDD VDD VSS VSS _4647_/B _5346_/A _4984_/C _4638_/B gf180mcu_as_sc_mcu7t3v3__ao21_2
XFILLER_190_425 VDD VDD VSS VSS gf180mcu_as_sc_mcu7t3v3__fill_2
XFILLER_200_1033 VDD VDD VSS VSS gf180mcu_as_sc_mcu7t3v3__fillcap_16
X_4564_ VDD VDD VSS VSS _4565_/C _4564_/B _6308_/Q gf180mcu_as_sc_mcu7t3v3__nor2_2
XFILLER_155_190 VDD VDD VSS VSS gf180mcu_as_sc_mcu7t3v3__fillcap_16
X_6303_ VDD VDD VSS VSS clkload8/A _6303_/D _6303_/Q gf180mcu_as_sc_mcu7t3v3__dfxtp_2
X_3515_ VDD VDD VSS VSS _4628_/A _4977_/A _5951_/A gf180mcu_as_sc_mcu7t3v3__nand2b_2
X_6234_ VDD VDD VSS VSS _6316_/CLK _6234_/D _6234_/Q gf180mcu_as_sc_mcu7t3v3__dfxtp_2
X_4495_ VDD VDD VSS VSS _4495_/A _4512_/S _4499_/C _4495_/D _4496_/C gf180mcu_as_sc_mcu7t3v3__ao22_2
XFILLER_170_171 VDD VDD VSS VSS gf180mcu_as_sc_mcu7t3v3__fillcap_4
XFILLER_170_193 VDD VDD VSS VSS gf180mcu_as_sc_mcu7t3v3__fillcap_8
X_3446_ VDD VDD VSS VSS _6550_/D _3455_/B _6328_/Q _6327_/D gf180mcu_as_sc_mcu7t3v3__mux2_2
X_6165_ VDD VDD VSS VSS _6526_/CLK _6165_/D _6165_/Q gf180mcu_as_sc_mcu7t3v3__dfxtp_2
X_3377_ VDD VDD VSS VSS _3389_/A _3438_/A _3438_/D gf180mcu_as_sc_mcu7t3v3__nand2b_2
XTAP_TAPCELL_ROW_148_2_3070 VDD VSS gf180mcu_as_sc_mcu7t3v3__tap_2
X_6096_ VDD VDD VSS VSS _6125_/CLK _6096_/D _6096_/Q gf180mcu_as_sc_mcu7t3v3__dfxtp_2
X_5116_ VDD VDD VSS VSS _5777_/A _5217_/S _5226_/C _5772_/A _5117_/D gf180mcu_as_sc_mcu7t3v3__ao22_2
XTAP_TAPCELL_ROW_71_2_2955 VDD VSS gf180mcu_as_sc_mcu7t3v3__tap_2
X_5047_ VDD VDD VSS VSS _5049_/C _5715_/A _5140_/B _5047_/C gf180mcu_as_sc_mcu7t3v3__ao21_2
XTAP_TAPCELL_ROW_205_2438 VDD VSS gf180mcu_as_sc_mcu7t3v3__tap_2
XTAP_TAPCELL_ROW_205_2427 VDD VSS gf180mcu_as_sc_mcu7t3v3__tap_2
XFILLER_217_139 VDD VDD VSS VSS gf180mcu_as_sc_mcu7t3v3__fill_1
XTAP_TAPCELL_ROW_222_2741 VDD VSS gf180mcu_as_sc_mcu7t3v3__tap_2
XTAP_TAPCELL_ROW_222_2730 VDD VSS gf180mcu_as_sc_mcu7t3v3__tap_2
XFILLER_38_594 VDD VDD VSS VSS gf180mcu_as_sc_mcu7t3v3__fillcap_8
XPHY_EDGE_ROW_119_1_Right_691 VDD VSS gf180mcu_as_sc_mcu7t3v3__tap_2
XPHY_EDGE_ROW_95_2_Right_932 VDD VSS gf180mcu_as_sc_mcu7t3v3__tap_2
XFILLER_213_312 VDD VDD VSS VSS gf180mcu_as_sc_mcu7t3v3__fill_1
XFILLER_198_547 VDD VDD VSS VSS gf180mcu_as_sc_mcu7t3v3__fill_2
X_5949_ VDD VDD VSS VSS _5949_/B _5956_/A _6482_/D gf180mcu_as_sc_mcu7t3v3__and2_2
XFILLER_16_1226 VDD VDD VSS VSS gf180mcu_as_sc_mcu7t3v3__fillcap_4
XTAP_TAPCELL_ROW_179_1972 VDD VSS gf180mcu_as_sc_mcu7t3v3__tap_2
XTAP_TAPCELL_ROW_179_1961 VDD VSS gf180mcu_as_sc_mcu7t3v3__tap_2
XFILLER_142_1245 VDD VDD VSS VSS gf180mcu_as_sc_mcu7t3v3__fillcap_16
XFILLER_194_753 VDD VDD VSS VSS gf180mcu_as_sc_mcu7t3v3__fillcap_16
XFILLER_193_230 VDD VDD VSS VSS gf180mcu_as_sc_mcu7t3v3__fill_1
XFILLER_150_823 VDD VDD VSS VSS gf180mcu_as_sc_mcu7t3v3__fill_2
XFILLER_68_33 VDD VDD VSS VSS gf180mcu_as_sc_mcu7t3v3__fill_2
Xinput200 VDD VDD VSS VSS se_in[14] _5794_/A gf180mcu_as_sc_mcu7t3v3__buff_12
Xinput211 VDD VDD VSS VSS se_in[24] _5869_/A gf180mcu_as_sc_mcu7t3v3__buff_12
XFILLER_0_376 VDD VDD VSS VSS gf180mcu_as_sc_mcu7t3v3__fillcap_8
XFILLER_191_67 VDD VDD VSS VSS gf180mcu_as_sc_mcu7t3v3__fill_2
Xinput222 VDD VDD VSS VSS se_in[34] _5954_/A gf180mcu_as_sc_mcu7t3v3__buff_12
Xinput233 VDD VDD VSS VSS south_in[11] _5766_/A gf180mcu_as_sc_mcu7t3v3__buff_12
Xinput244 VDD VDD VSS VSS south_in[21] _5847_/A gf180mcu_as_sc_mcu7t3v3__buff_12
Xinput255 VDD VDD VSS VSS south_in[31] wire995/A gf180mcu_as_sc_mcu7t3v3__buff_12
Xinput266 VDD VDD VSS VSS south_in[9] _5750_/A gf180mcu_as_sc_mcu7t3v3__buff_12
Xinput277 VDD VDD VSS VSS sw_in[19] _5835_/A gf180mcu_as_sc_mcu7t3v3__buff_12
Xinput288 VDD VDD VSS VSS sw_in[29] _3632_/B gf180mcu_as_sc_mcu7t3v3__buff_12
XFILLER_208_139 VDD VDD VSS VSS gf180mcu_as_sc_mcu7t3v3__fillcap_16
XPHY_EDGE_ROW_30_3_Right_110 VDD VSS gf180mcu_as_sc_mcu7t3v3__tap_2
Xinput299 VDD VDD VSS VSS sw_in[6] wire984/A gf180mcu_as_sc_mcu7t3v3__buff_12
XFILLER_16_222 VDD VDD VSS VSS gf180mcu_as_sc_mcu7t3v3__fillcap_16
XFILLER_29_594 VDD VDD VSS VSS gf180mcu_as_sc_mcu7t3v3__fillcap_4
XFILLER_182_1014 VDD VDD VSS VSS gf180mcu_as_sc_mcu7t3v3__fill_1
XTAP_TAPCELL_ROW_2_1054 VDD VSS gf180mcu_as_sc_mcu7t3v3__tap_2
XTAP_TAPCELL_ROW_2_1043 VDD VSS gf180mcu_as_sc_mcu7t3v3__tap_2
XFILLER_169_293 VDD VDD VSS VSS gf180mcu_as_sc_mcu7t3v3__fillcap_8
XFILLER_9_944 VDD VDD VSS VSS gf180mcu_as_sc_mcu7t3v3__fillcap_16
XFILLER_12_494 VDD VDD VSS VSS gf180mcu_as_sc_mcu7t3v3__fill_2
XFILLER_157_477 VDD VDD VSS VSS gf180mcu_as_sc_mcu7t3v3__fill_1
XFILLER_8_454 VDD VDD VSS VSS gf180mcu_as_sc_mcu7t3v3__fill_1
XFILLER_145_628 VDD VDD VSS VSS gf180mcu_as_sc_mcu7t3v3__fillcap_16
XFILLER_173_937 VDD VDD VSS VSS gf180mcu_as_sc_mcu7t3v3__fill_1
XFILLER_184_274 VDD VDD VSS VSS gf180mcu_as_sc_mcu7t3v3__fill_1
XFILLER_153_672 VDD VDD VSS VSS gf180mcu_as_sc_mcu7t3v3__fill_1
XFILLER_193_1154 VDD VDD VSS VSS gf180mcu_as_sc_mcu7t3v3__fillcap_16
X_3300_ VDD VDD VSS VSS _3300_/Y _6137_/Q _6136_/Q gf180mcu_as_sc_mcu7t3v3__nor2b_2
XFILLER_152_171 VDD VDD VSS VSS gf180mcu_as_sc_mcu7t3v3__fillcap_4
XFILLER_152_193 VDD VDD VSS VSS gf180mcu_as_sc_mcu7t3v3__fillcap_16
X_4280_ VDD VDD VSS VSS _4977_/A _4280_/B _4280_/C _4280_/D _4283_/B gf180mcu_as_sc_mcu7t3v3__ao211_2
X_3231_ VDD VDD VSS VSS _4610_/B _3231_/B _3404_/A gf180mcu_as_sc_mcu7t3v3__nand2_2
X_3162_ VDD VDD VSS VSS _4146_/S _6163_/Q _3427_/B gf180mcu_as_sc_mcu7t3v3__and2_2
XTAP_TAPCELL_ROW_181_2007 VDD VSS gf180mcu_as_sc_mcu7t3v3__tap_2
XFILLER_228_949 VDD VDD VSS VSS gf180mcu_as_sc_mcu7t3v3__fill_2
X_3093_ VDD VDD VSS VSS _3331_/B _3093_/A gf180mcu_as_sc_mcu7t3v3__inv_2
XPHY_EDGE_ROW_21_3_Left_726 VDD VSS gf180mcu_as_sc_mcu7t3v3__tap_2
X_5803_ VDD VDD VSS VSS _5844_/B _5803_/B _5803_/C _5804_/C gf180mcu_as_sc_mcu7t3v3__nor3_2
XTAP_TAPCELL_ROW_200_2346 VDD VSS gf180mcu_as_sc_mcu7t3v3__tap_2
XTAP_TAPCELL_ROW_200_2335 VDD VSS gf180mcu_as_sc_mcu7t3v3__tap_2
XFILLER_211_838 VDD VDD VSS VSS gf180mcu_as_sc_mcu7t3v3__fill_2
XFILLER_223_687 VDD VDD VSS VSS gf180mcu_as_sc_mcu7t3v3__fill_1
XPHY_EDGE_ROW_146_3_Left_851 VDD VSS gf180mcu_as_sc_mcu7t3v3__tap_2
X_3995_ VDD VDD VSS VSS _4031_/B _4002_/B _4002_/C _6083_/Q _6083_/D gf180mcu_as_sc_mcu7t3v3__ao22_2
XTAP_TAPCELL_ROW_196_2272 VDD VSS gf180mcu_as_sc_mcu7t3v3__tap_2
XTAP_TAPCELL_ROW_196_2261 VDD VSS gf180mcu_as_sc_mcu7t3v3__tap_2
XFILLER_200_85 VDD VDD VSS VSS gf180mcu_as_sc_mcu7t3v3__fillcap_16
Xsram2048.u_bank1_1035 VDD VDD VSS VSS sram2048.u_bank1/WEN[1] gf180mcu_as_sc_mcu7t3v3__tiel_4
X_5734_ VDD VDD VSS VSS _5734_/A _5856_/B _5734_/C _5734_/D _5736_/C gf180mcu_as_sc_mcu7t3v3__ao211_2
XTAP_TAPCELL_ROW_157_1566 VDD VSS gf180mcu_as_sc_mcu7t3v3__tap_2
X_5665_ VDD VDD VSS VSS _5957_/A _5957_/B _5665_/Y gf180mcu_as_sc_mcu7t3v3__and2_2
XFILLER_175_263 VDD VDD VSS VSS gf180mcu_as_sc_mcu7t3v3__fillcap_4
XFILLER_198_1065 VDD VDD VSS VSS gf180mcu_as_sc_mcu7t3v3__fillcap_16
XTAP_TAPCELL_ROW_174_1880 VDD VSS gf180mcu_as_sc_mcu7t3v3__tap_2
X_4616_ VDD VDD VSS VSS _4617_/B _4617_/A _4976_/D gf180mcu_as_sc_mcu7t3v3__and2_2
XFILLER_163_447 VDD VDD VSS VSS gf180mcu_as_sc_mcu7t3v3__fillcap_8
XFILLER_163_469 VDD VDD VSS VSS gf180mcu_as_sc_mcu7t3v3__fill_2
XFILLER_190_244 VDD VDD VSS VSS gf180mcu_as_sc_mcu7t3v3__fill_1
XFILLER_198_1087 VDD VDD VSS VSS gf180mcu_as_sc_mcu7t3v3__fillcap_16
XFILLER_209_72 VDD VDD VSS VSS gf180mcu_as_sc_mcu7t3v3__fillcap_16
X_5596_ VDD VDD VSS VSS _5632_/B _5906_/D _5596_/A _5598_/C gf180mcu_as_sc_mcu7t3v3__mux2_2
XFILLER_144_661 VDD VDD VSS VSS gf180mcu_as_sc_mcu7t3v3__fillcap_4
XFILLER_190_266 VDD VDD VSS VSS gf180mcu_as_sc_mcu7t3v3__fill_1
X_4547_ VDD VDD VSS VSS _6303_/Q _4552_/B _4551_/C _6302_/Q _4548_/C gf180mcu_as_sc_mcu7t3v3__ao22_2
XFILLER_145_49 VDD VDD VSS VSS gf180mcu_as_sc_mcu7t3v3__fill_2
XFILLER_172_1205 VDD VDD VSS VSS gf180mcu_as_sc_mcu7t3v3__fillcap_16
XFILLER_172_1227 VDD VDD VSS VSS gf180mcu_as_sc_mcu7t3v3__fillcap_16
XTAP_TAPCELL_ROW_170_1799 VDD VSS gf180mcu_as_sc_mcu7t3v3__tap_2
X_4478_ VDD VDD VSS VSS _6277_/D _4478_/C _4478_/B _4478_/A gf180mcu_as_sc_mcu7t3v3__aoi21b_2
Xfanout901 VDD VDD VSS VSS _6266_/Q _4456_/A gf180mcu_as_sc_mcu7t3v3__buff_12
Xfanout912 VDD VDD VSS VSS _4307_/S _4370_/S gf180mcu_as_sc_mcu7t3v3__buff_12
Xfanout923 VDD VDD VSS VSS _5238_/A _5229_/A gf180mcu_as_sc_mcu7t3v3__buff_12
Xfanout934 VDD VDD VSS VSS _4912_/A _4826_/A gf180mcu_as_sc_mcu7t3v3__buff_12
X_6217_ VDD VDD VSS VSS _6365_/CLK _6217_/D _6217_/Q gf180mcu_as_sc_mcu7t3v3__dfxtp_2
X_3429_ VDD VDD VSS VSS _3429_/B _3429_/A _6549_/D gf180mcu_as_sc_mcu7t3v3__and2_2
XFILLER_213_1224 VDD VDD VSS VSS gf180mcu_as_sc_mcu7t3v3__fillcap_16
Xfanout945 VDD VDD VSS VSS _3011_/Y _5329_/A gf180mcu_as_sc_mcu7t3v3__buff_12
Xfanout956 VDD VDD VSS VSS input6/Y fanout956/Y gf180mcu_as_sc_mcu7t3v3__buff_12
Xfanout967 VDD VDD VSS VSS _5936_/D _4264_/A gf180mcu_as_sc_mcu7t3v3__buff_12
X_6148_ VDD VDD VSS VSS clkload8/A _6148_/D _6148_/Q gf180mcu_as_sc_mcu7t3v3__dfxtp_2
XTAP_TAPCELL_ROW_89_2_2982 VDD VSS gf180mcu_as_sc_mcu7t3v3__tap_2
XTAP_TAPCELL_ROW_16_1297 VDD VSS gf180mcu_as_sc_mcu7t3v3__tap_2
XTAP_TAPCELL_ROW_102_1_1372 VDD VSS gf180mcu_as_sc_mcu7t3v3__tap_2
Xclkbuf_leaf_28_clk_regs VDD VDD VSS VSS clkbuf_3_6_0_clk_regs/Y _6490_/CLK gf180mcu_as_sc_mcu7t3v3__clkbuff_12
X_6079_ VDD VDD VSS VSS _6525_/CLK _6079_/D _6079_/Q gf180mcu_as_sc_mcu7t3v3__dfxtp_2
XFILLER_173_6 VDD VDD VSS VSS gf180mcu_as_sc_mcu7t3v3__fillcap_16
XFILLER_227_982 VDD VDD VSS VSS gf180mcu_as_sc_mcu7t3v3__fillcap_16
Xhold1187 VDD VDD VSS VSS hold1218/Y hold1219/A gf180mcu_as_sc_mcu7t3v3__clkbuff_4
Xhold1198 VDD VDD VSS VSS hold1224/Y _6539_/D gf180mcu_as_sc_mcu7t3v3__clkbuff_4
XFILLER_14_715 VDD VDD VSS VSS gf180mcu_as_sc_mcu7t3v3__fill_2
XPHY_EDGE_ROW_96_2_Right_933 VDD VSS gf180mcu_as_sc_mcu7t3v3__tap_2
XFILLER_0_1081 VDD VDD VSS VSS gf180mcu_as_sc_mcu7t3v3__fill_2
XFILLER_14_737 VDD VDD VSS VSS gf180mcu_as_sc_mcu7t3v3__fillcap_4
XFILLER_213_153 VDD VDD VSS VSS gf180mcu_as_sc_mcu7t3v3__fill_1
XPHY_EDGE_ROW_78_3_Left_783 VDD VSS gf180mcu_as_sc_mcu7t3v3__tap_2
XFILLER_0_1092 VDD VDD VSS VSS gf180mcu_as_sc_mcu7t3v3__fill_1
XFILLER_186_517 VDD VDD VSS VSS gf180mcu_as_sc_mcu7t3v3__fill_1
XFILLER_213_175 VDD VDD VSS VSS gf180mcu_as_sc_mcu7t3v3__fillcap_4
XFILLER_201_359 VDD VDD VSS VSS gf180mcu_as_sc_mcu7t3v3__fillcap_4
XFILLER_70_34 VDD VDD VSS VSS gf180mcu_as_sc_mcu7t3v3__fill_1
XFILLER_166_241 VDD VDD VSS VSS gf180mcu_as_sc_mcu7t3v3__fillcap_4
XFILLER_167_753 VDD VDD VSS VSS gf180mcu_as_sc_mcu7t3v3__fillcap_4
XFILLER_210_871 VDD VDD VSS VSS gf180mcu_as_sc_mcu7t3v3__fillcap_4
XFILLER_70_45 VDD VDD VSS VSS gf180mcu_as_sc_mcu7t3v3__fillcap_4
XPHY_EDGE_ROW_137_2_Left_578 VDD VSS gf180mcu_as_sc_mcu7t3v3__tap_2
XFILLER_155_959 VDD VDD VSS VSS gf180mcu_as_sc_mcu7t3v3__fillcap_16
XFILLER_177_1116 VDD VDD VSS VSS gf180mcu_as_sc_mcu7t3v3__fillcap_4
XFILLER_177_1138 VDD VDD VSS VSS gf180mcu_as_sc_mcu7t3v3__fillcap_16
XFILLER_6_947 VDD VDD VSS VSS gf180mcu_as_sc_mcu7t3v3__fillcap_16
XFILLER_135_661 VDD VDD VSS VSS gf180mcu_as_sc_mcu7t3v3__fill_1
XFILLER_181_255 VDD VDD VSS VSS gf180mcu_as_sc_mcu7t3v3__fillcap_8
XFILLER_181_277 VDD VDD VSS VSS gf180mcu_as_sc_mcu7t3v3__fill_2
XPHY_EDGE_ROW_2_Left_231 VDD VSS gf180mcu_as_sc_mcu7t3v3__tap_2
XPHY_EDGE_ROW_74_2_Left_515 VDD VSS gf180mcu_as_sc_mcu7t3v3__tap_2
XFILLER_162_491 VDD VDD VSS VSS gf180mcu_as_sc_mcu7t3v3__fill_1
XFILLER_218_1135 VDD VDD VSS VSS gf180mcu_as_sc_mcu7t3v3__fillcap_16
XFILLER_218_1157 VDD VDD VSS VSS gf180mcu_as_sc_mcu7t3v3__fillcap_16
XFILLER_7_1224 VDD VDD VSS VSS gf180mcu_as_sc_mcu7t3v3__fillcap_16
XFILLER_221_18 VDD VDD VSS VSS gf180mcu_as_sc_mcu7t3v3__fillcap_16
XPHY_EDGE_ROW_31_3_Right_111 VDD VSS gf180mcu_as_sc_mcu7t3v3__tap_2
XFILLER_205_632 VDD VDD VSS VSS gf180mcu_as_sc_mcu7t3v3__fill_1
XFILLER_217_492 VDD VDD VSS VSS gf180mcu_as_sc_mcu7t3v3__fill_2
XFILLER_204_153 VDD VDD VSS VSS gf180mcu_as_sc_mcu7t3v3__fillcap_8
XFILLER_205_676 VDD VDD VSS VSS gf180mcu_as_sc_mcu7t3v3__fillcap_4
XTAP_TAPCELL_ROW_52_1_1347 VDD VSS gf180mcu_as_sc_mcu7t3v3__tap_2
X_3780_ VDD VDD VSS VSS _5778_/A _3892_/B _3780_/C _3780_/D _3781_/C gf180mcu_as_sc_mcu7t3v3__ao211_2
XFILLER_158_764 VDD VDD VSS VSS gf180mcu_as_sc_mcu7t3v3__fill_1
XFILLER_158_775 VDD VDD VSS VSS gf180mcu_as_sc_mcu7t3v3__fill_1
XFILLER_192_509 VDD VDD VSS VSS gf180mcu_as_sc_mcu7t3v3__fillcap_16
XFILLER_9_752 VDD VDD VSS VSS gf180mcu_as_sc_mcu7t3v3__fillcap_4
XFILLER_118_639 VDD VDD VSS VSS gf180mcu_as_sc_mcu7t3v3__fill_1
X_5450_ VDD VDD VSS VSS _6503_/Q _5631_/B _5549_/C _5757_/B _5451_/C gf180mcu_as_sc_mcu7t3v3__ao22_2
XTAP_TAPCELL_ROW_191_2180 VDD VSS gf180mcu_as_sc_mcu7t3v3__tap_2
XFILLER_8_295 VDD VDD VSS VSS gf180mcu_as_sc_mcu7t3v3__fillcap_16
X_4401_ VDD VDD VSS VSS _6133_/Q _4401_/B _4401_/C _4402_/B _4408_/D gf180mcu_as_sc_mcu7t3v3__oai211_2
X_5381_ VDD VDD VSS VSS _5689_/A _5484_/B _5492_/B _5692_/A _5384_/C gf180mcu_as_sc_mcu7t3v3__ao22_2
XTAP_TAPCELL_ROW_152_1474 VDD VSS gf180mcu_as_sc_mcu7t3v3__tap_2
XTAP_TAPCELL_ROW_152_1485 VDD VSS gf180mcu_as_sc_mcu7t3v3__tap_2
X_4332_ VDD VDD VSS VSS _6215_/D _4332_/B _4332_/A gf180mcu_as_sc_mcu7t3v3__nand2_2
XFILLER_141_664 VDD VDD VSS VSS gf180mcu_as_sc_mcu7t3v3__fill_2
X_4263_ VDD VDD VSS VSS _4263_/B _5977_/B _4264_/C gf180mcu_as_sc_mcu7t3v3__and2_2
XFILLER_45_1263 VDD VDD VSS VSS gf180mcu_as_sc_mcu7t3v3__fill_2
X_6002_ VDD VDD VSS VSS _6005_/B _6225_/Q _6515_/D gf180mcu_as_sc_mcu7t3v3__and2_2
X_3214_ VDD VDD VSS VSS _3332_/A _3214_/B _3214_/A _3214_/Y gf180mcu_as_sc_mcu7t3v3__mux2_2
XFILLER_227_212 VDD VDD VSS VSS gf180mcu_as_sc_mcu7t3v3__fill_2
XFILLER_228_713 VDD VDD VSS VSS gf180mcu_as_sc_mcu7t3v3__fill_1
X_4194_ VDD VDD VSS VSS _4195_/C _4194_/C _4194_/B _4366_/D gf180mcu_as_sc_mcu7t3v3__aoi21_2
X_3145_ VDD VDD VSS VSS _3251_/B _3229_/A _4475_/B gf180mcu_as_sc_mcu7t3v3__and2_2
XFILLER_209_971 VDD VDD VSS VSS gf180mcu_as_sc_mcu7t3v3__fillcap_8
XFILLER_209_982 VDD VDD VSS VSS gf180mcu_as_sc_mcu7t3v3__fillcap_16
XFILLER_227_267 VDD VDD VSS VSS gf180mcu_as_sc_mcu7t3v3__fill_2
XFILLER_228_779 VDD VDD VSS VSS gf180mcu_as_sc_mcu7t3v3__fill_2
XFILLER_55_648 VDD VDD VSS VSS gf180mcu_as_sc_mcu7t3v3__fill_1
X_3076_ VDD VDD VSS VSS _5804_/A _5145_/B gf180mcu_as_sc_mcu7t3v3__inv_2
XTAP_TAPCELL_ROW_198_2301 VDD VSS gf180mcu_as_sc_mcu7t3v3__tap_2
XTAP_TAPCELL_ROW_198_2312 VDD VSS gf180mcu_as_sc_mcu7t3v3__tap_2
XFILLER_224_963 VDD VDD VSS VSS gf180mcu_as_sc_mcu7t3v3__fillcap_16
XFILLER_210_101 VDD VDD VSS VSS gf180mcu_as_sc_mcu7t3v3__fillcap_4
XFILLER_24_27 VDD VDD VSS VSS gf180mcu_as_sc_mcu7t3v3__fillcap_8
XFILLER_24_49 VDD VDD VSS VSS gf180mcu_as_sc_mcu7t3v3__fill_2
XTAP_TAPCELL_ROW_159_1606 VDD VSS gf180mcu_as_sc_mcu7t3v3__tap_2
X_3978_ VDD VDD VSS VSS _4058_/B _3981_/C _3980_/B _6071_/Q _6071_/D gf180mcu_as_sc_mcu7t3v3__ao22_2
XFILLER_52_1245 VDD VDD VSS VSS gf180mcu_as_sc_mcu7t3v3__fill_2
X_5717_ VDD VDD VSS VSS _5717_/A _5799_/B _5717_/C _5799_/D _5718_/D gf180mcu_as_sc_mcu7t3v3__ao22_2
XTAP_TAPCELL_ROW_217_2640 VDD VSS gf180mcu_as_sc_mcu7t3v3__tap_2
XFILLER_109_628 VDD VDD VSS VSS gf180mcu_as_sc_mcu7t3v3__fill_2
XTAP_TAPCELL_ROW_217_2651 VDD VSS gf180mcu_as_sc_mcu7t3v3__tap_2
XFILLER_163_222 VDD VDD VSS VSS gf180mcu_as_sc_mcu7t3v3__fill_1
XFILLER_40_37 VDD VDD VSS VSS gf180mcu_as_sc_mcu7t3v3__fillcap_8
XTAP_TAPCELL_ROW_172_1839 VDD VSS gf180mcu_as_sc_mcu7t3v3__tap_2
X_5648_ VDD VDD VSS VSS _5886_/B _5649_/C _5649_/D gf180mcu_as_sc_mcu7t3v3__nand2_2
XFILLER_117_661 VDD VDD VSS VSS gf180mcu_as_sc_mcu7t3v3__fill_1
XFILLER_156_37 VDD VDD VSS VSS gf180mcu_as_sc_mcu7t3v3__fillcap_16
XTAP_TAPCELL_ROW_136_2_3052 VDD VSS gf180mcu_as_sc_mcu7t3v3__tap_2
X_5579_ VDD VDD VSS VSS _5616_/B _5888_/B _5581_/C gf180mcu_as_sc_mcu7t3v3__and2_2
XFILLER_151_439 VDD VDD VSS VSS gf180mcu_as_sc_mcu7t3v3__fill_1
XFILLER_172_1013 VDD VDD VSS VSS gf180mcu_as_sc_mcu7t3v3__fill_2
XFILLER_219_702 VDD VDD VSS VSS gf180mcu_as_sc_mcu7t3v3__fill_1
Xfanout720 VDD VDD VSS VSS _5839_/D _5799_/D gf180mcu_as_sc_mcu7t3v3__buff_12
Xfanout731 VDD VDD VSS VSS _5533_/B _5491_/C gf180mcu_as_sc_mcu7t3v3__buff_12
Xfanout742 VDD VDD VSS VSS _4960_/C _4953_/C gf180mcu_as_sc_mcu7t3v3__buff_12
XFILLER_172_69 VDD VDD VSS VSS gf180mcu_as_sc_mcu7t3v3__fillcap_16
Xfanout775 VDD VDD VSS VSS _4981_/Y _5187_/S gf180mcu_as_sc_mcu7t3v3__buff_12
XFILLER_219_757 VDD VDD VSS VSS gf180mcu_as_sc_mcu7t3v3__fill_1
XFILLER_46_626 VDD VDD VSS VSS gf180mcu_as_sc_mcu7t3v3__fill_1
Xfanout786 VDD VDD VSS VSS _4851_/B _4880_/B gf180mcu_as_sc_mcu7t3v3__buff_12
Xfanout797 VDD VDD VSS VSS _4446_/D _4442_/B gf180mcu_as_sc_mcu7t3v3__buff_12
XFILLER_100_594 VDD VDD VSS VSS gf180mcu_as_sc_mcu7t3v3__fill_1
XFILLER_65_45 VDD VDD VSS VSS gf180mcu_as_sc_mcu7t3v3__fillcap_4
XFILLER_159_506 VDD VDD VSS VSS gf180mcu_as_sc_mcu7t3v3__fillcap_16
XFILLER_187_826 VDD VDD VSS VSS gf180mcu_as_sc_mcu7t3v3__fill_2
XPHY_EDGE_ROW_97_2_Right_934 VDD VSS gf180mcu_as_sc_mcu7t3v3__tap_2
XFILLER_183_1186 VDD VDD VSS VSS gf180mcu_as_sc_mcu7t3v3__fillcap_4
XFILLER_186_314 VDD VDD VSS VSS gf180mcu_as_sc_mcu7t3v3__fill_1
XFILLER_186_325 VDD VDD VSS VSS gf180mcu_as_sc_mcu7t3v3__fill_1
XFILLER_198_174 VDD VDD VSS VSS gf180mcu_as_sc_mcu7t3v3__fill_1
XFILLER_199_697 VDD VDD VSS VSS gf180mcu_as_sc_mcu7t3v3__fill_2
XFILLER_214_495 VDD VDD VSS VSS gf180mcu_as_sc_mcu7t3v3__fill_1
XFILLER_197_88 VDD VDD VSS VSS gf180mcu_as_sc_mcu7t3v3__fillcap_8
XFILLER_10_762 VDD VDD VSS VSS gf180mcu_as_sc_mcu7t3v3__fill_1
XFILLER_155_734 VDD VDD VSS VSS gf180mcu_as_sc_mcu7t3v3__fillcap_4
XFILLER_167_594 VDD VDD VSS VSS gf180mcu_as_sc_mcu7t3v3__fillcap_16
XFILLER_194_380 VDD VDD VSS VSS gf180mcu_as_sc_mcu7t3v3__fillcap_4
XFILLER_170_737 VDD VDD VSS VSS gf180mcu_as_sc_mcu7t3v3__fillcap_16
XFILLER_216_18 VDD VDD VSS VSS gf180mcu_as_sc_mcu7t3v3__fillcap_16
XFILLER_29_1214 VDD VDD VSS VSS gf180mcu_as_sc_mcu7t3v3__fill_1
XFILLER_5_276 VDD VDD VSS VSS gf180mcu_as_sc_mcu7t3v3__fillcap_4
XFILLER_123_664 VDD VDD VSS VSS gf180mcu_as_sc_mcu7t3v3__fill_2
XFILLER_151_973 VDD VDD VSS VSS gf180mcu_as_sc_mcu7t3v3__fillcap_4
XFILLER_190_1135 VDD VDD VSS VSS gf180mcu_as_sc_mcu7t3v3__fillcap_16
XFILLER_190_1157 VDD VDD VSS VSS gf180mcu_as_sc_mcu7t3v3__fillcap_16
Xinput8 VDD VDD VSS VSS boot_addr[10] input8/Y gf180mcu_as_sc_mcu7t3v3__buff_12
XFILLER_149_1004 VDD VDD VSS VSS gf180mcu_as_sc_mcu7t3v3__fillcap_16
Xmesh_tile_1163 VDD VDD VSS VSS sw_out[14] gf180mcu_as_sc_mcu7t3v3__tiel_4
Xmesh_tile_1152 VDD VDD VSS VSS sw_out[3] gf180mcu_as_sc_mcu7t3v3__tiel_4
Xmesh_tile_1141 VDD VDD VSS VSS se_out[28] gf180mcu_as_sc_mcu7t3v3__tiel_4
Xmesh_tile_1130 VDD VDD VSS VSS se_out[17] gf180mcu_as_sc_mcu7t3v3__tiel_4
XFILLER_206_941 VDD VDD VSS VSS gf180mcu_as_sc_mcu7t3v3__fillcap_4
Xmesh_tile_1174 VDD VDD VSS VSS sw_out[25] gf180mcu_as_sc_mcu7t3v3__tiel_4
XFILLER_206_963 VDD VDD VSS VSS gf180mcu_as_sc_mcu7t3v3__fillcap_16
XFILLER_75_1212 VDD VDD VSS VSS gf180mcu_as_sc_mcu7t3v3__fill_1
XPHY_EDGE_ROW_32_3_Right_112 VDD VSS gf180mcu_as_sc_mcu7t3v3__tap_2
X_4950_ VDD VDD VSS VSS _5940_/A _4957_/B _4950_/C _4951_/C _4950_/D gf180mcu_as_sc_mcu7t3v3__aoi211_2
X_4881_ VDD VDD VSS VSS _4882_/C _5874_/A _4962_/B _4881_/C gf180mcu_as_sc_mcu7t3v3__ao21_2
X_3901_ VDD VDD VSS VSS _5881_/D _3929_/B _3901_/C _3901_/D _3902_/B gf180mcu_as_sc_mcu7t3v3__ao211_2
XFILLER_221_955 VDD VDD VSS VSS gf180mcu_as_sc_mcu7t3v3__fillcap_16
X_3832_ VDD VDD VSS VSS _6511_/Q _3897_/B _3927_/B _5822_/B _3834_/C gf180mcu_as_sc_mcu7t3v3__ao22_2
XTAP_TAPCELL_ROW_193_2220 VDD VSS gf180mcu_as_sc_mcu7t3v3__tap_2
XFILLER_162_1259 VDD VDD VSS VSS gf180mcu_as_sc_mcu7t3v3__fill_2
XFILLER_193_818 VDD VDD VSS VSS gf180mcu_as_sc_mcu7t3v3__fillcap_4
X_6551_ VDD VDD VSS VSS _6551_/CLK _6551_/D _6551_/Q gf180mcu_as_sc_mcu7t3v3__dfxtp_2
XFILLER_192_317 VDD VDD VSS VSS gf180mcu_as_sc_mcu7t3v3__fill_2
XFILLER_203_1234 VDD VDD VSS VSS gf180mcu_as_sc_mcu7t3v3__fill_1
XTAP_TAPCELL_ROW_154_1514 VDD VSS gf180mcu_as_sc_mcu7t3v3__tap_2
X_5502_ VDD VDD VSS VSS _5808_/A _5583_/B _5574_/C _5805_/A _5503_/D gf180mcu_as_sc_mcu7t3v3__ao22_2
X_3763_ VDD VDD VSS VSS _6026_/Q _3830_/B _4033_/B _3830_/D _6026_/D gf180mcu_as_sc_mcu7t3v3__ao22_2
X_6482_ VDD VDD VSS VSS _6484_/CLK _6482_/D _6482_/Q gf180mcu_as_sc_mcu7t3v3__dfxtp_2
X_3694_ VDD VDD VSS VSS _3695_/D _3809_/B _5703_/A gf180mcu_as_sc_mcu7t3v3__nand2b_2
XFILLER_161_726 VDD VDD VSS VSS gf180mcu_as_sc_mcu7t3v3__fill_2
XFILLER_195_1046 VDD VDD VSS VSS gf180mcu_as_sc_mcu7t3v3__fillcap_4
X_5433_ VDD VDD VSS VSS _5743_/A _5639_/B _5433_/C _5433_/D _5434_/C gf180mcu_as_sc_mcu7t3v3__ao211_2
XFILLER_160_225 VDD VDD VSS VSS gf180mcu_as_sc_mcu7t3v3__fillcap_16
XFILLER_195_1068 VDD VDD VSS VSS gf180mcu_as_sc_mcu7t3v3__fillcap_16
X_5364_ VDD VDD VSS VSS _6493_/Q _5564_/B _5563_/B _5675_/D _5366_/C gf180mcu_as_sc_mcu7t3v3__ao22_2
XFILLER_160_247 VDD VDD VSS VSS gf180mcu_as_sc_mcu7t3v3__fillcap_16
Xoutput378 VDD VDD VSS VSS _6418_/Q east_out[5] gf180mcu_as_sc_mcu7t3v3__buff_12
Xoutput367 VDD VDD VSS VSS _6441_/Q east_out[28] gf180mcu_as_sc_mcu7t3v3__buff_12
Xoutput356 VDD VDD VSS VSS _6431_/Q east_out[18] gf180mcu_as_sc_mcu7t3v3__buff_12
Xoutput345 VDD VDD VSS VSS _6721_/Y dft_rdata[6] gf180mcu_as_sc_mcu7t3v3__buff_12
X_4315_ VDD VDD VSS VSS _6213_/Q _4399_/B _4399_/C _6214_/Q _4316_/C gf180mcu_as_sc_mcu7t3v3__ao22_2
XFILLER_82_1238 VDD VDD VSS VSS gf180mcu_as_sc_mcu7t3v3__fillcap_4
Xoutput389 VDD VDD VSS VSS _6356_/Q north_out[15] gf180mcu_as_sc_mcu7t3v3__buff_12
X_5295_ VDD VDD VSS VSS _5297_/C _5295_/B _5295_/A gf180mcu_as_sc_mcu7t3v3__nand2_2
XFILLER_19_27 VDD VDD VSS VSS gf180mcu_as_sc_mcu7t3v3__fillcap_16
X_4246_ VDD VDD VSS VSS _4362_/D _4246_/B _4246_/A _4247_/B gf180mcu_as_sc_mcu7t3v3__mux2_2
XFILLER_210_1205 VDD VDD VSS VSS gf180mcu_as_sc_mcu7t3v3__fillcap_16
XFILLER_210_1227 VDD VDD VSS VSS gf180mcu_as_sc_mcu7t3v3__fillcap_8
XFILLER_228_543 VDD VDD VSS VSS gf180mcu_as_sc_mcu7t3v3__fill_1
XTAP_TAPCELL_ROW_13_1245 VDD VSS gf180mcu_as_sc_mcu7t3v3__tap_2
XTAP_TAPCELL_ROW_169_1790 VDD VSS gf180mcu_as_sc_mcu7t3v3__tap_2
X_4177_ VDD VDD VSS VSS _6165_/Q _5978_/D _4178_/D gf180mcu_as_sc_mcu7t3v3__and2_2
XTAP_TAPCELL_ROW_13_1256 VDD VSS gf180mcu_as_sc_mcu7t3v3__tap_2
X_3128_ VDD VDD VSS VSS _6313_/Q _6307_/Q _6308_/Q _6309_/Q _4566_/A gf180mcu_as_sc_mcu7t3v3__nand4_2
X_3059_ VDD VDD VSS VSS _4163_/B _6167_/Q gf180mcu_as_sc_mcu7t3v3__inv_2
XFILLER_195_100 VDD VDD VSS VSS gf180mcu_as_sc_mcu7t3v3__fill_2
XFILLER_196_645 VDD VDD VSS VSS gf180mcu_as_sc_mcu7t3v3__fillcap_4
XFILLER_11_526 VDD VDD VSS VSS gf180mcu_as_sc_mcu7t3v3__fill_2
XFILLER_196_667 VDD VDD VSS VSS gf180mcu_as_sc_mcu7t3v3__fillcap_4
XFILLER_208_1189 VDD VDD VSS VSS gf180mcu_as_sc_mcu7t3v3__fillcap_16
XFILLER_51_14 VDD VDD VSS VSS gf180mcu_as_sc_mcu7t3v3__fill_2
XFILLER_11_559 VDD VDD VSS VSS gf180mcu_as_sc_mcu7t3v3__fill_1
XFILLER_211_487 VDD VDD VSS VSS gf180mcu_as_sc_mcu7t3v3__fill_2
XPHY_EDGE_ROW_208_Left_436 VDD VSS gf180mcu_as_sc_mcu7t3v3__tap_2
XFILLER_164_531 VDD VDD VSS VSS gf180mcu_as_sc_mcu7t3v3__fill_2
XFILLER_167_69 VDD VDD VSS VSS gf180mcu_as_sc_mcu7t3v3__fill_1
XFILLER_176_391 VDD VDD VSS VSS gf180mcu_as_sc_mcu7t3v3__fill_1
XPHY_EDGE_ROW_109_3_Left_814 VDD VSS gf180mcu_as_sc_mcu7t3v3__tap_2
XTAP_TAPCELL_ROW_77_2_2964 VDD VSS gf180mcu_as_sc_mcu7t3v3__tap_2
XFILLER_152_748 VDD VDD VSS VSS gf180mcu_as_sc_mcu7t3v3__fillcap_4
XFILLER_164_597 VDD VDD VSS VSS gf180mcu_as_sc_mcu7t3v3__fillcap_4
XFILLER_174_1119 VDD VDD VSS VSS gf180mcu_as_sc_mcu7t3v3__fillcap_16
XFILLER_191_394 VDD VDD VSS VSS gf180mcu_as_sc_mcu7t3v3__fillcap_8
XFILLER_105_664 VDD VDD VSS VSS gf180mcu_as_sc_mcu7t3v3__fill_2
XFILLER_183_35 VDD VDD VSS VSS gf180mcu_as_sc_mcu7t3v3__fillcap_4
XFILLER_215_1116 VDD VDD VSS VSS gf180mcu_as_sc_mcu7t3v3__fillcap_4
XFILLER_215_1138 VDD VDD VSS VSS gf180mcu_as_sc_mcu7t3v3__fillcap_16
XFILLER_120_645 VDD VDD VSS VSS gf180mcu_as_sc_mcu7t3v3__fillcap_16
XFILLER_76_33 VDD VDD VSS VSS gf180mcu_as_sc_mcu7t3v3__fill_2
Xfanout550 VDD VDD VSS VSS _5316_/S _5267_/S gf180mcu_as_sc_mcu7t3v3__buff_12
XFILLER_4_1205 VDD VDD VSS VSS gf180mcu_as_sc_mcu7t3v3__fillcap_16
XFILLER_76_44 VDD VDD VSS VSS gf180mcu_as_sc_mcu7t3v3__fillcap_4
XPHY_EDGE_ROW_217_Left_445 VDD VSS gf180mcu_as_sc_mcu7t3v3__tap_2
Xfanout561 VDD VDD VSS VSS _4653_/Y _4725_/B gf180mcu_as_sc_mcu7t3v3__buff_12
Xfanout572 VDD VDD VSS VSS _3856_/B _3874_/B gf180mcu_as_sc_mcu7t3v3__buff_12
Xfanout583 VDD VDD VSS VSS _5857_/B _5946_/B gf180mcu_as_sc_mcu7t3v3__buff_12
XFILLER_19_637 VDD VDD VSS VSS gf180mcu_as_sc_mcu7t3v3__fillcap_8
XFILLER_219_554 VDD VDD VSS VSS gf180mcu_as_sc_mcu7t3v3__fillcap_4
XFILLER_4_1227 VDD VDD VSS VSS gf180mcu_as_sc_mcu7t3v3__fillcap_16
XFILLER_98_1245 VDD VDD VSS VSS gf180mcu_as_sc_mcu7t3v3__fillcap_16
Xfanout594 VDD VDD VSS VSS _5641_/B _5584_/C gf180mcu_as_sc_mcu7t3v3__buff_12
XFILLER_42_640 VDD VDD VSS VSS gf180mcu_as_sc_mcu7t3v3__fillcap_4
XFILLER_159_314 VDD VDD VSS VSS gf180mcu_as_sc_mcu7t3v3__fillcap_16
XFILLER_186_111 VDD VDD VSS VSS gf180mcu_as_sc_mcu7t3v3__fill_1
XFILLER_203_944 VDD VDD VSS VSS gf180mcu_as_sc_mcu7t3v3__fillcap_16
XPHY_EDGE_ROW_98_2_Right_935 VDD VSS gf180mcu_as_sc_mcu7t3v3__tap_2
XPHY_EDGE_ROW_226_Left_454 VDD VSS gf180mcu_as_sc_mcu7t3v3__tap_2
XFILLER_122_1210 VDD VDD VSS VSS gf180mcu_as_sc_mcu7t3v3__fillcap_8
XFILLER_174_317 VDD VDD VSS VSS gf180mcu_as_sc_mcu7t3v3__fill_2
XFILLER_186_177 VDD VDD VSS VSS gf180mcu_as_sc_mcu7t3v3__fillcap_4
Xwire951 VDD VDD VSS VSS wire951/A _5877_/A gf180mcu_as_sc_mcu7t3v3__clkbuff_12
Xwire962 VDD VDD VSS VSS wire962/A _5676_/D gf180mcu_as_sc_mcu7t3v3__clkbuff_12
Xwire984 VDD VDD VSS VSS wire984/A _5730_/A gf180mcu_as_sc_mcu7t3v3__clkbuff_12
Xwire995 VDD VDD VSS VSS wire995/A _5931_/A gf180mcu_as_sc_mcu7t3v3__clkbuff_12
XFILLER_155_1030 VDD VDD VSS VSS gf180mcu_as_sc_mcu7t3v3__fillcap_16
XPHY_EDGE_ROW_30_3_Left_735 VDD VSS gf180mcu_as_sc_mcu7t3v3__tap_2
XFILLER_155_1052 VDD VDD VSS VSS gf180mcu_as_sc_mcu7t3v3__fillcap_16
XFILLER_9_1116 VDD VDD VSS VSS gf180mcu_as_sc_mcu7t3v3__fillcap_4
XFILLER_9_1138 VDD VDD VSS VSS gf180mcu_as_sc_mcu7t3v3__fillcap_16
XFILLER_111_656 VDD VDD VSS VSS gf180mcu_as_sc_mcu7t3v3__fillcap_4
X_5080_ VDD VDD VSS VSS _5237_/S _5746_/A _5080_/A _5081_/B gf180mcu_as_sc_mcu7t3v3__mux2_2
X_4100_ VDD VDD VSS VSS _4101_/S _6721_/A _6160_/Q _6160_/D gf180mcu_as_sc_mcu7t3v3__mux2_2
X_4031_ VDD VDD VSS VSS _4055_/S _4031_/B _6112_/Q _6112_/D gf180mcu_as_sc_mcu7t3v3__mux2_2
XTAP_TAPCELL_ROW_186_2090 VDD VSS gf180mcu_as_sc_mcu7t3v3__tap_2
X_5982_ VDD VDD VSS VSS _6010_/B _6205_/Q _6495_/D gf180mcu_as_sc_mcu7t3v3__and2_2
XFILLER_178_601 VDD VDD VSS VSS gf180mcu_as_sc_mcu7t3v3__fill_1
XPHY_EDGE_ROW_33_3_Right_113 VDD VSS gf180mcu_as_sc_mcu7t3v3__tap_2
X_4933_ VDD VDD VSS VSS _4933_/B _5919_/A _4934_/D gf180mcu_as_sc_mcu7t3v3__or2_2
XANTENNA_13 VDD VDD VSS VSS _4780_/B gf180mcu_as_sc_mcu7t3v3__diode_2
XFILLER_166_807 VDD VDD VSS VSS gf180mcu_as_sc_mcu7t3v3__fill_1
XFILLER_220_240 VDD VDD VSS VSS gf180mcu_as_sc_mcu7t3v3__fill_1
X_4864_ VDD VDD VSS VSS _4864_/S _4864_/B _5859_/A _4865_/B gf180mcu_as_sc_mcu7t3v3__mux2_2
XANTENNA_24 VDD VDD VSS VSS _5163_/A gf180mcu_as_sc_mcu7t3v3__diode_2
XANTENNA_35 VDD VDD VSS VSS wire507/Y gf180mcu_as_sc_mcu7t3v3__diode_2
XANTENNA_46 VDD VDD VSS VSS _3791_/B gf180mcu_as_sc_mcu7t3v3__diode_2
XFILLER_159_870 VDD VDD VSS VSS gf180mcu_as_sc_mcu7t3v3__fill_1
X_4795_ VDD VDD VSS VSS _5802_/D _4795_/B _4795_/C _5801_/B _4796_/D gf180mcu_as_sc_mcu7t3v3__ao22_2
X_3815_ VDD VDD VSS VSS _5806_/B _3886_/C _3815_/C _3815_/D _3817_/C gf180mcu_as_sc_mcu7t3v3__ao211_2
X_6534_ VDD VDD VSS VSS _6546_/CLK _6534_/D _6534_/Q gf180mcu_as_sc_mcu7t3v3__dfxtp_2
X_3746_ VDD VDD VSS VSS _3805_/B _5748_/A _3747_/D gf180mcu_as_sc_mcu7t3v3__and2_2
X_6465_ VDD VDD VSS VSS _6474_/CLK _6465_/D _6465_/Q gf180mcu_as_sc_mcu7t3v3__dfxtp_2
XFILLER_12_1081 VDD VDD VSS VSS gf180mcu_as_sc_mcu7t3v3__fillcap_4
X_5416_ VDD VDD VSS VSS _5417_/D _5728_/D _5563_/B _5416_/C gf180mcu_as_sc_mcu7t3v3__ao21_2
X_3677_ VDD VDD VSS VSS _3904_/B _6017_/Q _3678_/C gf180mcu_as_sc_mcu7t3v3__and2_2
XTAP_TAPCELL_ROW_210_2529 VDD VSS gf180mcu_as_sc_mcu7t3v3__tap_2
XTAP_TAPCELL_ROW_210_2518 VDD VSS gf180mcu_as_sc_mcu7t3v3__tap_2
XFILLER_217_50 VDD VDD VSS VSS gf180mcu_as_sc_mcu7t3v3__fillcap_16
XPHY_EDGE_ROW_60_2_Right_897 VDD VSS gf180mcu_as_sc_mcu7t3v3__tap_2
X_6396_ VDD VDD VSS VSS clkload3/A _6396_/D _6396_/Q gf180mcu_as_sc_mcu7t3v3__dfxtp_2
XFILLER_138_1261 VDD VDD VSS VSS gf180mcu_as_sc_mcu7t3v3__fillcap_4
XFILLER_161_589 VDD VDD VSS VSS gf180mcu_as_sc_mcu7t3v3__fillcap_4
XFILLER_217_72 VDD VDD VSS VSS gf180mcu_as_sc_mcu7t3v3__fillcap_16
XPHY_EDGE_ROW_87_3_Left_792 VDD VSS gf180mcu_as_sc_mcu7t3v3__tap_2
X_5347_ VDD VDD VSS VSS _5656_/A _5656_/B _5359_/C gf180mcu_as_sc_mcu7t3v3__or2_2
XFILLER_153_38 VDD VDD VSS VSS gf180mcu_as_sc_mcu7t3v3__fillcap_16
X_5278_ VDD VDD VSS VSS _5921_/D _5312_/B _5302_/C _5278_/D _5279_/B gf180mcu_as_sc_mcu7t3v3__ao22_2
XTAP_TAPCELL_ROW_167_1749 VDD VSS gf180mcu_as_sc_mcu7t3v3__tap_2
X_4229_ VDD VDD VSS VSS _4231_/S _4229_/B _6201_/Q _6201_/D gf180mcu_as_sc_mcu7t3v3__mux2_2
XPHY_EDGE_ROW_146_2_Left_587 VDD VSS gf180mcu_as_sc_mcu7t3v3__tap_2
XTAP_TAPCELL_ROW_225_2794 VDD VSS gf180mcu_as_sc_mcu7t3v3__tap_2
XTAP_TAPCELL_ROW_225_2783 VDD VSS gf180mcu_as_sc_mcu7t3v3__tap_2
XPHY_EDGE_ROW_83_2_Left_524 VDD VSS gf180mcu_as_sc_mcu7t3v3__tap_2
XFILLER_145_1210 VDD VDD VSS VSS gf180mcu_as_sc_mcu7t3v3__fillcap_16
XFILLER_197_976 VDD VDD VSS VSS gf180mcu_as_sc_mcu7t3v3__fillcap_4
XFILLER_212_752 VDD VDD VSS VSS gf180mcu_as_sc_mcu7t3v3__fill_1
XTAP_TAPCELL_ROW_124_2_3034 VDD VSS gf180mcu_as_sc_mcu7t3v3__tap_2
XFILLER_156_317 VDD VDD VSS VSS gf180mcu_as_sc_mcu7t3v3__fillcap_16
XFILLER_168_155 VDD VDD VSS VSS gf180mcu_as_sc_mcu7t3v3__fillcap_16
XFILLER_168_177 VDD VDD VSS VSS gf180mcu_as_sc_mcu7t3v3__fillcap_16
XFILLER_180_1189 VDD VDD VSS VSS gf180mcu_as_sc_mcu7t3v3__fillcap_16
XFILLER_184_626 VDD VDD VSS VSS gf180mcu_as_sc_mcu7t3v3__fillcap_4
XFILLER_197_998 VDD VDD VSS VSS gf180mcu_as_sc_mcu7t3v3__fillcap_16
XFILLER_200_947 VDD VDD VSS VSS gf180mcu_as_sc_mcu7t3v3__fillcap_16
XFILLER_183_114 VDD VDD VSS VSS gf180mcu_as_sc_mcu7t3v3__fill_2
XFILLER_7_338 VDD VDD VSS VSS gf180mcu_as_sc_mcu7t3v3__fillcap_4
XFILLER_8_839 VDD VDD VSS VSS gf180mcu_as_sc_mcu7t3v3__fillcap_16
XFILLER_183_158 VDD VDD VSS VSS gf180mcu_as_sc_mcu7t3v3__fill_1
XFILLER_221_1186 VDD VDD VSS VSS gf180mcu_as_sc_mcu7t3v3__fillcap_4
XFILLER_11_72 VDD VDD VSS VSS gf180mcu_as_sc_mcu7t3v3__fillcap_16
XFILLER_152_589 VDD VDD VSS VSS gf180mcu_as_sc_mcu7t3v3__fillcap_4
XFILLER_189_1170 VDD VDD VSS VSS gf180mcu_as_sc_mcu7t3v3__fillcap_16
XFILLER_207_524 VDD VDD VSS VSS gf180mcu_as_sc_mcu7t3v3__fill_1
XFILLER_189_1192 VDD VDD VSS VSS gf180mcu_as_sc_mcu7t3v3__fillcap_16
XFILLER_222_527 VDD VDD VSS VSS gf180mcu_as_sc_mcu7t3v3__fillcap_4
XTAP_TAPCELL_ROW_5_1096 VDD VSS gf180mcu_as_sc_mcu7t3v3__tap_2
XFILLER_15_640 VDD VDD VSS VSS gf180mcu_as_sc_mcu7t3v3__fillcap_4
XFILLER_202_251 VDD VDD VSS VSS gf180mcu_as_sc_mcu7t3v3__fill_2
XPHY_EDGE_ROW_204_Right_72 VDD VSS gf180mcu_as_sc_mcu7t3v3__tap_2
XFILLER_30_665 VDD VDD VSS VSS gf180mcu_as_sc_mcu7t3v3__fill_2
XPHY_EDGE_ROW_99_2_Right_936 VDD VSS gf180mcu_as_sc_mcu7t3v3__tap_2
Xinput11 VDD VDD VSS VSS boot_addr[3] _3257_/B gf180mcu_as_sc_mcu7t3v3__buff_12
Xinput22 VDD VDD VSS VSS boot_data[4] _3339_/A gf180mcu_as_sc_mcu7t3v3__buff_12
X_4580_ VDD VDD VSS VSS _6314_/Q _4583_/B _4580_/C _4581_/A _6314_/D gf180mcu_as_sc_mcu7t3v3__ao22_2
X_3600_ VDD VDD VSS VSS _5323_/C _3607_/B _3607_/A gf180mcu_as_sc_mcu7t3v3__nand2_2
XFILLER_11_890 VDD VDD VSS VSS gf180mcu_as_sc_mcu7t3v3__fillcap_16
XFILLER_156_862 VDD VDD VSS VSS gf180mcu_as_sc_mcu7t3v3__fill_2
Xinput33 VDD VDD VSS VSS dft_addr[4] _3270_/B gf180mcu_as_sc_mcu7t3v3__buff_12
Xinput44 VDD VDD VSS VSS dft_wdata[3] _3332_/B gf180mcu_as_sc_mcu7t3v3__buff_12
Xinput55 VDD VDD VSS VSS east_in[14] _5789_/A gf180mcu_as_sc_mcu7t3v3__buff_12
X_3531_ VDD VDD VSS VSS _5339_/A _5911_/A _3532_/C _3534_/D _3532_/D gf180mcu_as_sc_mcu7t3v3__aoi211_2
Xinput66 VDD VDD VSS VSS east_in[24] wire952/A gf180mcu_as_sc_mcu7t3v3__buff_12
Xinput77 VDD VDD VSS VSS east_in[34] wire949/A gf180mcu_as_sc_mcu7t3v3__buff_12
Xinput88 VDD VDD VSS VSS ne_in[11] _5768_/D gf180mcu_as_sc_mcu7t3v3__buff_12
Xinput99 VDD VDD VSS VSS ne_in[21] _5849_/D gf180mcu_as_sc_mcu7t3v3__buff_12
Xmax_cap558 VDD VDD VSS VSS _4844_/S _4797_/S gf180mcu_as_sc_mcu7t3v3__clkbuff_12
X_6250_ VDD VDD VSS VSS _6531_/CLK _6250_/D _6250_/Q gf180mcu_as_sc_mcu7t3v3__dfxtp_2
X_3462_ VDD VDD VSS VSS _3474_/A _5936_/D _3463_/B _3463_/C _5943_/D gf180mcu_as_sc_mcu7t3v3__aoi22_2
XTAP_TAPCELL_ROW_188_2130 VDD VSS gf180mcu_as_sc_mcu7t3v3__tap_2
XFILLER_192_1049 VDD VDD VSS VSS gf180mcu_as_sc_mcu7t3v3__fillcap_16
XPHY_EDGE_ROW_213_Right_81 VDD VSS gf180mcu_as_sc_mcu7t3v3__tap_2
X_6181_ VDD VDD VSS VSS _6490_/CLK _6181_/D _6181_/Q gf180mcu_as_sc_mcu7t3v3__dfxtp_2
X_5201_ VDD VDD VSS VSS _5201_/B _5229_/A _6398_/D gf180mcu_as_sc_mcu7t3v3__and2_2
X_3393_ VDD VDD VSS VSS _3394_/B _4102_/C _4102_/B gf180mcu_as_sc_mcu7t3v3__nand2_2
XFILLER_97_632 VDD VDD VSS VSS gf180mcu_as_sc_mcu7t3v3__fill_1
XPHY_EDGE_ROW_79_1_Left_307 VDD VSS gf180mcu_as_sc_mcu7t3v3__tap_2
XTAP_TAPCELL_ROW_149_1402 VDD VSS gf180mcu_as_sc_mcu7t3v3__tap_2
XTAP_TAPCELL_ROW_149_1413 VDD VSS gf180mcu_as_sc_mcu7t3v3__tap_2
Xclkbuf_1_0__f_clk VDD VDD VSS VSS clkbuf_0_clk/Y clkbuf_1_0__f_clk/Y gf180mcu_as_sc_mcu7t3v3__clkbuff_12
X_5132_ VDD VDD VSS VSS _5133_/D _5142_/B _5132_/B _5790_/B gf180mcu_as_sc_mcu7t3v3__aoi21b_2
XTAP_TAPCELL_ROW_149_1424 VDD VSS gf180mcu_as_sc_mcu7t3v3__tap_2
Xload_slew764 VDD VDD VSS VSS _5324_/Y _5532_/B gf180mcu_as_sc_mcu7t3v3__clkbuff_12
XTAP_TAPCELL_ROW_184_2049 VDD VSS gf180mcu_as_sc_mcu7t3v3__tap_2
XPHY_EDGE_ROW_131_1_Left_359 VDD VSS gf180mcu_as_sc_mcu7t3v3__tap_2
X_5063_ VDD VDD VSS VSS _5063_/B _5063_/A _6383_/D gf180mcu_as_sc_mcu7t3v3__and2_2
X_4014_ VDD VDD VSS VSS _4061_/B _4014_/B _4014_/C _6102_/Q _6102_/D gf180mcu_as_sc_mcu7t3v3__ao22_2
XFILLER_168_1221 VDD VDD VSS VSS gf180mcu_as_sc_mcu7t3v3__fillcap_4
XFILLER_168_1243 VDD VDD VSS VSS gf180mcu_as_sc_mcu7t3v3__fillcap_16
XTAP_TAPCELL_ROW_162_1657 VDD VSS gf180mcu_as_sc_mcu7t3v3__tap_2
XPHY_EDGE_ROW_222_Right_90 VDD VSS gf180mcu_as_sc_mcu7t3v3__tap_2
X_5965_ VDD VDD VSS VSS _5966_/B _6489_/Q _5967_/A gf180mcu_as_sc_mcu7t3v3__or2_2
XTAP_TAPCELL_ROW_203_2399 VDD VSS gf180mcu_as_sc_mcu7t3v3__tap_2
XTAP_TAPCELL_ROW_203_2388 VDD VSS gf180mcu_as_sc_mcu7t3v3__tap_2
XFILLER_209_1262 VDD VDD VSS VSS gf180mcu_as_sc_mcu7t3v3__fill_2
XPHY_EDGE_ROW_34_3_Right_114 VDD VSS gf180mcu_as_sc_mcu7t3v3__tap_2
X_5896_ VDD VDD VSS VSS _5951_/B _5896_/A _5898_/C gf180mcu_as_sc_mcu7t3v3__and2_2
X_4916_ VDD VDD VSS VSS _5906_/D _4963_/B _4939_/C _4916_/D _4918_/A gf180mcu_as_sc_mcu7t3v3__ao211_2
XFILLER_179_998 VDD VDD VSS VSS gf180mcu_as_sc_mcu7t3v3__fillcap_16
XFILLER_32_27 VDD VDD VSS VSS gf180mcu_as_sc_mcu7t3v3__fillcap_8
X_4847_ VDD VDD VSS VSS _4850_/C _4876_/B _5845_/A gf180mcu_as_sc_mcu7t3v3__nand2_2
XFILLER_148_16 VDD VDD VSS VSS gf180mcu_as_sc_mcu7t3v3__fill_1
XFILLER_165_136 VDD VDD VSS VSS gf180mcu_as_sc_mcu7t3v3__fillcap_4
XFILLER_32_49 VDD VDD VSS VSS gf180mcu_as_sc_mcu7t3v3__fill_2
XFILLER_148_49 VDD VDD VSS VSS gf180mcu_as_sc_mcu7t3v3__fill_2
XFILLER_165_158 VDD VDD VSS VSS gf180mcu_as_sc_mcu7t3v3__fillcap_16
XFILLER_194_979 VDD VDD VSS VSS gf180mcu_as_sc_mcu7t3v3__fillcap_16
X_4778_ VDD VDD VSS VSS _4779_/B _5786_/A _4796_/B _4778_/C gf180mcu_as_sc_mcu7t3v3__ao21_2
X_6517_ VDD VDD VSS VSS _6517_/CLK _6517_/D _6517_/Q gf180mcu_as_sc_mcu7t3v3__dfxtp_2
X_3729_ VDD VDD VSS VSS _3871_/B _5734_/A _3730_/D gf180mcu_as_sc_mcu7t3v3__and2_2
X_6448_ VDD VDD VSS VSS _6448_/CLK _6448_/D _6448_/Q gf180mcu_as_sc_mcu7t3v3__dfxtp_2
XFILLER_164_37 VDD VDD VSS VSS gf180mcu_as_sc_mcu7t3v3__fillcap_16
XPHY_EDGE_ROW_61_2_Right_898 VDD VSS gf180mcu_as_sc_mcu7t3v3__tap_2
X_6379_ VDD VDD VSS VSS _6527_/CLK _6379_/D _6379_/Q gf180mcu_as_sc_mcu7t3v3__dfxtp_2
XFILLER_212_1119 VDD VDD VSS VSS gf180mcu_as_sc_mcu7t3v3__fillcap_16
XTAP_TAPCELL_ROW_227_2834 VDD VSS gf180mcu_as_sc_mcu7t3v3__tap_2
XTAP_TAPCELL_ROW_227_2823 VDD VSS gf180mcu_as_sc_mcu7t3v3__tap_2
XFILLER_169_1018 VDD VDD VSS VSS gf180mcu_as_sc_mcu7t3v3__fillcap_16
XFILLER_216_310 VDD VDD VSS VSS gf180mcu_as_sc_mcu7t3v3__fillcap_4
XFILLER_1_1208 VDD VDD VSS VSS gf180mcu_as_sc_mcu7t3v3__fillcap_16
XFILLER_16_437 VDD VDD VSS VSS gf180mcu_as_sc_mcu7t3v3__fill_1
XFILLER_73_45 VDD VDD VSS VSS gf180mcu_as_sc_mcu7t3v3__fillcap_4
XTAP_TAPCELL_ROW_65_2_2946 VDD VSS gf180mcu_as_sc_mcu7t3v3__tap_2
XFILLER_11_120 VDD VDD VSS VSS gf180mcu_as_sc_mcu7t3v3__fillcap_16
XFILLER_12_632 VDD VDD VSS VSS gf180mcu_as_sc_mcu7t3v3__fillcap_16
XFILLER_169_464 VDD VDD VSS VSS gf180mcu_as_sc_mcu7t3v3__fill_1
XFILLER_169_475 VDD VDD VSS VSS gf180mcu_as_sc_mcu7t3v3__fillcap_8
XFILLER_212_593 VDD VDD VSS VSS gf180mcu_as_sc_mcu7t3v3__fill_2
XPHY_EDGE_ROW_159_Left_387 VDD VSS gf180mcu_as_sc_mcu7t3v3__tap_2
XFILLER_11_142 VDD VDD VSS VSS gf180mcu_as_sc_mcu7t3v3__fillcap_16
XFILLER_184_445 VDD VDD VSS VSS gf180mcu_as_sc_mcu7t3v3__fill_2
XFILLER_32_1210 VDD VDD VSS VSS gf180mcu_as_sc_mcu7t3v3__fillcap_8
XFILLER_153_821 VDD VDD VSS VSS gf180mcu_as_sc_mcu7t3v3__fillcap_16
XFILLER_152_1011 VDD VDD VSS VSS gf180mcu_as_sc_mcu7t3v3__fillcap_4
XFILLER_224_18 VDD VDD VSS VSS gf180mcu_as_sc_mcu7t3v3__fillcap_16
XFILLER_4_897 VDD VDD VSS VSS gf180mcu_as_sc_mcu7t3v3__fill_2
XFILLER_152_1033 VDD VDD VSS VSS gf180mcu_as_sc_mcu7t3v3__fillcap_16
XFILLER_6_1119 VDD VDD VSS VSS gf180mcu_as_sc_mcu7t3v3__fillcap_16
XPHY_EDGE_ROW_168_Left_396 VDD VSS gf180mcu_as_sc_mcu7t3v3__tap_2
XPHY_EDGE_ROW_40_1_Right_612 VDD VSS gf180mcu_as_sc_mcu7t3v3__tap_2
XFILLER_226_107 VDD VDD VSS VSS gf180mcu_as_sc_mcu7t3v3__fill_1
XTAP_TAPCELL_ROW_7_1147 VDD VSS gf180mcu_as_sc_mcu7t3v3__tap_2
XTAP_TAPCELL_ROW_7_1136 VDD VSS gf180mcu_as_sc_mcu7t3v3__tap_2
XFILLER_222_302 VDD VDD VSS VSS gf180mcu_as_sc_mcu7t3v3__fill_2
XPHY_EDGE_ROW_23_2_Right_860 VDD VSS gf180mcu_as_sc_mcu7t3v3__tap_2
XFILLER_179_228 VDD VDD VSS VSS gf180mcu_as_sc_mcu7t3v3__fill_1
XFILLER_228_1137 VDD VDD VSS VSS gf180mcu_as_sc_mcu7t3v3__fillcap_4
X_5750_ VDD VDD VSS VSS _5750_/A _5799_/B _5750_/C _5799_/D _5751_/D gf180mcu_as_sc_mcu7t3v3__ao22_2
XFILLER_15_492 VDD VDD VSS VSS gf180mcu_as_sc_mcu7t3v3__fillcap_8
X_5681_ VDD VDD VSS VSS _5797_/B _5681_/A _5684_/C gf180mcu_as_sc_mcu7t3v3__and2_2
X_4701_ VDD VDD VSS VSS _4701_/B _4794_/S _4703_/C gf180mcu_as_sc_mcu7t3v3__and2_2
XFILLER_148_659 VDD VDD VSS VSS gf180mcu_as_sc_mcu7t3v3__fill_1
X_4632_ VDD VDD VSS VSS _5346_/D _4632_/C _4632_/B _4632_/A gf180mcu_as_sc_mcu7t3v3__aoi21_2
XFILLER_175_489 VDD VDD VSS VSS gf180mcu_as_sc_mcu7t3v3__fill_1
XFILLER_191_938 VDD VDD VSS VSS gf180mcu_as_sc_mcu7t3v3__fillcap_16
X_4563_ VDD VDD VSS VSS _6307_/D _4563_/B _4564_/B gf180mcu_as_sc_mcu7t3v3__nor2_2
XFILLER_162_139 VDD VDD VSS VSS gf180mcu_as_sc_mcu7t3v3__fillcap_16
XFILLER_171_651 VDD VDD VSS VSS gf180mcu_as_sc_mcu7t3v3__fill_2
X_6302_ VDD VDD VSS VSS clkload8/A _6302_/D _6302_/Q gf180mcu_as_sc_mcu7t3v3__dfxtp_2
X_4494_ VDD VDD VSS VSS _6283_/D _4494_/C _4503_/C _6283_/Q gf180mcu_as_sc_mcu7t3v3__aoi21b_2
X_3514_ VDD VDD VSS VSS _4627_/B _4272_/A _5944_/A gf180mcu_as_sc_mcu7t3v3__nand2b_2
X_6233_ VDD VDD VSS VSS _6526_/CLK _6233_/D _6233_/Q gf180mcu_as_sc_mcu7t3v3__dfxtp_2
X_3445_ VDD VDD VSS VSS _6718_/A _4584_/A _3455_/B gf180mcu_as_sc_mcu7t3v3__and2_2
XFILLER_48_1261 VDD VDD VSS VSS gf180mcu_as_sc_mcu7t3v3__fillcap_4
X_6164_ VDD VDD VSS VSS _6316_/CLK _6164_/D _6164_/Q gf180mcu_as_sc_mcu7t3v3__dfxtp_2
X_3376_ VDD VDD VSS VSS _6529_/Q _6324_/Q _3438_/A gf180mcu_as_sc_mcu7t3v3__or2_2
X_6095_ VDD VDD VSS VSS _6525_/CLK _6095_/D _6095_/Q gf180mcu_as_sc_mcu7t3v3__dfxtp_2
X_5115_ VDD VDD VSS VSS _6505_/Q _5233_/C _5115_/C _5115_/D _5117_/C gf180mcu_as_sc_mcu7t3v3__ao22_2
XFILLER_27_27 VDD VDD VSS VSS gf180mcu_as_sc_mcu7t3v3__fillcap_16
X_5046_ VDD VDD VSS VSS _5046_/D _5718_/A _5139_/B _5139_/C _5047_/C gf180mcu_as_sc_mcu7t3v3__ao31_2
XTAP_TAPCELL_ROW_205_2428 VDD VSS gf180mcu_as_sc_mcu7t3v3__tap_2
XFILLER_226_652 VDD VDD VSS VSS gf180mcu_as_sc_mcu7t3v3__fill_1
XTAP_TAPCELL_ROW_222_2742 VDD VSS gf180mcu_as_sc_mcu7t3v3__tap_2
XTAP_TAPCELL_ROW_222_2731 VDD VSS gf180mcu_as_sc_mcu7t3v3__tap_2
XTAP_TAPCELL_ROW_205_2439 VDD VSS gf180mcu_as_sc_mcu7t3v3__tap_2
XPHY_EDGE_ROW_118_3_Left_823 VDD VSS gf180mcu_as_sc_mcu7t3v3__tap_2
XFILLER_13_407 VDD VDD VSS VSS gf180mcu_as_sc_mcu7t3v3__fill_1
XFILLER_198_515 VDD VDD VSS VSS gf180mcu_as_sc_mcu7t3v3__fill_2
XFILLER_201_508 VDD VDD VSS VSS gf180mcu_as_sc_mcu7t3v3__fillcap_8
XFILLER_55_1210 VDD VDD VSS VSS gf180mcu_as_sc_mcu7t3v3__fill_2
X_5948_ VDD VDD VSS VSS _5948_/S _5948_/B _5948_/A _5949_/B gf180mcu_as_sc_mcu7t3v3__mux2_2
XFILLER_181_1240 VDD VDD VSS VSS gf180mcu_as_sc_mcu7t3v3__fillcap_16
XFILLER_181_1262 VDD VDD VSS VSS gf180mcu_as_sc_mcu7t3v3__fill_2
XPHY_EDGE_ROW_35_3_Right_115 VDD VSS gf180mcu_as_sc_mcu7t3v3__tap_2
XTAP_TAPCELL_ROW_179_1962 VDD VSS gf180mcu_as_sc_mcu7t3v3__tap_2
XFILLER_178_272 VDD VDD VSS VSS gf180mcu_as_sc_mcu7t3v3__fillcap_4
X_5879_ VDD VDD VSS VSS _5879_/A _5922_/B _5879_/C _5879_/D _5880_/D gf180mcu_as_sc_mcu7t3v3__ao22_2
XFILLER_167_979 VDD VDD VSS VSS gf180mcu_as_sc_mcu7t3v3__fill_1
XFILLER_181_448 VDD VDD VSS VSS gf180mcu_as_sc_mcu7t3v3__fillcap_8
XFILLER_162_662 VDD VDD VSS VSS gf180mcu_as_sc_mcu7t3v3__fill_2
XFILLER_190_993 VDD VDD VSS VSS gf180mcu_as_sc_mcu7t3v3__fillcap_16
XFILLER_68_45 VDD VDD VSS VSS gf180mcu_as_sc_mcu7t3v3__fillcap_4
XFILLER_150_879 VDD VDD VSS VSS gf180mcu_as_sc_mcu7t3v3__fill_1
XFILLER_1_856 VDD VDD VSS VSS gf180mcu_as_sc_mcu7t3v3__fill_1
XPHY_EDGE_ROW_62_2_Right_899 VDD VSS gf180mcu_as_sc_mcu7t3v3__tap_2
Xinput201 VDD VDD VSS VSS se_in[15] _5802_/A gf180mcu_as_sc_mcu7t3v3__buff_12
Xinput212 VDD VDD VSS VSS se_in[25] _5882_/A gf180mcu_as_sc_mcu7t3v3__buff_12
Xinput223 VDD VDD VSS VSS se_in[35] _5354_/A gf180mcu_as_sc_mcu7t3v3__buff_12
Xinput234 VDD VDD VSS VSS south_in[12] _5775_/A gf180mcu_as_sc_mcu7t3v3__buff_12
Xinput245 VDD VDD VSS VSS south_in[22] _5855_/A gf180mcu_as_sc_mcu7t3v3__buff_12
XFILLER_208_107 VDD VDD VSS VSS gf180mcu_as_sc_mcu7t3v3__fillcap_16
Xinput256 VDD VDD VSS VSS south_in[32] _5293_/A gf180mcu_as_sc_mcu7t3v3__buff_12
Xinput267 VDD VDD VSS VSS sw_in[0] wire988/A gf180mcu_as_sc_mcu7t3v3__buff_12
Xinput278 VDD VDD VSS VSS sw_in[1] _5687_/A gf180mcu_as_sc_mcu7t3v3__buff_12
XFILLER_84_33 VDD VDD VSS VSS gf180mcu_as_sc_mcu7t3v3__fill_2
XFILLER_84_44 VDD VDD VSS VSS gf180mcu_as_sc_mcu7t3v3__fillcap_4
XTAP_TAPCELL_ROW_112_2_3016 VDD VSS gf180mcu_as_sc_mcu7t3v3__tap_2
Xinput289 VDD VDD VSS VSS sw_in[2] _5695_/A gf180mcu_as_sc_mcu7t3v3__buff_12
XFILLER_186_1151 VDD VDD VSS VSS gf180mcu_as_sc_mcu7t3v3__fillcap_4
XFILLER_186_1173 VDD VDD VSS VSS gf180mcu_as_sc_mcu7t3v3__fillcap_16
XTAP_TAPCELL_ROW_2_1055 VDD VSS gf180mcu_as_sc_mcu7t3v3__tap_2
XTAP_TAPCELL_ROW_2_1044 VDD VSS gf180mcu_as_sc_mcu7t3v3__tap_2
XFILLER_16_267 VDD VDD VSS VSS gf180mcu_as_sc_mcu7t3v3__fillcap_4
XFILLER_227_1170 VDD VDD VSS VSS gf180mcu_as_sc_mcu7t3v3__fillcap_16
XFILLER_227_1192 VDD VDD VSS VSS gf180mcu_as_sc_mcu7t3v3__fillcap_16
XFILLER_9_912 VDD VDD VSS VSS gf180mcu_as_sc_mcu7t3v3__fillcap_16
XFILLER_149_70 VDD VDD VSS VSS gf180mcu_as_sc_mcu7t3v3__fillcap_16
XFILLER_157_445 VDD VDD VSS VSS gf180mcu_as_sc_mcu7t3v3__fillcap_16
XFILLER_158_979 VDD VDD VSS VSS gf180mcu_as_sc_mcu7t3v3__fillcap_16
XFILLER_219_18 VDD VDD VSS VSS gf180mcu_as_sc_mcu7t3v3__fillcap_16
XFILLER_172_404 VDD VDD VSS VSS gf180mcu_as_sc_mcu7t3v3__fill_1
XFILLER_184_286 VDD VDD VSS VSS gf180mcu_as_sc_mcu7t3v3__fillcap_4
XFILLER_193_1100 VDD VDD VSS VSS gf180mcu_as_sc_mcu7t3v3__fillcap_16
XFILLER_181_982 VDD VDD VSS VSS gf180mcu_as_sc_mcu7t3v3__fillcap_16
XFILLER_193_1122 VDD VDD VSS VSS gf180mcu_as_sc_mcu7t3v3__fillcap_16
XFILLER_119_1226 VDD VDD VSS VSS gf180mcu_as_sc_mcu7t3v3__fillcap_8
XFILLER_180_492 VDD VDD VSS VSS gf180mcu_as_sc_mcu7t3v3__fillcap_4
XPHY_EDGE_ROW_176_Left_404 VDD VSS gf180mcu_as_sc_mcu7t3v3__tap_2
X_3230_ VDD VDD VSS VSS _3238_/B _6267_/Q _3231_/B gf180mcu_as_sc_mcu7t3v3__or2_2
X_3161_ VDD VDD VSS VSS _3161_/A _3161_/B _3161_/C _6315_/Q _3161_/Y gf180mcu_as_sc_mcu7t3v3__ao22_2
XTAP_TAPCELL_ROW_181_2008 VDD VSS gf180mcu_as_sc_mcu7t3v3__tap_2
XPHY_EDGE_ROW_41_1_Right_613 VDD VSS gf180mcu_as_sc_mcu7t3v3__tap_2
XFILLER_78_1210 VDD VDD VSS VSS gf180mcu_as_sc_mcu7t3v3__fillcap_4
X_3092_ VDD VDD VSS VSS _3316_/B _3092_/A gf180mcu_as_sc_mcu7t3v3__inv_2
XFILLER_165_1224 VDD VDD VSS VSS gf180mcu_as_sc_mcu7t3v3__fillcap_4
XFILLER_207_184 VDD VDD VSS VSS gf180mcu_as_sc_mcu7t3v3__fillcap_16
XFILLER_223_644 VDD VDD VSS VSS gf180mcu_as_sc_mcu7t3v3__fillcap_8
XPHY_EDGE_ROW_185_Left_413 VDD VSS gf180mcu_as_sc_mcu7t3v3__tap_2
XPHY_EDGE_ROW_24_2_Right_861 VDD VSS gf180mcu_as_sc_mcu7t3v3__tap_2
X_5802_ VDD VDD VSS VSS _5802_/A _5802_/B _5802_/C _5802_/D _5803_/C gf180mcu_as_sc_mcu7t3v3__ao22_2
XTAP_TAPCELL_ROW_200_2347 VDD VSS gf180mcu_as_sc_mcu7t3v3__tap_2
XTAP_TAPCELL_ROW_200_2336 VDD VSS gf180mcu_as_sc_mcu7t3v3__tap_2
XFILLER_200_31 VDD VDD VSS VSS gf180mcu_as_sc_mcu7t3v3__fillcap_4
XFILLER_200_53 VDD VDD VSS VSS gf180mcu_as_sc_mcu7t3v3__fillcap_16
XFILLER_206_1221 VDD VDD VSS VSS gf180mcu_as_sc_mcu7t3v3__fillcap_4
X_3994_ VDD VDD VSS VSS _4030_/B _4002_/B _4002_/C _6082_/Q _6082_/D gf180mcu_as_sc_mcu7t3v3__ao22_2
XTAP_TAPCELL_ROW_196_2273 VDD VSS gf180mcu_as_sc_mcu7t3v3__tap_2
XTAP_TAPCELL_ROW_196_2262 VDD VSS gf180mcu_as_sc_mcu7t3v3__tap_2
Xsram2048.u_bank1_1036 VDD VDD VSS VSS sram2048.u_bank1/WEN[2] gf180mcu_as_sc_mcu7t3v3__tiel_4
X_5733_ VDD VDD VSS VSS _5733_/A _5931_/B _5733_/C _5855_/D _5734_/D gf180mcu_as_sc_mcu7t3v3__ao22_2
XFILLER_175_220 VDD VDD VSS VSS gf180mcu_as_sc_mcu7t3v3__fillcap_4
XFILLER_191_702 VDD VDD VSS VSS gf180mcu_as_sc_mcu7t3v3__fill_1
XFILLER_198_1011 VDD VDD VSS VSS gf180mcu_as_sc_mcu7t3v3__fillcap_4
XFILLER_198_1033 VDD VDD VSS VSS gf180mcu_as_sc_mcu7t3v3__fillcap_16
XTAP_TAPCELL_ROW_157_1567 VDD VSS gf180mcu_as_sc_mcu7t3v3__tap_2
X_5664_ VDD VDD VSS VSS _5957_/A _5664_/B _5664_/A gf180mcu_as_sc_mcu7t3v3__nor2b_2
XFILLER_136_629 VDD VDD VSS VSS gf180mcu_as_sc_mcu7t3v3__fill_1
XFILLER_191_735 VDD VDD VSS VSS gf180mcu_as_sc_mcu7t3v3__fill_1
XTAP_TAPCELL_ROW_174_1870 VDD VSS gf180mcu_as_sc_mcu7t3v3__tap_2
X_5595_ VDD VDD VSS VSS _5596_/A _5904_/A _5616_/B _5595_/C gf180mcu_as_sc_mcu7t3v3__ao21_2
X_4615_ VDD VDD VSS VSS _4615_/A _4615_/B _4615_/C _4615_/D _4617_/B gf180mcu_as_sc_mcu7t3v3__ao211_2
XFILLER_190_223 VDD VDD VSS VSS gf180mcu_as_sc_mcu7t3v3__fillcap_4
XTAP_TAPCELL_ROW_174_1881 VDD VSS gf180mcu_as_sc_mcu7t3v3__tap_2
X_4546_ VDD VDD VSS VSS _6301_/D _6146_/Q _4546_/B _4546_/C gf180mcu_as_sc_mcu7t3v3__ao21_2
XPHY_EDGE_ROW_194_Left_422 VDD VSS gf180mcu_as_sc_mcu7t3v3__tap_2
XFILLER_171_492 VDD VDD VSS VSS gf180mcu_as_sc_mcu7t3v3__fillcap_8
XFILLER_172_993 VDD VDD VSS VSS gf180mcu_as_sc_mcu7t3v3__fillcap_16
X_4477_ VDD VDD VSS VSS _4478_/C _4477_/B _4477_/A gf180mcu_as_sc_mcu7t3v3__nor2_2
XPHY_EDGE_ROW_92_2_Left_533 VDD VSS gf180mcu_as_sc_mcu7t3v3__tap_2
Xfanout902 VDD VDD VSS VSS _6265_/Q _3433_/B gf180mcu_as_sc_mcu7t3v3__buff_12
Xfanout913 VDD VDD VSS VSS _4307_/S _4321_/S gf180mcu_as_sc_mcu7t3v3__buff_12
Xfanout924 VDD VDD VSS VSS _5796_/A _5238_/A gf180mcu_as_sc_mcu7t3v3__buff_12
X_6216_ VDD VDD VSS VSS _6368_/CLK _6216_/D _6216_/Q gf180mcu_as_sc_mcu7t3v3__dfxtp_2
X_3428_ VDD VDD VSS VSS _4509_/A _4443_/B _3428_/C _4610_/A _3429_/B gf180mcu_as_sc_mcu7t3v3__ao211_2
XFILLER_225_72 VDD VDD VSS VSS gf180mcu_as_sc_mcu7t3v3__fill_2
Xfanout935 VDD VDD VSS VSS fanout935/A fanout935/Y gf180mcu_as_sc_mcu7t3v3__buff_12
Xfanout946 VDD VDD VSS VSS _3591_/A _3638_/A gf180mcu_as_sc_mcu7t3v3__buff_12
Xfanout968 VDD VDD VSS VSS _3540_/A _5936_/D gf180mcu_as_sc_mcu7t3v3__buff_12
X_6147_ VDD VDD VSS VSS clkload8/A _6147_/D _6147_/Q gf180mcu_as_sc_mcu7t3v3__dfxtp_2
X_3359_ VDD VDD VSS VSS _6202_/Q _4072_/B _4093_/S _6226_/Q _3360_/B gf180mcu_as_sc_mcu7t3v3__ao22_2
XFILLER_161_38 VDD VDD VSS VSS gf180mcu_as_sc_mcu7t3v3__fillcap_16
XFILLER_219_928 VDD VDD VSS VSS gf180mcu_as_sc_mcu7t3v3__fillcap_16
XFILLER_38_37 VDD VDD VSS VSS gf180mcu_as_sc_mcu7t3v3__fillcap_8
XTAP_TAPCELL_ROW_16_1298 VDD VSS gf180mcu_as_sc_mcu7t3v3__tap_2
XFILLER_22_1242 VDD VDD VSS VSS gf180mcu_as_sc_mcu7t3v3__fill_1
X_6078_ VDD VDD VSS VSS _6506_/CLK _6078_/D _6078_/Q gf180mcu_as_sc_mcu7t3v3__dfxtp_2
Xhold1188 VDD VDD VSS VSS _3197_/Y _3198_/B gf180mcu_as_sc_mcu7t3v3__clkbuff_4
Xhold1199 VDD VDD VSS VSS hold1223/Y _6534_/D gf180mcu_as_sc_mcu7t3v3__clkbuff_4
X_5029_ VDD VDD VSS VSS _5030_/D _5141_/B _5138_/B _5029_/A gf180mcu_as_sc_mcu7t3v3__aoi21_2
XFILLER_166_6 VDD VDD VSS VSS gf180mcu_as_sc_mcu7t3v3__fillcap_4
XFILLER_81_660 VDD VDD VSS VSS gf180mcu_as_sc_mcu7t3v3__fill_2
XFILLER_0_1060 VDD VDD VSS VSS gf180mcu_as_sc_mcu7t3v3__fill_1
XFILLER_158_209 VDD VDD VSS VSS gf180mcu_as_sc_mcu7t3v3__fillcap_16
XFILLER_201_349 VDD VDD VSS VSS gf180mcu_as_sc_mcu7t3v3__fill_1
XFILLER_210_883 VDD VDD VSS VSS gf180mcu_as_sc_mcu7t3v3__fill_1
XPHY_EDGE_ROW_36_3_Right_116 VDD VSS gf180mcu_as_sc_mcu7t3v3__tap_2
XFILLER_186_68 VDD VDD VSS VSS gf180mcu_as_sc_mcu7t3v3__fillcap_16
XFILLER_181_212 VDD VDD VSS VSS gf180mcu_as_sc_mcu7t3v3__fillcap_8
XFILLER_163_982 VDD VDD VSS VSS gf180mcu_as_sc_mcu7t3v3__fillcap_16
XFILLER_218_1103 VDD VDD VSS VSS gf180mcu_as_sc_mcu7t3v3__fillcap_16
XFILLER_162_470 VDD VDD VSS VSS gf180mcu_as_sc_mcu7t3v3__fill_2
XTAP_TAPCELL_ROW_53_2_2928 VDD VSS gf180mcu_as_sc_mcu7t3v3__tap_2
XFILLER_149_1208 VDD VDD VSS VSS gf180mcu_as_sc_mcu7t3v3__fillcap_16
XFILLER_204_121 VDD VDD VSS VSS gf180mcu_as_sc_mcu7t3v3__fill_1
XFILLER_205_644 VDD VDD VSS VSS gf180mcu_as_sc_mcu7t3v3__fillcap_8
XFILLER_189_356 VDD VDD VSS VSS gf180mcu_as_sc_mcu7t3v3__fill_1
XPHY_EDGE_ROW_88_1_Left_316 VDD VSS gf180mcu_as_sc_mcu7t3v3__tap_2
XFILLER_118_629 VDD VDD VSS VSS gf180mcu_as_sc_mcu7t3v3__fillcap_8
XFILLER_158_787 VDD VDD VSS VSS gf180mcu_as_sc_mcu7t3v3__fillcap_16
XFILLER_173_702 VDD VDD VSS VSS gf180mcu_as_sc_mcu7t3v3__fillcap_8
XFILLER_8_241 VDD VDD VSS VSS gf180mcu_as_sc_mcu7t3v3__fillcap_4
XFILLER_8_263 VDD VDD VSS VSS gf180mcu_as_sc_mcu7t3v3__fillcap_16
XTAP_TAPCELL_ROW_191_2181 VDD VSS gf180mcu_as_sc_mcu7t3v3__tap_2
XPHY_EDGE_ROW_140_1_Left_368 VDD VSS gf180mcu_as_sc_mcu7t3v3__tap_2
X_4400_ VDD VDD VSS VSS _4402_/A _4400_/C _4400_/B _6144_/Q gf180mcu_as_sc_mcu7t3v3__aoi21_2
XPHY_EDGE_ROW_154_Right_22 VDD VSS gf180mcu_as_sc_mcu7t3v3__tap_2
X_5380_ VDD VDD VSS VSS _5380_/B _5396_/A _6414_/D gf180mcu_as_sc_mcu7t3v3__and2_2
XFILLER_153_492 VDD VDD VSS VSS gf180mcu_as_sc_mcu7t3v3__fillcap_4
XTAP_TAPCELL_ROW_152_1475 VDD VSS gf180mcu_as_sc_mcu7t3v3__tap_2
XTAP_TAPCELL_ROW_152_1486 VDD VSS gf180mcu_as_sc_mcu7t3v3__tap_2
X_4331_ VDD VDD VSS VSS _4366_/A _4331_/B _4331_/C _4332_/B _4373_/D gf180mcu_as_sc_mcu7t3v3__oai211_2
X_4262_ VDD VDD VSS VSS _4348_/D _4262_/B _4262_/A _4263_/B gf180mcu_as_sc_mcu7t3v3__mux2_2
X_6001_ VDD VDD VSS VSS _6010_/B _6224_/Q _6514_/D gf180mcu_as_sc_mcu7t3v3__and2_2
X_3213_ VDD VDD VSS VSS _3294_/B _3213_/B _3281_/D _3214_/A gf180mcu_as_sc_mcu7t3v3__mux2_2
XFILLER_132_1245 VDD VDD VSS VSS gf180mcu_as_sc_mcu7t3v3__fillcap_16
X_4193_ VDD VDD VSS VSS _6716_/A _4337_/B _4193_/C _4223_/B _4194_/C gf180mcu_as_sc_mcu7t3v3__ao211_2
XFILLER_228_747 VDD VDD VSS VSS gf180mcu_as_sc_mcu7t3v3__fill_1
XPHY_EDGE_ROW_42_1_Right_614 VDD VSS gf180mcu_as_sc_mcu7t3v3__tap_2
X_3144_ VDD VDD VSS VSS _4456_/A _3434_/A _4528_/C _3251_/B gf180mcu_as_sc_mcu7t3v3__nor3_2
X_3075_ VDD VDD VSS VSS _4792_/A _5799_/A gf180mcu_as_sc_mcu7t3v3__inv_2
XTAP_TAPCELL_ROW_198_2302 VDD VSS gf180mcu_as_sc_mcu7t3v3__tap_2
XFILLER_70_619 VDD VDD VSS VSS gf180mcu_as_sc_mcu7t3v3__fillcap_8
XPHY_EDGE_ROW_163_Right_31 VDD VSS gf180mcu_as_sc_mcu7t3v3__tap_2
XTAP_TAPCELL_ROW_198_2313 VDD VSS gf180mcu_as_sc_mcu7t3v3__tap_2
XFILLER_165_1021 VDD VDD VSS VSS gf180mcu_as_sc_mcu7t3v3__fillcap_16
XFILLER_223_430 VDD VDD VSS VSS gf180mcu_as_sc_mcu7t3v3__fill_2
XPHY_EDGE_ROW_25_2_Right_862 VDD VSS gf180mcu_as_sc_mcu7t3v3__tap_2
XTAP_TAPCELL_ROW_159_1607 VDD VSS gf180mcu_as_sc_mcu7t3v3__tap_2
XFILLER_149_732 VDD VDD VSS VSS gf180mcu_as_sc_mcu7t3v3__fillcap_16
XFILLER_223_496 VDD VDD VSS VSS gf180mcu_as_sc_mcu7t3v3__fill_2
XTAP_TAPCELL_ROW_176_1910 VDD VSS gf180mcu_as_sc_mcu7t3v3__tap_2
X_3977_ VDD VDD VSS VSS _3977_/D _4053_/A _4057_/B _3981_/C _6070_/D gf180mcu_as_sc_mcu7t3v3__ao31_2
XFILLER_13_1208 VDD VDD VSS VSS gf180mcu_as_sc_mcu7t3v3__fillcap_16
XFILLER_149_754 VDD VDD VSS VSS gf180mcu_as_sc_mcu7t3v3__fill_2
XFILLER_210_168 VDD VDD VSS VSS gf180mcu_as_sc_mcu7t3v3__fillcap_4
XFILLER_52_1257 VDD VDD VSS VSS gf180mcu_as_sc_mcu7t3v3__fillcap_8
X_5716_ VDD VDD VSS VSS _5798_/S _5716_/B _6498_/Q _5717_/C gf180mcu_as_sc_mcu7t3v3__mux2_2
XTAP_TAPCELL_ROW_217_2641 VDD VSS gf180mcu_as_sc_mcu7t3v3__tap_2
XFILLER_164_724 VDD VDD VSS VSS gf180mcu_as_sc_mcu7t3v3__fill_1
XFILLER_40_27 VDD VDD VSS VSS gf180mcu_as_sc_mcu7t3v3__fillcap_8
XTAP_TAPCELL_ROW_172_1829 VDD VSS gf180mcu_as_sc_mcu7t3v3__tap_2
XTAP_TAPCELL_ROW_217_2652 VDD VSS gf180mcu_as_sc_mcu7t3v3__tap_2
XFILLER_163_212 VDD VDD VSS VSS gf180mcu_as_sc_mcu7t3v3__fillcap_8
XFILLER_191_532 VDD VDD VSS VSS gf180mcu_as_sc_mcu7t3v3__fillcap_16
XFILLER_40_49 VDD VDD VSS VSS gf180mcu_as_sc_mcu7t3v3__fill_2
XPHY_EDGE_ROW_172_Right_40 VDD VSS gf180mcu_as_sc_mcu7t3v3__tap_2
X_5647_ VDD VDD VSS VSS _5674_/A _5649_/B _5649_/A gf180mcu_as_sc_mcu7t3v3__nand2_2
XFILLER_163_267 VDD VDD VSS VSS gf180mcu_as_sc_mcu7t3v3__fillcap_8
X_5578_ VDD VDD VSS VSS _5578_/B _5578_/A _6438_/D gf180mcu_as_sc_mcu7t3v3__and2_2
X_4529_ VDD VDD VSS VSS _4537_/S _6295_/Q _6296_/Q _4530_/B gf180mcu_as_sc_mcu7t3v3__mux2_2
XFILLER_132_665 VDD VDD VSS VSS gf180mcu_as_sc_mcu7t3v3__fill_2
XFILLER_172_37 VDD VDD VSS VSS gf180mcu_as_sc_mcu7t3v3__fillcap_16
Xfanout710 VDD VDD VSS VSS _3161_/Y _4144_/S gf180mcu_as_sc_mcu7t3v3__buff_12
Xfanout721 VDD VDD VSS VSS _5879_/D _5871_/D gf180mcu_as_sc_mcu7t3v3__buff_12
Xfanout732 VDD VDD VSS VSS _5572_/B _5563_/C gf180mcu_as_sc_mcu7t3v3__buff_12
Xfanout743 VDD VDD VSS VSS _3757_/B _3887_/B gf180mcu_as_sc_mcu7t3v3__buff_12
Xfanout754 VDD VDD VSS VSS _5878_/S _5862_/S gf180mcu_as_sc_mcu7t3v3__buff_12
Xfanout765 VDD VDD VSS VSS _5184_/B _5139_/C gf180mcu_as_sc_mcu7t3v3__buff_12
Xfanout776 VDD VDD VSS VSS _5124_/B _5086_/B gf180mcu_as_sc_mcu7t3v3__buff_12
XFILLER_207_909 VDD VDD VSS VSS gf180mcu_as_sc_mcu7t3v3__fill_1
Xfanout787 VDD VDD VSS VSS _4861_/B _4851_/B gf180mcu_as_sc_mcu7t3v3__buff_12
Xfanout798 VDD VDD VSS VSS _4410_/Y _4446_/D gf180mcu_as_sc_mcu7t3v3__buff_12
XFILLER_148_1241 VDD VDD VSS VSS gf180mcu_as_sc_mcu7t3v3__fill_2
XFILLER_14_513 VDD VDD VSS VSS gf180mcu_as_sc_mcu7t3v3__fillcap_8
XFILLER_199_632 VDD VDD VSS VSS gf180mcu_as_sc_mcu7t3v3__fill_2
XFILLER_183_1154 VDD VDD VSS VSS gf180mcu_as_sc_mcu7t3v3__fillcap_16
XFILLER_198_142 VDD VDD VSS VSS gf180mcu_as_sc_mcu7t3v3__fill_1
XFILLER_199_665 VDD VDD VSS VSS gf180mcu_as_sc_mcu7t3v3__fillcap_16
XFILLER_197_67 VDD VDD VSS VSS gf180mcu_as_sc_mcu7t3v3__fill_2
XFILLER_224_1151 VDD VDD VSS VSS gf180mcu_as_sc_mcu7t3v3__fillcap_4
XFILLER_224_1173 VDD VDD VSS VSS gf180mcu_as_sc_mcu7t3v3__fillcap_16
XFILLER_155_702 VDD VDD VSS VSS gf180mcu_as_sc_mcu7t3v3__fillcap_16
XFILLER_167_562 VDD VDD VSS VSS gf180mcu_as_sc_mcu7t3v3__fillcap_16
XFILLER_195_871 VDD VDD VSS VSS gf180mcu_as_sc_mcu7t3v3__fill_2
XPHY_EDGE_ROW_37_3_Right_117 VDD VSS gf180mcu_as_sc_mcu7t3v3__tap_2
XFILLER_170_716 VDD VDD VSS VSS gf180mcu_as_sc_mcu7t3v3__fillcap_4
XFILLER_5_244 VDD VDD VSS VSS gf180mcu_as_sc_mcu7t3v3__fillcap_16
XFILLER_151_930 VDD VDD VSS VSS gf180mcu_as_sc_mcu7t3v3__fill_1
XFILLER_123_643 VDD VDD VSS VSS gf180mcu_as_sc_mcu7t3v3__fill_2
XFILLER_155_1234 VDD VDD VSS VSS gf180mcu_as_sc_mcu7t3v3__fillcap_16
XFILLER_190_1103 VDD VDD VSS VSS gf180mcu_as_sc_mcu7t3v3__fillcap_16
XFILLER_2_995 VDD VDD VSS VSS gf180mcu_as_sc_mcu7t3v3__fillcap_16
XFILLER_1_494 VDD VDD VSS VSS gf180mcu_as_sc_mcu7t3v3__fill_1
Xmesh_tile_1120 VDD VDD VSS VSS se_out[7] gf180mcu_as_sc_mcu7t3v3__tiel_4
XFILLER_37_638 VDD VDD VSS VSS gf180mcu_as_sc_mcu7t3v3__fill_2
Xinput9 VDD VDD VSS VSS boot_addr[1] input9/Y gf180mcu_as_sc_mcu7t3v3__buff_12
Xmesh_tile_1153 VDD VDD VSS VSS sw_out[4] gf180mcu_as_sc_mcu7t3v3__tiel_4
Xmesh_tile_1142 VDD VDD VSS VSS se_out[29] gf180mcu_as_sc_mcu7t3v3__tiel_4
Xmesh_tile_1131 VDD VDD VSS VSS se_out[18] gf180mcu_as_sc_mcu7t3v3__tiel_4
XFILLER_188_1065 VDD VDD VSS VSS gf180mcu_as_sc_mcu7t3v3__fillcap_16
XFILLER_188_1087 VDD VDD VSS VSS gf180mcu_as_sc_mcu7t3v3__fillcap_16
Xmesh_tile_1175 VDD VDD VSS VSS sw_out[26] gf180mcu_as_sc_mcu7t3v3__tiel_4
Xmesh_tile_1164 VDD VDD VSS VSS sw_out[15] gf180mcu_as_sc_mcu7t3v3__tiel_4
XFILLER_205_441 VDD VDD VSS VSS gf180mcu_as_sc_mcu7t3v3__fill_2
XFILLER_162_1205 VDD VDD VSS VSS gf180mcu_as_sc_mcu7t3v3__fillcap_16
XFILLER_189_142 VDD VDD VSS VSS gf180mcu_as_sc_mcu7t3v3__fill_2
XFILLER_221_923 VDD VDD VSS VSS gf180mcu_as_sc_mcu7t3v3__fillcap_16
X_4880_ VDD VDD VSS VSS _6517_/Q _4880_/B _4962_/C _5873_/A _4881_/C gf180mcu_as_sc_mcu7t3v3__ao22_2
X_3900_ VDD VDD VSS VSS _3928_/B _5880_/A _3901_/D gf180mcu_as_sc_mcu7t3v3__and2_2
XFILLER_162_1227 VDD VDD VSS VSS gf180mcu_as_sc_mcu7t3v3__fillcap_16
XFILLER_220_422 VDD VDD VSS VSS gf180mcu_as_sc_mcu7t3v3__fill_1
X_3831_ VDD VDD VSS VSS _3892_/B _5826_/A _3838_/C gf180mcu_as_sc_mcu7t3v3__and2_2
XTAP_TAPCELL_ROW_193_2221 VDD VSS gf180mcu_as_sc_mcu7t3v3__tap_2
XTAP_TAPCELL_ROW_193_2210 VDD VSS gf180mcu_as_sc_mcu7t3v3__tap_2
XFILLER_203_1224 VDD VDD VSS VSS gf180mcu_as_sc_mcu7t3v3__fillcap_8
X_6550_ VDD VDD VSS VSS _6551_/CLK _6550_/D _6550_/Q gf180mcu_as_sc_mcu7t3v3__dfxtp_2
X_3762_ VDD VDD VSS VSS _4033_/B _5763_/A _3874_/B _3762_/C gf180mcu_as_sc_mcu7t3v3__ao21_2
XTAP_TAPCELL_ROW_154_1515 VDD VSS gf180mcu_as_sc_mcu7t3v3__tap_2
X_5501_ VDD VDD VSS VSS _5573_/S _5807_/A _5501_/A _5503_/C gf180mcu_as_sc_mcu7t3v3__mux2_2
XFILLER_173_521 VDD VDD VSS VSS gf180mcu_as_sc_mcu7t3v3__fill_2
XFILLER_195_1014 VDD VDD VSS VSS gf180mcu_as_sc_mcu7t3v3__fillcap_16
X_6481_ VDD VDD VSS VSS _6484_/CLK _6481_/D _6481_/Q gf180mcu_as_sc_mcu7t3v3__dfxtp_2
X_3693_ VDD VDD VSS VSS _5702_/A _3808_/B _3693_/C _3809_/B _3695_/C gf180mcu_as_sc_mcu7t3v3__ao211_2
XFILLER_12_1263 VDD VDD VSS VSS gf180mcu_as_sc_mcu7t3v3__fill_2
X_5432_ VDD VDD VSS VSS _5742_/A _5549_/B _5549_/C _5741_/B _5433_/D gf180mcu_as_sc_mcu7t3v3__ao22_2
XFILLER_114_621 VDD VDD VSS VSS gf180mcu_as_sc_mcu7t3v3__fillcap_4
XPHY_EDGE_ROW_127_3_Left_832 VDD VSS gf180mcu_as_sc_mcu7t3v3__tap_2
X_5363_ VDD VDD VSS VSS _5563_/C _5673_/B _5366_/D gf180mcu_as_sc_mcu7t3v3__and2_2
XTAP_TAPCELL_ROW_212_2560 VDD VSS gf180mcu_as_sc_mcu7t3v3__tap_2
Xoutput368 VDD VDD VSS VSS _6442_/Q east_out[29] gf180mcu_as_sc_mcu7t3v3__buff_12
Xoutput357 VDD VDD VSS VSS _6432_/Q east_out[19] gf180mcu_as_sc_mcu7t3v3__buff_12
Xoutput346 VDD VDD VSS VSS _6722_/Y dft_rdata[7] gf180mcu_as_sc_mcu7t3v3__buff_12
X_4314_ VDD VDD VSS VSS _4363_/S _6055_/Q _6084_/Q _4317_/B gf180mcu_as_sc_mcu7t3v3__mux2_2
Xoutput379 VDD VDD VSS VSS _6419_/Q east_out[6] gf180mcu_as_sc_mcu7t3v3__buff_12
X_5294_ VDD VDD VSS VSS _5294_/A _5294_/B _5294_/C _5295_/B _5297_/B gf180mcu_as_sc_mcu7t3v3__ao211_2
XFILLER_206_85 VDD VDD VSS VSS gf180mcu_as_sc_mcu7t3v3__fillcap_16
X_4245_ VDD VDD VSS VSS _4342_/S _6046_/Q _6075_/Q _4246_/B gf180mcu_as_sc_mcu7t3v3__mux2_2
XTAP_TAPCELL_ROW_169_1780 VDD VSS gf180mcu_as_sc_mcu7t3v3__tap_2
XTAP_TAPCELL_ROW_169_1791 VDD VSS gf180mcu_as_sc_mcu7t3v3__tap_2
X_4176_ VDD VDD VSS VSS _4176_/B _4176_/A _4236_/C gf180mcu_as_sc_mcu7t3v3__and2_2
XFILLER_210_1239 VDD VDD VSS VSS gf180mcu_as_sc_mcu7t3v3__fill_1
XTAP_TAPCELL_ROW_13_1246 VDD VSS gf180mcu_as_sc_mcu7t3v3__tap_2
X_3127_ VDD VDD VSS VSS _4567_/B _6309_/Q _4462_/A gf180mcu_as_sc_mcu7t3v3__and2_2
XTAP_TAPCELL_ROW_23_2_2883 VDD VSS gf180mcu_as_sc_mcu7t3v3__tap_2
XFILLER_167_1116 VDD VDD VSS VSS gf180mcu_as_sc_mcu7t3v3__fillcap_4
XFILLER_216_739 VDD VDD VSS VSS gf180mcu_as_sc_mcu7t3v3__fill_1
XPHY_EDGE_ROW_43_1_Right_615 VDD VSS gf180mcu_as_sc_mcu7t3v3__tap_2
XFILLER_167_1138 VDD VDD VSS VSS gf180mcu_as_sc_mcu7t3v3__fillcap_16
XFILLER_35_49 VDD VDD VSS VSS gf180mcu_as_sc_mcu7t3v3__fill_2
X_3058_ VDD VDD VSS VSS _4236_/A _6165_/Q gf180mcu_as_sc_mcu7t3v3__inv_2
XFILLER_208_1135 VDD VDD VSS VSS gf180mcu_as_sc_mcu7t3v3__fillcap_16
XFILLER_208_1157 VDD VDD VSS VSS gf180mcu_as_sc_mcu7t3v3__fillcap_16
XFILLER_211_433 VDD VDD VSS VSS gf180mcu_as_sc_mcu7t3v3__fillcap_4
XFILLER_223_293 VDD VDD VSS VSS gf180mcu_as_sc_mcu7t3v3__fill_1
XPHY_EDGE_ROW_26_2_Right_863 VDD VSS gf180mcu_as_sc_mcu7t3v3__tap_2
XFILLER_11_549 VDD VDD VSS VSS gf180mcu_as_sc_mcu7t3v3__fillcap_8
XFILLER_149_562 VDD VDD VSS VSS gf180mcu_as_sc_mcu7t3v3__fillcap_16
XFILLER_183_329 VDD VDD VSS VSS gf180mcu_as_sc_mcu7t3v3__fillcap_4
XFILLER_149_584 VDD VDD VSS VSS gf180mcu_as_sc_mcu7t3v3__fill_2
XFILLER_176_370 VDD VDD VSS VSS gf180mcu_as_sc_mcu7t3v3__fillcap_4
XPHY_EDGE_ROW_59_3_Left_764 VDD VSS gf180mcu_as_sc_mcu7t3v3__tap_2
XFILLER_219_1264 VDD VDD VSS VSS gf180mcu_as_sc_mcu7t3v3__fill_1
XFILLER_2_247 VDD VDD VSS VSS gf180mcu_as_sc_mcu7t3v3__fillcap_16
XFILLER_160_760 VDD VDD VSS VSS gf180mcu_as_sc_mcu7t3v3__fill_2
XFILLER_183_69 VDD VDD VSS VSS gf180mcu_as_sc_mcu7t3v3__fill_1
XPHY_EDGE_ROW_118_2_Left_559 VDD VSS gf180mcu_as_sc_mcu7t3v3__tap_2
Xfanout540 VDD VDD VSS VSS _5531_/B _5497_/B gf180mcu_as_sc_mcu7t3v3__buff_12
Xfanout551 VDD VDD VSS VSS _5275_/B _5316_/S gf180mcu_as_sc_mcu7t3v3__buff_12
Xfanout562 VDD VDD VSS VSS _4061_/C _4057_/C gf180mcu_as_sc_mcu7t3v3__buff_12
Xfanout573 VDD VDD VSS VSS _3651_/Y _3856_/B gf180mcu_as_sc_mcu7t3v3__buff_12
Xfanout584 VDD VDD VSS VSS _5841_/B _5857_/B gf180mcu_as_sc_mcu7t3v3__buff_12
XFILLER_19_649 VDD VDD VSS VSS gf180mcu_as_sc_mcu7t3v3__fill_1
Xfanout595 VDD VDD VSS VSS _5641_/B _5634_/B gf180mcu_as_sc_mcu7t3v3__buff_12
Xclkbuf_leaf_12_clk_regs VDD VDD VSS VSS clkbuf_3_1_0_clk_regs/Y clkload8/A gf180mcu_as_sc_mcu7t3v3__clkbuff_12
XFILLER_92_33 VDD VDD VSS VSS gf180mcu_as_sc_mcu7t3v3__fill_2
XFILLER_199_440 VDD VDD VSS VSS gf180mcu_as_sc_mcu7t3v3__fillcap_4
XFILLER_203_912 VDD VDD VSS VSS gf180mcu_as_sc_mcu7t3v3__fillcap_16
XFILLER_215_772 VDD VDD VSS VSS gf180mcu_as_sc_mcu7t3v3__fill_2
XFILLER_14_365 VDD VDD VSS VSS gf180mcu_as_sc_mcu7t3v3__fillcap_16
XFILLER_122_1222 VDD VDD VSS VSS gf180mcu_as_sc_mcu7t3v3__fill_2
Xwire952 VDD VDD VSS VSS wire952/A _5872_/D gf180mcu_as_sc_mcu7t3v3__clkbuff_12
XFILLER_10_582 VDD VDD VSS VSS gf180mcu_as_sc_mcu7t3v3__fill_2
XFILLER_227_18 VDD VDD VSS VSS gf180mcu_as_sc_mcu7t3v3__fill_2
XPHY_EDGE_ROW_38_3_Right_118 VDD VSS gf180mcu_as_sc_mcu7t3v3__tap_2
XFILLER_170_524 VDD VDD VSS VSS gf180mcu_as_sc_mcu7t3v3__fill_1
Xwire996 VDD VDD VSS VSS wire996/A _5922_/A gf180mcu_as_sc_mcu7t3v3__clkbuff_12
XFILLER_6_597 VDD VDD VSS VSS gf180mcu_as_sc_mcu7t3v3__fillcap_4
XTAP_TAPCELL_ROW_118_2_3025 VDD VSS gf180mcu_as_sc_mcu7t3v3__tap_2
XFILLER_151_782 VDD VDD VSS VSS gf180mcu_as_sc_mcu7t3v3__fill_2
XFILLER_2_53 VDD VDD VSS VSS gf180mcu_as_sc_mcu7t3v3__fill_2
XPHY_EDGE_ROW_10_Right_10 VDD VSS gf180mcu_as_sc_mcu7t3v3__tap_2
X_4030_ VDD VDD VSS VSS _4055_/S _4030_/B _6111_/Q _6111_/D gf180mcu_as_sc_mcu7t3v3__mux2_2
XTAP_TAPCELL_ROW_186_2091 VDD VSS gf180mcu_as_sc_mcu7t3v3__tap_2
XFILLER_42_1245 VDD VDD VSS VSS gf180mcu_as_sc_mcu7t3v3__fillcap_16
X_5981_ VDD VDD VSS VSS _6006_/B _6204_/Q _6494_/D gf180mcu_as_sc_mcu7t3v3__and2_2
XFILLER_206_772 VDD VDD VSS VSS gf180mcu_as_sc_mcu7t3v3__fill_1
X_4932_ VDD VDD VSS VSS _4932_/A _4932_/B _4932_/C _4932_/D _4934_/C gf180mcu_as_sc_mcu7t3v3__ao211_2
XFILLER_205_282 VDD VDD VSS VSS gf180mcu_as_sc_mcu7t3v3__fill_1
XFILLER_33_652 VDD VDD VSS VSS gf180mcu_as_sc_mcu7t3v3__fillcap_8
XANTENNA_14 VDD VDD VSS VSS _4780_/B gf180mcu_as_sc_mcu7t3v3__diode_2
X_4863_ VDD VDD VSS VSS _4864_/B _5858_/A _4863_/B _4863_/C gf180mcu_as_sc_mcu7t3v3__ao21_2
XANTENNA_25 VDD VDD VSS VSS _5172_/A gf180mcu_as_sc_mcu7t3v3__diode_2
XANTENNA_36 VDD VDD VSS VSS _5931_/A gf180mcu_as_sc_mcu7t3v3__diode_2
XANTENNA_47 VDD VDD VSS VSS _5247_/A gf180mcu_as_sc_mcu7t3v3__diode_2
XFILLER_177_167 VDD VDD VSS VSS gf180mcu_as_sc_mcu7t3v3__fill_2
XFILLER_220_263 VDD VDD VSS VSS gf180mcu_as_sc_mcu7t3v3__fill_1
X_4794_ VDD VDD VSS VSS _4794_/S _4794_/B _6508_/Q _4796_/C gf180mcu_as_sc_mcu7t3v3__mux2_2
X_3814_ VDD VDD VSS VSS _3888_/B _5807_/A _3815_/D gf180mcu_as_sc_mcu7t3v3__and2_2
XTAP_TAPCELL_ROW_82_1_1362 VDD VSS gf180mcu_as_sc_mcu7t3v3__tap_2
XFILLER_192_115 VDD VDD VSS VSS gf180mcu_as_sc_mcu7t3v3__fillcap_4
XFILLER_192_137 VDD VDD VSS VSS gf180mcu_as_sc_mcu7t3v3__fill_1
X_6533_ VDD VDD VSS VSS _6546_/CLK _6533_/D _6533_/Q gf180mcu_as_sc_mcu7t3v3__dfxtp_2
X_3745_ VDD VDD VSS VSS _6502_/Q _3804_/B _3852_/B _5750_/A _3747_/C gf180mcu_as_sc_mcu7t3v3__ao22_2
XTAP_TAPCELL_ROW_214_2600 VDD VSS gf180mcu_as_sc_mcu7t3v3__tap_2
XFILLER_174_874 VDD VDD VSS VSS gf180mcu_as_sc_mcu7t3v3__fill_1
X_6464_ VDD VDD VSS VSS clkload4/A _6464_/D _6464_/Q gf180mcu_as_sc_mcu7t3v3__dfxtp_2
X_6528__1186 VDD VDD VSS VSS _6528_/RN gf180mcu_as_sc_mcu7t3v3__tieh_4
X_5415_ VDD VDD VSS VSS _6499_/Q _5564_/B _5563_/C _5724_/B _5416_/C gf180mcu_as_sc_mcu7t3v3__ao22_2
X_3676_ VDD VDD VSS VSS _4021_/A _3676_/C _3810_/B _5687_/A gf180mcu_as_sc_mcu7t3v3__aoi21_2
XTAP_TAPCELL_ROW_210_2519 VDD VSS gf180mcu_as_sc_mcu7t3v3__tap_2
X_6395_ VDD VDD VSS VSS clkload3/A _6395_/D _6395_/Q gf180mcu_as_sc_mcu7t3v3__dfxtp_2
X_5346_ VDD VDD VSS VSS _5346_/A _5346_/B _5346_/C _5346_/D _5656_/A gf180mcu_as_sc_mcu7t3v3__nand4_2
XFILLER_173_1186 VDD VDD VSS VSS gf180mcu_as_sc_mcu7t3v3__fillcap_4
X_5277_ VDD VDD VSS VSS _5294_/A _5920_/A _5922_/A _5278_/D gf180mcu_as_sc_mcu7t3v3__mux2_2
XTAP_TAPCELL_ROW_167_1739 VDD VSS gf180mcu_as_sc_mcu7t3v3__tap_2
X_4228_ VDD VDD VSS VSS _6202_/Q _4230_/B _4337_/B _6721_/A _4229_/B gf180mcu_as_sc_mcu7t3v3__ao22_2
XFILLER_46_37 VDD VDD VSS VSS gf180mcu_as_sc_mcu7t3v3__fillcap_8
X_4159_ VDD VDD VSS VSS _4237_/B _6012_/C _6262_/Q gf180mcu_as_sc_mcu7t3v3__nor2_2
XTAP_TAPCELL_ROW_225_2784 VDD VSS gf180mcu_as_sc_mcu7t3v3__tap_2
XPHY_EDGE_ROW_44_1_Right_616 VDD VSS gf180mcu_as_sc_mcu7t3v3__tap_2
XTAP_TAPCELL_ROW_225_2795 VDD VSS gf180mcu_as_sc_mcu7t3v3__tap_2
XFILLER_83_596 VDD VDD VSS VSS gf180mcu_as_sc_mcu7t3v3__fill_1
XFILLER_168_101 VDD VDD VSS VSS gf180mcu_as_sc_mcu7t3v3__fillcap_4
XFILLER_197_944 VDD VDD VSS VSS gf180mcu_as_sc_mcu7t3v3__fillcap_16
XFILLER_19_1214 VDD VDD VSS VSS gf180mcu_as_sc_mcu7t3v3__fillcap_16
XFILLER_24_641 VDD VDD VSS VSS gf180mcu_as_sc_mcu7t3v3__fill_2
XFILLER_24_663 VDD VDD VSS VSS gf180mcu_as_sc_mcu7t3v3__fillcap_4
XFILLER_168_123 VDD VDD VSS VSS gf180mcu_as_sc_mcu7t3v3__fillcap_16
XFILLER_169_657 VDD VDD VSS VSS gf180mcu_as_sc_mcu7t3v3__fillcap_8
XFILLER_180_1135 VDD VDD VSS VSS gf180mcu_as_sc_mcu7t3v3__fillcap_16
XFILLER_11_346 VDD VDD VSS VSS gf180mcu_as_sc_mcu7t3v3__fillcap_4
XFILLER_180_1157 VDD VDD VSS VSS gf180mcu_as_sc_mcu7t3v3__fillcap_16
XFILLER_196_454 VDD VDD VSS VSS gf180mcu_as_sc_mcu7t3v3__fill_1
XFILLER_8_807 VDD VDD VSS VSS gf180mcu_as_sc_mcu7t3v3__fillcap_16
XPHY_EDGE_ROW_27_2_Right_864 VDD VSS gf180mcu_as_sc_mcu7t3v3__tap_2
XFILLER_221_1154 VDD VDD VSS VSS gf180mcu_as_sc_mcu7t3v3__fillcap_16
XFILLER_183_148 VDD VDD VSS VSS gf180mcu_as_sc_mcu7t3v3__fill_1
XFILLER_192_660 VDD VDD VSS VSS gf180mcu_as_sc_mcu7t3v3__fillcap_4
XFILLER_152_524 VDD VDD VSS VSS gf180mcu_as_sc_mcu7t3v3__fill_1
XFILLER_164_384 VDD VDD VSS VSS gf180mcu_as_sc_mcu7t3v3__fill_1
XFILLER_180_811 VDD VDD VSS VSS gf180mcu_as_sc_mcu7t3v3__fill_2
XFILLER_164_395 VDD VDD VSS VSS gf180mcu_as_sc_mcu7t3v3__fill_2
XFILLER_3_578 VDD VDD VSS VSS gf180mcu_as_sc_mcu7t3v3__fill_2
XFILLER_191_1264 VDD VDD VSS VSS gf180mcu_as_sc_mcu7t3v3__fill_1
XFILLER_3_589 VDD VDD VSS VSS gf180mcu_as_sc_mcu7t3v3__fill_1
XFILLER_152_1259 VDD VDD VSS VSS gf180mcu_as_sc_mcu7t3v3__fill_2
XFILLER_143_50 VDD VDD VSS VSS gf180mcu_as_sc_mcu7t3v3__fill_1
XFILLER_219_352 VDD VDD VSS VSS gf180mcu_as_sc_mcu7t3v3__fillcap_4
XPHY_EDGE_ROW_97_1_Left_325 VDD VSS gf180mcu_as_sc_mcu7t3v3__tap_2
XTAP_TAPCELL_ROW_24_1_1333 VDD VSS gf180mcu_as_sc_mcu7t3v3__tap_2
XFILLER_185_1046 VDD VDD VSS VSS gf180mcu_as_sc_mcu7t3v3__fillcap_4
XFILLER_185_1068 VDD VDD VSS VSS gf180mcu_as_sc_mcu7t3v3__fillcap_16
XTAP_TAPCELL_ROW_5_1097 VDD VSS gf180mcu_as_sc_mcu7t3v3__tap_2
XFILLER_226_1065 VDD VDD VSS VSS gf180mcu_as_sc_mcu7t3v3__fillcap_16
XFILLER_188_988 VDD VDD VSS VSS gf180mcu_as_sc_mcu7t3v3__fillcap_16
XFILLER_226_1087 VDD VDD VSS VSS gf180mcu_as_sc_mcu7t3v3__fillcap_16
XFILLER_200_1205 VDD VDD VSS VSS gf180mcu_as_sc_mcu7t3v3__fillcap_16
Xinput12 VDD VDD VSS VSS boot_addr[4] _3269_/A gf180mcu_as_sc_mcu7t3v3__buff_12
XFILLER_190_608 VDD VDD VSS VSS gf180mcu_as_sc_mcu7t3v3__fillcap_4
XFILLER_200_1227 VDD VDD VSS VSS gf180mcu_as_sc_mcu7t3v3__fillcap_8
Xinput23 VDD VDD VSS VSS boot_data[5] _3347_/A gf180mcu_as_sc_mcu7t3v3__buff_12
Xinput34 VDD VDD VSS VSS dft_addr[5] _3278_/B gf180mcu_as_sc_mcu7t3v3__buff_12
Xinput45 VDD VDD VSS VSS dft_wdata[4] _3340_/B gf180mcu_as_sc_mcu7t3v3__buff_12
X_3530_ VDD VDD VSS VSS _5335_/D _5335_/C _3532_/D gf180mcu_as_sc_mcu7t3v3__or2_2
XFILLER_156_885 VDD VDD VSS VSS gf180mcu_as_sc_mcu7t3v3__fill_2
XFILLER_6_350 VDD VDD VSS VSS gf180mcu_as_sc_mcu7t3v3__fillcap_8
XPHY_EDGE_ROW_39_3_Right_119 VDD VSS gf180mcu_as_sc_mcu7t3v3__tap_2
Xinput56 VDD VDD VSS VSS east_in[15] _5797_/A gf180mcu_as_sc_mcu7t3v3__buff_12
Xinput67 VDD VDD VSS VSS east_in[25] wire951/A gf180mcu_as_sc_mcu7t3v3__buff_12
Xinput78 VDD VDD VSS VSS east_in[35] _5652_/C gf180mcu_as_sc_mcu7t3v3__buff_12
Xinput89 VDD VDD VSS VSS ne_in[12] _5772_/A gf180mcu_as_sc_mcu7t3v3__buff_12
XTAP_TAPCELL_ROW_59_2_2937 VDD VSS gf180mcu_as_sc_mcu7t3v3__tap_2
XFILLER_192_1017 VDD VDD VSS VSS gf180mcu_as_sc_mcu7t3v3__fillcap_16
X_3461_ VDD VDD VSS VSS _3615_/A _5970_/A _6491_/Q gf180mcu_as_sc_mcu7t3v3__nand2_2
XTAP_TAPCELL_ROW_188_2131 VDD VSS gf180mcu_as_sc_mcu7t3v3__tap_2
XTAP_TAPCELL_ROW_188_2120 VDD VSS gf180mcu_as_sc_mcu7t3v3__tap_2
X_6180_ VDD VDD VSS VSS _6490_/CLK _6180_/D _6180_/Q gf180mcu_as_sc_mcu7t3v3__dfxtp_2
X_5200_ VDD VDD VSS VSS _5237_/S _5851_/A _5200_/A _5201_/B gf180mcu_as_sc_mcu7t3v3__mux2_2
X_3392_ VDD VDD VSS VSS _4511_/A _3392_/B _3392_/C _3392_/D _4102_/C gf180mcu_as_sc_mcu7t3v3__ao211_2
XFILLER_170_387 VDD VDD VSS VSS gf180mcu_as_sc_mcu7t3v3__fill_1
XTAP_TAPCELL_ROW_149_1403 VDD VSS gf180mcu_as_sc_mcu7t3v3__tap_2
XTAP_TAPCELL_ROW_149_1414 VDD VSS gf180mcu_as_sc_mcu7t3v3__tap_2
X_5131_ VDD VDD VSS VSS _5133_/C _5789_/A _5140_/B _5131_/C gf180mcu_as_sc_mcu7t3v3__ao21_2
XFILLER_97_666 VDD VDD VSS VSS gf180mcu_as_sc_mcu7t3v3__fill_1
XTAP_TAPCELL_ROW_149_1425 VDD VSS gf180mcu_as_sc_mcu7t3v3__tap_2
X_5062_ VDD VDD VSS VSS _5063_/B _5804_/D _5228_/S _5730_/A gf180mcu_as_sc_mcu7t3v3__aoi21b_2
X_4013_ VDD VDD VSS VSS _4059_/B _4014_/B _4014_/C _6101_/Q _6101_/D gf180mcu_as_sc_mcu7t3v3__ao22_2
XFILLER_226_834 VDD VDD VSS VSS gf180mcu_as_sc_mcu7t3v3__fillcap_8
XTAP_TAPCELL_ROW_207_2470 VDD VSS gf180mcu_as_sc_mcu7t3v3__tap_2
XTAP_TAPCELL_ROW_162_1658 VDD VSS gf180mcu_as_sc_mcu7t3v3__tap_2
XFILLER_164_1119 VDD VDD VSS VSS gf180mcu_as_sc_mcu7t3v3__fillcap_16
X_5964_ VDD VDD VSS VSS _5966_/B _5971_/B _5971_/A gf180mcu_as_sc_mcu7t3v3__nand2_2
XTAP_TAPCELL_ROW_203_2389 VDD VSS gf180mcu_as_sc_mcu7t3v3__tap_2
XFILLER_178_443 VDD VDD VSS VSS gf180mcu_as_sc_mcu7t3v3__fill_1
XFILLER_205_1116 VDD VDD VSS VSS gf180mcu_as_sc_mcu7t3v3__fillcap_4
X_5895_ VDD VDD VSS VSS _5952_/B _5895_/A _5899_/C gf180mcu_as_sc_mcu7t3v3__and2_2
X_4915_ VDD VDD VSS VSS _5904_/A _4959_/B _4953_/C _5904_/D _4916_/D gf180mcu_as_sc_mcu7t3v3__ao22_2
XFILLER_166_605 VDD VDD VSS VSS gf180mcu_as_sc_mcu7t3v3__fill_2
XFILLER_205_1138 VDD VDD VSS VSS gf180mcu_as_sc_mcu7t3v3__fillcap_16
XFILLER_21_655 VDD VDD VSS VSS gf180mcu_as_sc_mcu7t3v3__fillcap_4
X_4846_ VDD VDD VSS VSS _4850_/B _4885_/B _5848_/A gf180mcu_as_sc_mcu7t3v3__nand2_2
XFILLER_165_104 VDD VDD VSS VSS gf180mcu_as_sc_mcu7t3v3__fillcap_16
XFILLER_194_947 VDD VDD VSS VSS gf180mcu_as_sc_mcu7t3v3__fillcap_16
XFILLER_21_666 VDD VDD VSS VSS gf180mcu_as_sc_mcu7t3v3__fill_1
XFILLER_88_1212 VDD VDD VSS VSS gf180mcu_as_sc_mcu7t3v3__fill_1
X_6516_ VDD VDD VSS VSS _6518_/CLK _6516_/D _6516_/Q gf180mcu_as_sc_mcu7t3v3__dfxtp_2
X_4777_ VDD VDD VSS VSS _5786_/D _4795_/B _4777_/C _4777_/D _4778_/C gf180mcu_as_sc_mcu7t3v3__ao211_2
XFILLER_180_107 VDD VDD VSS VSS gf180mcu_as_sc_mcu7t3v3__fillcap_8
XFILLER_88_1245 VDD VDD VSS VSS gf180mcu_as_sc_mcu7t3v3__fillcap_16
X_3728_ VDD VDD VSS VSS _5733_/A _3757_/B _3728_/C _3728_/D _3730_/C gf180mcu_as_sc_mcu7t3v3__ao211_2
XTAP_TAPCELL_ROW_94_2_2989 VDD VSS gf180mcu_as_sc_mcu7t3v3__tap_2
X_6447_ VDD VDD VSS VSS _6448_/CLK _6447_/D _6447_/Q gf180mcu_as_sc_mcu7t3v3__dfxtp_2
X_3659_ VDD VDD VSS VSS _6493_/Q _3897_/B _3886_/C _5673_/B _3661_/C gf180mcu_as_sc_mcu7t3v3__ao22_2
XFILLER_162_877 VDD VDD VSS VSS gf180mcu_as_sc_mcu7t3v3__fill_2
X_6378_ VDD VDD VSS VSS _6527_/CLK _6378_/D _6378_/Q gf180mcu_as_sc_mcu7t3v3__dfxtp_2
X_5329_ VDD VDD VSS VSS _5331_/B _5329_/A _5930_/D _5329_/C gf180mcu_as_sc_mcu7t3v3__maj3_2
XFILLER_88_666 VDD VDD VSS VSS gf180mcu_as_sc_mcu7t3v3__fill_1
XTAP_TAPCELL_ROW_227_2835 VDD VSS gf180mcu_as_sc_mcu7t3v3__tap_2
XTAP_TAPCELL_ROW_227_2824 VDD VSS gf180mcu_as_sc_mcu7t3v3__tap_2
XFILLER_112_1210 VDD VDD VSS VSS gf180mcu_as_sc_mcu7t3v3__fillcap_8
XFILLER_180_37 VDD VDD VSS VSS gf180mcu_as_sc_mcu7t3v3__fillcap_4
XFILLER_217_801 VDD VDD VSS VSS gf180mcu_as_sc_mcu7t3v3__fillcap_4
XFILLER_16_405 VDD VDD VSS VSS gf180mcu_as_sc_mcu7t3v3__fill_2
XFILLER_217_867 VDD VDD VSS VSS gf180mcu_as_sc_mcu7t3v3__fillcap_4
XPHY_EDGE_ROW_45_1_Right_617 VDD VSS gf180mcu_as_sc_mcu7t3v3__tap_2
XFILLER_169_454 VDD VDD VSS VSS gf180mcu_as_sc_mcu7t3v3__fill_2
XFILLER_12_677 VDD VDD VSS VSS gf180mcu_as_sc_mcu7t3v3__fill_1
XFILLER_12_688 VDD VDD VSS VSS gf180mcu_as_sc_mcu7t3v3__fillcap_8
XFILLER_169_487 VDD VDD VSS VSS gf180mcu_as_sc_mcu7t3v3__fill_2
XFILLER_185_936 VDD VDD VSS VSS gf180mcu_as_sc_mcu7t3v3__fill_2
XFILLER_200_745 VDD VDD VSS VSS gf180mcu_as_sc_mcu7t3v3__fillcap_4
XFILLER_8_615 VDD VDD VSS VSS gf180mcu_as_sc_mcu7t3v3__fill_1
XPHY_EDGE_ROW_28_2_Right_865 VDD VSS gf180mcu_as_sc_mcu7t3v3__tap_2
XFILLER_184_457 VDD VDD VSS VSS gf180mcu_as_sc_mcu7t3v3__fillcap_8
XFILLER_7_136 VDD VDD VSS VSS gf180mcu_as_sc_mcu7t3v3__fillcap_4
XFILLER_184_479 VDD VDD VSS VSS gf180mcu_as_sc_mcu7t3v3__fill_1
XFILLER_7_158 VDD VDD VSS VSS gf180mcu_as_sc_mcu7t3v3__fillcap_16
XFILLER_79_666 VDD VDD VSS VSS gf180mcu_as_sc_mcu7t3v3__fill_1
XTAP_TAPCELL_ROW_7_1148 VDD VSS gf180mcu_as_sc_mcu7t3v3__tap_2
XTAP_TAPCELL_ROW_7_1137 VDD VSS gf180mcu_as_sc_mcu7t3v3__tap_2
XFILLER_228_1105 VDD VDD VSS VSS gf180mcu_as_sc_mcu7t3v3__fillcap_4
XFILLER_179_207 VDD VDD VSS VSS gf180mcu_as_sc_mcu7t3v3__fill_2
XFILLER_15_460 VDD VDD VSS VSS gf180mcu_as_sc_mcu7t3v3__fillcap_16
XPHY_EDGE_ROW_136_3_Left_841 VDD VSS gf180mcu_as_sc_mcu7t3v3__tap_2
XFILLER_128_1261 VDD VDD VSS VSS gf180mcu_as_sc_mcu7t3v3__fillcap_4
XFILLER_97_4 VDD VDD VSS VSS gf180mcu_as_sc_mcu7t3v3__fillcap_16
X_5680_ VDD VDD VSS VSS _5680_/B _5836_/A _6449_/D gf180mcu_as_sc_mcu7t3v3__and2_2
X_4700_ VDD VDD VSS VSS _4701_/B _5715_/A _4932_/A _4700_/C gf180mcu_as_sc_mcu7t3v3__ao21_2
XFILLER_175_413 VDD VDD VSS VSS gf180mcu_as_sc_mcu7t3v3__fillcap_4
XFILLER_176_958 VDD VDD VSS VSS gf180mcu_as_sc_mcu7t3v3__fill_2
XTAP_TAPCELL_ROW_106_2_3007 VDD VSS gf180mcu_as_sc_mcu7t3v3__tap_2
X_4631_ VDD VDD VSS VSS _4984_/C _4632_/A _4632_/B _4632_/C gf180mcu_as_sc_mcu7t3v3__ao21_2
XFILLER_175_446 VDD VDD VSS VSS gf180mcu_as_sc_mcu7t3v3__fill_1
XFILLER_8_85 VDD VDD VSS VSS gf180mcu_as_sc_mcu7t3v3__fillcap_16
XFILLER_156_660 VDD VDD VSS VSS gf180mcu_as_sc_mcu7t3v3__fillcap_4
XFILLER_162_107 VDD VDD VSS VSS gf180mcu_as_sc_mcu7t3v3__fillcap_16
XFILLER_184_991 VDD VDD VSS VSS gf180mcu_as_sc_mcu7t3v3__fillcap_16
X_4562_ VDD VDD VSS VSS _4563_/B _4562_/B _4603_/A gf180mcu_as_sc_mcu7t3v3__nand2_2
XFILLER_190_438 VDD VDD VSS VSS gf180mcu_as_sc_mcu7t3v3__fillcap_4
X_6301_ VDD VDD VSS VSS clkload8/A _6301_/D _6301_/Q gf180mcu_as_sc_mcu7t3v3__dfxtp_2
X_4493_ VDD VDD VSS VSS _4493_/A _4512_/S _4499_/C _4493_/D _4494_/C gf180mcu_as_sc_mcu7t3v3__ao22_2
X_3513_ VDD VDD VSS VSS _4627_/A _4264_/A _5937_/A gf180mcu_as_sc_mcu7t3v3__nand2b_2
X_6232_ VDD VDD VSS VSS _6526_/CLK _6232_/D _6232_/Q gf180mcu_as_sc_mcu7t3v3__dfxtp_2
X_3444_ VDD VDD VSS VSS _6550_/D _3454_/B _6327_/Q _6326_/D gf180mcu_as_sc_mcu7t3v3__mux2_2
XFILLER_135_1210 VDD VDD VSS VSS gf180mcu_as_sc_mcu7t3v3__fillcap_4
X_6163_ VDD VDD VSS VSS _6316_/CLK _6163_/D _6163_/Q gf180mcu_as_sc_mcu7t3v3__dfxtp_2
X_3375_ VDD VDD VSS VSS _6529_/Q _6324_/Q _3438_/D gf180mcu_as_sc_mcu7t3v3__and2_2
XTAP_TAPCELL_ROW_209_2510 VDD VSS gf180mcu_as_sc_mcu7t3v3__tap_2
X_6094_ VDD VDD VSS VSS _6492_/CLK _6094_/D _6094_/Q gf180mcu_as_sc_mcu7t3v3__dfxtp_2
X_5114_ VDD VDD VSS VSS _5115_/D _5233_/C _5224_/B _5114_/A gf180mcu_as_sc_mcu7t3v3__aoi21_2
XFILLER_170_1189 VDD VDD VSS VSS gf180mcu_as_sc_mcu7t3v3__fillcap_16
X_5045_ VDD VDD VSS VSS _5046_/D _5717_/A _5138_/B _5132_/B gf180mcu_as_sc_mcu7t3v3__ao21_2
XTAP_TAPCELL_ROW_205_2429 VDD VSS gf180mcu_as_sc_mcu7t3v3__tap_2
XFILLER_214_85 VDD VDD VSS VSS gf180mcu_as_sc_mcu7t3v3__fillcap_16
XTAP_TAPCELL_ROW_222_2732 VDD VSS gf180mcu_as_sc_mcu7t3v3__tap_2
XFILLER_211_1186 VDD VDD VSS VSS gf180mcu_as_sc_mcu7t3v3__fillcap_4
XFILLER_226_664 VDD VDD VSS VSS gf180mcu_as_sc_mcu7t3v3__fill_1
XPHY_EDGE_ROW_68_3_Left_773 VDD VSS gf180mcu_as_sc_mcu7t3v3__tap_2
XTAP_TAPCELL_ROW_222_2743 VDD VSS gf180mcu_as_sc_mcu7t3v3__tap_2
XFILLER_0_1242 VDD VDD VSS VSS gf180mcu_as_sc_mcu7t3v3__fillcap_16
XFILLER_14_909 VDD VDD VSS VSS gf180mcu_as_sc_mcu7t3v3__fillcap_16
XFILLER_198_527 VDD VDD VSS VSS gf180mcu_as_sc_mcu7t3v3__fillcap_16
XFILLER_0_1264 VDD VDD VSS VSS gf180mcu_as_sc_mcu7t3v3__fill_1
XFILLER_43_27 VDD VDD VSS VSS gf180mcu_as_sc_mcu7t3v3__fillcap_16
X_5947_ VDD VDD VSS VSS _5947_/A _5947_/B _5947_/C _5947_/D _5948_/B gf180mcu_as_sc_mcu7t3v3__ao211_2
XFILLER_159_38 VDD VDD VSS VSS gf180mcu_as_sc_mcu7t3v3__fillcap_16
XTAP_TAPCELL_ROW_179_1963 VDD VSS gf180mcu_as_sc_mcu7t3v3__tap_2
XFILLER_139_638 VDD VDD VSS VSS gf180mcu_as_sc_mcu7t3v3__fillcap_8
XFILLER_166_402 VDD VDD VSS VSS gf180mcu_as_sc_mcu7t3v3__fill_2
XFILLER_166_424 VDD VDD VSS VSS gf180mcu_as_sc_mcu7t3v3__fill_2
XPHY_EDGE_ROW_127_2_Left_568 VDD VSS gf180mcu_as_sc_mcu7t3v3__tap_2
X_5878_ VDD VDD VSS VSS _5878_/S _5878_/B _6518_/Q _5879_/C gf180mcu_as_sc_mcu7t3v3__mux2_2
XFILLER_166_468 VDD VDD VSS VSS gf180mcu_as_sc_mcu7t3v3__fillcap_8
XFILLER_194_777 VDD VDD VSS VSS gf180mcu_as_sc_mcu7t3v3__fillcap_4
X_4829_ VDD VDD VSS VSS _5832_/A _4885_/B _4829_/C _4867_/D _4832_/C gf180mcu_as_sc_mcu7t3v3__ao211_2
XFILLER_147_660 VDD VDD VSS VSS gf180mcu_as_sc_mcu7t3v3__fill_2
XFILLER_179_1170 VDD VDD VSS VSS gf180mcu_as_sc_mcu7t3v3__fillcap_16
XFILLER_4_139 VDD VDD VSS VSS gf180mcu_as_sc_mcu7t3v3__fill_2
XPHY_EDGE_ROW_64_2_Left_505 VDD VSS gf180mcu_as_sc_mcu7t3v3__tap_2
XTAP_TAPCELL_ROW_29_2_2892 VDD VSS gf180mcu_as_sc_mcu7t3v3__tap_2
XFILLER_150_803 VDD VDD VSS VSS gf180mcu_as_sc_mcu7t3v3__fill_2
XFILLER_162_674 VDD VDD VSS VSS gf180mcu_as_sc_mcu7t3v3__fillcap_4
XFILLER_179_1192 VDD VDD VSS VSS gf180mcu_as_sc_mcu7t3v3__fillcap_16
XPHY_EDGE_ROW_90_3_Right_170 VDD VSS gf180mcu_as_sc_mcu7t3v3__tap_2
XFILLER_0_312 VDD VDD VSS VSS gf180mcu_as_sc_mcu7t3v3__fill_2
XFILLER_150_825 VDD VDD VSS VSS gf180mcu_as_sc_mcu7t3v3__fill_1
Xinput202 VDD VDD VSS VSS se_in[16] _5810_/A gf180mcu_as_sc_mcu7t3v3__buff_12
XFILLER_191_69 VDD VDD VSS VSS gf180mcu_as_sc_mcu7t3v3__fill_1
Xinput213 VDD VDD VSS VSS se_in[26] _5885_/A gf180mcu_as_sc_mcu7t3v3__buff_12
Xinput224 VDD VDD VSS VSS se_in[3] _5703_/A gf180mcu_as_sc_mcu7t3v3__buff_12
Xinput235 VDD VDD VSS VSS south_in[13] _5783_/A gf180mcu_as_sc_mcu7t3v3__buff_12
Xinput246 VDD VDD VSS VSS south_in[23] _5863_/A gf180mcu_as_sc_mcu7t3v3__buff_12
Xinput257 VDD VDD VSS VSS south_in[33] _5301_/A gf180mcu_as_sc_mcu7t3v3__buff_12
Xinput268 VDD VDD VSS VSS sw_in[10] _5763_/A gf180mcu_as_sc_mcu7t3v3__buff_12
Xinput279 VDD VDD VSS VSS sw_in[20] _5844_/A gf180mcu_as_sc_mcu7t3v3__buff_12
XFILLER_5_1186 VDD VDD VSS VSS gf180mcu_as_sc_mcu7t3v3__fillcap_4
XFILLER_204_314 VDD VDD VSS VSS gf180mcu_as_sc_mcu7t3v3__fill_1
XTAP_TAPCELL_ROW_2_1056 VDD VSS gf180mcu_as_sc_mcu7t3v3__tap_2
XTAP_TAPCELL_ROW_2_1045 VDD VSS gf180mcu_as_sc_mcu7t3v3__tap_2
XFILLER_182_1049 VDD VDD VSS VSS gf180mcu_as_sc_mcu7t3v3__fillcap_16
XPHY_EDGE_ROW_46_1_Right_618 VDD VSS gf180mcu_as_sc_mcu7t3v3__tap_2
XFILLER_158_947 VDD VDD VSS VSS gf180mcu_as_sc_mcu7t3v3__fillcap_8
XFILLER_213_892 VDD VDD VSS VSS gf180mcu_as_sc_mcu7t3v3__fillcap_8
XFILLER_223_1046 VDD VDD VSS VSS gf180mcu_as_sc_mcu7t3v3__fillcap_4
XFILLER_12_496 VDD VDD VSS VSS gf180mcu_as_sc_mcu7t3v3__fill_1
XFILLER_173_906 VDD VDD VSS VSS gf180mcu_as_sc_mcu7t3v3__fillcap_4
XFILLER_223_1068 VDD VDD VSS VSS gf180mcu_as_sc_mcu7t3v3__fillcap_16
XFILLER_172_416 VDD VDD VSS VSS gf180mcu_as_sc_mcu7t3v3__fillcap_4
XFILLER_200_597 VDD VDD VSS VSS gf180mcu_as_sc_mcu7t3v3__fillcap_16
XPHY_EDGE_ROW_29_2_Right_866 VDD VSS gf180mcu_as_sc_mcu7t3v3__tap_2
Xclkbuf_3_1_0_clk_regs VDD VDD VSS VSS clkbuf_0_clk_regs/Y clkbuf_3_1_0_clk_regs/Y
+ gf180mcu_as_sc_mcu7t3v3__clkbuff_12
XFILLER_158_1221 VDD VDD VSS VSS gf180mcu_as_sc_mcu7t3v3__fillcap_4
XFILLER_166_991 VDD VDD VSS VSS gf180mcu_as_sc_mcu7t3v3__fillcap_16
XFILLER_119_1238 VDD VDD VSS VSS gf180mcu_as_sc_mcu7t3v3__fill_2
XFILLER_153_696 VDD VDD VSS VSS gf180mcu_as_sc_mcu7t3v3__fillcap_4
X_3160_ VDD VDD VSS VSS _3161_/C _4224_/B _4570_/A _4570_/B gf180mcu_as_sc_mcu7t3v3__aoi21b_2
X_3091_ VDD VDD VSS VSS _3284_/B _3091_/A gf180mcu_as_sc_mcu7t3v3__inv_2
XFILLER_207_152 VDD VDD VSS VSS gf180mcu_as_sc_mcu7t3v3__fillcap_4
XFILLER_222_111 VDD VDD VSS VSS gf180mcu_as_sc_mcu7t3v3__fill_2
XPHY_EDGE_ROW_8_Right_8 VDD VSS gf180mcu_as_sc_mcu7t3v3__tap_2
X_5801_ VDD VDD VSS VSS _5801_/S _5801_/B _5801_/A _5803_/B gf180mcu_as_sc_mcu7t3v3__mux2_2
XTAP_TAPCELL_ROW_200_2348 VDD VSS gf180mcu_as_sc_mcu7t3v3__tap_2
XTAP_TAPCELL_ROW_200_2337 VDD VSS gf180mcu_as_sc_mcu7t3v3__tap_2
XFILLER_188_560 VDD VDD VSS VSS gf180mcu_as_sc_mcu7t3v3__fill_1
XFILLER_210_317 VDD VDD VSS VSS gf180mcu_as_sc_mcu7t3v3__fillcap_4
XFILLER_222_177 VDD VDD VSS VSS gf180mcu_as_sc_mcu7t3v3__fill_1
X_5732_ VDD VDD VSS VSS _5854_/S _5732_/B _6500_/Q _5733_/C gf180mcu_as_sc_mcu7t3v3__mux2_2
X_3993_ VDD VDD VSS VSS _4029_/D _4008_/B _4008_/C _6081_/Q _6081_/D gf180mcu_as_sc_mcu7t3v3__ao22_2
XTAP_TAPCELL_ROW_47_2_2919 VDD VSS gf180mcu_as_sc_mcu7t3v3__tap_2
XTAP_TAPCELL_ROW_196_2274 VDD VSS gf180mcu_as_sc_mcu7t3v3__tap_2
XTAP_TAPCELL_ROW_196_2263 VDD VSS gf180mcu_as_sc_mcu7t3v3__tap_2
XFILLER_176_733 VDD VDD VSS VSS gf180mcu_as_sc_mcu7t3v3__fill_2
Xsram2048.u_bank1_1037 VDD VDD VSS VSS sram2048.u_bank1/WEN[3] gf180mcu_as_sc_mcu7t3v3__tiel_4
XFILLER_202_1119 VDD VDD VSS VSS gf180mcu_as_sc_mcu7t3v3__fillcap_16
X_5663_ VDD VDD VSS VSS _5667_/C _5663_/A _5957_/B gf180mcu_as_sc_mcu7t3v3__and2_2
XFILLER_129_660 VDD VDD VSS VSS gf180mcu_as_sc_mcu7t3v3__fill_2
XTAP_TAPCELL_ROW_157_1568 VDD VSS gf180mcu_as_sc_mcu7t3v3__tap_2
XTAP_TAPCELL_ROW_174_1871 VDD VSS gf180mcu_as_sc_mcu7t3v3__tap_2
X_5594_ VDD VDD VSS VSS _5930_/A _5638_/B _5615_/C _5904_/D _5595_/C gf180mcu_as_sc_mcu7t3v3__ao22_2
X_4614_ VDD VDD VSS VSS _4982_/D _4979_/D _4930_/B gf180mcu_as_sc_mcu7t3v3__or2_2
XTAP_TAPCELL_ROW_174_1882 VDD VSS gf180mcu_as_sc_mcu7t3v3__tap_2
X_4545_ VDD VDD VSS VSS _6302_/Q _4552_/B _4551_/C _6301_/Q _4546_/C gf180mcu_as_sc_mcu7t3v3__ao22_2
XFILLER_144_641 VDD VDD VSS VSS gf180mcu_as_sc_mcu7t3v3__fill_1
XFILLER_145_29 VDD VDD VSS VSS gf180mcu_as_sc_mcu7t3v3__fillcap_16
X_4476_ VDD VDD VSS VSS _4476_/B _4477_/B _4478_/B gf180mcu_as_sc_mcu7t3v3__and2_2
XTAP_TAPCELL_ROW_74_3_2960 VDD VSS gf180mcu_as_sc_mcu7t3v3__tap_2
Xfanout903 VDD VDD VSS VSS _6265_/Q _4455_/A gf180mcu_as_sc_mcu7t3v3__buff_12
Xfanout914 VDD VDD VSS VSS _4307_/S _4342_/S gf180mcu_as_sc_mcu7t3v3__buff_12
Xfanout925 VDD VDD VSS VSS fanout935/A _5796_/A gf180mcu_as_sc_mcu7t3v3__buff_12
X_6215_ VDD VDD VSS VSS _6546_/CLK _6215_/D _6215_/Q gf180mcu_as_sc_mcu7t3v3__dfxtp_2
X_3427_ VDD VDD VSS VSS _3427_/B _4579_/D _3428_/C gf180mcu_as_sc_mcu7t3v3__and2_2
XFILLER_38_27 VDD VDD VSS VSS gf180mcu_as_sc_mcu7t3v3__fillcap_8
X_6146_ VDD VDD VSS VSS clkload8/A _6146_/D _6146_/Q gf180mcu_as_sc_mcu7t3v3__dfxtp_2
X_3358_ VDD VDD VSS VSS _3358_/B _3358_/A _3362_/A gf180mcu_as_sc_mcu7t3v3__or2_2
XFILLER_22_1210 VDD VDD VSS VSS gf180mcu_as_sc_mcu7t3v3__fillcap_16
XFILLER_38_49 VDD VDD VSS VSS gf180mcu_as_sc_mcu7t3v3__fill_2
XTAP_TAPCELL_ROW_16_1299 VDD VSS gf180mcu_as_sc_mcu7t3v3__tap_2
X_6077_ VDD VDD VSS VSS _6486_/CLK _6077_/D _6077_/Q gf180mcu_as_sc_mcu7t3v3__dfxtp_2
X_3289_ VDD VDD VSS VSS _3290_/C _3294_/B _3289_/B _3291_/B gf180mcu_as_sc_mcu7t3v3__ao21_2
XFILLER_227_962 VDD VDD VSS VSS gf180mcu_as_sc_mcu7t3v3__fillcap_16
Xhold1189 VDD VDD VSS VSS _6013_/S _3200_/B gf180mcu_as_sc_mcu7t3v3__clkbuff_4
X_5028_ VDD VDD VSS VSS _5701_/A _5139_/C _5028_/C _5138_/B _5030_/C gf180mcu_as_sc_mcu7t3v3__ao211_2
XFILLER_54_37 VDD VDD VSS VSS gf180mcu_as_sc_mcu7t3v3__fillcap_8
XFILLER_14_717 VDD VDD VSS VSS gf180mcu_as_sc_mcu7t3v3__fill_1
XFILLER_159_6 VDD VDD VSS VSS gf180mcu_as_sc_mcu7t3v3__fillcap_16
XFILLER_199_858 VDD VDD VSS VSS gf180mcu_as_sc_mcu7t3v3__fill_2
XFILLER_202_807 VDD VDD VSS VSS gf180mcu_as_sc_mcu7t3v3__fill_1
XFILLER_0_1083 VDD VDD VSS VSS gf180mcu_as_sc_mcu7t3v3__fill_1
XFILLER_198_379 VDD VDD VSS VSS gf180mcu_as_sc_mcu7t3v3__fillcap_4
XFILLER_9_209 VDD VDD VSS VSS gf180mcu_as_sc_mcu7t3v3__fill_1
XFILLER_154_427 VDD VDD VSS VSS gf180mcu_as_sc_mcu7t3v3__fillcap_8
XFILLER_5_426 VDD VDD VSS VSS gf180mcu_as_sc_mcu7t3v3__fill_2
XFILLER_163_972 VDD VDD VSS VSS gf180mcu_as_sc_mcu7t3v3__fillcap_8
XFILLER_181_279 VDD VDD VSS VSS gf180mcu_as_sc_mcu7t3v3__fill_1
XFILLER_79_45 VDD VDD VSS VSS gf180mcu_as_sc_mcu7t3v3__fillcap_4
XFILLER_1_632 VDD VDD VSS VSS gf180mcu_as_sc_mcu7t3v3__fill_2
XPHY_EDGE_ROW_91_3_Right_171 VDD VSS gf180mcu_as_sc_mcu7t3v3__tap_2
XFILLER_0_142 VDD VDD VSS VSS gf180mcu_as_sc_mcu7t3v3__fill_2
XFILLER_151_72 VDD VDD VSS VSS gf180mcu_as_sc_mcu7t3v3__fillcap_16
XFILLER_218_995 VDD VDD VSS VSS gf180mcu_as_sc_mcu7t3v3__fillcap_16
XFILLER_205_656 VDD VDD VSS VSS gf180mcu_as_sc_mcu7t3v3__fill_1
XFILLER_13_750 VDD VDD VSS VSS gf180mcu_as_sc_mcu7t3v3__fill_1
XFILLER_158_733 VDD VDD VSS VSS gf180mcu_as_sc_mcu7t3v3__fill_2
XFILLER_38_1261 VDD VDD VSS VSS gf180mcu_as_sc_mcu7t3v3__fillcap_4
XPHY_EDGE_ROW_47_1_Right_619 VDD VSS gf180mcu_as_sc_mcu7t3v3__tap_2
XFILLER_13_772 VDD VDD VSS VSS gf180mcu_as_sc_mcu7t3v3__fill_2
XFILLER_157_276 VDD VDD VSS VSS gf180mcu_as_sc_mcu7t3v3__fillcap_4
XFILLER_173_714 VDD VDD VSS VSS gf180mcu_as_sc_mcu7t3v3__fill_2
XFILLER_201_884 VDD VDD VSS VSS gf180mcu_as_sc_mcu7t3v3__fill_2
XFILLER_74_6 VDD VDD VSS VSS gf180mcu_as_sc_mcu7t3v3__fill_2
XTAP_TAPCELL_ROW_191_2171 VDD VSS gf180mcu_as_sc_mcu7t3v3__tap_2
XFILLER_157_298 VDD VDD VSS VSS gf180mcu_as_sc_mcu7t3v3__fillcap_16
XTAP_TAPCELL_ROW_191_2182 VDD VSS gf180mcu_as_sc_mcu7t3v3__tap_2
XFILLER_126_641 VDD VDD VSS VSS gf180mcu_as_sc_mcu7t3v3__fill_1
XFILLER_5_960 VDD VDD VSS VSS gf180mcu_as_sc_mcu7t3v3__fillcap_16
XFILLER_5_982 VDD VDD VSS VSS gf180mcu_as_sc_mcu7t3v3__fillcap_16
XTAP_TAPCELL_ROW_152_1476 VDD VSS gf180mcu_as_sc_mcu7t3v3__tap_2
X_4330_ VDD VDD VSS VSS _4332_/A _4330_/C _4337_/B _6150_/Q gf180mcu_as_sc_mcu7t3v3__aoi21_2
XFILLER_141_633 VDD VDD VSS VSS gf180mcu_as_sc_mcu7t3v3__fillcap_4
XFILLER_141_666 VDD VDD VSS VSS gf180mcu_as_sc_mcu7t3v3__fill_1
XFILLER_45_1210 VDD VDD VSS VSS gf180mcu_as_sc_mcu7t3v3__fillcap_8
X_4261_ VDD VDD VSS VSS _4335_/S _6048_/Q _6077_/Q _4262_/B gf180mcu_as_sc_mcu7t3v3__mux2_2
XFILLER_171_1240 VDD VDD VSS VSS gf180mcu_as_sc_mcu7t3v3__fillcap_16
XFILLER_45_1243 VDD VDD VSS VSS gf180mcu_as_sc_mcu7t3v3__fillcap_16
X_6000_ VDD VDD VSS VSS _6010_/B _6223_/Q _6513_/D gf180mcu_as_sc_mcu7t3v3__and2_2
X_3212_ VDD VDD VSS VSS _3241_/S _3216_/D _3212_/B _3212_/A gf180mcu_as_sc_mcu7t3v3__aoi21b_2
XFILLER_171_1262 VDD VDD VSS VSS gf180mcu_as_sc_mcu7t3v3__fill_2
X_4192_ VDD VDD VSS VSS _4404_/D _4192_/B _4192_/A _4194_/B gf180mcu_as_sc_mcu7t3v3__mux2_2
X_3143_ VDD VDD VSS VSS _3390_/A _3434_/A _4456_/A gf180mcu_as_sc_mcu7t3v3__nor2_2
XFILLER_208_450 VDD VDD VSS VSS gf180mcu_as_sc_mcu7t3v3__fillcap_4
X_3074_ VDD VDD VSS VSS _4774_/D _5783_/A gf180mcu_as_sc_mcu7t3v3__inv_2
XTAP_TAPCELL_ROW_198_2314 VDD VSS gf180mcu_as_sc_mcu7t3v3__tap_2
XTAP_TAPCELL_ROW_198_2303 VDD VSS gf180mcu_as_sc_mcu7t3v3__tap_2
XFILLER_224_943 VDD VDD VSS VSS gf180mcu_as_sc_mcu7t3v3__fill_2
XFILLER_211_626 VDD VDD VSS VSS gf180mcu_as_sc_mcu7t3v3__fillcap_4
XTAP_TAPCELL_ROW_159_1608 VDD VSS gf180mcu_as_sc_mcu7t3v3__tap_2
XTAP_TAPCELL_ROW_176_1911 VDD VSS gf180mcu_as_sc_mcu7t3v3__tap_2
X_3976_ VDD VDD VSS VSS _3980_/B _6070_/Q _3977_/D gf180mcu_as_sc_mcu7t3v3__and2_2
X_5715_ VDD VDD VSS VSS _5797_/B _5715_/A _5718_/C gf180mcu_as_sc_mcu7t3v3__and2_2
XFILLER_149_777 VDD VDD VSS VSS gf180mcu_as_sc_mcu7t3v3__fillcap_4
X_5646_ VDD VDD VSS VSS _5646_/Y _5646_/B _5646_/A gf180mcu_as_sc_mcu7t3v3__nand2_2
XTAP_TAPCELL_ROW_217_2653 VDD VSS gf180mcu_as_sc_mcu7t3v3__tap_2
XTAP_TAPCELL_ROW_217_2642 VDD VSS gf180mcu_as_sc_mcu7t3v3__tap_2
XFILLER_163_235 VDD VDD VSS VSS gf180mcu_as_sc_mcu7t3v3__fillcap_16
XFILLER_164_769 VDD VDD VSS VSS gf180mcu_as_sc_mcu7t3v3__fill_2
XFILLER_3_908 VDD VDD VSS VSS gf180mcu_as_sc_mcu7t3v3__fill_2
X_5577_ VDD VDD VSS VSS _5883_/A _5628_/D _5577_/C _5577_/D _5578_/B gf180mcu_as_sc_mcu7t3v3__ao211_2
XFILLER_132_600 VDD VDD VSS VSS gf180mcu_as_sc_mcu7t3v3__fill_1
XFILLER_151_419 VDD VDD VSS VSS gf180mcu_as_sc_mcu7t3v3__fill_1
XFILLER_163_279 VDD VDD VSS VSS gf180mcu_as_sc_mcu7t3v3__fill_1
XFILLER_176_1151 VDD VDD VSS VSS gf180mcu_as_sc_mcu7t3v3__fillcap_4
X_4528_ VDD VDD VSS VSS _4610_/C _4539_/A _4579_/A _4528_/C _4537_/S gf180mcu_as_sc_mcu7t3v3__ao31_2
XFILLER_176_1173 VDD VDD VSS VSS gf180mcu_as_sc_mcu7t3v3__fillcap_16
Xfanout700 VDD VDD VSS VSS _4359_/B _4336_/B gf180mcu_as_sc_mcu7t3v3__buff_12
X_4459_ VDD VDD VSS VSS _4520_/S _6144_/Q _6269_/Q _6269_/D gf180mcu_as_sc_mcu7t3v3__mux2_2
XFILLER_217_1170 VDD VDD VSS VSS gf180mcu_as_sc_mcu7t3v3__fillcap_16
Xfanout711 VDD VDD VSS VSS _4140_/S _4143_/S gf180mcu_as_sc_mcu7t3v3__buff_12
Xfanout722 VDD VDD VSS VSS _5855_/D _5879_/D gf180mcu_as_sc_mcu7t3v3__buff_12
Xfanout733 VDD VDD VSS VSS _5615_/C _5572_/B gf180mcu_as_sc_mcu7t3v3__buff_12
XFILLER_217_1192 VDD VDD VSS VSS gf180mcu_as_sc_mcu7t3v3__fillcap_16
Xfanout744 VDD VDD VSS VSS _3757_/B _3925_/C gf180mcu_as_sc_mcu7t3v3__buff_12
Xfanout755 VDD VDD VSS VSS _5854_/S _5878_/S gf180mcu_as_sc_mcu7t3v3__buff_12
Xfanout766 VDD VDD VSS VSS _5203_/C _5222_/C gf180mcu_as_sc_mcu7t3v3__buff_12
XFILLER_105_43 VDD VDD VSS VSS gf180mcu_as_sc_mcu7t3v3__fillcap_8
Xfanout777 VDD VDD VSS VSS _5124_/B _5142_/B gf180mcu_as_sc_mcu7t3v3__buff_12
Xfanout788 VDD VDD VSS VSS _4960_/B _4953_/B gf180mcu_as_sc_mcu7t3v3__buff_12
Xfanout799 VDD VDD VSS VSS _4410_/Y _4428_/B gf180mcu_as_sc_mcu7t3v3__buff_12
X_6129_ VDD VDD VSS VSS _6486_/CLK _6129_/D _6129_/Q gf180mcu_as_sc_mcu7t3v3__dfxtp_2
XFILLER_183_1100 VDD VDD VSS VSS gf180mcu_as_sc_mcu7t3v3__fillcap_16
XFILLER_183_1122 VDD VDD VSS VSS gf180mcu_as_sc_mcu7t3v3__fillcap_16
XFILLER_2_1189 VDD VDD VSS VSS gf180mcu_as_sc_mcu7t3v3__fillcap_16
XFILLER_202_626 VDD VDD VSS VSS gf180mcu_as_sc_mcu7t3v3__fill_2
XFILLER_215_998 VDD VDD VSS VSS gf180mcu_as_sc_mcu7t3v3__fillcap_16
XFILLER_187_839 VDD VDD VSS VSS gf180mcu_as_sc_mcu7t3v3__fill_1
XFILLER_199_699 VDD VDD VSS VSS gf180mcu_as_sc_mcu7t3v3__fill_1
XFILLER_201_136 VDD VDD VSS VSS gf180mcu_as_sc_mcu7t3v3__fillcap_4
XTAP_TAPCELL_ROW_17_2_2874 VDD VSS gf180mcu_as_sc_mcu7t3v3__tap_2
XFILLER_167_530 VDD VDD VSS VSS gf180mcu_as_sc_mcu7t3v3__fill_2
XFILLER_201_158 VDD VDD VSS VSS gf180mcu_as_sc_mcu7t3v3__fillcap_4
XFILLER_182_522 VDD VDD VSS VSS gf180mcu_as_sc_mcu7t3v3__fill_2
XFILLER_220_1049 VDD VDD VSS VSS gf180mcu_as_sc_mcu7t3v3__fillcap_16
XFILLER_5_212 VDD VDD VSS VSS gf180mcu_as_sc_mcu7t3v3__fillcap_16
XFILLER_108_641 VDD VDD VSS VSS gf180mcu_as_sc_mcu7t3v3__fillcap_16
XFILLER_155_769 VDD VDD VSS VSS gf180mcu_as_sc_mcu7t3v3__fill_1
XFILLER_154_279 VDD VDD VSS VSS gf180mcu_as_sc_mcu7t3v3__fillcap_16
XFILLER_170_728 VDD VDD VSS VSS gf180mcu_as_sc_mcu7t3v3__fillcap_4
XPHY_EDGE_ROW_20_3_Left_725 VDD VSS gf180mcu_as_sc_mcu7t3v3__tap_2
XFILLER_155_1224 VDD VDD VSS VSS gf180mcu_as_sc_mcu7t3v3__fill_2
XFILLER_123_666 VDD VDD VSS VSS gf180mcu_as_sc_mcu7t3v3__fill_1
XFILLER_2_963 VDD VDD VSS VSS gf180mcu_as_sc_mcu7t3v3__fillcap_16
XPHY_EDGE_ROW_145_3_Left_850 VDD VSS gf180mcu_as_sc_mcu7t3v3__tap_2
XPHY_EDGE_ROW_92_3_Right_172 VDD VSS gf180mcu_as_sc_mcu7t3v3__tap_2
Xmesh_tile_1110 VDD VDD VSS VSS nw_out[33] gf180mcu_as_sc_mcu7t3v3__tiel_4
XFILLER_188_1033 VDD VDD VSS VSS gf180mcu_as_sc_mcu7t3v3__fillcap_16
XFILLER_209_258 VDD VDD VSS VSS gf180mcu_as_sc_mcu7t3v3__fill_1
XFILLER_225_707 VDD VDD VSS VSS gf180mcu_as_sc_mcu7t3v3__fill_2
Xmesh_tile_1143 VDD VDD VSS VSS se_out[30] gf180mcu_as_sc_mcu7t3v3__tiel_4
Xmesh_tile_1132 VDD VDD VSS VSS se_out[19] gf180mcu_as_sc_mcu7t3v3__tiel_4
Xmesh_tile_1121 VDD VDD VSS VSS se_out[8] gf180mcu_as_sc_mcu7t3v3__tiel_4
Xmesh_tile_1176 VDD VDD VSS VSS sw_out[27] gf180mcu_as_sc_mcu7t3v3__tiel_4
Xmesh_tile_1165 VDD VDD VSS VSS sw_out[16] gf180mcu_as_sc_mcu7t3v3__tiel_4
Xmesh_tile_1154 VDD VDD VSS VSS sw_out[5] gf180mcu_as_sc_mcu7t3v3__tiel_4
XFILLER_189_187 VDD VDD VSS VSS gf180mcu_as_sc_mcu7t3v3__fill_2
X_3830_ VDD VDD VSS VSS _6033_/Q _3830_/B _4043_/B _3830_/D _6033_/D gf180mcu_as_sc_mcu7t3v3__ao22_2
XTAP_TAPCELL_ROW_193_2222 VDD VSS gf180mcu_as_sc_mcu7t3v3__tap_2
XTAP_TAPCELL_ROW_193_2211 VDD VSS gf180mcu_as_sc_mcu7t3v3__tap_2
XFILLER_221_979 VDD VDD VSS VSS gf180mcu_as_sc_mcu7t3v3__fill_1
X_3761_ VDD VDD VSS VSS _5761_/A _3867_/B _3761_/C _3761_/D _3762_/C gf180mcu_as_sc_mcu7t3v3__ao211_2
XTAP_TAPCELL_ROW_154_1505 VDD VSS gf180mcu_as_sc_mcu7t3v3__tap_2
X_5500_ VDD VDD VSS VSS _5501_/A _5806_/B _5572_/B _5500_/C gf180mcu_as_sc_mcu7t3v3__ao21_2
XFILLER_185_371 VDD VDD VSS VSS gf180mcu_as_sc_mcu7t3v3__fill_1
XTAP_TAPCELL_ROW_154_1516 VDD VSS gf180mcu_as_sc_mcu7t3v3__tap_2
X_6480_ VDD VDD VSS VSS _6484_/CLK _6480_/D _6480_/Q gf180mcu_as_sc_mcu7t3v3__dfxtp_2
X_3692_ VDD VDD VSS VSS _3807_/S _5697_/A _3692_/A _3693_/C gf180mcu_as_sc_mcu7t3v3__mux2_2
X_5431_ VDD VDD VSS VSS _5631_/B _6501_/Q _5433_/C gf180mcu_as_sc_mcu7t3v3__and2_2
X_5362_ VDD VDD VSS VSS _5362_/B _5362_/A _5533_/B gf180mcu_as_sc_mcu7t3v3__and2_2
XTAP_TAPCELL_ROW_212_2561 VDD VSS gf180mcu_as_sc_mcu7t3v3__tap_2
XTAP_TAPCELL_ROW_212_2550 VDD VSS gf180mcu_as_sc_mcu7t3v3__tap_2
XFILLER_114_633 VDD VDD VSS VSS gf180mcu_as_sc_mcu7t3v3__fill_1
XFILLER_154_791 VDD VDD VSS VSS gf180mcu_as_sc_mcu7t3v3__fill_2
XPHY_EDGE_ROW_77_3_Left_782 VDD VSS gf180mcu_as_sc_mcu7t3v3__tap_2
Xoutput369 VDD VDD VSS VSS _6415_/Q east_out[2] gf180mcu_as_sc_mcu7t3v3__buff_12
Xoutput358 VDD VDD VSS VSS _6414_/Q east_out[1] gf180mcu_as_sc_mcu7t3v3__buff_12
Xoutput347 VDD VDD VSS VSS _6413_/Q east_out[0] gf180mcu_as_sc_mcu7t3v3__buff_12
X_4313_ VDD VDD VSS VSS _4363_/S _6113_/Q _4313_/C _4362_/D _4317_/C gf180mcu_as_sc_mcu7t3v3__ao211_2
X_5293_ VDD VDD VSS VSS _5293_/B _5293_/A _5294_/C gf180mcu_as_sc_mcu7t3v3__and2_2
XFILLER_206_53 VDD VDD VSS VSS gf180mcu_as_sc_mcu7t3v3__fillcap_16
X_4244_ VDD VDD VSS VSS _4362_/A _6104_/Q _6017_/Q _4246_/A gf180mcu_as_sc_mcu7t3v3__mux2_2
XFILLER_228_512 VDD VDD VSS VSS gf180mcu_as_sc_mcu7t3v3__fillcap_4
XPHY_EDGE_ROW_136_2_Left_577 VDD VSS gf180mcu_as_sc_mcu7t3v3__tap_2
XTAP_TAPCELL_ROW_169_1781 VDD VSS gf180mcu_as_sc_mcu7t3v3__tap_2
XTAP_TAPCELL_ROW_169_1792 VDD VSS gf180mcu_as_sc_mcu7t3v3__tap_2
X_4175_ VDD VDD VSS VSS _6176_/Q _6175_/Q _4175_/C _4176_/B gf180mcu_as_sc_mcu7t3v3__nor3_2
XTAP_TAPCELL_ROW_13_1247 VDD VSS gf180mcu_as_sc_mcu7t3v3__tap_2
X_3126_ VDD VDD VSS VSS _6307_/Q _6308_/Q _6309_/Q _4574_/B gf180mcu_as_sc_mcu7t3v3__nand3_2
XFILLER_36_661 VDD VDD VSS VSS gf180mcu_as_sc_mcu7t3v3__fillcap_4
XPHY_EDGE_ROW_73_2_Left_514 VDD VSS gf180mcu_as_sc_mcu7t3v3__tap_2
X_3057_ VDD VDD VSS VSS _5978_/D _6166_/Q gf180mcu_as_sc_mcu7t3v3__inv_2
XFILLER_208_1103 VDD VDD VSS VSS gf180mcu_as_sc_mcu7t3v3__fillcap_16
XFILLER_195_102 VDD VDD VSS VSS gf180mcu_as_sc_mcu7t3v3__fill_1
XFILLER_212_935 VDD VDD VSS VSS gf180mcu_as_sc_mcu7t3v3__fillcap_8
XFILLER_51_664 VDD VDD VSS VSS gf180mcu_as_sc_mcu7t3v3__fill_2
XFILLER_11_528 VDD VDD VSS VSS gf180mcu_as_sc_mcu7t3v3__fill_1
XFILLER_211_467 VDD VDD VSS VSS gf180mcu_as_sc_mcu7t3v3__fillcap_16
XFILLER_212_979 VDD VDD VSS VSS gf180mcu_as_sc_mcu7t3v3__fillcap_16
XFILLER_211_489 VDD VDD VSS VSS gf180mcu_as_sc_mcu7t3v3__fill_1
X_3959_ VDD VDD VSS VSS _3963_/B _6061_/Q _3960_/D gf180mcu_as_sc_mcu7t3v3__and2_2
XTAP_TAPCELL_ROW_62_3_2942 VDD VSS gf180mcu_as_sc_mcu7t3v3__tap_2
XFILLER_164_522 VDD VDD VSS VSS gf180mcu_as_sc_mcu7t3v3__fill_2
XFILLER_164_533 VDD VDD VSS VSS gf180mcu_as_sc_mcu7t3v3__fill_1
XFILLER_164_544 VDD VDD VSS VSS gf180mcu_as_sc_mcu7t3v3__fill_1
XFILLER_164_555 VDD VDD VSS VSS gf180mcu_as_sc_mcu7t3v3__fillcap_16
X_5629_ VDD VDD VSS VSS _5629_/A _5642_/S _5629_/C _6445_/D _5909_/D gf180mcu_as_sc_mcu7t3v3__aoi211_2
XFILLER_105_666 VDD VDD VSS VSS gf180mcu_as_sc_mcu7t3v3__fill_1
Xfanout530 VDD VDD VSS VSS fanout531/Y _3933_/B gf180mcu_as_sc_mcu7t3v3__buff_12
Xfanout541 VDD VDD VSS VSS _5584_/B _5568_/B gf180mcu_as_sc_mcu7t3v3__buff_12
Xfanout552 VDD VDD VSS VSS _5307_/B _5306_/D gf180mcu_as_sc_mcu7t3v3__buff_12
Xfanout563 VDD VDD VSS VSS _4015_/Y _4061_/C gf180mcu_as_sc_mcu7t3v3__buff_12
XFILLER_86_594 VDD VDD VSS VSS gf180mcu_as_sc_mcu7t3v3__fillcap_8
Xfanout585 VDD VDD VSS VSS _5668_/Y _5841_/B gf180mcu_as_sc_mcu7t3v3__buff_12
Xfanout596 VDD VDD VSS VSS _5358_/Y _5641_/B gf180mcu_as_sc_mcu7t3v3__buff_12
XFILLER_219_589 VDD VDD VSS VSS gf180mcu_as_sc_mcu7t3v3__fillcap_8
XFILLER_92_45 VDD VDD VSS VSS gf180mcu_as_sc_mcu7t3v3__fillcap_4
XFILLER_14_311 VDD VDD VSS VSS gf180mcu_as_sc_mcu7t3v3__fillcap_4
XFILLER_14_333 VDD VDD VSS VSS gf180mcu_as_sc_mcu7t3v3__fillcap_4
XFILLER_214_272 VDD VDD VSS VSS gf180mcu_as_sc_mcu7t3v3__fillcap_4
XFILLER_14_399 VDD VDD VSS VSS gf180mcu_as_sc_mcu7t3v3__fillcap_8
XFILLER_187_647 VDD VDD VSS VSS gf180mcu_as_sc_mcu7t3v3__fill_2
XFILLER_174_319 VDD VDD VSS VSS gf180mcu_as_sc_mcu7t3v3__fill_1
XFILLER_122_1245 VDD VDD VSS VSS gf180mcu_as_sc_mcu7t3v3__fillcap_16
Xwire942 VDD VDD VSS VSS wire942/A wire942/Y gf180mcu_as_sc_mcu7t3v3__clkbuff_12
Xwire953 VDD VDD VSS VSS wire953/A _5845_/A gf180mcu_as_sc_mcu7t3v3__clkbuff_12
Xwire986 VDD VDD VSS VSS wire986/A _5875_/A gf180mcu_as_sc_mcu7t3v3__clkbuff_12
Xwire997 VDD VDD VSS VSS wire997/A _5913_/A gf180mcu_as_sc_mcu7t3v3__clkbuff_12
XFILLER_151_761 VDD VDD VSS VSS gf180mcu_as_sc_mcu7t3v3__fillcap_8
XFILLER_194_1081 VDD VDD VSS VSS gf180mcu_as_sc_mcu7t3v3__fillcap_4
XPHY_EDGE_ROW_191_Right_59 VDD VSS gf180mcu_as_sc_mcu7t3v3__tap_2
XPHY_EDGE_ROW_121_1_Left_349 VDD VSS gf180mcu_as_sc_mcu7t3v3__tap_2
XPHY_EDGE_ROW_93_3_Right_173 VDD VSS gf180mcu_as_sc_mcu7t3v3__tap_2
XTAP_TAPCELL_ROW_186_2092 VDD VSS gf180mcu_as_sc_mcu7t3v3__tap_2
XTAP_TAPCELL_ROW_186_2081 VDD VSS gf180mcu_as_sc_mcu7t3v3__tap_2
X_5980_ VDD VDD VSS VSS _6011_/B _6203_/Q _6493_/D gf180mcu_as_sc_mcu7t3v3__and2_2
X_4931_ VDD VDD VSS VSS _5922_/A _4959_/B _4953_/C _5921_/D _4932_/C gf180mcu_as_sc_mcu7t3v3__ao22_2
XFILLER_162_1014 VDD VDD VSS VSS gf180mcu_as_sc_mcu7t3v3__fill_1
XFILLER_33_664 VDD VDD VSS VSS gf180mcu_as_sc_mcu7t3v3__fill_2
X_4862_ VDD VDD VSS VSS _5857_/A _4862_/B _4862_/C _4862_/D _4863_/C gf180mcu_as_sc_mcu7t3v3__ao211_2
XFILLER_177_124 VDD VDD VSS VSS gf180mcu_as_sc_mcu7t3v3__fillcap_16
X_3813_ VDD VDD VSS VSS _6509_/Q _3925_/B _3887_/B _5810_/D _3815_/C gf180mcu_as_sc_mcu7t3v3__ao22_2
XANTENNA_15 VDD VDD VSS VSS _4798_/B gf180mcu_as_sc_mcu7t3v3__diode_2
XANTENNA_26 VDD VDD VSS VSS _5172_/A gf180mcu_as_sc_mcu7t3v3__diode_2
XANTENNA_37 VDD VDD VSS VSS _4930_/B gf180mcu_as_sc_mcu7t3v3__diode_2
XANTENNA_48 VDD VDD VSS VSS _5247_/A gf180mcu_as_sc_mcu7t3v3__diode_2
X_4793_ VDD VDD VSS VSS _5798_/B _4840_/B _4793_/C _4793_/D _4794_/B gf180mcu_as_sc_mcu7t3v3__ao22_2
X_6532_ VDD VDD VSS VSS clkload9/A _6532_/D _6532_/Q gf180mcu_as_sc_mcu7t3v3__dfxtp_2
X_3744_ VDD VDD VSS VSS _6024_/Q _3830_/B _4030_/B _3895_/D _6024_/D gf180mcu_as_sc_mcu7t3v3__ao22_2
XTAP_TAPCELL_ROW_214_2601 VDD VSS gf180mcu_as_sc_mcu7t3v3__tap_2
X_6463_ VDD VDD VSS VSS clkload4/A _6463_/D _6463_/Q gf180mcu_as_sc_mcu7t3v3__dfxtp_2
X_3675_ VDD VDD VSS VSS _5686_/A _3809_/B _3675_/C _3675_/D _3676_/C gf180mcu_as_sc_mcu7t3v3__ao211_2
XFILLER_173_352 VDD VDD VSS VSS gf180mcu_as_sc_mcu7t3v3__fillcap_8
X_5414_ VDD VDD VSS VSS _5422_/A _5568_/B _5730_/A gf180mcu_as_sc_mcu7t3v3__nand2_2
X_6394_ VDD VDD VSS VSS clkload3/A _6394_/D _6394_/Q gf180mcu_as_sc_mcu7t3v3__dfxtp_2
X_5345_ VDD VDD VSS VSS _5656_/B _5345_/A _5345_/B _5345_/C gf180mcu_as_sc_mcu7t3v3__ao21_2
XFILLER_173_1154 VDD VDD VSS VSS gf180mcu_as_sc_mcu7t3v3__fillcap_16
X_5276_ VDD VDD VSS VSS _5924_/A _5304_/B _5296_/C _5923_/A _5281_/C gf180mcu_as_sc_mcu7t3v3__ao22_2
XFILLER_214_1151 VDD VDD VSS VSS gf180mcu_as_sc_mcu7t3v3__fillcap_4
X_4227_ VDD VDD VSS VSS _4231_/S _4227_/B _6200_/Q _6200_/D gf180mcu_as_sc_mcu7t3v3__mux2_2
XFILLER_214_1173 VDD VDD VSS VSS gf180mcu_as_sc_mcu7t3v3__fillcap_16
XFILLER_228_342 VDD VDD VSS VSS gf180mcu_as_sc_mcu7t3v3__fill_1
XFILLER_46_49 VDD VDD VSS VSS gf180mcu_as_sc_mcu7t3v3__fill_2
X_4158_ VDD VDD VSS VSS _4158_/B _4280_/D _6012_/C gf180mcu_as_sc_mcu7t3v3__or2_2
XTAP_TAPCELL_ROW_225_2785 VDD VSS gf180mcu_as_sc_mcu7t3v3__tap_2
XFILLER_3_1240 VDD VDD VSS VSS gf180mcu_as_sc_mcu7t3v3__fillcap_16
XFILLER_3_1262 VDD VDD VSS VSS gf180mcu_as_sc_mcu7t3v3__fill_2
X_4089_ VDD VDD VSS VSS _4089_/S _6718_/A _6149_/Q _6149_/D gf180mcu_as_sc_mcu7t3v3__mux2_2
X_3109_ VDD VDD VSS VSS _4468_/A _4224_/A _6307_/Q gf180mcu_as_sc_mcu7t3v3__nor2_2
XTAP_TAPCELL_ROW_225_2796 VDD VSS gf180mcu_as_sc_mcu7t3v3__tap_2
XFILLER_197_901 VDD VDD VSS VSS gf180mcu_as_sc_mcu7t3v3__fillcap_8
XFILLER_58_1242 VDD VDD VSS VSS gf180mcu_as_sc_mcu7t3v3__fill_1
XFILLER_12_804 VDD VDD VSS VSS gf180mcu_as_sc_mcu7t3v3__fill_1
XFILLER_180_1103 VDD VDD VSS VSS gf180mcu_as_sc_mcu7t3v3__fillcap_16
XFILLER_197_912 VDD VDD VSS VSS gf180mcu_as_sc_mcu7t3v3__fillcap_16
XFILLER_212_732 VDD VDD VSS VSS gf180mcu_as_sc_mcu7t3v3__fill_2
XFILLER_62_37 VDD VDD VSS VSS gf180mcu_as_sc_mcu7t3v3__fillcap_8
XFILLER_11_314 VDD VDD VSS VSS gf180mcu_as_sc_mcu7t3v3__fillcap_16
XFILLER_141_6 VDD VDD VSS VSS gf180mcu_as_sc_mcu7t3v3__fillcap_16
XFILLER_178_37 VDD VDD VSS VSS gf180mcu_as_sc_mcu7t3v3__fillcap_8
XFILLER_169_669 VDD VDD VSS VSS gf180mcu_as_sc_mcu7t3v3__fill_2
XFILLER_184_617 VDD VDD VSS VSS gf180mcu_as_sc_mcu7t3v3__fill_2
XFILLER_221_1100 VDD VDD VSS VSS gf180mcu_as_sc_mcu7t3v3__fillcap_16
XFILLER_221_1122 VDD VDD VSS VSS gf180mcu_as_sc_mcu7t3v3__fillcap_16
XFILLER_165_831 VDD VDD VSS VSS gf180mcu_as_sc_mcu7t3v3__fill_2
XFILLER_165_842 VDD VDD VSS VSS gf180mcu_as_sc_mcu7t3v3__fillcap_4
XFILLER_178_1065 VDD VDD VSS VSS gf180mcu_as_sc_mcu7t3v3__fillcap_16
XFILLER_11_52 VDD VDD VSS VSS gf180mcu_as_sc_mcu7t3v3__fillcap_16
XFILLER_178_1087 VDD VDD VSS VSS gf180mcu_as_sc_mcu7t3v3__fillcap_16
XFILLER_191_182 VDD VDD VSS VSS gf180mcu_as_sc_mcu7t3v3__fill_2
XFILLER_194_69 VDD VDD VSS VSS gf180mcu_as_sc_mcu7t3v3__fillcap_16
XFILLER_191_1232 VDD VDD VSS VSS gf180mcu_as_sc_mcu7t3v3__fill_2
XFILLER_152_1205 VDD VDD VSS VSS gf180mcu_as_sc_mcu7t3v3__fillcap_16
XFILLER_152_1227 VDD VDD VSS VSS gf180mcu_as_sc_mcu7t3v3__fillcap_16
XFILLER_219_1084 VDD VDD VSS VSS gf180mcu_as_sc_mcu7t3v3__fillcap_16
XFILLER_87_45 VDD VDD VSS VSS gf180mcu_as_sc_mcu7t3v3__fillcap_4
XFILLER_8_1151 VDD VDD VSS VSS gf180mcu_as_sc_mcu7t3v3__fillcap_4
XFILLER_8_1173 VDD VDD VSS VSS gf180mcu_as_sc_mcu7t3v3__fillcap_16
XFILLER_185_1014 VDD VDD VSS VSS gf180mcu_as_sc_mcu7t3v3__fillcap_16
XTAP_TAPCELL_ROW_5_1098 VDD VSS gf180mcu_as_sc_mcu7t3v3__tap_2
XFILLER_15_664 VDD VDD VSS VSS gf180mcu_as_sc_mcu7t3v3__fillcap_4
XFILLER_203_732 VDD VDD VSS VSS gf180mcu_as_sc_mcu7t3v3__fillcap_8
XFILLER_215_570 VDD VDD VSS VSS gf180mcu_as_sc_mcu7t3v3__fillcap_4
XFILLER_226_1033 VDD VDD VSS VSS gf180mcu_as_sc_mcu7t3v3__fillcap_16
XFILLER_187_422 VDD VDD VSS VSS gf180mcu_as_sc_mcu7t3v3__fillcap_8
XFILLER_199_282 VDD VDD VSS VSS gf180mcu_as_sc_mcu7t3v3__fill_1
XFILLER_202_253 VDD VDD VSS VSS gf180mcu_as_sc_mcu7t3v3__fill_1
XFILLER_30_645 VDD VDD VSS VSS gf180mcu_as_sc_mcu7t3v3__fillcap_16
Xinput13 VDD VDD VSS VSS boot_addr[5] _3277_/A gf180mcu_as_sc_mcu7t3v3__buff_12
XFILLER_155_330 VDD VDD VSS VSS gf180mcu_as_sc_mcu7t3v3__fillcap_16
XFILLER_167_190 VDD VDD VSS VSS gf180mcu_as_sc_mcu7t3v3__fillcap_8
Xinput24 VDD VDD VSS VSS boot_data[6] _3355_/A gf180mcu_as_sc_mcu7t3v3__buff_12
Xinput35 VDD VDD VSS VSS dft_addr[6] _3286_/B gf180mcu_as_sc_mcu7t3v3__buff_12
Xinput46 VDD VDD VSS VSS dft_wdata[5] _3348_/B gf180mcu_as_sc_mcu7t3v3__buff_12
XFILLER_200_1239 VDD VDD VSS VSS gf180mcu_as_sc_mcu7t3v3__fill_1
XFILLER_7_874 VDD VDD VSS VSS gf180mcu_as_sc_mcu7t3v3__fillcap_16
Xinput57 VDD VDD VSS VSS east_in[16] wire959/A gf180mcu_as_sc_mcu7t3v3__buff_12
Xinput68 VDD VDD VSS VSS east_in[26] _5889_/D gf180mcu_as_sc_mcu7t3v3__buff_12
Xinput79 VDD VDD VSS VSS east_in[3] _5698_/A gf180mcu_as_sc_mcu7t3v3__buff_12
XFILLER_157_1116 VDD VDD VSS VSS gf180mcu_as_sc_mcu7t3v3__fillcap_4
XFILLER_157_1138 VDD VDD VSS VSS gf180mcu_as_sc_mcu7t3v3__fillcap_16
XFILLER_170_311 VDD VDD VSS VSS gf180mcu_as_sc_mcu7t3v3__fillcap_4
XFILLER_170_333 VDD VDD VSS VSS gf180mcu_as_sc_mcu7t3v3__fillcap_16
X_3460_ VDD VDD VSS VSS _5970_/A _6491_/Q _5973_/B gf180mcu_as_sc_mcu7t3v3__and2_2
XTAP_TAPCELL_ROW_188_2121 VDD VSS gf180mcu_as_sc_mcu7t3v3__tap_2
X_3391_ VDD VDD VSS VSS _4511_/A _3391_/B _3391_/C _6324_/Q _4102_/B gf180mcu_as_sc_mcu7t3v3__ao211_2
XTAP_TAPCELL_ROW_188_2132 VDD VSS gf180mcu_as_sc_mcu7t3v3__tap_2
XFILLER_170_399 VDD VDD VSS VSS gf180mcu_as_sc_mcu7t3v3__fillcap_16
XTAP_TAPCELL_ROW_149_1404 VDD VSS gf180mcu_as_sc_mcu7t3v3__tap_2
X_5130_ VDD VDD VSS VSS _5130_/D _5792_/A _5139_/B _5139_/C _5131_/C gf180mcu_as_sc_mcu7t3v3__ao31_2
XTAP_TAPCELL_ROW_149_1415 VDD VSS gf180mcu_as_sc_mcu7t3v3__tap_2
XTAP_TAPCELL_ROW_149_1426 VDD VSS gf180mcu_as_sc_mcu7t3v3__tap_2
X_5061_ VDD VDD VSS VSS _5728_/A _5218_/B _5061_/C _5275_/B _5063_/A gf180mcu_as_sc_mcu7t3v3__ao211_2
XPHY_EDGE_ROW_94_3_Right_174 VDD VSS gf180mcu_as_sc_mcu7t3v3__tap_2
X_4012_ VDD VDD VSS VSS _4058_/B _4012_/B _4012_/C _6100_/Q _6100_/D gf180mcu_as_sc_mcu7t3v3__ao22_2
XPHY_EDGE_ROW_108_3_Left_813 VDD VSS gf180mcu_as_sc_mcu7t3v3__tap_2
XTAP_TAPCELL_ROW_207_2460 VDD VSS gf180mcu_as_sc_mcu7t3v3__tap_2
XFILLER_203_43 VDD VDD VSS VSS gf180mcu_as_sc_mcu7t3v3__fillcap_16
XTAP_TAPCELL_ROW_162_1659 VDD VSS gf180mcu_as_sc_mcu7t3v3__tap_2
XTAP_TAPCELL_ROW_207_2471 VDD VSS gf180mcu_as_sc_mcu7t3v3__tap_2
XFILLER_213_507 VDD VDD VSS VSS gf180mcu_as_sc_mcu7t3v3__fillcap_8
X_5963_ VDD VDD VSS VSS _5971_/B _5963_/B _5963_/A gf180mcu_as_sc_mcu7t3v3__nand2_2
XFILLER_197_219 VDD VDD VSS VSS gf180mcu_as_sc_mcu7t3v3__fill_2
X_4914_ VDD VDD VSS VSS _4939_/C _5930_/A _4953_/B _4948_/B gf180mcu_as_sc_mcu7t3v3__ao21_2
XFILLER_209_1264 VDD VDD VSS VSS gf180mcu_as_sc_mcu7t3v3__fill_1
X_5894_ VDD VDD VSS VSS _5947_/B _5894_/A _5900_/C gf180mcu_as_sc_mcu7t3v3__and2_2
XTAP_TAPCELL_ROW_220_2693 VDD VSS gf180mcu_as_sc_mcu7t3v3__tap_2
XFILLER_179_978 VDD VDD VSS VSS gf180mcu_as_sc_mcu7t3v3__fill_2
XFILLER_21_634 VDD VDD VSS VSS gf180mcu_as_sc_mcu7t3v3__fill_2
XFILLER_221_562 VDD VDD VSS VSS gf180mcu_as_sc_mcu7t3v3__fillcap_4
X_4845_ VDD VDD VSS VSS _4845_/B _5978_/A _6361_/D gf180mcu_as_sc_mcu7t3v3__and2_2
XFILLER_178_488 VDD VDD VSS VSS gf180mcu_as_sc_mcu7t3v3__fillcap_4
X_4776_ VDD VDD VSS VSS _4776_/D _4794_/S _4776_/B _4776_/C _4777_/D gf180mcu_as_sc_mcu7t3v3__ao31_2
X_6515_ VDD VDD VSS VSS _6518_/CLK _6515_/D _6515_/Q gf180mcu_as_sc_mcu7t3v3__dfxtp_2
X_3727_ VDD VDD VSS VSS _3869_/B _5731_/A _3728_/D gf180mcu_as_sc_mcu7t3v3__and2_2
XFILLER_14_1189 VDD VDD VSS VSS gf180mcu_as_sc_mcu7t3v3__fillcap_16
XFILLER_228_40 VDD VDD VSS VSS gf180mcu_as_sc_mcu7t3v3__fill_2
XFILLER_173_171 VDD VDD VSS VSS gf180mcu_as_sc_mcu7t3v3__fill_1
X_6446_ VDD VDD VSS VSS _6448_/CLK _6446_/D _6446_/Q gf180mcu_as_sc_mcu7t3v3__dfxtp_2
X_3658_ VDD VDD VSS VSS _5646_/A _3658_/B _3658_/C _3658_/Y _3658_/D gf180mcu_as_sc_mcu7t3v3__aoi211_2
X_6377_ VDD VDD VSS VSS _6527_/CLK _6377_/D _6377_/Q gf180mcu_as_sc_mcu7t3v3__dfxtp_2
X_3589_ VDD VDD VSS VSS _3595_/B _4264_/A _6522_/Q gf180mcu_as_sc_mcu7t3v3__nand2b_2
XPHY_EDGE_ROW_138_1_Right_710 VDD VSS gf180mcu_as_sc_mcu7t3v3__tap_2
X_5328_ VDD VDD VSS VSS _5649_/A _5328_/B _5328_/C _5361_/B gf180mcu_as_sc_mcu7t3v3__nand3_2
XTAP_TAPCELL_ROW_227_2836 VDD VSS gf180mcu_as_sc_mcu7t3v3__tap_2
XTAP_TAPCELL_ROW_227_2825 VDD VSS gf180mcu_as_sc_mcu7t3v3__tap_2
XFILLER_180_27 VDD VDD VSS VSS gf180mcu_as_sc_mcu7t3v3__fillcap_8
X_5259_ VDD VDD VSS VSS _5259_/B _5291_/A _6404_/D gf180mcu_as_sc_mcu7t3v3__and2_2
XFILLER_113_43 VDD VDD VSS VSS gf180mcu_as_sc_mcu7t3v3__fillcap_8
XFILLER_228_172 VDD VDD VSS VSS gf180mcu_as_sc_mcu7t3v3__fillcap_4
XTAP_TAPCELL_ROW_50_3_2924 VDD VSS gf180mcu_as_sc_mcu7t3v3__tap_2
XFILLER_225_890 VDD VDD VSS VSS gf180mcu_as_sc_mcu7t3v3__fillcap_16
XTAP_TAPCELL_ROW_148_1_1395 VDD VSS gf180mcu_as_sc_mcu7t3v3__tap_2
XFILLER_169_422 VDD VDD VSS VSS gf180mcu_as_sc_mcu7t3v3__fillcap_16
XFILLER_196_241 VDD VDD VSS VSS gf180mcu_as_sc_mcu7t3v3__fillcap_4
XFILLER_197_764 VDD VDD VSS VSS gf180mcu_as_sc_mcu7t3v3__fillcap_4
XFILLER_12_667 VDD VDD VSS VSS gf180mcu_as_sc_mcu7t3v3__fillcap_8
XFILLER_196_274 VDD VDD VSS VSS gf180mcu_as_sc_mcu7t3v3__fill_1
XFILLER_7_104 VDD VDD VSS VSS gf180mcu_as_sc_mcu7t3v3__fillcap_16
XFILLER_8_638 VDD VDD VSS VSS gf180mcu_as_sc_mcu7t3v3__fill_1
XFILLER_200_779 VDD VDD VSS VSS gf180mcu_as_sc_mcu7t3v3__fillcap_8
XFILLER_32_1245 VDD VDD VSS VSS gf180mcu_as_sc_mcu7t3v3__fillcap_16
XFILLER_152_311 VDD VDD VSS VSS gf180mcu_as_sc_mcu7t3v3__fillcap_4
XFILLER_152_333 VDD VDD VSS VSS gf180mcu_as_sc_mcu7t3v3__fillcap_8
XFILLER_164_171 VDD VDD VSS VSS gf180mcu_as_sc_mcu7t3v3__fillcap_4
XFILLER_164_193 VDD VDD VSS VSS gf180mcu_as_sc_mcu7t3v3__fillcap_8
XFILLER_98_33 VDD VDD VSS VSS gf180mcu_as_sc_mcu7t3v3__fill_2
XFILLER_153_889 VDD VDD VSS VSS gf180mcu_as_sc_mcu7t3v3__fill_1
XFILLER_4_877 VDD VDD VSS VSS gf180mcu_as_sc_mcu7t3v3__fillcap_16
XFILLER_4_899 VDD VDD VSS VSS gf180mcu_as_sc_mcu7t3v3__fill_1
XFILLER_191_1084 VDD VDD VSS VSS gf180mcu_as_sc_mcu7t3v3__fillcap_16
XFILLER_94_626 VDD VDD VSS VSS gf180mcu_as_sc_mcu7t3v3__fill_1
XTAP_TAPCELL_ROW_120_1_1381 VDD VSS gf180mcu_as_sc_mcu7t3v3__tap_2
XTAP_TAPCELL_ROW_183_2040 VDD VSS gf180mcu_as_sc_mcu7t3v3__tap_2
XTAP_TAPCELL_ROW_7_1138 VDD VSS gf180mcu_as_sc_mcu7t3v3__tap_2
XFILLER_207_356 VDD VDD VSS VSS gf180mcu_as_sc_mcu7t3v3__fill_1
XPHY_EDGE_ROW_100_1_Right_672 VDD VSS gf180mcu_as_sc_mcu7t3v3__tap_2
XFILLER_223_838 VDD VDD VSS VSS gf180mcu_as_sc_mcu7t3v3__fill_2
XFILLER_188_731 VDD VDD VSS VSS gf180mcu_as_sc_mcu7t3v3__fillcap_4
XPHY_EDGE_ROW_86_3_Left_791 VDD VSS gf180mcu_as_sc_mcu7t3v3__tap_2
XFILLER_148_606 VDD VDD VSS VSS gf180mcu_as_sc_mcu7t3v3__fill_2
XFILLER_188_775 VDD VDD VSS VSS gf180mcu_as_sc_mcu7t3v3__fill_1
XFILLER_203_562 VDD VDD VSS VSS gf180mcu_as_sc_mcu7t3v3__fillcap_4
XFILLER_163_1186 VDD VDD VSS VSS gf180mcu_as_sc_mcu7t3v3__fillcap_4
XFILLER_198_1205 VDD VDD VSS VSS gf180mcu_as_sc_mcu7t3v3__fillcap_16
X_4630_ VDD VDD VSS VSS _4896_/A _4889_/A _4630_/C _4638_/B gf180mcu_as_sc_mcu7t3v3__nand3_2
XFILLER_175_458 VDD VDD VSS VSS gf180mcu_as_sc_mcu7t3v3__fillcap_16
XFILLER_198_1227 VDD VDD VSS VSS gf180mcu_as_sc_mcu7t3v3__fillcap_8
XFILLER_8_53 VDD VDD VSS VSS gf180mcu_as_sc_mcu7t3v3__fillcap_16
XPHY_EDGE_ROW_145_2_Left_586 VDD VSS gf180mcu_as_sc_mcu7t3v3__tap_2
X_6300_ VDD VDD VSS VSS clkload7/A _6300_/D _6300_/Q gf180mcu_as_sc_mcu7t3v3__dfxtp_2
X_4561_ VDD VDD VSS VSS _4602_/C _4599_/A _4561_/C _6306_/D gf180mcu_as_sc_mcu7t3v3__nor3_2
X_4492_ VDD VDD VSS VSS _6282_/D _6282_/Q _4503_/C _4492_/C gf180mcu_as_sc_mcu7t3v3__ao21_2
X_3512_ VDD VDD VSS VSS _3614_/D _3655_/B _3655_/A gf180mcu_as_sc_mcu7t3v3__nor2_2
XPHY_EDGE_ROW_82_2_Left_523 VDD VSS gf180mcu_as_sc_mcu7t3v3__tap_2
X_6231_ VDD VDD VSS VSS _6526_/CLK _6231_/D _6231_/Q gf180mcu_as_sc_mcu7t3v3__dfxtp_2
X_3443_ VDD VDD VSS VSS _6717_/A _4584_/A _3454_/B gf180mcu_as_sc_mcu7t3v3__and2_2
X_6162_ VDD VDD VSS VSS _6531_/CLK _6162_/D _6162_/Q gf180mcu_as_sc_mcu7t3v3__dfxtp_2
XFILLER_170_1135 VDD VDD VSS VSS gf180mcu_as_sc_mcu7t3v3__fillcap_16
X_5113_ VDD VDD VSS VSS _5115_/C _5773_/A _5242_/B _5113_/C gf180mcu_as_sc_mcu7t3v3__ao21_2
X_3374_ VDD VDD VSS VSS _3374_/B _6261_/Q _4569_/A gf180mcu_as_sc_mcu7t3v3__and2_2
XTAP_TAPCELL_ROW_209_2511 VDD VSS gf180mcu_as_sc_mcu7t3v3__tap_2
XTAP_TAPCELL_ROW_209_2500 VDD VSS gf180mcu_as_sc_mcu7t3v3__tap_2
XFILLER_170_1157 VDD VDD VSS VSS gf180mcu_as_sc_mcu7t3v3__fillcap_16
X_6093_ VDD VDD VSS VSS _6492_/CLK _6093_/D _6093_/Q gf180mcu_as_sc_mcu7t3v3__dfxtp_2
XFILLER_214_53 VDD VDD VSS VSS gf180mcu_as_sc_mcu7t3v3__fillcap_16
X_5044_ VDD VDD VSS VSS _5044_/B _5164_/A _6381_/D gf180mcu_as_sc_mcu7t3v3__and2_2
XFILLER_211_1154 VDD VDD VSS VSS gf180mcu_as_sc_mcu7t3v3__fillcap_16
XPHY_EDGE_ROW_95_3_Right_175 VDD VSS gf180mcu_as_sc_mcu7t3v3__tap_2
XTAP_TAPCELL_ROW_222_2733 VDD VSS gf180mcu_as_sc_mcu7t3v3__tap_2
XFILLER_0_1221 VDD VDD VSS VSS gf180mcu_as_sc_mcu7t3v3__fill_2
XFILLER_225_142 VDD VDD VSS VSS gf180mcu_as_sc_mcu7t3v3__fillcap_4
XTAP_TAPCELL_ROW_70_1_1356 VDD VSS gf180mcu_as_sc_mcu7t3v3__tap_2
XTAP_TAPCELL_ROW_222_2744 VDD VSS gf180mcu_as_sc_mcu7t3v3__tap_2
XFILLER_198_517 VDD VDD VSS VSS gf180mcu_as_sc_mcu7t3v3__fill_1
XFILLER_55_1212 VDD VDD VSS VSS gf180mcu_as_sc_mcu7t3v3__fill_1
XFILLER_94_1261 VDD VDD VSS VSS gf180mcu_as_sc_mcu7t3v3__fillcap_4
X_5946_ VDD VDD VSS VSS _5946_/A _5946_/B _5946_/C _5946_/D _5947_/D gf180mcu_as_sc_mcu7t3v3__ao22_2
XFILLER_181_1264 VDD VDD VSS VSS gf180mcu_as_sc_mcu7t3v3__fill_1
X_5877_ VDD VDD VSS VSS _5944_/B _5877_/A _5880_/C gf180mcu_as_sc_mcu7t3v3__and2_2
XTAP_TAPCELL_ROW_179_1964 VDD VSS gf180mcu_as_sc_mcu7t3v3__tap_2
XFILLER_142_1226 VDD VDD VSS VSS gf180mcu_as_sc_mcu7t3v3__fillcap_16
XFILLER_179_797 VDD VDD VSS VSS gf180mcu_as_sc_mcu7t3v3__fill_2
X_4828_ VDD VDD VSS VSS _4945_/B _5829_/A _4829_/C gf180mcu_as_sc_mcu7t3v3__and2_2
X_4759_ VDD VDD VSS VSS _5769_/A _4872_/B _4759_/C _4759_/D _4760_/B gf180mcu_as_sc_mcu7t3v3__ao211_2
XFILLER_175_38 VDD VDD VSS VSS gf180mcu_as_sc_mcu7t3v3__fillcap_16
XFILLER_4_107 VDD VDD VSS VSS gf180mcu_as_sc_mcu7t3v3__fillcap_16
XFILLER_162_664 VDD VDD VSS VSS gf180mcu_as_sc_mcu7t3v3__fill_1
XFILLER_175_1046 VDD VDD VSS VSS gf180mcu_as_sc_mcu7t3v3__fillcap_4
XFILLER_190_951 VDD VDD VSS VSS gf180mcu_as_sc_mcu7t3v3__fill_1
X_6429_ VDD VDD VSS VSS _6437_/CLK _6429_/D _6429_/Q gf180mcu_as_sc_mcu7t3v3__dfxtp_2
XFILLER_150_837 VDD VDD VSS VSS gf180mcu_as_sc_mcu7t3v3__fillcap_16
XFILLER_161_174 VDD VDD VSS VSS gf180mcu_as_sc_mcu7t3v3__fillcap_16
XFILLER_162_697 VDD VDD VSS VSS gf180mcu_as_sc_mcu7t3v3__fillcap_4
XFILLER_175_1068 VDD VDD VSS VSS gf180mcu_as_sc_mcu7t3v3__fillcap_16
XFILLER_0_346 VDD VDD VSS VSS gf180mcu_as_sc_mcu7t3v3__fill_1
XPHY_EDGE_ROW_139_1_Right_711 VDD VSS gf180mcu_as_sc_mcu7t3v3__tap_2
XFILLER_191_59 VDD VDD VSS VSS gf180mcu_as_sc_mcu7t3v3__fillcap_8
XFILLER_216_1065 VDD VDD VSS VSS gf180mcu_as_sc_mcu7t3v3__fillcap_16
XFILLER_216_1087 VDD VDD VSS VSS gf180mcu_as_sc_mcu7t3v3__fillcap_16
XFILLER_76_626 VDD VDD VSS VSS gf180mcu_as_sc_mcu7t3v3__fill_1
Xinput203 VDD VDD VSS VSS se_in[17] _5818_/A gf180mcu_as_sc_mcu7t3v3__buff_12
Xinput214 VDD VDD VSS VSS se_in[27] _5894_/A gf180mcu_as_sc_mcu7t3v3__buff_12
Xinput225 VDD VDD VSS VSS se_in[4] _5711_/A gf180mcu_as_sc_mcu7t3v3__buff_12
Xinput236 VDD VDD VSS VSS south_in[14] _5791_/A gf180mcu_as_sc_mcu7t3v3__buff_12
XFILLER_130_594 VDD VDD VSS VSS gf180mcu_as_sc_mcu7t3v3__fillcap_4
Xinput247 VDD VDD VSS VSS south_in[24] _5871_/A gf180mcu_as_sc_mcu7t3v3__buff_12
Xinput258 VDD VDD VSS VSS south_in[34] wire994/A gf180mcu_as_sc_mcu7t3v3__buff_12
Xinput269 VDD VDD VSS VSS sw_in[11] _5770_/A gf180mcu_as_sc_mcu7t3v3__buff_12
XFILLER_217_632 VDD VDD VSS VSS gf180mcu_as_sc_mcu7t3v3__fill_2
XFILLER_5_1154 VDD VDD VSS VSS gf180mcu_as_sc_mcu7t3v3__fillcap_16
XTAP_TAPCELL_ROW_68_3_2951 VDD VSS gf180mcu_as_sc_mcu7t3v3__tap_2
XFILLER_140_30 VDD VDD VSS VSS gf180mcu_as_sc_mcu7t3v3__fillcap_4
XFILLER_205_849 VDD VDD VSS VSS gf180mcu_as_sc_mcu7t3v3__fill_1
XTAP_TAPCELL_ROW_2_1046 VDD VSS gf180mcu_as_sc_mcu7t3v3__tap_2
XFILLER_182_1017 VDD VDD VSS VSS gf180mcu_as_sc_mcu7t3v3__fillcap_16
XTAP_TAPCELL_ROW_2_1057 VDD VSS gf180mcu_as_sc_mcu7t3v3__tap_2
XFILLER_223_1014 VDD VDD VSS VSS gf180mcu_as_sc_mcu7t3v3__fillcap_16
XFILLER_13_976 VDD VDD VSS VSS gf180mcu_as_sc_mcu7t3v3__fillcap_4
XFILLER_212_370 VDD VDD VSS VSS gf180mcu_as_sc_mcu7t3v3__fill_1
XFILLER_212_381 VDD VDD VSS VSS gf180mcu_as_sc_mcu7t3v3__fillcap_4
XPHY_EDGE_ROW_78_1_Left_306 VDD VSS gf180mcu_as_sc_mcu7t3v3__tap_2
XFILLER_13_998 VDD VDD VSS VSS gf180mcu_as_sc_mcu7t3v3__fillcap_16
XFILLER_200_543 VDD VDD VSS VSS gf180mcu_as_sc_mcu7t3v3__fill_1
XPHY_EDGE_ROW_130_1_Left_358 VDD VSS gf180mcu_as_sc_mcu7t3v3__tap_2
XFILLER_184_255 VDD VDD VSS VSS gf180mcu_as_sc_mcu7t3v3__fillcap_4
XFILLER_153_664 VDD VDD VSS VSS gf180mcu_as_sc_mcu7t3v3__fillcap_8
XFILLER_154_1119 VDD VDD VSS VSS gf180mcu_as_sc_mcu7t3v3__fillcap_16
XFILLER_121_594 VDD VDD VSS VSS gf180mcu_as_sc_mcu7t3v3__fillcap_8
X_3090_ VDD VDD VSS VSS _3226_/B input9/Y gf180mcu_as_sc_mcu7t3v3__inv_2
Xclkbuf_leaf_7_clk_regs VDD VDD VSS VSS clkload0/A _6313_/CLK gf180mcu_as_sc_mcu7t3v3__clkbuff_12
XFILLER_78_1245 VDD VDD VSS VSS gf180mcu_as_sc_mcu7t3v3__fillcap_16
XPHY_EDGE_ROW_101_1_Right_673 VDD VSS gf180mcu_as_sc_mcu7t3v3__tap_2
X_5800_ VDD VDD VSS VSS _5800_/A _5800_/B _5800_/C _5800_/D _5801_/A gf180mcu_as_sc_mcu7t3v3__ao211_2
X_3992_ VDD VDD VSS VSS _6080_/D _3992_/C _4008_/B _4028_/A gf180mcu_as_sc_mcu7t3v3__ao21b_2
XTAP_TAPCELL_ROW_200_2349 VDD VSS gf180mcu_as_sc_mcu7t3v3__tap_2
XTAP_TAPCELL_ROW_200_2338 VDD VSS gf180mcu_as_sc_mcu7t3v3__tap_2
XFILLER_149_915 VDD VDD VSS VSS gf180mcu_as_sc_mcu7t3v3__fill_2
X_5731_ VDD VDD VSS VSS _5853_/B _5731_/A _5734_/C gf180mcu_as_sc_mcu7t3v3__and2_2
XTAP_TAPCELL_ROW_196_2275 VDD VSS gf180mcu_as_sc_mcu7t3v3__tap_2
XTAP_TAPCELL_ROW_196_2264 VDD VSS gf180mcu_as_sc_mcu7t3v3__tap_2
Xsram2048.u_bank1_1038 VDD VDD VSS VSS sram2048.u_bank1/WEN[4] gf180mcu_as_sc_mcu7t3v3__tiel_4
X_5662_ VDD VDD VSS VSS _5662_/B _5662_/A _5667_/C gf180mcu_as_sc_mcu7t3v3__or2_2
XFILLER_102_1210 VDD VDD VSS VSS gf180mcu_as_sc_mcu7t3v3__fillcap_8
XFILLER_15_1262 VDD VDD VSS VSS gf180mcu_as_sc_mcu7t3v3__fill_2
XFILLER_163_417 VDD VDD VSS VSS gf180mcu_as_sc_mcu7t3v3__fill_2
XTAP_TAPCELL_ROW_157_1569 VDD VSS gf180mcu_as_sc_mcu7t3v3__tap_2
X_5593_ VDD VDD VSS VSS _5593_/B _5643_/A _6440_/D gf180mcu_as_sc_mcu7t3v3__and2_2
X_4613_ VDD VDD VSS VSS _4613_/Y _4982_/D _4979_/D gf180mcu_as_sc_mcu7t3v3__nor2_2
XTAP_TAPCELL_ROW_174_1872 VDD VSS gf180mcu_as_sc_mcu7t3v3__tap_2
X_4544_ VDD VDD VSS VSS _6300_/D _6301_/Q _4552_/B _4544_/C gf180mcu_as_sc_mcu7t3v3__ao21_2
XFILLER_144_653 VDD VDD VSS VSS gf180mcu_as_sc_mcu7t3v3__fillcap_8
X_6214_ VDD VDD VSS VSS _6526_/CLK _6214_/D _6214_/Q gf180mcu_as_sc_mcu7t3v3__dfxtp_2
X_4475_ VDD VDD VSS VSS _4476_/B _4475_/B _6267_/Q gf180mcu_as_sc_mcu7t3v3__nand2b_2
Xfanout904 VDD VDD VSS VSS _4569_/D _4509_/A gf180mcu_as_sc_mcu7t3v3__buff_12
Xfanout915 VDD VDD VSS VSS _4293_/S _4307_/S gf180mcu_as_sc_mcu7t3v3__buff_12
X_3426_ VDD VDD VSS VSS _3426_/A _4443_/B _3426_/C _3426_/D _3429_/A gf180mcu_as_sc_mcu7t3v3__ao211_2
XFILLER_219_908 VDD VDD VSS VSS gf180mcu_as_sc_mcu7t3v3__fill_2
XFILLER_225_74 VDD VDD VSS VSS gf180mcu_as_sc_mcu7t3v3__fill_1
Xfanout926 VDD VDD VSS VSS _5893_/A _5836_/A gf180mcu_as_sc_mcu7t3v3__buff_12
Xfanout937 VDD VDD VSS VSS _5578_/A _5643_/A gf180mcu_as_sc_mcu7t3v3__buff_12
X_6145_ VDD VDD VSS VSS clkload8/A _6145_/D _6145_/Q gf180mcu_as_sc_mcu7t3v3__dfxtp_2
X_3357_ VDD VDD VSS VSS _3357_/S _6540_/Q _6549_/Q _3358_/B gf180mcu_as_sc_mcu7t3v3__mux2_2
XFILLER_112_594 VDD VDD VSS VSS gf180mcu_as_sc_mcu7t3v3__fillcap_8
X_6076_ VDD VDD VSS VSS _6506_/CLK _6076_/D _6076_/Q gf180mcu_as_sc_mcu7t3v3__dfxtp_2
X_5027_ VDD VDD VSS VSS _5183_/B _5698_/A _5028_/C gf180mcu_as_sc_mcu7t3v3__and2_2
X_3288_ VDD VDD VSS VSS _6170_/Q _3296_/B _3288_/C _3288_/D _3290_/B gf180mcu_as_sc_mcu7t3v3__ao211_2
XFILLER_226_451 VDD VDD VSS VSS gf180mcu_as_sc_mcu7t3v3__fillcap_4
XPHY_EDGE_ROW_96_3_Right_176 VDD VSS gf180mcu_as_sc_mcu7t3v3__tap_2
XFILLER_13_206 VDD VDD VSS VSS gf180mcu_as_sc_mcu7t3v3__fillcap_4
XFILLER_14_729 VDD VDD VSS VSS gf180mcu_as_sc_mcu7t3v3__fillcap_4
XFILLER_54_49 VDD VDD VSS VSS gf180mcu_as_sc_mcu7t3v3__fill_2
XFILLER_0_1073 VDD VDD VSS VSS gf180mcu_as_sc_mcu7t3v3__fillcap_4
XFILLER_13_228 VDD VDD VSS VSS gf180mcu_as_sc_mcu7t3v3__fillcap_16
XFILLER_16_1004 VDD VDD VSS VSS gf180mcu_as_sc_mcu7t3v3__fillcap_16
X_5929_ VDD VDD VSS VSS _5951_/B _5929_/A _5931_/C gf180mcu_as_sc_mcu7t3v3__and2_2
XFILLER_70_37 VDD VDD VSS VSS gf180mcu_as_sc_mcu7t3v3__fillcap_8
XFILLER_10_979 VDD VDD VSS VSS gf180mcu_as_sc_mcu7t3v3__fillcap_16
XFILLER_186_37 VDD VDD VSS VSS gf180mcu_as_sc_mcu7t3v3__fillcap_4
XFILLER_135_664 VDD VDD VSS VSS gf180mcu_as_sc_mcu7t3v3__fill_2
XFILLER_162_483 VDD VDD VSS VSS gf180mcu_as_sc_mcu7t3v3__fillcap_8
XFILLER_0_110 VDD VDD VSS VSS gf180mcu_as_sc_mcu7t3v3__fill_1
XFILLER_150_634 VDD VDD VSS VSS gf180mcu_as_sc_mcu7t3v3__fillcap_4
XFILLER_118_1261 VDD VDD VSS VSS gf180mcu_as_sc_mcu7t3v3__fillcap_4
XFILLER_150_667 VDD VDD VSS VSS gf180mcu_as_sc_mcu7t3v3__fillcap_16
XFILLER_0_176 VDD VDD VSS VSS gf180mcu_as_sc_mcu7t3v3__fill_2
XFILLER_103_594 VDD VDD VSS VSS gf180mcu_as_sc_mcu7t3v3__fill_1
XFILLER_95_45 VDD VDD VSS VSS gf180mcu_as_sc_mcu7t3v3__fillcap_4
XFILLER_218_963 VDD VDD VSS VSS gf180mcu_as_sc_mcu7t3v3__fillcap_16
XFILLER_72_662 VDD VDD VSS VSS gf180mcu_as_sc_mcu7t3v3__fillcap_4
XFILLER_177_509 VDD VDD VSS VSS gf180mcu_as_sc_mcu7t3v3__fill_1
XFILLER_125_1210 VDD VDD VSS VSS gf180mcu_as_sc_mcu7t3v3__fillcap_16
XFILLER_13_762 VDD VDD VSS VSS gf180mcu_as_sc_mcu7t3v3__fillcap_8
XFILLER_157_244 VDD VDD VSS VSS gf180mcu_as_sc_mcu7t3v3__fillcap_16
XFILLER_160_1189 VDD VDD VSS VSS gf180mcu_as_sc_mcu7t3v3__fillcap_16
XTAP_TAPCELL_ROW_191_2172 VDD VSS gf180mcu_as_sc_mcu7t3v3__tap_2
XFILLER_195_1208 VDD VDD VSS VSS gf180mcu_as_sc_mcu7t3v3__fillcap_16
XFILLER_200_395 VDD VDD VSS VSS gf180mcu_as_sc_mcu7t3v3__fill_2
XFILLER_9_788 VDD VDD VSS VSS gf180mcu_as_sc_mcu7t3v3__fillcap_16
XTAP_TAPCELL_ROW_191_2183 VDD VSS gf180mcu_as_sc_mcu7t3v3__tap_2
XFILLER_172_247 VDD VDD VSS VSS gf180mcu_as_sc_mcu7t3v3__fillcap_16
XFILLER_201_1186 VDD VDD VSS VSS gf180mcu_as_sc_mcu7t3v3__fillcap_4
XPHY_EDGE_ROW_117_3_Left_822 VDD VSS gf180mcu_as_sc_mcu7t3v3__tap_2
XFILLER_5_43 VDD VDD VSS VSS gf180mcu_as_sc_mcu7t3v3__fillcap_16
XTAP_TAPCELL_ROW_152_1477 VDD VSS gf180mcu_as_sc_mcu7t3v3__tap_2
X_4260_ VDD VDD VSS VSS _4335_/S _6106_/Q _6019_/Q _4262_/A gf180mcu_as_sc_mcu7t3v3__mux2_2
X_4191_ VDD VDD VSS VSS _4335_/S _6070_/Q _6099_/Q _4192_/B gf180mcu_as_sc_mcu7t3v3__mux2_2
X_3211_ VDD VDD VSS VSS _3211_/B _3211_/A _3212_/B gf180mcu_as_sc_mcu7t3v3__and2_2
X_3142_ VDD VDD VSS VSS _4456_/A _3433_/B _4106_/A gf180mcu_as_sc_mcu7t3v3__or2_2
X_3073_ VDD VDD VSS VSS _5123_/A _5782_/B gf180mcu_as_sc_mcu7t3v3__inv_2
XTAP_TAPCELL_ROW_198_2304 VDD VSS gf180mcu_as_sc_mcu7t3v3__tap_2
XFILLER_169_1170 VDD VDD VSS VSS gf180mcu_as_sc_mcu7t3v3__fillcap_16
XFILLER_169_1192 VDD VDD VSS VSS gf180mcu_as_sc_mcu7t3v3__fillcap_16
XFILLER_211_54 VDD VDD VSS VSS gf180mcu_as_sc_mcu7t3v3__fillcap_16
XFILLER_223_432 VDD VDD VSS VSS gf180mcu_as_sc_mcu7t3v3__fill_1
XFILLER_165_1045 VDD VDD VSS VSS gf180mcu_as_sc_mcu7t3v3__fillcap_4
XFILLER_168_509 VDD VDD VSS VSS gf180mcu_as_sc_mcu7t3v3__fill_2
XFILLER_196_807 VDD VDD VSS VSS gf180mcu_as_sc_mcu7t3v3__fillcap_4
XPHY_EDGE_ROW_102_1_Right_674 VDD VSS gf180mcu_as_sc_mcu7t3v3__tap_2
XTAP_TAPCELL_ROW_159_1609 VDD VSS gf180mcu_as_sc_mcu7t3v3__tap_2
XFILLER_189_881 VDD VDD VSS VSS gf180mcu_as_sc_mcu7t3v3__fill_1
XTAP_TAPCELL_ROW_176_1901 VDD VSS gf180mcu_as_sc_mcu7t3v3__tap_2
XTAP_TAPCELL_ROW_176_1912 VDD VSS gf180mcu_as_sc_mcu7t3v3__tap_2
X_3975_ VDD VDD VSS VSS _4055_/B _3975_/B _3975_/C _6069_/Q _6069_/D gf180mcu_as_sc_mcu7t3v3__ao22_2
XFILLER_10_209 VDD VDD VSS VSS gf180mcu_as_sc_mcu7t3v3__fillcap_16
XFILLER_188_380 VDD VDD VSS VSS gf180mcu_as_sc_mcu7t3v3__fillcap_4
XFILLER_210_137 VDD VDD VSS VSS gf180mcu_as_sc_mcu7t3v3__fill_1
X_5714_ VDD VDD VSS VSS _5801_/S _5714_/A _5719_/C gf180mcu_as_sc_mcu7t3v3__and2_2
X_5645_ VDD VDD VSS VSS _5646_/B _5646_/A _5950_/B gf180mcu_as_sc_mcu7t3v3__and2_2
XTAP_TAPCELL_ROW_217_2654 VDD VSS gf180mcu_as_sc_mcu7t3v3__tap_2
XTAP_TAPCELL_ROW_217_2643 VDD VSS gf180mcu_as_sc_mcu7t3v3__tap_2
XFILLER_164_737 VDD VDD VSS VSS gf180mcu_as_sc_mcu7t3v3__fillcap_16
XPHY_EDGE_ROW_49_3_Left_754 VDD VSS gf180mcu_as_sc_mcu7t3v3__tap_2
X_5576_ VDD VDD VSS VSS _5634_/B _5882_/A _5577_/D gf180mcu_as_sc_mcu7t3v3__and2_2
XFILLER_117_664 VDD VDD VSS VSS gf180mcu_as_sc_mcu7t3v3__fill_2
XFILLER_132_612 VDD VDD VSS VSS gf180mcu_as_sc_mcu7t3v3__fillcap_4
X_4527_ VDD VDD VSS VSS _4527_/S _6294_/Q _4527_/A _6294_/D gf180mcu_as_sc_mcu7t3v3__mux2_2
XFILLER_132_645 VDD VDD VSS VSS gf180mcu_as_sc_mcu7t3v3__fill_1
XPHY_EDGE_ROW_108_2_Left_549 VDD VSS gf180mcu_as_sc_mcu7t3v3__tap_2
X_4458_ VDD VDD VSS VSS _4520_/S _6143_/Q _6268_/Q _6268_/D gf180mcu_as_sc_mcu7t3v3__mux2_2
XFILLER_172_1049 VDD VDD VSS VSS gf180mcu_as_sc_mcu7t3v3__fillcap_16
Xfanout701 VDD VDD VSS VSS _3853_/B _3806_/S gf180mcu_as_sc_mcu7t3v3__buff_12
Xfanout712 VDD VDD VSS VSS _4140_/S _4135_/S gf180mcu_as_sc_mcu7t3v3__buff_12
Xfanout723 VDD VDD VSS VSS _5839_/D _5855_/D gf180mcu_as_sc_mcu7t3v3__buff_12
X_3409_ VDD VDD VSS VSS _4468_/A _6313_/Q _3410_/B gf180mcu_as_sc_mcu7t3v3__and2_2
Xfanout734 VDD VDD VSS VSS _5549_/C _5615_/C gf180mcu_as_sc_mcu7t3v3__buff_12
Xfanout745 VDD VDD VSS VSS _3852_/B _3757_/B gf180mcu_as_sc_mcu7t3v3__buff_12
Xfanout756 VDD VDD VSS VSS _5838_/S _5854_/S gf180mcu_as_sc_mcu7t3v3__buff_12
Xfanout767 VDD VDD VSS VSS _5203_/C _5292_/C gf180mcu_as_sc_mcu7t3v3__buff_12
X_6128_ VDD VDD VSS VSS _6486_/CLK _6128_/D _6128_/Q gf180mcu_as_sc_mcu7t3v3__dfxtp_2
X_4389_ VDD VDD VSS VSS _4390_/C _4405_/S _6037_/Q gf180mcu_as_sc_mcu7t3v3__nor2b_2
XFILLER_213_1046 VDD VDD VSS VSS gf180mcu_as_sc_mcu7t3v3__fillcap_4
XFILLER_213_1068 VDD VDD VSS VSS gf180mcu_as_sc_mcu7t3v3__fillcap_16
Xfanout778 VDD VDD VSS VSS _4980_/Y _5124_/B gf180mcu_as_sc_mcu7t3v3__buff_12
Xfanout789 VDD VDD VSS VSS _4861_/B _4960_/B gf180mcu_as_sc_mcu7t3v3__buff_12
X_6059_ VDD VDD VSS VSS _6125_/CLK _6059_/D _6059_/Q gf180mcu_as_sc_mcu7t3v3__dfxtp_2
XFILLER_171_6 VDD VDD VSS VSS gf180mcu_as_sc_mcu7t3v3__fillcap_16
XFILLER_2_1135 VDD VDD VSS VSS gf180mcu_as_sc_mcu7t3v3__fillcap_16
XFILLER_2_1157 VDD VDD VSS VSS gf180mcu_as_sc_mcu7t3v3__fillcap_16
XFILLER_121_43 VDD VDD VSS VSS gf180mcu_as_sc_mcu7t3v3__fillcap_8
XFILLER_148_1210 VDD VDD VSS VSS gf180mcu_as_sc_mcu7t3v3__fillcap_16
XFILLER_199_634 VDD VDD VSS VSS gf180mcu_as_sc_mcu7t3v3__fill_1
XFILLER_214_443 VDD VDD VSS VSS gf180mcu_as_sc_mcu7t3v3__fillcap_4
XFILLER_215_955 VDD VDD VSS VSS gf180mcu_as_sc_mcu7t3v3__fillcap_16
XPHY_EDGE_ROW_97_3_Right_177 VDD VSS gf180mcu_as_sc_mcu7t3v3__tap_2
XFILLER_81_14 VDD VDD VSS VSS gf180mcu_as_sc_mcu7t3v3__fill_2
XFILLER_186_317 VDD VDD VSS VSS gf180mcu_as_sc_mcu7t3v3__fillcap_8
XFILLER_214_487 VDD VDD VSS VSS gf180mcu_as_sc_mcu7t3v3__fillcap_8
XFILLER_197_69 VDD VDD VSS VSS gf180mcu_as_sc_mcu7t3v3__fill_1
XFILLER_195_873 VDD VDD VSS VSS gf180mcu_as_sc_mcu7t3v3__fill_1
XFILLER_220_1017 VDD VDD VSS VSS gf180mcu_as_sc_mcu7t3v3__fillcap_16
XFILLER_154_225 VDD VDD VSS VSS gf180mcu_as_sc_mcu7t3v3__fillcap_16
XFILLER_212_2 VDD VDD VSS VSS gf180mcu_as_sc_mcu7t3v3__fillcap_8
XFILLER_154_247 VDD VDD VSS VSS gf180mcu_as_sc_mcu7t3v3__fillcap_16
XFILLER_123_645 VDD VDD VSS VSS gf180mcu_as_sc_mcu7t3v3__fill_1
XFILLER_151_998 VDD VDD VSS VSS gf180mcu_as_sc_mcu7t3v3__fillcap_16
XTAP_TAPCELL_ROW_56_3_2933 VDD VSS gf180mcu_as_sc_mcu7t3v3__tap_2
XFILLER_7_1046 VDD VDD VSS VSS gf180mcu_as_sc_mcu7t3v3__fillcap_4
XFILLER_7_1068 VDD VDD VSS VSS gf180mcu_as_sc_mcu7t3v3__fillcap_16
Xmesh_tile_1111 VDD VDD VSS VSS nw_out[34] gf180mcu_as_sc_mcu7t3v3__tiel_4
Xmesh_tile_1100 VDD VDD VSS VSS nw_out[23] gf180mcu_as_sc_mcu7t3v3__tiel_4
XFILLER_188_1012 VDD VDD VSS VSS gf180mcu_as_sc_mcu7t3v3__fill_2
Xmesh_tile_1144 VDD VDD VSS VSS se_out[31] gf180mcu_as_sc_mcu7t3v3__tiel_4
Xmesh_tile_1133 VDD VDD VSS VSS se_out[20] gf180mcu_as_sc_mcu7t3v3__tiel_4
Xmesh_tile_1122 VDD VDD VSS VSS se_out[9] gf180mcu_as_sc_mcu7t3v3__tiel_4
XFILLER_218_760 VDD VDD VSS VSS gf180mcu_as_sc_mcu7t3v3__fill_2
Xmesh_tile_1177 VDD VDD VSS VSS sw_out[28] gf180mcu_as_sc_mcu7t3v3__tiel_4
Xmesh_tile_1166 VDD VDD VSS VSS sw_out[17] gf180mcu_as_sc_mcu7t3v3__tiel_4
Xmesh_tile_1155 VDD VDD VSS VSS sw_out[6] gf180mcu_as_sc_mcu7t3v3__tiel_4
XFILLER_189_100 VDD VDD VSS VSS gf180mcu_as_sc_mcu7t3v3__fillcap_16
XFILLER_178_807 VDD VDD VSS VSS gf180mcu_as_sc_mcu7t3v3__fill_2
XFILLER_205_443 VDD VDD VSS VSS gf180mcu_as_sc_mcu7t3v3__fill_1
XFILLER_189_155 VDD VDD VSS VSS gf180mcu_as_sc_mcu7t3v3__fillcap_16
XFILLER_60_665 VDD VDD VSS VSS gf180mcu_as_sc_mcu7t3v3__fill_2
XPHY_EDGE_ROW_91_2_Left_532 VDD VSS gf180mcu_as_sc_mcu7t3v3__tap_2
XTAP_TAPCELL_ROW_193_2223 VDD VSS gf180mcu_as_sc_mcu7t3v3__tap_2
XTAP_TAPCELL_ROW_193_2212 VDD VSS gf180mcu_as_sc_mcu7t3v3__tap_2
XFILLER_220_457 VDD VDD VSS VSS gf180mcu_as_sc_mcu7t3v3__fillcap_4
X_3760_ VDD VDD VSS VSS _3910_/B _5760_/A _3761_/D gf180mcu_as_sc_mcu7t3v3__and2_2
XTAP_TAPCELL_ROW_154_1506 VDD VSS gf180mcu_as_sc_mcu7t3v3__tap_2
XFILLER_12_1221 VDD VDD VSS VSS gf180mcu_as_sc_mcu7t3v3__fillcap_4
XFILLER_158_597 VDD VDD VSS VSS gf180mcu_as_sc_mcu7t3v3__fillcap_4
XFILLER_173_523 VDD VDD VSS VSS gf180mcu_as_sc_mcu7t3v3__fill_1
XFILLER_185_383 VDD VDD VSS VSS gf180mcu_as_sc_mcu7t3v3__fillcap_16
XFILLER_200_170 VDD VDD VSS VSS gf180mcu_as_sc_mcu7t3v3__fill_1
XTAP_TAPCELL_ROW_154_1517 VDD VSS gf180mcu_as_sc_mcu7t3v3__tap_2
X_5430_ VDD VDD VSS VSS _5430_/B _5506_/A _6420_/D gf180mcu_as_sc_mcu7t3v3__and2_2
X_3691_ VDD VDD VSS VSS _3806_/S _5701_/A _3691_/A _3692_/A gf180mcu_as_sc_mcu7t3v3__mux2_2
XFILLER_12_1243 VDD VDD VSS VSS gf180mcu_as_sc_mcu7t3v3__fillcap_16
XTAP_TAPCELL_ROW_171_1820 VDD VSS gf180mcu_as_sc_mcu7t3v3__tap_2
XFILLER_161_718 VDD VDD VSS VSS gf180mcu_as_sc_mcu7t3v3__fillcap_8
XFILLER_173_589 VDD VDD VSS VSS gf180mcu_as_sc_mcu7t3v3__fill_2
XFILLER_58_2 VDD VDD VSS VSS gf180mcu_as_sc_mcu7t3v3__fillcap_8
X_5361_ VDD VDD VSS VSS _5638_/B _5361_/B _5362_/B _5361_/Y gf180mcu_as_sc_mcu7t3v3__nor3_2
XTAP_TAPCELL_ROW_212_2562 VDD VSS gf180mcu_as_sc_mcu7t3v3__tap_2
XTAP_TAPCELL_ROW_212_2551 VDD VSS gf180mcu_as_sc_mcu7t3v3__tap_2
Xoutput359 VDD VDD VSS VSS _6433_/Q east_out[20] gf180mcu_as_sc_mcu7t3v3__buff_12
Xoutput348 VDD VDD VSS VSS _6423_/Q east_out[10] gf180mcu_as_sc_mcu7t3v3__buff_12
X_5292_ VDD VDD VSS VSS _5937_/A _5292_/B _5292_/C _5938_/B _5294_/B gf180mcu_as_sc_mcu7t3v3__ao22_2
X_4312_ VDD VDD VSS VSS _4313_/C _4363_/S _6026_/Q gf180mcu_as_sc_mcu7t3v3__nor2b_2
X_4243_ VDD VDD VSS VSS _4243_/D _4243_/A _4243_/B _4243_/C _6203_/D gf180mcu_as_sc_mcu7t3v3__ao31_2
XTAP_TAPCELL_ROW_169_1782 VDD VSS gf180mcu_as_sc_mcu7t3v3__tap_2
X_4174_ VDD VDD VSS VSS _6174_/Q _6173_/Q _4175_/C gf180mcu_as_sc_mcu7t3v3__or2_2
XFILLER_28_629 VDD VDD VSS VSS gf180mcu_as_sc_mcu7t3v3__fillcap_16
XTAP_TAPCELL_ROW_13_1248 VDD VSS gf180mcu_as_sc_mcu7t3v3__tap_2
X_3125_ VDD VDD VSS VSS _4564_/B _6308_/Q _4567_/B gf180mcu_as_sc_mcu7t3v3__and2_2
XFILLER_222_53 VDD VDD VSS VSS gf180mcu_as_sc_mcu7t3v3__fill_2
X_3056_ VDD VDD VSS VSS _4583_/A _6316_/Q gf180mcu_as_sc_mcu7t3v3__inv_2
XFILLER_35_29 VDD VDD VSS VSS gf180mcu_as_sc_mcu7t3v3__fillcap_16
XFILLER_212_947 VDD VDD VSS VSS gf180mcu_as_sc_mcu7t3v3__fillcap_16
XPHY_EDGE_ROW_103_1_Right_675 VDD VSS gf180mcu_as_sc_mcu7t3v3__tap_2
X_3958_ VDD VDD VSS VSS _4039_/B _3981_/C _3980_/B _6060_/Q _6060_/D gf180mcu_as_sc_mcu7t3v3__ao22_2
XFILLER_149_597 VDD VDD VSS VSS gf180mcu_as_sc_mcu7t3v3__fillcap_8
X_3889_ VDD VDD VSS VSS _5872_/A _3889_/B _3889_/C _3889_/D _3891_/C gf180mcu_as_sc_mcu7t3v3__ao211_2
X_5628_ VDD VDD VSS VSS _5940_/A _5634_/B _5628_/C _5629_/C _5628_/D gf180mcu_as_sc_mcu7t3v3__aoi211_2
XFILLER_151_206 VDD VDD VSS VSS gf180mcu_as_sc_mcu7t3v3__fillcap_4
XFILLER_3_717 VDD VDD VSS VSS gf180mcu_as_sc_mcu7t3v3__fill_1
X_5559_ VDD VDD VSS VSS _5865_/A _5585_/B _5559_/C _5559_/D _5560_/A gf180mcu_as_sc_mcu7t3v3__ao211_2
XFILLER_151_228 VDD VDD VSS VSS gf180mcu_as_sc_mcu7t3v3__fillcap_16
XFILLER_183_27 VDD VDD VSS VSS gf180mcu_as_sc_mcu7t3v3__fillcap_8
XFILLER_160_762 VDD VDD VSS VSS gf180mcu_as_sc_mcu7t3v3__fill_1
XFILLER_120_626 VDD VDD VSS VSS gf180mcu_as_sc_mcu7t3v3__fill_1
XFILLER_28_1261 VDD VDD VSS VSS gf180mcu_as_sc_mcu7t3v3__fillcap_4
Xfanout520 VDD VDD VSS VSS _4012_/C _4002_/C gf180mcu_as_sc_mcu7t3v3__buff_12
Xfanout531 VDD VDD VSS VSS _3667_/Y fanout531/Y gf180mcu_as_sc_mcu7t3v3__buff_12
Xfanout542 VDD VDD VSS VSS _5456_/B _5584_/B gf180mcu_as_sc_mcu7t3v3__buff_12
XPHY_EDGE_ROW_87_1_Left_315 VDD VSS gf180mcu_as_sc_mcu7t3v3__tap_2
Xfanout564 VDD VDD VSS VSS _3975_/B _3962_/C gf180mcu_as_sc_mcu7t3v3__buff_12
Xfanout575 VDD VDD VSS VSS _4045_/A _4043_/A gf180mcu_as_sc_mcu7t3v3__buff_12
XTAP_TAPCELL_ROW_147_2_3069 VDD VSS gf180mcu_as_sc_mcu7t3v3__tap_2
Xfanout586 VDD VDD VSS VSS _5536_/B _5495_/B gf180mcu_as_sc_mcu7t3v3__buff_12
XFILLER_206_207 VDD VDD VSS VSS gf180mcu_as_sc_mcu7t3v3__fillcap_4
XFILLER_214_240 VDD VDD VSS VSS gf180mcu_as_sc_mcu7t3v3__fillcap_4
XFILLER_215_774 VDD VDD VSS VSS gf180mcu_as_sc_mcu7t3v3__fill_1
XPHY_EDGE_ROW_98_3_Right_178 VDD VSS gf180mcu_as_sc_mcu7t3v3__tap_2
XFILLER_226_1259 VDD VDD VSS VSS gf180mcu_as_sc_mcu7t3v3__fillcap_4
XFILLER_35_1210 VDD VDD VSS VSS gf180mcu_as_sc_mcu7t3v3__fillcap_4
XFILLER_161_1240 VDD VDD VSS VSS gf180mcu_as_sc_mcu7t3v3__fillcap_16
XFILLER_161_1262 VDD VDD VSS VSS gf180mcu_as_sc_mcu7t3v3__fill_2
XFILLER_174_309 VDD VDD VSS VSS gf180mcu_as_sc_mcu7t3v3__fill_1
XFILLER_155_523 VDD VDD VSS VSS gf180mcu_as_sc_mcu7t3v3__fillcap_16
Xclkbuf_leaf_21_clk_regs VDD VDD VSS VSS clkbuf_3_2_0_clk_regs/Y _6517_/CLK gf180mcu_as_sc_mcu7t3v3__clkbuff_12
Xwire976 VDD VDD VSS VSS wire976/A _5952_/A gf180mcu_as_sc_mcu7t3v3__clkbuff_12
XFILLER_157_72 VDD VDD VSS VSS gf180mcu_as_sc_mcu7t3v3__fillcap_16
Xwire987 VDD VDD VSS VSS wire987/A _5779_/A gf180mcu_as_sc_mcu7t3v3__clkbuff_12
Xwire998 VDD VDD VSS VSS wire998/A _5888_/B gf180mcu_as_sc_mcu7t3v3__clkbuff_12
XFILLER_1_282 VDD VDD VSS VSS gf180mcu_as_sc_mcu7t3v3__fillcap_16
XPHY_EDGE_ROW_71_1_Left_299 VDD VSS gf180mcu_as_sc_mcu7t3v3__tap_2
XTAP_TAPCELL_ROW_186_2093 VDD VSS gf180mcu_as_sc_mcu7t3v3__tap_2
XTAP_TAPCELL_ROW_186_2082 VDD VSS gf180mcu_as_sc_mcu7t3v3__tap_2
XPHY_EDGE_ROW_204_Left_432 VDD VSS gf180mcu_as_sc_mcu7t3v3__tap_2
XFILLER_206_741 VDD VDD VSS VSS gf180mcu_as_sc_mcu7t3v3__fill_2
XFILLER_218_590 VDD VDD VSS VSS gf180mcu_as_sc_mcu7t3v3__fillcap_4
XTAP_TAPCELL_ROW_164_1690 VDD VSS gf180mcu_as_sc_mcu7t3v3__tap_2
XFILLER_33_610 VDD VDD VSS VSS gf180mcu_as_sc_mcu7t3v3__fill_2
X_4930_ VDD VDD VSS VSS _4930_/B _5920_/A _4932_/B gf180mcu_as_sc_mcu7t3v3__and2_2
XFILLER_166_1151 VDD VDD VSS VSS gf180mcu_as_sc_mcu7t3v3__fillcap_4
XFILLER_166_1173 VDD VDD VSS VSS gf180mcu_as_sc_mcu7t3v3__fillcap_16
X_4861_ VDD VDD VSS VSS _6515_/Q _4861_/B _4861_/C _4861_/D _4862_/D gf180mcu_as_sc_mcu7t3v3__ao22_2
X_3812_ VDD VDD VSS VSS _6031_/Q _3933_/B _4039_/B _3933_/D _6031_/D gf180mcu_as_sc_mcu7t3v3__ao22_2
XANTENNA_16 VDD VDD VSS VSS _4798_/B gf180mcu_as_sc_mcu7t3v3__diode_2
XANTENNA_27 VDD VDD VSS VSS _5237_/A gf180mcu_as_sc_mcu7t3v3__diode_2
XANTENNA_38 VDD VDD VSS VSS _4707_/B gf180mcu_as_sc_mcu7t3v3__diode_2
XFILLER_165_309 VDD VDD VSS VSS gf180mcu_as_sc_mcu7t3v3__fillcap_16
XFILLER_207_1170 VDD VDD VSS VSS gf180mcu_as_sc_mcu7t3v3__fillcap_16
XFILLER_207_1192 VDD VDD VSS VSS gf180mcu_as_sc_mcu7t3v3__fillcap_16
X_4792_ VDD VDD VSS VSS _4793_/D _4840_/B _4792_/B _4792_/A gf180mcu_as_sc_mcu7t3v3__aoi21_2
XANTENNA_49 VDD VDD VSS VSS _5852_/B gf180mcu_as_sc_mcu7t3v3__diode_2
XFILLER_158_372 VDD VDD VSS VSS gf180mcu_as_sc_mcu7t3v3__fillcap_4
XPHY_EDGE_ROW_213_Left_441 VDD VSS gf180mcu_as_sc_mcu7t3v3__tap_2
X_6531_ VDD VDD VSS VSS _6531_/CLK _6531_/D _6531_/Q gf180mcu_as_sc_mcu7t3v3__dfxtp_2
X_3743_ VDD VDD VSS VSS _3743_/B _3743_/A _4030_/B gf180mcu_as_sc_mcu7t3v3__and2_2
XTAP_TAPCELL_ROW_214_2602 VDD VSS gf180mcu_as_sc_mcu7t3v3__tap_2
XFILLER_9_382 VDD VDD VSS VSS gf180mcu_as_sc_mcu7t3v3__fill_2
X_6462_ VDD VDD VSS VSS _6474_/CLK _6462_/D _6462_/Q gf180mcu_as_sc_mcu7t3v3__dfxtp_2
X_3674_ VDD VDD VSS VSS _3808_/B _5685_/A _3675_/D gf180mcu_as_sc_mcu7t3v3__and2_2
X_6393_ VDD VDD VSS VSS clkload3/A _6393_/D _6393_/Q gf180mcu_as_sc_mcu7t3v3__dfxtp_2
X_5413_ VDD VDD VSS VSS _5413_/B _5506_/A _6418_/D gf180mcu_as_sc_mcu7t3v3__and2_2
XFILLER_173_1100 VDD VDD VSS VSS gf180mcu_as_sc_mcu7t3v3__fillcap_16
X_5344_ VDD VDD VSS VSS _5345_/C _5344_/B _5344_/A gf180mcu_as_sc_mcu7t3v3__nand2_2
XFILLER_138_1242 VDD VDD VSS VSS gf180mcu_as_sc_mcu7t3v3__fill_1
XFILLER_173_1122 VDD VDD VSS VSS gf180mcu_as_sc_mcu7t3v3__fillcap_16
X_5275_ VDD VDD VSS VSS _5917_/A _5275_/B _5275_/C _5275_/Y _5957_/C gf180mcu_as_sc_mcu7t3v3__aoi211_2
X_4226_ VDD VDD VSS VSS _6720_/A _4226_/B _4226_/C _4570_/B _4227_/B gf180mcu_as_sc_mcu7t3v3__ao22_2
XPHY_EDGE_ROW_222_Left_450 VDD VSS gf180mcu_as_sc_mcu7t3v3__tap_2
X_4157_ VDD VDD VSS VSS _4283_/A _4280_/D _4157_/Y gf180mcu_as_sc_mcu7t3v3__and2_2
XFILLER_210_1049 VDD VDD VSS VSS gf180mcu_as_sc_mcu7t3v3__fillcap_16
XFILLER_216_527 VDD VDD VSS VSS gf180mcu_as_sc_mcu7t3v3__fillcap_8
XFILLER_228_376 VDD VDD VSS VSS gf180mcu_as_sc_mcu7t3v3__fillcap_4
X_3108_ VDD VDD VSS VSS _6309_/Q _6308_/Q _4224_/A gf180mcu_as_sc_mcu7t3v3__or2_2
X_4088_ VDD VDD VSS VSS _4089_/S _6717_/A _6148_/Q _6148_/D gf180mcu_as_sc_mcu7t3v3__mux2_2
XTAP_TAPCELL_ROW_225_2797 VDD VSS gf180mcu_as_sc_mcu7t3v3__tap_2
XTAP_TAPCELL_ROW_225_2786 VDD VSS gf180mcu_as_sc_mcu7t3v3__tap_2
XFILLER_102_45 VDD VDD VSS VSS gf180mcu_as_sc_mcu7t3v3__fillcap_4
XFILLER_58_1210 VDD VDD VSS VSS gf180mcu_as_sc_mcu7t3v3__fill_2
X_3039_ VDD VDD VSS VSS _5003_/A _4652_/A gf180mcu_as_sc_mcu7t3v3__inv_2
XFILLER_24_643 VDD VDD VSS VSS gf180mcu_as_sc_mcu7t3v3__fill_1
XFILLER_145_1235 VDD VDD VSS VSS gf180mcu_as_sc_mcu7t3v3__fillcap_16
XFILLER_19_1238 VDD VDD VSS VSS gf180mcu_as_sc_mcu7t3v3__fill_2
XFILLER_62_49 VDD VDD VSS VSS gf180mcu_as_sc_mcu7t3v3__fill_2
XTAP_TAPCELL_ROW_34_2_2899 VDD VSS gf180mcu_as_sc_mcu7t3v3__tap_2
XFILLER_178_49 VDD VDD VSS VSS gf180mcu_as_sc_mcu7t3v3__fill_2
XFILLER_200_939 VDD VDD VSS VSS gf180mcu_as_sc_mcu7t3v3__fillcap_4
XPHY_EDGE_ROW_104_1_Right_676 VDD VSS gf180mcu_as_sc_mcu7t3v3__tap_2
XPHY_EDGE_ROW_80_2_Right_917 VDD VSS gf180mcu_as_sc_mcu7t3v3__tap_2
XFILLER_178_1011 VDD VDD VSS VSS gf180mcu_as_sc_mcu7t3v3__fillcap_4
XFILLER_178_1033 VDD VDD VSS VSS gf180mcu_as_sc_mcu7t3v3__fillcap_16
XFILLER_194_37 VDD VDD VSS VSS gf180mcu_as_sc_mcu7t3v3__fillcap_16
XFILLER_152_548 VDD VDD VSS VSS gf180mcu_as_sc_mcu7t3v3__fill_2
XFILLER_219_1030 VDD VDD VSS VSS gf180mcu_as_sc_mcu7t3v3__fillcap_16
XFILLER_219_1052 VDD VDD VSS VSS gf180mcu_as_sc_mcu7t3v3__fillcap_16
XFILLER_65_1214 VDD VDD VSS VSS gf180mcu_as_sc_mcu7t3v3__fill_2
XFILLER_4_1049 VDD VDD VSS VSS gf180mcu_as_sc_mcu7t3v3__fillcap_16
XTAP_TAPCELL_ROW_9_1180 VDD VSS gf180mcu_as_sc_mcu7t3v3__tap_2
XPHY_EDGE_ROW_126_3_Left_831 VDD VSS gf180mcu_as_sc_mcu7t3v3__tap_2
XTAP_TAPCELL_ROW_5_1099 VDD VSS gf180mcu_as_sc_mcu7t3v3__tap_2
XFILLER_15_632 VDD VDD VSS VSS gf180mcu_as_sc_mcu7t3v3__fillcap_8
XFILLER_226_1012 VDD VDD VSS VSS gf180mcu_as_sc_mcu7t3v3__fill_2
XPHY_EDGE_ROW_99_3_Right_179 VDD VSS gf180mcu_as_sc_mcu7t3v3__tap_2
XFILLER_159_136 VDD VDD VSS VSS gf180mcu_as_sc_mcu7t3v3__fillcap_4
XFILLER_159_158 VDD VDD VSS VSS gf180mcu_as_sc_mcu7t3v3__fillcap_16
XFILLER_30_624 VDD VDD VSS VSS gf180mcu_as_sc_mcu7t3v3__fill_2
XFILLER_10_370 VDD VDD VSS VSS gf180mcu_as_sc_mcu7t3v3__fill_1
XFILLER_7_842 VDD VDD VSS VSS gf180mcu_as_sc_mcu7t3v3__fillcap_16
Xinput14 VDD VDD VSS VSS boot_addr[6] _3091_/A gf180mcu_as_sc_mcu7t3v3__buff_12
Xinput25 VDD VDD VSS VSS boot_data[7] _3363_/A gf180mcu_as_sc_mcu7t3v3__buff_12
Xinput36 VDD VDD VSS VSS dft_addr[7] _3291_/A gf180mcu_as_sc_mcu7t3v3__buff_12
XTAP_TAPCELL_ROW_44_3_2915 VDD VSS gf180mcu_as_sc_mcu7t3v3__tap_2
XFILLER_183_684 VDD VDD VSS VSS gf180mcu_as_sc_mcu7t3v3__fillcap_4
Xinput47 VDD VDD VSS VSS dft_wdata[6] _3356_/B gf180mcu_as_sc_mcu7t3v3__buff_12
Xinput58 VDD VDD VSS VSS east_in[17] wire958/A gf180mcu_as_sc_mcu7t3v3__buff_12
Xinput69 VDD VDD VSS VSS east_in[27] _5896_/A gf180mcu_as_sc_mcu7t3v3__buff_12
XFILLER_182_161 VDD VDD VSS VSS gf180mcu_as_sc_mcu7t3v3__fill_1
XTAP_TAPCELL_ROW_188_2122 VDD VSS gf180mcu_as_sc_mcu7t3v3__tap_2
XFILLER_184_70 VDD VDD VSS VSS gf180mcu_as_sc_mcu7t3v3__fillcap_8
X_3390_ VDD VDD VSS VSS _3397_/C _4106_/D _3390_/A gf180mcu_as_sc_mcu7t3v3__nor2b_2
XTAP_TAPCELL_ROW_188_2133 VDD VSS gf180mcu_as_sc_mcu7t3v3__tap_2
XTAP_TAPCELL_ROW_149_1405 VDD VSS gf180mcu_as_sc_mcu7t3v3__tap_2
XTAP_TAPCELL_ROW_149_1416 VDD VSS gf180mcu_as_sc_mcu7t3v3__tap_2
XTAP_TAPCELL_ROW_149_1427 VDD VSS gf180mcu_as_sc_mcu7t3v3__tap_2
X_5060_ VDD VDD VSS VSS _5217_/S _5727_/A _5060_/A _5061_/C gf180mcu_as_sc_mcu7t3v3__mux2_2
XTAP_TAPCELL_ROW_166_1730 VDD VSS gf180mcu_as_sc_mcu7t3v3__tap_2
X_4011_ VDD VDD VSS VSS _4057_/B _4012_/B _4012_/C _6099_/Q _6099_/D gf180mcu_as_sc_mcu7t3v3__ao22_2
XTAP_TAPCELL_ROW_207_2461 VDD VSS gf180mcu_as_sc_mcu7t3v3__tap_2
XPHY_EDGE_ROW_58_3_Left_763 VDD VSS gf180mcu_as_sc_mcu7t3v3__tap_2
XTAP_TAPCELL_ROW_162_1649 VDD VSS gf180mcu_as_sc_mcu7t3v3__tap_2
XTAP_TAPCELL_ROW_207_2472 VDD VSS gf180mcu_as_sc_mcu7t3v3__tap_2
XFILLER_203_88 VDD VDD VSS VSS gf180mcu_as_sc_mcu7t3v3__fill_1
XPHY_EDGE_ROW_9_Left_238 VDD VSS gf180mcu_as_sc_mcu7t3v3__tap_2
X_5962_ VDD VDD VSS VSS _5963_/B _5963_/A _5971_/A gf180mcu_as_sc_mcu7t3v3__or2_2
XFILLER_197_209 VDD VDD VSS VSS gf180mcu_as_sc_mcu7t3v3__fill_1
XFILLER_209_1232 VDD VDD VSS VSS gf180mcu_as_sc_mcu7t3v3__fill_2
X_4913_ VDD VDD VSS VSS _5907_/A _4955_/B _4955_/C _5905_/A _4919_/C gf180mcu_as_sc_mcu7t3v3__ao22_2
XPHY_EDGE_ROW_117_2_Left_558 VDD VSS gf180mcu_as_sc_mcu7t3v3__tap_2
X_5893_ VDD VDD VSS VSS _5893_/B _5893_/A _6475_/D gf180mcu_as_sc_mcu7t3v3__and2_2
XTAP_TAPCELL_ROW_220_2694 VDD VSS gf180mcu_as_sc_mcu7t3v3__tap_2
XFILLER_194_916 VDD VDD VSS VSS gf180mcu_as_sc_mcu7t3v3__fillcap_16
X_4844_ VDD VDD VSS VSS _4844_/S _4844_/B _5844_/A _4845_/B gf180mcu_as_sc_mcu7t3v3__mux2_2
X_4775_ VDD VDD VSS VSS _4841_/B _6506_/Q _4776_/D gf180mcu_as_sc_mcu7t3v3__and2_2
XFILLER_14_1135 VDD VDD VSS VSS gf180mcu_as_sc_mcu7t3v3__fillcap_16
XFILLER_14_1157 VDD VDD VSS VSS gf180mcu_as_sc_mcu7t3v3__fillcap_16
X_6514_ VDD VDD VSS VSS _6518_/CLK _6514_/D _6514_/Q gf180mcu_as_sc_mcu7t3v3__dfxtp_2
X_3726_ VDD VDD VSS VSS _6500_/Q _3868_/B _3868_/C _5732_/B _3728_/C gf180mcu_as_sc_mcu7t3v3__ao22_2
XFILLER_174_662 VDD VDD VSS VSS gf180mcu_as_sc_mcu7t3v3__fill_2
XFILLER_228_74 VDD VDD VSS VSS gf180mcu_as_sc_mcu7t3v3__fill_2
X_6445_ VDD VDD VSS VSS _6448_/CLK _6445_/D _6445_/Q gf180mcu_as_sc_mcu7t3v3__dfxtp_2
X_3657_ VDD VDD VSS VSS _3657_/Y _3905_/C _3905_/B gf180mcu_as_sc_mcu7t3v3__nor2_2
X_6376_ VDD VDD VSS VSS _6376_/CLK _6376_/D _6376_/Q gf180mcu_as_sc_mcu7t3v3__dfxtp_2
X_3588_ VDD VDD VSS VSS _3595_/A _4272_/A _6523_/Q gf180mcu_as_sc_mcu7t3v3__nand2b_2
X_5327_ VDD VDD VSS VSS _5328_/C _5327_/C _5327_/B _5327_/A gf180mcu_as_sc_mcu7t3v3__aoi21_2
XTAP_TAPCELL_ROW_227_2826 VDD VSS gf180mcu_as_sc_mcu7t3v3__tap_2
XFILLER_151_1250 VDD VDD VSS VSS gf180mcu_as_sc_mcu7t3v3__fillcap_4
X_5258_ VDD VDD VSS VSS _5267_/S _5901_/A _5258_/A _5259_/B gf180mcu_as_sc_mcu7t3v3__mux2_2
X_5189_ VDD VDD VSS VSS _5842_/A _5189_/B _5189_/C _5189_/D _5190_/A gf180mcu_as_sc_mcu7t3v3__ao211_2
X_4209_ VDD VDD VSS VSS _4349_/S _6072_/Q _6101_/Q _4210_/B gf180mcu_as_sc_mcu7t3v3__mux2_2
XFILLER_112_1245 VDD VDD VSS VSS gf180mcu_as_sc_mcu7t3v3__fillcap_16
XFILLER_16_407 VDD VDD VSS VSS gf180mcu_as_sc_mcu7t3v3__fill_1
XFILLER_56_598 VDD VDD VSS VSS gf180mcu_as_sc_mcu7t3v3__fill_2
XFILLER_12_613 VDD VDD VSS VSS gf180mcu_as_sc_mcu7t3v3__fill_1
XFILLER_184_1081 VDD VDD VSS VSS gf180mcu_as_sc_mcu7t3v3__fillcap_4
XFILLER_189_59 VDD VDD VSS VSS gf180mcu_as_sc_mcu7t3v3__fillcap_4
XFILLER_197_732 VDD VDD VSS VSS gf180mcu_as_sc_mcu7t3v3__fillcap_4
XFILLER_169_456 VDD VDD VSS VSS gf180mcu_as_sc_mcu7t3v3__fill_1
XFILLER_196_220 VDD VDD VSS VSS gf180mcu_as_sc_mcu7t3v3__fillcap_4
XFILLER_200_703 VDD VDD VSS VSS gf180mcu_as_sc_mcu7t3v3__fill_1
XFILLER_169_489 VDD VDD VSS VSS gf180mcu_as_sc_mcu7t3v3__fill_1
XFILLER_185_938 VDD VDD VSS VSS gf180mcu_as_sc_mcu7t3v3__fill_1
XPHY_EDGE_ROW_105_1_Right_677 VDD VSS gf180mcu_as_sc_mcu7t3v3__tap_2
XPHY_EDGE_ROW_81_2_Right_918 VDD VSS gf180mcu_as_sc_mcu7t3v3__tap_2
XFILLER_156_139 VDD VDD VSS VSS gf180mcu_as_sc_mcu7t3v3__fillcap_16
XFILLER_184_437 VDD VDD VSS VSS gf180mcu_as_sc_mcu7t3v3__fillcap_8
XFILLER_138_30 VDD VDD VSS VSS gf180mcu_as_sc_mcu7t3v3__fillcap_4
XFILLER_165_651 VDD VDD VSS VSS gf180mcu_as_sc_mcu7t3v3__fill_1
XFILLER_193_982 VDD VDD VSS VSS gf180mcu_as_sc_mcu7t3v3__fillcap_16
XFILLER_153_846 VDD VDD VSS VSS gf180mcu_as_sc_mcu7t3v3__fill_1
XFILLER_98_45 VDD VDD VSS VSS gf180mcu_as_sc_mcu7t3v3__fillcap_4
XFILLER_191_1030 VDD VDD VSS VSS gf180mcu_as_sc_mcu7t3v3__fillcap_16
XFILLER_191_1052 VDD VDD VSS VSS gf180mcu_as_sc_mcu7t3v3__fillcap_16
XTAP_TAPCELL_ROW_183_2041 VDD VSS gf180mcu_as_sc_mcu7t3v3__tap_2
XTAP_TAPCELL_ROW_183_2030 VDD VSS gf180mcu_as_sc_mcu7t3v3__tap_2
XFILLER_219_151 VDD VDD VSS VSS gf180mcu_as_sc_mcu7t3v3__fill_2
XTAP_TAPCELL_ROW_7_1139 VDD VSS gf180mcu_as_sc_mcu7t3v3__tap_2
XFILLER_208_869 VDD VDD VSS VSS gf180mcu_as_sc_mcu7t3v3__fillcap_4
XFILLER_47_598 VDD VDD VSS VSS gf180mcu_as_sc_mcu7t3v3__fill_2
XFILLER_179_209 VDD VDD VSS VSS gf180mcu_as_sc_mcu7t3v3__fill_1
XFILLER_228_1129 VDD VDD VSS VSS gf180mcu_as_sc_mcu7t3v3__fillcap_4
XFILLER_203_541 VDD VDD VSS VSS gf180mcu_as_sc_mcu7t3v3__fillcap_8
XTAP_TAPCELL_ROW_202_2380 VDD VSS gf180mcu_as_sc_mcu7t3v3__tap_2
XFILLER_15_484 VDD VDD VSS VSS gf180mcu_as_sc_mcu7t3v3__fillcap_4
XFILLER_163_1154 VDD VDD VSS VSS gf180mcu_as_sc_mcu7t3v3__fillcap_16
XFILLER_148_629 VDD VDD VSS VSS gf180mcu_as_sc_mcu7t3v3__fillcap_16
XFILLER_198_1239 VDD VDD VSS VSS gf180mcu_as_sc_mcu7t3v3__fill_1
XFILLER_204_1151 VDD VDD VSS VSS gf180mcu_as_sc_mcu7t3v3__fillcap_4
XFILLER_204_1173 VDD VDD VSS VSS gf180mcu_as_sc_mcu7t3v3__fillcap_16
X_4560_ VDD VDD VSS VSS _4561_/C _4601_/C _6306_/Q gf180mcu_as_sc_mcu7t3v3__nor2_2
XFILLER_156_695 VDD VDD VSS VSS gf180mcu_as_sc_mcu7t3v3__fillcap_8
XFILLER_183_492 VDD VDD VSS VSS gf180mcu_as_sc_mcu7t3v3__fillcap_4
XFILLER_6_171 VDD VDD VSS VSS gf180mcu_as_sc_mcu7t3v3__fillcap_4
X_4491_ VDD VDD VSS VSS _6152_/Q _4512_/S _4499_/C _6283_/Q _4492_/C gf180mcu_as_sc_mcu7t3v3__ao22_2
X_3511_ VDD VDD VSS VSS _3655_/B _5654_/B _5654_/A gf180mcu_as_sc_mcu7t3v3__nand2b_2
XFILLER_171_643 VDD VDD VSS VSS gf180mcu_as_sc_mcu7t3v3__fillcap_8
XFILLER_6_193 VDD VDD VSS VSS gf180mcu_as_sc_mcu7t3v3__fillcap_16
X_6230_ VDD VDD VSS VSS _6526_/CLK _6230_/D _6230_/Q gf180mcu_as_sc_mcu7t3v3__dfxtp_2
X_3442_ VDD VDD VSS VSS _6550_/D _3453_/B _6326_/Q _6325_/D gf180mcu_as_sc_mcu7t3v3__mux2_2
XFILLER_171_687 VDD VDD VSS VSS gf180mcu_as_sc_mcu7t3v3__fillcap_4
X_6161_ VDD VDD VSS VSS clkload8/A _6161_/D _6161_/Q gf180mcu_as_sc_mcu7t3v3__dfxtp_2
X_3373_ VDD VDD VSS VSS _4443_/B _3373_/B _4104_/B gf180mcu_as_sc_mcu7t3v3__nor2_2
XFILLER_170_1103 VDD VDD VSS VSS gf180mcu_as_sc_mcu7t3v3__fillcap_16
X_5112_ VDD VDD VSS VSS _5112_/D _5776_/A _5222_/B _5222_/C _5113_/C gf180mcu_as_sc_mcu7t3v3__ao31_2
XTAP_TAPCELL_ROW_209_2512 VDD VSS gf180mcu_as_sc_mcu7t3v3__tap_2
XTAP_TAPCELL_ROW_209_2501 VDD VSS gf180mcu_as_sc_mcu7t3v3__tap_2
XFILLER_211_1100 VDD VDD VSS VSS gf180mcu_as_sc_mcu7t3v3__fillcap_16
X_6092_ VDD VDD VSS VSS _6370_/CLK _6092_/D _6092_/Q gf180mcu_as_sc_mcu7t3v3__dfxtp_2
XFILLER_211_1122 VDD VDD VSS VSS gf180mcu_as_sc_mcu7t3v3__fillcap_16
XPHY_EDGE_ROW_155_Left_383 VDD VSS gf180mcu_as_sc_mcu7t3v3__tap_2
X_5043_ VDD VDD VSS VSS _5228_/S _5712_/A _5043_/A _5044_/B gf180mcu_as_sc_mcu7t3v3__mux2_2
XTAP_TAPCELL_ROW_222_2745 VDD VSS gf180mcu_as_sc_mcu7t3v3__tap_2
XTAP_TAPCELL_ROW_222_2734 VDD VSS gf180mcu_as_sc_mcu7t3v3__tap_2
XFILLER_168_1065 VDD VDD VSS VSS gf180mcu_as_sc_mcu7t3v3__fillcap_16
XFILLER_214_839 VDD VDD VSS VSS gf180mcu_as_sc_mcu7t3v3__fill_1
XFILLER_168_1087 VDD VDD VSS VSS gf180mcu_as_sc_mcu7t3v3__fillcap_16
XFILLER_207_891 VDD VDD VSS VSS gf180mcu_as_sc_mcu7t3v3__fillcap_4
XFILLER_213_338 VDD VDD VSS VSS gf180mcu_as_sc_mcu7t3v3__fill_2
X_5945_ VDD VDD VSS VSS _5947_/C _5945_/C _5951_/D _5945_/A gf180mcu_as_sc_mcu7t3v3__aoi21b_2
XFILLER_16_1208 VDD VDD VSS VSS gf180mcu_as_sc_mcu7t3v3__fillcap_16
XFILLER_178_242 VDD VDD VSS VSS gf180mcu_as_sc_mcu7t3v3__fill_2
XFILLER_209_1084 VDD VDD VSS VSS gf180mcu_as_sc_mcu7t3v3__fillcap_16
X_5876_ VDD VDD VSS VSS _5876_/B _5956_/A _6473_/D gf180mcu_as_sc_mcu7t3v3__and2_2
XTAP_TAPCELL_ROW_179_1965 VDD VSS gf180mcu_as_sc_mcu7t3v3__tap_2
XFILLER_166_404 VDD VDD VSS VSS gf180mcu_as_sc_mcu7t3v3__fill_1
X_4827_ VDD VDD VSS VSS _4955_/C _5833_/D _4833_/C gf180mcu_as_sc_mcu7t3v3__and2_2
XFILLER_166_437 VDD VDD VSS VSS gf180mcu_as_sc_mcu7t3v3__fillcap_16
XFILLER_178_297 VDD VDD VSS VSS gf180mcu_as_sc_mcu7t3v3__fill_2
XFILLER_193_212 VDD VDD VSS VSS gf180mcu_as_sc_mcu7t3v3__fillcap_16
XFILLER_193_245 VDD VDD VSS VSS gf180mcu_as_sc_mcu7t3v3__fillcap_4
XPHY_EDGE_ROW_164_Left_392 VDD VSS gf180mcu_as_sc_mcu7t3v3__tap_2
XPHY_EDGE_ROW_96_1_Left_324 VDD VSS gf180mcu_as_sc_mcu7t3v3__tap_2
XFILLER_181_407 VDD VDD VSS VSS gf180mcu_as_sc_mcu7t3v3__fill_2
X_4758_ VDD VDD VSS VSS _5768_/A _4871_/B _4871_/C _5768_/D _4759_/D gf180mcu_as_sc_mcu7t3v3__ao22_2
XFILLER_174_492 VDD VDD VSS VSS gf180mcu_as_sc_mcu7t3v3__fill_1
X_4689_ VDD VDD VSS VSS _4933_/B _4875_/B _4689_/A gf180mcu_as_sc_mcu7t3v3__nand2_2
X_3709_ VDD VDD VSS VSS _3806_/S _5718_/A _3710_/D gf180mcu_as_sc_mcu7t3v3__and2_2
XFILLER_161_120 VDD VDD VSS VSS gf180mcu_as_sc_mcu7t3v3__fillcap_16
XFILLER_161_142 VDD VDD VSS VSS gf180mcu_as_sc_mcu7t3v3__fillcap_16
XFILLER_175_1014 VDD VDD VSS VSS gf180mcu_as_sc_mcu7t3v3__fillcap_16
X_6428_ VDD VDD VSS VSS _6437_/CLK _6428_/D _6428_/Q gf180mcu_as_sc_mcu7t3v3__dfxtp_2
XFILLER_162_687 VDD VDD VSS VSS gf180mcu_as_sc_mcu7t3v3__fill_2
XFILLER_216_1011 VDD VDD VSS VSS gf180mcu_as_sc_mcu7t3v3__fillcap_4
XFILLER_0_314 VDD VDD VSS VSS gf180mcu_as_sc_mcu7t3v3__fill_1
XFILLER_191_27 VDD VDD VSS VSS gf180mcu_as_sc_mcu7t3v3__fillcap_16
XFILLER_1_837 VDD VDD VSS VSS gf180mcu_as_sc_mcu7t3v3__fill_2
XFILLER_216_1033 VDD VDD VSS VSS gf180mcu_as_sc_mcu7t3v3__fillcap_16
XFILLER_68_37 VDD VDD VSS VSS gf180mcu_as_sc_mcu7t3v3__fillcap_8
X_6359_ VDD VDD VSS VSS _6368_/CLK _6359_/D _6359_/Q gf180mcu_as_sc_mcu7t3v3__dfxtp_2
Xinput204 VDD VDD VSS VSS se_in[18] _5826_/A gf180mcu_as_sc_mcu7t3v3__buff_12
Xinput215 VDD VDD VSS VSS se_in[28] _5908_/A gf180mcu_as_sc_mcu7t3v3__buff_12
Xinput226 VDD VDD VSS VSS se_in[5] _5720_/A gf180mcu_as_sc_mcu7t3v3__buff_12
XFILLER_5_1100 VDD VDD VSS VSS gf180mcu_as_sc_mcu7t3v3__fillcap_16
XFILLER_5_1122 VDD VDD VSS VSS gf180mcu_as_sc_mcu7t3v3__fillcap_16
Xinput237 VDD VDD VSS VSS south_in[15] _5799_/A gf180mcu_as_sc_mcu7t3v3__buff_12
Xinput248 VDD VDD VSS VSS south_in[25] _5879_/A gf180mcu_as_sc_mcu7t3v3__buff_12
Xinput259 VDD VDD VSS VSS south_in[35] _3547_/A gf180mcu_as_sc_mcu7t3v3__buff_12
XFILLER_29_598 VDD VDD VSS VSS gf180mcu_as_sc_mcu7t3v3__fill_1
XFILLER_16_248 VDD VDD VSS VSS gf180mcu_as_sc_mcu7t3v3__fillcap_4
XTAP_TAPCELL_ROW_2_1047 VDD VSS gf180mcu_as_sc_mcu7t3v3__tap_2
XTAP_TAPCELL_ROW_2_1058 VDD VSS gf180mcu_as_sc_mcu7t3v3__tap_2
XFILLER_13_944 VDD VDD VSS VSS gf180mcu_as_sc_mcu7t3v3__fillcap_16
XFILLER_169_275 VDD VDD VSS VSS gf180mcu_as_sc_mcu7t3v3__fill_1
XFILLER_197_573 VDD VDD VSS VSS gf180mcu_as_sc_mcu7t3v3__fill_2
XFILLER_8_414 VDD VDD VSS VSS gf180mcu_as_sc_mcu7t3v3__fill_2
XFILLER_200_588 VDD VDD VSS VSS gf180mcu_as_sc_mcu7t3v3__fillcap_4
XFILLER_8_469 VDD VDD VSS VSS gf180mcu_as_sc_mcu7t3v3__fillcap_4
XPHY_EDGE_ROW_106_1_Right_678 VDD VSS gf180mcu_as_sc_mcu7t3v3__tap_2
XPHY_EDGE_ROW_82_2_Right_919 VDD VSS gf180mcu_as_sc_mcu7t3v3__tap_2
XFILLER_153_632 VDD VDD VSS VSS gf180mcu_as_sc_mcu7t3v3__fillcap_16
XFILLER_158_1234 VDD VDD VSS VSS gf180mcu_as_sc_mcu7t3v3__fillcap_16
XFILLER_165_492 VDD VDD VSS VSS gf180mcu_as_sc_mcu7t3v3__fillcap_16
XFILLER_180_440 VDD VDD VSS VSS gf180mcu_as_sc_mcu7t3v3__fillcap_8
XFILLER_181_974 VDD VDD VSS VSS gf180mcu_as_sc_mcu7t3v3__fillcap_4
XFILLER_165_72 VDD VDD VSS VSS gf180mcu_as_sc_mcu7t3v3__fillcap_16
XFILLER_180_484 VDD VDD VSS VSS gf180mcu_as_sc_mcu7t3v3__fillcap_8
XFILLER_3_174 VDD VDD VSS VSS gf180mcu_as_sc_mcu7t3v3__fillcap_4
XFILLER_82_619 VDD VDD VSS VSS gf180mcu_as_sc_mcu7t3v3__fill_1
XFILLER_208_655 VDD VDD VSS VSS gf180mcu_as_sc_mcu7t3v3__fill_2
XFILLER_75_660 VDD VDD VSS VSS gf180mcu_as_sc_mcu7t3v3__fill_2
XTAP_TAPCELL_ROW_204_2420 VDD VSS gf180mcu_as_sc_mcu7t3v3__tap_2
XFILLER_222_113 VDD VDD VSS VSS gf180mcu_as_sc_mcu7t3v3__fill_1
XFILLER_90_663 VDD VDD VSS VSS gf180mcu_as_sc_mcu7t3v3__fillcap_4
X_3991_ VDD VDD VSS VSS _4008_/C _6080_/Q _3992_/C gf180mcu_as_sc_mcu7t3v3__and2_2
XTAP_TAPCELL_ROW_200_2339 VDD VSS gf180mcu_as_sc_mcu7t3v3__tap_2
XFILLER_200_23 VDD VDD VSS VSS gf180mcu_as_sc_mcu7t3v3__fillcap_8
XPHY_EDGE_ROW_68_1_Right_640 VDD VSS gf180mcu_as_sc_mcu7t3v3__tap_2
X_5730_ VDD VDD VSS VSS _6455_/D _5730_/C _5730_/B _5730_/A gf180mcu_as_sc_mcu7t3v3__aoi21b_2
XTAP_TAPCELL_ROW_196_2265 VDD VSS gf180mcu_as_sc_mcu7t3v3__tap_2
XFILLER_206_1235 VDD VDD VSS VSS gf180mcu_as_sc_mcu7t3v3__fillcap_4
XTAP_TAPCELL_ROW_196_2276 VDD VSS gf180mcu_as_sc_mcu7t3v3__tap_2
XFILLER_149_949 VDD VDD VSS VSS gf180mcu_as_sc_mcu7t3v3__fill_2
XFILLER_175_212 VDD VDD VSS VSS gf180mcu_as_sc_mcu7t3v3__fillcap_8
XFILLER_203_393 VDD VDD VSS VSS gf180mcu_as_sc_mcu7t3v3__fillcap_16
Xsram2048.u_bank1_1039 VDD VDD VSS VSS sram2048.u_bank1/WEN[5] gf180mcu_as_sc_mcu7t3v3__tiel_4
X_5661_ VDD VDD VSS VSS _5661_/A _5661_/B _5661_/C _5661_/D _5662_/B gf180mcu_as_sc_mcu7t3v3__ao211_2
XFILLER_129_640 VDD VDD VSS VSS gf180mcu_as_sc_mcu7t3v3__fill_1
XFILLER_175_267 VDD VDD VSS VSS gf180mcu_as_sc_mcu7t3v3__fill_1
XTAP_TAPCELL_ROW_157_1559 VDD VSS gf180mcu_as_sc_mcu7t3v3__tap_2
X_5592_ VDD VDD VSS VSS _5900_/A _5630_/B _5592_/C _5592_/D _5593_/B gf180mcu_as_sc_mcu7t3v3__ao211_2
X_4612_ VDD VDD VSS VSS _4982_/D _4612_/C _4979_/A _4979_/B gf180mcu_as_sc_mcu7t3v3__aoi21b_2
XFILLER_11_1116 VDD VDD VSS VSS gf180mcu_as_sc_mcu7t3v3__fillcap_4
XFILLER_11_1138 VDD VDD VSS VSS gf180mcu_as_sc_mcu7t3v3__fillcap_16
XFILLER_157_982 VDD VDD VSS VSS gf180mcu_as_sc_mcu7t3v3__fillcap_16
XFILLER_190_215 VDD VDD VSS VSS gf180mcu_as_sc_mcu7t3v3__fillcap_8
XFILLER_209_43 VDD VDD VSS VSS gf180mcu_as_sc_mcu7t3v3__fillcap_16
XTAP_TAPCELL_ROW_174_1873 VDD VSS gf180mcu_as_sc_mcu7t3v3__tap_2
X_4543_ VDD VDD VSS VSS _6161_/Q _4546_/B _4551_/C _6300_/Q _4544_/C gf180mcu_as_sc_mcu7t3v3__ao22_2
XFILLER_144_665 VDD VDD VSS VSS gf180mcu_as_sc_mcu7t3v3__fill_2
XFILLER_171_484 VDD VDD VSS VSS gf180mcu_as_sc_mcu7t3v3__fillcap_4
X_6213_ VDD VDD VSS VSS _6518_/CLK _6213_/D _6213_/Q gf180mcu_as_sc_mcu7t3v3__dfxtp_2
X_4474_ VDD VDD VSS VSS _4477_/B _4474_/B _6276_/Q _6276_/D gf180mcu_as_sc_mcu7t3v3__mux2_2
Xfanout905 VDD VDD VSS VSS _6263_/Q _4569_/D gf180mcu_as_sc_mcu7t3v3__buff_12
Xfanout916 VDD VDD VSS VSS _4398_/S _4405_/S gf180mcu_as_sc_mcu7t3v3__buff_12
X_3425_ VDD VDD VSS VSS _4539_/B _3425_/B _3425_/C _3432_/A _3426_/D gf180mcu_as_sc_mcu7t3v3__ao211_2
Xfanout927 VDD VDD VSS VSS fanout935/A _5893_/A gf180mcu_as_sc_mcu7t3v3__buff_12
Xfanout938 VDD VDD VSS VSS _5562_/A _5578_/A gf180mcu_as_sc_mcu7t3v3__buff_12
Xsram2048.u_bank0 _3295_/Y _3291_/Y wire493/Y wire514/Y wire515/Y wire494/Y _3246_/Y
+ _3227_/Y _3220_/Y hold1190/Y clkbuf_1_0__f_clk/Y wire506/Y wire507/Y wire508/Y wire509/Y
+ wire510/Y wire511/Y wire512/Y wire513/Y _3214_/Y _3371_/A _3370_/A _3369_/A _3368_/A
+ _3367_/A _3366_/A _3365_/A _3099_/A VDD VSS sram2048.u_bank0/WEN[7] sram2048.u_bank0/WEN[6]
+ sram2048.u_bank0/WEN[5] sram2048.u_bank0/WEN[4] sram2048.u_bank0/WEN[3] sram2048.u_bank0/WEN[2]
+ sram2048.u_bank0/WEN[1] sram2048.u_bank0/WEN[0] _3299_/Y gf180mcu_ocd_ip_sram__sram1024x8m8wm1
X_6144_ VDD VDD VSS VSS _6517_/CLK _6144_/D _6144_/Q gf180mcu_as_sc_mcu7t3v3__dfxtp_2
X_3356_ VDD VDD VSS VSS _3356_/A _3356_/B _3356_/C _3356_/D _3356_/Y gf180mcu_as_sc_mcu7t3v3__ao22_2
X_6075_ VDD VDD VSS VSS _6125_/CLK _6075_/D _6075_/Q gf180mcu_as_sc_mcu7t3v3__dfxtp_2
X_3287_ VDD VDD VSS VSS _4448_/B _6234_/Q _3288_/D gf180mcu_as_sc_mcu7t3v3__and2_2
X_5026_ VDD VDD VSS VSS _5026_/B _5164_/A _6379_/D gf180mcu_as_sc_mcu7t3v3__and2_2
XFILLER_22_1245 VDD VDD VSS VSS gf180mcu_as_sc_mcu7t3v3__fillcap_16
XFILLER_0_1041 VDD VDD VSS VSS gf180mcu_as_sc_mcu7t3v3__fillcap_4
XPHY_EDGE_ROW_172_Left_400 VDD VSS gf180mcu_as_sc_mcu7t3v3__tap_2
X_5928_ VDD VDD VSS VSS _5952_/B _5928_/A _5932_/C gf180mcu_as_sc_mcu7t3v3__and2_2
XFILLER_110_45 VDD VDD VSS VSS gf180mcu_as_sc_mcu7t3v3__fillcap_4
XFILLER_10_925 VDD VDD VSS VSS gf180mcu_as_sc_mcu7t3v3__fillcap_16
XFILLER_167_757 VDD VDD VSS VSS gf180mcu_as_sc_mcu7t3v3__fill_2
XFILLER_16_1038 VDD VDD VSS VSS gf180mcu_as_sc_mcu7t3v3__fillcap_16
XFILLER_181_1084 VDD VDD VSS VSS gf180mcu_as_sc_mcu7t3v3__fillcap_16
XFILLER_70_49 VDD VDD VSS VSS gf180mcu_as_sc_mcu7t3v3__fill_2
X_5859_ VDD VDD VSS VSS _5859_/S _5859_/B _5859_/A _5860_/B gf180mcu_as_sc_mcu7t3v3__mux2_2
XFILLER_10_947 VDD VDD VSS VSS gf180mcu_as_sc_mcu7t3v3__fillcap_16
XFILLER_186_27 VDD VDD VSS VSS gf180mcu_as_sc_mcu7t3v3__fillcap_8
XFILLER_6_918 VDD VDD VSS VSS gf180mcu_as_sc_mcu7t3v3__fillcap_16
XFILLER_119_43 VDD VDD VSS VSS gf180mcu_as_sc_mcu7t3v3__fillcap_8
XFILLER_222_1081 VDD VDD VSS VSS gf180mcu_as_sc_mcu7t3v3__fillcap_4
XFILLER_190_793 VDD VDD VSS VSS gf180mcu_as_sc_mcu7t3v3__fill_2
XPHY_EDGE_ROW_135_3_Left_840 VDD VSS gf180mcu_as_sc_mcu7t3v3__tap_2
XFILLER_0_144 VDD VDD VSS VSS gf180mcu_as_sc_mcu7t3v3__fill_1
XFILLER_49_605 VDD VDD VSS VSS gf180mcu_as_sc_mcu7t3v3__fillcap_4
XFILLER_153_1186 VDD VDD VSS VSS gf180mcu_as_sc_mcu7t3v3__fillcap_4
XFILLER_192_2 VDD VDD VSS VSS gf180mcu_as_sc_mcu7t3v3__fillcap_8
XTAP_TAPCELL_ROW_136_1_1389 VDD VSS gf180mcu_as_sc_mcu7t3v3__tap_2
XFILLER_188_1205 VDD VDD VSS VSS gf180mcu_as_sc_mcu7t3v3__fillcap_16
XFILLER_188_1227 VDD VDD VSS VSS gf180mcu_as_sc_mcu7t3v3__fillcap_16
XFILLER_64_619 VDD VDD VSS VSS gf180mcu_as_sc_mcu7t3v3__fillcap_8
XFILLER_205_614 VDD VDD VSS VSS gf180mcu_as_sc_mcu7t3v3__fillcap_16
XFILLER_189_348 VDD VDD VSS VSS gf180mcu_as_sc_mcu7t3v3__fill_2
XFILLER_158_713 VDD VDD VSS VSS gf180mcu_as_sc_mcu7t3v3__fillcap_16
XFILLER_164_1260 VDD VDD VSS VSS gf180mcu_as_sc_mcu7t3v3__fillcap_4
XFILLER_13_774 VDD VDD VSS VSS gf180mcu_as_sc_mcu7t3v3__fill_1
XFILLER_13_785 VDD VDD VSS VSS gf180mcu_as_sc_mcu7t3v3__fillcap_16
XFILLER_157_212 VDD VDD VSS VSS gf180mcu_as_sc_mcu7t3v3__fillcap_16
XFILLER_160_1135 VDD VDD VSS VSS gf180mcu_as_sc_mcu7t3v3__fillcap_16
XFILLER_185_521 VDD VDD VSS VSS gf180mcu_as_sc_mcu7t3v3__fill_2
XFILLER_12_295 VDD VDD VSS VSS gf180mcu_as_sc_mcu7t3v3__fillcap_16
XFILLER_160_1157 VDD VDD VSS VSS gf180mcu_as_sc_mcu7t3v3__fillcap_16
XFILLER_173_716 VDD VDD VSS VSS gf180mcu_as_sc_mcu7t3v3__fill_1
XFILLER_9_756 VDD VDD VSS VSS gf180mcu_as_sc_mcu7t3v3__fill_2
XFILLER_126_610 VDD VDD VSS VSS gf180mcu_as_sc_mcu7t3v3__fillcap_16
XFILLER_173_749 VDD VDD VSS VSS gf180mcu_as_sc_mcu7t3v3__fill_2
XFILLER_201_1154 VDD VDD VSS VSS gf180mcu_as_sc_mcu7t3v3__fillcap_16
XPHY_EDGE_ROW_107_1_Right_679 VDD VSS gf180mcu_as_sc_mcu7t3v3__tap_2
XTAP_TAPCELL_ROW_191_2184 VDD VSS gf180mcu_as_sc_mcu7t3v3__tap_2
XTAP_TAPCELL_ROW_191_2173 VDD VSS gf180mcu_as_sc_mcu7t3v3__tap_2
XPHY_EDGE_ROW_67_3_Left_772 VDD VSS gf180mcu_as_sc_mcu7t3v3__tap_2
XFILLER_153_473 VDD VDD VSS VSS gf180mcu_as_sc_mcu7t3v3__fillcap_16
XTAP_TAPCELL_ROW_152_1478 VDD VSS gf180mcu_as_sc_mcu7t3v3__tap_2
XFILLER_180_281 VDD VDD VSS VSS gf180mcu_as_sc_mcu7t3v3__fillcap_4
XFILLER_4_494 VDD VDD VSS VSS gf180mcu_as_sc_mcu7t3v3__fillcap_4
XFILLER_5_88 VDD VDD VSS VSS gf180mcu_as_sc_mcu7t3v3__fillcap_16
XFILLER_84_1261 VDD VDD VSS VSS gf180mcu_as_sc_mcu7t3v3__fillcap_4
X_4190_ VDD VDD VSS VSS _4335_/S _6128_/Q _6041_/Q _4192_/A gf180mcu_as_sc_mcu7t3v3__mux2_2
X_3210_ VDD VDD VSS VSS _4511_/A _6135_/Q _4448_/B _3211_/B gf180mcu_as_sc_mcu7t3v3__nor3_2
XFILLER_132_1226 VDD VDD VSS VSS gf180mcu_as_sc_mcu7t3v3__fillcap_16
XFILLER_171_1264 VDD VDD VSS VSS gf180mcu_as_sc_mcu7t3v3__fill_1
XPHY_EDGE_ROW_126_2_Left_567 VDD VSS gf180mcu_as_sc_mcu7t3v3__tap_2
X_3141_ VDD VDD VSS VSS _3392_/B _3163_/B _3141_/C _3163_/D gf180mcu_as_sc_mcu7t3v3__nor3_2
XTAP_TAPCELL_ROW_15_1290 VDD VSS gf180mcu_as_sc_mcu7t3v3__tap_2
X_3072_ VDD VDD VSS VSS _5114_/A _5774_/B gf180mcu_as_sc_mcu7t3v3__inv_2
XPHY_EDGE_ROW_63_2_Left_504 VDD VSS gf180mcu_as_sc_mcu7t3v3__tap_2
XTAP_TAPCELL_ROW_198_2305 VDD VSS gf180mcu_as_sc_mcu7t3v3__tap_2
XFILLER_223_422 VDD VDD VSS VSS gf180mcu_as_sc_mcu7t3v3__fillcap_8
XFILLER_91_1210 VDD VDD VSS VSS gf180mcu_as_sc_mcu7t3v3__fill_1
XFILLER_165_1068 VDD VDD VSS VSS gf180mcu_as_sc_mcu7t3v3__fillcap_16
XFILLER_211_88 VDD VDD VSS VSS gf180mcu_as_sc_mcu7t3v3__fillcap_4
XTAP_TAPCELL_ROW_176_1902 VDD VSS gf180mcu_as_sc_mcu7t3v3__tap_2
XTAP_TAPCELL_ROW_176_1913 VDD VSS gf180mcu_as_sc_mcu7t3v3__tap_2
X_3974_ VDD VDD VSS VSS _6068_/Q _3974_/B _4054_/A _3974_/D _6068_/D gf180mcu_as_sc_mcu7t3v3__ao22_2
XFILLER_206_1065 VDD VDD VSS VSS gf180mcu_as_sc_mcu7t3v3__fillcap_16
XPHY_EDGE_ROW_69_1_Right_641 VDD VSS gf180mcu_as_sc_mcu7t3v3__tap_2
X_5713_ VDD VDD VSS VSS _5713_/B _5796_/A _6453_/D gf180mcu_as_sc_mcu7t3v3__and2_2
XFILLER_164_705 VDD VDD VSS VSS gf180mcu_as_sc_mcu7t3v3__fill_2
XFILLER_206_1087 VDD VDD VSS VSS gf180mcu_as_sc_mcu7t3v3__fillcap_16
X_5644_ VDD VDD VSS VSS _6448_/D _5957_/C _5644_/B _5644_/A gf180mcu_as_sc_mcu7t3v3__aoi21b_2
XTAP_TAPCELL_ROW_217_2655 VDD VSS gf180mcu_as_sc_mcu7t3v3__tap_2
XTAP_TAPCELL_ROW_217_2644 VDD VSS gf180mcu_as_sc_mcu7t3v3__tap_2
X_5575_ VDD VDD VSS VSS _5881_/A _5585_/B _5575_/C _5575_/D _5577_/C gf180mcu_as_sc_mcu7t3v3__ao211_2
X_4526_ VDD VDD VSS VSS _4538_/S _4526_/B _6721_/A _4527_/A gf180mcu_as_sc_mcu7t3v3__mux2_2
XFILLER_160_955 VDD VDD VSS VSS gf180mcu_as_sc_mcu7t3v3__fillcap_4
XFILLER_172_1017 VDD VDD VSS VSS gf180mcu_as_sc_mcu7t3v3__fillcap_16
X_4457_ VDD VDD VSS VSS _4520_/S _6142_/Q _6267_/Q _6267_/D gf180mcu_as_sc_mcu7t3v3__mux2_2
XFILLER_132_657 VDD VDD VSS VSS gf180mcu_as_sc_mcu7t3v3__fillcap_8
XFILLER_160_977 VDD VDD VSS VSS gf180mcu_as_sc_mcu7t3v3__fillcap_16
XPHY_EDGE_ROW_58_2_Left_499 VDD VSS gf180mcu_as_sc_mcu7t3v3__tap_2
Xfanout702 VDD VDD VSS VSS _3871_/B _3889_/B gf180mcu_as_sc_mcu7t3v3__buff_12
Xfanout713 VDD VDD VSS VSS _3161_/Y _4140_/S gf180mcu_as_sc_mcu7t3v3__buff_12
Xfanout724 VDD VDD VSS VSS _5651_/Y _5839_/D gf180mcu_as_sc_mcu7t3v3__buff_12
X_3408_ VDD VDD VSS VSS _3412_/C _4444_/A _4610_/B gf180mcu_as_sc_mcu7t3v3__nor2_2
XFILLER_213_1014 VDD VDD VSS VSS gf180mcu_as_sc_mcu7t3v3__fillcap_16
Xfanout735 VDD VDD VSS VSS _5533_/B _5549_/C gf180mcu_as_sc_mcu7t3v3__buff_12
Xfanout746 VDD VDD VSS VSS _3657_/Y _3852_/B gf180mcu_as_sc_mcu7t3v3__buff_12
Xfanout757 VDD VDD VSS VSS _5646_/Y _5838_/S gf180mcu_as_sc_mcu7t3v3__buff_12
X_6127_ VDD VDD VSS VSS _6370_/CLK _6127_/D _6127_/Q gf180mcu_as_sc_mcu7t3v3__dfxtp_2
X_4388_ VDD VDD VSS VSS _6223_/D _4388_/B _4388_/A gf180mcu_as_sc_mcu7t3v3__nand2_2
Xfanout768 VDD VDD VSS VSS _5184_/B _5203_/C gf180mcu_as_sc_mcu7t3v3__buff_12
Xfanout779 VDD VDD VSS VSS _5234_/B _5233_/C gf180mcu_as_sc_mcu7t3v3__buff_12
X_3339_ VDD VDD VSS VSS _3340_/D _3356_/A _3355_/B _3339_/A gf180mcu_as_sc_mcu7t3v3__aoi21b_2
XFILLER_2_1103 VDD VDD VSS VSS gf180mcu_as_sc_mcu7t3v3__fillcap_16
XFILLER_65_49 VDD VDD VSS VSS gf180mcu_as_sc_mcu7t3v3__fill_2
X_6058_ VDD VDD VSS VSS _6371_/CLK _6058_/D _6058_/Q gf180mcu_as_sc_mcu7t3v3__dfxtp_2
XFILLER_199_602 VDD VDD VSS VSS gf180mcu_as_sc_mcu7t3v3__fillcap_16
X_5009_ VDD VDD VSS VSS _5010_/D _5683_/A _5138_/B _5141_/B gf180mcu_as_sc_mcu7t3v3__ao21_2
XFILLER_148_1233 VDD VDD VSS VSS gf180mcu_as_sc_mcu7t3v3__fillcap_8
XFILLER_164_6 VDD VDD VSS VSS gf180mcu_as_sc_mcu7t3v3__fillcap_8
XFILLER_14_527 VDD VDD VSS VSS gf180mcu_as_sc_mcu7t3v3__fillcap_4
XFILLER_167_532 VDD VDD VSS VSS gf180mcu_as_sc_mcu7t3v3__fill_1
XFILLER_197_59 VDD VDD VSS VSS gf180mcu_as_sc_mcu7t3v3__fillcap_8
XFILLER_10_722 VDD VDD VSS VSS gf180mcu_as_sc_mcu7t3v3__fill_1
XFILLER_10_744 VDD VDD VSS VSS gf180mcu_as_sc_mcu7t3v3__fillcap_16
XFILLER_155_738 VDD VDD VSS VSS gf180mcu_as_sc_mcu7t3v3__fill_1
XFILLER_182_524 VDD VDD VSS VSS gf180mcu_as_sc_mcu7t3v3__fill_1
XFILLER_194_384 VDD VDD VSS VSS gf180mcu_as_sc_mcu7t3v3__fill_1
XFILLER_194_395 VDD VDD VSS VSS gf180mcu_as_sc_mcu7t3v3__fillcap_4
XFILLER_6_737 VDD VDD VSS VSS gf180mcu_as_sc_mcu7t3v3__fillcap_4
XFILLER_108_665 VDD VDD VSS VSS gf180mcu_as_sc_mcu7t3v3__fill_2
XFILLER_123_613 VDD VDD VSS VSS gf180mcu_as_sc_mcu7t3v3__fill_1
XFILLER_146_30 VDD VDD VSS VSS gf180mcu_as_sc_mcu7t3v3__fillcap_4
XFILLER_68_1245 VDD VDD VSS VSS gf180mcu_as_sc_mcu7t3v3__fillcap_16
XFILLER_155_1226 VDD VDD VSS VSS gf180mcu_as_sc_mcu7t3v3__fill_1
XFILLER_190_590 VDD VDD VSS VSS gf180mcu_as_sc_mcu7t3v3__fillcap_4
XFILLER_151_977 VDD VDD VSS VSS gf180mcu_as_sc_mcu7t3v3__fill_2
XPHY_EDGE_ROW_111_1_Left_339 VDD VSS gf180mcu_as_sc_mcu7t3v3__tap_2
XFILLER_7_1014 VDD VDD VSS VSS gf180mcu_as_sc_mcu7t3v3__fillcap_16
Xmesh_tile_1101 VDD VDD VSS VSS nw_out[24] gf180mcu_as_sc_mcu7t3v3__tiel_4
XFILLER_225_709 VDD VDD VSS VSS gf180mcu_as_sc_mcu7t3v3__fill_1
Xmesh_tile_1134 VDD VDD VSS VSS se_out[21] gf180mcu_as_sc_mcu7t3v3__tiel_4
Xmesh_tile_1123 VDD VDD VSS VSS se_out[10] gf180mcu_as_sc_mcu7t3v3__tiel_4
Xmesh_tile_1112 VDD VDD VSS VSS nw_out[35] gf180mcu_as_sc_mcu7t3v3__tiel_4
Xmesh_tile_1178 VDD VDD VSS VSS sw_out[29] gf180mcu_as_sc_mcu7t3v3__tiel_4
Xmesh_tile_1167 VDD VDD VSS VSS sw_out[18] gf180mcu_as_sc_mcu7t3v3__tiel_4
Xmesh_tile_1156 VDD VDD VSS VSS sw_out[7] gf180mcu_as_sc_mcu7t3v3__tiel_4
Xmesh_tile_1145 VDD VDD VSS VSS se_out[32] gf180mcu_as_sc_mcu7t3v3__tiel_4
XFILLER_205_422 VDD VDD VSS VSS gf180mcu_as_sc_mcu7t3v3__fillcap_4
XFILLER_217_282 VDD VDD VSS VSS gf180mcu_as_sc_mcu7t3v3__fillcap_4
XFILLER_205_466 VDD VDD VSS VSS gf180mcu_as_sc_mcu7t3v3__fillcap_16
XFILLER_177_307 VDD VDD VSS VSS gf180mcu_as_sc_mcu7t3v3__fillcap_8
XFILLER_220_414 VDD VDD VSS VSS gf180mcu_as_sc_mcu7t3v3__fillcap_8
XTAP_TAPCELL_ROW_193_2213 VDD VSS gf180mcu_as_sc_mcu7t3v3__tap_2
XTAP_TAPCELL_ROW_193_2224 VDD VSS gf180mcu_as_sc_mcu7t3v3__tap_2
XFILLER_158_543 VDD VDD VSS VSS gf180mcu_as_sc_mcu7t3v3__fillcap_4
XTAP_TAPCELL_ROW_154_1507 VDD VSS gf180mcu_as_sc_mcu7t3v3__tap_2
XTAP_TAPCELL_ROW_154_1518 VDD VSS gf180mcu_as_sc_mcu7t3v3__tap_2
X_3690_ VDD VDD VSS VSS _5698_/A _3805_/B _3690_/C _3690_/D _3691_/A gf180mcu_as_sc_mcu7t3v3__ao211_2
XFILLER_199_1186 VDD VDD VSS VSS gf180mcu_as_sc_mcu7t3v3__fillcap_4
XTAP_TAPCELL_ROW_171_1821 VDD VSS gf180mcu_as_sc_mcu7t3v3__tap_2
XFILLER_154_771 VDD VDD VSS VSS gf180mcu_as_sc_mcu7t3v3__fillcap_16
X_5360_ VDD VDD VSS VSS _5567_/B _5677_/A _5368_/D gf180mcu_as_sc_mcu7t3v3__and2_2
XTAP_TAPCELL_ROW_212_2552 VDD VSS gf180mcu_as_sc_mcu7t3v3__tap_2
XFILLER_154_793 VDD VDD VSS VSS gf180mcu_as_sc_mcu7t3v3__fill_1
Xoutput349 VDD VDD VSS VSS _6424_/Q east_out[11] gf180mcu_as_sc_mcu7t3v3__buff_12
X_5291_ VDD VDD VSS VSS _5291_/B _5291_/A _6408_/D gf180mcu_as_sc_mcu7t3v3__and2_2
X_4311_ VDD VDD VSS VSS _6212_/D _4311_/B _4311_/A gf180mcu_as_sc_mcu7t3v3__nand2_2
XTAP_TAPCELL_ROW_212_2563 VDD VSS gf180mcu_as_sc_mcu7t3v3__tap_2
X_4242_ VDD VDD VSS VSS _6203_/Q _4336_/B _4336_/C _6204_/Q _4243_/D gf180mcu_as_sc_mcu7t3v3__ao22_2
XTAP_TAPCELL_ROW_42_1_1342 VDD VSS gf180mcu_as_sc_mcu7t3v3__tap_2
XTAP_TAPCELL_ROW_169_1783 VDD VSS gf180mcu_as_sc_mcu7t3v3__tap_2
X_4173_ VDD VDD VSS VSS _6180_/Q _6179_/Q _4173_/C _4176_/A gf180mcu_as_sc_mcu7t3v3__nor3_2
XTAP_TAPCELL_ROW_13_1249 VDD VSS gf180mcu_as_sc_mcu7t3v3__tap_2
X_3124_ VDD VDD VSS VSS _6307_/Q _6313_/Q _4564_/B gf180mcu_as_sc_mcu7t3v3__and2_2
XFILLER_215_208 VDD VDD VSS VSS gf180mcu_as_sc_mcu7t3v3__fill_2
X_3055_ VDD VDD VSS VSS _3134_/D _6295_/Q gf180mcu_as_sc_mcu7t3v3__inv_2
XFILLER_51_666 VDD VDD VSS VSS gf180mcu_as_sc_mcu7t3v3__fill_1
XFILLER_196_649 VDD VDD VSS VSS gf180mcu_as_sc_mcu7t3v3__fill_2
X_3957_ VDD VDD VSS VSS _4038_/B _3962_/C _3975_/C _6059_/Q _6059_/D gf180mcu_as_sc_mcu7t3v3__ao22_2
XFILLER_108_1261 VDD VDD VSS VSS gf180mcu_as_sc_mcu7t3v3__fillcap_4
XFILLER_149_543 VDD VDD VSS VSS gf180mcu_as_sc_mcu7t3v3__fill_1
Xclkbuf_0_clk_regs VDD VDD VSS VSS clkbuf_regs_0_clk/Y clkbuf_0_clk_regs/Y gf180mcu_as_sc_mcu7t3v3__clkbuff_12
XFILLER_164_524 VDD VDD VSS VSS gf180mcu_as_sc_mcu7t3v3__fill_1
XFILLER_176_384 VDD VDD VSS VSS gf180mcu_as_sc_mcu7t3v3__fill_1
X_3888_ VDD VDD VSS VSS _3888_/B _5872_/D _3889_/D gf180mcu_as_sc_mcu7t3v3__and2_2
X_5627_ VDD VDD VSS VSS _5939_/A _5630_/B _5627_/C _5627_/D _5628_/C gf180mcu_as_sc_mcu7t3v3__ao211_2
XFILLER_178_1259 VDD VDD VSS VSS gf180mcu_as_sc_mcu7t3v3__fill_2
XFILLER_192_877 VDD VDD VSS VSS gf180mcu_as_sc_mcu7t3v3__fill_2
X_5558_ VDD VDD VSS VSS _5865_/D _5583_/B _5574_/C _5864_/A _5559_/D gf180mcu_as_sc_mcu7t3v3__ao22_2
XFILLER_183_39 VDD VDD VSS VSS gf180mcu_as_sc_mcu7t3v3__fill_1
XFILLER_219_1256 VDD VDD VSS VSS gf180mcu_as_sc_mcu7t3v3__fillcap_4
X_4509_ VDD VDD VSS VSS _4558_/B _4509_/B _4509_/A gf180mcu_as_sc_mcu7t3v3__nor2_2
XFILLER_160_741 VDD VDD VSS VSS gf180mcu_as_sc_mcu7t3v3__fill_1
X_5489_ VDD VDD VSS VSS _5489_/B _5506_/A _6427_/D gf180mcu_as_sc_mcu7t3v3__and2_2
XFILLER_115_1210 VDD VDD VSS VSS gf180mcu_as_sc_mcu7t3v3__fillcap_16
XFILLER_28_1240 VDD VDD VSS VSS gf180mcu_as_sc_mcu7t3v3__fill_2
Xfanout521 VDD VDD VSS VSS _4014_/C _4012_/C gf180mcu_as_sc_mcu7t3v3__buff_12
Xfanout532 VDD VDD VSS VSS _5955_/S _5795_/S gf180mcu_as_sc_mcu7t3v3__buff_12
XFILLER_219_525 VDD VDD VSS VSS gf180mcu_as_sc_mcu7t3v3__fill_2
XFILLER_76_48 VDD VDD VSS VSS gf180mcu_as_sc_mcu7t3v3__fill_2
Xfanout543 VDD VDD VSS VSS _5642_/S _5628_/D gf180mcu_as_sc_mcu7t3v3__buff_12
Xfanout554 VDD VDD VSS VSS _4965_/S _4883_/A gf180mcu_as_sc_mcu7t3v3__buff_12
Xfanout565 VDD VDD VSS VSS _3975_/B _3974_/D gf180mcu_as_sc_mcu7t3v3__buff_12
XFILLER_219_558 VDD VDD VSS VSS gf180mcu_as_sc_mcu7t3v3__fill_2
Xfanout576 VDD VDD VSS VSS _4061_/A _4051_/A gf180mcu_as_sc_mcu7t3v3__buff_12
Xfanout587 VDD VDD VSS VSS _5630_/B _5569_/B gf180mcu_as_sc_mcu7t3v3__buff_12
Xfanout598 VDD VDD VSS VSS _5189_/B _5144_/B gf180mcu_as_sc_mcu7t3v3__buff_12
XFILLER_150_1189 VDD VDD VSS VSS gf180mcu_as_sc_mcu7t3v3__fillcap_16
XFILLER_185_1208 VDD VDD VSS VSS gf180mcu_as_sc_mcu7t3v3__fillcap_16
XFILLER_15_814 VDD VDD VSS VSS gf180mcu_as_sc_mcu7t3v3__fillcap_16
XFILLER_199_432 VDD VDD VSS VSS gf180mcu_as_sc_mcu7t3v3__fillcap_8
XFILLER_215_753 VDD VDD VSS VSS gf180mcu_as_sc_mcu7t3v3__fillcap_4
XFILLER_226_1205 VDD VDD VSS VSS gf180mcu_as_sc_mcu7t3v3__fillcap_16
XFILLER_15_858 VDD VDD VSS VSS gf180mcu_as_sc_mcu7t3v3__fillcap_16
XFILLER_202_403 VDD VDD VSS VSS gf180mcu_as_sc_mcu7t3v3__fill_2
XFILLER_226_1227 VDD VDD VSS VSS gf180mcu_as_sc_mcu7t3v3__fillcap_16
XFILLER_42_644 VDD VDD VSS VSS gf180mcu_as_sc_mcu7t3v3__fill_1
XFILLER_187_649 VDD VDD VSS VSS gf180mcu_as_sc_mcu7t3v3__fill_1
XFILLER_199_487 VDD VDD VSS VSS gf180mcu_as_sc_mcu7t3v3__fill_2
XFILLER_167_340 VDD VDD VSS VSS gf180mcu_as_sc_mcu7t3v3__fillcap_8
XFILLER_167_384 VDD VDD VSS VSS gf180mcu_as_sc_mcu7t3v3__fill_2
Xwire977 VDD VDD VSS VSS wire977/A _5945_/A gf180mcu_as_sc_mcu7t3v3__clkbuff_12
XFILLER_6_567 VDD VDD VSS VSS gf180mcu_as_sc_mcu7t3v3__fill_2
Xwire988 VDD VDD VSS VSS wire988/A _5679_/A gf180mcu_as_sc_mcu7t3v3__clkbuff_12
XFILLER_159_1170 VDD VDD VSS VSS gf180mcu_as_sc_mcu7t3v3__fillcap_16
XFILLER_170_527 VDD VDD VSS VSS gf180mcu_as_sc_mcu7t3v3__fillcap_4
XFILLER_182_387 VDD VDD VSS VSS gf180mcu_as_sc_mcu7t3v3__fillcap_4
XFILLER_159_1192 VDD VDD VSS VSS gf180mcu_as_sc_mcu7t3v3__fillcap_16
XFILLER_150_295 VDD VDD VSS VSS gf180mcu_as_sc_mcu7t3v3__fillcap_16
XFILLER_173_72 VDD VDD VSS VSS gf180mcu_as_sc_mcu7t3v3__fillcap_16
XTAP_TAPCELL_ROW_186_2094 VDD VSS gf180mcu_as_sc_mcu7t3v3__tap_2
XTAP_TAPCELL_ROW_186_2083 VDD VSS gf180mcu_as_sc_mcu7t3v3__tap_2
XFILLER_206_731 VDD VDD VSS VSS gf180mcu_as_sc_mcu7t3v3__fillcap_4
XTAP_TAPCELL_ROW_164_1691 VDD VSS gf180mcu_as_sc_mcu7t3v3__tap_2
X_4860_ VDD VDD VSS VSS _5205_/A _4860_/B _4860_/C _4861_/D _4861_/B gf180mcu_as_sc_mcu7t3v3__aoi211_2
XFILLER_162_1049 VDD VDD VSS VSS gf180mcu_as_sc_mcu7t3v3__fillcap_16
XFILLER_33_666 VDD VDD VSS VSS gf180mcu_as_sc_mcu7t3v3__fill_1
X_3811_ VDD VDD VSS VSS _3811_/B _4053_/A _4039_/B gf180mcu_as_sc_mcu7t3v3__and2_2
XANTENNA_17 VDD VDD VSS VSS _4845_/B gf180mcu_as_sc_mcu7t3v3__diode_2
XANTENNA_28 VDD VDD VSS VSS _5237_/A gf180mcu_as_sc_mcu7t3v3__diode_2
XANTENNA_39 VDD VDD VSS VSS _4707_/B gf180mcu_as_sc_mcu7t3v3__diode_2
X_6530_ VDD VDD VSS VSS _6531_/CLK _6530_/D _6530_/Q gf180mcu_as_sc_mcu7t3v3__dfxtp_2
X_4791_ VDD VDD VSS VSS _5800_/A _4838_/B _4791_/C _4792_/B _4793_/C gf180mcu_as_sc_mcu7t3v3__ao211_2
XFILLER_192_107 VDD VDD VSS VSS gf180mcu_as_sc_mcu7t3v3__fillcap_8
XFILLER_203_1046 VDD VDD VSS VSS gf180mcu_as_sc_mcu7t3v3__fillcap_4
XFILLER_70_2 VDD VDD VSS VSS gf180mcu_as_sc_mcu7t3v3__fill_2
X_3742_ VDD VDD VSS VSS _3743_/B _3922_/C _3874_/B _5746_/A gf180mcu_as_sc_mcu7t3v3__aoi21b_2
XFILLER_173_321 VDD VDD VSS VSS gf180mcu_as_sc_mcu7t3v3__fill_2
XFILLER_203_1068 VDD VDD VSS VSS gf180mcu_as_sc_mcu7t3v3__fillcap_16
X_6461_ VDD VDD VSS VSS _6474_/CLK _6461_/D _6461_/Q gf180mcu_as_sc_mcu7t3v3__dfxtp_2
X_3673_ VDD VDD VSS VSS _5685_/D _3807_/S _3673_/C _3673_/D _3675_/C gf180mcu_as_sc_mcu7t3v3__ao211_2
XFILLER_173_376 VDD VDD VSS VSS gf180mcu_as_sc_mcu7t3v3__fillcap_4
X_6392_ VDD VDD VSS VSS clkload3/A _6392_/D _6392_/Q gf180mcu_as_sc_mcu7t3v3__dfxtp_2
X_5412_ VDD VDD VSS VSS _5721_/A _5497_/B _5412_/C _5412_/D _5413_/B gf180mcu_as_sc_mcu7t3v3__ao211_2
XFILLER_138_1210 VDD VDD VSS VSS gf180mcu_as_sc_mcu7t3v3__fillcap_16
X_5343_ VDD VDD VSS VSS _5349_/A _5359_/B _5367_/A gf180mcu_as_sc_mcu7t3v3__nor2_2
X_5274_ VDD VDD VSS VSS _5916_/A _5306_/B _5274_/C _5275_/C _5275_/B gf180mcu_as_sc_mcu7t3v3__aoi211_2
XTAP_TAPCELL_ROW_38_3_2906 VDD VSS gf180mcu_as_sc_mcu7t3v3__tap_2
X_4225_ VDD VDD VSS VSS _4564_/B _4225_/B _4225_/C _4226_/C _4572_/D gf180mcu_as_sc_mcu7t3v3__aoi31_2
XFILLER_210_1017 VDD VDD VSS VSS gf180mcu_as_sc_mcu7t3v3__fillcap_16
X_4156_ VDD VDD VSS VSS _4231_/S _4336_/B _4215_/A gf180mcu_as_sc_mcu7t3v3__nand2_2
XFILLER_46_29 VDD VDD VSS VSS gf180mcu_as_sc_mcu7t3v3__fillcap_4
X_3107_ VDD VDD VSS VSS _4411_/A _3154_/A _3161_/A _4571_/C gf180mcu_as_sc_mcu7t3v3__ao21_2
XFILLER_3_1264 VDD VDD VSS VSS gf180mcu_as_sc_mcu7t3v3__fill_1
X_4087_ VDD VDD VSS VSS _4089_/S _6716_/A _6147_/Q _6147_/D gf180mcu_as_sc_mcu7t3v3__mux2_2
XTAP_TAPCELL_ROW_225_2798 VDD VSS gf180mcu_as_sc_mcu7t3v3__tap_2
XTAP_TAPCELL_ROW_225_2787 VDD VSS gf180mcu_as_sc_mcu7t3v3__tap_2
X_3038_ VDD VDD VSS VSS _5926_/A _5612_/A gf180mcu_as_sc_mcu7t3v3__inv_2
XFILLER_24_655 VDD VDD VSS VSS gf180mcu_as_sc_mcu7t3v3__fillcap_8
XFILLER_212_734 VDD VDD VSS VSS gf180mcu_as_sc_mcu7t3v3__fill_1
XFILLER_12_839 VDD VDD VSS VSS gf180mcu_as_sc_mcu7t3v3__fillcap_16
XFILLER_196_446 VDD VDD VSS VSS gf180mcu_as_sc_mcu7t3v3__fill_1
XFILLER_196_457 VDD VDD VSS VSS gf180mcu_as_sc_mcu7t3v3__fillcap_8
XFILLER_212_778 VDD VDD VSS VSS gf180mcu_as_sc_mcu7t3v3__fill_2
X_4989_ VDD VDD VSS VSS _5139_/B _5183_/B _4989_/Y gf180mcu_as_sc_mcu7t3v3__and2_2
XFILLER_165_800 VDD VDD VSS VSS gf180mcu_as_sc_mcu7t3v3__fillcap_8
XFILLER_164_354 VDD VDD VSS VSS gf180mcu_as_sc_mcu7t3v3__fillcap_16
XFILLER_127_43 VDD VDD VSS VSS gf180mcu_as_sc_mcu7t3v3__fillcap_8
XFILLER_152_527 VDD VDD VSS VSS gf180mcu_as_sc_mcu7t3v3__fill_1
XFILLER_164_387 VDD VDD VSS VSS gf180mcu_as_sc_mcu7t3v3__fillcap_8
XFILLER_191_184 VDD VDD VSS VSS gf180mcu_as_sc_mcu7t3v3__fill_1
XFILLER_192_696 VDD VDD VSS VSS gf180mcu_as_sc_mcu7t3v3__fillcap_16
XFILLER_191_1234 VDD VDD VSS VSS gf180mcu_as_sc_mcu7t3v3__fill_1
Xdelaybuf_1_clk VDD VDD VSS VSS delaybuf_1_clk/A clkbuf_0_clk/A gf180mcu_as_sc_mcu7t3v3__clkbuff_12
XFILLER_101_660 VDD VDD VSS VSS gf180mcu_as_sc_mcu7t3v3__fill_2
XFILLER_219_333 VDD VDD VSS VSS gf180mcu_as_sc_mcu7t3v3__fillcap_4
XFILLER_4_1017 VDD VDD VSS VSS gf180mcu_as_sc_mcu7t3v3__fillcap_16
XTAP_TAPCELL_ROW_9_1181 VDD VSS gf180mcu_as_sc_mcu7t3v3__tap_2
XTAP_TAPCELL_ROW_9_1170 VDD VSS gf180mcu_as_sc_mcu7t3v3__tap_2
XFILLER_15_611 VDD VDD VSS VSS gf180mcu_as_sc_mcu7t3v3__fill_1
XFILLER_15_644 VDD VDD VSS VSS gf180mcu_as_sc_mcu7t3v3__fill_1
XPHY_EDGE_ROW_76_3_Left_781 VDD VSS gf180mcu_as_sc_mcu7t3v3__tap_2
XFILLER_159_104 VDD VDD VSS VSS gf180mcu_as_sc_mcu7t3v3__fillcap_16
XFILLER_188_936 VDD VDD VSS VSS gf180mcu_as_sc_mcu7t3v3__fillcap_4
XFILLER_199_262 VDD VDD VSS VSS gf180mcu_as_sc_mcu7t3v3__fillcap_4
XFILLER_199_273 VDD VDD VSS VSS gf180mcu_as_sc_mcu7t3v3__fillcap_4
XFILLER_202_211 VDD VDD VSS VSS gf180mcu_as_sc_mcu7t3v3__fill_1
XFILLER_202_244 VDD VDD VSS VSS gf180mcu_as_sc_mcu7t3v3__fill_1
XFILLER_52_50 VDD VDD VSS VSS gf180mcu_as_sc_mcu7t3v3__fill_1
XFILLER_174_107 VDD VDD VSS VSS gf180mcu_as_sc_mcu7t3v3__fillcap_16
XFILLER_187_479 VDD VDD VSS VSS gf180mcu_as_sc_mcu7t3v3__fill_1
XFILLER_7_810 VDD VDD VSS VSS gf180mcu_as_sc_mcu7t3v3__fill_2
XPHY_EDGE_ROW_135_2_Left_576 VDD VSS gf180mcu_as_sc_mcu7t3v3__tap_2
Xinput15 VDD VDD VSS VSS boot_addr[7] _3289_/B gf180mcu_as_sc_mcu7t3v3__buff_12
Xinput26 VDD VDD VSS VSS boot_mode _3363_/B gf180mcu_as_sc_mcu7t3v3__buff_12
Xinput37 VDD VDD VSS VSS dft_addr[8] _3295_/B gf180mcu_as_sc_mcu7t3v3__buff_12
XFILLER_156_877 VDD VDD VSS VSS gf180mcu_as_sc_mcu7t3v3__fillcap_8
Xinput48 VDD VDD VSS VSS dft_wdata[7] _3364_/B gf180mcu_as_sc_mcu7t3v3__buff_12
Xinput59 VDD VDD VSS VSS east_in[18] _5821_/A gf180mcu_as_sc_mcu7t3v3__buff_12
XFILLER_155_387 VDD VDD VSS VSS gf180mcu_as_sc_mcu7t3v3__fill_2
XPHY_EDGE_ROW_72_2_Left_513 VDD VSS gf180mcu_as_sc_mcu7t3v3__tap_2
XFILLER_170_357 VDD VDD VSS VSS gf180mcu_as_sc_mcu7t3v3__fill_2
XFILLER_196_1189 VDD VDD VSS VSS gf180mcu_as_sc_mcu7t3v3__fillcap_16
XTAP_TAPCELL_ROW_188_2134 VDD VSS gf180mcu_as_sc_mcu7t3v3__tap_2
XTAP_TAPCELL_ROW_188_2123 VDD VSS gf180mcu_as_sc_mcu7t3v3__tap_2
XTAP_TAPCELL_ROW_149_1406 VDD VSS gf180mcu_as_sc_mcu7t3v3__tap_2
XTAP_TAPCELL_ROW_149_1417 VDD VSS gf180mcu_as_sc_mcu7t3v3__tap_2
XTAP_TAPCELL_ROW_149_1428 VDD VSS gf180mcu_as_sc_mcu7t3v3__tap_2
XTAP_TAPCELL_ROW_166_1731 VDD VSS gf180mcu_as_sc_mcu7t3v3__tap_2
X_4010_ VDD VDD VSS VSS _4055_/B _4012_/B _4012_/C _6098_/Q _6098_/D gf180mcu_as_sc_mcu7t3v3__ao22_2
XTAP_TAPCELL_ROW_207_2473 VDD VSS gf180mcu_as_sc_mcu7t3v3__tap_2
XTAP_TAPCELL_ROW_207_2462 VDD VSS gf180mcu_as_sc_mcu7t3v3__tap_2
XFILLER_203_67 VDD VDD VSS VSS gf180mcu_as_sc_mcu7t3v3__fill_2
X_5961_ VDD VDD VSS VSS _5975_/B _5963_/B _5963_/A gf180mcu_as_sc_mcu7t3v3__nor2_2
X_4912_ VDD VDD VSS VSS _4912_/B _4912_/A _6368_/D gf180mcu_as_sc_mcu7t3v3__and2_2
XFILLER_206_594 VDD VDD VSS VSS gf180mcu_as_sc_mcu7t3v3__fill_1
X_5892_ VDD VDD VSS VSS _5948_/S _5892_/B _5892_/A _5893_/B gf180mcu_as_sc_mcu7t3v3__mux2_2
XTAP_TAPCELL_ROW_220_2695 VDD VSS gf180mcu_as_sc_mcu7t3v3__tap_2
XFILLER_178_457 VDD VDD VSS VSS gf180mcu_as_sc_mcu7t3v3__fillcap_4
XFILLER_21_636 VDD VDD VSS VSS gf180mcu_as_sc_mcu7t3v3__fill_1
X_4843_ VDD VDD VSS VSS _5842_/A _4843_/B _4843_/C _4843_/D _4844_/B gf180mcu_as_sc_mcu7t3v3__ao211_2
XFILLER_14_1103 VDD VDD VSS VSS gf180mcu_as_sc_mcu7t3v3__fillcap_16
XFILLER_18_1261 VDD VDD VSS VSS gf180mcu_as_sc_mcu7t3v3__fillcap_4
X_4774_ VDD VDD VSS VSS _4776_/C _5123_/A _4840_/B _4774_/C _4774_/D gf180mcu_as_sc_mcu7t3v3__aoi22_2
XFILLER_193_438 VDD VDD VSS VSS gf180mcu_as_sc_mcu7t3v3__fill_2
X_6513_ VDD VDD VSS VSS _6518_/CLK _6513_/D _6513_/Q gf180mcu_as_sc_mcu7t3v3__dfxtp_2
X_3725_ VDD VDD VSS VSS _3874_/B _5737_/A _3732_/C gf180mcu_as_sc_mcu7t3v3__and2_2
XFILLER_228_42 VDD VDD VSS VSS gf180mcu_as_sc_mcu7t3v3__fill_1
X_6444_ VDD VDD VSS VSS _6448_/CLK _6444_/D _6444_/Q gf180mcu_as_sc_mcu7t3v3__dfxtp_2
X_3656_ VDD VDD VSS VSS _3656_/A _3905_/C _3656_/C _3656_/Y _3656_/D gf180mcu_as_sc_mcu7t3v3__aoi211_2
XFILLER_161_346 VDD VDD VSS VSS gf180mcu_as_sc_mcu7t3v3__fillcap_4
X_6375_ VDD VDD VSS VSS _6376_/CLK _6375_/D _6375_/Q gf180mcu_as_sc_mcu7t3v3__dfxtp_2
X_3587_ VDD VDD VSS VSS _3637_/A _6523_/Q _3591_/A _6524_/Q _3596_/B gf180mcu_as_sc_mcu7t3v3__ao22_2
X_5326_ VDD VDD VSS VSS _5649_/B _5327_/A _5327_/B _5327_/C gf180mcu_as_sc_mcu7t3v3__ao21_2
XFILLER_216_1259 VDD VDD VSS VSS gf180mcu_as_sc_mcu7t3v3__fillcap_4
XFILLER_25_1210 VDD VDD VSS VSS gf180mcu_as_sc_mcu7t3v3__fillcap_4
X_5257_ VDD VDD VSS VSS _5894_/A _5306_/B _5257_/C _5257_/D _5258_/A gf180mcu_as_sc_mcu7t3v3__ao211_2
XTAP_TAPCELL_ROW_227_2827 VDD VSS gf180mcu_as_sc_mcu7t3v3__tap_2
X_4208_ VDD VDD VSS VSS _4349_/S _6130_/Q _6043_/Q _4210_/A gf180mcu_as_sc_mcu7t3v3__mux2_2
XFILLER_151_1262 VDD VDD VSS VSS gf180mcu_as_sc_mcu7t3v3__fill_2
X_5188_ VDD VDD VSS VSS _5841_/A _5188_/B _5188_/C _5837_/A _5189_/D gf180mcu_as_sc_mcu7t3v3__ao22_2
XFILLER_216_314 VDD VDD VSS VSS gf180mcu_as_sc_mcu7t3v3__fill_1
X_4139_ VDD VDD VSS VSS _4140_/S _6189_/Q _6188_/Q _6188_/D gf180mcu_as_sc_mcu7t3v3__mux2_2
XFILLER_189_27 VDD VDD VSS VSS gf180mcu_as_sc_mcu7t3v3__fillcap_16
XFILLER_73_49 VDD VDD VSS VSS gf180mcu_as_sc_mcu7t3v3__fill_2
XFILLER_223_1208 VDD VDD VSS VSS gf180mcu_as_sc_mcu7t3v3__fillcap_16
XFILLER_156_107 VDD VDD VSS VSS gf180mcu_as_sc_mcu7t3v3__fillcap_16
XFILLER_200_737 VDD VDD VSS VSS gf180mcu_as_sc_mcu7t3v3__fillcap_8
XFILLER_212_597 VDD VDD VSS VSS gf180mcu_as_sc_mcu7t3v3__fill_2
XPHY_EDGE_ROW_120_1_Left_348 VDD VSS gf180mcu_as_sc_mcu7t3v3__tap_2
XFILLER_165_663 VDD VDD VSS VSS gf180mcu_as_sc_mcu7t3v3__fill_2
XFILLER_192_493 VDD VDD VSS VSS gf180mcu_as_sc_mcu7t3v3__fillcap_16
XFILLER_4_857 VDD VDD VSS VSS gf180mcu_as_sc_mcu7t3v3__fillcap_16
XFILLER_0_2 VDD VDD VSS VSS gf180mcu_as_sc_mcu7t3v3__fillcap_16
XFILLER_154_30 VDD VDD VSS VSS gf180mcu_as_sc_mcu7t3v3__fillcap_4
XFILLER_156_1151 VDD VDD VSS VSS gf180mcu_as_sc_mcu7t3v3__fillcap_4
XFILLER_156_1173 VDD VDD VSS VSS gf180mcu_as_sc_mcu7t3v3__fillcap_16
XFILLER_154_85 VDD VDD VSS VSS gf180mcu_as_sc_mcu7t3v3__fillcap_16
XTAP_TAPCELL_ROW_183_2042 VDD VSS gf180mcu_as_sc_mcu7t3v3__tap_2
XTAP_TAPCELL_ROW_183_2031 VDD VSS gf180mcu_as_sc_mcu7t3v3__tap_2
XPHY_EDGE_ROW_179_Right_47 VDD VSS gf180mcu_as_sc_mcu7t3v3__tap_2
XFILLER_16_920 VDD VDD VSS VSS gf180mcu_as_sc_mcu7t3v3__fillcap_16
XFILLER_222_317 VDD VDD VSS VSS gf180mcu_as_sc_mcu7t3v3__fillcap_4
XFILLER_128_1242 VDD VDD VSS VSS gf180mcu_as_sc_mcu7t3v3__fill_1
XFILLER_163_1100 VDD VDD VSS VSS gf180mcu_as_sc_mcu7t3v3__fillcap_16
XFILLER_163_1122 VDD VDD VSS VSS gf180mcu_as_sc_mcu7t3v3__fillcap_16
XTAP_TAPCELL_ROW_202_2381 VDD VSS gf180mcu_as_sc_mcu7t3v3__tap_2
XTAP_TAPCELL_ROW_202_2370 VDD VSS gf180mcu_as_sc_mcu7t3v3__tap_2
XFILLER_148_619 VDD VDD VSS VSS gf180mcu_as_sc_mcu7t3v3__fillcap_8
XFILLER_187_254 VDD VDD VSS VSS gf180mcu_as_sc_mcu7t3v3__fillcap_4
XFILLER_187_276 VDD VDD VSS VSS gf180mcu_as_sc_mcu7t3v3__fillcap_4
XFILLER_175_438 VDD VDD VSS VSS gf180mcu_as_sc_mcu7t3v3__fillcap_8
XPHY_EDGE_ROW_188_Right_56 VDD VSS gf180mcu_as_sc_mcu7t3v3__tap_2
X_3510_ VDD VDD VSS VSS _4625_/C _3510_/B _3510_/C _5654_/B gf180mcu_as_sc_mcu7t3v3__nor3_2
XFILLER_200_1049 VDD VDD VSS VSS gf180mcu_as_sc_mcu7t3v3__fillcap_16
XFILLER_7_662 VDD VDD VSS VSS gf180mcu_as_sc_mcu7t3v3__fillcap_4
X_4490_ VDD VDD VSS VSS _6281_/D _6281_/Q _4503_/C _4490_/C gf180mcu_as_sc_mcu7t3v3__ao21_2
XFILLER_48_1210 VDD VDD VSS VSS gf180mcu_as_sc_mcu7t3v3__fillcap_8
X_3441_ VDD VDD VSS VSS _6716_/A _4584_/A _3453_/B gf180mcu_as_sc_mcu7t3v3__and2_2
X_6160_ VDD VDD VSS VSS clkload8/A _6160_/D _6160_/Q gf180mcu_as_sc_mcu7t3v3__dfxtp_2
X_3372_ VDD VDD VSS VSS _3372_/B _3372_/A _3373_/B gf180mcu_as_sc_mcu7t3v3__xnor2_2
X_5111_ VDD VDD VSS VSS _5112_/D _5775_/A _5221_/B _5224_/B gf180mcu_as_sc_mcu7t3v3__ao21_2
XTAP_TAPCELL_ROW_209_2502 VDD VSS gf180mcu_as_sc_mcu7t3v3__tap_2
X_6091_ VDD VDD VSS VSS _6519_/CLK _6091_/D _6091_/Q gf180mcu_as_sc_mcu7t3v3__dfxtp_2
X_5042_ VDD VDD VSS VSS _5711_/A _5144_/B _5042_/C _5042_/D _5043_/A gf180mcu_as_sc_mcu7t3v3__ao211_2
XPHY_EDGE_ROW_197_Right_65 VDD VSS gf180mcu_as_sc_mcu7t3v3__tap_2
XFILLER_0_1201 VDD VDD VSS VSS gf180mcu_as_sc_mcu7t3v3__fillcap_4
XFILLER_168_1033 VDD VDD VSS VSS gf180mcu_as_sc_mcu7t3v3__fillcap_16
XFILLER_226_667 VDD VDD VSS VSS gf180mcu_as_sc_mcu7t3v3__fill_1
XTAP_TAPCELL_ROW_222_2746 VDD VSS gf180mcu_as_sc_mcu7t3v3__tap_2
XTAP_TAPCELL_ROW_222_2735 VDD VSS gf180mcu_as_sc_mcu7t3v3__tap_2
XFILLER_0_1223 VDD VDD VSS VSS gf180mcu_as_sc_mcu7t3v3__fill_1
XFILLER_209_1030 VDD VDD VSS VSS gf180mcu_as_sc_mcu7t3v3__fillcap_16
X_5944_ VDD VDD VSS VSS _5944_/A _5944_/B _5944_/C _5945_/C _5952_/B gf180mcu_as_sc_mcu7t3v3__aoi211_2
XFILLER_209_1052 VDD VDD VSS VSS gf180mcu_as_sc_mcu7t3v3__fillcap_16
X_5875_ VDD VDD VSS VSS _5875_/S _5875_/B _5875_/A _5876_/B gf180mcu_as_sc_mcu7t3v3__mux2_2
XTAP_TAPCELL_ROW_179_1955 VDD VSS gf180mcu_as_sc_mcu7t3v3__tap_2
XFILLER_178_276 VDD VDD VSS VSS gf180mcu_as_sc_mcu7t3v3__fill_1
XFILLER_193_202 VDD VDD VSS VSS gf180mcu_as_sc_mcu7t3v3__fillcap_8
X_4826_ VDD VDD VSS VSS _4826_/B _4826_/A _6359_/D gf180mcu_as_sc_mcu7t3v3__and2_2
XTAP_TAPCELL_ROW_179_1966 VDD VSS gf180mcu_as_sc_mcu7t3v3__tap_2
XFILLER_147_630 VDD VDD VSS VSS gf180mcu_as_sc_mcu7t3v3__fillcap_8
XFILLER_222_1263 VDD VDD VSS VSS gf180mcu_as_sc_mcu7t3v3__fill_2
XFILLER_194_769 VDD VDD VSS VSS gf180mcu_as_sc_mcu7t3v3__fillcap_8
X_4757_ VDD VDD VSS VSS _6504_/Q _4880_/B _4757_/C _4757_/D _4759_/C gf180mcu_as_sc_mcu7t3v3__ao22_2
XFILLER_174_471 VDD VDD VSS VSS gf180mcu_as_sc_mcu7t3v3__fillcap_4
X_4688_ VDD VDD VSS VSS _4875_/B _4689_/A _4961_/B gf180mcu_as_sc_mcu7t3v3__and2_2
X_3708_ VDD VDD VSS VSS _5717_/A _3852_/B _3708_/C _3708_/D _3710_/C gf180mcu_as_sc_mcu7t3v3__ao211_2
X_6427_ VDD VDD VSS VSS _6437_/CLK _6427_/D _6427_/Q gf180mcu_as_sc_mcu7t3v3__dfxtp_2
X_3639_ VDD VDD VSS VSS _3639_/A _5941_/A _4651_/A _3640_/B _4651_/C gf180mcu_as_sc_mcu7t3v3__aoi211_2
XFILLER_108_45 VDD VDD VSS VSS gf180mcu_as_sc_mcu7t3v3__fillcap_4
X_6358_ VDD VDD VSS VSS _6365_/CLK _6358_/D _6358_/Q gf180mcu_as_sc_mcu7t3v3__dfxtp_2
XFILLER_68_49 VDD VDD VSS VSS gf180mcu_as_sc_mcu7t3v3__fill_2
X_5309_ VDD VDD VSS VSS _5309_/B _5952_/A _5313_/C gf180mcu_as_sc_mcu7t3v3__and2_2
Xinput205 VDD VDD VSS VSS se_in[19] _5834_/A gf180mcu_as_sc_mcu7t3v3__buff_12
Xinput216 VDD VDD VSS VSS se_in[29] _5916_/A gf180mcu_as_sc_mcu7t3v3__buff_12
Xinput227 VDD VDD VSS VSS se_in[6] _5728_/A gf180mcu_as_sc_mcu7t3v3__buff_12
X_6289_ VDD VDD VSS VSS clkload5/A _6289_/D _6289_/Q gf180mcu_as_sc_mcu7t3v3__dfxtp_2
Xinput238 VDD VDD VSS VSS south_in[16] _5810_/D gf180mcu_as_sc_mcu7t3v3__buff_12
Xinput249 VDD VDD VSS VSS south_in[26] wire998/A gf180mcu_as_sc_mcu7t3v3__buff_12
XFILLER_84_48 VDD VDD VSS VSS gf180mcu_as_sc_mcu7t3v3__fill_2
XPHY_EDGE_ROW_201_Right_69 VDD VSS gf180mcu_as_sc_mcu7t3v3__tap_2
XTAP_TAPCELL_ROW_2_1048 VDD VSS gf180mcu_as_sc_mcu7t3v3__tap_2
XFILLER_13_912 VDD VDD VSS VSS gf180mcu_as_sc_mcu7t3v3__fillcap_16
XFILLER_12_477 VDD VDD VSS VSS gf180mcu_as_sc_mcu7t3v3__fillcap_4
XFILLER_149_30 VDD VDD VSS VSS gf180mcu_as_sc_mcu7t3v3__fillcap_4
XFILLER_149_52 VDD VDD VSS VSS gf180mcu_as_sc_mcu7t3v3__fillcap_16
XFILLER_185_747 VDD VDD VSS VSS gf180mcu_as_sc_mcu7t3v3__fill_2
XFILLER_212_394 VDD VDD VSS VSS gf180mcu_as_sc_mcu7t3v3__fill_1
XPHY_EDGE_ROW_107_3_Left_812 VDD VSS gf180mcu_as_sc_mcu7t3v3__tap_2
XFILLER_193_780 VDD VDD VSS VSS gf180mcu_as_sc_mcu7t3v3__fill_1
XFILLER_193_791 VDD VDD VSS VSS gf180mcu_as_sc_mcu7t3v3__fillcap_4
XFILLER_197_1262 VDD VDD VSS VSS gf180mcu_as_sc_mcu7t3v3__fill_2
XFILLER_180_452 VDD VDD VSS VSS gf180mcu_as_sc_mcu7t3v3__fill_2
XFILLER_3_142 VDD VDD VSS VSS gf180mcu_as_sc_mcu7t3v3__fillcap_4
XPHY_EDGE_ROW_210_Right_78 VDD VSS gf180mcu_as_sc_mcu7t3v3__tap_2
XFILLER_181_72 VDD VDD VSS VSS gf180mcu_as_sc_mcu7t3v3__fillcap_8
XFILLER_208_601 VDD VDD VSS VSS gf180mcu_as_sc_mcu7t3v3__fill_2
XFILLER_78_1214 VDD VDD VSS VSS gf180mcu_as_sc_mcu7t3v3__fill_2
XTAP_TAPCELL_ROW_204_2421 VDD VSS gf180mcu_as_sc_mcu7t3v3__tap_2
XTAP_TAPCELL_ROW_204_2410 VDD VSS gf180mcu_as_sc_mcu7t3v3__tap_2
XFILLER_165_1228 VDD VDD VSS VSS gf180mcu_as_sc_mcu7t3v3__fill_2
X_3990_ VDD VDD VSS VSS _4026_/B _4008_/B _4008_/C _6079_/Q _6079_/D gf180mcu_as_sc_mcu7t3v3__ao22_2
XFILLER_15_260 VDD VDD VSS VSS gf180mcu_as_sc_mcu7t3v3__fillcap_4
XTAP_TAPCELL_ROW_196_2266 VDD VSS gf180mcu_as_sc_mcu7t3v3__tap_2
XFILLER_149_917 VDD VDD VSS VSS gf180mcu_as_sc_mcu7t3v3__fill_1
XFILLER_149_928 VDD VDD VSS VSS gf180mcu_as_sc_mcu7t3v3__fill_2
XFILLER_15_282 VDD VDD VSS VSS gf180mcu_as_sc_mcu7t3v3__fillcap_16
XFILLER_176_725 VDD VDD VSS VSS gf180mcu_as_sc_mcu7t3v3__fillcap_8
X_5660_ VDD VDD VSS VSS _5663_/A _5668_/B _5667_/A gf180mcu_as_sc_mcu7t3v3__nor2_2
XTAP_TAPCELL_ROW_196_2277 VDD VSS gf180mcu_as_sc_mcu7t3v3__tap_2
XFILLER_176_758 VDD VDD VSS VSS gf180mcu_as_sc_mcu7t3v3__fill_1
XPHY_EDGE_ROW_39_3_Left_744 VDD VSS gf180mcu_as_sc_mcu7t3v3__tap_2
X_4611_ VDD VDD VSS VSS _6333_/Q _4611_/B _6340_/Q _6340_/D gf180mcu_as_sc_mcu7t3v3__mux2_2
XFILLER_129_652 VDD VDD VSS VSS gf180mcu_as_sc_mcu7t3v3__fillcap_8
XFILLER_15_1264 VDD VDD VSS VSS gf180mcu_as_sc_mcu7t3v3__fill_1
X_5591_ VDD VDD VSS VSS _5901_/A _5628_/D _5634_/B _5894_/A _5592_/D gf180mcu_as_sc_mcu7t3v3__ao22_2
XFILLER_102_1245 VDD VDD VSS VSS gf180mcu_as_sc_mcu7t3v3__fillcap_16
XFILLER_163_419 VDD VDD VSS VSS gf180mcu_as_sc_mcu7t3v3__fill_1
XFILLER_190_227 VDD VDD VSS VSS gf180mcu_as_sc_mcu7t3v3__fill_1
XTAP_TAPCELL_ROW_174_1874 VDD VSS gf180mcu_as_sc_mcu7t3v3__tap_2
X_4542_ VDD VDD VSS VSS _4542_/B _4582_/A _4551_/C gf180mcu_as_sc_mcu7t3v3__and2_2
XFILLER_171_430 VDD VDD VSS VSS gf180mcu_as_sc_mcu7t3v3__fill_2
XFILLER_190_238 VDD VDD VSS VSS gf180mcu_as_sc_mcu7t3v3__fillcap_4
XFILLER_209_88 VDD VDD VSS VSS gf180mcu_as_sc_mcu7t3v3__fill_2
X_4473_ VDD VDD VSS VSS _4474_/B _6277_/Q _4610_/A _4579_/D gf180mcu_as_sc_mcu7t3v3__ao21_2
X_6212_ VDD VDD VSS VSS _6519_/CLK _6212_/D _6212_/Q gf180mcu_as_sc_mcu7t3v3__dfxtp_2
X_3424_ VDD VDD VSS VSS _4462_/B _4509_/A _6259_/Q _4443_/A _3425_/C gf180mcu_as_sc_mcu7t3v3__ao31_2
Xfanout906 VDD VDD VSS VSS _6262_/Q _4539_/A gf180mcu_as_sc_mcu7t3v3__buff_12
XFILLER_174_1081 VDD VDD VSS VSS gf180mcu_as_sc_mcu7t3v3__fillcap_4
Xfanout917 VDD VDD VSS VSS _4293_/S _4398_/S gf180mcu_as_sc_mcu7t3v3__buff_12
Xfanout928 VDD VDD VSS VSS _5396_/A _5291_/A gf180mcu_as_sc_mcu7t3v3__buff_12
Xfanout939 VDD VDD VSS VSS _5977_/A _5562_/A gf180mcu_as_sc_mcu7t3v3__buff_12
Xsram2048.u_bank1 _3295_/Y _3291_/Y wire493/Y wire514/Y wire515/Y wire494/Y _3246_/Y
+ _3227_/Y _3220_/Y hold1194/Y clkbuf_1_1__f_clk/Y wire506/Y wire507/Y wire508/Y wire509/Y
+ wire510/Y wire511/Y wire512/Y wire513/Y _3214_/Y _3371_/B _3370_/B _3369_/B _3368_/B
+ _3367_/B _3366_/B _3365_/B _3099_/B VDD VSS sram2048.u_bank1/WEN[7] sram2048.u_bank1/WEN[6]
+ sram2048.u_bank1/WEN[5] sram2048.u_bank1/WEN[4] sram2048.u_bank1/WEN[3] sram2048.u_bank1/WEN[2]
+ sram2048.u_bank1/WEN[1] sram2048.u_bank1/WEN[0] _3299_/Y gf180mcu_ocd_ip_sram__sram1024x8m8wm1
X_6143_ VDD VDD VSS VSS clkload7/A _6143_/D _6143_/Q gf180mcu_as_sc_mcu7t3v3__dfxtp_2
X_3355_ VDD VDD VSS VSS _3356_/D _3356_/A _3355_/B _3355_/A gf180mcu_as_sc_mcu7t3v3__aoi21b_2
X_6074_ VDD VDD VSS VSS _6125_/CLK _6074_/D _6074_/Q gf180mcu_as_sc_mcu7t3v3__dfxtp_2
X_3286_ VDD VDD VSS VSS _3286_/Y _3291_/B _3286_/B _3286_/C gf180mcu_as_sc_mcu7t3v3__ao21_2
X_5025_ VDD VDD VSS VSS _5228_/S _5695_/A _5025_/A _5026_/B gf180mcu_as_sc_mcu7t3v3__mux2_2
XFILLER_227_998 VDD VDD VSS VSS gf180mcu_as_sc_mcu7t3v3__fillcap_16
XFILLER_54_29 VDD VDD VSS VSS gf180mcu_as_sc_mcu7t3v3__fillcap_4
XFILLER_199_839 VDD VDD VSS VSS gf180mcu_as_sc_mcu7t3v3__fill_1
XFILLER_81_664 VDD VDD VSS VSS gf180mcu_as_sc_mcu7t3v3__fill_2
XTAP_TAPCELL_ROW_144_3_3065 VDD VSS gf180mcu_as_sc_mcu7t3v3__tap_2
X_5927_ VDD VDD VSS VSS _5947_/B _5927_/A _5933_/C gf180mcu_as_sc_mcu7t3v3__and2_2
XFILLER_0_1097 VDD VDD VSS VSS gf180mcu_as_sc_mcu7t3v3__fillcap_4
XFILLER_181_1030 VDD VDD VSS VSS gf180mcu_as_sc_mcu7t3v3__fillcap_16
XFILLER_181_1052 VDD VDD VSS VSS gf180mcu_as_sc_mcu7t3v3__fillcap_16
X_5858_ VDD VDD VSS VSS _5858_/A _5858_/B _5858_/C _5858_/D _5859_/B gf180mcu_as_sc_mcu7t3v3__ao211_2
XFILLER_182_717 VDD VDD VSS VSS gf180mcu_as_sc_mcu7t3v3__fillcap_4
X_5789_ VDD VDD VSS VSS _5797_/B _5789_/A _5792_/C gf180mcu_as_sc_mcu7t3v3__and2_2
X_4809_ VDD VDD VSS VSS _4876_/B _5813_/A _4810_/C gf180mcu_as_sc_mcu7t3v3__and2_2
XTAP_TAPCELL_ROW_61_2_2940 VDD VSS gf180mcu_as_sc_mcu7t3v3__tap_2
XFILLER_135_655 VDD VDD VSS VSS gf180mcu_as_sc_mcu7t3v3__fillcap_4
XFILLER_163_964 VDD VDD VSS VSS gf180mcu_as_sc_mcu7t3v3__fill_1
XFILLER_135_666 VDD VDD VSS VSS gf180mcu_as_sc_mcu7t3v3__fill_1
XPHY_EDGE_ROW_85_3_Left_790 VDD VSS gf180mcu_as_sc_mcu7t3v3__tap_2
XFILLER_135_43 VDD VDD VSS VSS gf180mcu_as_sc_mcu7t3v3__fillcap_8
XFILLER_0_178 VDD VDD VSS VSS gf180mcu_as_sc_mcu7t3v3__fill_1
XFILLER_153_1154 VDD VDD VSS VSS gf180mcu_as_sc_mcu7t3v3__fillcap_16
XPHY_EDGE_ROW_144_2_Left_585 VDD VSS gf180mcu_as_sc_mcu7t3v3__tap_2
Xclkbuf_leaf_15_clk_regs VDD VDD VSS VSS clkbuf_3_2_0_clk_regs/Y _6365_/CLK gf180mcu_as_sc_mcu7t3v3__clkbuff_12
XPHY_EDGE_ROW_81_2_Left_522 VDD VSS gf180mcu_as_sc_mcu7t3v3__tap_2
XFILLER_160_1103 VDD VDD VSS VSS gf180mcu_as_sc_mcu7t3v3__fillcap_16
XFILLER_125_1234 VDD VDD VSS VSS gf180mcu_as_sc_mcu7t3v3__fillcap_4
XFILLER_12_241 VDD VDD VSS VSS gf180mcu_as_sc_mcu7t3v3__fillcap_4
XFILLER_12_263 VDD VDD VSS VSS gf180mcu_as_sc_mcu7t3v3__fillcap_16
XFILLER_197_393 VDD VDD VSS VSS gf180mcu_as_sc_mcu7t3v3__fillcap_8
XFILLER_201_1100 VDD VDD VSS VSS gf180mcu_as_sc_mcu7t3v3__fillcap_16
XFILLER_9_768 VDD VDD VSS VSS gf180mcu_as_sc_mcu7t3v3__fill_2
XFILLER_172_205 VDD VDD VSS VSS gf180mcu_as_sc_mcu7t3v3__fill_2
XFILLER_201_1122 VDD VDD VSS VSS gf180mcu_as_sc_mcu7t3v3__fillcap_16
XTAP_TAPCELL_ROW_191_2185 VDD VSS gf180mcu_as_sc_mcu7t3v3__tap_2
XTAP_TAPCELL_ROW_191_2174 VDD VSS gf180mcu_as_sc_mcu7t3v3__tap_2
XFILLER_154_975 VDD VDD VSS VSS gf180mcu_as_sc_mcu7t3v3__fillcap_16
XTAP_TAPCELL_ROW_152_1479 VDD VSS gf180mcu_as_sc_mcu7t3v3__tap_2
XFILLER_141_625 VDD VDD VSS VSS gf180mcu_as_sc_mcu7t3v3__fillcap_8
XFILLER_153_496 VDD VDD VSS VSS gf180mcu_as_sc_mcu7t3v3__fill_2
XFILLER_158_1065 VDD VDD VSS VSS gf180mcu_as_sc_mcu7t3v3__fillcap_16
XFILLER_158_1087 VDD VDD VSS VSS gf180mcu_as_sc_mcu7t3v3__fillcap_16
XFILLER_5_67 VDD VDD VSS VSS gf180mcu_as_sc_mcu7t3v3__fill_2
XFILLER_141_658 VDD VDD VSS VSS gf180mcu_as_sc_mcu7t3v3__fillcap_4
XFILLER_228_707 VDD VDD VSS VSS gf180mcu_as_sc_mcu7t3v3__fillcap_4
X_3140_ VDD VDD VSS VSS _3141_/C _6309_/Q _6308_/Q _6307_/Q gf180mcu_as_sc_mcu7t3v3__aoi21_2
XTAP_TAPCELL_ROW_15_1280 VDD VSS gf180mcu_as_sc_mcu7t3v3__tap_2
XTAP_TAPCELL_ROW_15_1291 VDD VSS gf180mcu_as_sc_mcu7t3v3__tap_2
X_3071_ VDD VDD VSS VSS _5104_/A _5765_/B gf180mcu_as_sc_mcu7t3v3__inv_2
XFILLER_208_442 VDD VDD VSS VSS gf180mcu_as_sc_mcu7t3v3__fillcap_8
XFILLER_209_998 VDD VDD VSS VSS gf180mcu_as_sc_mcu7t3v3__fillcap_16
XTAP_TAPCELL_ROW_198_2306 VDD VSS gf180mcu_as_sc_mcu7t3v3__tap_2
XFILLER_63_664 VDD VDD VSS VSS gf180mcu_as_sc_mcu7t3v3__fill_2
XFILLER_224_979 VDD VDD VSS VSS gf180mcu_as_sc_mcu7t3v3__fillcap_16
XFILLER_16_580 VDD VDD VSS VSS gf180mcu_as_sc_mcu7t3v3__fillcap_16
XFILLER_206_1011 VDD VDD VSS VSS gf180mcu_as_sc_mcu7t3v3__fillcap_4
XFILLER_206_1033 VDD VDD VSS VSS gf180mcu_as_sc_mcu7t3v3__fillcap_16
XFILLER_211_618 VDD VDD VSS VSS gf180mcu_as_sc_mcu7t3v3__fillcap_8
XTAP_TAPCELL_ROW_176_1903 VDD VSS gf180mcu_as_sc_mcu7t3v3__tap_2
X_5712_ VDD VDD VSS VSS _5795_/S _5712_/B _5712_/A _5713_/B gf180mcu_as_sc_mcu7t3v3__mux2_2
X_3973_ VDD VDD VSS VSS _4009_/A _4051_/A _4054_/A gf180mcu_as_sc_mcu7t3v3__and2_2
XTAP_TAPCELL_ROW_176_1914 VDD VSS gf180mcu_as_sc_mcu7t3v3__tap_2
XFILLER_31_594 VDD VDD VSS VSS gf180mcu_as_sc_mcu7t3v3__fillcap_16
X_5643_ VDD VDD VSS VSS _5643_/B _5643_/A _6447_/D gf180mcu_as_sc_mcu7t3v3__and2_2
XTAP_TAPCELL_ROW_217_2656 VDD VSS gf180mcu_as_sc_mcu7t3v3__tap_2
XTAP_TAPCELL_ROW_217_2645 VDD VSS gf180mcu_as_sc_mcu7t3v3__tap_2
XFILLER_191_503 VDD VDD VSS VSS gf180mcu_as_sc_mcu7t3v3__fill_2
X_5574_ VDD VDD VSS VSS _5881_/D _5583_/B _5574_/C _5880_/A _5575_/D gf180mcu_as_sc_mcu7t3v3__ao22_2
X_4525_ VDD VDD VSS VSS _4525_/D _4525_/A _4525_/B _4525_/C _4526_/B gf180mcu_as_sc_mcu7t3v3__ao31_2
XFILLER_117_666 VDD VDD VSS VSS gf180mcu_as_sc_mcu7t3v3__fill_1
XFILLER_172_750 VDD VDD VSS VSS gf180mcu_as_sc_mcu7t3v3__fill_1
XFILLER_49_18 VDD VDD VSS VSS gf180mcu_as_sc_mcu7t3v3__fillcap_8
X_4456_ VDD VDD VSS VSS _4546_/B _6152_/Q _4456_/A _6266_/D gf180mcu_as_sc_mcu7t3v3__mux2_2
Xfanout703 VDD VDD VSS VSS _3871_/B _3928_/B gf180mcu_as_sc_mcu7t3v3__buff_12
Xfanout714 VDD VDD VSS VSS _5840_/B _5797_/B gf180mcu_as_sc_mcu7t3v3__buff_12
X_4387_ VDD VDD VSS VSS _4394_/A _4387_/B _4387_/C _4388_/B _4408_/D gf180mcu_as_sc_mcu7t3v3__oai211_2
X_3407_ VDD VDD VSS VSS _6307_/Q _6313_/Q _4562_/B gf180mcu_as_sc_mcu7t3v3__or2_2
XPHY_EDGE_ROW_77_1_Left_305 VDD VSS gf180mcu_as_sc_mcu7t3v3__tap_2
Xfanout725 VDD VDD VSS VSS _5534_/S _5484_/B gf180mcu_as_sc_mcu7t3v3__buff_12
Xfanout736 VDD VDD VSS VSS _5532_/C _5491_/B gf180mcu_as_sc_mcu7t3v3__buff_12
Xfanout747 VDD VDD VSS VSS _3851_/B _3805_/B gf180mcu_as_sc_mcu7t3v3__buff_12
Xfanout758 VDD VDD VSS VSS _5950_/B _5936_/B gf180mcu_as_sc_mcu7t3v3__buff_12
X_6126_ VDD VDD VSS VSS _6525_/CLK _6126_/D _6126_/Q gf180mcu_as_sc_mcu7t3v3__dfxtp_2
X_3338_ VDD VDD VSS VSS _4076_/B _3338_/B _3338_/C _3338_/D _3340_/C gf180mcu_as_sc_mcu7t3v3__ao22_2
XFILLER_98_594 VDD VDD VSS VSS gf180mcu_as_sc_mcu7t3v3__fill_1
Xfanout769 VDD VDD VSS VSS _4990_/Y _5184_/B gf180mcu_as_sc_mcu7t3v3__buff_12
XFILLER_39_661 VDD VDD VSS VSS gf180mcu_as_sc_mcu7t3v3__fill_1
Xclkbuf_3_0_0_clk_regs VDD VDD VSS VSS clkbuf_0_clk_regs/Y clkbuf_3_0_0_clk_regs/Y
+ gf180mcu_as_sc_mcu7t3v3__clkbuff_12
X_6057_ VDD VDD VSS VSS _6368_/CLK _6057_/D _6057_/Q gf180mcu_as_sc_mcu7t3v3__dfxtp_2
X_3269_ VDD VDD VSS VSS _3270_/D _3277_/C _3277_/B _3269_/A gf180mcu_as_sc_mcu7t3v3__aoi21b_2
X_5008_ VDD VDD VSS VSS _5008_/B _5164_/A _6377_/D gf180mcu_as_sc_mcu7t3v3__and2_2
XFILLER_109_1218 VDD VDD VSS VSS gf180mcu_as_sc_mcu7t3v3__fill_2
XFILLER_148_1245 VDD VDD VSS VSS gf180mcu_as_sc_mcu7t3v3__fillcap_16
XFILLER_157_6 VDD VDD VSS VSS gf180mcu_as_sc_mcu7t3v3__fillcap_16
XFILLER_215_979 VDD VDD VSS VSS gf180mcu_as_sc_mcu7t3v3__fill_1
XFILLER_81_16 VDD VDD VSS VSS gf180mcu_as_sc_mcu7t3v3__fill_1
XFILLER_197_27 VDD VDD VSS VSS gf180mcu_as_sc_mcu7t3v3__fillcap_16
XFILLER_179_371 VDD VDD VSS VSS gf180mcu_as_sc_mcu7t3v3__fill_1
XFILLER_14_87 VDD VDD VSS VSS gf180mcu_as_sc_mcu7t3v3__fillcap_16
XFILLER_6_727 VDD VDD VSS VSS gf180mcu_as_sc_mcu7t3v3__fillcap_8
XFILLER_151_912 VDD VDD VSS VSS gf180mcu_as_sc_mcu7t3v3__fillcap_4
XFILLER_163_750 VDD VDD VSS VSS gf180mcu_as_sc_mcu7t3v3__fillcap_16
XFILLER_163_772 VDD VDD VSS VSS gf180mcu_as_sc_mcu7t3v3__fillcap_16
XFILLER_194_1221 VDD VDD VSS VSS gf180mcu_as_sc_mcu7t3v3__fillcap_4
XPHY_EDGE_ROW_61_1_Left_289 VDD VSS gf180mcu_as_sc_mcu7t3v3__tap_2
XFILLER_89_594 VDD VDD VSS VSS gf180mcu_as_sc_mcu7t3v3__fillcap_4
Xmesh_tile_1102 VDD VDD VSS VSS nw_out[25] gf180mcu_as_sc_mcu7t3v3__tiel_4
XFILLER_162_85 VDD VDD VSS VSS gf180mcu_as_sc_mcu7t3v3__fillcap_16
XFILLER_188_1014 VDD VDD VSS VSS gf180mcu_as_sc_mcu7t3v3__fill_1
Xmesh_tile_1135 VDD VDD VSS VSS se_out[22] gf180mcu_as_sc_mcu7t3v3__tiel_4
Xmesh_tile_1124 VDD VDD VSS VSS se_out[11] gf180mcu_as_sc_mcu7t3v3__tiel_4
Xmesh_tile_1113 VDD VDD VSS VSS se_out[0] gf180mcu_as_sc_mcu7t3v3__tiel_4
Xmesh_tile_1168 VDD VDD VSS VSS sw_out[19] gf180mcu_as_sc_mcu7t3v3__tiel_4
Xmesh_tile_1157 VDD VDD VSS VSS sw_out[8] gf180mcu_as_sc_mcu7t3v3__tiel_4
Xmesh_tile_1146 VDD VDD VSS VSS se_out[33] gf180mcu_as_sc_mcu7t3v3__tiel_4
XFILLER_205_401 VDD VDD VSS VSS gf180mcu_as_sc_mcu7t3v3__fillcap_4
XFILLER_45_664 VDD VDD VSS VSS gf180mcu_as_sc_mcu7t3v3__fill_2
Xmesh_tile_1179 VDD VDD VSS VSS sw_out[30] gf180mcu_as_sc_mcu7t3v3__tiel_4
XFILLER_178_809 VDD VDD VSS VSS gf180mcu_as_sc_mcu7t3v3__fill_1
XFILLER_189_124 VDD VDD VSS VSS gf180mcu_as_sc_mcu7t3v3__fill_2
XFILLER_206_979 VDD VDD VSS VSS gf180mcu_as_sc_mcu7t3v3__fillcap_16
XTAP_TAPCELL_ROW_193_2214 VDD VSS gf180mcu_as_sc_mcu7t3v3__tap_2
XFILLER_158_500 VDD VDD VSS VSS gf180mcu_as_sc_mcu7t3v3__fillcap_16
XFILLER_186_853 VDD VDD VSS VSS gf180mcu_as_sc_mcu7t3v3__fill_1
XFILLER_199_1154 VDD VDD VSS VSS gf180mcu_as_sc_mcu7t3v3__fillcap_16
XTAP_TAPCELL_ROW_154_1508 VDD VSS gf180mcu_as_sc_mcu7t3v3__tap_2
XTAP_TAPCELL_ROW_154_1519 VDD VSS gf180mcu_as_sc_mcu7t3v3__tap_2
XPHY_EDGE_ROW_191_Left_419 VDD VSS gf180mcu_as_sc_mcu7t3v3__tap_2
XTAP_TAPCELL_ROW_171_1811 VDD VSS gf180mcu_as_sc_mcu7t3v3__tap_2
XTAP_TAPCELL_ROW_171_1822 VDD VSS gf180mcu_as_sc_mcu7t3v3__tap_2
XTAP_TAPCELL_ROW_212_2553 VDD VSS gf180mcu_as_sc_mcu7t3v3__tap_2
XFILLER_114_625 VDD VDD VSS VSS gf180mcu_as_sc_mcu7t3v3__fill_2
XFILLER_153_260 VDD VDD VSS VSS gf180mcu_as_sc_mcu7t3v3__fillcap_16
XFILLER_153_282 VDD VDD VSS VSS gf180mcu_as_sc_mcu7t3v3__fillcap_16
Xoutput339 VDD VDD VSS VSS _6715_/Y dft_rdata[0] gf180mcu_as_sc_mcu7t3v3__buff_12
X_5290_ VDD VDD VSS VSS _5316_/S _5934_/A _5290_/A _5291_/B gf180mcu_as_sc_mcu7t3v3__mux2_2
X_4310_ VDD VDD VSS VSS _4366_/A _4310_/B _4310_/C _4311_/B _4408_/D gf180mcu_as_sc_mcu7t3v3__oai211_2
XTAP_TAPCELL_ROW_212_2564 VDD VSS gf180mcu_as_sc_mcu7t3v3__tap_2
X_4241_ VDD VDD VSS VSS _4241_/Y _4241_/B _4243_/A gf180mcu_as_sc_mcu7t3v3__nor2_2
XFILLER_171_1084 VDD VDD VSS VSS gf180mcu_as_sc_mcu7t3v3__fillcap_16
XTAP_TAPCELL_ROW_169_1784 VDD VSS gf180mcu_as_sc_mcu7t3v3__tap_2
X_4172_ VDD VDD VSS VSS _6177_/Q _6178_/Q _4173_/C gf180mcu_as_sc_mcu7t3v3__or2_2
XTAP_TAPCELL_ROW_13_1239 VDD VSS gf180mcu_as_sc_mcu7t3v3__tap_2
X_3123_ VDD VDD VSS VSS _3165_/B _6531_/Q _3372_/A gf180mcu_as_sc_mcu7t3v3__xnor2_2
XFILLER_212_1081 VDD VDD VSS VSS gf180mcu_as_sc_mcu7t3v3__fillcap_4
X_3054_ VDD VDD VSS VSS _4223_/A _6199_/Q gf180mcu_as_sc_mcu7t3v3__inv_2
XFILLER_1_1170 VDD VDD VSS VSS gf180mcu_as_sc_mcu7t3v3__fillcap_16
XFILLER_1_1192 VDD VDD VSS VSS gf180mcu_as_sc_mcu7t3v3__fillcap_16
XFILLER_211_437 VDD VDD VSS VSS gf180mcu_as_sc_mcu7t3v3__fill_2
X_3956_ VDD VDD VSS VSS _4037_/B _3981_/C _3974_/B _6058_/Q _6058_/D gf180mcu_as_sc_mcu7t3v3__ao22_2
XFILLER_178_1205 VDD VDD VSS VSS gf180mcu_as_sc_mcu7t3v3__fillcap_16
X_5626_ VDD VDD VSS VSS _5640_/B _5939_/D _5627_/D gf180mcu_as_sc_mcu7t3v3__and2_2
X_3887_ VDD VDD VSS VSS _3889_/C _5871_/A _3887_/B _3887_/C gf180mcu_as_sc_mcu7t3v3__ao21_2
XFILLER_178_1227 VDD VDD VSS VSS gf180mcu_as_sc_mcu7t3v3__fillcap_16
X_5557_ VDD VDD VSS VSS _5573_/S _5861_/A _5557_/A _5559_/C gf180mcu_as_sc_mcu7t3v3__mux2_2
XFILLER_160_720 VDD VDD VSS VSS gf180mcu_as_sc_mcu7t3v3__fill_1
XFILLER_219_1224 VDD VDD VSS VSS gf180mcu_as_sc_mcu7t3v3__fillcap_16
X_5488_ VDD VDD VSS VSS _5793_/A _5495_/B _5488_/C _5488_/D _5489_/B gf180mcu_as_sc_mcu7t3v3__ao211_2
X_4508_ VDD VDD VSS VSS _6288_/Q _4511_/D _4508_/C _4508_/D _6288_/D gf180mcu_as_sc_mcu7t3v3__ao211_2
X_4439_ VDD VDD VSS VSS _6255_/Q _4442_/B _4442_/C _6254_/Q _6254_/D gf180mcu_as_sc_mcu7t3v3__ao22_2
XFILLER_116_45 VDD VDD VSS VSS gf180mcu_as_sc_mcu7t3v3__fillcap_4
XFILLER_154_1260 VDD VDD VSS VSS gf180mcu_as_sc_mcu7t3v3__fill_1
Xfanout500 VDD VDD VSS VSS _3982_/Y _4014_/B gf180mcu_as_sc_mcu7t3v3__buff_12
Xfanout522 VDD VDD VSS VSS _3983_/Y _4014_/C gf180mcu_as_sc_mcu7t3v3__buff_12
Xfanout533 VDD VDD VSS VSS _5955_/S _5859_/S gf180mcu_as_sc_mcu7t3v3__buff_12
XTAP_TAPCELL_ROW_132_3_3047 VDD VSS gf180mcu_as_sc_mcu7t3v3__tap_2
Xfanout544 VDD VDD VSS VSS _5456_/B _5642_/S gf180mcu_as_sc_mcu7t3v3__buff_12
Xfanout555 VDD VDD VSS VSS _4864_/S _4965_/S gf180mcu_as_sc_mcu7t3v3__buff_12
Xfanout566 VDD VDD VSS VSS _3975_/B _3981_/C gf180mcu_as_sc_mcu7t3v3__buff_12
XFILLER_150_1135 VDD VDD VSS VSS gf180mcu_as_sc_mcu7t3v3__fillcap_16
XFILLER_150_1157 VDD VDD VSS VSS gf180mcu_as_sc_mcu7t3v3__fillcap_16
Xfanout577 VDD VDD VSS VSS _4061_/A _4053_/A gf180mcu_as_sc_mcu7t3v3__buff_12
Xfanout588 VDD VDD VSS VSS _5630_/B _5585_/B gf180mcu_as_sc_mcu7t3v3__buff_12
Xfanout599 VDD VDD VSS VSS _5308_/B _5218_/B gf180mcu_as_sc_mcu7t3v3__buff_12
X_6109_ VDD VDD VSS VSS _6519_/CLK _6109_/D _6109_/Q gf180mcu_as_sc_mcu7t3v3__dfxtp_2
XFILLER_6_1081 VDD VDD VSS VSS gf180mcu_as_sc_mcu7t3v3__fillcap_4
XFILLER_27_631 VDD VDD VSS VSS gf180mcu_as_sc_mcu7t3v3__fill_1
XFILLER_27_642 VDD VDD VSS VSS gf180mcu_as_sc_mcu7t3v3__fill_2
XPHY_EDGE_ROW_116_3_Left_821 VDD VSS gf180mcu_as_sc_mcu7t3v3__tap_2
XFILLER_199_444 VDD VDD VSS VSS gf180mcu_as_sc_mcu7t3v3__fill_2
XFILLER_27_664 VDD VDD VSS VSS gf180mcu_as_sc_mcu7t3v3__fill_2
XFILLER_92_37 VDD VDD VSS VSS gf180mcu_as_sc_mcu7t3v3__fillcap_8
XFILLER_215_787 VDD VDD VSS VSS gf180mcu_as_sc_mcu7t3v3__fill_1
XFILLER_74_1261 VDD VDD VSS VSS gf180mcu_as_sc_mcu7t3v3__fillcap_4
XFILLER_10_531 VDD VDD VSS VSS gf180mcu_as_sc_mcu7t3v3__fill_1
XFILLER_161_1264 VDD VDD VSS VSS gf180mcu_as_sc_mcu7t3v3__fill_1
XFILLER_167_352 VDD VDD VSS VSS gf180mcu_as_sc_mcu7t3v3__fillcap_16
XFILLER_182_300 VDD VDD VSS VSS gf180mcu_as_sc_mcu7t3v3__fill_1
XFILLER_211_982 VDD VDD VSS VSS gf180mcu_as_sc_mcu7t3v3__fillcap_16
XPHY_EDGE_ROW_151_Right_19 VDD VSS gf180mcu_as_sc_mcu7t3v3__tap_2
XFILLER_10_597 VDD VDD VSS VSS gf180mcu_as_sc_mcu7t3v3__fillcap_4
Xwire978 VDD VDD VSS VSS wire978/A _5938_/B gf180mcu_as_sc_mcu7t3v3__clkbuff_12
Xwire989 VDD VDD VSS VSS wire989/A _5728_/D gf180mcu_as_sc_mcu7t3v3__clkbuff_12
XFILLER_182_377 VDD VDD VSS VSS gf180mcu_as_sc_mcu7t3v3__fillcap_8
XFILLER_182_399 VDD VDD VSS VSS gf180mcu_as_sc_mcu7t3v3__fillcap_4
XFILLER_155_1046 VDD VDD VSS VSS gf180mcu_as_sc_mcu7t3v3__fillcap_4
XFILLER_150_241 VDD VDD VSS VSS gf180mcu_as_sc_mcu7t3v3__fillcap_4
XFILLER_150_263 VDD VDD VSS VSS gf180mcu_as_sc_mcu7t3v3__fillcap_16
XFILLER_155_1068 VDD VDD VSS VSS gf180mcu_as_sc_mcu7t3v3__fillcap_16
XFILLER_2_774 VDD VDD VSS VSS gf180mcu_as_sc_mcu7t3v3__fill_2
XFILLER_81_1210 VDD VDD VSS VSS gf180mcu_as_sc_mcu7t3v3__fill_2
XTAP_TAPCELL_ROW_186_2095 VDD VSS gf180mcu_as_sc_mcu7t3v3__tap_2
XTAP_TAPCELL_ROW_186_2084 VDD VSS gf180mcu_as_sc_mcu7t3v3__tap_2
Xclkbuf_leaf_30_clk_regs VDD VDD VSS VSS clkbuf_3_6_0_clk_regs/Y _6448_/CLK gf180mcu_as_sc_mcu7t3v3__clkbuff_12
XPHY_EDGE_ROW_160_Right_28 VDD VSS gf180mcu_as_sc_mcu7t3v3__tap_2
XPHY_EDGE_ROW_48_3_Left_753 VDD VSS gf180mcu_as_sc_mcu7t3v3__tap_2
XFILLER_225_529 VDD VDD VSS VSS gf180mcu_as_sc_mcu7t3v3__fillcap_4
XFILLER_206_743 VDD VDD VSS VSS gf180mcu_as_sc_mcu7t3v3__fill_1
XFILLER_206_754 VDD VDD VSS VSS gf180mcu_as_sc_mcu7t3v3__fillcap_16
XFILLER_33_612 VDD VDD VSS VSS gf180mcu_as_sc_mcu7t3v3__fill_1
XTAP_TAPCELL_ROW_164_1692 VDD VSS gf180mcu_as_sc_mcu7t3v3__tap_2
XFILLER_162_1006 VDD VDD VSS VSS gf180mcu_as_sc_mcu7t3v3__fillcap_8
XFILLER_221_702 VDD VDD VSS VSS gf180mcu_as_sc_mcu7t3v3__fill_1
XPHY_EDGE_ROW_107_2_Left_548 VDD VSS gf180mcu_as_sc_mcu7t3v3__tap_2
XFILLER_162_1017 VDD VDD VSS VSS gf180mcu_as_sc_mcu7t3v3__fillcap_16
X_4790_ VDD VDD VSS VSS _4837_/B _5797_/A _4791_/C gf180mcu_as_sc_mcu7t3v3__and2_2
X_3810_ VDD VDD VSS VSS _5145_/B _3810_/B _3810_/C _3810_/D _3811_/B gf180mcu_as_sc_mcu7t3v3__ao22_2
XANTENNA_18 VDD VDD VSS VSS _4865_/B gf180mcu_as_sc_mcu7t3v3__diode_2
XANTENNA_29 VDD VDD VSS VSS _5258_/A gf180mcu_as_sc_mcu7t3v3__diode_2
XFILLER_159_842 VDD VDD VSS VSS gf180mcu_as_sc_mcu7t3v3__fill_2
XFILLER_203_1014 VDD VDD VSS VSS gf180mcu_as_sc_mcu7t3v3__fillcap_16
X_3741_ VDD VDD VSS VSS _3741_/A _3741_/B _3874_/B _3741_/D _3743_/A gf180mcu_as_sc_mcu7t3v3__ao211_2
XFILLER_13_380 VDD VDD VSS VSS gf180mcu_as_sc_mcu7t3v3__fill_2
XFILLER_192_119 VDD VDD VSS VSS gf180mcu_as_sc_mcu7t3v3__fill_2
XFILLER_201_492 VDD VDD VSS VSS gf180mcu_as_sc_mcu7t3v3__fillcap_16
X_6460_ VDD VDD VSS VSS _6474_/CLK _6460_/D _6460_/Q gf180mcu_as_sc_mcu7t3v3__dfxtp_2
X_3672_ VDD VDD VSS VSS _3806_/S _5684_/A _3673_/D gf180mcu_as_sc_mcu7t3v3__and2_2
X_6391_ VDD VDD VSS VSS _6412_/CLK _6391_/D _6391_/Q gf180mcu_as_sc_mcu7t3v3__dfxtp_2
X_5411_ VDD VDD VSS VSS _5496_/B _5720_/A _5412_/D gf180mcu_as_sc_mcu7t3v3__and2_2
X_5342_ VDD VDD VSS VSS _5359_/B _5367_/C _5654_/C gf180mcu_as_sc_mcu7t3v3__nor2_2
XFILLER_217_66 VDD VDD VSS VSS gf180mcu_as_sc_mcu7t3v3__fillcap_4
XFILLER_217_88 VDD VDD VSS VSS gf180mcu_as_sc_mcu7t3v3__fillcap_16
X_5273_ VDD VDD VSS VSS _5914_/A _5304_/B _5273_/C _5273_/D _5274_/C gf180mcu_as_sc_mcu7t3v3__ao211_2
X_4224_ VDD VDD VSS VSS _4225_/C _4224_/B _4224_/A gf180mcu_as_sc_mcu7t3v3__nor2_2
XFILLER_228_312 VDD VDD VSS VSS gf180mcu_as_sc_mcu7t3v3__fill_2
X_4155_ VDD VDD VSS VSS _4336_/B _4215_/A _4223_/B gf180mcu_as_sc_mcu7t3v3__and2_2
X_3106_ VDD VDD VSS VSS _4607_/A _3161_/A _3154_/A gf180mcu_as_sc_mcu7t3v3__nand2_2
XFILLER_209_581 VDD VDD VSS VSS gf180mcu_as_sc_mcu7t3v3__fill_2
X_4086_ VDD VDD VSS VSS _4089_/S _6715_/A _6146_/Q _6146_/D gf180mcu_as_sc_mcu7t3v3__mux2_2
XTAP_TAPCELL_ROW_225_2799 VDD VSS gf180mcu_as_sc_mcu7t3v3__tap_2
XTAP_TAPCELL_ROW_225_2788 VDD VSS gf180mcu_as_sc_mcu7t3v3__tap_2
XFILLER_58_1212 VDD VDD VSS VSS gf180mcu_as_sc_mcu7t3v3__fill_1
X_3037_ VDD VDD VSS VSS _5917_/A _3632_/B gf180mcu_as_sc_mcu7t3v3__inv_2
XFILLER_24_623 VDD VDD VSS VSS gf180mcu_as_sc_mcu7t3v3__fillcap_4
XFILLER_58_1245 VDD VDD VSS VSS gf180mcu_as_sc_mcu7t3v3__fillcap_16
XFILLER_12_807 VDD VDD VSS VSS gf180mcu_as_sc_mcu7t3v3__fillcap_16
XFILLER_145_1226 VDD VDD VSS VSS gf180mcu_as_sc_mcu7t3v3__fill_2
XFILLER_211_212 VDD VDD VSS VSS gf180mcu_as_sc_mcu7t3v3__fill_2
XFILLER_145_1259 VDD VDD VSS VSS gf180mcu_as_sc_mcu7t3v3__fill_2
X_4988_ VDD VDD VSS VSS _5188_/B _5001_/B _5001_/A gf180mcu_as_sc_mcu7t3v3__nor2b_2
X_3939_ VDD VDD VSS VSS _3963_/B _6046_/Q _3940_/C gf180mcu_as_sc_mcu7t3v3__and2_2
XFILLER_180_804 VDD VDD VSS VSS gf180mcu_as_sc_mcu7t3v3__fill_1
XFILLER_192_664 VDD VDD VSS VSS gf180mcu_as_sc_mcu7t3v3__fill_1
XFILLER_192_675 VDD VDD VSS VSS gf180mcu_as_sc_mcu7t3v3__fillcap_4
XPHY_EDGE_ROW_140_2_Right_977 VDD VSS gf180mcu_as_sc_mcu7t3v3__tap_2
X_5609_ VDD VDD VSS VSS _5921_/A _5638_/B _5615_/C _5921_/D _5610_/C gf180mcu_as_sc_mcu7t3v3__ao22_2
XTAP_TAPCELL_ROW_108_1_1375 VDD VSS gf180mcu_as_sc_mcu7t3v3__tap_2
XFILLER_11_88 VDD VDD VSS VSS gf180mcu_as_sc_mcu7t3v3__fillcap_16
XFILLER_191_1224 VDD VDD VSS VSS gf180mcu_as_sc_mcu7t3v3__fillcap_8
XFILLER_87_37 VDD VDD VSS VSS gf180mcu_as_sc_mcu7t3v3__fillcap_8
XPHY_EDGE_ROW_90_2_Left_531 VDD VSS gf180mcu_as_sc_mcu7t3v3__tap_2
XFILLER_219_301 VDD VDD VSS VSS gf180mcu_as_sc_mcu7t3v3__fillcap_4
XFILLER_219_356 VDD VDD VSS VSS gf180mcu_as_sc_mcu7t3v3__fill_1
XTAP_TAPCELL_ROW_9_1182 VDD VSS gf180mcu_as_sc_mcu7t3v3__tap_2
XTAP_TAPCELL_ROW_9_1171 VDD VSS gf180mcu_as_sc_mcu7t3v3__tap_2
XFILLER_15_601 VDD VDD VSS VSS gf180mcu_as_sc_mcu7t3v3__fillcap_8
XFILLER_189_1186 VDD VDD VSS VSS gf180mcu_as_sc_mcu7t3v3__fillcap_4
XFILLER_15_623 VDD VDD VSS VSS gf180mcu_as_sc_mcu7t3v3__fillcap_4
XFILLER_203_702 VDD VDD VSS VSS gf180mcu_as_sc_mcu7t3v3__fillcap_8
XFILLER_215_562 VDD VDD VSS VSS gf180mcu_as_sc_mcu7t3v3__fillcap_8
XFILLER_226_1014 VDD VDD VSS VSS gf180mcu_as_sc_mcu7t3v3__fill_1
XFILLER_14_155 VDD VDD VSS VSS gf180mcu_as_sc_mcu7t3v3__fillcap_16
XFILLER_15_656 VDD VDD VSS VSS gf180mcu_as_sc_mcu7t3v3__fillcap_8
XFILLER_202_201 VDD VDD VSS VSS gf180mcu_as_sc_mcu7t3v3__fill_1
XFILLER_14_177 VDD VDD VSS VSS gf180mcu_as_sc_mcu7t3v3__fillcap_16
XFILLER_203_768 VDD VDD VSS VSS gf180mcu_as_sc_mcu7t3v3__fill_2
XFILLER_30_626 VDD VDD VSS VSS gf180mcu_as_sc_mcu7t3v3__fill_1
XFILLER_156_834 VDD VDD VSS VSS gf180mcu_as_sc_mcu7t3v3__fillcap_16
XFILLER_7_833 VDD VDD VSS VSS gf180mcu_as_sc_mcu7t3v3__fillcap_4
Xinput16 VDD VDD VSS VSS boot_addr[8] _3294_/A gf180mcu_as_sc_mcu7t3v3__buff_12
Xinput27 VDD VDD VSS VSS boot_wen _3213_/B gf180mcu_as_sc_mcu7t3v3__buff_12
XFILLER_196_1135 VDD VDD VSS VSS gf180mcu_as_sc_mcu7t3v3__fillcap_16
Xinput38 VDD VDD VSS VSS dft_addr[9] _3299_/B gf180mcu_as_sc_mcu7t3v3__buff_12
Xinput49 VDD VDD VSS VSS dft_we _3089_/A gf180mcu_as_sc_mcu7t3v3__buff_12
XFILLER_170_303 VDD VDD VSS VSS gf180mcu_as_sc_mcu7t3v3__fillcap_8
XFILLER_182_174 VDD VDD VSS VSS gf180mcu_as_sc_mcu7t3v3__fill_1
XFILLER_196_1157 VDD VDD VSS VSS gf180mcu_as_sc_mcu7t3v3__fillcap_16
XFILLER_6_387 VDD VDD VSS VSS gf180mcu_as_sc_mcu7t3v3__fillcap_4
XTAP_TAPCELL_ROW_188_2124 VDD VSS gf180mcu_as_sc_mcu7t3v3__tap_2
XFILLER_151_550 VDD VDD VSS VSS gf180mcu_as_sc_mcu7t3v3__fillcap_8
XTAP_TAPCELL_ROW_149_1407 VDD VSS gf180mcu_as_sc_mcu7t3v3__tap_2
XTAP_TAPCELL_ROW_149_1418 VDD VSS gf180mcu_as_sc_mcu7t3v3__tap_2
XTAP_TAPCELL_ROW_149_1429 VDD VSS gf180mcu_as_sc_mcu7t3v3__tap_2
XTAP_TAPCELL_ROW_166_1721 VDD VSS gf180mcu_as_sc_mcu7t3v3__tap_2
XTAP_TAPCELL_ROW_166_1732 VDD VSS gf180mcu_as_sc_mcu7t3v3__tap_2
XFILLER_219_890 VDD VDD VSS VSS gf180mcu_as_sc_mcu7t3v3__fill_2
XTAP_TAPCELL_ROW_207_2474 VDD VSS gf180mcu_as_sc_mcu7t3v3__tap_2
XTAP_TAPCELL_ROW_207_2463 VDD VSS gf180mcu_as_sc_mcu7t3v3__tap_2
XFILLER_168_1259 VDD VDD VSS VSS gf180mcu_as_sc_mcu7t3v3__fill_2
XFILLER_225_337 VDD VDD VSS VSS gf180mcu_as_sc_mcu7t3v3__fill_2
X_5960_ VDD VDD VSS VSS _6486_/D _5960_/C _5960_/B _5960_/A gf180mcu_as_sc_mcu7t3v3__aoi21_2
XFILLER_209_1234 VDD VDD VSS VSS gf180mcu_as_sc_mcu7t3v3__fill_1
X_5891_ VDD VDD VSS VSS _5891_/A _5953_/B _5891_/C _5891_/D _5892_/B gf180mcu_as_sc_mcu7t3v3__ao211_2
X_4911_ VDD VDD VSS VSS _4965_/S _4911_/B _5901_/A _4912_/B gf180mcu_as_sc_mcu7t3v3__mux2_2
XFILLER_221_521 VDD VDD VSS VSS gf180mcu_as_sc_mcu7t3v3__fill_2
XTAP_TAPCELL_ROW_220_2696 VDD VSS gf180mcu_as_sc_mcu7t3v3__tap_2
X_4842_ VDD VDD VSS VSS _5841_/A _4842_/B _4842_/C _5837_/A _4843_/D gf180mcu_as_sc_mcu7t3v3__ao22_2
XFILLER_105_1210 VDD VDD VSS VSS gf180mcu_as_sc_mcu7t3v3__fillcap_4
XFILLER_21_659 VDD VDD VSS VSS gf180mcu_as_sc_mcu7t3v3__fill_2
XPHY_EDGE_ROW_86_1_Left_314 VDD VSS gf180mcu_as_sc_mcu7t3v3__tap_2
X_4773_ VDD VDD VSS VSS _5784_/A _4838_/B _4773_/C _4945_/C _4776_/B gf180mcu_as_sc_mcu7t3v3__ao211_2
XFILLER_158_171 VDD VDD VSS VSS gf180mcu_as_sc_mcu7t3v3__fillcap_4
X_6512_ VDD VDD VSS VSS _6519_/CLK _6512_/D _6512_/Q gf180mcu_as_sc_mcu7t3v3__dfxtp_2
X_3724_ VDD VDD VSS VSS _6022_/D _3724_/C _3830_/D _4028_/A gf180mcu_as_sc_mcu7t3v3__ao21b_2
XFILLER_158_193 VDD VDD VSS VSS gf180mcu_as_sc_mcu7t3v3__fillcap_16
XFILLER_162_804 VDD VDD VSS VSS gf180mcu_as_sc_mcu7t3v3__fill_1
XFILLER_174_664 VDD VDD VSS VSS gf180mcu_as_sc_mcu7t3v3__fill_1
XFILLER_88_1238 VDD VDD VSS VSS gf180mcu_as_sc_mcu7t3v3__fillcap_4
X_6443_ VDD VDD VSS VSS _6448_/CLK _6443_/D _6443_/Q gf180mcu_as_sc_mcu7t3v3__dfxtp_2
X_3655_ VDD VDD VSS VSS _3655_/A _3655_/B _3655_/C _3655_/Y gf180mcu_as_sc_mcu7t3v3__nor3_2
XTAP_TAPCELL_ROW_30_1_1336 VDD VSS gf180mcu_as_sc_mcu7t3v3__tap_2
XFILLER_161_314 VDD VDD VSS VSS gf180mcu_as_sc_mcu7t3v3__fillcap_16
XFILLER_162_848 VDD VDD VSS VSS gf180mcu_as_sc_mcu7t3v3__fill_1
XFILLER_175_1208 VDD VDD VSS VSS gf180mcu_as_sc_mcu7t3v3__fillcap_16
XFILLER_228_76 VDD VDD VSS VSS gf180mcu_as_sc_mcu7t3v3__fill_1
X_6374_ VDD VDD VSS VSS _6376_/CLK _6374_/D _6374_/Q gf180mcu_as_sc_mcu7t3v3__dfxtp_2
X_3586_ VDD VDD VSS VSS _4979_/A _3637_/A _6523_/Q _3591_/A _6524_/Q gf180mcu_as_sc_mcu7t3v3__aoi22_2
XFILLER_216_1205 VDD VDD VSS VSS gf180mcu_as_sc_mcu7t3v3__fillcap_16
XFILLER_216_1227 VDD VDD VSS VSS gf180mcu_as_sc_mcu7t3v3__fillcap_16
X_5325_ VDD VDD VSS VSS _5325_/A _5325_/B _5646_/B _5325_/D _5362_/A gf180mcu_as_sc_mcu7t3v3__ao211_2
XFILLER_142_594 VDD VDD VSS VSS gf180mcu_as_sc_mcu7t3v3__fillcap_8
X_5256_ VDD VDD VSS VSS _5257_/D _5256_/C _5309_/B _5895_/A gf180mcu_as_sc_mcu7t3v3__aoi21b_2
XFILLER_57_18 VDD VDD VSS VSS gf180mcu_as_sc_mcu7t3v3__fillcap_4
X_4207_ VDD VDD VSS VSS _4211_/C _4207_/C _4215_/A _4223_/A gf180mcu_as_sc_mcu7t3v3__aoi21_2
XTAP_TAPCELL_ROW_227_2828 VDD VSS gf180mcu_as_sc_mcu7t3v3__tap_2
XFILLER_217_805 VDD VDD VSS VSS gf180mcu_as_sc_mcu7t3v3__fill_2
XFILLER_228_142 VDD VDD VSS VSS gf180mcu_as_sc_mcu7t3v3__fill_2
X_5187_ VDD VDD VSS VSS _5187_/S _5187_/B _6513_/Q _5189_/C gf180mcu_as_sc_mcu7t3v3__mux2_2
X_4138_ VDD VDD VSS VSS _4140_/S _6188_/Q _6187_/Q _6187_/D gf180mcu_as_sc_mcu7t3v3__mux2_2
X_4069_ VDD VDD VSS VSS _4071_/A _4069_/C _4070_/B _4462_/A gf180mcu_as_sc_mcu7t3v3__aoi21_2
XFILLER_3_1084 VDD VDD VSS VSS gf180mcu_as_sc_mcu7t3v3__fillcap_16
XFILLER_149_1192 VDD VDD VSS VSS gf180mcu_as_sc_mcu7t3v3__fillcap_16
XTAP_TAPCELL_ROW_4_1090 VDD VSS gf180mcu_as_sc_mcu7t3v3__tap_2
XFILLER_212_554 VDD VDD VSS VSS gf180mcu_as_sc_mcu7t3v3__fill_1
XFILLER_11_136 VDD VDD VSS VSS gf180mcu_as_sc_mcu7t3v3__fillcap_4
XFILLER_12_648 VDD VDD VSS VSS gf180mcu_as_sc_mcu7t3v3__fillcap_4
XFILLER_200_727 VDD VDD VSS VSS gf180mcu_as_sc_mcu7t3v3__fillcap_8
XFILLER_200_749 VDD VDD VSS VSS gf180mcu_as_sc_mcu7t3v3__fill_2
XPHY_EDGE_ROW_70_1_Left_298 VDD VSS gf180mcu_as_sc_mcu7t3v3__tap_2
XFILLER_11_158 VDD VDD VSS VSS gf180mcu_as_sc_mcu7t3v3__fillcap_16
XFILLER_192_450 VDD VDD VSS VSS gf180mcu_as_sc_mcu7t3v3__fillcap_4
XFILLER_193_973 VDD VDD VSS VSS gf180mcu_as_sc_mcu7t3v3__fillcap_4
XFILLER_153_837 VDD VDD VSS VSS gf180mcu_as_sc_mcu7t3v3__fill_2
XFILLER_192_461 VDD VDD VSS VSS gf180mcu_as_sc_mcu7t3v3__fill_1
XFILLER_4_803 VDD VDD VSS VSS gf180mcu_as_sc_mcu7t3v3__fill_2
XTAP_TAPCELL_ROW_120_3_3029 VDD VSS gf180mcu_as_sc_mcu7t3v3__tap_2
XFILLER_180_634 VDD VDD VSS VSS gf180mcu_as_sc_mcu7t3v3__fill_2
XPHY_EDGE_ROW_141_2_Right_978 VDD VSS gf180mcu_as_sc_mcu7t3v3__tap_2
XFILLER_3_379 VDD VDD VSS VSS gf180mcu_as_sc_mcu7t3v3__fill_2
XFILLER_133_594 VDD VDD VSS VSS gf180mcu_as_sc_mcu7t3v3__fill_2
XFILLER_154_53 VDD VDD VSS VSS gf180mcu_as_sc_mcu7t3v3__fillcap_16
XFILLER_152_1049 VDD VDD VSS VSS gf180mcu_as_sc_mcu7t3v3__fillcap_16
XTAP_TAPCELL_ROW_183_2043 VDD VSS gf180mcu_as_sc_mcu7t3v3__tap_2
XTAP_TAPCELL_ROW_183_2032 VDD VSS gf180mcu_as_sc_mcu7t3v3__tap_2
XFILLER_219_142 VDD VDD VSS VSS gf180mcu_as_sc_mcu7t3v3__fill_2
XFILLER_94_629 VDD VDD VSS VSS gf180mcu_as_sc_mcu7t3v3__fill_2
XFILLER_170_30 VDD VDD VSS VSS gf180mcu_as_sc_mcu7t3v3__fillcap_4
XFILLER_170_85 VDD VDD VSS VSS gf180mcu_as_sc_mcu7t3v3__fillcap_16
XFILLER_216_871 VDD VDD VSS VSS gf180mcu_as_sc_mcu7t3v3__fillcap_4
XTAP_TAPCELL_ROW_161_1640 VDD VSS gf180mcu_as_sc_mcu7t3v3__tap_2
XFILLER_128_1210 VDD VDD VSS VSS gf180mcu_as_sc_mcu7t3v3__fillcap_16
XFILLER_15_442 VDD VDD VSS VSS gf180mcu_as_sc_mcu7t3v3__fillcap_4
XFILLER_16_954 VDD VDD VSS VSS gf180mcu_as_sc_mcu7t3v3__fillcap_16
XFILLER_203_510 VDD VDD VSS VSS gf180mcu_as_sc_mcu7t3v3__fillcap_4
XTAP_TAPCELL_ROW_202_2382 VDD VSS gf180mcu_as_sc_mcu7t3v3__tap_2
XTAP_TAPCELL_ROW_202_2371 VDD VSS gf180mcu_as_sc_mcu7t3v3__tap_2
XFILLER_175_417 VDD VDD VSS VSS gf180mcu_as_sc_mcu7t3v3__fill_2
XFILLER_179_72 VDD VDD VSS VSS gf180mcu_as_sc_mcu7t3v3__fill_2
XFILLER_156_664 VDD VDD VSS VSS gf180mcu_as_sc_mcu7t3v3__fill_1
XFILLER_200_1017 VDD VDD VSS VSS gf180mcu_as_sc_mcu7t3v3__fillcap_16
XFILLER_13_1170 VDD VDD VSS VSS gf180mcu_as_sc_mcu7t3v3__fillcap_16
XFILLER_155_174 VDD VDD VSS VSS gf180mcu_as_sc_mcu7t3v3__fillcap_16
XFILLER_7_674 VDD VDD VSS VSS gf180mcu_as_sc_mcu7t3v3__fillcap_4
XFILLER_13_1192 VDD VDD VSS VSS gf180mcu_as_sc_mcu7t3v3__fillcap_16
X_3440_ VDD VDD VSS VSS _6550_/D _3440_/B _6325_/Q _6324_/D gf180mcu_as_sc_mcu7t3v3__mux2_2
XFILLER_170_155 VDD VDD VSS VSS gf180mcu_as_sc_mcu7t3v3__fillcap_16
X_3371_ VDD VDD VSS VSS _6527_/Q _3371_/B _3371_/A _3371_/Y gf180mcu_as_sc_mcu7t3v3__mux2_2
XFILLER_124_594 VDD VDD VSS VSS gf180mcu_as_sc_mcu7t3v3__fillcap_4
XFILLER_135_1214 VDD VDD VSS VSS gf180mcu_as_sc_mcu7t3v3__fill_1
XFILLER_170_177 VDD VDD VSS VSS gf180mcu_as_sc_mcu7t3v3__fillcap_16
X_6090_ VDD VDD VSS VSS _6506_/CLK _6090_/D _6090_/Q gf180mcu_as_sc_mcu7t3v3__dfxtp_2
X_5110_ VDD VDD VSS VSS _5110_/B _5164_/A _6388_/D gf180mcu_as_sc_mcu7t3v3__and2_2
XTAP_TAPCELL_ROW_209_2503 VDD VSS gf180mcu_as_sc_mcu7t3v3__tap_2
X_5041_ VDD VDD VSS VSS _5710_/A _5143_/B _5143_/C _5710_/D _5042_/D gf180mcu_as_sc_mcu7t3v3__ao22_2
XPHY_EDGE_ROW_103_2_Right_940 VDD VSS gf180mcu_as_sc_mcu7t3v3__tap_2
XFILLER_168_1012 VDD VDD VSS VSS gf180mcu_as_sc_mcu7t3v3__fill_2
XTAP_TAPCELL_ROW_222_2736 VDD VSS gf180mcu_as_sc_mcu7t3v3__tap_2
XFILLER_226_679 VDD VDD VSS VSS gf180mcu_as_sc_mcu7t3v3__fill_1
XFILLER_206_370 VDD VDD VSS VSS gf180mcu_as_sc_mcu7t3v3__fill_2
X_5943_ VDD VDD VSS VSS _6523_/Q _5950_/B _5950_/C _5943_/D _5944_/C gf180mcu_as_sc_mcu7t3v3__ao22_2
X_5874_ VDD VDD VSS VSS _5874_/A _5874_/B _5874_/C _5874_/D _5875_/B gf180mcu_as_sc_mcu7t3v3__ao211_2
XTAP_TAPCELL_ROW_179_1956 VDD VSS gf180mcu_as_sc_mcu7t3v3__tap_2
XFILLER_178_244 VDD VDD VSS VSS gf180mcu_as_sc_mcu7t3v3__fill_1
XFILLER_194_704 VDD VDD VSS VSS gf180mcu_as_sc_mcu7t3v3__fillcap_4
X_4825_ VDD VDD VSS VSS _4965_/S _4825_/B _5827_/A _4826_/B gf180mcu_as_sc_mcu7t3v3__mux2_2
XTAP_TAPCELL_ROW_179_1967 VDD VSS gf180mcu_as_sc_mcu7t3v3__tap_2
XFILLER_194_737 VDD VDD VSS VSS gf180mcu_as_sc_mcu7t3v3__fillcap_16
XFILLER_147_642 VDD VDD VSS VSS gf180mcu_as_sc_mcu7t3v3__fill_2
XFILLER_147_664 VDD VDD VSS VSS gf180mcu_as_sc_mcu7t3v3__fill_2
XFILLER_181_409 VDD VDD VSS VSS gf180mcu_as_sc_mcu7t3v3__fill_1
X_4756_ VDD VDD VSS VSS _5104_/A _4878_/B _4756_/C _4757_/D _4851_/B gf180mcu_as_sc_mcu7t3v3__aoi211_2
X_4687_ VDD VDD VSS VSS _4687_/B _5977_/A _6344_/D gf180mcu_as_sc_mcu7t3v3__and2_2
X_3707_ VDD VDD VSS VSS _3805_/B _5715_/A _3708_/D gf180mcu_as_sc_mcu7t3v3__and2_2
XFILLER_190_943 VDD VDD VSS VSS gf180mcu_as_sc_mcu7t3v3__fill_2
XPHY_EDGE_ROW_125_3_Left_830 VDD VSS gf180mcu_as_sc_mcu7t3v3__tap_2
X_6426_ VDD VDD VSS VSS _6437_/CLK _6426_/D _6426_/Q gf180mcu_as_sc_mcu7t3v3__dfxtp_2
X_3638_ VDD VDD VSS VSS _4651_/C _5955_/A _3638_/A gf180mcu_as_sc_mcu7t3v3__nor2_2
XFILLER_150_807 VDD VDD VSS VSS gf180mcu_as_sc_mcu7t3v3__fillcap_16
XFILLER_162_678 VDD VDD VSS VSS gf180mcu_as_sc_mcu7t3v3__fill_2
XFILLER_162_689 VDD VDD VSS VSS gf180mcu_as_sc_mcu7t3v3__fill_1
X_6357_ VDD VDD VSS VSS _6365_/CLK _6357_/D _6357_/Q gf180mcu_as_sc_mcu7t3v3__dfxtp_2
X_3569_ VDD VDD VSS VSS _3570_/A _3570_/B _4619_/C _3573_/D _4619_/D gf180mcu_as_sc_mcu7t3v3__aoi211_2
XFILLER_115_594 VDD VDD VSS VSS gf180mcu_as_sc_mcu7t3v3__fillcap_8
XFILLER_1_839 VDD VDD VSS VSS gf180mcu_as_sc_mcu7t3v3__fill_1
X_5308_ VDD VDD VSS VSS _5308_/B _5954_/A _5315_/C gf180mcu_as_sc_mcu7t3v3__and2_2
Xinput206 VDD VDD VSS VSS se_in[1] _5686_/A gf180mcu_as_sc_mcu7t3v3__buff_12
Xinput217 VDD VDD VSS VSS se_in[2] _5694_/A gf180mcu_as_sc_mcu7t3v3__buff_12
X_6288_ VDD VDD VSS VSS clkload7/A _6288_/D _6288_/Q gf180mcu_as_sc_mcu7t3v3__dfxtp_2
XFILLER_124_45 VDD VDD VSS VSS gf180mcu_as_sc_mcu7t3v3__fillcap_4
Xinput228 VDD VDD VSS VSS se_in[7] _5736_/A gf180mcu_as_sc_mcu7t3v3__buff_12
Xinput239 VDD VDD VSS VSS south_in[17] _5815_/A gf180mcu_as_sc_mcu7t3v3__buff_12
X_5239_ VDD VDD VSS VSS _5304_/B _5891_/A _5246_/C gf180mcu_as_sc_mcu7t3v3__and2_2
XFILLER_216_101 VDD VDD VSS VSS gf180mcu_as_sc_mcu7t3v3__fillcap_4
XTAP_TAPCELL_ROW_6_1130 VDD VSS gf180mcu_as_sc_mcu7t3v3__tap_2
XFILLER_16_206 VDD VDD VSS VSS gf180mcu_as_sc_mcu7t3v3__fillcap_16
XFILLER_140_22 VDD VDD VSS VSS gf180mcu_as_sc_mcu7t3v3__fillcap_8
XFILLER_17_43 VDD VDD VSS VSS gf180mcu_as_sc_mcu7t3v3__fillcap_8
XFILLER_216_145 VDD VDD VSS VSS gf180mcu_as_sc_mcu7t3v3__fill_2
XFILLER_186_1189 VDD VDD VSS VSS gf180mcu_as_sc_mcu7t3v3__fillcap_16
XFILLER_204_329 VDD VDD VSS VSS gf180mcu_as_sc_mcu7t3v3__fillcap_4
XTAP_TAPCELL_ROW_2_1049 VDD VSS gf180mcu_as_sc_mcu7t3v3__tap_2
XFILLER_157_406 VDD VDD VSS VSS gf180mcu_as_sc_mcu7t3v3__fillcap_4
XFILLER_197_575 VDD VDD VSS VSS gf180mcu_as_sc_mcu7t3v3__fill_1
XFILLER_227_1186 VDD VDD VSS VSS gf180mcu_as_sc_mcu7t3v3__fillcap_4
XFILLER_9_906 VDD VDD VSS VSS gf180mcu_as_sc_mcu7t3v3__fillcap_4
XFILLER_9_928 VDD VDD VSS VSS gf180mcu_as_sc_mcu7t3v3__fillcap_16
XFILLER_149_86 VDD VDD VSS VSS gf180mcu_as_sc_mcu7t3v3__fillcap_16
XFILLER_166_962 VDD VDD VSS VSS gf180mcu_as_sc_mcu7t3v3__fill_1
XFILLER_184_247 VDD VDD VSS VSS gf180mcu_as_sc_mcu7t3v3__fillcap_8
XFILLER_228_2 VDD VDD VSS VSS gf180mcu_as_sc_mcu7t3v3__fillcap_4
XTAP_TAPCELL_ROW_138_3_3056 VDD VSS gf180mcu_as_sc_mcu7t3v3__tap_2
XFILLER_165_461 VDD VDD VSS VSS gf180mcu_as_sc_mcu7t3v3__fillcap_16
XPHY_EDGE_ROW_57_3_Left_762 VDD VSS gf180mcu_as_sc_mcu7t3v3__tap_2
XFILLER_192_280 VDD VDD VSS VSS gf180mcu_as_sc_mcu7t3v3__fill_1
XFILLER_193_1116 VDD VDD VSS VSS gf180mcu_as_sc_mcu7t3v3__fillcap_4
XFILLER_152_155 VDD VDD VSS VSS gf180mcu_as_sc_mcu7t3v3__fillcap_16
XFILLER_158_1258 VDD VDD VSS VSS gf180mcu_as_sc_mcu7t3v3__fill_2
XFILLER_181_998 VDD VDD VSS VSS gf180mcu_as_sc_mcu7t3v3__fillcap_16
XFILLER_193_1138 VDD VDD VSS VSS gf180mcu_as_sc_mcu7t3v3__fillcap_16
XPHY_EDGE_ROW_142_2_Right_979 VDD VSS gf180mcu_as_sc_mcu7t3v3__tap_2
XFILLER_152_177 VDD VDD VSS VSS gf180mcu_as_sc_mcu7t3v3__fillcap_16
XPHY_EDGE_ROW_116_2_Left_557 VDD VSS gf180mcu_as_sc_mcu7t3v3__tap_2
XTAP_TAPCELL_ROW_55_2_2931 VDD VSS gf180mcu_as_sc_mcu7t3v3__tap_2
XFILLER_208_657 VDD VDD VSS VSS gf180mcu_as_sc_mcu7t3v3__fill_1
XTAP_TAPCELL_ROW_204_2422 VDD VSS gf180mcu_as_sc_mcu7t3v3__tap_2
XTAP_TAPCELL_ROW_204_2411 VDD VSS gf180mcu_as_sc_mcu7t3v3__tap_2
XFILLER_207_156 VDD VDD VSS VSS gf180mcu_as_sc_mcu7t3v3__fill_2
XFILLER_16_784 VDD VDD VSS VSS gf180mcu_as_sc_mcu7t3v3__fillcap_16
XFILLER_200_69 VDD VDD VSS VSS gf180mcu_as_sc_mcu7t3v3__fillcap_16
XFILLER_204_874 VDD VDD VSS VSS gf180mcu_as_sc_mcu7t3v3__fill_1
XFILLER_204_885 VDD VDD VSS VSS gf180mcu_as_sc_mcu7t3v3__fillcap_4
XTAP_TAPCELL_ROW_196_2278 VDD VSS gf180mcu_as_sc_mcu7t3v3__tap_2
XTAP_TAPCELL_ROW_196_2267 VDD VSS gf180mcu_as_sc_mcu7t3v3__tap_2
XFILLER_188_597 VDD VDD VSS VSS gf180mcu_as_sc_mcu7t3v3__fillcap_4
X_4610_ VDD VDD VSS VSS _4611_/B _4610_/C _4610_/B _4610_/A gf180mcu_as_sc_mcu7t3v3__aoi21_2
XFILLER_15_1232 VDD VDD VSS VSS gf180mcu_as_sc_mcu7t3v3__fill_2
XFILLER_163_409 VDD VDD VSS VSS gf180mcu_as_sc_mcu7t3v3__fillcap_8
X_5590_ VDD VDD VSS VSS _5899_/A _5640_/B _5590_/C _5590_/D _5592_/C gf180mcu_as_sc_mcu7t3v3__ao211_2
XFILLER_129_664 VDD VDD VSS VSS gf180mcu_as_sc_mcu7t3v3__fill_2
XFILLER_191_729 VDD VDD VSS VSS gf180mcu_as_sc_mcu7t3v3__fillcap_4
XFILLER_198_1049 VDD VDD VSS VSS gf180mcu_as_sc_mcu7t3v3__fillcap_16
XFILLER_7_460 VDD VDD VSS VSS gf180mcu_as_sc_mcu7t3v3__fill_1
XTAP_TAPCELL_ROW_174_1875 VDD VSS gf180mcu_as_sc_mcu7t3v3__tap_2
X_4541_ VDD VDD VSS VSS _4552_/B _4542_/B _4546_/B gf180mcu_as_sc_mcu7t3v3__nor2_2
XFILLER_209_67 VDD VDD VSS VSS gf180mcu_as_sc_mcu7t3v3__fill_2
X_4472_ VDD VDD VSS VSS _4477_/B _4472_/B _6275_/Q _6275_/D gf180mcu_as_sc_mcu7t3v3__mux2_2
XPHY_EDGE_ROW_48_2_Left_489 VDD VSS gf180mcu_as_sc_mcu7t3v3__tap_2
X_6211_ VDD VDD VSS VSS _6506_/CLK _6211_/D _6211_/Q gf180mcu_as_sc_mcu7t3v3__dfxtp_2
X_3423_ VDD VDD VSS VSS _3423_/B _3423_/A _4443_/A gf180mcu_as_sc_mcu7t3v3__xnor2_2
Xfanout907 VDD VDD VSS VSS _6261_/Q _4509_/B gf180mcu_as_sc_mcu7t3v3__buff_12
X_6142_ VDD VDD VSS VSS _6517_/CLK _6142_/D _6142_/Q gf180mcu_as_sc_mcu7t3v3__dfxtp_2
XFILLER_213_1208 VDD VDD VSS VSS gf180mcu_as_sc_mcu7t3v3__fillcap_16
Xfanout918 VDD VDD VSS VSS _4293_/S _4335_/S gf180mcu_as_sc_mcu7t3v3__buff_12
Xfanout929 VDD VDD VSS VSS _5506_/A _5396_/A gf180mcu_as_sc_mcu7t3v3__buff_12
X_3354_ VDD VDD VSS VSS _4076_/B _3354_/B _3354_/C _3354_/D _3356_/C gf180mcu_as_sc_mcu7t3v3__ao22_2
XTAP_TAPCELL_ROW_90_2_2983 VDD VSS gf180mcu_as_sc_mcu7t3v3__tap_2
X_6073_ VDD VDD VSS VSS _6486_/CLK _6073_/D _6073_/Q gf180mcu_as_sc_mcu7t3v3__dfxtp_2
X_3285_ VDD VDD VSS VSS _3286_/C _3285_/C _3285_/B _3343_/A gf180mcu_as_sc_mcu7t3v3__aoi21b_2
X_5024_ VDD VDD VSS VSS _5694_/A _5144_/B _5024_/C _5024_/D _5025_/A gf180mcu_as_sc_mcu7t3v3__ao211_2
XPHY_EDGE_ROW_104_2_Right_941 VDD VSS gf180mcu_as_sc_mcu7t3v3__tap_2
XFILLER_213_104 VDD VDD VSS VSS gf180mcu_as_sc_mcu7t3v3__fill_2
XFILLER_0_1065 VDD VDD VSS VSS gf180mcu_as_sc_mcu7t3v3__fillcap_4
X_5926_ VDD VDD VSS VSS _6479_/D _5926_/C _5926_/B _5926_/A gf180mcu_as_sc_mcu7t3v3__aoi21_2
XFILLER_222_682 VDD VDD VSS VSS gf180mcu_as_sc_mcu7t3v3__fill_1
XFILLER_166_225 VDD VDD VSS VSS gf180mcu_as_sc_mcu7t3v3__fillcap_4
X_5857_ VDD VDD VSS VSS _5857_/A _5857_/B _5857_/C _5857_/D _5858_/D gf180mcu_as_sc_mcu7t3v3__ao22_2
XFILLER_166_247 VDD VDD VSS VSS gf180mcu_as_sc_mcu7t3v3__fillcap_4
XFILLER_167_759 VDD VDD VSS VSS gf180mcu_as_sc_mcu7t3v3__fill_1
XFILLER_210_877 VDD VDD VSS VSS gf180mcu_as_sc_mcu7t3v3__fillcap_4
X_5788_ VDD VDD VSS VSS _6462_/D _5788_/C _5844_/B _5788_/A gf180mcu_as_sc_mcu7t3v3__aoi21b_2
X_4808_ VDD VDD VSS VSS _4808_/B _4826_/A _6357_/D gf180mcu_as_sc_mcu7t3v3__and2_2
X_4739_ VDD VDD VSS VSS _5751_/A _4924_/B _4739_/C _4739_/D _4741_/C gf180mcu_as_sc_mcu7t3v3__ao211_2
XFILLER_135_634 VDD VDD VSS VSS gf180mcu_as_sc_mcu7t3v3__fillcap_4
XFILLER_174_280 VDD VDD VSS VSS gf180mcu_as_sc_mcu7t3v3__fillcap_4
XFILLER_163_998 VDD VDD VSS VSS gf180mcu_as_sc_mcu7t3v3__fillcap_16
XFILLER_218_1119 VDD VDD VSS VSS gf180mcu_as_sc_mcu7t3v3__fillcap_16
XFILLER_79_49 VDD VDD VSS VSS gf180mcu_as_sc_mcu7t3v3__fill_2
X_6409_ VDD VDD VSS VSS _6412_/CLK _6409_/D _6409_/Q gf180mcu_as_sc_mcu7t3v3__dfxtp_2
XFILLER_153_1100 VDD VDD VSS VSS gf180mcu_as_sc_mcu7t3v3__fillcap_16
XPHY_EDGE_ROW_101_1_Left_329 VDD VSS gf180mcu_as_sc_mcu7t3v3__tap_2
XFILLER_118_1242 VDD VDD VSS VSS gf180mcu_as_sc_mcu7t3v3__fill_1
XFILLER_153_1122 VDD VDD VSS VSS gf180mcu_as_sc_mcu7t3v3__fillcap_16
XFILLER_7_1208 VDD VDD VSS VSS gf180mcu_as_sc_mcu7t3v3__fillcap_16
XFILLER_151_54 VDD VDD VSS VSS gf180mcu_as_sc_mcu7t3v3__fillcap_16
XFILLER_217_476 VDD VDD VSS VSS gf180mcu_as_sc_mcu7t3v3__fill_2
XFILLER_220_608 VDD VDD VSS VSS gf180mcu_as_sc_mcu7t3v3__fillcap_4
XFILLER_38_1210 VDD VDD VSS VSS gf180mcu_as_sc_mcu7t3v3__fillcap_8
XFILLER_185_501 VDD VDD VSS VSS gf180mcu_as_sc_mcu7t3v3__fillcap_16
XFILLER_198_884 VDD VDD VSS VSS gf180mcu_as_sc_mcu7t3v3__fillcap_16
XFILLER_9_714 VDD VDD VSS VSS gf180mcu_as_sc_mcu7t3v3__fillcap_4
Xsram2048.u_bank0_1030 VDD VDD VSS VSS sram2048.u_bank0/WEN[4] gf180mcu_as_sc_mcu7t3v3__tiel_4
XFILLER_200_387 VDD VDD VSS VSS gf180mcu_as_sc_mcu7t3v3__fillcap_8
XFILLER_8_279 VDD VDD VSS VSS gf180mcu_as_sc_mcu7t3v3__fillcap_16
XTAP_TAPCELL_ROW_156_1550 VDD VSS gf180mcu_as_sc_mcu7t3v3__tap_2
XTAP_TAPCELL_ROW_191_2186 VDD VSS gf180mcu_as_sc_mcu7t3v3__tap_2
XTAP_TAPCELL_ROW_191_2175 VDD VSS gf180mcu_as_sc_mcu7t3v3__tap_2
XFILLER_154_943 VDD VDD VSS VSS gf180mcu_as_sc_mcu7t3v3__fill_2
XFILLER_158_1011 VDD VDD VSS VSS gf180mcu_as_sc_mcu7t3v3__fillcap_4
XFILLER_10_1151 VDD VDD VSS VSS gf180mcu_as_sc_mcu7t3v3__fillcap_4
XFILLER_158_1033 VDD VDD VSS VSS gf180mcu_as_sc_mcu7t3v3__fillcap_16
XTAP_TAPCELL_ROW_102_2_3001 VDD VSS gf180mcu_as_sc_mcu7t3v3__tap_2
XTAP_TAPCELL_ROW_152_1469 VDD VSS gf180mcu_as_sc_mcu7t3v3__tap_2
XFILLER_10_1173 VDD VDD VSS VSS gf180mcu_as_sc_mcu7t3v3__fillcap_16
XFILLER_141_637 VDD VDD VSS VSS gf180mcu_as_sc_mcu7t3v3__fill_2
XPHY_EDGE_ROW_95_1_Left_323 VDD VSS gf180mcu_as_sc_mcu7t3v3__tap_2
X_3070_ VDD VDD VSS VSS _5447_/A _5753_/A gf180mcu_as_sc_mcu7t3v3__inv_2
XFILLER_209_955 VDD VDD VSS VSS gf180mcu_as_sc_mcu7t3v3__fillcap_16
XFILLER_212_1263 VDD VDD VSS VSS gf180mcu_as_sc_mcu7t3v3__fill_2
XFILLER_48_640 VDD VDD VSS VSS gf180mcu_as_sc_mcu7t3v3__fill_2
XTAP_TAPCELL_ROW_15_1281 VDD VSS gf180mcu_as_sc_mcu7t3v3__tap_2
XTAP_TAPCELL_ROW_15_1292 VDD VSS gf180mcu_as_sc_mcu7t3v3__tap_2
XFILLER_208_454 VDD VDD VSS VSS gf180mcu_as_sc_mcu7t3v3__fill_1
XFILLER_63_610 VDD VDD VSS VSS gf180mcu_as_sc_mcu7t3v3__fill_2
XTAP_TAPCELL_ROW_198_2307 VDD VSS gf180mcu_as_sc_mcu7t3v3__tap_2
XFILLER_208_498 VDD VDD VSS VSS gf180mcu_as_sc_mcu7t3v3__fill_2
XFILLER_224_947 VDD VDD VSS VSS gf180mcu_as_sc_mcu7t3v3__fillcap_16
XFILLER_165_1037 VDD VDD VSS VSS gf180mcu_as_sc_mcu7t3v3__fillcap_8
XFILLER_93_2 VDD VDD VSS VSS gf180mcu_as_sc_mcu7t3v3__fillcap_16
XTAP_TAPCELL_ROW_176_1904 VDD VSS gf180mcu_as_sc_mcu7t3v3__tap_2
X_5711_ VDD VDD VSS VSS _5711_/A _5802_/B _5711_/C _5711_/D _5712_/B gf180mcu_as_sc_mcu7t3v3__ao211_2
X_3972_ VDD VDD VSS VSS _3972_/D _4051_/A _4053_/B _3974_/D _6067_/D gf180mcu_as_sc_mcu7t3v3__ao31_2
XFILLER_203_181 VDD VDD VSS VSS gf180mcu_as_sc_mcu7t3v3__fillcap_4
XTAP_TAPCELL_ROW_176_1915 VDD VSS gf180mcu_as_sc_mcu7t3v3__tap_2
XFILLER_164_707 VDD VDD VSS VSS gf180mcu_as_sc_mcu7t3v3__fill_1
X_5642_ VDD VDD VSS VSS _5642_/S _5955_/A _5642_/A _5643_/B gf180mcu_as_sc_mcu7t3v3__mux2_2
XTAP_TAPCELL_ROW_217_2646 VDD VSS gf180mcu_as_sc_mcu7t3v3__tap_2
XFILLER_163_206 VDD VDD VSS VSS gf180mcu_as_sc_mcu7t3v3__fillcap_4
XFILLER_164_718 VDD VDD VSS VSS gf180mcu_as_sc_mcu7t3v3__fillcap_4
X_5573_ VDD VDD VSS VSS _5573_/S _5877_/A _5573_/A _5575_/C gf180mcu_as_sc_mcu7t3v3__mux2_2
XFILLER_15_1084 VDD VDD VSS VSS gf180mcu_as_sc_mcu7t3v3__fillcap_16
XFILLER_191_548 VDD VDD VSS VSS gf180mcu_as_sc_mcu7t3v3__fill_1
X_4524_ VDD VDD VSS VSS _4525_/C _4524_/A _4524_/B _6279_/Q gf180mcu_as_sc_mcu7t3v3__ao21_2
XFILLER_172_773 VDD VDD VSS VSS gf180mcu_as_sc_mcu7t3v3__fill_2
XFILLER_171_272 VDD VDD VSS VSS gf180mcu_as_sc_mcu7t3v3__fillcap_8
X_4455_ VDD VDD VSS VSS _4599_/A _6151_/Q _4455_/A _6265_/D gf180mcu_as_sc_mcu7t3v3__mux2_2
Xfanout704 VDD VDD VSS VSS _3853_/B _3871_/B gf180mcu_as_sc_mcu7t3v3__buff_12
Xfanout715 VDD VDD VSS VSS _5944_/B _5861_/B gf180mcu_as_sc_mcu7t3v3__buff_12
X_4386_ VDD VDD VSS VSS _4388_/A _4386_/C _4407_/B _6142_/Q gf180mcu_as_sc_mcu7t3v3__aoi21_2
X_3406_ VDD VDD VSS VSS _3406_/B _6308_/Q _3413_/B gf180mcu_as_sc_mcu7t3v3__and2_2
XPHY_EDGE_ROW_13_Left_242 VDD VSS gf180mcu_as_sc_mcu7t3v3__tap_2
Xfanout726 VDD VDD VSS VSS _5365_/Y _5534_/S gf180mcu_as_sc_mcu7t3v3__buff_12
Xfanout737 VDD VDD VSS VSS _5571_/C _5563_/B gf180mcu_as_sc_mcu7t3v3__buff_12
Xfanout748 VDD VDD VSS VSS _3869_/B _3888_/B gf180mcu_as_sc_mcu7t3v3__buff_12
X_6125_ VDD VDD VSS VSS _6125_/CLK _6125_/D _6125_/Q gf180mcu_as_sc_mcu7t3v3__dfxtp_2
X_3337_ VDD VDD VSS VSS _3337_/B _3353_/A _3338_/D gf180mcu_as_sc_mcu7t3v3__or2_2
Xfanout759 VDD VDD VSS VSS _5532_/B _5490_/B gf180mcu_as_sc_mcu7t3v3__buff_12
XFILLER_65_29 VDD VDD VSS VSS gf180mcu_as_sc_mcu7t3v3__fillcap_16
XFILLER_6_1263 VDD VDD VSS VSS gf180mcu_as_sc_mcu7t3v3__fill_2
X_6056_ VDD VDD VSS VSS _6370_/CLK _6056_/D _6056_/Q gf180mcu_as_sc_mcu7t3v3__dfxtp_2
X_3268_ VDD VDD VSS VSS _4072_/A _3268_/B _3268_/C _3270_/C _3290_/A gf180mcu_as_sc_mcu7t3v3__oai211_2
XFILLER_226_251 VDD VDD VSS VSS gf180mcu_as_sc_mcu7t3v3__fill_1
X_5007_ VDD VDD VSS VSS _5228_/S _5679_/A _5007_/A _5008_/B gf180mcu_as_sc_mcu7t3v3__mux2_2
X_3199_ VDD VDD VSS VSS _3199_/Y _3200_/B _3200_/A gf180mcu_as_sc_mcu7t3v3__nand2_2
XFILLER_187_1262 VDD VDD VSS VSS gf180mcu_as_sc_mcu7t3v3__fill_2
XFILLER_199_626 VDD VDD VSS VSS gf180mcu_as_sc_mcu7t3v3__fillcap_4
XPHY_EDGE_ROW_105_2_Right_942 VDD VSS gf180mcu_as_sc_mcu7t3v3__tap_2
XFILLER_198_125 VDD VDD VSS VSS gf180mcu_as_sc_mcu7t3v3__fill_1
XFILLER_198_136 VDD VDD VSS VSS gf180mcu_as_sc_mcu7t3v3__fillcap_4
XFILLER_214_457 VDD VDD VSS VSS gf180mcu_as_sc_mcu7t3v3__fillcap_4
X_5909_ VDD VDD VSS VSS _5909_/D _5948_/S _5909_/B _5909_/C _5910_/C gf180mcu_as_sc_mcu7t3v3__ao31_2
XFILLER_167_556 VDD VDD VSS VSS gf180mcu_as_sc_mcu7t3v3__fillcap_4
XFILLER_224_1189 VDD VDD VSS VSS gf180mcu_as_sc_mcu7t3v3__fillcap_16
XFILLER_155_718 VDD VDD VSS VSS gf180mcu_as_sc_mcu7t3v3__fillcap_16
XFILLER_167_578 VDD VDD VSS VSS gf180mcu_as_sc_mcu7t3v3__fillcap_16
XPHY_EDGE_ROW_40_3_Right_120 VDD VSS gf180mcu_as_sc_mcu7t3v3__tap_2
XFILLER_151_902 VDD VDD VSS VSS gf180mcu_as_sc_mcu7t3v3__fill_1
XFILLER_123_659 VDD VDD VSS VSS gf180mcu_as_sc_mcu7t3v3__fill_2
XFILLER_151_957 VDD VDD VSS VSS gf180mcu_as_sc_mcu7t3v3__fillcap_16
XFILLER_151_979 VDD VDD VSS VSS gf180mcu_as_sc_mcu7t3v3__fill_1
XFILLER_190_1119 VDD VDD VSS VSS gf180mcu_as_sc_mcu7t3v3__fillcap_16
XFILLER_162_31 VDD VDD VSS VSS gf180mcu_as_sc_mcu7t3v3__fillcap_4
XFILLER_162_53 VDD VDD VSS VSS gf180mcu_as_sc_mcu7t3v3__fillcap_16
XFILLER_188_1004 VDD VDD VSS VSS gf180mcu_as_sc_mcu7t3v3__fillcap_8
Xmesh_tile_1125 VDD VDD VSS VSS se_out[12] gf180mcu_as_sc_mcu7t3v3__tiel_4
Xmesh_tile_1114 VDD VDD VSS VSS se_out[1] gf180mcu_as_sc_mcu7t3v3__tiel_4
Xmesh_tile_1103 VDD VDD VSS VSS nw_out[26] gf180mcu_as_sc_mcu7t3v3__tiel_4
Xmesh_tile_1169 VDD VDD VSS VSS sw_out[20] gf180mcu_as_sc_mcu7t3v3__tiel_4
Xmesh_tile_1158 VDD VDD VSS VSS sw_out[9] gf180mcu_as_sc_mcu7t3v3__tiel_4
Xmesh_tile_1147 VDD VDD VSS VSS se_out[34] gf180mcu_as_sc_mcu7t3v3__tiel_4
Xmesh_tile_1136 VDD VDD VSS VSS se_out[23] gf180mcu_as_sc_mcu7t3v3__tiel_4
XFILLER_206_925 VDD VDD VSS VSS gf180mcu_as_sc_mcu7t3v3__fillcap_16
XFILLER_206_947 VDD VDD VSS VSS gf180mcu_as_sc_mcu7t3v3__fillcap_16
XFILLER_218_796 VDD VDD VSS VSS gf180mcu_as_sc_mcu7t3v3__fillcap_8
XTAP_TAPCELL_ROW_126_3_3038 VDD VSS gf180mcu_as_sc_mcu7t3v3__tap_2
XFILLER_221_939 VDD VDD VSS VSS gf180mcu_as_sc_mcu7t3v3__fillcap_16
XFILLER_164_1081 VDD VDD VSS VSS gf180mcu_as_sc_mcu7t3v3__fillcap_4
XTAP_TAPCELL_ROW_193_2215 VDD VSS gf180mcu_as_sc_mcu7t3v3__tap_2
XFILLER_13_573 VDD VDD VSS VSS gf180mcu_as_sc_mcu7t3v3__fillcap_4
XFILLER_185_331 VDD VDD VSS VSS gf180mcu_as_sc_mcu7t3v3__fill_2
XFILLER_199_1100 VDD VDD VSS VSS gf180mcu_as_sc_mcu7t3v3__fillcap_16
XFILLER_199_1122 VDD VDD VSS VSS gf180mcu_as_sc_mcu7t3v3__fillcap_16
XFILLER_200_140 VDD VDD VSS VSS gf180mcu_as_sc_mcu7t3v3__fillcap_16
XFILLER_158_589 VDD VDD VSS VSS gf180mcu_as_sc_mcu7t3v3__fillcap_4
XFILLER_187_72 VDD VDD VSS VSS gf180mcu_as_sc_mcu7t3v3__fillcap_16
XFILLER_201_696 VDD VDD VSS VSS gf180mcu_as_sc_mcu7t3v3__fillcap_4
XTAP_TAPCELL_ROW_154_1509 VDD VSS gf180mcu_as_sc_mcu7t3v3__tap_2
XTAP_TAPCELL_ROW_171_1812 VDD VSS gf180mcu_as_sc_mcu7t3v3__tap_2
XTAP_TAPCELL_ROW_171_1823 VDD VSS gf180mcu_as_sc_mcu7t3v3__tap_2
XFILLER_160_209 VDD VDD VSS VSS gf180mcu_as_sc_mcu7t3v3__fillcap_16
XTAP_TAPCELL_ROW_43_2_2913 VDD VSS gf180mcu_as_sc_mcu7t3v3__tap_2
XFILLER_5_772 VDD VDD VSS VSS gf180mcu_as_sc_mcu7t3v3__fill_1
XTAP_TAPCELL_ROW_212_2565 VDD VSS gf180mcu_as_sc_mcu7t3v3__tap_2
XTAP_TAPCELL_ROW_212_2554 VDD VSS gf180mcu_as_sc_mcu7t3v3__tap_2
XFILLER_114_659 VDD VDD VSS VSS gf180mcu_as_sc_mcu7t3v3__fillcap_8
X_4240_ VDD VDD VSS VSS _4281_/B _6154_/Q _4243_/C gf180mcu_as_sc_mcu7t3v3__or2_2
XFILLER_171_1030 VDD VDD VSS VSS gf180mcu_as_sc_mcu7t3v3__fillcap_16
X_4171_ VDD VDD VSS VSS _4236_/B _4171_/B _4171_/A gf180mcu_as_sc_mcu7t3v3__nor2_2
XFILLER_171_1052 VDD VDD VSS VSS gf180mcu_as_sc_mcu7t3v3__fillcap_16
XTAP_TAPCELL_ROW_169_1785 VDD VSS gf180mcu_as_sc_mcu7t3v3__tap_2
X_3122_ VDD VDD VSS VSS _3122_/B _6227_/Q _3165_/B gf180mcu_as_sc_mcu7t3v3__and2_2
XFILLER_222_34 VDD VDD VSS VSS gf180mcu_as_sc_mcu7t3v3__fill_1
X_3053_ VDD VDD VSS VSS _4149_/A _6195_/Q gf180mcu_as_sc_mcu7t3v3__inv_2
XFILLER_208_262 VDD VDD VSS VSS gf180mcu_as_sc_mcu7t3v3__fill_2
XFILLER_212_906 VDD VDD VSS VSS gf180mcu_as_sc_mcu7t3v3__fill_1
XFILLER_36_665 VDD VDD VSS VSS gf180mcu_as_sc_mcu7t3v3__fill_2
XFILLER_196_607 VDD VDD VSS VSS gf180mcu_as_sc_mcu7t3v3__fillcap_4
XFILLER_224_777 VDD VDD VSS VSS gf180mcu_as_sc_mcu7t3v3__fill_1
XFILLER_149_512 VDD VDD VSS VSS gf180mcu_as_sc_mcu7t3v3__fill_1
XFILLER_149_523 VDD VDD VSS VSS gf180mcu_as_sc_mcu7t3v3__fillcap_16
X_3955_ VDD VDD VSS VSS _3955_/D _4043_/A _4036_/B _3962_/C _6057_/D gf180mcu_as_sc_mcu7t3v3__ao31_2
XFILLER_176_342 VDD VDD VSS VSS gf180mcu_as_sc_mcu7t3v3__fill_1
XFILLER_192_824 VDD VDD VSS VSS gf180mcu_as_sc_mcu7t3v3__fillcap_4
X_5625_ VDD VDD VSS VSS _5632_/C _5938_/B _5625_/A _5627_/C gf180mcu_as_sc_mcu7t3v3__mux2_2
X_3886_ VDD VDD VSS VSS _6517_/Q _3897_/B _3886_/C _5870_/B _3887_/C gf180mcu_as_sc_mcu7t3v3__ao22_2
XFILLER_192_835 VDD VDD VSS VSS gf180mcu_as_sc_mcu7t3v3__fillcap_4
Xclkbuf_leaf_0_clk_regs VDD VDD VSS VSS clkbuf_3_0_0_clk_regs/Y _6474_/CLK gf180mcu_as_sc_mcu7t3v3__clkbuff_12
XFILLER_191_345 VDD VDD VSS VSS gf180mcu_as_sc_mcu7t3v3__fillcap_4
XFILLER_192_879 VDD VDD VSS VSS gf180mcu_as_sc_mcu7t3v3__fill_1
XFILLER_3_709 VDD VDD VSS VSS gf180mcu_as_sc_mcu7t3v3__fillcap_8
X_5556_ VDD VDD VSS VSS _5557_/A _5862_/B _5563_/C _5556_/C gf180mcu_as_sc_mcu7t3v3__ao21_2
XFILLER_172_570 VDD VDD VSS VSS gf180mcu_as_sc_mcu7t3v3__fillcap_4
X_5487_ VDD VDD VSS VSS _5795_/A _5497_/B _5496_/B _5794_/A _5488_/D gf180mcu_as_sc_mcu7t3v3__ao22_2
X_4507_ VDD VDD VSS VSS _4546_/B _6161_/Q _4508_/D gf180mcu_as_sc_mcu7t3v3__and2_2
XFILLER_105_648 VDD VDD VSS VSS gf180mcu_as_sc_mcu7t3v3__fillcap_4
XFILLER_105_659 VDD VDD VSS VSS gf180mcu_as_sc_mcu7t3v3__fill_2
XFILLER_160_732 VDD VDD VSS VSS gf180mcu_as_sc_mcu7t3v3__fill_2
X_4438_ VDD VDD VSS VSS _6254_/Q _4442_/B _4442_/C _6253_/Q _6253_/D gf180mcu_as_sc_mcu7t3v3__ao22_2
XFILLER_120_629 VDD VDD VSS VSS gf180mcu_as_sc_mcu7t3v3__fillcap_16
XFILLER_154_1250 VDD VDD VSS VSS gf180mcu_as_sc_mcu7t3v3__fillcap_8
XFILLER_160_776 VDD VDD VSS VSS gf180mcu_as_sc_mcu7t3v3__fillcap_4
XFILLER_28_1242 VDD VDD VSS VSS gf180mcu_as_sc_mcu7t3v3__fill_1
Xfanout501 VDD VDD VSS VSS fanout505/Y _3830_/D gf180mcu_as_sc_mcu7t3v3__buff_12
Xfanout523 VDD VDD VSS VSS _3975_/C _3963_/B gf180mcu_as_sc_mcu7t3v3__buff_12
XFILLER_115_1234 VDD VDD VSS VSS gf180mcu_as_sc_mcu7t3v3__fillcap_4
XFILLER_150_1103 VDD VDD VSS VSS gf180mcu_as_sc_mcu7t3v3__fillcap_16
Xfanout534 VDD VDD VSS VSS _5948_/S _5875_/S gf180mcu_as_sc_mcu7t3v3__buff_12
Xfanout545 VDD VDD VSS VSS _5531_/B _5456_/B gf180mcu_as_sc_mcu7t3v3__buff_12
Xfanout556 VDD VDD VSS VSS _4654_/Y _4864_/S gf180mcu_as_sc_mcu7t3v3__buff_12
X_4369_ VDD VDD VSS VSS _4370_/S _6121_/Q _4369_/C _4369_/D _4373_/C gf180mcu_as_sc_mcu7t3v3__ao211_2
Xfanout567 VDD VDD VSS VSS _3935_/Y _3975_/B gf180mcu_as_sc_mcu7t3v3__buff_12
Xfanout578 VDD VDD VSS VSS _4045_/A _4061_/A gf180mcu_as_sc_mcu7t3v3__buff_12
Xfanout589 VDD VDD VSS VSS _5640_/C _5630_/B gf180mcu_as_sc_mcu7t3v3__buff_12
X_6108_ VDD VDD VSS VSS _6525_/CLK _6108_/D _6108_/Q gf180mcu_as_sc_mcu7t3v3__dfxtp_2
XFILLER_132_45 VDD VDD VSS VSS gf180mcu_as_sc_mcu7t3v3__fillcap_4
X_6039_ VDD VDD VSS VSS _6525_/CLK _6039_/D _6039_/Q gf180mcu_as_sc_mcu7t3v3__dfxtp_2
XPHY_EDGE_ROW_66_3_Left_771 VDD VSS gf180mcu_as_sc_mcu7t3v3__tap_2
XFILLER_92_49 VDD VDD VSS VSS gf180mcu_as_sc_mcu7t3v3__fill_2
XFILLER_14_337 VDD VDD VSS VSS gf180mcu_as_sc_mcu7t3v3__fill_1
XFILLER_15_838 VDD VDD VSS VSS gf180mcu_as_sc_mcu7t3v3__fill_2
XFILLER_202_405 VDD VDD VSS VSS gf180mcu_as_sc_mcu7t3v3__fill_1
XFILLER_203_928 VDD VDD VSS VSS gf180mcu_as_sc_mcu7t3v3__fillcap_16
XFILLER_25_43 VDD VDD VSS VSS gf180mcu_as_sc_mcu7t3v3__fillcap_8
XFILLER_42_624 VDD VDD VSS VSS gf180mcu_as_sc_mcu7t3v3__fill_2
XPHY_EDGE_ROW_106_2_Right_943 VDD VSS gf180mcu_as_sc_mcu7t3v3__tap_2
XFILLER_199_489 VDD VDD VSS VSS gf180mcu_as_sc_mcu7t3v3__fill_1
XFILLER_211_972 VDD VDD VSS VSS gf180mcu_as_sc_mcu7t3v3__fillcap_8
XPHY_EDGE_ROW_125_2_Left_566 VDD VSS gf180mcu_as_sc_mcu7t3v3__tap_2
XFILLER_10_543 VDD VDD VSS VSS gf180mcu_as_sc_mcu7t3v3__fillcap_4
XFILLER_167_386 VDD VDD VSS VSS gf180mcu_as_sc_mcu7t3v3__fill_1
XFILLER_6_569 VDD VDD VSS VSS gf180mcu_as_sc_mcu7t3v3__fill_1
XPHY_EDGE_ROW_41_3_Right_121 VDD VSS gf180mcu_as_sc_mcu7t3v3__tap_2
XPHY_EDGE_ROW_62_2_Left_503 VDD VSS gf180mcu_as_sc_mcu7t3v3__tap_2
Xwire979 VDD VDD VSS VSS wire979/A _5928_/A gf180mcu_as_sc_mcu7t3v3__clkbuff_12
XFILLER_155_1014 VDD VDD VSS VSS gf180mcu_as_sc_mcu7t3v3__fillcap_16
XFILLER_2_720 VDD VDD VSS VSS gf180mcu_as_sc_mcu7t3v3__fillcap_8
XTAP_TAPCELL_ROW_186_2096 VDD VSS gf180mcu_as_sc_mcu7t3v3__tap_2
XTAP_TAPCELL_ROW_186_2085 VDD VSS gf180mcu_as_sc_mcu7t3v3__tap_2
XFILLER_18_621 VDD VDD VSS VSS gf180mcu_as_sc_mcu7t3v3__fillcap_4
XFILLER_218_582 VDD VDD VSS VSS gf180mcu_as_sc_mcu7t3v3__fillcap_8
XTAP_TAPCELL_ROW_164_1693 VDD VSS gf180mcu_as_sc_mcu7t3v3__tap_2
XFILLER_33_635 VDD VDD VSS VSS gf180mcu_as_sc_mcu7t3v3__fillcap_4
XPHY_EDGE_ROW_57_2_Left_498 VDD VSS gf180mcu_as_sc_mcu7t3v3__tap_2
XANTENNA_19 VDD VDD VSS VSS _5007_/A gf180mcu_as_sc_mcu7t3v3__diode_2
XFILLER_14_871 VDD VDD VSS VSS gf180mcu_as_sc_mcu7t3v3__fillcap_4
XFILLER_14_893 VDD VDD VSS VSS gf180mcu_as_sc_mcu7t3v3__fillcap_16
XFILLER_198_93 VDD VDD VSS VSS gf180mcu_as_sc_mcu7t3v3__fill_2
X_3740_ VDD VDD VSS VSS _3873_/S _5744_/A _3741_/B gf180mcu_as_sc_mcu7t3v3__or2_2
XFILLER_158_364 VDD VDD VSS VSS gf180mcu_as_sc_mcu7t3v3__fillcap_8
XFILLER_9_352 VDD VDD VSS VSS gf180mcu_as_sc_mcu7t3v3__fillcap_4
XFILLER_185_172 VDD VDD VSS VSS gf180mcu_as_sc_mcu7t3v3__fill_2
XFILLER_70_4 VDD VDD VSS VSS gf180mcu_as_sc_mcu7t3v3__fill_1
X_3671_ VDD VDD VSS VSS _5682_/B _3804_/C _3671_/C _3671_/D _3673_/C gf180mcu_as_sc_mcu7t3v3__ao211_2
X_6390_ VDD VDD VSS VSS clkload3/A _6390_/D _6390_/Q gf180mcu_as_sc_mcu7t3v3__dfxtp_2
X_5410_ VDD VDD VSS VSS _5719_/A _5495_/B _5410_/C _5410_/D _5412_/C gf180mcu_as_sc_mcu7t3v3__ao211_2
XFILLER_12_1065 VDD VDD VSS VSS gf180mcu_as_sc_mcu7t3v3__fillcap_16
XFILLER_12_1087 VDD VDD VSS VSS gf180mcu_as_sc_mcu7t3v3__fillcap_16
XFILLER_217_34 VDD VDD VSS VSS gf180mcu_as_sc_mcu7t3v3__fillcap_16
X_5341_ VDD VDD VSS VSS _5367_/C _5654_/B _5654_/A gf180mcu_as_sc_mcu7t3v3__nand2_2
XFILLER_138_1245 VDD VDD VSS VSS gf180mcu_as_sc_mcu7t3v3__fillcap_16
X_5272_ VDD VDD VSS VSS _5912_/A _5313_/B _5296_/C _5914_/D _5273_/D gf180mcu_as_sc_mcu7t3v3__ao22_2
X_4223_ VDD VDD VSS VSS _6199_/D _4223_/C _4223_/B _4223_/A gf180mcu_as_sc_mcu7t3v3__aoi21_2
X_4154_ VDD VDD VSS VSS _4241_/B _4230_/B _4359_/B gf180mcu_as_sc_mcu7t3v3__and2_2
X_4085_ VDD VDD VSS VSS _4085_/S _6722_/A _6145_/Q _6145_/D gf180mcu_as_sc_mcu7t3v3__mux2_2
X_3105_ VDD VDD VSS VSS _4480_/A _4102_/A _3434_/A _3374_/B _3161_/A gf180mcu_as_sc_mcu7t3v3__ao31_2
X_3036_ VDD VDD VSS VSS _5307_/A _5948_/A gf180mcu_as_sc_mcu7t3v3__inv_2
XTAP_TAPCELL_ROW_225_2789 VDD VSS gf180mcu_as_sc_mcu7t3v3__tap_2
XFILLER_102_37 VDD VDD VSS VSS gf180mcu_as_sc_mcu7t3v3__fillcap_8
XFILLER_184_1221 VDD VDD VSS VSS gf180mcu_as_sc_mcu7t3v3__fillcap_4
XFILLER_24_602 VDD VDD VSS VSS gf180mcu_as_sc_mcu7t3v3__fillcap_4
XPHY_EDGE_ROW_110_1_Left_338 VDD VSS gf180mcu_as_sc_mcu7t3v3__tap_2
XFILLER_168_139 VDD VDD VSS VSS gf180mcu_as_sc_mcu7t3v3__fillcap_16
XFILLER_211_235 VDD VDD VSS VSS gf180mcu_as_sc_mcu7t3v3__fill_2
XFILLER_225_1240 VDD VDD VSS VSS gf180mcu_as_sc_mcu7t3v3__fillcap_16
XFILLER_225_1262 VDD VDD VSS VSS gf180mcu_as_sc_mcu7t3v3__fill_2
X_4987_ VDD VDD VSS VSS _4987_/B _4987_/A _5001_/B gf180mcu_as_sc_mcu7t3v3__or2_2
XFILLER_149_342 VDD VDD VSS VSS gf180mcu_as_sc_mcu7t3v3__fillcap_4
X_3938_ VDD VDD VSS VSS _3962_/C _5977_/A _3948_/C gf180mcu_as_sc_mcu7t3v3__and2_2
XFILLER_178_1003 VDD VDD VSS VSS gf180mcu_as_sc_mcu7t3v3__fillcap_8
XFILLER_192_632 VDD VDD VSS VSS gf180mcu_as_sc_mcu7t3v3__fill_1
X_3869_ VDD VDD VSS VSS _3869_/B _5853_/A _3870_/D gf180mcu_as_sc_mcu7t3v3__and2_2
XTAP_TAPCELL_ROW_96_2_2992 VDD VSS gf180mcu_as_sc_mcu7t3v3__tap_2
XFILLER_152_507 VDD VDD VSS VSS gf180mcu_as_sc_mcu7t3v3__fill_2
XFILLER_176_194 VDD VDD VSS VSS gf180mcu_as_sc_mcu7t3v3__fillcap_8
XFILLER_191_142 VDD VDD VSS VSS gf180mcu_as_sc_mcu7t3v3__fillcap_4
X_5608_ VDD VDD VSS VSS _5920_/A _5632_/B _5632_/C _5919_/A _5611_/C gf180mcu_as_sc_mcu7t3v3__ao22_2
XFILLER_164_378 VDD VDD VSS VSS gf180mcu_as_sc_mcu7t3v3__fillcap_4
X_5539_ VDD VDD VSS VSS _6433_/D _5843_/D _5539_/B _5539_/A gf180mcu_as_sc_mcu7t3v3__aoi21_2
XFILLER_87_27 VDD VDD VSS VSS gf180mcu_as_sc_mcu7t3v3__fillcap_8
XFILLER_87_49 VDD VDD VSS VSS gf180mcu_as_sc_mcu7t3v3__fill_2
XFILLER_143_22 VDD VDD VSS VSS gf180mcu_as_sc_mcu7t3v3__fillcap_16
XFILLER_207_508 VDD VDD VSS VSS gf180mcu_as_sc_mcu7t3v3__fillcap_16
XTAP_TAPCELL_ROW_9_1172 VDD VSS gf180mcu_as_sc_mcu7t3v3__tap_2
XFILLER_189_1154 VDD VDD VSS VSS gf180mcu_as_sc_mcu7t3v3__fillcap_16
XTAP_TAPCELL_ROW_9_1183 VDD VSS gf180mcu_as_sc_mcu7t3v3__tap_2
XFILLER_160_2 VDD VDD VSS VSS gf180mcu_as_sc_mcu7t3v3__fillcap_16
XFILLER_215_574 VDD VDD VSS VSS gf180mcu_as_sc_mcu7t3v3__fill_1
XFILLER_226_1004 VDD VDD VSS VSS gf180mcu_as_sc_mcu7t3v3__fillcap_8
XFILLER_14_123 VDD VDD VSS VSS gf180mcu_as_sc_mcu7t3v3__fillcap_16
XPHY_EDGE_ROW_107_2_Right_944 VDD VSS gf180mcu_as_sc_mcu7t3v3__tap_2
XFILLER_11_830 VDD VDD VSS VSS gf180mcu_as_sc_mcu7t3v3__fillcap_8
XFILLER_156_802 VDD VDD VSS VSS gf180mcu_as_sc_mcu7t3v3__fill_2
XFILLER_11_874 VDD VDD VSS VSS gf180mcu_as_sc_mcu7t3v3__fillcap_16
XFILLER_161_1084 VDD VDD VSS VSS gf180mcu_as_sc_mcu7t3v3__fillcap_16
XFILLER_168_85 VDD VDD VSS VSS gf180mcu_as_sc_mcu7t3v3__fillcap_16
XFILLER_183_632 VDD VDD VSS VSS gf180mcu_as_sc_mcu7t3v3__fill_2
XFILLER_195_492 VDD VDD VSS VSS gf180mcu_as_sc_mcu7t3v3__fill_2
XFILLER_196_1103 VDD VDD VSS VSS gf180mcu_as_sc_mcu7t3v3__fillcap_16
XFILLER_6_311 VDD VDD VSS VSS gf180mcu_as_sc_mcu7t3v3__fillcap_4
XFILLER_7_812 VDD VDD VSS VSS gf180mcu_as_sc_mcu7t3v3__fill_1
Xinput17 VDD VDD VSS VSS boot_addr[9] _3298_/A gf180mcu_as_sc_mcu7t3v3__buff_12
Xinput28 VDD VDD VSS VSS dft_addr[0] _3220_/B gf180mcu_as_sc_mcu7t3v3__buff_12
XFILLER_10_384 VDD VDD VSS VSS gf180mcu_as_sc_mcu7t3v3__fill_1
Xinput39 VDD VDD VSS VSS dft_ce input39/Y gf180mcu_as_sc_mcu7t3v3__buff_12
XFILLER_155_389 VDD VDD VSS VSS gf180mcu_as_sc_mcu7t3v3__fill_1
XFILLER_202_1081 VDD VDD VSS VSS gf180mcu_as_sc_mcu7t3v3__fillcap_4
XPHY_EDGE_ROW_42_3_Right_122 VDD VSS gf180mcu_as_sc_mcu7t3v3__tap_2
XFILLER_170_359 VDD VDD VSS VSS gf180mcu_as_sc_mcu7t3v3__fill_1
XTAP_TAPCELL_ROW_188_2125 VDD VSS gf180mcu_as_sc_mcu7t3v3__tap_2
XFILLER_151_573 VDD VDD VSS VSS gf180mcu_as_sc_mcu7t3v3__fillcap_4
XTAP_TAPCELL_ROW_149_1408 VDD VSS gf180mcu_as_sc_mcu7t3v3__tap_2
XTAP_TAPCELL_ROW_149_1419 VDD VSS gf180mcu_as_sc_mcu7t3v3__tap_2
XTAP_TAPCELL_ROW_166_1722 VDD VSS gf180mcu_as_sc_mcu7t3v3__tap_2
XTAP_TAPCELL_ROW_166_1733 VDD VSS gf180mcu_as_sc_mcu7t3v3__tap_2
XFILLER_168_1205 VDD VDD VSS VSS gf180mcu_as_sc_mcu7t3v3__fillcap_16
XTAP_TAPCELL_ROW_207_2475 VDD VSS gf180mcu_as_sc_mcu7t3v3__tap_2
XTAP_TAPCELL_ROW_207_2464 VDD VSS gf180mcu_as_sc_mcu7t3v3__tap_2
XFILLER_168_1227 VDD VDD VSS VSS gf180mcu_as_sc_mcu7t3v3__fillcap_16
XFILLER_203_69 VDD VDD VSS VSS gf180mcu_as_sc_mcu7t3v3__fill_1
XFILLER_209_1224 VDD VDD VSS VSS gf180mcu_as_sc_mcu7t3v3__fillcap_8
X_5890_ VDD VDD VSS VSS _5890_/A _5953_/C _5890_/C _5890_/D _5891_/D gf180mcu_as_sc_mcu7t3v3__ao211_2
X_4910_ VDD VDD VSS VSS _5894_/A _4957_/B _4910_/C _4910_/D _4911_/B gf180mcu_as_sc_mcu7t3v3__ao211_2
X_4841_ VDD VDD VSS VSS _6513_/Q _4841_/B _4841_/C _4841_/D _4843_/C gf180mcu_as_sc_mcu7t3v3__ao22_2
XTAP_TAPCELL_ROW_220_2697 VDD VSS gf180mcu_as_sc_mcu7t3v3__tap_2
XTAP_TAPCELL_ROW_108_2_3010 VDD VSS gf180mcu_as_sc_mcu7t3v3__tap_2
XFILLER_187_960 VDD VDD VSS VSS gf180mcu_as_sc_mcu7t3v3__fillcap_16
XFILLER_187_982 VDD VDD VSS VSS gf180mcu_as_sc_mcu7t3v3__fillcap_16
X_4772_ VDD VDD VSS VSS _4837_/B _5781_/A _4773_/C gf180mcu_as_sc_mcu7t3v3__and2_2
X_6511_ VDD VDD VSS VSS _6518_/CLK _6511_/D _6511_/Q gf180mcu_as_sc_mcu7t3v3__dfxtp_2
X_3723_ VDD VDD VSS VSS _3830_/B _6022_/Q _3724_/C gf180mcu_as_sc_mcu7t3v3__and2_2
XFILLER_173_120 VDD VDD VSS VSS gf180mcu_as_sc_mcu7t3v3__fillcap_16
XFILLER_173_142 VDD VDD VSS VSS gf180mcu_as_sc_mcu7t3v3__fillcap_16
X_6442_ VDD VDD VSS VSS _6448_/CLK _6442_/D _6442_/Q gf180mcu_as_sc_mcu7t3v3__dfxtp_2
X_3654_ VDD VDD VSS VSS _3654_/B _3654_/A _3854_/B gf180mcu_as_sc_mcu7t3v3__and2_2
X_6373_ VDD VDD VSS VSS _6376_/CLK _6373_/D _6373_/Q gf180mcu_as_sc_mcu7t3v3__dfxtp_2
X_3585_ VDD VDD VSS VSS _6491_/Q _5970_/A _3585_/C _3585_/D _3658_/D gf180mcu_as_sc_mcu7t3v3__ao211_2
X_5324_ VDD VDD VSS VSS _5325_/A _5325_/B _5646_/B _5324_/Y _5325_/D gf180mcu_as_sc_mcu7t3v3__aoi211_2
X_5255_ VDD VDD VSS VSS _5256_/C _5279_/C _5255_/B _5297_/A gf180mcu_as_sc_mcu7t3v3__aoi21_2
XFILLER_64_1261 VDD VDD VSS VSS gf180mcu_as_sc_mcu7t3v3__fillcap_4
X_4206_ VDD VDD VSS VSS _4207_/C _4216_/B _4206_/B _4243_/A gf180mcu_as_sc_mcu7t3v3__ao21_2
XTAP_TAPCELL_ROW_227_2829 VDD VSS gf180mcu_as_sc_mcu7t3v3__tap_2
XFILLER_151_1264 VDD VDD VSS VSS gf180mcu_as_sc_mcu7t3v3__fill_1
XFILLER_228_110 VDD VDD VSS VSS gf180mcu_as_sc_mcu7t3v3__fill_1
X_5186_ VDD VDD VSS VSS _5838_/B _5186_/B _5186_/C _5186_/D _5187_/B gf180mcu_as_sc_mcu7t3v3__ao22_2
XFILLER_228_176 VDD VDD VSS VSS gf180mcu_as_sc_mcu7t3v3__fill_2
XFILLER_3_1030 VDD VDD VSS VSS gf180mcu_as_sc_mcu7t3v3__fillcap_16
X_4137_ VDD VDD VSS VSS _4140_/S _6187_/Q _6186_/Q _6186_/D gf180mcu_as_sc_mcu7t3v3__mux2_2
XFILLER_3_1052 VDD VDD VSS VSS gf180mcu_as_sc_mcu7t3v3__fillcap_16
X_4068_ VDD VDD VSS VSS _6133_/D _6015_/B _5972_/C gf180mcu_as_sc_mcu7t3v3__nor2_2
XFILLER_73_29 VDD VDD VSS VSS gf180mcu_as_sc_mcu7t3v3__fillcap_16
X_3019_ VDD VDD VSS VSS _4626_/B _5951_/A gf180mcu_as_sc_mcu7t3v3__inv_2
XTAP_TAPCELL_ROW_4_1091 VDD VSS gf180mcu_as_sc_mcu7t3v3__tap_2
XTAP_TAPCELL_ROW_4_1080 VDD VSS gf180mcu_as_sc_mcu7t3v3__tap_2
XFILLER_11_104 VDD VDD VSS VSS gf180mcu_as_sc_mcu7t3v3__fillcap_16
XFILLER_71_1210 VDD VDD VSS VSS gf180mcu_as_sc_mcu7t3v3__fill_2
XFILLER_178_971 VDD VDD VSS VSS gf180mcu_as_sc_mcu7t3v3__fillcap_4
XFILLER_197_768 VDD VDD VSS VSS gf180mcu_as_sc_mcu7t3v3__fill_2
XFILLER_138_22 VDD VDD VSS VSS gf180mcu_as_sc_mcu7t3v3__fillcap_8
XFILLER_153_805 VDD VDD VSS VSS gf180mcu_as_sc_mcu7t3v3__fillcap_16
XFILLER_177_492 VDD VDD VSS VSS gf180mcu_as_sc_mcu7t3v3__fillcap_4
XFILLER_193_952 VDD VDD VSS VSS gf180mcu_as_sc_mcu7t3v3__fill_1
XFILLER_98_37 VDD VDD VSS VSS gf180mcu_as_sc_mcu7t3v3__fillcap_8
XPHY_EDGE_ROW_5_Left_234 VDD VSS gf180mcu_as_sc_mcu7t3v3__tap_2
XFILLER_152_1017 VDD VDD VSS VSS gf180mcu_as_sc_mcu7t3v3__fillcap_16
Xoutput490 VDD VDD VSS VSS _6458_/Q west_out[9] gf180mcu_as_sc_mcu7t3v3__buff_12
XTAP_TAPCELL_ROW_183_2033 VDD VSS gf180mcu_as_sc_mcu7t3v3__tap_2
XFILLER_87_660 VDD VDD VSS VSS gf180mcu_as_sc_mcu7t3v3__fill_2
XTAP_TAPCELL_ROW_183_2044 VDD VSS gf180mcu_as_sc_mcu7t3v3__tap_2
XFILLER_170_53 VDD VDD VSS VSS gf180mcu_as_sc_mcu7t3v3__fillcap_16
XTAP_TAPCELL_ROW_161_1641 VDD VSS gf180mcu_as_sc_mcu7t3v3__tap_2
XTAP_TAPCELL_ROW_202_2372 VDD VSS gf180mcu_as_sc_mcu7t3v3__tap_2
XFILLER_15_476 VDD VDD VSS VSS gf180mcu_as_sc_mcu7t3v3__fillcap_8
XFILLER_16_988 VDD VDD VSS VSS gf180mcu_as_sc_mcu7t3v3__fillcap_16
XFILLER_187_212 VDD VDD VSS VSS gf180mcu_as_sc_mcu7t3v3__fillcap_8
XTAP_TAPCELL_ROW_202_2383 VDD VSS gf180mcu_as_sc_mcu7t3v3__tap_2
XFILLER_203_566 VDD VDD VSS VSS gf180mcu_as_sc_mcu7t3v3__fill_1
XPHY_EDGE_ROW_108_2_Right_945 VDD VSS gf180mcu_as_sc_mcu7t3v3__tap_2
XPHY_EDGE_ROW_29_3_Left_734 VDD VSS gf180mcu_as_sc_mcu7t3v3__tap_2
XFILLER_156_610 VDD VDD VSS VSS gf180mcu_as_sc_mcu7t3v3__fill_1
XFILLER_184_930 VDD VDD VSS VSS gf180mcu_as_sc_mcu7t3v3__fillcap_4
XFILLER_155_120 VDD VDD VSS VSS gf180mcu_as_sc_mcu7t3v3__fillcap_16
XFILLER_155_142 VDD VDD VSS VSS gf180mcu_as_sc_mcu7t3v3__fillcap_16
XFILLER_195_72 VDD VDD VSS VSS gf180mcu_as_sc_mcu7t3v3__fillcap_16
XFILLER_170_101 VDD VDD VSS VSS gf180mcu_as_sc_mcu7t3v3__fillcap_4
XFILLER_170_123 VDD VDD VSS VSS gf180mcu_as_sc_mcu7t3v3__fillcap_16
XFILLER_48_1245 VDD VDD VSS VSS gf180mcu_as_sc_mcu7t3v3__fillcap_16
XPHY_EDGE_ROW_43_3_Right_123 VDD VSS gf180mcu_as_sc_mcu7t3v3__tap_2
X_3370_ VDD VDD VSS VSS _6527_/Q _3370_/B _3370_/A _3370_/Y gf180mcu_as_sc_mcu7t3v3__mux2_2
XFILLER_152_893 VDD VDD VSS VSS gf180mcu_as_sc_mcu7t3v3__fill_2
XFILLER_3_892 VDD VDD VSS VSS gf180mcu_as_sc_mcu7t3v3__fillcap_16
XFILLER_2_391 VDD VDD VSS VSS gf180mcu_as_sc_mcu7t3v3__fill_1
X_5040_ VDD VDD VSS VSS _6497_/Q _5086_/B _5040_/C _5040_/D _5042_/C gf180mcu_as_sc_mcu7t3v3__ao22_2
XTAP_TAPCELL_ROW_209_2504 VDD VSS gf180mcu_as_sc_mcu7t3v3__tap_2
XTAP_TAPCELL_ROW_222_2737 VDD VSS gf180mcu_as_sc_mcu7t3v3__tap_2
XFILLER_225_146 VDD VDD VSS VSS gf180mcu_as_sc_mcu7t3v3__fill_2
XFILLER_94_1210 VDD VDD VSS VSS gf180mcu_as_sc_mcu7t3v3__fillcap_8
X_5942_ VDD VDD VSS VSS _5942_/B _5956_/A _6481_/D gf180mcu_as_sc_mcu7t3v3__and2_2
XTAP_TAPCELL_ROW_49_2_2922 VDD VSS gf180mcu_as_sc_mcu7t3v3__tap_2
XFILLER_181_1224 VDD VDD VSS VSS gf180mcu_as_sc_mcu7t3v3__fillcap_16
X_5873_ VDD VDD VSS VSS _5873_/A _5873_/B _5873_/C _5873_/D _5874_/D gf180mcu_as_sc_mcu7t3v3__ao211_2
X_4824_ VDD VDD VSS VSS _5826_/A _4872_/B _4824_/C _4824_/D _4825_/B gf180mcu_as_sc_mcu7t3v3__ao211_2
XTAP_TAPCELL_ROW_179_1968 VDD VSS gf180mcu_as_sc_mcu7t3v3__tap_2
XTAP_TAPCELL_ROW_179_1957 VDD VSS gf180mcu_as_sc_mcu7t3v3__tap_2
XFILLER_178_289 VDD VDD VSS VSS gf180mcu_as_sc_mcu7t3v3__fillcap_8
XFILLER_222_1221 VDD VDD VSS VSS gf180mcu_as_sc_mcu7t3v3__fillcap_4
XFILLER_222_1243 VDD VDD VSS VSS gf180mcu_as_sc_mcu7t3v3__fillcap_16
X_4755_ VDD VDD VSS VSS _4756_/C _4877_/B _5766_/A gf180mcu_as_sc_mcu7t3v3__nor2_2
X_3706_ VDD VDD VSS VSS _6498_/Q _3804_/B _3804_/C _5716_/B _3708_/C gf180mcu_as_sc_mcu7t3v3__ao22_2
X_4686_ VDD VDD VSS VSS _4797_/S _4686_/B _5704_/A _4687_/B gf180mcu_as_sc_mcu7t3v3__mux2_2
XFILLER_179_1186 VDD VDD VSS VSS gf180mcu_as_sc_mcu7t3v3__fillcap_4
X_6425_ VDD VDD VSS VSS _6437_/CLK _6425_/D _6425_/Q gf180mcu_as_sc_mcu7t3v3__dfxtp_2
X_3637_ VDD VDD VSS VSS _4651_/B _3637_/A _5948_/A _5955_/A _3638_/A gf180mcu_as_sc_mcu7t3v3__aoi22_2
XFILLER_190_977 VDD VDD VSS VSS gf180mcu_as_sc_mcu7t3v3__fillcap_16
XPHY_EDGE_ROW_75_3_Left_780 VDD VSS gf180mcu_as_sc_mcu7t3v3__tap_2
X_6356_ VDD VDD VSS VSS _6368_/CLK _6356_/D _6356_/Q gf180mcu_as_sc_mcu7t3v3__dfxtp_2
X_3568_ VDD VDD VSS VSS _4619_/D _4977_/A _4960_/D gf180mcu_as_sc_mcu7t3v3__nor2b_2
XFILLER_68_29 VDD VDD VSS VSS gf180mcu_as_sc_mcu7t3v3__fillcap_4
X_5307_ VDD VDD VSS VSS _5307_/A _5307_/B _5307_/C _5307_/Y _5909_/D gf180mcu_as_sc_mcu7t3v3__aoi211_2
Xinput207 VDD VDD VSS VSS se_in[20] _5842_/A gf180mcu_as_sc_mcu7t3v3__buff_12
Xinput218 VDD VDD VSS VSS se_in[30] _5918_/A gf180mcu_as_sc_mcu7t3v3__buff_12
X_6287_ VDD VDD VSS VSS clkload6/A _6287_/D _6287_/Q gf180mcu_as_sc_mcu7t3v3__dfxtp_2
X_3499_ VDD VDD VSS VSS _3500_/D _5340_/B _5340_/A gf180mcu_as_sc_mcu7t3v3__nand2_2
XPHY_EDGE_ROW_134_2_Left_575 VDD VSS gf180mcu_as_sc_mcu7t3v3__tap_2
Xinput229 VDD VDD VSS VSS se_in[8] _5745_/A gf180mcu_as_sc_mcu7t3v3__buff_12
X_5238_ VDD VDD VSS VSS _5238_/B _5238_/A _6402_/D gf180mcu_as_sc_mcu7t3v3__and2_2
XFILLER_130_598 VDD VDD VSS VSS gf180mcu_as_sc_mcu7t3v3__fill_2
X_5169_ VDD VDD VSS VSS _5171_/C _6511_/Q _5296_/B _5169_/C gf180mcu_as_sc_mcu7t3v3__ao21_2
XTAP_TAPCELL_ROW_6_1120 VDD VSS gf180mcu_as_sc_mcu7t3v3__tap_2
XFILLER_140_34 VDD VDD VSS VSS gf180mcu_as_sc_mcu7t3v3__fill_1
XFILLER_186_1135 VDD VDD VSS VSS gf180mcu_as_sc_mcu7t3v3__fillcap_16
XFILLER_186_1157 VDD VDD VSS VSS gf180mcu_as_sc_mcu7t3v3__fillcap_16
XPHY_EDGE_ROW_71_2_Left_512 VDD VSS gf180mcu_as_sc_mcu7t3v3__tap_2
XFILLER_140_45 VDD VDD VSS VSS gf180mcu_as_sc_mcu7t3v3__fillcap_4
XTAP_TAPCELL_ROW_84_2_2974 VDD VSS gf180mcu_as_sc_mcu7t3v3__tap_2
XFILLER_169_212 VDD VDD VSS VSS gf180mcu_as_sc_mcu7t3v3__fill_2
XFILLER_227_1154 VDD VDD VSS VSS gf180mcu_as_sc_mcu7t3v3__fillcap_16
XFILLER_12_446 VDD VDD VSS VSS gf180mcu_as_sc_mcu7t3v3__fill_2
XFILLER_169_234 VDD VDD VSS VSS gf180mcu_as_sc_mcu7t3v3__fill_1
XFILLER_197_554 VDD VDD VSS VSS gf180mcu_as_sc_mcu7t3v3__fillcap_4
XFILLER_33_43 VDD VDD VSS VSS gf180mcu_as_sc_mcu7t3v3__fillcap_8
XFILLER_12_457 VDD VDD VSS VSS gf180mcu_as_sc_mcu7t3v3__fill_2
XFILLER_157_429 VDD VDD VSS VSS gf180mcu_as_sc_mcu7t3v3__fillcap_16
XFILLER_184_237 VDD VDD VSS VSS gf180mcu_as_sc_mcu7t3v3__fillcap_8
XFILLER_4_601 VDD VDD VSS VSS gf180mcu_as_sc_mcu7t3v3__fill_1
XFILLER_152_101 VDD VDD VSS VSS gf180mcu_as_sc_mcu7t3v3__fillcap_4
XFILLER_152_123 VDD VDD VSS VSS gf180mcu_as_sc_mcu7t3v3__fillcap_16
XFILLER_197_1264 VDD VDD VSS VSS gf180mcu_as_sc_mcu7t3v3__fill_1
XFILLER_180_454 VDD VDD VSS VSS gf180mcu_as_sc_mcu7t3v3__fill_1
XTAP_TAPCELL_ROW_138_1_1390 VDD VSS gf180mcu_as_sc_mcu7t3v3__tap_2
XTAP_TAPCELL_ROW_204_2412 VDD VSS gf180mcu_as_sc_mcu7t3v3__tap_2
XFILLER_207_135 VDD VDD VSS VSS gf180mcu_as_sc_mcu7t3v3__fillcap_4
XFILLER_165_1208 VDD VDD VSS VSS gf180mcu_as_sc_mcu7t3v3__fillcap_16
XFILLER_223_628 VDD VDD VSS VSS gf180mcu_as_sc_mcu7t3v3__fill_2
XFILLER_16_774 VDD VDD VSS VSS gf180mcu_as_sc_mcu7t3v3__fillcap_8
XFILLER_206_1205 VDD VDD VSS VSS gf180mcu_as_sc_mcu7t3v3__fillcap_16
XFILLER_188_554 VDD VDD VSS VSS gf180mcu_as_sc_mcu7t3v3__fillcap_4
XFILLER_200_37 VDD VDD VSS VSS gf180mcu_as_sc_mcu7t3v3__fillcap_16
XFILLER_204_897 VDD VDD VSS VSS gf180mcu_as_sc_mcu7t3v3__fill_2
XFILLER_206_1227 VDD VDD VSS VSS gf180mcu_as_sc_mcu7t3v3__fillcap_8
XTAP_TAPCELL_ROW_196_2268 VDD VSS gf180mcu_as_sc_mcu7t3v3__tap_2
XFILLER_129_610 VDD VDD VSS VSS gf180mcu_as_sc_mcu7t3v3__fillcap_8
XPHY_EDGE_ROW_109_2_Right_946 VDD VSS gf180mcu_as_sc_mcu7t3v3__tap_2
XFILLER_198_1017 VDD VDD VSS VSS gf180mcu_as_sc_mcu7t3v3__fillcap_16
XFILLER_144_602 VDD VDD VSS VSS gf180mcu_as_sc_mcu7t3v3__fill_2
XFILLER_156_473 VDD VDD VSS VSS gf180mcu_as_sc_mcu7t3v3__fillcap_16
XTAP_TAPCELL_ROW_174_1865 VDD VSS gf180mcu_as_sc_mcu7t3v3__tap_2
XTAP_TAPCELL_ROW_174_1876 VDD VSS gf180mcu_as_sc_mcu7t3v3__tap_2
X_4540_ VDD VDD VSS VSS _4607_/B _4610_/C _4542_/B gf180mcu_as_sc_mcu7t3v3__or2_2
XFILLER_8_995 VDD VDD VSS VSS gf180mcu_as_sc_mcu7t3v3__fillcap_16
X_4471_ VDD VDD VSS VSS _4471_/A _6276_/Q _4471_/C _4475_/B _4472_/B gf180mcu_as_sc_mcu7t3v3__ao211_2
XFILLER_171_443 VDD VDD VSS VSS gf180mcu_as_sc_mcu7t3v3__fill_2
X_6210_ VDD VDD VSS VSS _6518_/CLK _6210_/D _6210_/Q gf180mcu_as_sc_mcu7t3v3__dfxtp_2
X_3422_ VDD VDD VSS VSS _3425_/B _4570_/A _4553_/B _4553_/A gf180mcu_as_sc_mcu7t3v3__ao21_2
XPHY_EDGE_ROW_44_3_Right_124 VDD VSS gf180mcu_as_sc_mcu7t3v3__tap_2
X_6141_ VDD VDD VSS VSS clkload8/A _6141_/D _6141_/Q gf180mcu_as_sc_mcu7t3v3__dfxtp_2
Xfanout908 VDD VDD VSS VSS _4394_/A _4366_/A gf180mcu_as_sc_mcu7t3v3__buff_12
Xfanout919 VDD VDD VSS VSS fanout920/Y _4349_/S gf180mcu_as_sc_mcu7t3v3__buff_12
X_3353_ VDD VDD VSS VSS _3353_/B _3353_/A _3354_/D gf180mcu_as_sc_mcu7t3v3__or2_2
X_6072_ VDD VDD VSS VSS _6376_/CLK _6072_/D _6072_/Q gf180mcu_as_sc_mcu7t3v3__dfxtp_2
X_3284_ VDD VDD VSS VSS _3294_/B _3284_/B _3284_/C _3332_/A _3285_/C gf180mcu_as_sc_mcu7t3v3__ao211_2
X_5023_ VDD VDD VSS VSS _5693_/A _5143_/B _5143_/C _5693_/D _5024_/D gf180mcu_as_sc_mcu7t3v3__ao22_2
XFILLER_22_1226 VDD VDD VSS VSS gf180mcu_as_sc_mcu7t3v3__fillcap_16
XTAP_TAPCELL_ROW_88_1_1365 VDD VSS gf180mcu_as_sc_mcu7t3v3__tap_2
XFILLER_227_978 VDD VDD VSS VSS gf180mcu_as_sc_mcu7t3v3__fill_2
XFILLER_0_1033 VDD VDD VSS VSS gf180mcu_as_sc_mcu7t3v3__fillcap_4
XFILLER_81_666 VDD VDD VSS VSS gf180mcu_as_sc_mcu7t3v3__fill_1
X_5925_ VDD VDD VSS VSS _5925_/D _5948_/S _5925_/B _5925_/C _5926_/C gf180mcu_as_sc_mcu7t3v3__ao31_2
XFILLER_110_37 VDD VDD VSS VSS gf180mcu_as_sc_mcu7t3v3__fillcap_8
X_5856_ VDD VDD VSS VSS _5856_/A _5856_/B _5856_/C _5856_/D _5858_/C gf180mcu_as_sc_mcu7t3v3__ao211_2
XFILLER_167_727 VDD VDD VSS VSS gf180mcu_as_sc_mcu7t3v3__fill_1
XFILLER_194_513 VDD VDD VSS VSS gf180mcu_as_sc_mcu7t3v3__fillcap_4
XPHY_EDGE_ROW_3_Right_3 VDD VSS gf180mcu_as_sc_mcu7t3v3__tap_2
X_4807_ VDD VDD VSS VSS _4883_/A _4807_/B _5812_/A _4808_/B gf180mcu_as_sc_mcu7t3v3__mux2_2
XFILLER_194_535 VDD VDD VSS VSS gf180mcu_as_sc_mcu7t3v3__fillcap_4
X_5787_ VDD VDD VSS VSS _5843_/D _5795_/S _5787_/B _5787_/C _5788_/C gf180mcu_as_sc_mcu7t3v3__ao31_2
X_4738_ VDD VDD VSS VSS _6502_/Q _4960_/B _4953_/C _5749_/B _4739_/D gf180mcu_as_sc_mcu7t3v3__ao22_2
X_4669_ VDD VDD VSS VSS _4670_/C _4669_/C _4795_/B _5685_/A gf180mcu_as_sc_mcu7t3v3__aoi21_2
X_6408_ VDD VDD VSS VSS _6412_/CLK _6408_/D _6408_/Q gf180mcu_as_sc_mcu7t3v3__dfxtp_2
XFILLER_118_1210 VDD VDD VSS VSS gf180mcu_as_sc_mcu7t3v3__fillcap_16
XFILLER_150_638 VDD VDD VSS VSS gf180mcu_as_sc_mcu7t3v3__fill_2
XTAP_TAPCELL_ROW_60_1_1351 VDD VSS gf180mcu_as_sc_mcu7t3v3__tap_2
XPHY_EDGE_ROW_51_1_Left_279 VDD VSS gf180mcu_as_sc_mcu7t3v3__tap_2
Xclkbuf_1_1__f_clk VDD VDD VSS VSS clkbuf_0_clk/Y clkbuf_1_1__f_clk/Y gf180mcu_as_sc_mcu7t3v3__clkbuff_12
X_6339_ VDD VDD VSS VSS _6551_/CLK _6339_/D _6339_/Q gf180mcu_as_sc_mcu7t3v3__dfxtp_2
XFILLER_95_49 VDD VDD VSS VSS gf180mcu_as_sc_mcu7t3v3__fill_2
XFILLER_151_22 VDD VDD VSS VSS gf180mcu_as_sc_mcu7t3v3__fillcap_16
XFILLER_217_422 VDD VDD VSS VSS gf180mcu_as_sc_mcu7t3v3__fill_2
XFILLER_151_88 VDD VDD VSS VSS gf180mcu_as_sc_mcu7t3v3__fillcap_16
XFILLER_72_666 VDD VDD VSS VSS gf180mcu_as_sc_mcu7t3v3__fill_1
XFILLER_198_841 VDD VDD VSS VSS gf180mcu_as_sc_mcu7t3v3__fill_1
XFILLER_164_1252 VDD VDD VSS VSS gf180mcu_as_sc_mcu7t3v3__fillcap_8
XPHY_EDGE_ROW_50_1_Right_622 VDD VSS gf180mcu_as_sc_mcu7t3v3__tap_2
XFILLER_212_160 VDD VDD VSS VSS gf180mcu_as_sc_mcu7t3v3__fill_1
XFILLER_8_225 VDD VDD VSS VSS gf180mcu_as_sc_mcu7t3v3__fillcap_16
Xsram2048.u_bank0_1031 VDD VDD VSS VSS sram2048.u_bank0/WEN[5] gf180mcu_as_sc_mcu7t3v3__tiel_4
XFILLER_154_911 VDD VDD VSS VSS gf180mcu_as_sc_mcu7t3v3__fillcap_16
XFILLER_172_207 VDD VDD VSS VSS gf180mcu_as_sc_mcu7t3v3__fill_1
XFILLER_8_247 VDD VDD VSS VSS gf180mcu_as_sc_mcu7t3v3__fillcap_16
XTAP_TAPCELL_ROW_156_1551 VDD VSS gf180mcu_as_sc_mcu7t3v3__tap_2
XTAP_TAPCELL_ROW_191_2187 VDD VSS gf180mcu_as_sc_mcu7t3v3__tap_2
XTAP_TAPCELL_ROW_191_2176 VDD VSS gf180mcu_as_sc_mcu7t3v3__tap_2
XFILLER_153_410 VDD VDD VSS VSS gf180mcu_as_sc_mcu7t3v3__fillcap_8
XFILLER_166_782 VDD VDD VSS VSS gf180mcu_as_sc_mcu7t3v3__fill_2
XPHY_EDGE_ROW_33_2_Right_870 VDD VSS gf180mcu_as_sc_mcu7t3v3__tap_2
Xclkbuf_leaf_24_clk_regs VDD VDD VSS VSS clkload1/A _6125_/CLK gf180mcu_as_sc_mcu7t3v3__clkbuff_12
XFILLER_176_85 VDD VDD VSS VSS gf180mcu_as_sc_mcu7t3v3__fillcap_16
XFILLER_181_752 VDD VDD VSS VSS gf180mcu_as_sc_mcu7t3v3__fillcap_4
XFILLER_5_976 VDD VDD VSS VSS gf180mcu_as_sc_mcu7t3v3__fillcap_4
XFILLER_153_498 VDD VDD VSS VSS gf180mcu_as_sc_mcu7t3v3__fill_1
XFILLER_5_69 VDD VDD VSS VSS gf180mcu_as_sc_mcu7t3v3__fill_1
XFILLER_5_998 VDD VDD VSS VSS gf180mcu_as_sc_mcu7t3v3__fillcap_16
XFILLER_69_50 VDD VDD VSS VSS gf180mcu_as_sc_mcu7t3v3__fill_1
XFILLER_45_1259 VDD VDD VSS VSS gf180mcu_as_sc_mcu7t3v3__fillcap_4
XTAP_TAPCELL_ROW_15_1282 VDD VSS gf180mcu_as_sc_mcu7t3v3__tap_2
XTAP_TAPCELL_ROW_198_2308 VDD VSS gf180mcu_as_sc_mcu7t3v3__tap_2
XFILLER_165_1005 VDD VDD VSS VSS gf180mcu_as_sc_mcu7t3v3__fillcap_16
XFILLER_223_414 VDD VDD VSS VSS gf180mcu_as_sc_mcu7t3v3__fillcap_4
XFILLER_165_1049 VDD VDD VSS VSS gf180mcu_as_sc_mcu7t3v3__fill_1
XFILLER_63_666 VDD VDD VSS VSS gf180mcu_as_sc_mcu7t3v3__fill_1
X_3971_ VDD VDD VSS VSS _3974_/B _6067_/Q _3972_/D gf180mcu_as_sc_mcu7t3v3__and2_2
XFILLER_16_571 VDD VDD VSS VSS gf180mcu_as_sc_mcu7t3v3__fillcap_4
XFILLER_204_650 VDD VDD VSS VSS gf180mcu_as_sc_mcu7t3v3__fill_1
X_5710_ VDD VDD VSS VSS _5710_/A _5802_/C _5801_/S _5710_/D _5711_/D gf180mcu_as_sc_mcu7t3v3__ao22_2
XFILLER_149_716 VDD VDD VSS VSS gf180mcu_as_sc_mcu7t3v3__fillcap_16
XFILLER_188_384 VDD VDD VSS VSS gf180mcu_as_sc_mcu7t3v3__fill_1
XTAP_TAPCELL_ROW_176_1905 VDD VSS gf180mcu_as_sc_mcu7t3v3__tap_2
XTAP_TAPCELL_ROW_176_1916 VDD VSS gf180mcu_as_sc_mcu7t3v3__tap_2
XFILLER_15_1030 VDD VDD VSS VSS gf180mcu_as_sc_mcu7t3v3__fillcap_16
X_5641_ VDD VDD VSS VSS _5954_/A _5641_/B _5641_/C _5641_/D _5642_/A gf180mcu_as_sc_mcu7t3v3__ao211_2
XTAP_TAPCELL_ROW_217_2647 VDD VSS gf180mcu_as_sc_mcu7t3v3__tap_2
XFILLER_15_1052 VDD VDD VSS VSS gf180mcu_as_sc_mcu7t3v3__fillcap_16
X_5572_ VDD VDD VSS VSS _5573_/A _5878_/B _5572_/B _5572_/C gf180mcu_as_sc_mcu7t3v3__ao21_2
XFILLER_8_770 VDD VDD VSS VSS gf180mcu_as_sc_mcu7t3v3__fillcap_4
X_4523_ VDD VDD VSS VSS _4524_/A _4523_/B _4524_/B _4525_/B gf180mcu_as_sc_mcu7t3v3__nand3_2
XFILLER_117_657 VDD VDD VSS VSS gf180mcu_as_sc_mcu7t3v3__fillcap_4
XFILLER_171_240 VDD VDD VSS VSS gf180mcu_as_sc_mcu7t3v3__fillcap_16
XFILLER_132_616 VDD VDD VSS VSS gf180mcu_as_sc_mcu7t3v3__fill_1
XFILLER_172_1009 VDD VDD VSS VSS gf180mcu_as_sc_mcu7t3v3__fillcap_4
X_4454_ VDD VDD VSS VSS _4599_/A _6150_/Q _6264_/Q _6264_/D gf180mcu_as_sc_mcu7t3v3__mux2_2
XFILLER_176_1189 VDD VDD VSS VSS gf180mcu_as_sc_mcu7t3v3__fillcap_16
X_4385_ VDD VDD VSS VSS _6223_/Q _4399_/B _4399_/C _6224_/Q _4386_/C gf180mcu_as_sc_mcu7t3v3__ao22_2
X_3405_ VDD VDD VSS VSS _3406_/B _6309_/Q _6307_/Q _6310_/Q gf180mcu_as_sc_mcu7t3v3__aoi21b_2
XFILLER_217_1186 VDD VDD VSS VSS gf180mcu_as_sc_mcu7t3v3__fillcap_4
XPHY_EDGE_ROW_45_3_Right_125 VDD VSS gf180mcu_as_sc_mcu7t3v3__tap_2
Xfanout716 VDD VDD VSS VSS _5944_/B _5951_/B gf180mcu_as_sc_mcu7t3v3__buff_12
Xfanout727 VDD VDD VSS VSS _5573_/S _5565_/B gf180mcu_as_sc_mcu7t3v3__buff_12
Xfanout738 VDD VDD VSS VSS _5616_/B _5571_/C gf180mcu_as_sc_mcu7t3v3__buff_12
Xfanout749 VDD VDD VSS VSS _3869_/B _3926_/B gf180mcu_as_sc_mcu7t3v3__buff_12
X_6124_ VDD VDD VSS VSS _6525_/CLK _6124_/D _6124_/Q gf180mcu_as_sc_mcu7t3v3__dfxtp_2
X_3336_ VDD VDD VSS VSS _6199_/Q _4072_/B _4089_/S _6223_/Q _3337_/B gf180mcu_as_sc_mcu7t3v3__ao22_2
X_6055_ VDD VDD VSS VSS _6519_/CLK _6055_/D _6055_/Q gf180mcu_as_sc_mcu7t3v3__dfxtp_2
XTAP_TAPCELL_ROW_37_2_2904 VDD VSS gf180mcu_as_sc_mcu7t3v3__tap_2
XPHY_EDGE_ROW_106_3_Left_811 VDD VSS gf180mcu_as_sc_mcu7t3v3__tap_2
X_5006_ VDD VDD VSS VSS _5678_/A _5218_/B _5006_/C _5006_/D _5007_/A gf180mcu_as_sc_mcu7t3v3__ao211_2
X_3267_ VDD VDD VSS VSS _3281_/D _3267_/B _6302_/Q _3268_/B gf180mcu_as_sc_mcu7t3v3__mux2_2
XFILLER_227_753 VDD VDD VSS VSS gf180mcu_as_sc_mcu7t3v3__fill_1
XFILLER_54_611 VDD VDD VSS VSS gf180mcu_as_sc_mcu7t3v3__fill_1
X_3198_ VDD VDD VSS VSS _6013_/S _3198_/B _3291_/B gf180mcu_as_sc_mcu7t3v3__nand2b_2
XFILLER_183_1116 VDD VDD VSS VSS gf180mcu_as_sc_mcu7t3v3__fillcap_4
XFILLER_183_1138 VDD VDD VSS VSS gf180mcu_as_sc_mcu7t3v3__fillcap_16
XFILLER_214_447 VDD VDD VSS VSS gf180mcu_as_sc_mcu7t3v3__fill_1
XFILLER_228_1260 VDD VDD VSS VSS gf180mcu_as_sc_mcu7t3v3__fillcap_4
XFILLER_167_513 VDD VDD VSS VSS gf180mcu_as_sc_mcu7t3v3__fill_2
XFILLER_210_631 VDD VDD VSS VSS gf180mcu_as_sc_mcu7t3v3__fillcap_16
XFILLER_224_1135 VDD VDD VSS VSS gf180mcu_as_sc_mcu7t3v3__fillcap_16
X_5908_ VDD VDD VSS VSS _5909_/C _5908_/C _5947_/B _5908_/A gf180mcu_as_sc_mcu7t3v3__aoi21_2
XFILLER_194_321 VDD VDD VSS VSS gf180mcu_as_sc_mcu7t3v3__fill_2
XFILLER_224_1157 VDD VDD VSS VSS gf180mcu_as_sc_mcu7t3v3__fillcap_16
X_5839_ VDD VDD VSS VSS _5839_/A _5839_/B _5839_/C _5839_/D _5840_/D gf180mcu_as_sc_mcu7t3v3__ao22_2
XFILLER_195_888 VDD VDD VSS VSS gf180mcu_as_sc_mcu7t3v3__fillcap_16
XFILLER_182_527 VDD VDD VSS VSS gf180mcu_as_sc_mcu7t3v3__fillcap_4
XFILLER_194_387 VDD VDD VSS VSS gf180mcu_as_sc_mcu7t3v3__fillcap_8
XFILLER_5_206 VDD VDD VSS VSS gf180mcu_as_sc_mcu7t3v3__fillcap_4
XFILLER_5_228 VDD VDD VSS VSS gf180mcu_as_sc_mcu7t3v3__fillcap_16
XFILLER_108_657 VDD VDD VSS VSS gf180mcu_as_sc_mcu7t3v3__fillcap_8
XFILLER_146_22 VDD VDD VSS VSS gf180mcu_as_sc_mcu7t3v3__fillcap_8
XFILLER_163_796 VDD VDD VSS VSS gf180mcu_as_sc_mcu7t3v3__fill_1
XFILLER_190_582 VDD VDD VSS VSS gf180mcu_as_sc_mcu7t3v3__fillcap_8
XFILLER_162_295 VDD VDD VSS VSS gf180mcu_as_sc_mcu7t3v3__fillcap_16
XFILLER_2_979 VDD VDD VSS VSS gf180mcu_as_sc_mcu7t3v3__fillcap_16
XPHY_EDGE_ROW_38_3_Left_743 VDD VSS gf180mcu_as_sc_mcu7t3v3__tap_2
XTAP_TAPCELL_ROW_72_2_2956 VDD VSS gf180mcu_as_sc_mcu7t3v3__tap_2
Xmesh_tile_1126 VDD VDD VSS VSS se_out[13] gf180mcu_as_sc_mcu7t3v3__tiel_4
Xmesh_tile_1115 VDD VDD VSS VSS se_out[2] gf180mcu_as_sc_mcu7t3v3__tiel_4
Xmesh_tile_1104 VDD VDD VSS VSS nw_out[27] gf180mcu_as_sc_mcu7t3v3__tiel_4
XFILLER_188_1049 VDD VDD VSS VSS gf180mcu_as_sc_mcu7t3v3__fillcap_16
XFILLER_45_600 VDD VDD VSS VSS gf180mcu_as_sc_mcu7t3v3__fill_1
Xmesh_tile_1159 VDD VDD VSS VSS sw_out[10] gf180mcu_as_sc_mcu7t3v3__tiel_4
Xmesh_tile_1148 VDD VDD VSS VSS se_out[35] gf180mcu_as_sc_mcu7t3v3__tiel_4
Xmesh_tile_1137 VDD VDD VSS VSS se_out[24] gf180mcu_as_sc_mcu7t3v3__tiel_4
XFILLER_55_41 VDD VDD VSS VSS gf180mcu_as_sc_mcu7t3v3__fill_1
XFILLER_221_907 VDD VDD VSS VSS gf180mcu_as_sc_mcu7t3v3__fill_2
XFILLER_45_666 VDD VDD VSS VSS gf180mcu_as_sc_mcu7t3v3__fill_1
XTAP_TAPCELL_ROW_10_1190 VDD VSS gf180mcu_as_sc_mcu7t3v3__tap_2
XFILLER_60_625 VDD VDD VSS VSS gf180mcu_as_sc_mcu7t3v3__fill_2
XTAP_TAPCELL_ROW_193_2216 VDD VSS gf180mcu_as_sc_mcu7t3v3__tap_2
XFILLER_158_524 VDD VDD VSS VSS gf180mcu_as_sc_mcu7t3v3__fill_1
XFILLER_203_1208 VDD VDD VSS VSS gf180mcu_as_sc_mcu7t3v3__fillcap_16
XPHY_EDGE_ROW_207_Right_75 VDD VSS gf180mcu_as_sc_mcu7t3v3__tap_2
XPHY_EDGE_ROW_51_1_Right_623 VDD VSS gf180mcu_as_sc_mcu7t3v3__tap_2
XFILLER_154_730 VDD VDD VSS VSS gf180mcu_as_sc_mcu7t3v3__fillcap_4
XTAP_TAPCELL_ROW_171_1813 VDD VSS gf180mcu_as_sc_mcu7t3v3__tap_2
XTAP_TAPCELL_ROW_171_1824 VDD VSS gf180mcu_as_sc_mcu7t3v3__tap_2
XPHY_EDGE_ROW_34_2_Right_871 VDD VSS gf180mcu_as_sc_mcu7t3v3__tap_2
XTAP_TAPCELL_ROW_212_2566 VDD VSS gf180mcu_as_sc_mcu7t3v3__tap_2
XTAP_TAPCELL_ROW_212_2555 VDD VSS gf180mcu_as_sc_mcu7t3v3__tap_2
X_4170_ VDD VDD VSS VSS _4170_/A _4170_/B _4170_/C _4170_/D _4171_/B gf180mcu_as_sc_mcu7t3v3__nand4_2
XFILLER_206_69 VDD VDD VSS VSS gf180mcu_as_sc_mcu7t3v3__fillcap_16
XPHY_EDGE_ROW_216_Right_84 VDD VSS gf180mcu_as_sc_mcu7t3v3__tap_2
XTAP_TAPCELL_ROW_169_1775 VDD VSS gf180mcu_as_sc_mcu7t3v3__tap_2
X_3121_ VDD VDD VSS VSS _4471_/C _3121_/B _3121_/C _3122_/B _3172_/B gf180mcu_as_sc_mcu7t3v3__oai211_2
XFILLER_209_731 VDD VDD VSS VSS gf180mcu_as_sc_mcu7t3v3__fill_1
XTAP_TAPCELL_ROW_169_1786 VDD VSS gf180mcu_as_sc_mcu7t3v3__tap_2
X_3052_ VDD VDD VSS VSS _4214_/A _6198_/Q gf180mcu_as_sc_mcu7t3v3__inv_2
XFILLER_208_1119 VDD VDD VSS VSS gf180mcu_as_sc_mcu7t3v3__fillcap_16
XFILLER_189_682 VDD VDD VSS VSS gf180mcu_as_sc_mcu7t3v3__fill_2
XFILLER_211_439 VDD VDD VSS VSS gf180mcu_as_sc_mcu7t3v3__fill_1
XPHY_EDGE_ROW_225_Right_93 VDD VSS gf180mcu_as_sc_mcu7t3v3__tap_2
X_3954_ VDD VDD VSS VSS _3963_/B _6057_/Q _3955_/D gf180mcu_as_sc_mcu7t3v3__and2_2
XFILLER_149_546 VDD VDD VSS VSS gf180mcu_as_sc_mcu7t3v3__fillcap_16
X_3885_ VDD VDD VSS VSS _6039_/Q _3904_/B _4009_/A _3904_/D _6039_/D gf180mcu_as_sc_mcu7t3v3__ao22_2
XFILLER_164_505 VDD VDD VSS VSS gf180mcu_as_sc_mcu7t3v3__fill_1
XFILLER_220_995 VDD VDD VSS VSS gf180mcu_as_sc_mcu7t3v3__fillcap_16
X_5624_ VDD VDD VSS VSS _5625_/A _5937_/A _5632_/B _5624_/C gf180mcu_as_sc_mcu7t3v3__ao21_2
XFILLER_164_527 VDD VDD VSS VSS gf180mcu_as_sc_mcu7t3v3__fillcap_4
XFILLER_176_387 VDD VDD VSS VSS gf180mcu_as_sc_mcu7t3v3__fillcap_4
XPHY_EDGE_ROW_143_2_Left_584 VDD VSS gf180mcu_as_sc_mcu7t3v3__tap_2
XFILLER_157_590 VDD VDD VSS VSS gf180mcu_as_sc_mcu7t3v3__fillcap_4
XFILLER_191_368 VDD VDD VSS VSS gf180mcu_as_sc_mcu7t3v3__fill_2
X_5555_ VDD VDD VSS VSS _6516_/Q _5564_/B _5563_/B _5863_/A _5556_/C gf180mcu_as_sc_mcu7t3v3__ao22_2
X_5486_ VDD VDD VSS VSS _5488_/C _5486_/A _5486_/B _5486_/C gf180mcu_as_sc_mcu7t3v3__ao21_2
X_4506_ VDD VDD VSS VSS _4610_/C _4523_/B _4551_/B _4508_/C gf180mcu_as_sc_mcu7t3v3__nor3_2
XFILLER_28_1210 VDD VDD VSS VSS gf180mcu_as_sc_mcu7t3v3__fillcap_4
XPHY_EDGE_ROW_80_2_Left_521 VDD VSS gf180mcu_as_sc_mcu7t3v3__tap_2
X_4437_ VDD VDD VSS VSS _6253_/Q _4442_/B _4442_/C _6252_/Q _6252_/D gf180mcu_as_sc_mcu7t3v3__ao22_2
Xfanout502 VDD VDD VSS VSS fanout505/Y _3895_/D gf180mcu_as_sc_mcu7t3v3__buff_12
Xfanout524 VDD VDD VSS VSS _3936_/Y _3975_/C gf180mcu_as_sc_mcu7t3v3__buff_12
XFILLER_160_799 VDD VDD VSS VSS gf180mcu_as_sc_mcu7t3v3__fillcap_4
XFILLER_76_29 VDD VDD VSS VSS gf180mcu_as_sc_mcu7t3v3__fillcap_4
XPHY_EDGE_ROW_46_3_Right_126 VDD VSS gf180mcu_as_sc_mcu7t3v3__tap_2
Xfanout535 VDD VDD VSS VSS _5955_/S _5948_/S gf180mcu_as_sc_mcu7t3v3__buff_12
Xfanout546 VDD VDD VSS VSS _5357_/Y _5531_/B gf180mcu_as_sc_mcu7t3v3__buff_12
Xfanout557 VDD VDD VSS VSS _4654_/Y _4844_/S gf180mcu_as_sc_mcu7t3v3__buff_12
X_6107_ VDD VDD VSS VSS _6125_/CLK _6107_/D _6107_/Q gf180mcu_as_sc_mcu7t3v3__dfxtp_2
X_4368_ VDD VDD VSS VSS _4369_/C _4370_/S _6034_/Q gf180mcu_as_sc_mcu7t3v3__nor2b_2
Xfanout568 VDD VDD VSS VSS _3856_/B _3810_/B gf180mcu_as_sc_mcu7t3v3__buff_12
Xfanout579 VDD VDD VSS VSS _3645_/Y _4045_/A gf180mcu_as_sc_mcu7t3v3__buff_12
X_4299_ VDD VDD VSS VSS _4370_/S _6111_/Q _4299_/C _4369_/D _4303_/C gf180mcu_as_sc_mcu7t3v3__ao211_2
X_3319_ VDD VDD VSS VSS _3319_/B _3343_/A _3323_/A gf180mcu_as_sc_mcu7t3v3__or2_2
XFILLER_27_600 VDD VDD VSS VSS gf180mcu_as_sc_mcu7t3v3__fill_1
X_6038_ VDD VDD VSS VSS _6125_/CLK _6038_/D _6038_/Q gf180mcu_as_sc_mcu7t3v3__dfxtp_2
XFILLER_162_6 VDD VDD VSS VSS gf180mcu_as_sc_mcu7t3v3__fillcap_8
XFILLER_27_666 VDD VDD VSS VSS gf180mcu_as_sc_mcu7t3v3__fill_1
XFILLER_203_907 VDD VDD VSS VSS gf180mcu_as_sc_mcu7t3v3__fill_2
XFILLER_214_244 VDD VDD VSS VSS gf180mcu_as_sc_mcu7t3v3__fill_1
XFILLER_186_107 VDD VDD VSS VSS gf180mcu_as_sc_mcu7t3v3__fillcap_4
XFILLER_199_479 VDD VDD VSS VSS gf180mcu_as_sc_mcu7t3v3__fillcap_8
XFILLER_228_1090 VDD VDD VSS VSS gf180mcu_as_sc_mcu7t3v3__fill_2
XFILLER_35_1214 VDD VDD VSS VSS gf180mcu_as_sc_mcu7t3v3__fill_1
XFILLER_211_940 VDD VDD VSS VSS gf180mcu_as_sc_mcu7t3v3__fillcap_16
XFILLER_195_674 VDD VDD VSS VSS gf180mcu_as_sc_mcu7t3v3__fill_2
XFILLER_122_1239 VDD VDD VSS VSS gf180mcu_as_sc_mcu7t3v3__fillcap_4
XFILLER_167_398 VDD VDD VSS VSS gf180mcu_as_sc_mcu7t3v3__fillcap_16
XFILLER_182_313 VDD VDD VSS VSS gf180mcu_as_sc_mcu7t3v3__fill_2
XFILLER_41_43 VDD VDD VSS VSS gf180mcu_as_sc_mcu7t3v3__fillcap_8
Xwire958 VDD VDD VSS VSS wire958/A _5813_/A gf180mcu_as_sc_mcu7t3v3__clkbuff_12
XFILLER_157_54 VDD VDD VSS VSS gf180mcu_as_sc_mcu7t3v3__fillcap_16
Xwire969 VDD VDD VSS VSS input4/Y _3540_/A gf180mcu_as_sc_mcu7t3v3__clkbuff_12
XFILLER_2_732 VDD VDD VSS VSS gf180mcu_as_sc_mcu7t3v3__fill_2
XFILLER_2_776 VDD VDD VSS VSS gf180mcu_as_sc_mcu7t3v3__fill_1
XFILLER_81_1212 VDD VDD VSS VSS gf180mcu_as_sc_mcu7t3v3__fill_1
XTAP_TAPCELL_ROW_186_2086 VDD VSS gf180mcu_as_sc_mcu7t3v3__tap_2
XFILLER_2_37 VDD VDD VSS VSS gf180mcu_as_sc_mcu7t3v3__fillcap_16
XTAP_TAPCELL_ROW_186_2097 VDD VSS gf180mcu_as_sc_mcu7t3v3__tap_2
XFILLER_18_600 VDD VDD VSS VSS gf180mcu_as_sc_mcu7t3v3__fill_1
XTAP_TAPCELL_ROW_12_1230 VDD VSS gf180mcu_as_sc_mcu7t3v3__tap_2
XFILLER_218_594 VDD VDD VSS VSS gf180mcu_as_sc_mcu7t3v3__fill_1
XPHY_EDGE_ROW_139_1_Left_367 VDD VSS gf180mcu_as_sc_mcu7t3v3__tap_2
XTAP_TAPCELL_ROW_164_1694 VDD VSS gf180mcu_as_sc_mcu7t3v3__tap_2
XFILLER_205_277 VDD VDD VSS VSS gf180mcu_as_sc_mcu7t3v3__fill_2
XFILLER_159_844 VDD VDD VSS VSS gf180mcu_as_sc_mcu7t3v3__fill_1
XFILLER_198_490 VDD VDD VSS VSS gf180mcu_as_sc_mcu7t3v3__fill_2
XPHY_EDGE_ROW_76_1_Left_304 VDD VSS gf180mcu_as_sc_mcu7t3v3__tap_2
XFILLER_13_382 VDD VDD VSS VSS gf180mcu_as_sc_mcu7t3v3__fill_1
XFILLER_202_995 VDD VDD VSS VSS gf180mcu_as_sc_mcu7t3v3__fillcap_16
XPHY_EDGE_ROW_52_1_Right_624 VDD VSS gf180mcu_as_sc_mcu7t3v3__tap_2
XFILLER_12_1011 VDD VDD VSS VSS gf180mcu_as_sc_mcu7t3v3__fillcap_4
XFILLER_158_376 VDD VDD VSS VSS gf180mcu_as_sc_mcu7t3v3__fill_2
XFILLER_173_313 VDD VDD VSS VSS gf180mcu_as_sc_mcu7t3v3__fillcap_8
XFILLER_186_685 VDD VDD VSS VSS gf180mcu_as_sc_mcu7t3v3__fill_2
X_3670_ VDD VDD VSS VSS _3805_/B _5681_/A _3671_/D gf180mcu_as_sc_mcu7t3v3__and2_2
XFILLER_12_1033 VDD VDD VSS VSS gf180mcu_as_sc_mcu7t3v3__fillcap_16
XFILLER_173_368 VDD VDD VSS VSS gf180mcu_as_sc_mcu7t3v3__fillcap_8
XFILLER_177_1240 VDD VDD VSS VSS gf180mcu_as_sc_mcu7t3v3__fillcap_16
X_5340_ VDD VDD VSS VSS _5340_/A _5340_/B _5340_/C _5340_/D _5654_/C gf180mcu_as_sc_mcu7t3v3__ao22_2
XFILLER_177_1262 VDD VDD VSS VSS gf180mcu_as_sc_mcu7t3v3__fill_2
XFILLER_49_2 VDD VDD VSS VSS gf180mcu_as_sc_mcu7t3v3__fillcap_16
XPHY_EDGE_ROW_35_2_Right_872 VDD VSS gf180mcu_as_sc_mcu7t3v3__tap_2
X_5271_ VDD VDD VSS VSS _5915_/A _5309_/B _5271_/C _5297_/A _5273_/C gf180mcu_as_sc_mcu7t3v3__ao22_2
X_4222_ VDD VDD VSS VSS _4223_/C _4222_/C _4222_/B _4366_/D gf180mcu_as_sc_mcu7t3v3__aoi21_2
XFILLER_228_314 VDD VDD VSS VSS gf180mcu_as_sc_mcu7t3v3__fill_1
X_4153_ VDD VDD VSS VSS _4572_/A _4153_/B _4153_/C _4571_/C _4241_/B gf180mcu_as_sc_mcu7t3v3__ao211_2
XFILLER_214_1189 VDD VDD VSS VSS gf180mcu_as_sc_mcu7t3v3__fillcap_16
X_4084_ VDD VDD VSS VSS _4085_/S _6721_/A _6144_/Q _6144_/D gf180mcu_as_sc_mcu7t3v3__mux2_2
X_3104_ VDD VDD VSS VSS _3374_/B _6259_/Q _4509_/A gf180mcu_as_sc_mcu7t3v3__nor2_2
X_3035_ VDD VDD VSS VSS _5629_/A _5941_/A gf180mcu_as_sc_mcu7t3v3__inv_2
XFILLER_102_27 VDD VDD VSS VSS gf180mcu_as_sc_mcu7t3v3__fillcap_8
XFILLER_209_583 VDD VDD VSS VSS gf180mcu_as_sc_mcu7t3v3__fill_1
XFILLER_224_531 VDD VDD VSS VSS gf180mcu_as_sc_mcu7t3v3__fill_1
XFILLER_3_1256 VDD VDD VSS VSS gf180mcu_as_sc_mcu7t3v3__fillcap_4
XFILLER_102_49 VDD VDD VSS VSS gf180mcu_as_sc_mcu7t3v3__fill_2
XFILLER_168_107 VDD VDD VSS VSS gf180mcu_as_sc_mcu7t3v3__fillcap_16
XFILLER_180_1119 VDD VDD VSS VSS gf180mcu_as_sc_mcu7t3v3__fillcap_16
XFILLER_197_928 VDD VDD VSS VSS gf180mcu_as_sc_mcu7t3v3__fillcap_16
XFILLER_212_737 VDD VDD VSS VSS gf180mcu_as_sc_mcu7t3v3__fill_1
X_4986_ VDD VDD VSS VSS _4987_/B _5351_/A _4986_/A gf180mcu_as_sc_mcu7t3v3__nand2_2
XPHY_EDGE_ROW_60_1_Left_288 VDD VSS gf180mcu_as_sc_mcu7t3v3__tap_2
X_3937_ VDD VDD VSS VSS _4018_/B _3974_/D _3974_/B _6045_/Q _6045_/D gf180mcu_as_sc_mcu7t3v3__ao22_2
XFILLER_211_269 VDD VDD VSS VSS gf180mcu_as_sc_mcu7t3v3__fill_1
XFILLER_221_1116 VDD VDD VSS VSS gf180mcu_as_sc_mcu7t3v3__fillcap_4
XFILLER_164_313 VDD VDD VSS VSS gf180mcu_as_sc_mcu7t3v3__fill_2
XFILLER_176_173 VDD VDD VSS VSS gf180mcu_as_sc_mcu7t3v3__fill_2
XFILLER_177_685 VDD VDD VSS VSS gf180mcu_as_sc_mcu7t3v3__fillcap_4
XFILLER_221_1138 VDD VDD VSS VSS gf180mcu_as_sc_mcu7t3v3__fillcap_16
X_3868_ VDD VDD VSS VSS _6515_/Q _3868_/B _3868_/C _5854_/B _3870_/C gf180mcu_as_sc_mcu7t3v3__ao22_2
XFILLER_191_110 VDD VDD VSS VSS gf180mcu_as_sc_mcu7t3v3__fill_1
X_5607_ VDD VDD VSS VSS _5917_/A _5628_/D _5607_/C _6442_/D _5957_/C gf180mcu_as_sc_mcu7t3v3__aoi211_2
X_3799_ VDD VDD VSS VSS _5794_/A _3809_/B _3810_/B _3799_/D _3801_/A gf180mcu_as_sc_mcu7t3v3__ao211_2
XFILLER_191_154 VDD VDD VSS VSS gf180mcu_as_sc_mcu7t3v3__fillcap_4
X_5538_ VDD VDD VSS VSS _5539_/B _5538_/A _5538_/B _5538_/C gf180mcu_as_sc_mcu7t3v3__ao21_2
XFILLER_11_68 VDD VDD VSS VSS gf180mcu_as_sc_mcu7t3v3__fill_2
X_5469_ VDD VDD VSS VSS _5772_/A _5567_/B _5469_/C _5469_/D _5470_/C gf180mcu_as_sc_mcu7t3v3__ao211_2
XFILLER_154_1081 VDD VDD VSS VSS gf180mcu_as_sc_mcu7t3v3__fillcap_4
XFILLER_189_1100 VDD VDD VSS VSS gf180mcu_as_sc_mcu7t3v3__fillcap_16
XPHY_EDGE_ROW_47_3_Right_127 VDD VSS gf180mcu_as_sc_mcu7t3v3__tap_2
XFILLER_189_1122 VDD VDD VSS VSS gf180mcu_as_sc_mcu7t3v3__fillcap_16
XFILLER_8_1189 VDD VDD VSS VSS gf180mcu_as_sc_mcu7t3v3__fillcap_16
XTAP_TAPCELL_ROW_9_1173 VDD VSS gf180mcu_as_sc_mcu7t3v3__tap_2
XFILLER_228_881 VDD VDD VSS VSS gf180mcu_as_sc_mcu7t3v3__fill_2
XTAP_TAPCELL_ROW_9_1184 VDD VSS gf180mcu_as_sc_mcu7t3v3__tap_2
XFILLER_199_254 VDD VDD VSS VSS gf180mcu_as_sc_mcu7t3v3__fillcap_8
XFILLER_226_1049 VDD VDD VSS VSS gf180mcu_as_sc_mcu7t3v3__fillcap_16
XFILLER_202_236 VDD VDD VSS VSS gf180mcu_as_sc_mcu7t3v3__fillcap_8
XFILLER_202_247 VDD VDD VSS VSS gf180mcu_as_sc_mcu7t3v3__fillcap_4
XFILLER_11_842 VDD VDD VSS VSS gf180mcu_as_sc_mcu7t3v3__fillcap_16
XFILLER_161_1030 VDD VDD VSS VSS gf180mcu_as_sc_mcu7t3v3__fillcap_16
XFILLER_161_1052 VDD VDD VSS VSS gf180mcu_as_sc_mcu7t3v3__fillcap_16
XFILLER_168_53 VDD VDD VSS VSS gf180mcu_as_sc_mcu7t3v3__fillcap_16
Xinput18 VDD VDD VSS VSS boot_data[0] _3309_/A gf180mcu_as_sc_mcu7t3v3__buff_12
XFILLER_155_346 VDD VDD VSS VSS gf180mcu_as_sc_mcu7t3v3__fillcap_4
XFILLER_156_858 VDD VDD VSS VSS gf180mcu_as_sc_mcu7t3v3__fillcap_4
XFILLER_182_121 VDD VDD VSS VSS gf180mcu_as_sc_mcu7t3v3__fill_1
Xinput29 VDD VDD VSS VSS dft_addr[10] _3196_/B gf180mcu_as_sc_mcu7t3v3__buff_12
XFILLER_155_379 VDD VDD VSS VSS gf180mcu_as_sc_mcu7t3v3__fillcap_8
XFILLER_183_699 VDD VDD VSS VSS gf180mcu_as_sc_mcu7t3v3__fill_1
XTAP_TAPCELL_ROW_60_2_2938 VDD VSS gf180mcu_as_sc_mcu7t3v3__tap_2
XFILLER_170_349 VDD VDD VSS VSS gf180mcu_as_sc_mcu7t3v3__fillcap_8
XFILLER_184_41 VDD VDD VSS VSS gf180mcu_as_sc_mcu7t3v3__fill_2
XTAP_TAPCELL_ROW_188_2126 VDD VSS gf180mcu_as_sc_mcu7t3v3__tap_2
XPHY_EDGE_ROW_179_Left_407 VDD VSS gf180mcu_as_sc_mcu7t3v3__tap_2
XTAP_TAPCELL_ROW_149_1409 VDD VSS gf180mcu_as_sc_mcu7t3v3__tap_2
XTAP_TAPCELL_ROW_166_1723 VDD VSS gf180mcu_as_sc_mcu7t3v3__tap_2
XTAP_TAPCELL_ROW_166_1734 VDD VSS gf180mcu_as_sc_mcu7t3v3__tap_2
XTAP_TAPCELL_ROW_207_2476 VDD VSS gf180mcu_as_sc_mcu7t3v3__tap_2
XTAP_TAPCELL_ROW_207_2465 VDD VSS gf180mcu_as_sc_mcu7t3v3__tap_2
XFILLER_203_59 VDD VDD VSS VSS gf180mcu_as_sc_mcu7t3v3__fillcap_8
XFILLER_178_416 VDD VDD VSS VSS gf180mcu_as_sc_mcu7t3v3__fill_1
XFILLER_179_939 VDD VDD VSS VSS gf180mcu_as_sc_mcu7t3v3__fill_2
XFILLER_206_597 VDD VDD VSS VSS gf180mcu_as_sc_mcu7t3v3__fillcap_8
XFILLER_221_523 VDD VDD VSS VSS gf180mcu_as_sc_mcu7t3v3__fill_1
X_4840_ VDD VDD VSS VSS _4840_/A _4840_/B _4840_/C _4841_/D _4841_/B gf180mcu_as_sc_mcu7t3v3__aoi211_2
XPHY_EDGE_ROW_188_Left_416 VDD VSS gf180mcu_as_sc_mcu7t3v3__tap_2
XTAP_TAPCELL_ROW_220_2698 VDD VSS gf180mcu_as_sc_mcu7t3v3__tap_2
XFILLER_18_1242 VDD VDD VSS VSS gf180mcu_as_sc_mcu7t3v3__fill_1
X_6510_ VDD VDD VSS VSS _6517_/CLK _6510_/D _6510_/Q gf180mcu_as_sc_mcu7t3v3__dfxtp_2
X_4771_ VDD VDD VSS VSS _4795_/C _5785_/A _4777_/C gf180mcu_as_sc_mcu7t3v3__and2_2
XFILLER_13_190 VDD VDD VSS VSS gf180mcu_as_sc_mcu7t3v3__fillcap_16
XFILLER_193_419 VDD VDD VSS VSS gf180mcu_as_sc_mcu7t3v3__fill_1
X_3722_ VDD VDD VSS VSS _4028_/A _3722_/C _3865_/B _5730_/A gf180mcu_as_sc_mcu7t3v3__aoi21_2
XPHY_EDGE_ROW_53_1_Right_625 VDD VSS gf180mcu_as_sc_mcu7t3v3__tap_2
X_6441_ VDD VDD VSS VSS _6448_/CLK _6441_/D _6441_/Q gf180mcu_as_sc_mcu7t3v3__dfxtp_2
X_3653_ VDD VDD VSS VSS _3653_/A _3653_/B _3654_/A _3653_/D _3902_/S gf180mcu_as_sc_mcu7t3v3__ao211_2
XPHY_EDGE_ROW_115_3_Left_820 VDD VSS gf180mcu_as_sc_mcu7t3v3__tap_2
X_6372_ VDD VDD VSS VSS _6376_/CLK _6372_/D _6372_/Q gf180mcu_as_sc_mcu7t3v3__dfxtp_2
X_5323_ VDD VDD VSS VSS _5323_/A _5323_/B _5323_/C _5325_/A _5646_/B gf180mcu_as_sc_mcu7t3v3__ao22_2
X_3584_ VDD VDD VSS VSS _5973_/B _3585_/C _3585_/D _3610_/B gf180mcu_as_sc_mcu7t3v3__nor3_2
XFILLER_170_872 VDD VDD VSS VSS gf180mcu_as_sc_mcu7t3v3__fill_2
XPHY_EDGE_ROW_197_Left_425 VDD VSS gf180mcu_as_sc_mcu7t3v3__tap_2
XPHY_EDGE_ROW_36_2_Right_873 VDD VSS gf180mcu_as_sc_mcu7t3v3__tap_2
X_5254_ VDD VDD VSS VSS _5897_/D _5263_/B _5302_/C _5254_/D _5255_/B gf180mcu_as_sc_mcu7t3v3__ao22_2
X_5185_ VDD VDD VSS VSS _5186_/D _5186_/B _5293_/B _5839_/A gf180mcu_as_sc_mcu7t3v3__aoi21b_2
X_4205_ VDD VDD VSS VSS _4214_/B _6198_/Q _4206_/B gf180mcu_as_sc_mcu7t3v3__xnor2_2
XTAP_TAPCELL_ROW_227_2819 VDD VSS gf180mcu_as_sc_mcu7t3v3__tap_2
XFILLER_151_1254 VDD VDD VSS VSS gf180mcu_as_sc_mcu7t3v3__fill_2
X_4136_ VDD VDD VSS VSS _4140_/S _6186_/Q _6185_/Q _6185_/D gf180mcu_as_sc_mcu7t3v3__mux2_2
XFILLER_216_317 VDD VDD VSS VSS gf180mcu_as_sc_mcu7t3v3__fill_1
XFILLER_228_144 VDD VDD VSS VSS gf180mcu_as_sc_mcu7t3v3__fill_1
X_4067_ VDD VDD VSS VSS _6014_/C _6488_/Q _6015_/B gf180mcu_as_sc_mcu7t3v3__xnor2_2
X_3018_ VDD VDD VSS VSS _4973_/C _3547_/A gf180mcu_as_sc_mcu7t3v3__inv_2
XTAP_TAPCELL_ROW_4_1092 VDD VSS gf180mcu_as_sc_mcu7t3v3__tap_2
XTAP_TAPCELL_ROW_4_1081 VDD VSS gf180mcu_as_sc_mcu7t3v3__tap_2
XFILLER_169_438 VDD VDD VSS VSS gf180mcu_as_sc_mcu7t3v3__fillcap_16
XFILLER_196_224 VDD VDD VSS VSS gf180mcu_as_sc_mcu7t3v3__fill_2
XFILLER_197_736 VDD VDD VSS VSS gf180mcu_as_sc_mcu7t3v3__fill_1
XTAP_TAPCELL_ROW_143_2_3063 VDD VSS gf180mcu_as_sc_mcu7t3v3__tap_2
XFILLER_212_589 VDD VDD VSS VSS gf180mcu_as_sc_mcu7t3v3__fillcap_4
X_4969_ VDD VDD VSS VSS _4983_/A _4970_/B _4970_/A gf180mcu_as_sc_mcu7t3v3__nor2_2
XFILLER_20_661 VDD VDD VSS VSS gf180mcu_as_sc_mcu7t3v3__fillcap_4
XFILLER_138_34 VDD VDD VSS VSS gf180mcu_as_sc_mcu7t3v3__fill_1
XFILLER_22_45 VDD VDD VSS VSS gf180mcu_as_sc_mcu7t3v3__fillcap_4
XPHY_EDGE_ROW_47_3_Left_752 VDD VSS gf180mcu_as_sc_mcu7t3v3__tap_2
XFILLER_138_45 VDD VDD VSS VSS gf180mcu_as_sc_mcu7t3v3__fillcap_4
XFILLER_153_839 VDD VDD VSS VSS gf180mcu_as_sc_mcu7t3v3__fill_1
XFILLER_98_49 VDD VDD VSS VSS gf180mcu_as_sc_mcu7t3v3__fill_2
XFILLER_195_1170 VDD VDD VSS VSS gf180mcu_as_sc_mcu7t3v3__fillcap_16
XFILLER_195_1192 VDD VDD VSS VSS gf180mcu_as_sc_mcu7t3v3__fillcap_16
XPHY_EDGE_ROW_106_2_Left_547 VDD VSS gf180mcu_as_sc_mcu7t3v3__tap_2
XFILLER_154_22 VDD VDD VSS VSS gf180mcu_as_sc_mcu7t3v3__fillcap_8
Xoutput480 VDD VDD VSS VSS _6481_/Q west_out[32] gf180mcu_as_sc_mcu7t3v3__buff_12
XFILLER_160_382 VDD VDD VSS VSS gf180mcu_as_sc_mcu7t3v3__fill_2
XTAP_TAPCELL_ROW_183_2034 VDD VSS gf180mcu_as_sc_mcu7t3v3__tap_2
XPHY_EDGE_ROW_201_Left_429 VDD VSS gf180mcu_as_sc_mcu7t3v3__tap_2
XFILLER_208_818 VDD VDD VSS VSS gf180mcu_as_sc_mcu7t3v3__fill_2
XPHY_EDGE_ROW_48_3_Right_128 VDD VSS gf180mcu_as_sc_mcu7t3v3__tap_2
XTAP_TAPCELL_ROW_161_1631 VDD VSS gf180mcu_as_sc_mcu7t3v3__tap_2
XTAP_TAPCELL_ROW_161_1642 VDD VSS gf180mcu_as_sc_mcu7t3v3__tap_2
XFILLER_15_422 VDD VDD VSS VSS gf180mcu_as_sc_mcu7t3v3__fill_1
XFILLER_216_884 VDD VDD VSS VSS gf180mcu_as_sc_mcu7t3v3__fill_2
XTAP_TAPCELL_ROW_202_2373 VDD VSS gf180mcu_as_sc_mcu7t3v3__tap_2
XFILLER_128_1245 VDD VDD VSS VSS gf180mcu_as_sc_mcu7t3v3__fillcap_16
XTAP_TAPCELL_ROW_202_2384 VDD VSS gf180mcu_as_sc_mcu7t3v3__tap_2
XFILLER_15_488 VDD VDD VSS VSS gf180mcu_as_sc_mcu7t3v3__fill_2
XFILLER_175_419 VDD VDD VSS VSS gf180mcu_as_sc_mcu7t3v3__fill_1
XPHY_EDGE_ROW_210_Left_438 VDD VSS gf180mcu_as_sc_mcu7t3v3__tap_2
XFILLER_11_683 VDD VDD VSS VSS gf180mcu_as_sc_mcu7t3v3__fillcap_4
XFILLER_196_791 VDD VDD VSS VSS gf180mcu_as_sc_mcu7t3v3__fill_2
XFILLER_8_69 VDD VDD VSS VSS gf180mcu_as_sc_mcu7t3v3__fillcap_16
XTAP_TAPCELL_ROW_78_2_2965 VDD VSS gf180mcu_as_sc_mcu7t3v3__tap_2
XFILLER_10_171 VDD VDD VSS VSS gf180mcu_as_sc_mcu7t3v3__fillcap_4
XFILLER_10_193 VDD VDD VSS VSS gf180mcu_as_sc_mcu7t3v3__fillcap_16
XFILLER_184_975 VDD VDD VSS VSS gf180mcu_as_sc_mcu7t3v3__fillcap_16
XFILLER_183_485 VDD VDD VSS VSS gf180mcu_as_sc_mcu7t3v3__fillcap_4
XPHY_EDGE_ROW_38_2_Left_479 VDD VSS gf180mcu_as_sc_mcu7t3v3__tap_2
XFILLER_174_1221 VDD VDD VSS VSS gf180mcu_as_sc_mcu7t3v3__fillcap_4
XFILLER_174_1243 VDD VDD VSS VSS gf180mcu_as_sc_mcu7t3v3__fillcap_16
XPHY_EDGE_ROW_157_Right_25 VDD VSS gf180mcu_as_sc_mcu7t3v3__tap_2
XFILLER_151_393 VDD VDD VSS VSS gf180mcu_as_sc_mcu7t3v3__fillcap_8
XFILLER_215_1240 VDD VDD VSS VSS gf180mcu_as_sc_mcu7t3v3__fillcap_16
XTAP_TAPCELL_ROW_209_2505 VDD VSS gf180mcu_as_sc_mcu7t3v3__tap_2
XFILLER_215_1262 VDD VDD VSS VSS gf180mcu_as_sc_mcu7t3v3__fill_2
XFILLER_214_69 VDD VDD VSS VSS gf180mcu_as_sc_mcu7t3v3__fillcap_16
XFILLER_168_1014 VDD VDD VSS VSS gf180mcu_as_sc_mcu7t3v3__fill_1
XFILLER_93_664 VDD VDD VSS VSS gf180mcu_as_sc_mcu7t3v3__fill_2
XTAP_TAPCELL_ROW_222_2738 VDD VSS gf180mcu_as_sc_mcu7t3v3__tap_2
XFILLER_0_1226 VDD VDD VSS VSS gf180mcu_as_sc_mcu7t3v3__fillcap_16
X_5941_ VDD VDD VSS VSS _5948_/S _5941_/B _5941_/A _5942_/B gf180mcu_as_sc_mcu7t3v3__mux2_2
XFILLER_206_372 VDD VDD VSS VSS gf180mcu_as_sc_mcu7t3v3__fill_1
XFILLER_207_895 VDD VDD VSS VSS gf180mcu_as_sc_mcu7t3v3__fill_2
XPHY_EDGE_ROW_166_Right_34 VDD VSS gf180mcu_as_sc_mcu7t3v3__tap_2
XFILLER_178_202 VDD VDD VSS VSS gf180mcu_as_sc_mcu7t3v3__fill_2
X_5872_ VDD VDD VSS VSS _5872_/A _5951_/D _5944_/B _5872_/D _5873_/D gf180mcu_as_sc_mcu7t3v3__ao22_2
XFILLER_61_594 VDD VDD VSS VSS gf180mcu_as_sc_mcu7t3v3__fill_2
X_4823_ VDD VDD VSS VSS _5825_/A _4871_/B _4871_/C _5825_/D _4824_/D gf180mcu_as_sc_mcu7t3v3__ao22_2
XTAP_TAPCELL_ROW_179_1969 VDD VSS gf180mcu_as_sc_mcu7t3v3__tap_2
XTAP_TAPCELL_ROW_179_1958 VDD VSS gf180mcu_as_sc_mcu7t3v3__tap_2
X_4754_ VDD VDD VSS VSS _5767_/A _4875_/B _4754_/C _4867_/D _4757_/C gf180mcu_as_sc_mcu7t3v3__ao211_2
XFILLER_193_249 VDD VDD VSS VSS gf180mcu_as_sc_mcu7t3v3__fill_2
X_3705_ VDD VDD VSS VSS _6020_/Q _3830_/B _4024_/D _3830_/D _6020_/D gf180mcu_as_sc_mcu7t3v3__ao22_2
XFILLER_147_666 VDD VDD VSS VSS gf180mcu_as_sc_mcu7t3v3__fill_1
XFILLER_174_452 VDD VDD VSS VSS gf180mcu_as_sc_mcu7t3v3__fill_2
XFILLER_179_1154 VDD VDD VSS VSS gf180mcu_as_sc_mcu7t3v3__fillcap_16
XFILLER_190_923 VDD VDD VSS VSS gf180mcu_as_sc_mcu7t3v3__fillcap_16
XPHY_EDGE_ROW_54_1_Right_626 VDD VSS gf180mcu_as_sc_mcu7t3v3__tap_2
X_4685_ VDD VDD VSS VSS _5703_/A _4796_/B _4685_/C _4685_/D _4686_/B gf180mcu_as_sc_mcu7t3v3__ao211_2
XTAP_TAPCELL_ROW_30_2_2893 VDD VSS gf180mcu_as_sc_mcu7t3v3__tap_2
X_6424_ VDD VDD VSS VSS _6437_/CLK _6424_/D _6424_/Q gf180mcu_as_sc_mcu7t3v3__dfxtp_2
X_3636_ VDD VDD VSS VSS _5936_/D _5629_/A _5307_/A _5943_/D _4651_/A gf180mcu_as_sc_mcu7t3v3__ao22_2
XFILLER_108_37 VDD VDD VSS VSS gf180mcu_as_sc_mcu7t3v3__fillcap_8
XPHY_EDGE_ROW_175_Right_43 VDD VSS gf180mcu_as_sc_mcu7t3v3__tap_2
X_6355_ VDD VDD VSS VSS _6365_/CLK _6355_/D _6355_/Q gf180mcu_as_sc_mcu7t3v3__dfxtp_2
X_3567_ VDD VDD VSS VSS _4619_/C _4272_/A _5302_/A gf180mcu_as_sc_mcu7t3v3__nor2b_2
X_6286_ VDD VDD VSS VSS clkload7/A _6286_/D _6286_/Q gf180mcu_as_sc_mcu7t3v3__dfxtp_2
X_5306_ VDD VDD VSS VSS _5947_/A _5306_/B _5306_/C _5307_/C _5306_/D gf180mcu_as_sc_mcu7t3v3__aoi211_2
XFILLER_9_1240 VDD VDD VSS VSS gf180mcu_as_sc_mcu7t3v3__fillcap_16
XPHY_EDGE_ROW_37_2_Right_874 VDD VSS gf180mcu_as_sc_mcu7t3v3__tap_2
Xinput208 VDD VDD VSS VSS se_in[21] _5850_/A gf180mcu_as_sc_mcu7t3v3__buff_12
X_5237_ VDD VDD VSS VSS _5237_/S _5237_/B _5237_/A _5238_/B gf180mcu_as_sc_mcu7t3v3__mux2_2
X_3498_ VDD VDD VSS VSS _5339_/C _5319_/A _5919_/A gf180mcu_as_sc_mcu7t3v3__nand2b_2
XFILLER_9_1262 VDD VDD VSS VSS gf180mcu_as_sc_mcu7t3v3__fill_2
Xinput219 VDD VDD VSS VSS se_in[31] _5927_/A gf180mcu_as_sc_mcu7t3v3__buff_12
XFILLER_84_29 VDD VDD VSS VSS gf180mcu_as_sc_mcu7t3v3__fillcap_4
X_5168_ VDD VDD VSS VSS _5168_/A _5263_/B _5296_/B _5169_/C _5168_/D gf180mcu_as_sc_mcu7t3v3__aoi211_2
XTAP_TAPCELL_ROW_6_1121 VDD VSS gf180mcu_as_sc_mcu7t3v3__tap_2
XFILLER_151_1084 VDD VDD VSS VSS gf180mcu_as_sc_mcu7t3v3__fillcap_16
XFILLER_186_1103 VDD VDD VSS VSS gf180mcu_as_sc_mcu7t3v3__fillcap_16
X_5099_ VDD VDD VSS VSS _5237_/S _5763_/A _5099_/A _5100_/B gf180mcu_as_sc_mcu7t3v3__mux2_2
X_4119_ VDD VDD VSS VSS _4146_/S _6169_/Q _6168_/Q _6168_/D gf180mcu_as_sc_mcu7t3v3__mux2_2
XFILLER_216_147 VDD VDD VSS VSS gf180mcu_as_sc_mcu7t3v3__fill_1
XPHY_EDGE_ROW_184_Right_52 VDD VSS gf180mcu_as_sc_mcu7t3v3__tap_2
XFILLER_227_1100 VDD VDD VSS VSS gf180mcu_as_sc_mcu7t3v3__fillcap_16
XFILLER_227_1122 VDD VDD VSS VSS gf180mcu_as_sc_mcu7t3v3__fillcap_16
XFILLER_149_22 VDD VDD VSS VSS gf180mcu_as_sc_mcu7t3v3__fillcap_8
XFILLER_165_430 VDD VDD VSS VSS gf180mcu_as_sc_mcu7t3v3__fillcap_8
XFILLER_181_912 VDD VDD VSS VSS gf180mcu_as_sc_mcu7t3v3__fillcap_4
XFILLER_193_761 VDD VDD VSS VSS gf180mcu_as_sc_mcu7t3v3__fill_1
XFILLER_193_772 VDD VDD VSS VSS gf180mcu_as_sc_mcu7t3v3__fillcap_8
XFILLER_197_1232 VDD VDD VSS VSS gf180mcu_as_sc_mcu7t3v3__fill_2
XFILLER_158_1205 VDD VDD VSS VSS gf180mcu_as_sc_mcu7t3v3__fillcap_16
XPHY_EDGE_ROW_193_Right_61 VDD VSS gf180mcu_as_sc_mcu7t3v3__tap_2
XFILLER_181_978 VDD VDD VSS VSS gf180mcu_as_sc_mcu7t3v3__fill_2
XFILLER_3_134 VDD VDD VSS VSS gf180mcu_as_sc_mcu7t3v3__fillcap_4
XPHY_EDGE_ROW_148_1_Left_376 VDD VSS gf180mcu_as_sc_mcu7t3v3__tap_2
XFILLER_161_680 VDD VDD VSS VSS gf180mcu_as_sc_mcu7t3v3__fillcap_16
XFILLER_165_65 VDD VDD VSS VSS gf180mcu_as_sc_mcu7t3v3__fillcap_4
XFILLER_3_178 VDD VDD VSS VSS gf180mcu_as_sc_mcu7t3v3__fill_2
XFILLER_0_852 VDD VDD VSS VSS gf180mcu_as_sc_mcu7t3v3__fillcap_4
XPHY_EDGE_ROW_85_1_Left_313 VDD VSS gf180mcu_as_sc_mcu7t3v3__tap_2
XFILLER_207_125 VDD VDD VSS VSS gf180mcu_as_sc_mcu7t3v3__fill_2
XFILLER_75_664 VDD VDD VSS VSS gf180mcu_as_sc_mcu7t3v3__fill_2
XPHY_EDGE_ROW_49_3_Right_129 VDD VSS gf180mcu_as_sc_mcu7t3v3__tap_2
XTAP_TAPCELL_ROW_204_2413 VDD VSS gf180mcu_as_sc_mcu7t3v3__tap_2
XFILLER_16_731 VDD VDD VSS VSS gf180mcu_as_sc_mcu7t3v3__fillcap_16
XFILLER_203_364 VDD VDD VSS VSS gf180mcu_as_sc_mcu7t3v3__fillcap_4
XFILLER_206_1239 VDD VDD VSS VSS gf180mcu_as_sc_mcu7t3v3__fill_1
XFILLER_43_594 VDD VDD VSS VSS gf180mcu_as_sc_mcu7t3v3__fill_1
XTAP_TAPCELL_ROW_196_2269 VDD VSS gf180mcu_as_sc_mcu7t3v3__tap_2
XFILLER_54_1261 VDD VDD VSS VSS gf180mcu_as_sc_mcu7t3v3__fillcap_4
XFILLER_156_430 VDD VDD VSS VSS gf180mcu_as_sc_mcu7t3v3__fillcap_16
XFILLER_15_1234 VDD VDD VSS VSS gf180mcu_as_sc_mcu7t3v3__fill_1
XFILLER_8_941 VDD VDD VSS VSS gf180mcu_as_sc_mcu7t3v3__fillcap_4
XFILLER_129_666 VDD VDD VSS VSS gf180mcu_as_sc_mcu7t3v3__fill_1
XFILLER_8_963 VDD VDD VSS VSS gf180mcu_as_sc_mcu7t3v3__fillcap_16
XTAP_TAPCELL_ROW_174_1866 VDD VSS gf180mcu_as_sc_mcu7t3v3__tap_2
XTAP_TAPCELL_ROW_174_1877 VDD VSS gf180mcu_as_sc_mcu7t3v3__tap_2
XFILLER_171_422 VDD VDD VSS VSS gf180mcu_as_sc_mcu7t3v3__fillcap_8
XFILLER_183_271 VDD VDD VSS VSS gf180mcu_as_sc_mcu7t3v3__fillcap_8
XFILLER_209_69 VDD VDD VSS VSS gf180mcu_as_sc_mcu7t3v3__fill_1
X_4470_ VDD VDD VSS VSS _4477_/B _4470_/B _6274_/Q _6274_/D gf180mcu_as_sc_mcu7t3v3__mux2_2
XFILLER_183_293 VDD VDD VSS VSS gf180mcu_as_sc_mcu7t3v3__fillcap_8
X_3421_ VDD VDD VSS VSS _4553_/B _3421_/B _6305_/Q gf180mcu_as_sc_mcu7t3v3__nor2b_2
XFILLER_171_488 VDD VDD VSS VSS gf180mcu_as_sc_mcu7t3v3__fill_2
X_6140_ VDD VDD VSS VSS clkload7/A _6140_/D _6140_/Q gf180mcu_as_sc_mcu7t3v3__dfxtp_2
X_3352_ VDD VDD VSS VSS _6201_/Q _4072_/B _4093_/S _6225_/Q _3353_/B gf180mcu_as_sc_mcu7t3v3__ao22_2
XFILLER_152_680 VDD VDD VSS VSS gf180mcu_as_sc_mcu7t3v3__fill_1
XFILLER_31_2 VDD VDD VSS VSS gf180mcu_as_sc_mcu7t3v3__fillcap_16
Xfanout909 VDD VDD VSS VSS _6133_/Q _4394_/A gf180mcu_as_sc_mcu7t3v3__buff_12
XFILLER_151_190 VDD VDD VSS VSS gf180mcu_as_sc_mcu7t3v3__fillcap_16
XFILLER_61_1210 VDD VDD VSS VSS gf180mcu_as_sc_mcu7t3v3__fill_2
X_6071_ VDD VDD VSS VSS _6486_/CLK _6071_/D _6071_/Q gf180mcu_as_sc_mcu7t3v3__dfxtp_2
X_3283_ VDD VDD VSS VSS _3284_/C _3283_/B _3360_/A gf180mcu_as_sc_mcu7t3v3__nor2_2
X_5022_ VDD VDD VSS VSS _6495_/Q _5086_/B _5022_/C _5022_/D _5024_/C gf180mcu_as_sc_mcu7t3v3__ao22_2
XFILLER_0_1001 VDD VDD VSS VSS gf180mcu_as_sc_mcu7t3v3__fillcap_4
XFILLER_226_467 VDD VDD VSS VSS gf180mcu_as_sc_mcu7t3v3__fillcap_4
XFILLER_0_70 VDD VDD VSS VSS gf180mcu_as_sc_mcu7t3v3__fillcap_4
XFILLER_81_656 VDD VDD VSS VSS gf180mcu_as_sc_mcu7t3v3__fillcap_4
XFILLER_0_1056 VDD VDD VSS VSS gf180mcu_as_sc_mcu7t3v3__fillcap_4
X_5924_ VDD VDD VSS VSS _5925_/C _5924_/C _5953_/B _5924_/A gf180mcu_as_sc_mcu7t3v3__aoi21_2
XTAP_TAPCELL_ROW_1_1040 VDD VSS gf180mcu_as_sc_mcu7t3v3__tap_2
XFILLER_110_27 VDD VDD VSS VSS gf180mcu_as_sc_mcu7t3v3__fillcap_8
XFILLER_110_49 VDD VDD VSS VSS gf180mcu_as_sc_mcu7t3v3__fill_2
XFILLER_34_594 VDD VDD VSS VSS gf180mcu_as_sc_mcu7t3v3__fillcap_8
X_5855_ VDD VDD VSS VSS _5855_/A _5931_/B _5855_/C _5855_/D _5856_/D gf180mcu_as_sc_mcu7t3v3__ao22_2
X_4806_ VDD VDD VSS VSS _4807_/B _5810_/A _4872_/B _4806_/C gf180mcu_as_sc_mcu7t3v3__ao21_2
X_5786_ VDD VDD VSS VSS _5787_/C _5786_/A _5842_/B _5841_/B _5786_/D gf180mcu_as_sc_mcu7t3v3__aoi22_2
XFILLER_175_772 VDD VDD VSS VSS gf180mcu_as_sc_mcu7t3v3__fill_1
XFILLER_181_208 VDD VDD VSS VSS gf180mcu_as_sc_mcu7t3v3__fill_2
X_4737_ VDD VDD VSS VSS _4878_/B _4896_/A _4960_/C gf180mcu_as_sc_mcu7t3v3__and2_2
XFILLER_162_422 VDD VDD VSS VSS gf180mcu_as_sc_mcu7t3v3__fill_1
X_4668_ VDD VDD VSS VSS _5686_/A _4796_/B _4668_/C _4725_/B _4669_/C gf180mcu_as_sc_mcu7t3v3__ao211_2
XFILLER_135_647 VDD VDD VSS VSS gf180mcu_as_sc_mcu7t3v3__fillcap_8
XFILLER_79_29 VDD VDD VSS VSS gf180mcu_as_sc_mcu7t3v3__fillcap_16
XPHY_EDGE_ROW_55_1_Right_627 VDD VSS gf180mcu_as_sc_mcu7t3v3__tap_2
X_6407_ VDD VDD VSS VSS _6412_/CLK _6407_/D _6407_/Q gf180mcu_as_sc_mcu7t3v3__dfxtp_2
X_3619_ VDD VDD VSS VSS _5353_/C _5927_/A _5340_/A gf180mcu_as_sc_mcu7t3v3__nor2b_2
X_4599_ VDD VDD VSS VSS _4601_/C _4599_/A _4603_/B gf180mcu_as_sc_mcu7t3v3__or2_2
XFILLER_0_104 VDD VDD VSS VSS gf180mcu_as_sc_mcu7t3v3__fillcap_4
XFILLER_192_1151 VDD VDD VSS VSS gf180mcu_as_sc_mcu7t3v3__fillcap_4
XFILLER_192_1173 VDD VDD VSS VSS gf180mcu_as_sc_mcu7t3v3__fillcap_16
X_6338_ VDD VDD VSS VSS _6531_/CLK _6338_/D _6338_/Q gf180mcu_as_sc_mcu7t3v3__dfxtp_2
XFILLER_49_609 VDD VDD VSS VSS gf180mcu_as_sc_mcu7t3v3__fill_2
XPHY_EDGE_ROW_38_2_Right_875 VDD VSS gf180mcu_as_sc_mcu7t3v3__tap_2
X_6269_ VDD VDD VSS VSS _6551_/CLK _6269_/D _6269_/Q gf180mcu_as_sc_mcu7t3v3__dfxtp_2
XFILLER_218_913 VDD VDD VSS VSS gf180mcu_as_sc_mcu7t3v3__fillcap_16
XFILLER_57_664 VDD VDD VSS VSS gf180mcu_as_sc_mcu7t3v3__fill_2
XTAP_TAPCELL_ROW_131_2_3045 VDD VSS gf180mcu_as_sc_mcu7t3v3__tap_2
XFILLER_218_979 VDD VDD VSS VSS gf180mcu_as_sc_mcu7t3v3__fillcap_16
XFILLER_217_478 VDD VDD VSS VSS gf180mcu_as_sc_mcu7t3v3__fill_1
XFILLER_13_734 VDD VDD VSS VSS gf180mcu_as_sc_mcu7t3v3__fillcap_16
XFILLER_25_594 VDD VDD VSS VSS gf180mcu_as_sc_mcu7t3v3__fillcap_16
XFILLER_38_1245 VDD VDD VSS VSS gf180mcu_as_sc_mcu7t3v3__fillcap_16
XFILLER_125_1226 VDD VDD VSS VSS gf180mcu_as_sc_mcu7t3v3__fillcap_8
XFILLER_164_1264 VDD VDD VSS VSS gf180mcu_as_sc_mcu7t3v3__fill_1
XFILLER_197_352 VDD VDD VSS VSS gf180mcu_as_sc_mcu7t3v3__fill_2
Xsram2048.u_bank0_1032 VDD VDD VSS VSS sram2048.u_bank0/WEN[6] gf180mcu_as_sc_mcu7t3v3__tiel_4
XTAP_TAPCELL_ROW_156_1541 VDD VSS gf180mcu_as_sc_mcu7t3v3__tap_2
XTAP_TAPCELL_ROW_156_1552 VDD VSS gf180mcu_as_sc_mcu7t3v3__tap_2
XTAP_TAPCELL_ROW_191_2177 VDD VSS gf180mcu_as_sc_mcu7t3v3__tap_2
XFILLER_153_422 VDD VDD VSS VSS gf180mcu_as_sc_mcu7t3v3__fill_2
XFILLER_176_53 VDD VDD VSS VSS gf180mcu_as_sc_mcu7t3v3__fillcap_16
XTAP_TAPCELL_ROW_191_2188 VDD VSS gf180mcu_as_sc_mcu7t3v3__tap_2
XFILLER_180_230 VDD VDD VSS VSS gf180mcu_as_sc_mcu7t3v3__fill_2
XFILLER_197_1084 VDD VDD VSS VSS gf180mcu_as_sc_mcu7t3v3__fillcap_16
XFILLER_5_944 VDD VDD VSS VSS gf180mcu_as_sc_mcu7t3v3__fillcap_16
XFILLER_5_59 VDD VDD VSS VSS gf180mcu_as_sc_mcu7t3v3__fillcap_8
XFILLER_84_1210 VDD VDD VSS VSS gf180mcu_as_sc_mcu7t3v3__fill_1
XFILLER_171_1224 VDD VDD VSS VSS gf180mcu_as_sc_mcu7t3v3__fillcap_16
XFILLER_4_498 VDD VDD VSS VSS gf180mcu_as_sc_mcu7t3v3__fill_2
XFILLER_192_85 VDD VDD VSS VSS gf180mcu_as_sc_mcu7t3v3__fillcap_16
XFILLER_0_682 VDD VDD VSS VSS gf180mcu_as_sc_mcu7t3v3__fillcap_4
XFILLER_212_1221 VDD VDD VSS VSS gf180mcu_as_sc_mcu7t3v3__fillcap_4
XFILLER_212_1243 VDD VDD VSS VSS gf180mcu_as_sc_mcu7t3v3__fillcap_16
XPHY_EDGE_ROW_13_Right_13 VDD VSS gf180mcu_as_sc_mcu7t3v3__tap_2
XTAP_TAPCELL_ROW_15_1283 VDD VSS gf180mcu_as_sc_mcu7t3v3__tap_2
XFILLER_209_979 VDD VDD VSS VSS gf180mcu_as_sc_mcu7t3v3__fill_1
XTAP_TAPCELL_ROW_198_2309 VDD VSS gf180mcu_as_sc_mcu7t3v3__tap_2
XFILLER_224_927 VDD VDD VSS VSS gf180mcu_as_sc_mcu7t3v3__fillcap_16
XFILLER_169_1186 VDD VDD VSS VSS gf180mcu_as_sc_mcu7t3v3__fillcap_4
XFILLER_16_550 VDD VDD VSS VSS gf180mcu_as_sc_mcu7t3v3__fill_1
X_3970_ VDD VDD VSS VSS _3970_/D _4051_/A _4051_/B _3974_/D _6066_/D gf180mcu_as_sc_mcu7t3v3__ao31_2
XTAP_TAPCELL_ROW_66_2_2947 VDD VSS gf180mcu_as_sc_mcu7t3v3__tap_2
XFILLER_189_842 VDD VDD VSS VSS gf180mcu_as_sc_mcu7t3v3__fill_2
XFILLER_203_161 VDD VDD VSS VSS gf180mcu_as_sc_mcu7t3v3__fillcap_4
XFILLER_204_684 VDD VDD VSS VSS gf180mcu_as_sc_mcu7t3v3__fill_1
XPHY_EDGE_ROW_161_Left_389 VDD VSS gf180mcu_as_sc_mcu7t3v3__tap_2
XTAP_TAPCELL_ROW_176_1906 VDD VSS gf180mcu_as_sc_mcu7t3v3__tap_2
XTAP_TAPCELL_ROW_176_1917 VDD VSS gf180mcu_as_sc_mcu7t3v3__tap_2
X_5640_ VDD VDD VSS VSS _5953_/D _5640_/B _5640_/C _5953_/A _5641_/D gf180mcu_as_sc_mcu7t3v3__ao22_2
X_5571_ VDD VDD VSS VSS _6518_/Q _5571_/B _5571_/C _5879_/A _5572_/C gf180mcu_as_sc_mcu7t3v3__ao22_2
XTAP_TAPCELL_ROW_217_2648 VDD VSS gf180mcu_as_sc_mcu7t3v3__tap_2
XFILLER_157_772 VDD VDD VSS VSS gf180mcu_as_sc_mcu7t3v3__fillcap_16
XFILLER_172_731 VDD VDD VSS VSS gf180mcu_as_sc_mcu7t3v3__fillcap_4
X_4522_ VDD VDD VSS VSS _4525_/D _4525_/A _6288_/Q gf180mcu_as_sc_mcu7t3v3__nor2b_2
XFILLER_176_1135 VDD VDD VSS VSS gf180mcu_as_sc_mcu7t3v3__fillcap_16
X_4453_ VDD VDD VSS VSS _4551_/B _6160_/Q _4569_/D _6263_/D gf180mcu_as_sc_mcu7t3v3__mux2_2
XFILLER_172_775 VDD VDD VSS VSS gf180mcu_as_sc_mcu7t3v3__fill_1
XFILLER_176_1157 VDD VDD VSS VSS gf180mcu_as_sc_mcu7t3v3__fillcap_16
X_3404_ VDD VDD VSS VSS _3404_/B _3404_/A _3413_/A gf180mcu_as_sc_mcu7t3v3__and2_2
XFILLER_160_959 VDD VDD VSS VSS gf180mcu_as_sc_mcu7t3v3__fill_1
XPHY_EDGE_ROW_170_Left_398 VDD VSS gf180mcu_as_sc_mcu7t3v3__tap_2
Xfanout706 VDD VDD VSS VSS _3241_/S _3281_/D gf180mcu_as_sc_mcu7t3v3__buff_12
X_4384_ VDD VDD VSS VSS _4398_/S _6065_/Q _6094_/Q _4387_/B gf180mcu_as_sc_mcu7t3v3__mux2_2
XFILLER_140_661 VDD VDD VSS VSS gf180mcu_as_sc_mcu7t3v3__fillcap_4
XFILLER_217_1154 VDD VDD VSS VSS gf180mcu_as_sc_mcu7t3v3__fillcap_16
Xfanout717 VDD VDD VSS VSS _5853_/B _5944_/B gf180mcu_as_sc_mcu7t3v3__buff_12
Xfanout728 VDD VDD VSS VSS _5632_/B _5573_/S gf180mcu_as_sc_mcu7t3v3__buff_12
Xfanout739 VDD VDD VSS VSS _5549_/B _5616_/B gf180mcu_as_sc_mcu7t3v3__buff_12
X_6123_ VDD VDD VSS VSS _6520_/CLK _6123_/D _6123_/Q gf180mcu_as_sc_mcu7t3v3__dfxtp_2
X_3335_ VDD VDD VSS VSS _3335_/B _3343_/A _3338_/C gf180mcu_as_sc_mcu7t3v3__or2_2
XFILLER_105_27 VDD VDD VSS VSS gf180mcu_as_sc_mcu7t3v3__fillcap_16
XFILLER_6_1221 VDD VDD VSS VSS gf180mcu_as_sc_mcu7t3v3__fillcap_4
X_6054_ VDD VDD VSS VSS _6371_/CLK _6054_/D _6054_/Q gf180mcu_as_sc_mcu7t3v3__dfxtp_2
X_3266_ VDD VDD VSS VSS _3268_/C _3266_/B _4072_/A gf180mcu_as_sc_mcu7t3v3__nand2_2
XFILLER_6_1243 VDD VDD VSS VSS gf180mcu_as_sc_mcu7t3v3__fillcap_16
X_5005_ VDD VDD VSS VSS _5005_/B _5005_/A _5189_/B gf180mcu_as_sc_mcu7t3v3__and2_2
XFILLER_215_905 VDD VDD VSS VSS gf180mcu_as_sc_mcu7t3v3__fillcap_4
XFILLER_226_242 VDD VDD VSS VSS gf180mcu_as_sc_mcu7t3v3__fill_2
XFILLER_39_664 VDD VDD VSS VSS gf180mcu_as_sc_mcu7t3v3__fill_2
XPHY_EDGE_ROW_56_3_Left_761 VDD VSS gf180mcu_as_sc_mcu7t3v3__tap_2
X_3197_ VDD VDD VSS VSS _6528_/D _3213_/B _3197_/A _3197_/Y gf180mcu_as_sc_mcu7t3v3__mux2_2
XFILLER_187_1264 VDD VDD VSS VSS gf180mcu_as_sc_mcu7t3v3__fill_1
XFILLER_54_623 VDD VDD VSS VSS gf180mcu_as_sc_mcu7t3v3__fillcap_4
XFILLER_224_1103 VDD VDD VSS VSS gf180mcu_as_sc_mcu7t3v3__fillcap_16
XPHY_EDGE_ROW_115_2_Left_556 VDD VSS gf180mcu_as_sc_mcu7t3v3__tap_2
X_5907_ VDD VDD VSS VSS _5907_/A _5953_/B _5907_/C _5907_/D _5908_/C gf180mcu_as_sc_mcu7t3v3__ao211_2
XFILLER_179_352 VDD VDD VSS VSS gf180mcu_as_sc_mcu7t3v3__fill_1
XFILLER_223_982 VDD VDD VSS VSS gf180mcu_as_sc_mcu7t3v3__fillcap_16
X_5838_ VDD VDD VSS VSS _5838_/S _5838_/B _6513_/Q _5839_/C gf180mcu_as_sc_mcu7t3v3__mux2_2
XFILLER_182_506 VDD VDD VSS VSS gf180mcu_as_sc_mcu7t3v3__fillcap_16
X_5769_ VDD VDD VSS VSS _5769_/A _5869_/B _5769_/C _5769_/D _5770_/B gf180mcu_as_sc_mcu7t3v3__ao211_2
XFILLER_108_614 VDD VDD VSS VSS gf180mcu_as_sc_mcu7t3v3__fill_2
XFILLER_194_399 VDD VDD VSS VSS gf180mcu_as_sc_mcu7t3v3__fill_1
XFILLER_30_45 VDD VDD VSS VSS gf180mcu_as_sc_mcu7t3v3__fillcap_4
XFILLER_146_34 VDD VDD VSS VSS gf180mcu_as_sc_mcu7t3v3__fill_1
XFILLER_146_45 VDD VDD VSS VSS gf180mcu_as_sc_mcu7t3v3__fillcap_4
XFILLER_155_1208 VDD VDD VSS VSS gf180mcu_as_sc_mcu7t3v3__fillcap_16
XFILLER_162_241 VDD VDD VSS VSS gf180mcu_as_sc_mcu7t3v3__fillcap_4
XFILLER_162_263 VDD VDD VSS VSS gf180mcu_as_sc_mcu7t3v3__fillcap_16
XFILLER_190_550 VDD VDD VSS VSS gf180mcu_as_sc_mcu7t3v3__fillcap_16
XFILLER_194_1235 VDD VDD VSS VSS gf180mcu_as_sc_mcu7t3v3__fillcap_4
XPHY_EDGE_ROW_56_1_Right_628 VDD VSS gf180mcu_as_sc_mcu7t3v3__tap_2
XFILLER_190_594 VDD VDD VSS VSS gf180mcu_as_sc_mcu7t3v3__fill_1
XFILLER_2_947 VDD VDD VSS VSS gf180mcu_as_sc_mcu7t3v3__fillcap_16
XPHY_EDGE_ROW_100_3_Right_180 VDD VSS gf180mcu_as_sc_mcu7t3v3__tap_2
XTAP_TAPCELL_ROW_151_1460 VDD VSS gf180mcu_as_sc_mcu7t3v3__tap_2
XFILLER_39_43 VDD VDD VSS VSS gf180mcu_as_sc_mcu7t3v3__fillcap_8
XFILLER_188_1017 VDD VDD VSS VSS gf180mcu_as_sc_mcu7t3v3__fillcap_16
XPHY_EDGE_ROW_39_2_Right_876 VDD VSS gf180mcu_as_sc_mcu7t3v3__tap_2
Xmesh_tile_1116 VDD VDD VSS VSS se_out[3] gf180mcu_as_sc_mcu7t3v3__tiel_4
Xmesh_tile_1105 VDD VDD VSS VSS nw_out[28] gf180mcu_as_sc_mcu7t3v3__tiel_4
XFILLER_45_612 VDD VDD VSS VSS gf180mcu_as_sc_mcu7t3v3__fill_1
Xmesh_tile_1149 VDD VDD VSS VSS sw_out[0] gf180mcu_as_sc_mcu7t3v3__tiel_4
Xmesh_tile_1138 VDD VDD VSS VSS se_out[25] gf180mcu_as_sc_mcu7t3v3__tiel_4
Xmesh_tile_1127 VDD VDD VSS VSS se_out[14] gf180mcu_as_sc_mcu7t3v3__tiel_4
XFILLER_189_116 VDD VDD VSS VSS gf180mcu_as_sc_mcu7t3v3__fillcap_8
XFILLER_205_426 VDD VDD VSS VSS gf180mcu_as_sc_mcu7t3v3__fill_2
XPHY_EDGE_ROW_47_2_Left_488 VDD VSS gf180mcu_as_sc_mcu7t3v3__tap_2
XTAP_TAPCELL_ROW_10_1191 VDD VSS gf180mcu_as_sc_mcu7t3v3__tap_2
XFILLER_198_661 VDD VDD VSS VSS gf180mcu_as_sc_mcu7t3v3__fillcap_4
XTAP_TAPCELL_ROW_193_2217 VDD VSS gf180mcu_as_sc_mcu7t3v3__tap_2
XFILLER_185_300 VDD VDD VSS VSS gf180mcu_as_sc_mcu7t3v3__fillcap_4
XFILLER_185_333 VDD VDD VSS VSS gf180mcu_as_sc_mcu7t3v3__fill_1
XFILLER_201_632 VDD VDD VSS VSS gf180mcu_as_sc_mcu7t3v3__fillcap_4
XFILLER_213_492 VDD VDD VSS VSS gf180mcu_as_sc_mcu7t3v3__fillcap_4
XFILLER_187_63 VDD VDD VSS VSS gf180mcu_as_sc_mcu7t3v3__fillcap_4
XFILLER_200_164 VDD VDD VSS VSS gf180mcu_as_sc_mcu7t3v3__fillcap_4
XFILLER_173_517 VDD VDD VSS VSS gf180mcu_as_sc_mcu7t3v3__fillcap_4
XFILLER_185_399 VDD VDD VSS VSS gf180mcu_as_sc_mcu7t3v3__fillcap_8
XTAP_TAPCELL_ROW_171_1814 VDD VSS gf180mcu_as_sc_mcu7t3v3__tap_2
XTAP_TAPCELL_ROW_171_1825 VDD VSS gf180mcu_as_sc_mcu7t3v3__tap_2
XFILLER_12_1259 VDD VDD VSS VSS gf180mcu_as_sc_mcu7t3v3__fillcap_4
XFILLER_154_753 VDD VDD VSS VSS gf180mcu_as_sc_mcu7t3v3__fillcap_4
XFILLER_166_591 VDD VDD VSS VSS gf180mcu_as_sc_mcu7t3v3__fillcap_4
XTAP_TAPCELL_ROW_126_1_1384 VDD VSS gf180mcu_as_sc_mcu7t3v3__tap_2
XFILLER_4_251 VDD VDD VSS VSS gf180mcu_as_sc_mcu7t3v3__fill_2
XTAP_TAPCELL_ROW_212_2556 VDD VSS gf180mcu_as_sc_mcu7t3v3__tap_2
XFILLER_206_37 VDD VDD VSS VSS gf180mcu_as_sc_mcu7t3v3__fillcap_16
XTAP_TAPCELL_ROW_169_1776 VDD VSS gf180mcu_as_sc_mcu7t3v3__tap_2
X_3120_ VDD VDD VSS VSS _4528_/C _4509_/B _4569_/D gf180mcu_as_sc_mcu7t3v3__nand2_2
XTAP_TAPCELL_ROW_169_1787 VDD VSS gf180mcu_as_sc_mcu7t3v3__tap_2
XFILLER_36_612 VDD VDD VSS VSS gf180mcu_as_sc_mcu7t3v3__fillcap_4
X_3051_ VDD VDD VSS VSS _4524_/A _6260_/Q gf180mcu_as_sc_mcu7t3v3__inv_2
XFILLER_205_960 VDD VDD VSS VSS gf180mcu_as_sc_mcu7t3v3__fillcap_16
XFILLER_212_919 VDD VDD VSS VSS gf180mcu_as_sc_mcu7t3v3__fillcap_16
XFILLER_51_637 VDD VDD VSS VSS gf180mcu_as_sc_mcu7t3v3__fill_1
XPHY_EDGE_ROW_100_1_Left_328 VDD VSS gf180mcu_as_sc_mcu7t3v3__tap_2
XFILLER_108_1210 VDD VDD VSS VSS gf180mcu_as_sc_mcu7t3v3__fillcap_8
XFILLER_204_481 VDD VDD VSS VSS gf180mcu_as_sc_mcu7t3v3__fill_2
XFILLER_205_982 VDD VDD VSS VSS gf180mcu_as_sc_mcu7t3v3__fillcap_16
X_3953_ VDD VDD VSS VSS _4034_/B _3962_/C _3963_/B _6056_/Q _6056_/D gf180mcu_as_sc_mcu7t3v3__ao22_2
XFILLER_177_834 VDD VDD VSS VSS gf180mcu_as_sc_mcu7t3v3__fillcap_4
XFILLER_188_160 VDD VDD VSS VSS gf180mcu_as_sc_mcu7t3v3__fillcap_8
XFILLER_220_963 VDD VDD VSS VSS gf180mcu_as_sc_mcu7t3v3__fillcap_16
X_3884_ VDD VDD VSS VSS _5867_/A _3912_/B _3884_/C _3884_/D _4009_/A gf180mcu_as_sc_mcu7t3v3__ao22_2
X_5623_ VDD VDD VSS VSS _6522_/Q _5638_/B _5638_/C _5936_/D _5624_/C gf180mcu_as_sc_mcu7t3v3__ao22_2
X_5554_ VDD VDD VSS VSS _5554_/B _5562_/A _6435_/D gf180mcu_as_sc_mcu7t3v3__and2_2
X_5485_ VDD VDD VSS VSS _5793_/D _5494_/B _5492_/B _5792_/A _5486_/C gf180mcu_as_sc_mcu7t3v3__ao22_2
X_4505_ VDD VDD VSS VSS _4538_/S _4610_/C _4511_/D gf180mcu_as_sc_mcu7t3v3__and2_2
XFILLER_160_734 VDD VDD VSS VSS gf180mcu_as_sc_mcu7t3v3__fill_1
X_4436_ VDD VDD VSS VSS _6252_/Q _4442_/B _4442_/C _6251_/Q _6251_/D gf180mcu_as_sc_mcu7t3v3__ao22_2
XTAP_TAPCELL_ROW_76_1_1359 VDD VSS gf180mcu_as_sc_mcu7t3v3__tap_2
XFILLER_116_37 VDD VDD VSS VSS gf180mcu_as_sc_mcu7t3v3__fillcap_8
Xfanout503 VDD VDD VSS VSS fanout505/Y _3904_/D gf180mcu_as_sc_mcu7t3v3__buff_12
X_4367_ VDD VDD VSS VSS _6220_/D _4367_/B _4367_/A gf180mcu_as_sc_mcu7t3v3__nand2_2
XFILLER_113_661 VDD VDD VSS VSS gf180mcu_as_sc_mcu7t3v3__fill_1
Xfanout525 VDD VDD VSS VSS _3936_/Y _3974_/B gf180mcu_as_sc_mcu7t3v3__buff_12
Xfanout536 VDD VDD VSS VSS _5666_/Y _5955_/S gf180mcu_as_sc_mcu7t3v3__buff_12
Xfanout547 VDD VDD VSS VSS _5267_/S _5228_/S gf180mcu_as_sc_mcu7t3v3__buff_12
X_6106_ VDD VDD VSS VSS _6371_/CLK _6106_/D _6106_/Q gf180mcu_as_sc_mcu7t3v3__dfxtp_2
X_3318_ VDD VDD VSS VSS _3326_/S _6535_/Q _6544_/Q _3319_/B gf180mcu_as_sc_mcu7t3v3__mux2_2
Xfanout569 VDD VDD VSS VSS _3912_/B _3865_/B gf180mcu_as_sc_mcu7t3v3__buff_12
X_4298_ VDD VDD VSS VSS _4299_/C _4370_/S _6024_/Q gf180mcu_as_sc_mcu7t3v3__nor2b_2
X_6037_ VDD VDD VSS VSS _6525_/CLK _6037_/D _6037_/Q gf180mcu_as_sc_mcu7t3v3__dfxtp_2
X_3249_ VDD VDD VSS VSS _3249_/B _4462_/B _3254_/A gf180mcu_as_sc_mcu7t3v3__or2_2
XFILLER_215_702 VDD VDD VSS VSS gf180mcu_as_sc_mcu7t3v3__fill_2
XFILLER_227_562 VDD VDD VSS VSS gf180mcu_as_sc_mcu7t3v3__fillcap_4
XFILLER_27_623 VDD VDD VSS VSS gf180mcu_as_sc_mcu7t3v3__fillcap_8
XFILLER_215_757 VDD VDD VSS VSS gf180mcu_as_sc_mcu7t3v3__fill_2
XFILLER_92_29 VDD VDD VSS VSS gf180mcu_as_sc_mcu7t3v3__fillcap_4
XFILLER_14_317 VDD VDD VSS VSS gf180mcu_as_sc_mcu7t3v3__fillcap_16
XFILLER_42_626 VDD VDD VSS VSS gf180mcu_as_sc_mcu7t3v3__fill_1
XFILLER_155_6 VDD VDD VSS VSS gf180mcu_as_sc_mcu7t3v3__fillcap_8
XFILLER_187_609 VDD VDD VSS VSS gf180mcu_as_sc_mcu7t3v3__fillcap_4
XFILLER_74_1242 VDD VDD VSS VSS gf180mcu_as_sc_mcu7t3v3__fill_1
XFILLER_10_512 VDD VDD VSS VSS gf180mcu_as_sc_mcu7t3v3__fill_2
XFILLER_122_1218 VDD VDD VSS VSS gf180mcu_as_sc_mcu7t3v3__fillcap_4
XPHY_EDGE_ROW_94_1_Left_322 VDD VSS gf180mcu_as_sc_mcu7t3v3__tap_2
XFILLER_155_539 VDD VDD VSS VSS gf180mcu_as_sc_mcu7t3v3__fill_2
XFILLER_157_22 VDD VDD VSS VSS gf180mcu_as_sc_mcu7t3v3__fillcap_16
XTAP_TAPCELL_ROW_153_1500 VDD VSS gf180mcu_as_sc_mcu7t3v3__tap_2
Xwire948 VDD VDD VSS VSS wire948/A _5725_/A gf180mcu_as_sc_mcu7t3v3__clkbuff_12
Xwire959 VDD VDD VSS VSS wire959/A _5807_/A gf180mcu_as_sc_mcu7t3v3__clkbuff_12
XFILLER_157_88 VDD VDD VSS VSS gf180mcu_as_sc_mcu7t3v3__fillcap_16
XFILLER_151_745 VDD VDD VSS VSS gf180mcu_as_sc_mcu7t3v3__fillcap_16
XFILLER_194_1065 VDD VDD VSS VSS gf180mcu_as_sc_mcu7t3v3__fillcap_16
XFILLER_194_1087 VDD VDD VSS VSS gf180mcu_as_sc_mcu7t3v3__fillcap_16
XPHY_EDGE_ROW_101_3_Right_181 VDD VSS gf180mcu_as_sc_mcu7t3v3__tap_2
XPHY_EDGE_ROW_57_1_Right_629 VDD VSS gf180mcu_as_sc_mcu7t3v3__tap_2
XFILLER_173_54 VDD VDD VSS VSS gf180mcu_as_sc_mcu7t3v3__fillcap_16
XTAP_TAPCELL_ROW_186_2087 VDD VSS gf180mcu_as_sc_mcu7t3v3__tap_2
XFILLER_1_298 VDD VDD VSS VSS gf180mcu_as_sc_mcu7t3v3__fill_2
XFILLER_2_27 VDD VDD VSS VSS gf180mcu_as_sc_mcu7t3v3__fillcap_8
XTAP_TAPCELL_ROW_186_2098 VDD VSS gf180mcu_as_sc_mcu7t3v3__tap_2
XTAP_TAPCELL_ROW_12_1231 VDD VSS gf180mcu_as_sc_mcu7t3v3__tap_2
XFILLER_18_645 VDD VDD VSS VSS gf180mcu_as_sc_mcu7t3v3__fill_2
XFILLER_205_212 VDD VDD VSS VSS gf180mcu_as_sc_mcu7t3v3__fill_1
XTAP_TAPCELL_ROW_164_1695 VDD VSS gf180mcu_as_sc_mcu7t3v3__tap_2
XFILLER_205_234 VDD VDD VSS VSS gf180mcu_as_sc_mcu7t3v3__fillcap_4
XFILLER_166_1189 VDD VDD VSS VSS gf180mcu_as_sc_mcu7t3v3__fillcap_16
XFILLER_177_108 VDD VDD VSS VSS gf180mcu_as_sc_mcu7t3v3__fillcap_16
XFILLER_158_311 VDD VDD VSS VSS gf180mcu_as_sc_mcu7t3v3__fillcap_4
XFILLER_202_963 VDD VDD VSS VSS gf180mcu_as_sc_mcu7t3v3__fillcap_16
XFILLER_158_333 VDD VDD VSS VSS gf180mcu_as_sc_mcu7t3v3__fillcap_4
XFILLER_198_95 VDD VDD VSS VSS gf180mcu_as_sc_mcu7t3v3__fill_1
XFILLER_201_473 VDD VDD VSS VSS gf180mcu_as_sc_mcu7t3v3__fillcap_16
XFILLER_207_1186 VDD VDD VSS VSS gf180mcu_as_sc_mcu7t3v3__fillcap_4
XFILLER_9_332 VDD VDD VSS VSS gf180mcu_as_sc_mcu7t3v3__fillcap_16
XFILLER_185_174 VDD VDD VSS VSS gf180mcu_as_sc_mcu7t3v3__fill_1
XFILLER_16_1192 VDD VDD VSS VSS gf180mcu_as_sc_mcu7t3v3__fillcap_16
XFILLER_154_561 VDD VDD VSS VSS gf180mcu_as_sc_mcu7t3v3__fill_1
XFILLER_173_1116 VDD VDD VSS VSS gf180mcu_as_sc_mcu7t3v3__fillcap_4
X_5270_ VDD VDD VSS VSS _5912_/D _5312_/B _5302_/C _5270_/D _5271_/C gf180mcu_as_sc_mcu7t3v3__ao22_2
XFILLER_173_1138 VDD VDD VSS VSS gf180mcu_as_sc_mcu7t3v3__fillcap_16
X_4221_ VDD VDD VSS VSS _6719_/A _4226_/B _4221_/C _4223_/B _4222_/C gf180mcu_as_sc_mcu7t3v3__ao211_2
XFILLER_214_1135 VDD VDD VSS VSS gf180mcu_as_sc_mcu7t3v3__fillcap_16
XFILLER_214_1157 VDD VDD VSS VSS gf180mcu_as_sc_mcu7t3v3__fillcap_16
X_4152_ VDD VDD VSS VSS _4153_/C _6164_/Q _6309_/Q _4152_/C gf180mcu_as_sc_mcu7t3v3__maj3_2
XTAP_TAPCELL_ROW_54_2_2929 VDD VSS gf180mcu_as_sc_mcu7t3v3__tap_2
X_4083_ VDD VDD VSS VSS _4085_/S _6720_/A _6143_/Q _6143_/D gf180mcu_as_sc_mcu7t3v3__mux2_2
X_3103_ VDD VDD VSS VSS _3433_/B _6264_/Q _3434_/A gf180mcu_as_sc_mcu7t3v3__or2_2
XFILLER_209_562 VDD VDD VSS VSS gf180mcu_as_sc_mcu7t3v3__fillcap_4
XFILLER_3_1224 VDD VDD VSS VSS gf180mcu_as_sc_mcu7t3v3__fillcap_16
X_3034_ VDD VDD VSS VSS _3620_/C _5918_/A gf180mcu_as_sc_mcu7t3v3__inv_2
XFILLER_24_615 VDD VDD VSS VSS gf180mcu_as_sc_mcu7t3v3__fillcap_8
XFILLER_24_637 VDD VDD VSS VSS gf180mcu_as_sc_mcu7t3v3__fillcap_4
X_4985_ VDD VDD VSS VSS _5001_/A _4995_/B _4995_/A gf180mcu_as_sc_mcu7t3v3__nor2b_2
X_3936_ VDD VDD VSS VSS _3936_/Y _3974_/D _5972_/C gf180mcu_as_sc_mcu7t3v3__nor2_2
XFILLER_225_1264 VDD VDD VSS VSS gf180mcu_as_sc_mcu7t3v3__fill_1
X_3867_ VDD VDD VSS VSS _3867_/B _5858_/A _3874_/C gf180mcu_as_sc_mcu7t3v3__and2_2
XFILLER_164_325 VDD VDD VSS VSS gf180mcu_as_sc_mcu7t3v3__fill_2
XFILLER_180_807 VDD VDD VSS VSS gf180mcu_as_sc_mcu7t3v3__fillcap_4
X_5606_ VDD VDD VSS VSS _5916_/A _5634_/B _5606_/C _5607_/C _5628_/D gf180mcu_as_sc_mcu7t3v3__aoi211_2
X_3798_ VDD VDD VSS VSS _5793_/D _3807_/S _3798_/C _3798_/D _3799_/D gf180mcu_as_sc_mcu7t3v3__ao211_2
XFILLER_152_509 VDD VDD VSS VSS gf180mcu_as_sc_mcu7t3v3__fill_1
XFILLER_178_1049 VDD VDD VSS VSS gf180mcu_as_sc_mcu7t3v3__fillcap_16
XFILLER_192_667 VDD VDD VSS VSS gf180mcu_as_sc_mcu7t3v3__fillcap_8
X_5537_ VDD VDD VSS VSS _5538_/C _5537_/B _5537_/A gf180mcu_as_sc_mcu7t3v3__nor2_2
XFILLER_219_1046 VDD VDD VSS VSS gf180mcu_as_sc_mcu7t3v3__fillcap_4
XFILLER_219_1068 VDD VDD VSS VSS gf180mcu_as_sc_mcu7t3v3__fillcap_16
X_5468_ VDD VDD VSS VSS _5469_/D _6505_/Q _5564_/B _5468_/C gf180mcu_as_sc_mcu7t3v3__ao21_2
XFILLER_160_597 VDD VDD VSS VSS gf180mcu_as_sc_mcu7t3v3__fillcap_4
X_5399_ VDD VDD VSS VSS _5400_/A _5707_/B _5491_/C _5399_/C gf180mcu_as_sc_mcu7t3v3__ao21_2
X_4419_ VDD VDD VSS VSS _6235_/Q _4422_/B _4425_/C _6234_/Q _6234_/D gf180mcu_as_sc_mcu7t3v3__ao22_2
XFILLER_8_1135 VDD VDD VSS VSS gf180mcu_as_sc_mcu7t3v3__fillcap_16
XFILLER_8_1157 VDD VDD VSS VSS gf180mcu_as_sc_mcu7t3v3__fillcap_16
XFILLER_101_664 VDD VDD VSS VSS gf180mcu_as_sc_mcu7t3v3__fill_2
XFILLER_143_46 VDD VDD VSS VSS gf180mcu_as_sc_mcu7t3v3__fillcap_4
XFILLER_219_337 VDD VDD VSS VSS gf180mcu_as_sc_mcu7t3v3__fill_1
XTAP_TAPCELL_ROW_9_1174 VDD VSS gf180mcu_as_sc_mcu7t3v3__tap_2
XFILLER_14_103 VDD VDD VSS VSS gf180mcu_as_sc_mcu7t3v3__fill_2
XFILLER_187_406 VDD VDD VSS VSS gf180mcu_as_sc_mcu7t3v3__fillcap_4
XFILLER_187_417 VDD VDD VSS VSS gf180mcu_as_sc_mcu7t3v3__fill_2
XFILLER_199_277 VDD VDD VSS VSS gf180mcu_as_sc_mcu7t3v3__fill_2
XFILLER_226_1017 VDD VDD VSS VSS gf180mcu_as_sc_mcu7t3v3__fillcap_16
XPHY_EDGE_ROW_19_3_Left_724 VDD VSS gf180mcu_as_sc_mcu7t3v3__tap_2
XFILLER_202_226 VDD VDD VSS VSS gf180mcu_as_sc_mcu7t3v3__fill_2
XFILLER_30_629 VDD VDD VSS VSS gf180mcu_as_sc_mcu7t3v3__fillcap_16
XFILLER_156_804 VDD VDD VSS VSS gf180mcu_as_sc_mcu7t3v3__fill_1
XFILLER_168_653 VDD VDD VSS VSS gf180mcu_as_sc_mcu7t3v3__fill_1
XFILLER_196_940 VDD VDD VSS VSS gf180mcu_as_sc_mcu7t3v3__fillcap_4
XFILLER_155_314 VDD VDD VSS VSS gf180mcu_as_sc_mcu7t3v3__fillcap_16
XFILLER_167_174 VDD VDD VSS VSS gf180mcu_as_sc_mcu7t3v3__fillcap_16
XFILLER_183_612 VDD VDD VSS VSS gf180mcu_as_sc_mcu7t3v3__fillcap_8
XFILLER_195_450 VDD VDD VSS VSS gf180mcu_as_sc_mcu7t3v3__fillcap_4
XFILLER_195_461 VDD VDD VSS VSS gf180mcu_as_sc_mcu7t3v3__fillcap_16
XFILLER_196_995 VDD VDD VSS VSS gf180mcu_as_sc_mcu7t3v3__fillcap_16
XFILLER_7_825 VDD VDD VSS VSS gf180mcu_as_sc_mcu7t3v3__fillcap_8
Xinput19 VDD VDD VSS VSS boot_data[1] _3092_/A gf180mcu_as_sc_mcu7t3v3__buff_12
XFILLER_195_494 VDD VDD VSS VSS gf180mcu_as_sc_mcu7t3v3__fill_1
XFILLER_7_858 VDD VDD VSS VSS gf180mcu_as_sc_mcu7t3v3__fillcap_16
XTAP_TAPCELL_ROW_137_2_3054 VDD VSS gf180mcu_as_sc_mcu7t3v3__tap_2
XFILLER_170_317 VDD VDD VSS VSS gf180mcu_as_sc_mcu7t3v3__fillcap_16
XFILLER_182_177 VDD VDD VSS VSS gf180mcu_as_sc_mcu7t3v3__fillcap_4
XTAP_TAPCELL_ROW_188_2127 VDD VSS gf180mcu_as_sc_mcu7t3v3__tap_2
XFILLER_151_597 VDD VDD VSS VSS gf180mcu_as_sc_mcu7t3v3__fillcap_4
XPHY_EDGE_ROW_102_3_Right_182 VDD VSS gf180mcu_as_sc_mcu7t3v3__tap_2
XTAP_TAPCELL_ROW_166_1724 VDD VSS gf180mcu_as_sc_mcu7t3v3__tap_2
XTAP_TAPCELL_ROW_166_1735 VDD VSS gf180mcu_as_sc_mcu7t3v3__tap_2
XFILLER_203_27 VDD VDD VSS VSS gf180mcu_as_sc_mcu7t3v3__fillcap_16
XTAP_TAPCELL_ROW_207_2466 VDD VSS gf180mcu_as_sc_mcu7t3v3__tap_2
XTAP_TAPCELL_ROW_100_3_2999 VDD VSS gf180mcu_as_sc_mcu7t3v3__tap_2
XTAP_TAPCELL_ROW_224_2780 VDD VSS gf180mcu_as_sc_mcu7t3v3__tap_2
XFILLER_178_439 VDD VDD VSS VSS gf180mcu_as_sc_mcu7t3v3__fillcap_4
XFILLER_18_1210 VDD VDD VSS VSS gf180mcu_as_sc_mcu7t3v3__fillcap_16
XTAP_TAPCELL_ROW_220_2699 VDD VSS gf180mcu_as_sc_mcu7t3v3__tap_2
X_4770_ VDD VDD VSS VSS _4770_/B _4912_/A _6353_/D gf180mcu_as_sc_mcu7t3v3__and2_2
XFILLER_159_686 VDD VDD VSS VSS gf180mcu_as_sc_mcu7t3v3__fill_2
XFILLER_186_450 VDD VDD VSS VSS gf180mcu_as_sc_mcu7t3v3__fillcap_4
X_3721_ VDD VDD VSS VSS _5728_/A _3892_/B _3721_/C _3721_/D _3722_/C gf180mcu_as_sc_mcu7t3v3__ao211_2
XFILLER_9_173 VDD VDD VSS VSS gf180mcu_as_sc_mcu7t3v3__fillcap_16
X_6440_ VDD VDD VSS VSS _6448_/CLK _6440_/D _6440_/Q gf180mcu_as_sc_mcu7t3v3__dfxtp_2
X_3652_ VDD VDD VSS VSS _3653_/A _3653_/B _3654_/A _3652_/Y _3653_/D gf180mcu_as_sc_mcu7t3v3__aoi211_2
XFILLER_162_807 VDD VDD VSS VSS gf180mcu_as_sc_mcu7t3v3__fill_1
XFILLER_174_667 VDD VDD VSS VSS gf180mcu_as_sc_mcu7t3v3__fill_2
XFILLER_61_2 VDD VDD VSS VSS gf180mcu_as_sc_mcu7t3v3__fill_1
X_6371_ VDD VDD VSS VSS _6371_/CLK _6371_/D _6371_/Q gf180mcu_as_sc_mcu7t3v3__dfxtp_2
X_3583_ VDD VDD VSS VSS _3583_/A _3583_/B _3583_/C _3583_/D _3585_/D gf180mcu_as_sc_mcu7t3v3__nand4_2
XFILLER_127_594 VDD VDD VSS VSS gf180mcu_as_sc_mcu7t3v3__fillcap_16
XFILLER_155_892 VDD VDD VSS VSS gf180mcu_as_sc_mcu7t3v3__fillcap_4
XFILLER_173_199 VDD VDD VSS VSS gf180mcu_as_sc_mcu7t3v3__fillcap_8
XPHY_EDGE_ROW_65_3_Left_770 VDD VSS gf180mcu_as_sc_mcu7t3v3__tap_2
X_5322_ VDD VDD VSS VSS _5664_/A _5664_/B _5644_/A gf180mcu_as_sc_mcu7t3v3__and2_2
X_5253_ VDD VDD VSS VSS _5294_/A _5896_/A _5898_/A _5254_/D gf180mcu_as_sc_mcu7t3v3__mux2_2
XFILLER_25_1214 VDD VDD VSS VSS gf180mcu_as_sc_mcu7t3v3__fill_1
XFILLER_96_640 VDD VDD VSS VSS gf180mcu_as_sc_mcu7t3v3__fillcap_4
XPHY_EDGE_ROW_124_2_Left_565 VDD VSS gf180mcu_as_sc_mcu7t3v3__tap_2
X_5184_ VDD VDD VSS VSS _5842_/D _5184_/B _5184_/C _5293_/B _5186_/C gf180mcu_as_sc_mcu7t3v3__ao211_2
X_4204_ VDD VDD VSS VSS _6197_/D _4204_/C _4223_/B _6197_/Q gf180mcu_as_sc_mcu7t3v3__aoi21b_2
X_4135_ VDD VDD VSS VSS _4135_/S _6185_/Q _6184_/Q _6184_/D gf180mcu_as_sc_mcu7t3v3__mux2_2
XFILLER_113_27 VDD VDD VSS VSS gf180mcu_as_sc_mcu7t3v3__fillcap_16
XFILLER_228_178 VDD VDD VSS VSS gf180mcu_as_sc_mcu7t3v3__fill_1
XPHY_EDGE_ROW_61_2_Left_502 VDD VSS gf180mcu_as_sc_mcu7t3v3__tap_2
X_4066_ VDD VDD VSS VSS _5972_/C _6014_/B _6014_/C _6132_/D gf180mcu_as_sc_mcu7t3v3__nor3_2
XFILLER_149_1140 VDD VDD VSS VSS gf180mcu_as_sc_mcu7t3v3__fillcap_16
XFILLER_209_392 VDD VDD VSS VSS gf180mcu_as_sc_mcu7t3v3__fill_2
X_3017_ VDD VDD VSS VSS _4947_/A _5293_/A gf180mcu_as_sc_mcu7t3v3__inv_2
XFILLER_225_885 VDD VDD VSS VSS gf180mcu_as_sc_mcu7t3v3__fill_2
XTAP_TAPCELL_ROW_4_1093 VDD VSS gf180mcu_as_sc_mcu7t3v3__tap_2
XTAP_TAPCELL_ROW_4_1082 VDD VSS gf180mcu_as_sc_mcu7t3v3__tap_2
XFILLER_224_395 VDD VDD VSS VSS gf180mcu_as_sc_mcu7t3v3__fillcap_4
XFILLER_196_247 VDD VDD VSS VSS gf180mcu_as_sc_mcu7t3v3__fillcap_8
XFILLER_71_1212 VDD VDD VSS VSS gf180mcu_as_sc_mcu7t3v3__fill_1
X_4968_ VDD VDD VSS VSS _4968_/A _4968_/B _4968_/C _4970_/B gf180mcu_as_sc_mcu7t3v3__nand3_2
X_4899_ VDD VDD VSS VSS _5888_/B _4959_/B _4899_/C _4899_/D _4900_/D gf180mcu_as_sc_mcu7t3v3__ao211_2
X_3919_ VDD VDD VSS VSS _3930_/B _5900_/A _3920_/D gf180mcu_as_sc_mcu7t3v3__and2_2
XFILLER_164_155 VDD VDD VSS VSS gf180mcu_as_sc_mcu7t3v3__fillcap_16
XFILLER_192_442 VDD VDD VSS VSS gf180mcu_as_sc_mcu7t3v3__fillcap_8
XFILLER_193_998 VDD VDD VSS VSS gf180mcu_as_sc_mcu7t3v3__fillcap_16
XFILLER_118_594 VDD VDD VSS VSS gf180mcu_as_sc_mcu7t3v3__fillcap_8
XFILLER_152_317 VDD VDD VSS VSS gf180mcu_as_sc_mcu7t3v3__fillcap_16
XFILLER_164_177 VDD VDD VSS VSS gf180mcu_as_sc_mcu7t3v3__fillcap_16
XFILLER_154_34 VDD VDD VSS VSS gf180mcu_as_sc_mcu7t3v3__fill_1
XFILLER_191_1046 VDD VDD VSS VSS gf180mcu_as_sc_mcu7t3v3__fillcap_4
XPHY_EDGE_ROW_56_2_Left_497 VDD VSS gf180mcu_as_sc_mcu7t3v3__tap_2
Xoutput470 VDD VDD VSS VSS _6472_/Q west_out[23] gf180mcu_as_sc_mcu7t3v3__buff_12
XFILLER_191_1068 VDD VDD VSS VSS gf180mcu_as_sc_mcu7t3v3__fillcap_16
Xoutput481 VDD VDD VSS VSS _6482_/Q west_out[33] gf180mcu_as_sc_mcu7t3v3__buff_12
XTAP_TAPCELL_ROW_24_2_2884 VDD VSS gf180mcu_as_sc_mcu7t3v3__tap_2
XTAP_TAPCELL_ROW_183_2035 VDD VSS gf180mcu_as_sc_mcu7t3v3__tap_2
XFILLER_170_22 VDD VDD VSS VSS gf180mcu_as_sc_mcu7t3v3__fillcap_8
XFILLER_47_43 VDD VDD VSS VSS gf180mcu_as_sc_mcu7t3v3__fillcap_8
XFILLER_16_902 VDD VDD VSS VSS gf180mcu_as_sc_mcu7t3v3__fillcap_16
XTAP_TAPCELL_ROW_161_1632 VDD VSS gf180mcu_as_sc_mcu7t3v3__tap_2
XTAP_TAPCELL_ROW_161_1643 VDD VSS gf180mcu_as_sc_mcu7t3v3__tap_2
XFILLER_15_434 VDD VDD VSS VSS gf180mcu_as_sc_mcu7t3v3__fillcap_8
XFILLER_167_1240 VDD VDD VSS VSS gf180mcu_as_sc_mcu7t3v3__fillcap_16
XFILLER_167_1262 VDD VDD VSS VSS gf180mcu_as_sc_mcu7t3v3__fill_2
XFILLER_188_737 VDD VDD VSS VSS gf180mcu_as_sc_mcu7t3v3__fill_1
Xclkbuf_leaf_18_clk_regs VDD VDD VSS VSS clkbuf_3_4_0_clk_regs/Y _6506_/CLK gf180mcu_as_sc_mcu7t3v3__clkbuff_12
XTAP_TAPCELL_ROW_202_2385 VDD VSS gf180mcu_as_sc_mcu7t3v3__tap_2
XTAP_TAPCELL_ROW_202_2374 VDD VSS gf180mcu_as_sc_mcu7t3v3__tap_2
XFILLER_187_258 VDD VDD VSS VSS gf180mcu_as_sc_mcu7t3v3__fill_1
XFILLER_11_651 VDD VDD VSS VSS gf180mcu_as_sc_mcu7t3v3__fillcap_4
XFILLER_8_37 VDD VDD VSS VSS gf180mcu_as_sc_mcu7t3v3__fillcap_16
XFILLER_171_604 VDD VDD VSS VSS gf180mcu_as_sc_mcu7t3v3__fill_2
XFILLER_204_1189 VDD VDD VSS VSS gf180mcu_as_sc_mcu7t3v3__fillcap_16
XFILLER_7_666 VDD VDD VSS VSS gf180mcu_as_sc_mcu7t3v3__fill_1
XFILLER_109_594 VDD VDD VSS VSS gf180mcu_as_sc_mcu7t3v3__fill_1
XFILLER_195_96 VDD VDD VSS VSS gf180mcu_as_sc_mcu7t3v3__fillcap_4
Xwire597 VDD VDD VSS VSS _5358_/Y wire597/Y gf180mcu_as_sc_mcu7t3v3__clkbuff_12
XFILLER_152_851 VDD VDD VSS VSS gf180mcu_as_sc_mcu7t3v3__fill_2
XFILLER_152_895 VDD VDD VSS VSS gf180mcu_as_sc_mcu7t3v3__fill_1
XFILLER_170_1119 VDD VDD VSS VSS gf180mcu_as_sc_mcu7t3v3__fillcap_16
XTAP_TAPCELL_ROW_209_2506 VDD VSS gf180mcu_as_sc_mcu7t3v3__tap_2
XFILLER_214_37 VDD VDD VSS VSS gf180mcu_as_sc_mcu7t3v3__fillcap_16
XPHY_EDGE_ROW_103_3_Right_183 VDD VSS gf180mcu_as_sc_mcu7t3v3__tap_2
XFILLER_211_1116 VDD VDD VSS VSS gf180mcu_as_sc_mcu7t3v3__fillcap_4
XFILLER_211_1138 VDD VDD VSS VSS gf180mcu_as_sc_mcu7t3v3__fillcap_16
XTAP_TAPCELL_ROW_222_2739 VDD VSS gf180mcu_as_sc_mcu7t3v3__tap_2
XFILLER_111_1261 VDD VDD VSS VSS gf180mcu_as_sc_mcu7t3v3__fillcap_4
XFILLER_225_148 VDD VDD VSS VSS gf180mcu_as_sc_mcu7t3v3__fill_1
X_5940_ VDD VDD VSS VSS _5940_/A _5947_/B _5940_/C _5940_/D _5941_/B gf180mcu_as_sc_mcu7t3v3__ao211_2
XTAP_TAPCELL_ROW_34_3_2900 VDD VSS gf180mcu_as_sc_mcu7t3v3__tap_2
XFILLER_94_1245 VDD VDD VSS VSS gf180mcu_as_sc_mcu7t3v3__fillcap_16
XFILLER_179_737 VDD VDD VSS VSS gf180mcu_as_sc_mcu7t3v3__fill_1
X_5871_ VDD VDD VSS VSS _5871_/A _5871_/B _5871_/C _5871_/D _5873_/C gf180mcu_as_sc_mcu7t3v3__ao22_2
X_4822_ VDD VDD VSS VSS _6511_/Q _4953_/B _4822_/C _4822_/D _4824_/C gf180mcu_as_sc_mcu7t3v3__ao22_2
XTAP_TAPCELL_ROW_179_1959 VDD VSS gf180mcu_as_sc_mcu7t3v3__tap_2
X_4753_ VDD VDD VSS VSS _4876_/B _5764_/A _4754_/C gf180mcu_as_sc_mcu7t3v3__and2_2
XFILLER_179_1100 VDD VDD VSS VSS gf180mcu_as_sc_mcu7t3v3__fillcap_16
XFILLER_193_228 VDD VDD VSS VSS gf180mcu_as_sc_mcu7t3v3__fill_2
XFILLER_202_590 VDD VDD VSS VSS gf180mcu_as_sc_mcu7t3v3__fillcap_4
X_3704_ VDD VDD VSS VSS _4024_/D _5712_/A _3810_/B _3704_/C gf180mcu_as_sc_mcu7t3v3__ao21_2
XFILLER_147_656 VDD VDD VSS VSS gf180mcu_as_sc_mcu7t3v3__fillcap_4
XFILLER_179_1122 VDD VDD VSS VSS gf180mcu_as_sc_mcu7t3v3__fillcap_16
X_6423_ VDD VDD VSS VSS _6437_/CLK _6423_/D _6423_/Q gf180mcu_as_sc_mcu7t3v3__dfxtp_2
X_4684_ VDD VDD VSS VSS _5702_/A _4795_/B _4795_/C _5697_/A _4685_/D gf180mcu_as_sc_mcu7t3v3__ao22_2
XFILLER_174_475 VDD VDD VSS VSS gf180mcu_as_sc_mcu7t3v3__fill_2
X_3635_ VDD VDD VSS VSS _3635_/B _5320_/A _5321_/A gf180mcu_as_sc_mcu7t3v3__and2_2
XFILLER_108_27 VDD VDD VSS VSS gf180mcu_as_sc_mcu7t3v3__fillcap_8
XFILLER_108_49 VDD VDD VSS VSS gf180mcu_as_sc_mcu7t3v3__fill_2
XFILLER_161_136 VDD VDD VSS VSS gf180mcu_as_sc_mcu7t3v3__fillcap_4
XFILLER_161_158 VDD VDD VSS VSS gf180mcu_as_sc_mcu7t3v3__fillcap_16
XPHY_EDGE_ROW_41_1_Left_269 VDD VSS gf180mcu_as_sc_mcu7t3v3__tap_2
X_6354_ VDD VDD VSS VSS _6365_/CLK _6354_/D _6354_/Q gf180mcu_as_sc_mcu7t3v3__dfxtp_2
X_3566_ VDD VDD VSS VSS _4619_/A _4619_/B _4620_/A _3572_/B gf180mcu_as_sc_mcu7t3v3__nand3_2
XFILLER_0_308 VDD VDD VSS VSS gf180mcu_as_sc_mcu7t3v3__fillcap_4
X_6285_ VDD VDD VSS VSS clkload7/A _6285_/D _6285_/Q gf180mcu_as_sc_mcu7t3v3__dfxtp_2
X_5305_ VDD VDD VSS VSS _5945_/A _5309_/B _5305_/C _5305_/D _5306_/C gf180mcu_as_sc_mcu7t3v3__ao211_2
X_3497_ VDD VDD VSS VSS _5915_/A _5319_/D _3500_/B gf180mcu_as_sc_mcu7t3v3__xnor2_2
XFILLER_216_1049 VDD VDD VSS VSS gf180mcu_as_sc_mcu7t3v3__fillcap_16
Xinput209 VDD VDD VSS VSS se_in[22] _5858_/A gf180mcu_as_sc_mcu7t3v3__buff_12
X_5236_ VDD VDD VSS VSS _5882_/A _5308_/B _5236_/C _5236_/D _5237_/A gf180mcu_as_sc_mcu7t3v3__ao211_2
XFILLER_124_37 VDD VDD VSS VSS gf180mcu_as_sc_mcu7t3v3__fillcap_8
XFILLER_151_1030 VDD VDD VSS VSS gf180mcu_as_sc_mcu7t3v3__fillcap_16
XFILLER_151_1052 VDD VDD VSS VSS gf180mcu_as_sc_mcu7t3v3__fillcap_16
XFILLER_5_1116 VDD VDD VSS VSS gf180mcu_as_sc_mcu7t3v3__fillcap_4
XFILLER_5_1138 VDD VDD VSS VSS gf180mcu_as_sc_mcu7t3v3__fillcap_16
X_5167_ VDD VDD VSS VSS _5168_/D _5167_/C _5242_/B _5821_/A gf180mcu_as_sc_mcu7t3v3__aoi21_2
X_5098_ VDD VDD VSS VSS _5761_/A _5098_/B _5098_/C _5098_/D _5099_/A gf180mcu_as_sc_mcu7t3v3__ao211_2
X_4118_ VDD VDD VSS VSS _4146_/S _6168_/Q _6167_/Q _6167_/D gf180mcu_as_sc_mcu7t3v3__mux2_2
XTAP_TAPCELL_ROW_6_1122 VDD VSS gf180mcu_as_sc_mcu7t3v3__tap_2
X_4049_ VDD VDD VSS VSS _4049_/D _4061_/A _4049_/B _4057_/C _6123_/D gf180mcu_as_sc_mcu7t3v3__ao31_2
XFILLER_224_181 VDD VDD VSS VSS gf180mcu_as_sc_mcu7t3v3__fill_1
XFILLER_225_682 VDD VDD VSS VSS gf180mcu_as_sc_mcu7t3v3__fillcap_4
XFILLER_12_415 VDD VDD VSS VSS gf180mcu_as_sc_mcu7t3v3__fillcap_4
XFILLER_184_217 VDD VDD VSS VSS gf180mcu_as_sc_mcu7t3v3__fillcap_4
XFILLER_200_527 VDD VDD VSS VSS gf180mcu_as_sc_mcu7t3v3__fillcap_16
XFILLER_193_795 VDD VDD VSS VSS gf180mcu_as_sc_mcu7t3v3__fill_2
XFILLER_3_102 VDD VDD VSS VSS gf180mcu_as_sc_mcu7t3v3__fillcap_4
XFILLER_153_648 VDD VDD VSS VSS gf180mcu_as_sc_mcu7t3v3__fillcap_16
XFILLER_165_88 VDD VDD VSS VSS gf180mcu_as_sc_mcu7t3v3__fillcap_16
XFILLER_3_146 VDD VDD VSS VSS gf180mcu_as_sc_mcu7t3v3__fill_2
XFILLER_134_1261 VDD VDD VSS VSS gf180mcu_as_sc_mcu7t3v3__fillcap_4
Xwire1020 VDD VDD VSS VSS wire1020/A _5790_/B gf180mcu_as_sc_mcu7t3v3__clkbuff_12
XFILLER_207_104 VDD VDD VSS VSS gf180mcu_as_sc_mcu7t3v3__fillcap_4
XTAP_TAPCELL_ROW_204_2414 VDD VSS gf180mcu_as_sc_mcu7t3v3__tap_2
XFILLER_216_660 VDD VDD VSS VSS gf180mcu_as_sc_mcu7t3v3__fillcap_4
XFILLER_222_107 VDD VDD VSS VSS gf180mcu_as_sc_mcu7t3v3__fillcap_4
XFILLER_15_264 VDD VDD VSS VSS gf180mcu_as_sc_mcu7t3v3__fill_2
XFILLER_204_866 VDD VDD VSS VSS gf180mcu_as_sc_mcu7t3v3__fill_1
XFILLER_204_877 VDD VDD VSS VSS gf180mcu_as_sc_mcu7t3v3__fillcap_8
XTAP_TAPCELL_ROW_125_2_3036 VDD VSS gf180mcu_as_sc_mcu7t3v3__tap_2
XFILLER_141_1210 VDD VDD VSS VSS gf180mcu_as_sc_mcu7t3v3__fillcap_16
XFILLER_15_1224 VDD VDD VSS VSS gf180mcu_as_sc_mcu7t3v3__fillcap_8
XFILLER_11_492 VDD VDD VSS VSS gf180mcu_as_sc_mcu7t3v3__fillcap_4
XFILLER_144_604 VDD VDD VSS VSS gf180mcu_as_sc_mcu7t3v3__fill_1
XFILLER_157_965 VDD VDD VSS VSS gf180mcu_as_sc_mcu7t3v3__fillcap_8
XFILLER_7_430 VDD VDD VSS VSS gf180mcu_as_sc_mcu7t3v3__fill_1
XTAP_TAPCELL_ROW_174_1867 VDD VSS gf180mcu_as_sc_mcu7t3v3__tap_2
XTAP_TAPCELL_ROW_219_2690 VDD VSS gf180mcu_as_sc_mcu7t3v3__tap_2
XFILLER_144_637 VDD VDD VSS VSS gf180mcu_as_sc_mcu7t3v3__fillcap_4
XFILLER_156_497 VDD VDD VSS VSS gf180mcu_as_sc_mcu7t3v3__fillcap_4
XFILLER_157_998 VDD VDD VSS VSS gf180mcu_as_sc_mcu7t3v3__fillcap_16
XFILLER_209_59 VDD VDD VSS VSS gf180mcu_as_sc_mcu7t3v3__fillcap_8
XTAP_TAPCELL_ROW_174_1878 VDD VSS gf180mcu_as_sc_mcu7t3v3__tap_2
XFILLER_171_456 VDD VDD VSS VSS gf180mcu_as_sc_mcu7t3v3__fillcap_16
XFILLER_172_957 VDD VDD VSS VSS gf180mcu_as_sc_mcu7t3v3__fill_2
X_3420_ VDD VDD VSS VSS _3421_/B _3420_/A _4553_/A gf180mcu_as_sc_mcu7t3v3__and2_2
X_3351_ VDD VDD VSS VSS _3351_/B _3358_/A _3354_/C gf180mcu_as_sc_mcu7t3v3__or2_2
X_6070_ VDD VDD VSS VSS _6125_/CLK _6070_/D _6070_/Q gf180mcu_as_sc_mcu7t3v3__dfxtp_2
X_3282_ VDD VDD VSS VSS _3296_/B _6169_/Q _6233_/Q _3283_/B gf180mcu_as_sc_mcu7t3v3__mux2_2
X_5021_ VDD VDD VSS VSS _5022_/D _5086_/B _5132_/B _5690_/B gf180mcu_as_sc_mcu7t3v3__aoi21b_2
XPHY_EDGE_ROW_104_3_Right_184 VDD VSS gf180mcu_as_sc_mcu7t3v3__tap_2
XFILLER_226_446 VDD VDD VSS VSS gf180mcu_as_sc_mcu7t3v3__fill_2
XFILLER_66_665 VDD VDD VSS VSS gf180mcu_as_sc_mcu7t3v3__fill_2
XFILLER_185_1170 VDD VDD VSS VSS gf180mcu_as_sc_mcu7t3v3__fillcap_16
XPHY_EDGE_ROW_148_1_Right_720 VDD VSS gf180mcu_as_sc_mcu7t3v3__tap_2
X_5923_ VDD VDD VSS VSS _5923_/A _5953_/C _5923_/C _5923_/D _5924_/C gf180mcu_as_sc_mcu7t3v3__ao211_2
XTAP_TAPCELL_ROW_1_1030 VDD VSS gf180mcu_as_sc_mcu7t3v3__tap_2
XFILLER_185_1192 VDD VDD VSS VSS gf180mcu_as_sc_mcu7t3v3__fillcap_16
X_5854_ VDD VDD VSS VSS _5854_/S _5854_/B _6515_/Q _5855_/C gf180mcu_as_sc_mcu7t3v3__mux2_2
X_4805_ VDD VDD VSS VSS _5809_/A _4871_/B _4805_/C _4805_/D _4806_/C gf180mcu_as_sc_mcu7t3v3__ao211_2
X_5785_ VDD VDD VSS VSS _5787_/B _5785_/C _5837_/B _5785_/A gf180mcu_as_sc_mcu7t3v3__aoi21_2
X_4736_ VDD VDD VSS VSS _4736_/B _4794_/S _4739_/C gf180mcu_as_sc_mcu7t3v3__and2_2
XFILLER_190_732 VDD VDD VSS VSS gf180mcu_as_sc_mcu7t3v3__fill_2
X_4667_ VDD VDD VSS VSS _4668_/C _4794_/S _4667_/B _4667_/C gf180mcu_as_sc_mcu7t3v3__ao21_2
XFILLER_135_659 VDD VDD VSS VSS gf180mcu_as_sc_mcu7t3v3__fill_2
XFILLER_162_445 VDD VDD VSS VSS gf180mcu_as_sc_mcu7t3v3__fill_2
X_6406_ VDD VDD VSS VSS _6412_/CLK _6406_/D _6406_/Q gf180mcu_as_sc_mcu7t3v3__dfxtp_2
X_3618_ VDD VDD VSS VSS _5353_/A _3631_/A _5918_/A _5927_/A _3631_/D gf180mcu_as_sc_mcu7t3v3__aoi22_2
X_6337_ VDD VDD VSS VSS _6551_/CLK _6337_/D _6337_/Q gf180mcu_as_sc_mcu7t3v3__dfxtp_2
X_4598_ VDD VDD VSS VSS _4602_/A _4598_/B _4598_/C _6336_/D gf180mcu_as_sc_mcu7t3v3__nor3_2
XFILLER_118_1245 VDD VDD VSS VSS gf180mcu_as_sc_mcu7t3v3__fillcap_16
X_3549_ VDD VDD VSS VSS _3556_/B _5319_/D _5913_/A gf180mcu_as_sc_mcu7t3v3__nand2b_2
XFILLER_0_138 VDD VDD VSS VSS gf180mcu_as_sc_mcu7t3v3__fillcap_4
XFILLER_95_29 VDD VDD VSS VSS gf180mcu_as_sc_mcu7t3v3__fillcap_16
XPHY_EDGE_ROW_28_3_Left_733 VDD VSS gf180mcu_as_sc_mcu7t3v3__tap_2
X_6268_ VDD VDD VSS VSS clkload6/A _6268_/D _6268_/Q gf180mcu_as_sc_mcu7t3v3__dfxtp_2
X_6199_ VDD VDD VSS VSS _6368_/CLK _6199_/D _6199_/Q gf180mcu_as_sc_mcu7t3v3__dfxtp_2
X_5219_ VDD VDD VSS VSS _5237_/S _5867_/A _5219_/A _5220_/B gf180mcu_as_sc_mcu7t3v3__mux2_2
XFILLER_217_424 VDD VDD VSS VSS gf180mcu_as_sc_mcu7t3v3__fill_1
XFILLER_218_947 VDD VDD VSS VSS gf180mcu_as_sc_mcu7t3v3__fillcap_16
XFILLER_28_45 VDD VDD VSS VSS gf180mcu_as_sc_mcu7t3v3__fillcap_4
XFILLER_13_702 VDD VDD VSS VSS gf180mcu_as_sc_mcu7t3v3__fillcap_16
XFILLER_164_1221 VDD VDD VSS VSS gf180mcu_as_sc_mcu7t3v3__fillcap_4
XFILLER_125_1238 VDD VDD VSS VSS gf180mcu_as_sc_mcu7t3v3__fill_2
XFILLER_157_206 VDD VDD VSS VSS gf180mcu_as_sc_mcu7t3v3__fillcap_4
XFILLER_158_729 VDD VDD VSS VSS gf180mcu_as_sc_mcu7t3v3__fillcap_4
XFILLER_200_313 VDD VDD VSS VSS gf180mcu_as_sc_mcu7t3v3__fill_2
XFILLER_157_228 VDD VDD VSS VSS gf180mcu_as_sc_mcu7t3v3__fillcap_16
XFILLER_205_1262 VDD VDD VSS VSS gf180mcu_as_sc_mcu7t3v3__fill_2
Xsram2048.u_bank0_1033 VDD VDD VSS VSS sram2048.u_bank0/WEN[7] gf180mcu_as_sc_mcu7t3v3__tiel_4
XFILLER_226_2 VDD VDD VSS VSS gf180mcu_as_sc_mcu7t3v3__fillcap_16
XTAP_TAPCELL_ROW_156_1542 VDD VSS gf180mcu_as_sc_mcu7t3v3__tap_2
XTAP_TAPCELL_ROW_156_1553 VDD VSS gf180mcu_as_sc_mcu7t3v3__tap_2
XTAP_TAPCELL_ROW_191_2178 VDD VSS gf180mcu_as_sc_mcu7t3v3__tap_2
XFILLER_126_626 VDD VDD VSS VSS gf180mcu_as_sc_mcu7t3v3__fill_1
XFILLER_126_637 VDD VDD VSS VSS gf180mcu_as_sc_mcu7t3v3__fillcap_4
XFILLER_154_935 VDD VDD VSS VSS gf180mcu_as_sc_mcu7t3v3__fill_1
XFILLER_197_1030 VDD VDD VSS VSS gf180mcu_as_sc_mcu7t3v3__fillcap_16
XFILLER_197_1052 VDD VDD VSS VSS gf180mcu_as_sc_mcu7t3v3__fillcap_16
XFILLER_5_912 VDD VDD VSS VSS gf180mcu_as_sc_mcu7t3v3__fillcap_16
XPHY_EDGE_ROW_110_1_Right_682 VDD VSS gf180mcu_as_sc_mcu7t3v3__tap_2
XFILLER_5_27 VDD VDD VSS VSS gf180mcu_as_sc_mcu7t3v3__fillcap_16
XFILLER_153_489 VDD VDD VSS VSS gf180mcu_as_sc_mcu7t3v3__fill_1
XFILLER_162_990 VDD VDD VSS VSS gf180mcu_as_sc_mcu7t3v3__fillcap_16
XFILLER_192_31 VDD VDD VSS VSS gf180mcu_as_sc_mcu7t3v3__fillcap_4
XFILLER_192_53 VDD VDD VSS VSS gf180mcu_as_sc_mcu7t3v3__fillcap_16
XTAP_TAPCELL_ROW_15_1284 VDD VSS gf180mcu_as_sc_mcu7t3v3__tap_2
XFILLER_208_457 VDD VDD VSS VSS gf180mcu_as_sc_mcu7t3v3__fill_2
Xclkbuf_leaf_33_clk_regs VDD VDD VSS VSS clkbuf_3_6_0_clk_regs/Y _6412_/CLK gf180mcu_as_sc_mcu7t3v3__clkbuff_12
XFILLER_169_1154 VDD VDD VSS VSS gf180mcu_as_sc_mcu7t3v3__fillcap_16
XFILLER_211_38 VDD VDD VSS VSS gf180mcu_as_sc_mcu7t3v3__fillcap_16
XFILLER_204_663 VDD VDD VSS VSS gf180mcu_as_sc_mcu7t3v3__fill_2
XFILLER_188_342 VDD VDD VSS VSS gf180mcu_as_sc_mcu7t3v3__fill_2
XTAP_TAPCELL_ROW_176_1907 VDD VSS gf180mcu_as_sc_mcu7t3v3__tap_2
XTAP_TAPCELL_ROW_176_1918 VDD VSS gf180mcu_as_sc_mcu7t3v3__tap_2
XPHY_EDGE_ROW_133_2_Left_574 VDD VSS gf180mcu_as_sc_mcu7t3v3__tap_2
X_5570_ VDD VDD VSS VSS _5570_/B _5643_/A _6437_/D gf180mcu_as_sc_mcu7t3v3__and2_2
XTAP_TAPCELL_ROW_217_2649 VDD VSS gf180mcu_as_sc_mcu7t3v3__tap_2
XFILLER_7_260 VDD VDD VSS VSS gf180mcu_as_sc_mcu7t3v3__fillcap_16
X_4521_ VDD VDD VSS VSS _4527_/S _6293_/Q _4521_/A _6293_/D gf180mcu_as_sc_mcu7t3v3__mux2_2
XFILLER_176_1103 VDD VDD VSS VSS gf180mcu_as_sc_mcu7t3v3__fillcap_16
XFILLER_7_282 VDD VDD VSS VSS gf180mcu_as_sc_mcu7t3v3__fillcap_16
XPHY_EDGE_ROW_70_2_Left_511 VDD VSS gf180mcu_as_sc_mcu7t3v3__tap_2
X_4452_ VDD VDD VSS VSS _4546_/B _6159_/Q _6262_/Q _6262_/D gf180mcu_as_sc_mcu7t3v3__mux2_2
XFILLER_132_629 VDD VDD VSS VSS gf180mcu_as_sc_mcu7t3v3__fillcap_16
XFILLER_217_1100 VDD VDD VSS VSS gf180mcu_as_sc_mcu7t3v3__fillcap_16
X_3403_ VDD VDD VSS VSS _6270_/Q _6269_/Q _6267_/Q _3404_/B gf180mcu_as_sc_mcu7t3v3__nor3_2
XFILLER_217_1122 VDD VDD VSS VSS gf180mcu_as_sc_mcu7t3v3__fillcap_16
X_4383_ VDD VDD VSS VSS _4398_/S _6123_/Q _4383_/C _4404_/D _4387_/C gf180mcu_as_sc_mcu7t3v3__ao211_2
Xfanout707 VDD VDD VSS VSS _4076_/B _4072_/A gf180mcu_as_sc_mcu7t3v3__buff_12
Xfanout718 VDD VDD VSS VSS _5840_/B _5853_/B gf180mcu_as_sc_mcu7t3v3__buff_12
Xfanout729 VDD VDD VSS VSS _5637_/B _5632_/B gf180mcu_as_sc_mcu7t3v3__buff_12
X_6122_ VDD VDD VSS VSS _6525_/CLK _6122_/D _6122_/Q gf180mcu_as_sc_mcu7t3v3__dfxtp_2
X_3334_ VDD VDD VSS VSS _3357_/S _6537_/Q _6546_/Q _3335_/B gf180mcu_as_sc_mcu7t3v3__mux2_2
X_6053_ VDD VDD VSS VSS _6368_/CLK _6053_/D _6053_/Q gf180mcu_as_sc_mcu7t3v3__dfxtp_2
X_3265_ VDD VDD VSS VSS _3296_/B _6167_/Q _6231_/Q _3266_/B gf180mcu_as_sc_mcu7t3v3__mux2_2
X_5004_ VDD VDD VSS VSS _5318_/A _5318_/B _5307_/B gf180mcu_as_sc_mcu7t3v3__and2_2
XFILLER_2_1119 VDD VDD VSS VSS gf180mcu_as_sc_mcu7t3v3__fillcap_16
XPHY_EDGE_ROW_105_3_Right_185 VDD VSS gf180mcu_as_sc_mcu7t3v3__tap_2
X_3196_ VDD VDD VSS VSS _3291_/B _3196_/B _3196_/C _3196_/D _6013_/B gf180mcu_as_sc_mcu7t3v3__ao22_2
XFILLER_187_1232 VDD VDD VSS VSS gf180mcu_as_sc_mcu7t3v3__fill_2
XFILLER_215_939 VDD VDD VSS VSS gf180mcu_as_sc_mcu7t3v3__fillcap_16
XFILLER_227_766 VDD VDD VSS VSS gf180mcu_as_sc_mcu7t3v3__fillcap_4
XFILLER_121_27 VDD VDD VSS VSS gf180mcu_as_sc_mcu7t3v3__fillcap_16
XFILLER_199_618 VDD VDD VSS VSS gf180mcu_as_sc_mcu7t3v3__fillcap_8
X_5906_ VDD VDD VSS VSS _5930_/A _5936_/B _5951_/B _5906_/D _5907_/D gf180mcu_as_sc_mcu7t3v3__ao22_2
XFILLER_167_515 VDD VDD VSS VSS gf180mcu_as_sc_mcu7t3v3__fill_1
XFILLER_167_526 VDD VDD VSS VSS gf180mcu_as_sc_mcu7t3v3__fillcap_4
XFILLER_179_397 VDD VDD VSS VSS gf180mcu_as_sc_mcu7t3v3__fillcap_8
X_5837_ VDD VDD VSS VSS _5837_/B _5837_/A _5840_/C gf180mcu_as_sc_mcu7t3v3__and2_2
X_5768_ VDD VDD VSS VSS _5768_/A _5874_/B _5873_/B _5768_/D _5769_/D gf180mcu_as_sc_mcu7t3v3__ao22_2
XFILLER_154_209 VDD VDD VSS VSS gf180mcu_as_sc_mcu7t3v3__fillcap_16
X_4719_ VDD VDD VSS VSS _4719_/B _5734_/A _4720_/D gf180mcu_as_sc_mcu7t3v3__and2_2
XFILLER_68_1217 VDD VDD VSS VSS gf180mcu_as_sc_mcu7t3v3__fill_1
X_5699_ VDD VDD VSS VSS _5798_/S _5699_/B _6496_/Q _5700_/C gf180mcu_as_sc_mcu7t3v3__mux2_2
XFILLER_151_916 VDD VDD VSS VSS gf180mcu_as_sc_mcu7t3v3__fill_1
XTAP_TAPCELL_ROW_151_1461 VDD VSS gf180mcu_as_sc_mcu7t3v3__tap_2
XFILLER_162_23 VDD VDD VSS VSS gf180mcu_as_sc_mcu7t3v3__fillcap_8
XFILLER_89_598 VDD VDD VSS VSS gf180mcu_as_sc_mcu7t3v3__fill_1
XFILLER_218_722 VDD VDD VSS VSS gf180mcu_as_sc_mcu7t3v3__fill_1
XFILLER_44_1261 VDD VDD VSS VSS gf180mcu_as_sc_mcu7t3v3__fillcap_4
Xmesh_tile_1117 VDD VDD VSS VSS se_out[4] gf180mcu_as_sc_mcu7t3v3__tiel_4
Xmesh_tile_1106 VDD VDD VSS VSS nw_out[29] gf180mcu_as_sc_mcu7t3v3__tiel_4
XPHY_EDGE_ROW_129_1_Left_357 VDD VSS gf180mcu_as_sc_mcu7t3v3__tap_2
Xmesh_tile_1139 VDD VDD VSS VSS se_out[26] gf180mcu_as_sc_mcu7t3v3__tiel_4
Xmesh_tile_1128 VDD VDD VSS VSS se_out[15] gf180mcu_as_sc_mcu7t3v3__tiel_4
XFILLER_176_2 VDD VDD VSS VSS gf180mcu_as_sc_mcu7t3v3__fillcap_16
XFILLER_205_405 VDD VDD VSS VSS gf180mcu_as_sc_mcu7t3v3__fill_2
XFILLER_13_510 VDD VDD VSS VSS gf180mcu_as_sc_mcu7t3v3__fill_2
XFILLER_221_909 VDD VDD VSS VSS gf180mcu_as_sc_mcu7t3v3__fill_1
XTAP_TAPCELL_ROW_10_1192 VDD VSS gf180mcu_as_sc_mcu7t3v3__tap_2
XTAP_TAPCELL_ROW_193_2218 VDD VSS gf180mcu_as_sc_mcu7t3v3__tap_2
XTAP_TAPCELL_ROW_193_2207 VDD VSS gf180mcu_as_sc_mcu7t3v3__tap_2
XFILLER_13_554 VDD VDD VSS VSS gf180mcu_as_sc_mcu7t3v3__fillcap_4
XFILLER_197_172 VDD VDD VSS VSS gf180mcu_as_sc_mcu7t3v3__fillcap_4
XFILLER_198_695 VDD VDD VSS VSS gf180mcu_as_sc_mcu7t3v3__fillcap_16
XFILLER_51_1210 VDD VDD VSS VSS gf180mcu_as_sc_mcu7t3v3__fillcap_4
XFILLER_185_367 VDD VDD VSS VSS gf180mcu_as_sc_mcu7t3v3__fillcap_4
XFILLER_201_688 VDD VDD VSS VSS gf180mcu_as_sc_mcu7t3v3__fillcap_8
XFILLER_12_1205 VDD VDD VSS VSS gf180mcu_as_sc_mcu7t3v3__fillcap_16
XFILLER_12_1227 VDD VDD VSS VSS gf180mcu_as_sc_mcu7t3v3__fillcap_16
XTAP_TAPCELL_ROW_171_1815 VDD VSS gf180mcu_as_sc_mcu7t3v3__tap_2
XTAP_TAPCELL_ROW_171_1826 VDD VSS gf180mcu_as_sc_mcu7t3v3__tap_2
XFILLER_154_787 VDD VDD VSS VSS gf180mcu_as_sc_mcu7t3v3__fillcap_4
XPHY_EDGE_ROW_111_1_Right_683 VDD VSS gf180mcu_as_sc_mcu7t3v3__tap_2
XTAP_TAPCELL_ROW_212_2557 VDD VSS gf180mcu_as_sc_mcu7t3v3__tap_2
XFILLER_114_629 VDD VDD VSS VSS gf180mcu_as_sc_mcu7t3v3__fillcap_4
XFILLER_206_27 VDD VDD VSS VSS gf180mcu_as_sc_mcu7t3v3__fillcap_8
XTAP_TAPCELL_ROW_169_1777 VDD VSS gf180mcu_as_sc_mcu7t3v3__tap_2
XTAP_TAPCELL_ROW_169_1788 VDD VSS gf180mcu_as_sc_mcu7t3v3__tap_2
X_3050_ VDD VDD VSS VSS _4579_/A _6259_/Q gf180mcu_as_sc_mcu7t3v3__inv_2
XTAP_TAPCELL_ROW_113_2_3018 VDD VSS gf180mcu_as_sc_mcu7t3v3__tap_2
XFILLER_222_37 VDD VDD VSS VSS gf180mcu_as_sc_mcu7t3v3__fillcap_16
XFILLER_149_504 VDD VDD VSS VSS gf180mcu_as_sc_mcu7t3v3__fillcap_4
XFILLER_182_1151 VDD VDD VSS VSS gf180mcu_as_sc_mcu7t3v3__fillcap_4
XPHY_EDGE_ROW_50_1_Left_278 VDD VSS gf180mcu_as_sc_mcu7t3v3__tap_2
X_3952_ VDD VDD VSS VSS _3952_/D _4043_/A _4033_/B _3962_/C _6055_/D gf180mcu_as_sc_mcu7t3v3__ao31_2
XFILLER_182_1173 VDD VDD VSS VSS gf180mcu_as_sc_mcu7t3v3__fillcap_16
XFILLER_188_172 VDD VDD VSS VSS gf180mcu_as_sc_mcu7t3v3__fill_2
XFILLER_189_684 VDD VDD VSS VSS gf180mcu_as_sc_mcu7t3v3__fill_1
XFILLER_220_931 VDD VDD VSS VSS gf180mcu_as_sc_mcu7t3v3__fillcap_8
X_3883_ VDD VDD VSS VSS _3884_/D _3911_/B _5866_/A gf180mcu_as_sc_mcu7t3v3__nand2b_2
X_5622_ VDD VDD VSS VSS _5622_/B _5643_/A _6444_/D gf180mcu_as_sc_mcu7t3v3__and2_2
XFILLER_164_518 VDD VDD VSS VSS gf180mcu_as_sc_mcu7t3v3__fillcap_4
XFILLER_223_1170 VDD VDD VSS VSS gf180mcu_as_sc_mcu7t3v3__fillcap_16
XFILLER_223_1192 VDD VDD VSS VSS gf180mcu_as_sc_mcu7t3v3__fillcap_16
X_5553_ VDD VDD VSS VSS _5857_/A _5640_/C _5553_/C _5553_/D _5554_/B gf180mcu_as_sc_mcu7t3v3__ao211_2
X_4504_ VDD VDD VSS VSS _4504_/D _4504_/A _4504_/B _4504_/C _6287_/D gf180mcu_as_sc_mcu7t3v3__ao31_2
X_5484_ VDD VDD VSS VSS _5486_/B _5484_/B _5789_/A gf180mcu_as_sc_mcu7t3v3__nand2b_2
X_4435_ VDD VDD VSS VSS _6251_/Q _4442_/B _4442_/C _6250_/Q _6250_/D gf180mcu_as_sc_mcu7t3v3__ao22_2
XFILLER_116_27 VDD VDD VSS VSS gf180mcu_as_sc_mcu7t3v3__fillcap_8
XFILLER_116_49 VDD VDD VSS VSS gf180mcu_as_sc_mcu7t3v3__fill_2
XFILLER_28_1245 VDD VDD VSS VSS gf180mcu_as_sc_mcu7t3v3__fillcap_16
Xfanout504 VDD VDD VSS VSS fanout505/Y _3933_/D gf180mcu_as_sc_mcu7t3v3__buff_12
X_4366_ VDD VDD VSS VSS _4366_/A _4366_/B _4366_/C _4367_/B _4366_/D gf180mcu_as_sc_mcu7t3v3__oai211_2
XFILLER_115_1226 VDD VDD VSS VSS gf180mcu_as_sc_mcu7t3v3__fillcap_8
Xfanout526 VDD VDD VSS VSS _3936_/Y _3980_/B gf180mcu_as_sc_mcu7t3v3__buff_12
Xfanout537 VDD VDD VSS VSS _5665_/Y _5730_/B gf180mcu_as_sc_mcu7t3v3__buff_12
Xfanout548 VDD VDD VSS VSS _5190_/S _5237_/S gf180mcu_as_sc_mcu7t3v3__buff_12
X_6105_ VDD VDD VSS VSS _6506_/CLK _6105_/D _6105_/Q gf180mcu_as_sc_mcu7t3v3__dfxtp_2
X_3317_ VDD VDD VSS VSS _3364_/A _3317_/B _3317_/C _3317_/D _3317_/Y gf180mcu_as_sc_mcu7t3v3__ao22_2
Xfanout559 VDD VDD VSS VSS _4958_/B _4950_/D gf180mcu_as_sc_mcu7t3v3__buff_12
X_4297_ VDD VDD VSS VSS _6210_/D _4297_/B _4297_/A gf180mcu_as_sc_mcu7t3v3__nand2_2
X_6036_ VDD VDD VSS VSS _6520_/CLK _6036_/D _6036_/Q gf180mcu_as_sc_mcu7t3v3__dfxtp_2
X_3248_ VDD VDD VSS VSS _3326_/S _3250_/B _6301_/Q _3249_/B gf180mcu_as_sc_mcu7t3v3__mux2_2
XFILLER_132_37 VDD VDD VSS VSS gf180mcu_as_sc_mcu7t3v3__fillcap_8
X_3179_ VDD VDD VSS VSS _3179_/Y _3180_/B _3355_/B gf180mcu_as_sc_mcu7t3v3__nor2_2
XPHY_EDGE_ROW_106_3_Right_186 VDD VSS gf180mcu_as_sc_mcu7t3v3__tap_2
XFILLER_187_1084 VDD VDD VSS VSS gf180mcu_as_sc_mcu7t3v3__fillcap_16
XFILLER_203_909 VDD VDD VSS VSS gf180mcu_as_sc_mcu7t3v3__fill_1
XFILLER_74_1210 VDD VDD VSS VSS gf180mcu_as_sc_mcu7t3v3__fill_2
XFILLER_228_1081 VDD VDD VSS VSS gf180mcu_as_sc_mcu7t3v3__fill_2
XFILLER_148_6 VDD VDD VSS VSS gf180mcu_as_sc_mcu7t3v3__fillcap_8
XFILLER_161_1224 VDD VDD VSS VSS gf180mcu_as_sc_mcu7t3v3__fillcap_16
XFILLER_223_791 VDD VDD VSS VSS gf180mcu_as_sc_mcu7t3v3__fill_1
XFILLER_228_1092 VDD VDD VSS VSS gf180mcu_as_sc_mcu7t3v3__fill_1
XFILLER_195_643 VDD VDD VSS VSS gf180mcu_as_sc_mcu7t3v3__fillcap_4
XFILLER_195_676 VDD VDD VSS VSS gf180mcu_as_sc_mcu7t3v3__fill_1
XFILLER_202_1221 VDD VDD VSS VSS gf180mcu_as_sc_mcu7t3v3__fillcap_4
XTAP_TAPCELL_ROW_153_1501 VDD VSS gf180mcu_as_sc_mcu7t3v3__tap_2
Xwire949 VDD VDD VSS VSS wire949/A _5951_/A gf180mcu_as_sc_mcu7t3v3__clkbuff_12
XFILLER_183_849 VDD VDD VSS VSS gf180mcu_as_sc_mcu7t3v3__fill_2
XFILLER_6_539 VDD VDD VSS VSS gf180mcu_as_sc_mcu7t3v3__fill_1
XFILLER_151_702 VDD VDD VSS VSS gf180mcu_as_sc_mcu7t3v3__fillcap_16
XFILLER_194_1011 VDD VDD VSS VSS gf180mcu_as_sc_mcu7t3v3__fillcap_4
XFILLER_194_1033 VDD VDD VSS VSS gf180mcu_as_sc_mcu7t3v3__fillcap_16
XFILLER_159_1186 VDD VDD VSS VSS gf180mcu_as_sc_mcu7t3v3__fillcap_4
XFILLER_163_573 VDD VDD VSS VSS gf180mcu_as_sc_mcu7t3v3__fillcap_16
XFILLER_173_22 VDD VDD VSS VSS gf180mcu_as_sc_mcu7t3v3__fillcap_16
XFILLER_2_734 VDD VDD VSS VSS gf180mcu_as_sc_mcu7t3v3__fill_1
XFILLER_104_662 VDD VDD VSS VSS gf180mcu_as_sc_mcu7t3v3__fillcap_4
XFILLER_173_88 VDD VDD VSS VSS gf180mcu_as_sc_mcu7t3v3__fillcap_16
XTAP_TAPCELL_ROW_186_2088 VDD VSS gf180mcu_as_sc_mcu7t3v3__tap_2
XTAP_TAPCELL_ROW_12_1221 VDD VSS gf180mcu_as_sc_mcu7t3v3__tap_2
XTAP_TAPCELL_ROW_12_1232 VDD VSS gf180mcu_as_sc_mcu7t3v3__tap_2
XFILLER_205_202 VDD VDD VSS VSS gf180mcu_as_sc_mcu7t3v3__fillcap_8
XTAP_TAPCELL_ROW_164_1685 VDD VSS gf180mcu_as_sc_mcu7t3v3__tap_2
XTAP_TAPCELL_ROW_164_1696 VDD VSS gf180mcu_as_sc_mcu7t3v3__tap_2
XFILLER_166_1135 VDD VDD VSS VSS gf180mcu_as_sc_mcu7t3v3__fillcap_16
XFILLER_166_1157 VDD VDD VSS VSS gf180mcu_as_sc_mcu7t3v3__fillcap_16
XFILLER_159_813 VDD VDD VSS VSS gf180mcu_as_sc_mcu7t3v3__fillcap_16
XFILLER_199_960 VDD VDD VSS VSS gf180mcu_as_sc_mcu7t3v3__fillcap_16
XFILLER_205_279 VDD VDD VSS VSS gf180mcu_as_sc_mcu7t3v3__fill_1
XFILLER_199_982 VDD VDD VSS VSS gf180mcu_as_sc_mcu7t3v3__fillcap_16
XFILLER_207_1154 VDD VDD VSS VSS gf180mcu_as_sc_mcu7t3v3__fillcap_16
XFILLER_214_791 VDD VDD VSS VSS gf180mcu_as_sc_mcu7t3v3__fill_2
XFILLER_198_492 VDD VDD VSS VSS gf180mcu_as_sc_mcu7t3v3__fill_1
XFILLER_198_85 VDD VDD VSS VSS gf180mcu_as_sc_mcu7t3v3__fillcap_8
XFILLER_185_142 VDD VDD VSS VSS gf180mcu_as_sc_mcu7t3v3__fill_1
XFILLER_185_164 VDD VDD VSS VSS gf180mcu_as_sc_mcu7t3v3__fillcap_8
XPHY_EDGE_ROW_105_3_Left_810 VDD VSS gf180mcu_as_sc_mcu7t3v3__tap_2
XFILLER_182_871 VDD VDD VSS VSS gf180mcu_as_sc_mcu7t3v3__fillcap_4
XFILLER_138_1226 VDD VDD VSS VSS gf180mcu_as_sc_mcu7t3v3__fillcap_16
XFILLER_177_1264 VDD VDD VSS VSS gf180mcu_as_sc_mcu7t3v3__fill_1
XPHY_EDGE_ROW_112_1_Right_684 VDD VSS gf180mcu_as_sc_mcu7t3v3__tap_2
X_4220_ VDD VDD VSS VSS _4348_/D _4220_/B _4220_/A _4222_/B gf180mcu_as_sc_mcu7t3v3__mux2_2
XFILLER_214_1103 VDD VDD VSS VSS gf180mcu_as_sc_mcu7t3v3__fillcap_16
X_4151_ VDD VDD VSS VSS _6308_/Q _6163_/Q _4152_/C gf180mcu_as_sc_mcu7t3v3__and2_2
X_4082_ VDD VDD VSS VSS _4085_/S _6719_/A _6142_/Q _6142_/D gf180mcu_as_sc_mcu7t3v3__mux2_2
X_3102_ VDD VDD VSS VSS _4102_/A _4456_/A _3433_/B gf180mcu_as_sc_mcu7t3v3__nand2_2
XFILLER_97_1210 VDD VDD VSS VSS gf180mcu_as_sc_mcu7t3v3__fill_2
X_3033_ VDD VDD VSS VSS _3620_/B _5916_/A gf180mcu_as_sc_mcu7t3v3__inv_2
XFILLER_184_1235 VDD VDD VSS VSS gf180mcu_as_sc_mcu7t3v3__fillcap_4
XFILLER_58_1238 VDD VDD VSS VSS gf180mcu_as_sc_mcu7t3v3__fillcap_4
X_4984_ VDD VDD VSS VSS _4984_/A _5346_/C _4984_/C _4995_/B gf180mcu_as_sc_mcu7t3v3__nor3_2
XFILLER_189_481 VDD VDD VSS VSS gf180mcu_as_sc_mcu7t3v3__fillcap_8
X_3935_ VDD VDD VSS VSS _6486_/Q _5958_/A _5963_/A _3935_/Y gf180mcu_as_sc_mcu7t3v3__nor3_2
XFILLER_177_632 VDD VDD VSS VSS gf180mcu_as_sc_mcu7t3v3__fillcap_4
XFILLER_189_492 VDD VDD VSS VSS gf180mcu_as_sc_mcu7t3v3__fill_2
XPHY_EDGE_ROW_37_3_Left_742 VDD VSS gf180mcu_as_sc_mcu7t3v3__tap_2
X_5605_ VDD VDD VSS VSS _5914_/D _5640_/B _5605_/C _5605_/D _5606_/C gf180mcu_as_sc_mcu7t3v3__ao211_2
X_3866_ VDD VDD VSS VSS _6037_/Q _3904_/B _4051_/B _3904_/D _6037_/D gf180mcu_as_sc_mcu7t3v3__ao22_2
XFILLER_178_1017 VDD VDD VSS VSS gf180mcu_as_sc_mcu7t3v3__fillcap_16
X_3797_ VDD VDD VSS VSS _3808_/B _5793_/A _3798_/D gf180mcu_as_sc_mcu7t3v3__and2_2
X_5536_ VDD VDD VSS VSS _5841_/A _5536_/B _5536_/C _5538_/B _5537_/B gf180mcu_as_sc_mcu7t3v3__ao211_2
XFILLER_160_521 VDD VDD VSS VSS gf180mcu_as_sc_mcu7t3v3__fillcap_4
XFILLER_219_1014 VDD VDD VSS VSS gf180mcu_as_sc_mcu7t3v3__fillcap_16
X_5467_ VDD VDD VSS VSS _5775_/A _5563_/B _5563_/C _5774_/B _5468_/C gf180mcu_as_sc_mcu7t3v3__ao22_2
X_4418_ VDD VDD VSS VSS _6234_/Q _4422_/B _4425_/C _6233_/Q _6233_/D gf180mcu_as_sc_mcu7t3v3__ao22_2
XFILLER_8_1103 VDD VDD VSS VSS gf180mcu_as_sc_mcu7t3v3__fillcap_16
XFILLER_99_660 VDD VDD VSS VSS gf180mcu_as_sc_mcu7t3v3__fill_2
X_5398_ VDD VDD VSS VSS _6497_/Q _5490_/B _5491_/B _5708_/A _5399_/C gf180mcu_as_sc_mcu7t3v3__ao22_2
XFILLER_101_632 VDD VDD VSS VSS gf180mcu_as_sc_mcu7t3v3__fill_2
XFILLER_219_305 VDD VDD VSS VSS gf180mcu_as_sc_mcu7t3v3__fill_1
X_4349_ VDD VDD VSS VSS _4349_/S _6060_/Q _6089_/Q _4352_/B gf180mcu_as_sc_mcu7t3v3__mux2_2
X_6019_ VDD VDD VSS VSS _6371_/CLK _6019_/D _6019_/Q gf180mcu_as_sc_mcu7t3v3__dfxtp_2
XTAP_TAPCELL_ROW_9_1175 VDD VSS gf180mcu_as_sc_mcu7t3v3__tap_2
XFILLER_228_883 VDD VDD VSS VSS gf180mcu_as_sc_mcu7t3v3__fill_1
XFILLER_36_45 VDD VDD VSS VSS gf180mcu_as_sc_mcu7t3v3__fillcap_4
XFILLER_15_627 VDD VDD VSS VSS gf180mcu_as_sc_mcu7t3v3__fill_2
XFILLER_199_212 VDD VDD VSS VSS gf180mcu_as_sc_mcu7t3v3__fillcap_8
XPHY_EDGE_ROW_107_3_Right_187 VDD VSS gf180mcu_as_sc_mcu7t3v3__tap_2
XFILLER_168_621 VDD VDD VSS VSS gf180mcu_as_sc_mcu7t3v3__fill_2
XFILLER_30_608 VDD VDD VSS VSS gf180mcu_as_sc_mcu7t3v3__fillcap_16
XFILLER_167_120 VDD VDD VSS VSS gf180mcu_as_sc_mcu7t3v3__fillcap_16
XFILLER_196_963 VDD VDD VSS VSS gf180mcu_as_sc_mcu7t3v3__fillcap_16
XFILLER_211_772 VDD VDD VSS VSS gf180mcu_as_sc_mcu7t3v3__fillcap_4
XFILLER_52_44 VDD VDD VSS VSS gf180mcu_as_sc_mcu7t3v3__fillcap_4
XFILLER_167_142 VDD VDD VSS VSS gf180mcu_as_sc_mcu7t3v3__fillcap_16
XFILLER_7_837 VDD VDD VSS VSS gf180mcu_as_sc_mcu7t3v3__fill_2
XPHY_EDGE_ROW_28_2_Left_469 VDD VSS gf180mcu_as_sc_mcu7t3v3__tap_2
XFILLER_10_387 VDD VDD VSS VSS gf180mcu_as_sc_mcu7t3v3__fill_2
XTAP_TAPCELL_ROW_188_2128 VDD VSS gf180mcu_as_sc_mcu7t3v3__tap_2
XTAP_TAPCELL_ROW_188_2117 VDD VSS gf180mcu_as_sc_mcu7t3v3__tap_2
XFILLER_163_381 VDD VDD VSS VSS gf180mcu_as_sc_mcu7t3v3__fillcap_4
XFILLER_97_619 VDD VDD VSS VSS gf180mcu_as_sc_mcu7t3v3__fill_2
XFILLER_2_597 VDD VDD VSS VSS gf180mcu_as_sc_mcu7t3v3__fillcap_4
XTAP_TAPCELL_ROW_166_1725 VDD VSS gf180mcu_as_sc_mcu7t3v3__tap_2
XTAP_TAPCELL_ROW_166_1736 VDD VSS gf180mcu_as_sc_mcu7t3v3__tap_2
XFILLER_219_861 VDD VDD VSS VSS gf180mcu_as_sc_mcu7t3v3__fill_2
XPHY_EDGE_ROW_142_2_Left_583 VDD VSS gf180mcu_as_sc_mcu7t3v3__tap_2
Xfanout890 VDD VDD VSS VSS fanout894/Y _4362_/D gf180mcu_as_sc_mcu7t3v3__buff_12
XTAP_TAPCELL_ROW_207_2467 VDD VSS gf180mcu_as_sc_mcu7t3v3__tap_2
XFILLER_206_522 VDD VDD VSS VSS gf180mcu_as_sc_mcu7t3v3__fill_2
XTAP_TAPCELL_ROW_224_2770 VDD VSS gf180mcu_as_sc_mcu7t3v3__tap_2
XTAP_TAPCELL_ROW_224_2781 VDD VSS gf180mcu_as_sc_mcu7t3v3__tap_2
XFILLER_21_619 VDD VDD VSS VSS gf180mcu_as_sc_mcu7t3v3__fillcap_4
XTAP_TAPCELL_ROW_114_1_1378 VDD VSS gf180mcu_as_sc_mcu7t3v3__tap_2
XTAP_TAPCELL_ROW_18_2_2875 VDD VSS gf180mcu_as_sc_mcu7t3v3__tap_2
X_3720_ VDD VDD VSS VSS _3930_/B _5727_/A _3721_/D gf180mcu_as_sc_mcu7t3v3__and2_2
XFILLER_105_1214 VDD VDD VSS VSS gf180mcu_as_sc_mcu7t3v3__fill_1
XFILLER_14_1119 VDD VDD VSS VSS gf180mcu_as_sc_mcu7t3v3__fillcap_16
XFILLER_186_473 VDD VDD VSS VSS gf180mcu_as_sc_mcu7t3v3__fillcap_16
XFILLER_201_282 VDD VDD VSS VSS gf180mcu_as_sc_mcu7t3v3__fill_2
XFILLER_220_1151 VDD VDD VSS VSS gf180mcu_as_sc_mcu7t3v3__fillcap_4
X_3651_ VDD VDD VSS VSS _3651_/B _3651_/A _3651_/Y gf180mcu_as_sc_mcu7t3v3__and2_2
XFILLER_220_1173 VDD VDD VSS VSS gf180mcu_as_sc_mcu7t3v3__fillcap_16
XFILLER_228_36 VDD VDD VSS VSS gf180mcu_as_sc_mcu7t3v3__fillcap_4
X_6370_ VDD VDD VSS VSS _6370_/CLK _6370_/D _6370_/Q gf180mcu_as_sc_mcu7t3v3__dfxtp_2
X_3582_ VDD VDD VSS VSS _5329_/A _5930_/D _5329_/C _3582_/D _5331_/A gf180mcu_as_sc_mcu7t3v3__ao211_2
X_5321_ VDD VDD VSS VSS _5664_/A _5321_/B _5321_/A gf180mcu_as_sc_mcu7t3v3__nor2_2
XFILLER_170_874 VDD VDD VSS VSS gf180mcu_as_sc_mcu7t3v3__fill_1
XPHY_EDGE_ROW_113_1_Right_685 VDD VSS gf180mcu_as_sc_mcu7t3v3__tap_2
X_5252_ VDD VDD VSS VSS _5302_/C _5263_/B _5252_/A gf180mcu_as_sc_mcu7t3v3__nor2b_2
X_5183_ VDD VDD VSS VSS _5183_/B _5840_/A _5184_/C gf180mcu_as_sc_mcu7t3v3__and2_2
X_4203_ VDD VDD VSS VSS _4204_/C _4203_/C _4203_/B _4366_/D gf180mcu_as_sc_mcu7t3v3__aoi21_2
XFILLER_151_1234 VDD VDD VSS VSS gf180mcu_as_sc_mcu7t3v3__fillcap_16
X_4134_ VDD VDD VSS VSS _4135_/S _6184_/Q _6183_/Q _6183_/D gf180mcu_as_sc_mcu7t3v3__mux2_2
X_4065_ VDD VDD VSS VSS _5963_/B _6487_/Q _6014_/C gf180mcu_as_sc_mcu7t3v3__and2_2
X_3016_ VDD VDD VSS VSS _4977_/C _3573_/A gf180mcu_as_sc_mcu7t3v3__inv_2
XFILLER_149_1174 VDD VDD VSS VSS gf180mcu_as_sc_mcu7t3v3__fillcap_16
XTAP_TAPCELL_ROW_4_1094 VDD VSS gf180mcu_as_sc_mcu7t3v3__tap_2
XTAP_TAPCELL_ROW_4_1083 VDD VSS gf180mcu_as_sc_mcu7t3v3__tap_2
XFILLER_184_1065 VDD VDD VSS VSS gf180mcu_as_sc_mcu7t3v3__fillcap_16
XFILLER_184_1087 VDD VDD VSS VSS gf180mcu_as_sc_mcu7t3v3__fillcap_16
XFILLER_196_226 VDD VDD VSS VSS gf180mcu_as_sc_mcu7t3v3__fill_1
XFILLER_149_120 VDD VDD VSS VSS gf180mcu_as_sc_mcu7t3v3__fillcap_16
X_4967_ VDD VDD VSS VSS _6376_/D _5957_/C _4967_/B _4967_/A gf180mcu_as_sc_mcu7t3v3__aoi21b_2
XFILLER_225_1084 VDD VDD VSS VSS gf180mcu_as_sc_mcu7t3v3__fillcap_16
X_4898_ VDD VDD VSS VSS _5889_/A _4924_/B _4963_/B _5889_/D _4899_/D gf180mcu_as_sc_mcu7t3v3__ao22_2
X_3918_ VDD VDD VSS VSS _5896_/A _3926_/B _3918_/C _3918_/D _3920_/C gf180mcu_as_sc_mcu7t3v3__ao211_2
XFILLER_149_197 VDD VDD VSS VSS gf180mcu_as_sc_mcu7t3v3__fillcap_4
XFILLER_164_101 VDD VDD VSS VSS gf180mcu_as_sc_mcu7t3v3__fillcap_4
XFILLER_164_123 VDD VDD VSS VSS gf180mcu_as_sc_mcu7t3v3__fillcap_16
XFILLER_193_944 VDD VDD VSS VSS gf180mcu_as_sc_mcu7t3v3__fillcap_8
X_3849_ VDD VDD VSS VSS _3849_/B _5842_/A _3856_/C gf180mcu_as_sc_mcu7t3v3__and2_2
XFILLER_192_454 VDD VDD VSS VSS gf180mcu_as_sc_mcu7t3v3__fill_1
XFILLER_193_977 VDD VDD VSS VSS gf180mcu_as_sc_mcu7t3v3__fill_2
XFILLER_98_29 VDD VDD VSS VSS gf180mcu_as_sc_mcu7t3v3__fillcap_4
XPHY_EDGE_ROW_138_1_Left_366 VDD VSS gf180mcu_as_sc_mcu7t3v3__tap_2
X_5519_ VDD VDD VSS VSS _5827_/A _5584_/B _5568_/C _5826_/A _5520_/B gf180mcu_as_sc_mcu7t3v3__ao22_2
XFILLER_191_1014 VDD VDD VSS VSS gf180mcu_as_sc_mcu7t3v3__fillcap_16
X_6499_ VDD VDD VSS VSS _6517_/CLK _6499_/D _6499_/Q gf180mcu_as_sc_mcu7t3v3__dfxtp_2
Xoutput471 VDD VDD VSS VSS _6473_/Q west_out[24] gf180mcu_as_sc_mcu7t3v3__buff_12
Xoutput460 VDD VDD VSS VSS _6463_/Q west_out[14] gf180mcu_as_sc_mcu7t3v3__buff_12
XFILLER_156_1189 VDD VDD VSS VSS gf180mcu_as_sc_mcu7t3v3__fillcap_16
XFILLER_160_384 VDD VDD VSS VSS gf180mcu_as_sc_mcu7t3v3__fill_1
XPHY_EDGE_ROW_75_1_Left_303 VDD VSS gf180mcu_as_sc_mcu7t3v3__tap_2
Xoutput482 VDD VDD VSS VSS _6483_/Q west_out[34] gf180mcu_as_sc_mcu7t3v3__buff_12
XTAP_TAPCELL_ROW_183_2036 VDD VSS gf180mcu_as_sc_mcu7t3v3__tap_2
XFILLER_170_34 VDD VDD VSS VSS gf180mcu_as_sc_mcu7t3v3__fill_1
XTAP_TAPCELL_ROW_161_1633 VDD VSS gf180mcu_as_sc_mcu7t3v3__tap_2
XTAP_TAPCELL_ROW_161_1644 VDD VSS gf180mcu_as_sc_mcu7t3v3__tap_2
XFILLER_16_936 VDD VDD VSS VSS gf180mcu_as_sc_mcu7t3v3__fillcap_16
XFILLER_216_886 VDD VDD VSS VSS gf180mcu_as_sc_mcu7t3v3__fill_1
XFILLER_15_446 VDD VDD VSS VSS gf180mcu_as_sc_mcu7t3v3__fill_2
XFILLER_163_1116 VDD VDD VSS VSS gf180mcu_as_sc_mcu7t3v3__fillcap_4
XFILLER_163_1138 VDD VDD VSS VSS gf180mcu_as_sc_mcu7t3v3__fillcap_16
XPHY_EDGE_ROW_108_3_Right_188 VDD VSS gf180mcu_as_sc_mcu7t3v3__tap_2
XTAP_TAPCELL_ROW_202_2386 VDD VSS gf180mcu_as_sc_mcu7t3v3__tap_2
XTAP_TAPCELL_ROW_202_2375 VDD VSS gf180mcu_as_sc_mcu7t3v3__tap_2
XFILLER_204_1135 VDD VDD VSS VSS gf180mcu_as_sc_mcu7t3v3__fillcap_16
XFILLER_8_27 VDD VDD VSS VSS gf180mcu_as_sc_mcu7t3v3__fillcap_8
XFILLER_168_473 VDD VDD VSS VSS gf180mcu_as_sc_mcu7t3v3__fill_2
XFILLER_183_410 VDD VDD VSS VSS gf180mcu_as_sc_mcu7t3v3__fill_2
XFILLER_204_1157 VDD VDD VSS VSS gf180mcu_as_sc_mcu7t3v3__fillcap_16
XTAP_TAPCELL_ROW_159_1595 VDD VSS gf180mcu_as_sc_mcu7t3v3__tap_2
Xwire510 VDD VDD VSS VSS _3332_/Y wire510/Y gf180mcu_as_sc_mcu7t3v3__clkbuff_12
XFILLER_156_679 VDD VDD VSS VSS gf180mcu_as_sc_mcu7t3v3__fillcap_16
XFILLER_6_155 VDD VDD VSS VSS gf180mcu_as_sc_mcu7t3v3__fillcap_16
XFILLER_6_177 VDD VDD VSS VSS gf180mcu_as_sc_mcu7t3v3__fillcap_16
XFILLER_7_678 VDD VDD VSS VSS gf180mcu_as_sc_mcu7t3v3__fill_1
XFILLER_124_598 VDD VDD VSS VSS gf180mcu_as_sc_mcu7t3v3__fill_2
XTAP_TAPCELL_ROW_209_2507 VDD VSS gf180mcu_as_sc_mcu7t3v3__tap_2
XFILLER_214_27 VDD VDD VSS VSS gf180mcu_as_sc_mcu7t3v3__fillcap_8
XFILLER_215_1264 VDD VDD VSS VSS gf180mcu_as_sc_mcu7t3v3__fill_1
XFILLER_78_641 VDD VDD VSS VSS gf180mcu_as_sc_mcu7t3v3__fill_1
XTAP_TAPCELL_ROW_226_2810 VDD VSS gf180mcu_as_sc_mcu7t3v3__tap_2
XFILLER_93_666 VDD VDD VSS VSS gf180mcu_as_sc_mcu7t3v3__fill_1
XTAP_TAPCELL_ROW_222_2729 VDD VSS gf180mcu_as_sc_mcu7t3v3__tap_2
XFILLER_0_1217 VDD VDD VSS VSS gf180mcu_as_sc_mcu7t3v3__fillcap_4
XFILLER_168_1049 VDD VDD VSS VSS gf180mcu_as_sc_mcu7t3v3__fillcap_16
XFILLER_207_875 VDD VDD VSS VSS gf180mcu_as_sc_mcu7t3v3__fillcap_16
X_5870_ VDD VDD VSS VSS _5878_/S _5870_/B _6517_/Q _5871_/C gf180mcu_as_sc_mcu7t3v3__mux2_2
XFILLER_206_396 VDD VDD VSS VSS gf180mcu_as_sc_mcu7t3v3__fillcap_8
XFILLER_209_1046 VDD VDD VSS VSS gf180mcu_as_sc_mcu7t3v3__fillcap_4
XFILLER_222_823 VDD VDD VSS VSS gf180mcu_as_sc_mcu7t3v3__fill_1
X_4821_ VDD VDD VSS VSS _5168_/A _4888_/B _4821_/C _4822_/D _4953_/B gf180mcu_as_sc_mcu7t3v3__aoi211_2
XFILLER_209_1068 VDD VDD VSS VSS gf180mcu_as_sc_mcu7t3v3__fillcap_16
XPHY_EDGE_ROW_1_Left_230 VDD VSS gf180mcu_as_sc_mcu7t3v3__tap_2
XFILLER_147_602 VDD VDD VSS VSS gf180mcu_as_sc_mcu7t3v3__fillcap_4
X_4752_ VDD VDD VSS VSS _4752_/B _4826_/A _6351_/D gf180mcu_as_sc_mcu7t3v3__and2_2
XFILLER_175_944 VDD VDD VSS VSS gf180mcu_as_sc_mcu7t3v3__fillcap_4
XFILLER_186_270 VDD VDD VSS VSS gf180mcu_as_sc_mcu7t3v3__fillcap_8
X_4683_ VDD VDD VSS VSS _4794_/S _4683_/B _6496_/Q _4685_/C gf180mcu_as_sc_mcu7t3v3__mux2_2
X_3703_ VDD VDD VSS VSS _3809_/B _5711_/A _3703_/A _3704_/C gf180mcu_as_sc_mcu7t3v3__mux2_2
XTAP_TAPCELL_ROW_48_1_1345 VDD VSS gf180mcu_as_sc_mcu7t3v3__tap_2
XFILLER_174_454 VDD VDD VSS VSS gf180mcu_as_sc_mcu7t3v3__fill_1
X_6422_ VDD VDD VSS VSS _6422_/CLK _6422_/D _6422_/Q gf180mcu_as_sc_mcu7t3v3__dfxtp_2
X_3634_ VDD VDD VSS VSS _5319_/A _5926_/A _3634_/C _3635_/B _5320_/C gf180mcu_as_sc_mcu7t3v3__aoi211_2
XFILLER_161_104 VDD VDD VSS VSS gf180mcu_as_sc_mcu7t3v3__fillcap_16
XFILLER_190_947 VDD VDD VSS VSS gf180mcu_as_sc_mcu7t3v3__fillcap_4
XFILLER_155_690 VDD VDD VSS VSS gf180mcu_as_sc_mcu7t3v3__fillcap_8
XTAP_TAPCELL_ROW_119_2_3027 VDD VSS gf180mcu_as_sc_mcu7t3v3__tap_2
X_6353_ VDD VDD VSS VSS _6526_/CLK _6353_/D _6353_/Q gf180mcu_as_sc_mcu7t3v3__dfxtp_2
X_3565_ VDD VDD VSS VSS _4619_/B _4619_/A _3573_/C gf180mcu_as_sc_mcu7t3v3__and2_2
XFILLER_216_1017 VDD VDD VSS VSS gf180mcu_as_sc_mcu7t3v3__fillcap_16
X_6284_ VDD VDD VSS VSS clkload5/A _6284_/D _6284_/Q gf180mcu_as_sc_mcu7t3v3__dfxtp_2
X_5304_ VDD VDD VSS VSS _5946_/A _5304_/B _5314_/S _5946_/D _5305_/D gf180mcu_as_sc_mcu7t3v3__ao22_2
X_3496_ VDD VDD VSS VSS _5340_/C _3631_/A _5919_/A _5928_/A _3631_/D gf180mcu_as_sc_mcu7t3v3__aoi22_2
XPHY_EDGE_ROW_114_1_Right_686 VDD VSS gf180mcu_as_sc_mcu7t3v3__tap_2
XPHY_EDGE_ROW_90_2_Right_927 VDD VSS gf180mcu_as_sc_mcu7t3v3__tap_2
X_5235_ VDD VDD VSS VSS _5881_/A _5315_/B _5314_/S _5881_/D _5236_/D gf180mcu_as_sc_mcu7t3v3__ao22_2
XFILLER_124_27 VDD VDD VSS VSS gf180mcu_as_sc_mcu7t3v3__fillcap_8
XFILLER_9_1264 VDD VDD VSS VSS gf180mcu_as_sc_mcu7t3v3__fill_1
XFILLER_124_49 VDD VDD VSS VSS gf180mcu_as_sc_mcu7t3v3__fill_2
X_5166_ VDD VDD VSS VSS _5166_/D _5824_/A _5294_/A _5222_/C _5167_/C gf180mcu_as_sc_mcu7t3v3__ao31_2
XFILLER_217_628 VDD VDD VSS VSS gf180mcu_as_sc_mcu7t3v3__fill_2
X_5097_ VDD VDD VSS VSS _5760_/A _5207_/B _5207_/C _5756_/A _5098_/D gf180mcu_as_sc_mcu7t3v3__ao22_2
X_4117_ VDD VDD VSS VSS _4144_/S _6167_/Q _6166_/Q _6166_/D gf180mcu_as_sc_mcu7t3v3__mux2_2
XTAP_TAPCELL_ROW_6_1123 VDD VSS gf180mcu_as_sc_mcu7t3v3__tap_2
XFILLER_204_93 VDD VDD VSS VSS gf180mcu_as_sc_mcu7t3v3__fill_2
X_4048_ VDD VDD VSS VSS _4060_/B _6123_/Q _4049_/D gf180mcu_as_sc_mcu7t3v3__and2_2
XFILLER_140_37 VDD VDD VSS VSS gf180mcu_as_sc_mcu7t3v3__fillcap_8
XFILLER_13_906 VDD VDD VSS VSS gf180mcu_as_sc_mcu7t3v3__fillcap_4
XTAP_TAPCELL_ROW_20_1_1331 VDD VSS gf180mcu_as_sc_mcu7t3v3__tap_2
XFILLER_13_928 VDD VDD VSS VSS gf180mcu_as_sc_mcu7t3v3__fillcap_16
XFILLER_169_226 VDD VDD VSS VSS gf180mcu_as_sc_mcu7t3v3__fillcap_8
XFILLER_197_546 VDD VDD VSS VSS gf180mcu_as_sc_mcu7t3v3__fillcap_8
XFILLER_212_344 VDD VDD VSS VSS gf180mcu_as_sc_mcu7t3v3__fillcap_8
X_5999_ VDD VDD VSS VSS _6006_/B _6222_/Q _6512_/D gf180mcu_as_sc_mcu7t3v3__and2_2
XFILLER_12_438 VDD VDD VSS VSS gf180mcu_as_sc_mcu7t3v3__fillcap_8
XFILLER_200_517 VDD VDD VSS VSS gf180mcu_as_sc_mcu7t3v3__fill_1
XFILLER_166_944 VDD VDD VSS VSS gf180mcu_as_sc_mcu7t3v3__fill_1
XFILLER_178_793 VDD VDD VSS VSS gf180mcu_as_sc_mcu7t3v3__fill_1
XFILLER_228_6 VDD VDD VSS VSS gf180mcu_as_sc_mcu7t3v3__fill_2
XFILLER_197_1234 VDD VDD VSS VSS gf180mcu_as_sc_mcu7t3v3__fill_1
XFILLER_153_616 VDD VDD VSS VSS gf180mcu_as_sc_mcu7t3v3__fill_1
XFILLER_165_23 VDD VDD VSS VSS gf180mcu_as_sc_mcu7t3v3__fill_1
XFILLER_0_843 VDD VDD VSS VSS gf180mcu_as_sc_mcu7t3v3__fillcap_4
Xwire1021 VDD VDD VSS VSS wire1021/A _5714_/A gf180mcu_as_sc_mcu7t3v3__clkbuff_12
XTAP_TAPCELL_ROW_204_2415 VDD VSS gf180mcu_as_sc_mcu7t3v3__tap_2
XFILLER_207_127 VDD VDD VSS VSS gf180mcu_as_sc_mcu7t3v3__fill_1
XFILLER_75_666 VDD VDD VSS VSS gf180mcu_as_sc_mcu7t3v3__fill_1
XFILLER_188_524 VDD VDD VSS VSS gf180mcu_as_sc_mcu7t3v3__fill_1
XPHY_EDGE_ROW_109_3_Right_189 VDD VSS gf180mcu_as_sc_mcu7t3v3__tap_2
XFILLER_15_298 VDD VDD VSS VSS gf180mcu_as_sc_mcu7t3v3__fillcap_16
XFILLER_175_207 VDD VDD VSS VSS gf180mcu_as_sc_mcu7t3v3__fill_2
XFILLER_204_889 VDD VDD VSS VSS gf180mcu_as_sc_mcu7t3v3__fill_1
XFILLER_157_933 VDD VDD VSS VSS gf180mcu_as_sc_mcu7t3v3__fillcap_16
XTAP_TAPCELL_ROW_219_2680 VDD VSS gf180mcu_as_sc_mcu7t3v3__tap_2
XFILLER_156_454 VDD VDD VSS VSS gf180mcu_as_sc_mcu7t3v3__fill_1
XFILLER_157_977 VDD VDD VSS VSS gf180mcu_as_sc_mcu7t3v3__fill_2
XFILLER_209_27 VDD VDD VSS VSS gf180mcu_as_sc_mcu7t3v3__fillcap_16
XTAP_TAPCELL_ROW_174_1868 VDD VSS gf180mcu_as_sc_mcu7t3v3__tap_2
XTAP_TAPCELL_ROW_219_2691 VDD VSS gf180mcu_as_sc_mcu7t3v3__tap_2
XFILLER_171_413 VDD VDD VSS VSS gf180mcu_as_sc_mcu7t3v3__fillcap_4
XTAP_TAPCELL_ROW_174_1879 VDD VSS gf180mcu_as_sc_mcu7t3v3__tap_2
XFILLER_7_486 VDD VDD VSS VSS gf180mcu_as_sc_mcu7t3v3__fillcap_4
X_3350_ VDD VDD VSS VSS _3357_/S _6539_/Q _6548_/Q _3351_/B gf180mcu_as_sc_mcu7t3v3__mux2_2
XFILLER_61_1212 VDD VDD VSS VSS gf180mcu_as_sc_mcu7t3v3__fill_1
X_5020_ VDD VDD VSS VSS _5022_/C _5689_/A _5140_/B _5020_/C gf180mcu_as_sc_mcu7t3v3__ao21_2
X_3281_ VDD VDD VSS VSS _6304_/Q _3281_/B _3281_/C _3281_/D _3285_/B gf180mcu_as_sc_mcu7t3v3__ao22_2
XPHY_EDGE_ROW_46_3_Left_751 VDD VSS gf180mcu_as_sc_mcu7t3v3__tap_2
XFILLER_214_609 VDD VDD VSS VSS gf180mcu_as_sc_mcu7t3v3__fill_2
XFILLER_206_171 VDD VDD VSS VSS gf180mcu_as_sc_mcu7t3v3__fillcap_4
XPHY_EDGE_ROW_105_2_Left_546 VDD VSS gf180mcu_as_sc_mcu7t3v3__tap_2
X_5922_ VDD VDD VSS VSS _5922_/A _5922_/B _5922_/C _5922_/D _5923_/D gf180mcu_as_sc_mcu7t3v3__ao211_2
XTAP_TAPCELL_ROW_1_1031 VDD VSS gf180mcu_as_sc_mcu7t3v3__tap_2
XFILLER_206_193 VDD VDD VSS VSS gf180mcu_as_sc_mcu7t3v3__fillcap_4
XFILLER_210_804 VDD VDD VSS VSS gf180mcu_as_sc_mcu7t3v3__fill_1
X_5853_ VDD VDD VSS VSS _5853_/B _5853_/A _5856_/C gf180mcu_as_sc_mcu7t3v3__and2_2
XFILLER_10_909 VDD VDD VSS VSS gf180mcu_as_sc_mcu7t3v3__fillcap_16
XFILLER_181_1046 VDD VDD VSS VSS gf180mcu_as_sc_mcu7t3v3__fillcap_4
XFILLER_181_1068 VDD VDD VSS VSS gf180mcu_as_sc_mcu7t3v3__fillcap_16
X_5784_ VDD VDD VSS VSS _5784_/A _5842_/C _5784_/C _5784_/D _5785_/C gf180mcu_as_sc_mcu7t3v3__ao211_2
X_4804_ VDD VDD VSS VSS _6509_/Q _4851_/B _4804_/C _4804_/D _4805_/D gf180mcu_as_sc_mcu7t3v3__ao22_2
XFILLER_194_527 VDD VDD VSS VSS gf180mcu_as_sc_mcu7t3v3__fillcap_8
X_4735_ VDD VDD VSS VSS _5750_/A _4774_/C _4932_/A _5748_/A _4736_/B gf180mcu_as_sc_mcu7t3v3__ao22_2
XFILLER_119_27 VDD VDD VSS VSS gf180mcu_as_sc_mcu7t3v3__fillcap_16
XFILLER_222_1065 VDD VDD VSS VSS gf180mcu_as_sc_mcu7t3v3__fillcap_16
XFILLER_174_251 VDD VDD VSS VSS gf180mcu_as_sc_mcu7t3v3__fill_2
XFILLER_222_1087 VDD VDD VSS VSS gf180mcu_as_sc_mcu7t3v3__fillcap_16
X_4666_ VDD VDD VSS VSS _6494_/Q _4841_/B _4795_/C _5685_/D _4667_/C gf180mcu_as_sc_mcu7t3v3__ao22_2
XFILLER_135_638 VDD VDD VSS VSS gf180mcu_as_sc_mcu7t3v3__fill_2
X_6405_ VDD VDD VSS VSS _6412_/CLK _6405_/D _6405_/Q gf180mcu_as_sc_mcu7t3v3__dfxtp_2
Xclkbuf_leaf_3_clk_regs VDD VDD VSS VSS clkbuf_3_1_0_clk_regs/Y clkload5/A gf180mcu_as_sc_mcu7t3v3__clkbuff_12
X_4597_ VDD VDD VSS VSS _4597_/B _6336_/Q _4598_/C gf180mcu_as_sc_mcu7t3v3__xnor2_2
X_3617_ VDD VDD VSS VSS _3653_/A _3653_/B _3654_/A _3617_/D _3650_/B gf180mcu_as_sc_mcu7t3v3__ao211_2
XFILLER_157_1240 VDD VDD VSS VSS gf180mcu_as_sc_mcu7t3v3__fillcap_16
XFILLER_162_457 VDD VDD VSS VSS gf180mcu_as_sc_mcu7t3v3__fill_1
X_6336_ VDD VDD VSS VSS clkload6/A _6336_/D _6336_/Q gf180mcu_as_sc_mcu7t3v3__dfxtp_2
X_3548_ VDD VDD VSS VSS _3556_/A _4248_/A _5922_/A gf180mcu_as_sc_mcu7t3v3__nand2b_2
XFILLER_157_1262 VDD VDD VSS VSS gf180mcu_as_sc_mcu7t3v3__fill_2
XPHY_EDGE_ROW_91_2_Right_928 VDD VSS gf180mcu_as_sc_mcu7t3v3__tap_2
X_6267_ VDD VDD VSS VSS clkload6/A _6267_/D _6267_/Q gf180mcu_as_sc_mcu7t3v3__dfxtp_2
X_3479_ VDD VDD VSS VSS _3483_/B _5932_/A _5340_/A gf180mcu_as_sc_mcu7t3v3__nand2b_2
XPHY_EDGE_ROW_115_1_Right_687 VDD VSS gf180mcu_as_sc_mcu7t3v3__tap_2
X_6198_ VDD VDD VSS VSS _6368_/CLK _6198_/D _6198_/Q gf180mcu_as_sc_mcu7t3v3__dfxtp_2
X_5218_ VDD VDD VSS VSS _5219_/A _5866_/A _5218_/B _5218_/C gf180mcu_as_sc_mcu7t3v3__ao21_2
X_5149_ VDD VDD VSS VSS _5151_/C _5807_/A _5242_/B _5149_/C gf180mcu_as_sc_mcu7t3v3__ao21_2
XFILLER_57_666 VDD VDD VSS VSS gf180mcu_as_sc_mcu7t3v3__fill_1
XFILLER_178_6 VDD VDD VSS VSS gf180mcu_as_sc_mcu7t3v3__fillcap_16
XPHY_EDGE_ROW_37_2_Left_478 VDD VSS gf180mcu_as_sc_mcu7t3v3__tap_2
XFILLER_204_119 VDD VDD VSS VSS gf180mcu_as_sc_mcu7t3v3__fill_2
XFILLER_44_34 VDD VDD VSS VSS gf180mcu_as_sc_mcu7t3v3__fill_1
XFILLER_44_45 VDD VDD VSS VSS gf180mcu_as_sc_mcu7t3v3__fillcap_4
XFILLER_160_1119 VDD VDD VSS VSS gf180mcu_as_sc_mcu7t3v3__fillcap_16
XTAP_TAPCELL_ROW_195_2260 VDD VSS gf180mcu_as_sc_mcu7t3v3__tap_2
XFILLER_12_279 VDD VDD VSS VSS gf180mcu_as_sc_mcu7t3v3__fillcap_16
XFILLER_166_730 VDD VDD VSS VSS gf180mcu_as_sc_mcu7t3v3__fillcap_4
XFILLER_166_752 VDD VDD VSS VSS gf180mcu_as_sc_mcu7t3v3__fillcap_8
XFILLER_201_1116 VDD VDD VSS VSS gf180mcu_as_sc_mcu7t3v3__fillcap_4
XFILLER_60_33 VDD VDD VSS VSS gf180mcu_as_sc_mcu7t3v3__fill_2
XPHY_EDGE_ROW_99_2_Left_540 VDD VSS gf180mcu_as_sc_mcu7t3v3__tap_2
XTAP_TAPCELL_ROW_156_1543 VDD VSS gf180mcu_as_sc_mcu7t3v3__tap_2
XFILLER_165_273 VDD VDD VSS VSS gf180mcu_as_sc_mcu7t3v3__fillcap_4
XFILLER_201_1138 VDD VDD VSS VSS gf180mcu_as_sc_mcu7t3v3__fillcap_16
XFILLER_219_2 VDD VDD VSS VSS gf180mcu_as_sc_mcu7t3v3__fillcap_16
XFILLER_5_902 VDD VDD VSS VSS gf180mcu_as_sc_mcu7t3v3__fillcap_8
XTAP_TAPCELL_ROW_156_1554 VDD VSS gf180mcu_as_sc_mcu7t3v3__tap_2
XTAP_TAPCELL_ROW_191_2179 VDD VSS gf180mcu_as_sc_mcu7t3v3__tap_2
XFILLER_153_424 VDD VDD VSS VSS gf180mcu_as_sc_mcu7t3v3__fill_1
XFILLER_180_232 VDD VDD VSS VSS gf180mcu_as_sc_mcu7t3v3__fill_1
XFILLER_180_243 VDD VDD VSS VSS gf180mcu_as_sc_mcu7t3v3__fill_2
XFILLER_84_1245 VDD VDD VSS VSS gf180mcu_as_sc_mcu7t3v3__fillcap_16
XFILLER_169_1100 VDD VDD VSS VSS gf180mcu_as_sc_mcu7t3v3__fillcap_16
XFILLER_169_1122 VDD VDD VSS VSS gf180mcu_as_sc_mcu7t3v3__fillcap_16
XTAP_TAPCELL_ROW_15_1285 VDD VSS gf180mcu_as_sc_mcu7t3v3__tap_2
XPHY_EDGE_ROW_207_Left_435 VDD VSS gf180mcu_as_sc_mcu7t3v3__tap_2
XFILLER_16_563 VDD VDD VSS VSS gf180mcu_as_sc_mcu7t3v3__fillcap_8
XFILLER_188_310 VDD VDD VSS VSS gf180mcu_as_sc_mcu7t3v3__fillcap_4
XFILLER_189_844 VDD VDD VSS VSS gf180mcu_as_sc_mcu7t3v3__fill_1
XFILLER_16_596 VDD VDD VSS VSS gf180mcu_as_sc_mcu7t3v3__fillcap_16
XTAP_TAPCELL_ROW_176_1908 VDD VSS gf180mcu_as_sc_mcu7t3v3__tap_2
XFILLER_176_516 VDD VDD VSS VSS gf180mcu_as_sc_mcu7t3v3__fill_2
XFILLER_203_185 VDD VDD VSS VSS gf180mcu_as_sc_mcu7t3v3__fill_2
XFILLER_206_1049 VDD VDD VSS VSS gf180mcu_as_sc_mcu7t3v3__fillcap_16
XTAP_TAPCELL_ROW_217_2639 VDD VSS gf180mcu_as_sc_mcu7t3v3__tap_2
XFILLER_117_627 VDD VDD VSS VSS gf180mcu_as_sc_mcu7t3v3__fillcap_8
XFILLER_157_796 VDD VDD VSS VSS gf180mcu_as_sc_mcu7t3v3__fillcap_4
X_4520_ VDD VDD VSS VSS _4520_/S _6720_/A _6294_/Q _4521_/A gf180mcu_as_sc_mcu7t3v3__mux2_2
XFILLER_156_295 VDD VDD VSS VSS gf180mcu_as_sc_mcu7t3v3__fillcap_16
XPHY_EDGE_ROW_216_Left_444 VDD VSS gf180mcu_as_sc_mcu7t3v3__tap_2
X_4451_ VDD VDD VSS VSS _4599_/A _6158_/Q _6261_/Q _6261_/D gf180mcu_as_sc_mcu7t3v3__mux2_2
XFILLER_125_660 VDD VDD VSS VSS gf180mcu_as_sc_mcu7t3v3__fill_2
X_3402_ VDD VDD VSS VSS _4468_/B _4571_/C _4070_/B gf180mcu_as_sc_mcu7t3v3__nor2b_2
X_6121_ VDD VDD VSS VSS _6370_/CLK _6121_/D _6121_/Q gf180mcu_as_sc_mcu7t3v3__dfxtp_2
X_4382_ VDD VDD VSS VSS _4383_/C _4398_/S _6036_/Q gf180mcu_as_sc_mcu7t3v3__nor2b_2
Xfanout708 VDD VDD VSS VSS _3190_/Y _4076_/B gf180mcu_as_sc_mcu7t3v3__buff_12
Xfanout719 VDD VDD VSS VSS _5672_/Y _5840_/B gf180mcu_as_sc_mcu7t3v3__buff_12
X_3333_ VDD VDD VSS VSS _6207_/Q _3361_/B _4098_/S _6215_/Q _3338_/B gf180mcu_as_sc_mcu7t3v3__ao22_2
XPHY_EDGE_ROW_7_Right_7 VDD VSS gf180mcu_as_sc_mcu7t3v3__tap_2
X_6052_ VDD VDD VSS VSS _6520_/CLK _6052_/D _6052_/Q gf180mcu_as_sc_mcu7t3v3__dfxtp_2
X_3264_ VDD VDD VSS VSS _3280_/B _6297_/Q _6285_/Q _3267_/B gf180mcu_as_sc_mcu7t3v3__mux2_2
X_5003_ VDD VDD VSS VSS _5003_/A _5003_/B _5003_/C _5318_/A gf180mcu_as_sc_mcu7t3v3__nor3_2
XFILLER_39_655 VDD VDD VSS VSS gf180mcu_as_sc_mcu7t3v3__fillcap_4
XFILLER_39_666 VDD VDD VSS VSS gf180mcu_as_sc_mcu7t3v3__fill_1
XPHY_EDGE_ROW_225_Left_453 VDD VSS gf180mcu_as_sc_mcu7t3v3__tap_2
X_3195_ VDD VDD VSS VSS _3196_/D _3332_/A _3294_/B input8/Y gf180mcu_as_sc_mcu7t3v3__aoi21b_2
XFILLER_226_244 VDD VDD VSS VSS gf180mcu_as_sc_mcu7t3v3__fill_1
XFILLER_198_107 VDD VDD VSS VSS gf180mcu_as_sc_mcu7t3v3__fill_1
XPHY_EDGE_ROW_147_1_Left_375 VDD VSS gf180mcu_as_sc_mcu7t3v3__tap_2
X_5905_ VDD VDD VSS VSS _5909_/B _5905_/C _5953_/C _5905_/A gf180mcu_as_sc_mcu7t3v3__aoi21_2
XFILLER_179_365 VDD VDD VSS VSS gf180mcu_as_sc_mcu7t3v3__fillcap_4
XFILLER_201_72 VDD VDD VSS VSS gf180mcu_as_sc_mcu7t3v3__fillcap_16
XFILLER_210_601 VDD VDD VSS VSS gf180mcu_as_sc_mcu7t3v3__fill_2
XFILLER_194_302 VDD VDD VSS VSS gf180mcu_as_sc_mcu7t3v3__fill_1
XPHY_EDGE_ROW_84_1_Left_312 VDD VSS gf180mcu_as_sc_mcu7t3v3__tap_2
XTAP_TAPCELL_ROW_107_2_3009 VDD VSS gf180mcu_as_sc_mcu7t3v3__tap_2
X_5836_ VDD VDD VSS VSS _5836_/B _5836_/A _6468_/D gf180mcu_as_sc_mcu7t3v3__and2_2
XFILLER_124_1261 VDD VDD VSS VSS gf180mcu_as_sc_mcu7t3v3__fillcap_4
X_5767_ VDD VDD VSS VSS _5767_/A _5864_/B _5767_/C _5767_/D _5769_/C gf180mcu_as_sc_mcu7t3v3__ao211_2
X_5698_ VDD VDD VSS VSS _5797_/B _5698_/A _5701_/C gf180mcu_as_sc_mcu7t3v3__and2_2
X_4718_ VDD VDD VSS VSS _5732_/B _4860_/B _4774_/C _5733_/A _4720_/C gf180mcu_as_sc_mcu7t3v3__ao22_2
XFILLER_146_14 VDD VDD VSS VSS gf180mcu_as_sc_mcu7t3v3__fill_1
XFILLER_163_722 VDD VDD VSS VSS gf180mcu_as_sc_mcu7t3v3__fill_2
X_4649_ VDD VDD VSS VSS _4655_/B _4999_/B _5354_/A gf180mcu_as_sc_mcu7t3v3__nand2_2
XFILLER_151_928 VDD VDD VSS VSS gf180mcu_as_sc_mcu7t3v3__fill_2
XFILLER_163_766 VDD VDD VSS VSS gf180mcu_as_sc_mcu7t3v3__fillcap_4
XFILLER_163_788 VDD VDD VSS VSS gf180mcu_as_sc_mcu7t3v3__fillcap_8
XFILLER_1_415 VDD VDD VSS VSS gf180mcu_as_sc_mcu7t3v3__fillcap_4
XTAP_TAPCELL_ROW_151_1451 VDD VSS gf180mcu_as_sc_mcu7t3v3__tap_2
XTAP_TAPCELL_ROW_151_1462 VDD VSS gf180mcu_as_sc_mcu7t3v3__tap_2
XFILLER_131_641 VDD VDD VSS VSS gf180mcu_as_sc_mcu7t3v3__fillcap_4
XFILLER_1_459 VDD VDD VSS VSS gf180mcu_as_sc_mcu7t3v3__fillcap_4
XTAP_TAPCELL_ROW_134_3_3050 VDD VSS gf180mcu_as_sc_mcu7t3v3__tap_2
X_6319_ VDD VDD VSS VSS _6551_/CLK _6319_/D _6319_/Q gf180mcu_as_sc_mcu7t3v3__dfxtp_2
XFILLER_131_1210 VDD VDD VSS VSS gf180mcu_as_sc_mcu7t3v3__fillcap_4
XPHY_EDGE_ROW_116_1_Right_688 VDD VSS gf180mcu_as_sc_mcu7t3v3__tap_2
XPHY_EDGE_ROW_92_2_Right_929 VDD VSS gf180mcu_as_sc_mcu7t3v3__tap_2
Xmesh_tile_1107 VDD VDD VSS VSS nw_out[30] gf180mcu_as_sc_mcu7t3v3__tiel_4
Xmesh_tile_1129 VDD VDD VSS VSS se_out[16] gf180mcu_as_sc_mcu7t3v3__tiel_4
Xmesh_tile_1118 VDD VDD VSS VSS se_out[5] gf180mcu_as_sc_mcu7t3v3__tiel_4
XFILLER_45_658 VDD VDD VSS VSS gf180mcu_as_sc_mcu7t3v3__fillcap_4
XTAP_TAPCELL_ROW_10_1193 VDD VSS gf180mcu_as_sc_mcu7t3v3__tap_2
XFILLER_186_803 VDD VDD VSS VSS gf180mcu_as_sc_mcu7t3v3__fill_2
XFILLER_213_450 VDD VDD VSS VSS gf180mcu_as_sc_mcu7t3v3__fill_1
XFILLER_214_995 VDD VDD VSS VSS gf180mcu_as_sc_mcu7t3v3__fillcap_16
XTAP_TAPCELL_ROW_193_2219 VDD VSS gf180mcu_as_sc_mcu7t3v3__tap_2
XTAP_TAPCELL_ROW_193_2208 VDD VSS gf180mcu_as_sc_mcu7t3v3__tap_2
XFILLER_13_577 VDD VDD VSS VSS gf180mcu_as_sc_mcu7t3v3__fill_2
XFILLER_158_516 VDD VDD VSS VSS gf180mcu_as_sc_mcu7t3v3__fillcap_8
XFILLER_158_527 VDD VDD VSS VSS gf180mcu_as_sc_mcu7t3v3__fillcap_16
XFILLER_200_111 VDD VDD VSS VSS gf180mcu_as_sc_mcu7t3v3__fill_1
XFILLER_200_177 VDD VDD VSS VSS gf180mcu_as_sc_mcu7t3v3__fill_2
XTAP_TAPCELL_ROW_171_1816 VDD VSS gf180mcu_as_sc_mcu7t3v3__tap_2
XTAP_TAPCELL_ROW_171_1827 VDD VSS gf180mcu_as_sc_mcu7t3v3__tap_2
XFILLER_154_766 VDD VDD VSS VSS gf180mcu_as_sc_mcu7t3v3__fill_1
XFILLER_4_242 VDD VDD VSS VSS gf180mcu_as_sc_mcu7t3v3__fill_2
XTAP_TAPCELL_ROW_212_2558 VDD VSS gf180mcu_as_sc_mcu7t3v3__tap_2
XFILLER_107_660 VDD VDD VSS VSS gf180mcu_as_sc_mcu7t3v3__fill_2
XFILLER_153_276 VDD VDD VSS VSS gf180mcu_as_sc_mcu7t3v3__fillcap_4
XFILLER_153_298 VDD VDD VSS VSS gf180mcu_as_sc_mcu7t3v3__fillcap_16
XPHY_EDGE_ROW_78_1_Right_650 VDD VSS gf180mcu_as_sc_mcu7t3v3__tap_2
XFILLER_122_641 VDD VDD VSS VSS gf180mcu_as_sc_mcu7t3v3__fillcap_4
XFILLER_175_1170 VDD VDD VSS VSS gf180mcu_as_sc_mcu7t3v3__fillcap_16
XFILLER_175_1192 VDD VDD VSS VSS gf180mcu_as_sc_mcu7t3v3__fillcap_16
XFILLER_4_286 VDD VDD VSS VSS gf180mcu_as_sc_mcu7t3v3__fillcap_4
XFILLER_1_982 VDD VDD VSS VSS gf180mcu_as_sc_mcu7t3v3__fillcap_16
XTAP_TAPCELL_ROW_169_1778 VDD VSS gf180mcu_as_sc_mcu7t3v3__tap_2
XTAP_TAPCELL_ROW_169_1789 VDD VSS gf180mcu_as_sc_mcu7t3v3__tap_2
XFILLER_224_748 VDD VDD VSS VSS gf180mcu_as_sc_mcu7t3v3__fill_2
XFILLER_1_1186 VDD VDD VSS VSS gf180mcu_as_sc_mcu7t3v3__fillcap_4
X_3951_ VDD VDD VSS VSS _3975_/C _6055_/Q _3952_/D gf180mcu_as_sc_mcu7t3v3__and2_2
XFILLER_108_1245 VDD VDD VSS VSS gf180mcu_as_sc_mcu7t3v3__fillcap_16
XFILLER_220_943 VDD VDD VSS VSS gf180mcu_as_sc_mcu7t3v3__fill_2
X_3882_ VDD VDD VSS VSS _3884_/C _3882_/A _3882_/B _3892_/B gf180mcu_as_sc_mcu7t3v3__ao21_2
X_5621_ VDD VDD VSS VSS _5934_/A _5628_/D _5621_/C _5621_/D _5622_/B gf180mcu_as_sc_mcu7t3v3__ao211_2
X_5552_ VDD VDD VSS VSS _5859_/A _5584_/B _5584_/C _5858_/A _5553_/D gf180mcu_as_sc_mcu7t3v3__ao22_2
XFILLER_191_349 VDD VDD VSS VSS gf180mcu_as_sc_mcu7t3v3__fill_1
X_4503_ VDD VDD VSS VSS _6141_/Q _4551_/B _4503_/C _6287_/Q _4504_/D gf180mcu_as_sc_mcu7t3v3__ao22_2
X_5483_ VDD VDD VSS VSS _6507_/Q _5490_/B _5484_/B _5483_/D _5486_/A gf180mcu_as_sc_mcu7t3v3__ao211_2
XFILLER_160_714 VDD VDD VSS VSS gf180mcu_as_sc_mcu7t3v3__fillcap_4
X_4434_ VDD VDD VSS VSS _6250_/Q _4442_/B _4442_/C _6249_/Q _6249_/D gf180mcu_as_sc_mcu7t3v3__ao22_2
XFILLER_154_1221 VDD VDD VSS VSS gf180mcu_as_sc_mcu7t3v3__fillcap_4
XFILLER_67_1262 VDD VDD VSS VSS gf180mcu_as_sc_mcu7t3v3__fill_2
Xfanout505 VDD VDD VSS VSS _3648_/Y fanout505/Y gf180mcu_as_sc_mcu7t3v3__buff_12
X_4365_ VDD VDD VSS VSS _4367_/A _4365_/C _4407_/B _6139_/Q gf180mcu_as_sc_mcu7t3v3__aoi21_2
Xfanout516 VDD VDD VSS VSS _5960_/C _4055_/S gf180mcu_as_sc_mcu7t3v3__buff_12
Xfanout527 VDD VDD VSS VSS fanout531/Y _3830_/B gf180mcu_as_sc_mcu7t3v3__buff_12
X_6104_ VDD VDD VSS VSS _6125_/CLK _6104_/D _6104_/Q gf180mcu_as_sc_mcu7t3v3__dfxtp_2
X_3316_ VDD VDD VSS VSS _3355_/B _3316_/B _3316_/C _3317_/D _3356_/A gf180mcu_as_sc_mcu7t3v3__aoi211_2
XFILLER_115_1238 VDD VDD VSS VSS gf180mcu_as_sc_mcu7t3v3__fill_2
Xfanout549 VDD VDD VSS VSS _5267_/S _5190_/S gf180mcu_as_sc_mcu7t3v3__buff_12
X_6035_ VDD VDD VSS VSS _6492_/CLK _6035_/D _6035_/Q gf180mcu_as_sc_mcu7t3v3__dfxtp_2
X_4296_ VDD VDD VSS VSS _4366_/A _4296_/B _4296_/C _4297_/B _4408_/D gf180mcu_as_sc_mcu7t3v3__oai211_2
XFILLER_132_27 VDD VDD VSS VSS gf180mcu_as_sc_mcu7t3v3__fillcap_8
XFILLER_227_520 VDD VDD VSS VSS gf180mcu_as_sc_mcu7t3v3__fillcap_4
XPHY_EDGE_ROW_203_Right_71 VDD VSS gf180mcu_as_sc_mcu7t3v3__tap_2
X_3247_ VDD VDD VSS VSS _6267_/Q _6270_/Q _3250_/B gf180mcu_as_sc_mcu7t3v3__and2_2
XFILLER_132_49 VDD VDD VSS VSS gf180mcu_as_sc_mcu7t3v3__fill_2
XFILLER_187_1030 VDD VDD VSS VSS gf180mcu_as_sc_mcu7t3v3__fillcap_16
XFILLER_215_704 VDD VDD VSS VSS gf180mcu_as_sc_mcu7t3v3__fill_1
X_3178_ VDD VDD VSS VSS _3178_/B _3178_/A _3180_/B gf180mcu_as_sc_mcu7t3v3__or2_2
XFILLER_187_1052 VDD VDD VSS VSS gf180mcu_as_sc_mcu7t3v3__fillcap_16
XFILLER_228_1060 VDD VDD VSS VSS gf180mcu_as_sc_mcu7t3v3__fill_1
XFILLER_194_121 VDD VDD VSS VSS gf180mcu_as_sc_mcu7t3v3__fillcap_8
XFILLER_210_453 VDD VDD VSS VSS gf180mcu_as_sc_mcu7t3v3__fill_2
XPHY_EDGE_ROW_212_Right_80 VDD VSS gf180mcu_as_sc_mcu7t3v3__tap_2
X_5819_ VDD VDD VSS VSS _5859_/S _5819_/B _5819_/A _5820_/B gf180mcu_as_sc_mcu7t3v3__mux2_2
XFILLER_10_547 VDD VDD VSS VSS gf180mcu_as_sc_mcu7t3v3__fill_2
XFILLER_167_368 VDD VDD VSS VSS gf180mcu_as_sc_mcu7t3v3__fillcap_16
XFILLER_195_699 VDD VDD VSS VSS gf180mcu_as_sc_mcu7t3v3__fill_1
XFILLER_211_998 VDD VDD VSS VSS gf180mcu_as_sc_mcu7t3v3__fillcap_16
XTAP_TAPCELL_ROW_153_1502 VDD VSS gf180mcu_as_sc_mcu7t3v3__tap_2
XFILLER_159_1154 VDD VDD VSS VSS gf180mcu_as_sc_mcu7t3v3__fillcap_16
XFILLER_191_894 VDD VDD VSS VSS gf180mcu_as_sc_mcu7t3v3__fillcap_4
XFILLER_151_769 VDD VDD VSS VSS gf180mcu_as_sc_mcu7t3v3__fill_1
XFILLER_1_212 VDD VDD VSS VSS gf180mcu_as_sc_mcu7t3v3__fillcap_16
XFILLER_150_279 VDD VDD VSS VSS gf180mcu_as_sc_mcu7t3v3__fillcap_16
XTAP_TAPCELL_ROW_186_2089 VDD VSS gf180mcu_as_sc_mcu7t3v3__tap_2
XFILLER_218_520 VDD VDD VSS VSS gf180mcu_as_sc_mcu7t3v3__fillcap_4
XTAP_TAPCELL_ROW_12_1222 VDD VSS gf180mcu_as_sc_mcu7t3v3__tap_2
XFILLER_18_625 VDD VDD VSS VSS gf180mcu_as_sc_mcu7t3v3__fill_2
XPHY_EDGE_ROW_117_1_Right_689 VDD VSS gf180mcu_as_sc_mcu7t3v3__tap_2
XTAP_TAPCELL_ROW_12_1233 VDD VSS gf180mcu_as_sc_mcu7t3v3__tap_2
XFILLER_166_1103 VDD VDD VSS VSS gf180mcu_as_sc_mcu7t3v3__fillcap_16
XFILLER_206_737 VDD VDD VSS VSS gf180mcu_as_sc_mcu7t3v3__fillcap_4
XTAP_TAPCELL_ROW_164_1686 VDD VSS gf180mcu_as_sc_mcu7t3v3__tap_2
XTAP_TAPCELL_ROW_164_1697 VDD VSS gf180mcu_as_sc_mcu7t3v3__tap_2
XFILLER_207_1100 VDD VDD VSS VSS gf180mcu_as_sc_mcu7t3v3__fillcap_16
XFILLER_207_1122 VDD VDD VSS VSS gf180mcu_as_sc_mcu7t3v3__fillcap_16
XFILLER_33_639 VDD VDD VSS VSS gf180mcu_as_sc_mcu7t3v3__fill_2
XFILLER_13_330 VDD VDD VSS VSS gf180mcu_as_sc_mcu7t3v3__fillcap_16
XFILLER_13_352 VDD VDD VSS VSS gf180mcu_as_sc_mcu7t3v3__fillcap_16
XFILLER_198_482 VDD VDD VSS VSS gf180mcu_as_sc_mcu7t3v3__fillcap_8
XFILLER_198_53 VDD VDD VSS VSS gf180mcu_as_sc_mcu7t3v3__fillcap_16
XFILLER_202_921 VDD VDD VSS VSS gf180mcu_as_sc_mcu7t3v3__fillcap_16
XFILLER_41_661 VDD VDD VSS VSS gf180mcu_as_sc_mcu7t3v3__fill_1
XFILLER_186_677 VDD VDD VSS VSS gf180mcu_as_sc_mcu7t3v3__fillcap_8
XFILLER_9_356 VDD VDD VSS VSS gf180mcu_as_sc_mcu7t3v3__fill_1
XPHY_EDGE_ROW_55_3_Left_760 VDD VSS gf180mcu_as_sc_mcu7t3v3__tap_2
XPHY_EDGE_ROW_149_Left_377 VDD VSS gf180mcu_as_sc_mcu7t3v3__tap_2
XFILLER_5_562 VDD VDD VSS VSS gf180mcu_as_sc_mcu7t3v3__fill_2
XPHY_EDGE_ROW_114_2_Left_555 VDD VSS gf180mcu_as_sc_mcu7t3v3__tap_2
XPHY_EDGE_ROW_10_Left_239 VDD VSS gf180mcu_as_sc_mcu7t3v3__tap_2
XPHY_EDGE_ROW_79_1_Right_651 VDD VSS gf180mcu_as_sc_mcu7t3v3__tap_2
X_4150_ VDD VDD VSS VSS _4224_/A _4607_/A _4153_/B gf180mcu_as_sc_mcu7t3v3__or2_2
XFILLER_150_791 VDD VDD VSS VSS gf180mcu_as_sc_mcu7t3v3__fillcap_8
X_3101_ VDD VDD VSS VSS _6312_/Q _6313_/Q _4108_/A _3101_/Y gf180mcu_as_sc_mcu7t3v3__nor3_2
X_4081_ VDD VDD VSS VSS _4085_/S _6718_/A _6141_/Q _6141_/D gf180mcu_as_sc_mcu7t3v3__mux2_2
XPHY_EDGE_ROW_158_Left_386 VDD VSS gf180mcu_as_sc_mcu7t3v3__tap_2
Xinput190 VDD VDD VSS VSS nw_in[6] _5727_/A gf180mcu_as_sc_mcu7t3v3__buff_12
X_3032_ VDD VDD VSS VSS _3625_/C _5947_/A gf180mcu_as_sc_mcu7t3v3__inv_2
XFILLER_24_606 VDD VDD VSS VSS gf180mcu_as_sc_mcu7t3v3__fill_2
XFILLER_197_909 VDD VDD VSS VSS gf180mcu_as_sc_mcu7t3v3__fill_1
XFILLER_91_594 VDD VDD VSS VSS gf180mcu_as_sc_mcu7t3v3__fillcap_4
X_4983_ VDD VDD VSS VSS _4983_/A _5252_/A _5250_/C _4995_/A gf180mcu_as_sc_mcu7t3v3__nor3_2
XFILLER_177_611 VDD VDD VSS VSS gf180mcu_as_sc_mcu7t3v3__fill_1
X_6722_ VDD VDD VSS VSS _6722_/A _6722_/Y gf180mcu_as_sc_mcu7t3v3__buff_2
X_3934_ VDD VDD VSS VSS _5963_/A _5958_/A _5960_/B gf180mcu_as_sc_mcu7t3v3__or2_2
XFILLER_149_324 VDD VDD VSS VSS gf180mcu_as_sc_mcu7t3v3__fillcap_16
XFILLER_149_346 VDD VDD VSS VSS gf180mcu_as_sc_mcu7t3v3__fill_2
XFILLER_32_661 VDD VDD VSS VSS gf180mcu_as_sc_mcu7t3v3__fillcap_4
X_3865_ VDD VDD VSS VSS _4051_/B _5851_/A _3865_/B _3865_/C gf180mcu_as_sc_mcu7t3v3__ao21_2
XFILLER_164_305 VDD VDD VSS VSS gf180mcu_as_sc_mcu7t3v3__fillcap_8
XFILLER_34_1261 VDD VDD VSS VSS gf180mcu_as_sc_mcu7t3v3__fillcap_4
X_5604_ VDD VDD VSS VSS _5914_/A _5630_/B _5604_/C _5604_/D _5605_/D gf180mcu_as_sc_mcu7t3v3__ao211_2
XFILLER_9_890 VDD VDD VSS VSS gf180mcu_as_sc_mcu7t3v3__fillcap_16
XPHY_EDGE_ROW_167_Left_395 VDD VSS gf180mcu_as_sc_mcu7t3v3__tap_2
X_3796_ VDD VDD VSS VSS _5792_/A _3806_/S _3796_/C _3796_/D _3798_/C gf180mcu_as_sc_mcu7t3v3__ao211_2
XFILLER_191_146 VDD VDD VSS VSS gf180mcu_as_sc_mcu7t3v3__fill_1
X_5535_ VDD VDD VSS VSS _5837_/A _5535_/B _5535_/C _5842_/D _5536_/C gf180mcu_as_sc_mcu7t3v3__ao22_2
XFILLER_127_27 VDD VDD VSS VSS gf180mcu_as_sc_mcu7t3v3__fillcap_16
XPHY_EDGE_ROW_46_2_Left_487 VDD VSS gf180mcu_as_sc_mcu7t3v3__tap_2
X_5466_ VDD VDD VSS VSS _5773_/A _5565_/B _5566_/B _5776_/A _5469_/C gf180mcu_as_sc_mcu7t3v3__ao22_2
X_4417_ VDD VDD VSS VSS _6233_/Q _4422_/B _4425_/C _6232_/Q _6232_/D gf180mcu_as_sc_mcu7t3v3__ao22_2
X_5397_ VDD VDD VSS VSS _5405_/A _5497_/B _5712_/A gf180mcu_as_sc_mcu7t3v3__nand2_2
X_4348_ VDD VDD VSS VSS _4349_/S _6118_/Q _4348_/C _4348_/D _4352_/C gf180mcu_as_sc_mcu7t3v3__ao211_2
XFILLER_101_666 VDD VDD VSS VSS gf180mcu_as_sc_mcu7t3v3__fill_1
XFILLER_41_1210 VDD VDD VSS VSS gf180mcu_as_sc_mcu7t3v3__fillcap_4
X_4279_ VDD VDD VSS VSS _4279_/B _5977_/B _4280_/C gf180mcu_as_sc_mcu7t3v3__and2_2
X_6018_ VDD VDD VSS VSS _6506_/CLK _6018_/D _6018_/Q gf180mcu_as_sc_mcu7t3v3__dfxtp_2
XTAP_TAPCELL_ROW_9_1176 VDD VSS gf180mcu_as_sc_mcu7t3v3__tap_2
XFILLER_215_556 VDD VDD VSS VSS gf180mcu_as_sc_mcu7t3v3__fillcap_4
XFILLER_187_419 VDD VDD VSS VSS gf180mcu_as_sc_mcu7t3v3__fill_1
XFILLER_199_279 VDD VDD VSS VSS gf180mcu_as_sc_mcu7t3v3__fill_1
XFILLER_202_228 VDD VDD VSS VSS gf180mcu_as_sc_mcu7t3v3__fill_1
XFILLER_10_311 VDD VDD VSS VSS gf180mcu_as_sc_mcu7t3v3__fillcap_4
XFILLER_10_333 VDD VDD VSS VSS gf180mcu_as_sc_mcu7t3v3__fillcap_16
XFILLER_168_34 VDD VDD VSS VSS gf180mcu_as_sc_mcu7t3v3__fill_1
XFILLER_210_261 VDD VDD VSS VSS gf180mcu_as_sc_mcu7t3v3__fill_2
XTAP_TAPCELL_ROW_122_3_3032 VDD VSS gf180mcu_as_sc_mcu7t3v3__tap_2
XTAP_TAPCELL_ROW_188_2129 VDD VSS gf180mcu_as_sc_mcu7t3v3__tap_2
XTAP_TAPCELL_ROW_188_2118 VDD VSS gf180mcu_as_sc_mcu7t3v3__tap_2
XFILLER_172_1151 VDD VDD VSS VSS gf180mcu_as_sc_mcu7t3v3__fillcap_4
XFILLER_172_1173 VDD VDD VSS VSS gf180mcu_as_sc_mcu7t3v3__fillcap_16
XTAP_TAPCELL_ROW_166_1726 VDD VSS gf180mcu_as_sc_mcu7t3v3__tap_2
XTAP_TAPCELL_ROW_166_1737 VDD VSS gf180mcu_as_sc_mcu7t3v3__tap_2
XFILLER_213_1170 VDD VDD VSS VSS gf180mcu_as_sc_mcu7t3v3__fillcap_16
Xfanout891 VDD VDD VSS VSS fanout894/Y _4369_/D gf180mcu_as_sc_mcu7t3v3__buff_12
XTAP_TAPCELL_ROW_207_2468 VDD VSS gf180mcu_as_sc_mcu7t3v3__tap_2
XFILLER_213_1192 VDD VDD VSS VSS gf180mcu_as_sc_mcu7t3v3__fillcap_16
XTAP_TAPCELL_ROW_224_2771 VDD VSS gf180mcu_as_sc_mcu7t3v3__tap_2
XTAP_TAPCELL_ROW_224_2782 VDD VSS gf180mcu_as_sc_mcu7t3v3__tap_2
XFILLER_14_650 VDD VDD VSS VSS gf180mcu_as_sc_mcu7t3v3__fillcap_4
XFILLER_199_780 VDD VDD VSS VSS gf180mcu_as_sc_mcu7t3v3__fillcap_4
XFILLER_144_1242 VDD VDD VSS VSS gf180mcu_as_sc_mcu7t3v3__fill_1
XFILLER_18_1245 VDD VDD VSS VSS gf180mcu_as_sc_mcu7t3v3__fillcap_16
XFILLER_9_120 VDD VDD VSS VSS gf180mcu_as_sc_mcu7t3v3__fillcap_16
XFILLER_9_142 VDD VDD VSS VSS gf180mcu_as_sc_mcu7t3v3__fillcap_4
XFILLER_159_699 VDD VDD VSS VSS gf180mcu_as_sc_mcu7t3v3__fill_1
X_3650_ VDD VDD VSS VSS _3655_/A _3650_/B _3650_/C _3651_/B gf180mcu_as_sc_mcu7t3v3__nor3_2
X_3581_ VDD VDD VSS VSS _3583_/D _5912_/D _4239_/A gf180mcu_as_sc_mcu7t3v3__nand2b_2
XFILLER_6_871 VDD VDD VSS VSS gf180mcu_as_sc_mcu7t3v3__fillcap_4
XPHY_EDGE_ROW_31_1_Left_259 VDD VSS gf180mcu_as_sc_mcu7t3v3__tap_2
X_5320_ VDD VDD VSS VSS _5664_/B _5320_/C _5320_/B _5320_/A gf180mcu_as_sc_mcu7t3v3__aoi21_2
XFILLER_177_1084 VDD VDD VSS VSS gf180mcu_as_sc_mcu7t3v3__fillcap_16
X_5251_ VDD VDD VSS VSS _5279_/C _5921_/A _5296_/B _5309_/B gf180mcu_as_sc_mcu7t3v3__ao21_2
XFILLER_47_2 VDD VDD VSS VSS gf180mcu_as_sc_mcu7t3v3__fillcap_16
X_4202_ VDD VDD VSS VSS _6717_/A _4337_/B _4202_/C _4223_/B _4203_/C gf180mcu_as_sc_mcu7t3v3__ao211_2
XFILLER_218_1081 VDD VDD VSS VSS gf180mcu_as_sc_mcu7t3v3__fillcap_4
X_5182_ VDD VDD VSS VSS _5182_/B _5229_/A _6396_/D gf180mcu_as_sc_mcu7t3v3__and2_2
XFILLER_151_1224 VDD VDD VSS VSS gf180mcu_as_sc_mcu7t3v3__fill_2
XFILLER_3_72 VDD VDD VSS VSS gf180mcu_as_sc_mcu7t3v3__fillcap_4
XPHY_EDGE_ROW_93_1_Left_321 VDD VSS gf180mcu_as_sc_mcu7t3v3__tap_2
X_4133_ VDD VDD VSS VSS _4135_/S _6183_/Q _6182_/Q _6182_/D gf180mcu_as_sc_mcu7t3v3__mux2_2
XFILLER_7_1170 VDD VDD VSS VSS gf180mcu_as_sc_mcu7t3v3__fillcap_16
X_4064_ VDD VDD VSS VSS _6014_/B _5963_/B _6487_/Q gf180mcu_as_sc_mcu7t3v3__nor2_2
XFILLER_7_1192 VDD VDD VSS VSS gf180mcu_as_sc_mcu7t3v3__fillcap_16
X_3015_ VDD VDD VSS VSS _5312_/A _4960_/D gf180mcu_as_sc_mcu7t3v3__inv_2
XFILLER_209_394 VDD VDD VSS VSS gf180mcu_as_sc_mcu7t3v3__fill_1
XFILLER_225_854 VDD VDD VSS VSS gf180mcu_as_sc_mcu7t3v3__fillcap_4
XFILLER_184_1033 VDD VDD VSS VSS gf180mcu_as_sc_mcu7t3v3__fillcap_16
XFILLER_225_887 VDD VDD VSS VSS gf180mcu_as_sc_mcu7t3v3__fill_1
XTAP_TAPCELL_ROW_4_1084 VDD VSS gf180mcu_as_sc_mcu7t3v3__tap_2
XFILLER_189_290 VDD VDD VSS VSS gf180mcu_as_sc_mcu7t3v3__fillcap_4
XFILLER_225_1030 VDD VDD VSS VSS gf180mcu_as_sc_mcu7t3v3__fillcap_16
XFILLER_225_1052 VDD VDD VSS VSS gf180mcu_as_sc_mcu7t3v3__fillcap_16
X_4966_ VDD VDD VSS VSS _4966_/B _5977_/A _6375_/D gf180mcu_as_sc_mcu7t3v3__and2_2
XFILLER_149_154 VDD VDD VSS VSS gf180mcu_as_sc_mcu7t3v3__fillcap_16
XFILLER_178_975 VDD VDD VSS VSS gf180mcu_as_sc_mcu7t3v3__fill_2
XFILLER_193_912 VDD VDD VSS VSS gf180mcu_as_sc_mcu7t3v3__fillcap_16
XPHY_EDGE_ROW_175_Left_403 VDD VSS gf180mcu_as_sc_mcu7t3v3__tap_2
X_4897_ VDD VDD VSS VSS _5912_/A _4953_/B _4953_/C _5887_/D _4899_/C gf180mcu_as_sc_mcu7t3v3__ao22_2
X_3917_ VDD VDD VSS VSS _3928_/B _5895_/A _3918_/D gf180mcu_as_sc_mcu7t3v3__and2_2
XFILLER_177_485 VDD VDD VSS VSS gf180mcu_as_sc_mcu7t3v3__fillcap_4
XFILLER_177_496 VDD VDD VSS VSS gf180mcu_as_sc_mcu7t3v3__fill_2
XFILLER_22_37 VDD VDD VSS VSS gf180mcu_as_sc_mcu7t3v3__fillcap_8
X_3848_ VDD VDD VSS VSS _6035_/Q _3904_/B _4047_/B _3904_/D _6035_/D gf180mcu_as_sc_mcu7t3v3__ao22_2
XFILLER_138_37 VDD VDD VSS VSS gf180mcu_as_sc_mcu7t3v3__fillcap_8
X_3779_ VDD VDD VSS VSS _3930_/B _5777_/A _3780_/D gf180mcu_as_sc_mcu7t3v3__and2_2
XFILLER_192_477 VDD VDD VSS VSS gf180mcu_as_sc_mcu7t3v3__fillcap_16
X_5518_ VDD VDD VSS VSS _5825_/D _5567_/B _5518_/C _5518_/D _5520_/A gf180mcu_as_sc_mcu7t3v3__ao211_2
XFILLER_156_1135 VDD VDD VSS VSS gf180mcu_as_sc_mcu7t3v3__fillcap_16
XFILLER_161_842 VDD VDD VSS VSS gf180mcu_as_sc_mcu7t3v3__fill_1
XFILLER_173_691 VDD VDD VSS VSS gf180mcu_as_sc_mcu7t3v3__fill_1
X_6498_ VDD VDD VSS VSS _6546_/CLK _6498_/D _6498_/Q gf180mcu_as_sc_mcu7t3v3__dfxtp_2
XFILLER_156_1157 VDD VDD VSS VSS gf180mcu_as_sc_mcu7t3v3__fillcap_16
XFILLER_160_341 VDD VDD VSS VSS gf180mcu_as_sc_mcu7t3v3__fillcap_4
Xoutput461 VDD VDD VSS VSS _6464_/Q west_out[15] gf180mcu_as_sc_mcu7t3v3__buff_12
Xoutput450 VDD VDD VSS VSS _6382_/Q south_out[5] gf180mcu_as_sc_mcu7t3v3__buff_12
X_5449_ VDD VDD VSS VSS _5456_/C _5641_/B _5761_/A gf180mcu_as_sc_mcu7t3v3__nand2b_2
XFILLER_154_69 VDD VDD VSS VSS gf180mcu_as_sc_mcu7t3v3__fillcap_16
XPHY_EDGE_ROW_184_Left_412 VDD VSS gf180mcu_as_sc_mcu7t3v3__tap_2
Xoutput483 VDD VDD VSS VSS _6484_/Q west_out[35] gf180mcu_as_sc_mcu7t3v3__buff_12
Xoutput472 VDD VDD VSS VSS _6474_/Q west_out[25] gf180mcu_as_sc_mcu7t3v3__buff_12
XFILLER_87_664 VDD VDD VSS VSS gf180mcu_as_sc_mcu7t3v3__fill_2
XTAP_TAPCELL_ROW_183_2037 VDD VSS gf180mcu_as_sc_mcu7t3v3__tap_2
XTAP_TAPCELL_ROW_161_1634 VDD VSS gf180mcu_as_sc_mcu7t3v3__tap_2
XTAP_TAPCELL_ROW_161_1645 VDD VSS gf180mcu_as_sc_mcu7t3v3__tap_2
XFILLER_167_1264 VDD VDD VSS VSS gf180mcu_as_sc_mcu7t3v3__fill_1
XFILLER_55_594 VDD VDD VSS VSS gf180mcu_as_sc_mcu7t3v3__fill_2
XFILLER_128_1226 VDD VDD VSS VSS gf180mcu_as_sc_mcu7t3v3__fillcap_16
XTAP_TAPCELL_ROW_202_2376 VDD VSS gf180mcu_as_sc_mcu7t3v3__tap_2
XFILLER_204_1103 VDD VDD VSS VSS gf180mcu_as_sc_mcu7t3v3__fillcap_16
XPHY_EDGE_ROW_193_Left_421 VDD VSS gf180mcu_as_sc_mcu7t3v3__tap_2
XFILLER_169_986 VDD VDD VSS VSS gf180mcu_as_sc_mcu7t3v3__fillcap_16
XFILLER_183_422 VDD VDD VSS VSS gf180mcu_as_sc_mcu7t3v3__fillcap_16
XFILLER_184_934 VDD VDD VSS VSS gf180mcu_as_sc_mcu7t3v3__fill_1
XFILLER_195_282 VDD VDD VSS VSS gf180mcu_as_sc_mcu7t3v3__fillcap_4
XFILLER_6_101 VDD VDD VSS VSS gf180mcu_as_sc_mcu7t3v3__fillcap_4
XFILLER_7_602 VDD VDD VSS VSS gf180mcu_as_sc_mcu7t3v3__fill_2
XTAP_TAPCELL_ROW_159_1596 VDD VSS gf180mcu_as_sc_mcu7t3v3__tap_2
Xwire511 VDD VDD VSS VSS _3325_/Y wire511/Y gf180mcu_as_sc_mcu7t3v3__clkbuff_12
XFILLER_171_606 VDD VDD VSS VSS gf180mcu_as_sc_mcu7t3v3__fill_1
XFILLER_6_123 VDD VDD VSS VSS gf180mcu_as_sc_mcu7t3v3__fillcap_16
XFILLER_13_1186 VDD VDD VSS VSS gf180mcu_as_sc_mcu7t3v3__fillcap_4
XFILLER_183_477 VDD VDD VSS VSS gf180mcu_as_sc_mcu7t3v3__fillcap_8
XFILLER_195_65 VDD VDD VSS VSS gf180mcu_as_sc_mcu7t3v3__fillcap_4
XFILLER_87_1210 VDD VDD VSS VSS gf180mcu_as_sc_mcu7t3v3__fill_1
Xclkbuf_leaf_27_clk_regs VDD VDD VSS VSS clkload2/A _6376_/CLK gf180mcu_as_sc_mcu7t3v3__clkbuff_12
XFILLER_151_330 VDD VDD VSS VSS gf180mcu_as_sc_mcu7t3v3__fillcap_16
XFILLER_151_352 VDD VDD VSS VSS gf180mcu_as_sc_mcu7t3v3__fillcap_4
XFILLER_163_190 VDD VDD VSS VSS gf180mcu_as_sc_mcu7t3v3__fillcap_16
XTAP_TAPCELL_ROW_209_2508 VDD VSS gf180mcu_as_sc_mcu7t3v3__tap_2
XTAP_TAPCELL_ROW_226_2811 VDD VSS gf180mcu_as_sc_mcu7t3v3__tap_2
XFILLER_168_1017 VDD VDD VSS VSS gf180mcu_as_sc_mcu7t3v3__fillcap_16
XFILLER_209_1014 VDD VDD VSS VSS gf180mcu_as_sc_mcu7t3v3__fillcap_16
X_4820_ VDD VDD VSS VSS _4821_/C _4877_/B _5823_/A gf180mcu_as_sc_mcu7t3v3__nor2_2
XFILLER_178_238 VDD VDD VSS VSS gf180mcu_as_sc_mcu7t3v3__fillcap_4
X_4751_ VDD VDD VSS VSS _4864_/S _4751_/B _5763_/A _4752_/B gf180mcu_as_sc_mcu7t3v3__mux2_2
X_4682_ VDD VDD VSS VSS _5701_/A _4719_/B _4682_/C _4682_/D _4683_/B gf180mcu_as_sc_mcu7t3v3__ao211_2
X_3702_ VDD VDD VSS VSS _5709_/A _3806_/S _3702_/C _3702_/D _3703_/A gf180mcu_as_sc_mcu7t3v3__ao211_2
XFILLER_174_444 VDD VDD VSS VSS gf180mcu_as_sc_mcu7t3v3__fillcap_8
XFILLER_175_978 VDD VDD VSS VSS gf180mcu_as_sc_mcu7t3v3__fill_2
X_6421_ VDD VDD VSS VSS _6437_/CLK _6421_/D _6421_/Q gf180mcu_as_sc_mcu7t3v3__dfxtp_2
X_3633_ VDD VDD VSS VSS _5320_/C _5934_/A _5329_/A gf180mcu_as_sc_mcu7t3v3__nor2_2
XFILLER_174_477 VDD VDD VSS VSS gf180mcu_as_sc_mcu7t3v3__fill_1
X_6352_ VDD VDD VSS VSS _6365_/CLK _6352_/D _6352_/Q gf180mcu_as_sc_mcu7t3v3__dfxtp_2
X_3564_ VDD VDD VSS VSS _4620_/A _4977_/A _4960_/D gf180mcu_as_sc_mcu7t3v3__nand2b_2
XPHY_EDGE_ROW_18_3_Left_723 VDD VSS gf180mcu_as_sc_mcu7t3v3__tap_2
X_6283_ VDD VDD VSS VSS clkload5/A _6283_/D _6283_/Q gf180mcu_as_sc_mcu7t3v3__dfxtp_2
X_5303_ VDD VDD VSS VSS _5303_/S _5303_/B _6523_/Q _5305_/C gf180mcu_as_sc_mcu7t3v3__mux2_2
X_3495_ VDD VDD VSS VSS _3654_/A _3653_/A _3655_/A gf180mcu_as_sc_mcu7t3v3__nor2_2
XFILLER_170_683 VDD VDD VSS VSS gf180mcu_as_sc_mcu7t3v3__fillcap_8
X_5234_ VDD VDD VSS VSS _5236_/C _6518_/Q _5234_/B _5234_/C gf180mcu_as_sc_mcu7t3v3__ao21_2
X_5165_ VDD VDD VSS VSS _5166_/D _5823_/A _5310_/B _5263_/B gf180mcu_as_sc_mcu7t3v3__ao21_2
XFILLER_190_1081 VDD VDD VSS VSS gf180mcu_as_sc_mcu7t3v3__fillcap_4
XFILLER_69_664 VDD VDD VSS VSS gf180mcu_as_sc_mcu7t3v3__fill_2
X_4116_ VDD VDD VSS VSS _4144_/S _6166_/Q _6165_/Q _6165_/D gf180mcu_as_sc_mcu7t3v3__mux2_2
X_5096_ VDD VDD VSS VSS _6503_/Q _5206_/B _5096_/C _5096_/D _5098_/C gf180mcu_as_sc_mcu7t3v3__ao22_2
XTAP_TAPCELL_ROW_6_1124 VDD VSS gf180mcu_as_sc_mcu7t3v3__tap_2
XTAP_TAPCELL_ROW_6_1113 VDD VSS gf180mcu_as_sc_mcu7t3v3__tap_2
X_4047_ VDD VDD VSS VSS _4047_/D _4051_/A _4047_/B _4057_/C _6122_/D gf180mcu_as_sc_mcu7t3v3__ao31_2
XFILLER_140_49 VDD VDD VSS VSS gf180mcu_as_sc_mcu7t3v3__fill_2
XFILLER_37_594 VDD VDD VSS VSS gf180mcu_as_sc_mcu7t3v3__fillcap_4
XFILLER_197_558 VDD VDD VSS VSS gf180mcu_as_sc_mcu7t3v3__fill_2
XPHY_EDGE_ROW_153_Right_21 VDD VSS gf180mcu_as_sc_mcu7t3v3__tap_2
X_5998_ VDD VDD VSS VSS _6006_/B _6221_/Q _6511_/D gf180mcu_as_sc_mcu7t3v3__and2_2
XFILLER_220_93 VDD VDD VSS VSS gf180mcu_as_sc_mcu7t3v3__fillcap_4
X_4949_ VDD VDD VSS VSS _5939_/A _4955_/B _4949_/C _4949_/D _4950_/C gf180mcu_as_sc_mcu7t3v3__ao211_2
XFILLER_149_36 VDD VDD VSS VSS gf180mcu_as_sc_mcu7t3v3__fillcap_16
XFILLER_165_422 VDD VDD VSS VSS gf180mcu_as_sc_mcu7t3v3__fill_1
XFILLER_197_1224 VDD VDD VSS VSS gf180mcu_as_sc_mcu7t3v3__fillcap_8
XFILLER_165_477 VDD VDD VSS VSS gf180mcu_as_sc_mcu7t3v3__fill_2
XFILLER_180_414 VDD VDD VSS VSS gf180mcu_as_sc_mcu7t3v3__fill_1
XFILLER_3_148 VDD VDD VSS VSS gf180mcu_as_sc_mcu7t3v3__fill_1
XFILLER_160_171 VDD VDD VSS VSS gf180mcu_as_sc_mcu7t3v3__fillcap_4
XPHY_EDGE_ROW_162_Right_30 VDD VSS gf180mcu_as_sc_mcu7t3v3__tap_2
XFILLER_160_193 VDD VDD VSS VSS gf180mcu_as_sc_mcu7t3v3__fillcap_16
Xwire1011 VDD VDD VSS VSS _3178_/A _6012_/A gf180mcu_as_sc_mcu7t3v3__clkbuff_12
Xwire1022 VDD VDD VSS VSS wire1022/A _5710_/D gf180mcu_as_sc_mcu7t3v3__clkbuff_12
XFILLER_75_623 VDD VDD VSS VSS gf180mcu_as_sc_mcu7t3v3__fill_2
XTAP_TAPCELL_ROW_204_2405 VDD VSS gf180mcu_as_sc_mcu7t3v3__tap_2
XFILLER_207_117 VDD VDD VSS VSS gf180mcu_as_sc_mcu7t3v3__fillcap_8
XFILLER_207_139 VDD VDD VSS VSS gf180mcu_as_sc_mcu7t3v3__fill_1
XFILLER_210_1151 VDD VDD VSS VSS gf180mcu_as_sc_mcu7t3v3__fillcap_4
XTAP_TAPCELL_ROW_204_2416 VDD VSS gf180mcu_as_sc_mcu7t3v3__tap_2
XFILLER_210_1173 VDD VDD VSS VSS gf180mcu_as_sc_mcu7t3v3__fillcap_16
XFILLER_28_594 VDD VDD VSS VSS gf180mcu_as_sc_mcu7t3v3__fillcap_8
XFILLER_15_244 VDD VDD VSS VSS gf180mcu_as_sc_mcu7t3v3__fillcap_16
XTAP_TAPCELL_ROW_110_3_3014 VDD VSS gf180mcu_as_sc_mcu7t3v3__tap_2
XFILLER_15_266 VDD VDD VSS VSS gf180mcu_as_sc_mcu7t3v3__fill_1
XFILLER_188_558 VDD VDD VSS VSS gf180mcu_as_sc_mcu7t3v3__fill_2
XPHY_EDGE_ROW_123_2_Left_564 VDD VSS gf180mcu_as_sc_mcu7t3v3__tap_2
XTAP_TAPCELL_ROW_178_1950 VDD VSS gf180mcu_as_sc_mcu7t3v3__tap_2
XFILLER_129_636 VDD VDD VSS VSS gf180mcu_as_sc_mcu7t3v3__fillcap_4
XFILLER_141_1234 VDD VDD VSS VSS gf180mcu_as_sc_mcu7t3v3__fillcap_4
XFILLER_169_772 VDD VDD VSS VSS gf180mcu_as_sc_mcu7t3v3__fillcap_4
XFILLER_12_995 VDD VDD VSS VSS gf180mcu_as_sc_mcu7t3v3__fillcap_16
XFILLER_184_731 VDD VDD VSS VSS gf180mcu_as_sc_mcu7t3v3__fillcap_4
XTAP_TAPCELL_ROW_219_2692 VDD VSS gf180mcu_as_sc_mcu7t3v3__tap_2
XTAP_TAPCELL_ROW_219_2681 VDD VSS gf180mcu_as_sc_mcu7t3v3__tap_2
XPHY_EDGE_ROW_60_2_Left_501 VDD VSS gf180mcu_as_sc_mcu7t3v3__tap_2
XTAP_TAPCELL_ROW_174_1869 VDD VSS gf180mcu_as_sc_mcu7t3v3__tap_2
XFILLER_174_1065 VDD VDD VSS VSS gf180mcu_as_sc_mcu7t3v3__fillcap_16
X_3280_ VDD VDD VSS VSS _3280_/D _6299_/Q _3280_/B _3280_/C _3281_/C gf180mcu_as_sc_mcu7t3v3__ao31_2
XFILLER_174_1087 VDD VDD VSS VSS gf180mcu_as_sc_mcu7t3v3__fillcap_16
XFILLER_215_1084 VDD VDD VSS VSS gf180mcu_as_sc_mcu7t3v3__fillcap_16
XFILLER_226_448 VDD VDD VSS VSS gf180mcu_as_sc_mcu7t3v3__fill_1
XFILLER_4_1151 VDD VDD VSS VSS gf180mcu_as_sc_mcu7t3v3__fillcap_4
XFILLER_0_1026 VDD VDD VSS VSS gf180mcu_as_sc_mcu7t3v3__fill_2
XFILLER_0_40 VDD VDD VSS VSS gf180mcu_as_sc_mcu7t3v3__fill_2
XFILLER_4_1173 VDD VDD VSS VSS gf180mcu_as_sc_mcu7t3v3__fillcap_16
X_5921_ VDD VDD VSS VSS _5921_/A _5936_/B _5930_/C _5921_/D _5922_/D gf180mcu_as_sc_mcu7t3v3__ao22_2
XTAP_TAPCELL_ROW_1_1032 VDD VSS gf180mcu_as_sc_mcu7t3v3__tap_2
XFILLER_181_1014 VDD VDD VSS VSS gf180mcu_as_sc_mcu7t3v3__fillcap_16
XPHY_EDGE_ROW_55_2_Left_496 VDD VSS gf180mcu_as_sc_mcu7t3v3__tap_2
X_5852_ VDD VDD VSS VSS _5852_/B _5956_/A _6470_/D gf180mcu_as_sc_mcu7t3v3__and2_2
X_5783_ VDD VDD VSS VSS _5783_/A _5839_/B _5783_/C _5839_/D _5784_/D gf180mcu_as_sc_mcu7t3v3__ao22_2
X_4803_ VDD VDD VSS VSS _5150_/A _4878_/B _4803_/C _4804_/D _4851_/B gf180mcu_as_sc_mcu7t3v3__aoi211_2
XFILLER_159_260 VDD VDD VSS VSS gf180mcu_as_sc_mcu7t3v3__fillcap_16
XFILLER_175_720 VDD VDD VSS VSS gf180mcu_as_sc_mcu7t3v3__fill_2
XFILLER_194_517 VDD VDD VSS VSS gf180mcu_as_sc_mcu7t3v3__fill_1
XFILLER_194_539 VDD VDD VSS VSS gf180mcu_as_sc_mcu7t3v3__fill_2
XFILLER_222_1011 VDD VDD VSS VSS gf180mcu_as_sc_mcu7t3v3__fillcap_4
XFILLER_222_1033 VDD VDD VSS VSS gf180mcu_as_sc_mcu7t3v3__fillcap_16
X_4734_ VDD VDD VSS VSS _4734_/B _4826_/A _6349_/D gf180mcu_as_sc_mcu7t3v3__and2_2
XFILLER_159_282 VDD VDD VSS VSS gf180mcu_as_sc_mcu7t3v3__fillcap_16
XTAP_TAPCELL_ROW_144_1_1393 VDD VSS gf180mcu_as_sc_mcu7t3v3__tap_2
XFILLER_162_414 VDD VDD VSS VSS gf180mcu_as_sc_mcu7t3v3__fillcap_8
XFILLER_163_937 VDD VDD VSS VSS gf180mcu_as_sc_mcu7t3v3__fill_2
X_4665_ VDD VDD VSS VSS _5681_/A _4932_/A _4665_/C _4665_/D _4667_/B gf180mcu_as_sc_mcu7t3v3__ao211_2
XFILLER_162_447 VDD VDD VSS VSS gf180mcu_as_sc_mcu7t3v3__fill_1
XFILLER_190_734 VDD VDD VSS VSS gf180mcu_as_sc_mcu7t3v3__fill_1
X_6404_ VDD VDD VSS VSS _6412_/CLK _6404_/D _6404_/Q gf180mcu_as_sc_mcu7t3v3__dfxtp_2
X_4596_ VDD VDD VSS VSS _4602_/A _4598_/B _4596_/C _6335_/D gf180mcu_as_sc_mcu7t3v3__nor3_2
X_3616_ VDD VDD VSS VSS _3653_/A _3654_/B _3616_/C _3617_/D _3644_/B gf180mcu_as_sc_mcu7t3v3__ao211_2
XFILLER_143_661 VDD VDD VSS VSS gf180mcu_as_sc_mcu7t3v3__fill_1
Xmax_cap641 VDD VDD VSS VSS _3881_/B _3873_/S gf180mcu_as_sc_mcu7t3v3__clkbuff_12
X_6335_ VDD VDD VSS VSS clkload6/A _6335_/D _6335_/Q gf180mcu_as_sc_mcu7t3v3__dfxtp_2
X_3547_ VDD VDD VSS VSS _3547_/A _4973_/A _4973_/B _3560_/B gf180mcu_as_sc_mcu7t3v3__nand3_2
XFILLER_135_27 VDD VDD VSS VSS gf180mcu_as_sc_mcu7t3v3__fillcap_16
XFILLER_153_1116 VDD VDD VSS VSS gf180mcu_as_sc_mcu7t3v3__fillcap_4
XFILLER_153_1138 VDD VDD VSS VSS gf180mcu_as_sc_mcu7t3v3__fillcap_16
X_6266_ VDD VDD VSS VSS clkload7/A _6266_/D _6266_/Q gf180mcu_as_sc_mcu7t3v3__dfxtp_2
X_3478_ VDD VDD VSS VSS _3483_/A _5923_/A _3598_/B gf180mcu_as_sc_mcu7t3v3__nand2b_2
X_6197_ VDD VDD VSS VSS _6368_/CLK _6197_/D _6197_/Q gf180mcu_as_sc_mcu7t3v3__dfxtp_2
X_5217_ VDD VDD VSS VSS _5217_/S _5865_/A _5217_/A _5218_/C gf180mcu_as_sc_mcu7t3v3__mux2_2
XFILLER_57_623 VDD VDD VSS VSS gf180mcu_as_sc_mcu7t3v3__fill_1
XFILLER_9_1084 VDD VDD VSS VSS gf180mcu_as_sc_mcu7t3v3__fillcap_16
XPHY_EDGE_ROW_119_1_Left_347 VDD VSS gf180mcu_as_sc_mcu7t3v3__tap_2
X_5148_ VDD VDD VSS VSS _5148_/D _5805_/A _5222_/B _5222_/C _5149_/C gf180mcu_as_sc_mcu7t3v3__ao31_2
X_5079_ VDD VDD VSS VSS _5745_/A _5098_/B _5079_/C _5079_/D _5080_/A gf180mcu_as_sc_mcu7t3v3__ao211_2
XFILLER_77_1264 VDD VDD VSS VSS gf180mcu_as_sc_mcu7t3v3__fill_1
XFILLER_213_632 VDD VDD VSS VSS gf180mcu_as_sc_mcu7t3v3__fillcap_4
XFILLER_225_492 VDD VDD VSS VSS gf180mcu_as_sc_mcu7t3v3__fillcap_8
XFILLER_12_225 VDD VDD VSS VSS gf180mcu_as_sc_mcu7t3v3__fillcap_16
XFILLER_198_867 VDD VDD VSS VSS gf180mcu_as_sc_mcu7t3v3__fillcap_8
XTAP_TAPCELL_ROW_195_2250 VDD VSS gf180mcu_as_sc_mcu7t3v3__tap_2
XFILLER_12_247 VDD VDD VSS VSS gf180mcu_as_sc_mcu7t3v3__fillcap_16
XFILLER_185_517 VDD VDD VSS VSS gf180mcu_as_sc_mcu7t3v3__fillcap_4
XFILLER_205_1264 VDD VDD VSS VSS gf180mcu_as_sc_mcu7t3v3__fill_1
XFILLER_60_45 VDD VDD VSS VSS gf180mcu_as_sc_mcu7t3v3__fillcap_4
XTAP_TAPCELL_ROW_156_1544 VDD VSS gf180mcu_as_sc_mcu7t3v3__tap_2
XFILLER_176_34 VDD VDD VSS VSS gf180mcu_as_sc_mcu7t3v3__fill_1
XTAP_TAPCELL_ROW_156_1555 VDD VSS gf180mcu_as_sc_mcu7t3v3__tap_2
XFILLER_153_447 VDD VDD VSS VSS gf180mcu_as_sc_mcu7t3v3__fillcap_8
XFILLER_154_959 VDD VDD VSS VSS gf180mcu_as_sc_mcu7t3v3__fillcap_16
XFILLER_158_1049 VDD VDD VSS VSS gf180mcu_as_sc_mcu7t3v3__fillcap_16
XFILLER_180_255 VDD VDD VSS VSS gf180mcu_as_sc_mcu7t3v3__fill_2
XTAP_TAPCELL_ROW_94_1_1368 VDD VSS gf180mcu_as_sc_mcu7t3v3__tap_2
XFILLER_10_1189 VDD VDD VSS VSS gf180mcu_as_sc_mcu7t3v3__fillcap_16
XFILLER_134_661 VDD VDD VSS VSS gf180mcu_as_sc_mcu7t3v3__fillcap_4
XFILLER_48_601 VDD VDD VSS VSS gf180mcu_as_sc_mcu7t3v3__fill_1
XTAP_TAPCELL_ROW_15_1275 VDD VSS gf180mcu_as_sc_mcu7t3v3__tap_2
XTAP_TAPCELL_ROW_15_1286 VDD VSS gf180mcu_as_sc_mcu7t3v3__tap_2
XFILLER_208_459 VDD VDD VSS VSS gf180mcu_as_sc_mcu7t3v3__fill_1
XTAP_TAPCELL_ROW_128_3_3041 VDD VSS gf180mcu_as_sc_mcu7t3v3__tap_2
XFILLER_216_470 VDD VDD VSS VSS gf180mcu_as_sc_mcu7t3v3__fill_1
XFILLER_217_982 VDD VDD VSS VSS gf180mcu_as_sc_mcu7t3v3__fillcap_16
XFILLER_223_418 VDD VDD VSS VSS gf180mcu_as_sc_mcu7t3v3__fill_2
XPHY_EDGE_ROW_40_1_Left_268 VDD VSS gf180mcu_as_sc_mcu7t3v3__tap_2
XFILLER_16_575 VDD VDD VSS VSS gf180mcu_as_sc_mcu7t3v3__fill_2
XFILLER_204_632 VDD VDD VSS VSS gf180mcu_as_sc_mcu7t3v3__fill_1
XFILLER_188_344 VDD VDD VSS VSS gf180mcu_as_sc_mcu7t3v3__fill_1
XFILLER_203_142 VDD VDD VSS VSS gf180mcu_as_sc_mcu7t3v3__fillcap_4
XFILLER_203_153 VDD VDD VSS VSS gf180mcu_as_sc_mcu7t3v3__fillcap_8
XFILLER_206_1017 VDD VDD VSS VSS gf180mcu_as_sc_mcu7t3v3__fillcap_16
XTAP_TAPCELL_ROW_176_1909 VDD VSS gf180mcu_as_sc_mcu7t3v3__tap_2
XFILLER_188_399 VDD VDD VSS VSS gf180mcu_as_sc_mcu7t3v3__fillcap_8
XFILLER_156_241 VDD VDD VSS VSS gf180mcu_as_sc_mcu7t3v3__fillcap_4
XFILLER_156_263 VDD VDD VSS VSS gf180mcu_as_sc_mcu7t3v3__fillcap_16
XFILLER_8_774 VDD VDD VSS VSS gf180mcu_as_sc_mcu7t3v3__fill_2
XFILLER_184_594 VDD VDD VSS VSS gf180mcu_as_sc_mcu7t3v3__fill_1
X_4450_ VDD VDD VSS VSS _4546_/B _6157_/Q _6260_/Q _6260_/D gf180mcu_as_sc_mcu7t3v3__mux2_2
X_4381_ VDD VDD VSS VSS _6222_/D _4381_/B _4381_/A gf180mcu_as_sc_mcu7t3v3__nand2_2
X_3401_ VDD VDD VSS VSS _4070_/B _3401_/B _6267_/Q gf180mcu_as_sc_mcu7t3v3__nor2_2
X_6120_ VDD VDD VSS VSS _6519_/CLK _6120_/D _6120_/Q gf180mcu_as_sc_mcu7t3v3__dfxtp_2
X_3332_ VDD VDD VSS VSS _3332_/A _3332_/B _3332_/C _3332_/D _3332_/Y gf180mcu_as_sc_mcu7t3v3__ao22_2
Xfanout709 VDD VDD VSS VSS _4144_/S _4146_/S gf180mcu_as_sc_mcu7t3v3__buff_12
X_6051_ VDD VDD VSS VSS _6520_/CLK _6051_/D _6051_/Q gf180mcu_as_sc_mcu7t3v3__dfxtp_2
X_3263_ VDD VDD VSS VSS _3290_/A _6528_/D _3263_/B _3288_/C gf180mcu_as_sc_mcu7t3v3__aoi21_2
XFILLER_227_702 VDD VDD VSS VSS gf180mcu_as_sc_mcu7t3v3__fillcap_8
XPHY_EDGE_ROW_20_2_Right_857 VDD VSS gf180mcu_as_sc_mcu7t3v3__tap_2
X_5002_ VDD VDD VSS VSS _5318_/B _5005_/A _5005_/B gf180mcu_as_sc_mcu7t3v3__nor2b_2
X_3194_ VDD VDD VSS VSS _3194_/A _4448_/B _3360_/A _3194_/D _3194_/Y gf180mcu_as_sc_mcu7t3v3__ao211_2
XFILLER_187_1234 VDD VDD VSS VSS gf180mcu_as_sc_mcu7t3v3__fill_1
XFILLER_207_492 VDD VDD VSS VSS gf180mcu_as_sc_mcu7t3v3__fillcap_16
XFILLER_228_1242 VDD VDD VSS VSS gf180mcu_as_sc_mcu7t3v3__fillcap_16
XFILLER_228_1264 VDD VDD VSS VSS gf180mcu_as_sc_mcu7t3v3__fill_1
X_5904_ VDD VDD VSS VSS _5904_/A _5922_/B _5930_/C _5904_/D _5905_/C gf180mcu_as_sc_mcu7t3v3__ao22_2
XTAP_TAPCELL_ROW_36_1_1339 VDD VSS gf180mcu_as_sc_mcu7t3v3__tap_2
XFILLER_14_27 VDD VDD VSS VSS gf180mcu_as_sc_mcu7t3v3__fillcap_8
XFILLER_222_451 VDD VDD VSS VSS gf180mcu_as_sc_mcu7t3v3__fillcap_4
XFILLER_223_974 VDD VDD VSS VSS gf180mcu_as_sc_mcu7t3v3__fillcap_4
X_5835_ VDD VDD VSS VSS _5859_/S _5835_/B _5835_/A _5836_/B gf180mcu_as_sc_mcu7t3v3__mux2_2
XFILLER_195_826 VDD VDD VSS VSS gf180mcu_as_sc_mcu7t3v3__fill_2
X_5766_ VDD VDD VSS VSS _5766_/A _5871_/B _5766_/C _5871_/D _5767_/D gf180mcu_as_sc_mcu7t3v3__ao22_2
X_5697_ VDD VDD VSS VSS _5801_/S _5697_/A _5702_/C gf180mcu_as_sc_mcu7t3v3__and2_2
X_4717_ VDD VDD VSS VSS _4717_/B _4826_/A _6347_/D gf180mcu_as_sc_mcu7t3v3__and2_2
XFILLER_163_734 VDD VDD VSS VSS gf180mcu_as_sc_mcu7t3v3__fillcap_16
XFILLER_194_1205 VDD VDD VSS VSS gf180mcu_as_sc_mcu7t3v3__fillcap_16
XFILLER_30_37 VDD VDD VSS VSS gf180mcu_as_sc_mcu7t3v3__fillcap_8
X_4648_ VDD VDD VSS VSS _4999_/B _4648_/A _4648_/B _4648_/C gf180mcu_as_sc_mcu7t3v3__ao21_2
XFILLER_146_37 VDD VDD VSS VSS gf180mcu_as_sc_mcu7t3v3__fillcap_8
XFILLER_194_1227 VDD VDD VSS VSS gf180mcu_as_sc_mcu7t3v3__fillcap_8
XTAP_TAPCELL_ROW_78_1_1360 VDD VSS gf180mcu_as_sc_mcu7t3v3__tap_2
XFILLER_116_661 VDD VDD VSS VSS gf180mcu_as_sc_mcu7t3v3__fillcap_4
XTAP_TAPCELL_ROW_151_1452 VDD VSS gf180mcu_as_sc_mcu7t3v3__tap_2
XTAP_TAPCELL_ROW_151_1463 VDD VSS gf180mcu_as_sc_mcu7t3v3__tap_2
X_4579_ VDD VDD VSS VSS _4579_/A _4579_/B _4579_/C _4580_/C _4579_/D gf180mcu_as_sc_mcu7t3v3__aoi211_2
X_6318_ VDD VDD VSS VSS _6551_/CLK _6318_/D _6318_/Q gf180mcu_as_sc_mcu7t3v3__dfxtp_2
XFILLER_131_664 VDD VDD VSS VSS gf180mcu_as_sc_mcu7t3v3__fill_2
XFILLER_162_14 VDD VDD VSS VSS gf180mcu_as_sc_mcu7t3v3__fill_2
X_6249_ VDD VDD VSS VSS _6313_/CLK _6249_/D _6249_/Q gf180mcu_as_sc_mcu7t3v3__dfxtp_2
Xmesh_tile_1108 VDD VDD VSS VSS nw_out[31] gf180mcu_as_sc_mcu7t3v3__tiel_4
XFILLER_162_69 VDD VDD VSS VSS gf180mcu_as_sc_mcu7t3v3__fillcap_16
Xmesh_tile_1119 VDD VDD VSS VSS se_out[6] gf180mcu_as_sc_mcu7t3v3__tiel_4
XFILLER_205_407 VDD VDD VSS VSS gf180mcu_as_sc_mcu7t3v3__fill_1
XTAP_TAPCELL_ROW_10_1194 VDD VSS gf180mcu_as_sc_mcu7t3v3__tap_2
XFILLER_13_512 VDD VDD VSS VSS gf180mcu_as_sc_mcu7t3v3__fill_1
XFILLER_198_653 VDD VDD VSS VSS gf180mcu_as_sc_mcu7t3v3__fillcap_8
XFILLER_214_963 VDD VDD VSS VSS gf180mcu_as_sc_mcu7t3v3__fillcap_16
XTAP_TAPCELL_ROW_193_2209 VDD VSS gf180mcu_as_sc_mcu7t3v3__tap_2
XFILLER_198_675 VDD VDD VSS VSS gf180mcu_as_sc_mcu7t3v3__fill_2
XFILLER_200_101 VDD VDD VSS VSS gf180mcu_as_sc_mcu7t3v3__fillcap_4
XFILLER_185_347 VDD VDD VSS VSS gf180mcu_as_sc_mcu7t3v3__fill_2
XFILLER_199_1116 VDD VDD VSS VSS gf180mcu_as_sc_mcu7t3v3__fillcap_4
XFILLER_200_156 VDD VDD VSS VSS gf180mcu_as_sc_mcu7t3v3__fillcap_8
XFILLER_90_1261 VDD VDD VSS VSS gf180mcu_as_sc_mcu7t3v3__fillcap_4
XPHY_EDGE_ROW_120_3_Right_200 VDD VSS gf180mcu_as_sc_mcu7t3v3__tap_2
XFILLER_166_550 VDD VDD VSS VSS gf180mcu_as_sc_mcu7t3v3__fill_1
XFILLER_173_509 VDD VDD VSS VSS gf180mcu_as_sc_mcu7t3v3__fillcap_8
XFILLER_187_88 VDD VDD VSS VSS gf180mcu_as_sc_mcu7t3v3__fillcap_4
XFILLER_199_1138 VDD VDD VSS VSS gf180mcu_as_sc_mcu7t3v3__fillcap_16
XFILLER_200_189 VDD VDD VSS VSS gf180mcu_as_sc_mcu7t3v3__fillcap_16
XFILLER_154_734 VDD VDD VSS VSS gf180mcu_as_sc_mcu7t3v3__fill_1
XTAP_TAPCELL_ROW_171_1817 VDD VSS gf180mcu_as_sc_mcu7t3v3__tap_2
XTAP_TAPCELL_ROW_171_1828 VDD VSS gf180mcu_as_sc_mcu7t3v3__tap_2
XFILLER_153_244 VDD VDD VSS VSS gf180mcu_as_sc_mcu7t3v3__fillcap_16
XFILLER_5_766 VDD VDD VSS VSS gf180mcu_as_sc_mcu7t3v3__fillcap_4
XTAP_TAPCELL_ROW_212_2559 VDD VSS gf180mcu_as_sc_mcu7t3v3__tap_2
XFILLER_171_1046 VDD VDD VSS VSS gf180mcu_as_sc_mcu7t3v3__fillcap_4
XFILLER_0_482 VDD VDD VSS VSS gf180mcu_as_sc_mcu7t3v3__fill_2
XFILLER_150_995 VDD VDD VSS VSS gf180mcu_as_sc_mcu7t3v3__fillcap_16
XFILLER_171_1068 VDD VDD VSS VSS gf180mcu_as_sc_mcu7t3v3__fillcap_16
XTAP_TAPCELL_ROW_169_1779 VDD VSS gf180mcu_as_sc_mcu7t3v3__tap_2
XFILLER_212_1065 VDD VDD VSS VSS gf180mcu_as_sc_mcu7t3v3__fillcap_16
Xmesh_tile VDD VDD VSS VSS ne_out[0] gf180mcu_as_sc_mcu7t3v3__tiel_4
XFILLER_212_1087 VDD VDD VSS VSS gf180mcu_as_sc_mcu7t3v3__fillcap_16
XFILLER_36_637 VDD VDD VSS VSS gf180mcu_as_sc_mcu7t3v3__fill_2
XFILLER_1_1154 VDD VDD VSS VSS gf180mcu_as_sc_mcu7t3v3__fillcap_16
X_3950_ VDD VDD VSS VSS _4031_/B _3962_/C _3963_/B _6054_/Q _6054_/D gf180mcu_as_sc_mcu7t3v3__ao22_2
XFILLER_188_174 VDD VDD VSS VSS gf180mcu_as_sc_mcu7t3v3__fill_1
XFILLER_189_697 VDD VDD VSS VSS gf180mcu_as_sc_mcu7t3v3__fill_2
XFILLER_204_473 VDD VDD VSS VSS gf180mcu_as_sc_mcu7t3v3__fillcap_8
XPHY_EDGE_ROW_27_3_Left_732 VDD VSS gf180mcu_as_sc_mcu7t3v3__tap_2
X_3881_ VDD VDD VSS VSS _3881_/B _5865_/A _3882_/B gf180mcu_as_sc_mcu7t3v3__or2_2
XFILLER_149_539 VDD VDD VSS VSS gf180mcu_as_sc_mcu7t3v3__fillcap_4
XFILLER_176_325 VDD VDD VSS VSS gf180mcu_as_sc_mcu7t3v3__fill_1
XFILLER_188_185 VDD VDD VSS VSS gf180mcu_as_sc_mcu7t3v3__fill_1
X_5620_ VDD VDD VSS VSS _5634_/B _5927_/A _5621_/D gf180mcu_as_sc_mcu7t3v3__and2_2
XFILLER_77_2 VDD VDD VSS VSS gf180mcu_as_sc_mcu7t3v3__fillcap_16
X_5551_ VDD VDD VSS VSS _5857_/D _5551_/B _5551_/C _5551_/D _5553_/C gf180mcu_as_sc_mcu7t3v3__ao211_2
XFILLER_157_594 VDD VDD VSS VSS gf180mcu_as_sc_mcu7t3v3__fill_2
XFILLER_172_520 VDD VDD VSS VSS gf180mcu_as_sc_mcu7t3v3__fillcap_4
X_4502_ VDD VDD VSS VSS _6295_/Q _4569_/D _4504_/C gf180mcu_as_sc_mcu7t3v3__or2_2
XFILLER_172_531 VDD VDD VSS VSS gf180mcu_as_sc_mcu7t3v3__fill_1
XFILLER_219_1208 VDD VDD VSS VSS gf180mcu_as_sc_mcu7t3v3__fillcap_16
X_5482_ VDD VDD VSS VSS _5791_/A _5491_/B _5491_/C _5790_/B _5483_/D gf180mcu_as_sc_mcu7t3v3__ao22_2
XFILLER_160_737 VDD VDD VSS VSS gf180mcu_as_sc_mcu7t3v3__fillcap_4
X_4433_ VDD VDD VSS VSS _6249_/Q _4446_/D _4446_/B _6248_/Q _6248_/D gf180mcu_as_sc_mcu7t3v3__ao22_2
XFILLER_113_620 VDD VDD VSS VSS gf180mcu_as_sc_mcu7t3v3__fillcap_4
XFILLER_28_1214 VDD VDD VSS VSS gf180mcu_as_sc_mcu7t3v3__fill_1
X_4364_ VDD VDD VSS VSS _6220_/Q _4406_/B _4406_/C _6221_/Q _4365_/C gf180mcu_as_sc_mcu7t3v3__ao22_2
XFILLER_113_664 VDD VDD VSS VSS gf180mcu_as_sc_mcu7t3v3__fill_2
Xfanout517 VDD VDD VSS VSS _4016_/Y _4044_/B gf180mcu_as_sc_mcu7t3v3__buff_12
Xfanout528 VDD VDD VSS VSS fanout531/Y _3895_/B gf180mcu_as_sc_mcu7t3v3__buff_12
Xfanout539 VDD VDD VSS VSS _5665_/Y _5926_/B gf180mcu_as_sc_mcu7t3v3__buff_12
X_6103_ VDD VDD VSS VSS _6125_/CLK _6103_/D _6103_/Q gf180mcu_as_sc_mcu7t3v3__dfxtp_2
X_4295_ VDD VDD VSS VSS _4297_/A _4295_/C _4407_/B _6161_/Q gf180mcu_as_sc_mcu7t3v3__aoi21_2
X_3315_ VDD VDD VSS VSS _3353_/A _3315_/B _3315_/C _3316_/C gf180mcu_as_sc_mcu7t3v3__nor3_2
XFILLER_150_1119 VDD VDD VSS VSS gf180mcu_as_sc_mcu7t3v3__fillcap_16
X_6034_ VDD VDD VSS VSS _6370_/CLK _6034_/D _6034_/Q gf180mcu_as_sc_mcu7t3v3__dfxtp_2
X_3246_ VDD VDD VSS VSS _3246_/Y _3246_/C _3299_/A _3246_/A gf180mcu_as_sc_mcu7t3v3__aoi21b_2
XPHY_EDGE_ROW_21_2_Right_858 VDD VSS gf180mcu_as_sc_mcu7t3v3__tap_2
XFILLER_6_1065 VDD VDD VSS VSS gf180mcu_as_sc_mcu7t3v3__fillcap_16
XFILLER_6_1087 VDD VDD VSS VSS gf180mcu_as_sc_mcu7t3v3__fillcap_16
X_3177_ VDD VDD VSS VSS _3177_/B _4146_/S _6532_/D gf180mcu_as_sc_mcu7t3v3__and2_2
XFILLER_74_1212 VDD VDD VSS VSS gf180mcu_as_sc_mcu7t3v3__fill_1
XFILLER_74_1245 VDD VDD VSS VSS gf180mcu_as_sc_mcu7t3v3__fillcap_16
XFILLER_195_612 VDD VDD VSS VSS gf180mcu_as_sc_mcu7t3v3__fill_1
XFILLER_228_1083 VDD VDD VSS VSS gf180mcu_as_sc_mcu7t3v3__fill_1
XFILLER_194_133 VDD VDD VSS VSS gf180mcu_as_sc_mcu7t3v3__fill_1
X_5818_ VDD VDD VSS VSS _5818_/A _5869_/B _5818_/C _5818_/D _5819_/B gf180mcu_as_sc_mcu7t3v3__ao211_2
XFILLER_176_870 VDD VDD VSS VSS gf180mcu_as_sc_mcu7t3v3__fillcap_4
XFILLER_210_465 VDD VDD VSS VSS gf180mcu_as_sc_mcu7t3v3__fillcap_4
XPHY_EDGE_ROW_18_2_Left_459 VDD VSS gf180mcu_as_sc_mcu7t3v3__tap_2
X_5749_ VDD VDD VSS VSS _5798_/S _5749_/B _6502_/Q _5750_/C gf180mcu_as_sc_mcu7t3v3__mux2_2
XFILLER_159_1100 VDD VDD VSS VSS gf180mcu_as_sc_mcu7t3v3__fillcap_16
XFILLER_182_317 VDD VDD VSS VSS gf180mcu_as_sc_mcu7t3v3__fillcap_8
XFILLER_194_188 VDD VDD VSS VSS gf180mcu_as_sc_mcu7t3v3__fillcap_4
XFILLER_194_199 VDD VDD VSS VSS gf180mcu_as_sc_mcu7t3v3__fillcap_16
XTAP_TAPCELL_ROW_153_1503 VDD VSS gf180mcu_as_sc_mcu7t3v3__tap_2
XFILLER_11_1240 VDD VDD VSS VSS gf180mcu_as_sc_mcu7t3v3__fillcap_16
XFILLER_159_1122 VDD VDD VSS VSS gf180mcu_as_sc_mcu7t3v3__fillcap_16
XFILLER_163_553 VDD VDD VSS VSS gf180mcu_as_sc_mcu7t3v3__fillcap_4
XFILLER_11_1262 VDD VDD VSS VSS gf180mcu_as_sc_mcu7t3v3__fill_2
XFILLER_150_225 VDD VDD VSS VSS gf180mcu_as_sc_mcu7t3v3__fillcap_16
XFILLER_150_247 VDD VDD VSS VSS gf180mcu_as_sc_mcu7t3v3__fillcap_16
XPHY_EDGE_ROW_132_2_Left_573 VDD VSS gf180mcu_as_sc_mcu7t3v3__tap_2
XFILLER_66_33 VDD VDD VSS VSS gf180mcu_as_sc_mcu7t3v3__fill_2
XTAP_TAPCELL_ROW_12_1223 VDD VSS gf180mcu_as_sc_mcu7t3v3__tap_2
XTAP_TAPCELL_ROW_12_1234 VDD VSS gf180mcu_as_sc_mcu7t3v3__tap_2
XFILLER_18_659 VDD VDD VSS VSS gf180mcu_as_sc_mcu7t3v3__fillcap_8
XTAP_TAPCELL_ROW_164_1687 VDD VSS gf180mcu_as_sc_mcu7t3v3__tap_2
XTAP_TAPCELL_ROW_164_1698 VDD VSS gf180mcu_as_sc_mcu7t3v3__tap_2
XFILLER_159_837 VDD VDD VSS VSS gf180mcu_as_sc_mcu7t3v3__fill_2
XFILLER_186_645 VDD VDD VSS VSS gf180mcu_as_sc_mcu7t3v3__fill_2
XPHY_EDGE_ROW_121_3_Right_201 VDD VSS gf180mcu_as_sc_mcu7t3v3__tap_2
XFILLER_139_594 VDD VDD VSS VSS gf180mcu_as_sc_mcu7t3v3__fillcap_16
XFILLER_154_597 VDD VDD VSS VSS gf180mcu_as_sc_mcu7t3v3__fillcap_16
XFILLER_181_394 VDD VDD VSS VSS gf180mcu_as_sc_mcu7t3v3__fill_2
XFILLER_218_1263 VDD VDD VSS VSS gf180mcu_as_sc_mcu7t3v3__fill_2
XTAP_TAPCELL_ROW_116_3_3023 VDD VSS gf180mcu_as_sc_mcu7t3v3__tap_2
X_3100_ VDD VDD VSS VSS _6310_/Q _6311_/Q _4108_/A gf180mcu_as_sc_mcu7t3v3__or2_2
XFILLER_110_645 VDD VDD VSS VSS gf180mcu_as_sc_mcu7t3v3__fillcap_8
X_4080_ VDD VDD VSS VSS _4085_/S _6717_/A _6140_/Q _6140_/D gf180mcu_as_sc_mcu7t3v3__mux2_2
XFILLER_114_1261 VDD VDD VSS VSS gf180mcu_as_sc_mcu7t3v3__fillcap_4
XFILLER_97_1212 VDD VDD VSS VSS gf180mcu_as_sc_mcu7t3v3__fill_1
Xinput180 VDD VDD VSS VSS nw_in[2] _5693_/A gf180mcu_as_sc_mcu7t3v3__buff_12
X_3031_ VDD VDD VSS VSS _3625_/B _5940_/A gf180mcu_as_sc_mcu7t3v3__inv_2
XFILLER_224_513 VDD VDD VSS VSS gf180mcu_as_sc_mcu7t3v3__fillcap_4
Xinput191 VDD VDD VSS VSS nw_in[7] _5735_/A gf180mcu_as_sc_mcu7t3v3__buff_12
XFILLER_24_629 VDD VDD VSS VSS gf180mcu_as_sc_mcu7t3v3__fillcap_8
X_4982_ VDD VDD VSS VSS _4982_/A _4982_/B _4982_/C _4982_/D _5250_/C gf180mcu_as_sc_mcu7t3v3__ao22_2
X_6721_ VDD VDD VSS VSS _6721_/A _6721_/Y gf180mcu_as_sc_mcu7t3v3__buff_2
X_3933_ VDD VDD VSS VSS _6044_/Q _3933_/B _4061_/B _3933_/D _6044_/D gf180mcu_as_sc_mcu7t3v3__ao22_2
XFILLER_189_494 VDD VDD VSS VSS gf180mcu_as_sc_mcu7t3v3__fill_1
XFILLER_225_1256 VDD VDD VSS VSS gf180mcu_as_sc_mcu7t3v3__fillcap_4
X_3864_ VDD VDD VSS VSS _5850_/A _3892_/B _3864_/C _3864_/D _3865_/C gf180mcu_as_sc_mcu7t3v3__ao211_2
XFILLER_176_155 VDD VDD VSS VSS gf180mcu_as_sc_mcu7t3v3__fillcap_4
XFILLER_220_774 VDD VDD VSS VSS gf180mcu_as_sc_mcu7t3v3__fillcap_4
X_5603_ VDD VDD VSS VSS _5911_/A _5632_/B _5632_/C _5915_/A _5605_/C gf180mcu_as_sc_mcu7t3v3__ao22_2
XFILLER_121_1210 VDD VDD VSS VSS gf180mcu_as_sc_mcu7t3v3__fillcap_4
XFILLER_164_317 VDD VDD VSS VSS gf180mcu_as_sc_mcu7t3v3__fillcap_8
XFILLER_176_177 VDD VDD VSS VSS gf180mcu_as_sc_mcu7t3v3__fill_2
XPHY_EDGE_ROW_128_1_Left_356 VDD VSS gf180mcu_as_sc_mcu7t3v3__tap_2
X_3795_ VDD VDD VSS VSS _3805_/B _5789_/A _3796_/D gf180mcu_as_sc_mcu7t3v3__and2_2
XFILLER_191_158 VDD VDD VSS VSS gf180mcu_as_sc_mcu7t3v3__fill_1
X_5534_ VDD VDD VSS VSS _5534_/S _5840_/A _5534_/A _5537_/A gf180mcu_as_sc_mcu7t3v3__mux2_2
X_5465_ VDD VDD VSS VSS _5465_/B _5578_/A _6424_/D gf180mcu_as_sc_mcu7t3v3__and2_2
XFILLER_160_534 VDD VDD VSS VSS gf180mcu_as_sc_mcu7t3v3__fill_2
XFILLER_191_1208 VDD VDD VSS VSS gf180mcu_as_sc_mcu7t3v3__fillcap_16
X_4416_ VDD VDD VSS VSS _6232_/Q _4422_/B _4425_/C _6231_/Q _6231_/D gf180mcu_as_sc_mcu7t3v3__ao22_2
XFILLER_207_72 VDD VDD VSS VSS gf180mcu_as_sc_mcu7t3v3__fillcap_16
X_5396_ VDD VDD VSS VSS _5396_/B _5396_/A _6416_/D gf180mcu_as_sc_mcu7t3v3__and2_2
X_4347_ VDD VDD VSS VSS _4348_/C _4349_/S _6031_/Q gf180mcu_as_sc_mcu7t3v3__nor2b_2
XFILLER_101_634 VDD VDD VSS VSS gf180mcu_as_sc_mcu7t3v3__fill_1
XFILLER_143_38 VDD VDD VSS VSS gf180mcu_as_sc_mcu7t3v3__fillcap_8
XFILLER_80_1260 VDD VDD VSS VSS gf180mcu_as_sc_mcu7t3v3__fillcap_4
X_4278_ VDD VDD VSS VSS _4404_/D _4278_/B _4278_/A _4279_/B gf180mcu_as_sc_mcu7t3v3__mux2_2
X_6017_ VDD VDD VSS VSS _6125_/CLK _6017_/D _6017_/Q gf180mcu_as_sc_mcu7t3v3__dfxtp_2
X_3229_ VDD VDD VSS VSS _6270_/Q _3229_/A _3238_/B gf180mcu_as_sc_mcu7t3v3__and2_2
XTAP_TAPCELL_ROW_9_1177 VDD VSS gf180mcu_as_sc_mcu7t3v3__tap_2
XPHY_EDGE_ROW_22_2_Right_859 VDD VSS gf180mcu_as_sc_mcu7t3v3__tap_2
XFILLER_15_629 VDD VDD VSS VSS gf180mcu_as_sc_mcu7t3v3__fill_1
XFILLER_14_139 VDD VDD VSS VSS gf180mcu_as_sc_mcu7t3v3__fillcap_16
XFILLER_153_6 VDD VDD VSS VSS gf180mcu_as_sc_mcu7t3v3__fillcap_16
XFILLER_165_1170 VDD VDD VSS VSS gf180mcu_as_sc_mcu7t3v3__fillcap_16
XFILLER_165_1192 VDD VDD VSS VSS gf180mcu_as_sc_mcu7t3v3__fillcap_16
XFILLER_168_623 VDD VDD VSS VSS gf180mcu_as_sc_mcu7t3v3__fill_1
XFILLER_195_431 VDD VDD VSS VSS gf180mcu_as_sc_mcu7t3v3__fillcap_4
XFILLER_196_932 VDD VDD VSS VSS gf180mcu_as_sc_mcu7t3v3__fillcap_8
XFILLER_156_818 VDD VDD VSS VSS gf180mcu_as_sc_mcu7t3v3__fillcap_16
XFILLER_168_667 VDD VDD VSS VSS gf180mcu_as_sc_mcu7t3v3__fillcap_4
XFILLER_195_442 VDD VDD VSS VSS gf180mcu_as_sc_mcu7t3v3__fillcap_8
XFILLER_7_806 VDD VDD VSS VSS gf180mcu_as_sc_mcu7t3v3__fillcap_4
XFILLER_149_881 VDD VDD VSS VSS gf180mcu_as_sc_mcu7t3v3__fill_2
XFILLER_182_103 VDD VDD VSS VSS gf180mcu_as_sc_mcu7t3v3__fill_2
XFILLER_196_1119 VDD VDD VSS VSS gf180mcu_as_sc_mcu7t3v3__fillcap_16
XFILLER_7_839 VDD VDD VSS VSS gf180mcu_as_sc_mcu7t3v3__fill_1
XFILLER_184_34 VDD VDD VSS VSS gf180mcu_as_sc_mcu7t3v3__fill_1
XFILLER_191_670 VDD VDD VSS VSS gf180mcu_as_sc_mcu7t3v3__fill_2
XTAP_TAPCELL_ROW_188_2119 VDD VSS gf180mcu_as_sc_mcu7t3v3__tap_2
XFILLER_151_523 VDD VDD VSS VSS gf180mcu_as_sc_mcu7t3v3__fillcap_4
XFILLER_151_534 VDD VDD VSS VSS gf180mcu_as_sc_mcu7t3v3__fillcap_4
XFILLER_151_589 VDD VDD VSS VSS gf180mcu_as_sc_mcu7t3v3__fillcap_8
XTAP_TAPCELL_ROW_166_1727 VDD VSS gf180mcu_as_sc_mcu7t3v3__tap_2
XTAP_TAPCELL_ROW_166_1738 VDD VSS gf180mcu_as_sc_mcu7t3v3__tap_2
Xfanout870 VDD VDD VSS VSS _4148_/B _3296_/B gf180mcu_as_sc_mcu7t3v3__buff_12
Xfanout881 VDD VDD VSS VSS _4093_/S _4089_/S gf180mcu_as_sc_mcu7t3v3__buff_12
Xfanout892 VDD VDD VSS VSS fanout894/Y _4404_/D gf180mcu_as_sc_mcu7t3v3__buff_12
XTAP_TAPCELL_ROW_207_2469 VDD VSS gf180mcu_as_sc_mcu7t3v3__tap_2
XFILLER_206_524 VDD VDD VSS VSS gf180mcu_as_sc_mcu7t3v3__fill_1
XTAP_TAPCELL_ROW_224_2772 VDD VSS gf180mcu_as_sc_mcu7t3v3__tap_2
XFILLER_144_1210 VDD VDD VSS VSS gf180mcu_as_sc_mcu7t3v3__fillcap_16
XFILLER_202_741 VDD VDD VSS VSS gf180mcu_as_sc_mcu7t3v3__fill_1
XFILLER_158_155 VDD VDD VSS VSS gf180mcu_as_sc_mcu7t3v3__fillcap_16
XFILLER_187_976 VDD VDD VSS VSS gf180mcu_as_sc_mcu7t3v3__fillcap_4
XFILLER_158_177 VDD VDD VSS VSS gf180mcu_as_sc_mcu7t3v3__fillcap_16
XFILLER_187_998 VDD VDD VSS VSS gf180mcu_as_sc_mcu7t3v3__fillcap_16
XFILLER_173_136 VDD VDD VSS VSS gf180mcu_as_sc_mcu7t3v3__fillcap_4
XPHY_EDGE_ROW_122_3_Right_202 VDD VSS gf180mcu_as_sc_mcu7t3v3__tap_2
X_3580_ VDD VDD VSS VSS _3582_/D _4239_/A _5912_/D gf180mcu_as_sc_mcu7t3v3__nor2b_2
XFILLER_173_158 VDD VDD VSS VSS gf180mcu_as_sc_mcu7t3v3__fill_2
XFILLER_177_1052 VDD VDD VSS VSS gf180mcu_as_sc_mcu7t3v3__fillcap_16
X_5250_ VDD VDD VSS VSS _5250_/A _5252_/A _5250_/C _5309_/B gf180mcu_as_sc_mcu7t3v3__nor3_2
X_4201_ VDD VDD VSS VSS _4404_/D _4201_/B _4201_/A _4203_/B gf180mcu_as_sc_mcu7t3v3__mux2_2
X_5181_ VDD VDD VSS VSS _5190_/S _5835_/A _5181_/A _5182_/B gf180mcu_as_sc_mcu7t3v3__mux2_2
XFILLER_228_104 VDD VDD VSS VSS gf180mcu_as_sc_mcu7t3v3__fillcap_4
X_4132_ VDD VDD VSS VSS _4135_/S _6182_/Q _6181_/Q _6181_/D gf180mcu_as_sc_mcu7t3v3__mux2_2
X_4063_ VDD VDD VSS VSS _4178_/A _6492_/Q _5963_/B gf180mcu_as_sc_mcu7t3v3__and2_2
X_3014_ VDD VDD VSS VSS _5295_/A _3570_/B gf180mcu_as_sc_mcu7t3v3__inv_2
XFILLER_3_1046 VDD VDD VSS VSS gf180mcu_as_sc_mcu7t3v3__fillcap_4
XFILLER_3_1068 VDD VDD VSS VSS gf180mcu_as_sc_mcu7t3v3__fillcap_16
XTAP_TAPCELL_ROW_4_1085 VDD VSS gf180mcu_as_sc_mcu7t3v3__tap_2
XFILLER_212_527 VDD VDD VSS VSS gf180mcu_as_sc_mcu7t3v3__fillcap_16
XFILLER_224_387 VDD VDD VSS VSS gf180mcu_as_sc_mcu7t3v3__fillcap_8
X_4965_ VDD VDD VSS VSS _4965_/S _4965_/B _5955_/A _4966_/B gf180mcu_as_sc_mcu7t3v3__mux2_2
X_3916_ VDD VDD VSS VSS _3918_/C _5898_/A _3925_/C _3916_/C gf180mcu_as_sc_mcu7t3v3__ao21_2
XFILLER_178_987 VDD VDD VSS VSS gf180mcu_as_sc_mcu7t3v3__fillcap_16
X_4896_ VDD VDD VSS VSS _4932_/A _4896_/A _4963_/B gf180mcu_as_sc_mcu7t3v3__and2_2
XFILLER_192_412 VDD VDD VSS VSS gf180mcu_as_sc_mcu7t3v3__fill_2
XFILLER_20_665 VDD VDD VSS VSS gf180mcu_as_sc_mcu7t3v3__fill_2
XFILLER_22_27 VDD VDD VSS VSS gf180mcu_as_sc_mcu7t3v3__fillcap_8
XFILLER_22_49 VDD VDD VSS VSS gf180mcu_as_sc_mcu7t3v3__fill_2
X_3847_ VDD VDD VSS VSS _5835_/A _3932_/B _3847_/C _3847_/D _4047_/B gf180mcu_as_sc_mcu7t3v3__ao211_2
XFILLER_138_49 VDD VDD VSS VSS gf180mcu_as_sc_mcu7t3v3__fill_2
XFILLER_165_659 VDD VDD VSS VSS gf180mcu_as_sc_mcu7t3v3__fillcap_4
XFILLER_193_957 VDD VDD VSS VSS gf180mcu_as_sc_mcu7t3v3__fillcap_16
XFILLER_193_979 VDD VDD VSS VSS gf180mcu_as_sc_mcu7t3v3__fill_1
X_3778_ VDD VDD VSS VSS _5772_/A _3891_/B _3778_/C _3778_/D _3780_/C gf180mcu_as_sc_mcu7t3v3__ao211_2
XFILLER_180_607 VDD VDD VSS VSS gf180mcu_as_sc_mcu7t3v3__fill_2
X_5517_ VDD VDD VSS VSS _5825_/A _5569_/B _5517_/C _5517_/D _5518_/D gf180mcu_as_sc_mcu7t3v3__ao211_2
XFILLER_156_1103 VDD VDD VSS VSS gf180mcu_as_sc_mcu7t3v3__fillcap_16
X_6497_ VDD VDD VSS VSS _6517_/CLK _6497_/D _6497_/Q gf180mcu_as_sc_mcu7t3v3__dfxtp_2
XTAP_TAPCELL_ROW_92_3_2987 VDD VSS gf180mcu_as_sc_mcu7t3v3__tap_2
XFILLER_154_37 VDD VDD VSS VSS gf180mcu_as_sc_mcu7t3v3__fillcap_16
XFILLER_161_854 VDD VDD VSS VSS gf180mcu_as_sc_mcu7t3v3__fill_2
XFILLER_218_93 VDD VDD VSS VSS gf180mcu_as_sc_mcu7t3v3__fillcap_4
Xoutput462 VDD VDD VSS VSS _6465_/Q west_out[16] gf180mcu_as_sc_mcu7t3v3__buff_12
Xoutput451 VDD VDD VSS VSS _6383_/Q south_out[6] gf180mcu_as_sc_mcu7t3v3__buff_12
Xoutput440 VDD VDD VSS VSS _6406_/Q south_out[29] gf180mcu_as_sc_mcu7t3v3__buff_12
X_5448_ VDD VDD VSS VSS _6422_/D _5804_/D _5448_/B _5448_/A gf180mcu_as_sc_mcu7t3v3__aoi21_2
Xoutput484 VDD VDD VSS VSS _6452_/Q west_out[3] gf180mcu_as_sc_mcu7t3v3__buff_12
Xoutput473 VDD VDD VSS VSS _6475_/Q west_out[26] gf180mcu_as_sc_mcu7t3v3__buff_12
X_5379_ VDD VDD VSS VSS _5685_/A _5495_/B _5379_/C _5379_/D _5380_/B gf180mcu_as_sc_mcu7t3v3__ao211_2
XFILLER_87_643 VDD VDD VSS VSS gf180mcu_as_sc_mcu7t3v3__fill_1
XTAP_TAPCELL_ROW_183_2038 VDD VSS gf180mcu_as_sc_mcu7t3v3__tap_2
XTAP_TAPCELL_ROW_183_2027 VDD VSS gf180mcu_as_sc_mcu7t3v3__tap_2
XFILLER_170_69 VDD VDD VSS VSS gf180mcu_as_sc_mcu7t3v3__fillcap_16
XTAP_TAPCELL_ROW_161_1635 VDD VSS gf180mcu_as_sc_mcu7t3v3__tap_2
XFILLER_227_192 VDD VDD VSS VSS gf180mcu_as_sc_mcu7t3v3__fillcap_4
XTAP_TAPCELL_ROW_161_1646 VDD VSS gf180mcu_as_sc_mcu7t3v3__tap_2
XFILLER_15_448 VDD VDD VSS VSS gf180mcu_as_sc_mcu7t3v3__fill_1
XFILLER_63_45 VDD VDD VSS VSS gf180mcu_as_sc_mcu7t3v3__fillcap_4
XTAP_TAPCELL_ROW_202_2377 VDD VSS gf180mcu_as_sc_mcu7t3v3__tap_2
XFILLER_203_549 VDD VDD VSS VSS gf180mcu_as_sc_mcu7t3v3__fill_1
XFILLER_11_632 VDD VDD VSS VSS gf180mcu_as_sc_mcu7t3v3__fillcap_8
XFILLER_156_604 VDD VDD VSS VSS gf180mcu_as_sc_mcu7t3v3__fillcap_4
XFILLER_168_453 VDD VDD VSS VSS gf180mcu_as_sc_mcu7t3v3__fill_2
XFILLER_169_965 VDD VDD VSS VSS gf180mcu_as_sc_mcu7t3v3__fill_2
XFILLER_196_762 VDD VDD VSS VSS gf180mcu_as_sc_mcu7t3v3__fill_2
XFILLER_195_250 VDD VDD VSS VSS gf180mcu_as_sc_mcu7t3v3__fill_2
XTAP_TAPCELL_ROW_159_1597 VDD VSS gf180mcu_as_sc_mcu7t3v3__tap_2
Xwire512 VDD VDD VSS VSS _3317_/Y wire512/Y gf180mcu_as_sc_mcu7t3v3__clkbuff_12
XFILLER_11_687 VDD VDD VSS VSS gf180mcu_as_sc_mcu7t3v3__fill_2
XFILLER_155_136 VDD VDD VSS VSS gf180mcu_as_sc_mcu7t3v3__fillcap_4
XFILLER_183_445 VDD VDD VSS VSS gf180mcu_as_sc_mcu7t3v3__fillcap_4
XFILLER_195_33 VDD VDD VSS VSS gf180mcu_as_sc_mcu7t3v3__fillcap_16
XFILLER_7_636 VDD VDD VSS VSS gf180mcu_as_sc_mcu7t3v3__fill_1
XFILLER_13_1154 VDD VDD VSS VSS gf180mcu_as_sc_mcu7t3v3__fillcap_16
XFILLER_155_158 VDD VDD VSS VSS gf180mcu_as_sc_mcu7t3v3__fillcap_16
XFILLER_183_489 VDD VDD VSS VSS gf180mcu_as_sc_mcu7t3v3__fill_1
XFILLER_195_88 VDD VDD VSS VSS gf180mcu_as_sc_mcu7t3v3__fillcap_8
XFILLER_170_139 VDD VDD VSS VSS gf180mcu_as_sc_mcu7t3v3__fillcap_16
XTAP_TAPCELL_ROW_209_2509 VDD VSS gf180mcu_as_sc_mcu7t3v3__tap_2
XPHY_EDGE_ROW_36_3_Left_741 VDD VSS gf180mcu_as_sc_mcu7t3v3__tap_2
XTAP_TAPCELL_ROW_226_2812 VDD VSS gf180mcu_as_sc_mcu7t3v3__tap_2
XTAP_TAPCELL_ROW_226_2801 VDD VSS gf180mcu_as_sc_mcu7t3v3__tap_2
XFILLER_24_1261 VDD VDD VSS VSS gf180mcu_as_sc_mcu7t3v3__fillcap_4
XFILLER_111_1253 VDD VDD VSS VSS gf180mcu_as_sc_mcu7t3v3__fillcap_8
XFILLER_15_960 VDD VDD VSS VSS gf180mcu_as_sc_mcu7t3v3__fillcap_16
XFILLER_15_982 VDD VDD VSS VSS gf180mcu_as_sc_mcu7t3v3__fillcap_16
XFILLER_14_492 VDD VDD VSS VSS gf180mcu_as_sc_mcu7t3v3__fillcap_4
X_4750_ VDD VDD VSS VSS _5761_/A _4863_/B _4750_/C _4750_/D _4751_/B gf180mcu_as_sc_mcu7t3v3__ao211_2
XFILLER_159_475 VDD VDD VSS VSS gf180mcu_as_sc_mcu7t3v3__fillcap_8
XFILLER_222_1259 VDD VDD VSS VSS gf180mcu_as_sc_mcu7t3v3__fillcap_4
X_4681_ VDD VDD VSS VSS _5699_/B _4784_/B _4774_/C _5700_/A _4682_/D gf180mcu_as_sc_mcu7t3v3__ao22_2
X_3701_ VDD VDD VSS VSS _5710_/A _3808_/B _3807_/S _5710_/D _3702_/D gf180mcu_as_sc_mcu7t3v3__ao22_2
XFILLER_31_1210 VDD VDD VSS VSS gf180mcu_as_sc_mcu7t3v3__fillcap_4
XTAP_TAPCELL_ROW_104_3_3005 VDD VSS gf180mcu_as_sc_mcu7t3v3__tap_2
X_6420_ VDD VDD VSS VSS _6437_/CLK _6420_/D _6420_/Q gf180mcu_as_sc_mcu7t3v3__dfxtp_2
X_3632_ VDD VDD VSS VSS _3632_/B _5339_/A _3634_/C gf180mcu_as_sc_mcu7t3v3__xnor2_2
XPHY_EDGE_ROW_123_3_Right_203 VDD VSS gf180mcu_as_sc_mcu7t3v3__tap_2
X_6351_ VDD VDD VSS VSS _6365_/CLK _6351_/D _6351_/Q gf180mcu_as_sc_mcu7t3v3__dfxtp_2
X_5302_ VDD VDD VSS VSS _5302_/A _5312_/B _5302_/C _5302_/D _5303_/B gf180mcu_as_sc_mcu7t3v3__ao22_2
X_3563_ VDD VDD VSS VSS _4619_/B _4272_/A _5302_/A gf180mcu_as_sc_mcu7t3v3__nand2b_2
XFILLER_5_190 VDD VDD VSS VSS gf180mcu_as_sc_mcu7t3v3__fillcap_16
X_6282_ VDD VDD VSS VSS clkload5/A _6282_/D _6282_/Q gf180mcu_as_sc_mcu7t3v3__dfxtp_2
X_3494_ VDD VDD VSS VSS _3494_/B _5346_/B _3653_/A gf180mcu_as_sc_mcu7t3v3__or2_2
X_5233_ VDD VDD VSS VSS _5233_/A _5263_/B _5233_/C _5234_/C _5233_/D gf180mcu_as_sc_mcu7t3v3__aoi211_2
X_5164_ VDD VDD VSS VSS _5164_/B _5164_/A _6394_/D gf180mcu_as_sc_mcu7t3v3__and2_2
X_4115_ VDD VDD VSS VSS _4115_/S _4115_/B _6164_/Q _6164_/D gf180mcu_as_sc_mcu7t3v3__mux2_2
XPHY_EDGE_ROW_27_2_Left_468 VDD VSS gf180mcu_as_sc_mcu7t3v3__tap_2
X_5095_ VDD VDD VSS VSS _5096_/D _5206_/B _5205_/B _5757_/B gf180mcu_as_sc_mcu7t3v3__aoi21b_2
XTAP_TAPCELL_ROW_6_1125 VDD VSS gf180mcu_as_sc_mcu7t3v3__tap_2
XTAP_TAPCELL_ROW_6_1114 VDD VSS gf180mcu_as_sc_mcu7t3v3__tap_2
XFILLER_17_27 VDD VDD VSS VSS gf180mcu_as_sc_mcu7t3v3__fillcap_16
X_4046_ VDD VDD VSS VSS _4060_/B _6122_/Q _4047_/D gf180mcu_as_sc_mcu7t3v3__and2_2
XFILLER_209_192 VDD VDD VSS VSS gf180mcu_as_sc_mcu7t3v3__fill_2
XFILLER_212_313 VDD VDD VSS VSS gf180mcu_as_sc_mcu7t3v3__fill_2
X_5997_ VDD VDD VSS VSS _6011_/B _6220_/Q _6510_/D gf180mcu_as_sc_mcu7t3v3__and2_2
XFILLER_162_1151 VDD VDD VSS VSS gf180mcu_as_sc_mcu7t3v3__fillcap_4
XPHY_EDGE_ROW_89_2_Left_530 VDD VSS gf180mcu_as_sc_mcu7t3v3__tap_2
X_4948_ VDD VDD VSS VSS _5938_/B _4948_/B _4948_/C _4948_/D _4949_/D gf180mcu_as_sc_mcu7t3v3__ao22_2
XFILLER_162_1173 VDD VDD VSS VSS gf180mcu_as_sc_mcu7t3v3__fillcap_16
XFILLER_165_412 VDD VDD VSS VSS gf180mcu_as_sc_mcu7t3v3__fillcap_8
XFILLER_184_209 VDD VDD VSS VSS gf180mcu_as_sc_mcu7t3v3__fillcap_8
X_4879_ VDD VDD VSS VSS _4879_/D _4889_/A _4879_/B _4879_/C _4883_/B gf180mcu_as_sc_mcu7t3v3__ao31_2
XFILLER_228_8 VDD VDD VSS VSS gf180mcu_as_sc_mcu7t3v3__fill_1
XPHY_EDGE_ROW_141_2_Left_582 VDD VSS gf180mcu_as_sc_mcu7t3v3__tap_2
XFILLER_153_629 VDD VDD VSS VSS gf180mcu_as_sc_mcu7t3v3__fill_1
XFILLER_181_916 VDD VDD VSS VSS gf180mcu_as_sc_mcu7t3v3__fill_1
XFILLER_203_1170 VDD VDD VSS VSS gf180mcu_as_sc_mcu7t3v3__fillcap_16
XFILLER_203_1192 VDD VDD VSS VSS gf180mcu_as_sc_mcu7t3v3__fillcap_16
XFILLER_152_139 VDD VDD VSS VSS gf180mcu_as_sc_mcu7t3v3__fillcap_16
XFILLER_180_448 VDD VDD VSS VSS gf180mcu_as_sc_mcu7t3v3__fillcap_4
XFILLER_4_639 VDD VDD VSS VSS gf180mcu_as_sc_mcu7t3v3__fill_1
X_6549_ VDD VDD VSS VSS clkload9/A _6549_/D _6549_/Q gf180mcu_as_sc_mcu7t3v3__dfxtp_2
XFILLER_165_69 VDD VDD VSS VSS gf180mcu_as_sc_mcu7t3v3__fill_1
XFILLER_3_138 VDD VDD VSS VSS gf180mcu_as_sc_mcu7t3v3__fill_2
XFILLER_0_856 VDD VDD VSS VSS gf180mcu_as_sc_mcu7t3v3__fill_1
XFILLER_58_45 VDD VDD VSS VSS gf180mcu_as_sc_mcu7t3v3__fillcap_4
XFILLER_134_1242 VDD VDD VSS VSS gf180mcu_as_sc_mcu7t3v3__fill_1
XFILLER_181_35 VDD VDD VSS VSS gf180mcu_as_sc_mcu7t3v3__fill_1
Xwire1023 VDD VDD VSS VSS wire1023/A _5693_/D gf180mcu_as_sc_mcu7t3v3__clkbuff_12
XTAP_TAPCELL_ROW_204_2406 VDD VSS gf180mcu_as_sc_mcu7t3v3__tap_2
XTAP_TAPCELL_ROW_204_2417 VDD VSS gf180mcu_as_sc_mcu7t3v3__tap_2
XTAP_TAPCELL_ROW_221_2720 VDD VSS gf180mcu_as_sc_mcu7t3v3__tap_2
XFILLER_15_212 VDD VDD VSS VSS gf180mcu_as_sc_mcu7t3v3__fillcap_16
XFILLER_167_1084 VDD VDD VSS VSS gf180mcu_as_sc_mcu7t3v3__fillcap_16
XFILLER_12_941 VDD VDD VSS VSS gf180mcu_as_sc_mcu7t3v3__fillcap_4
XTAP_TAPCELL_ROW_178_1951 VDD VSS gf180mcu_as_sc_mcu7t3v3__tap_2
XTAP_TAPCELL_ROW_178_1940 VDD VSS gf180mcu_as_sc_mcu7t3v3__tap_2
XFILLER_12_963 VDD VDD VSS VSS gf180mcu_as_sc_mcu7t3v3__fillcap_16
XFILLER_156_401 VDD VDD VSS VSS gf180mcu_as_sc_mcu7t3v3__fillcap_4
XFILLER_175_209 VDD VDD VSS VSS gf180mcu_as_sc_mcu7t3v3__fill_1
XFILLER_208_1081 VDD VDD VSS VSS gf180mcu_as_sc_mcu7t3v3__fillcap_4
XFILLER_168_294 VDD VDD VSS VSS gf180mcu_as_sc_mcu7t3v3__fillcap_4
XFILLER_7_422 VDD VDD VSS VSS gf180mcu_as_sc_mcu7t3v3__fillcap_8
XTAP_TAPCELL_ROW_219_2682 VDD VSS gf180mcu_as_sc_mcu7t3v3__tap_2
XFILLER_144_629 VDD VDD VSS VSS gf180mcu_as_sc_mcu7t3v3__fillcap_8
XFILLER_157_979 VDD VDD VSS VSS gf180mcu_as_sc_mcu7t3v3__fill_1
XFILLER_156_489 VDD VDD VSS VSS gf180mcu_as_sc_mcu7t3v3__fillcap_8
XFILLER_174_1033 VDD VDD VSS VSS gf180mcu_as_sc_mcu7t3v3__fillcap_16
XFILLER_215_1030 VDD VDD VSS VSS gf180mcu_as_sc_mcu7t3v3__fillcap_16
XFILLER_215_1052 VDD VDD VSS VSS gf180mcu_as_sc_mcu7t3v3__fillcap_16
XFILLER_2_193 VDD VDD VSS VSS gf180mcu_as_sc_mcu7t3v3__fill_2
XFILLER_226_438 VDD VDD VSS VSS gf180mcu_as_sc_mcu7t3v3__fillcap_8
XFILLER_207_652 VDD VDD VSS VSS gf180mcu_as_sc_mcu7t3v3__fill_2
XPHY_EDGE_ROW_137_1_Left_365 VDD VSS gf180mcu_as_sc_mcu7t3v3__tap_2
X_5920_ VDD VDD VSS VSS _5951_/B _5920_/A _5922_/C gf180mcu_as_sc_mcu7t3v3__and2_2
XFILLER_0_1049 VDD VDD VSS VSS gf180mcu_as_sc_mcu7t3v3__fill_1
XFILLER_0_74 VDD VDD VSS VSS gf180mcu_as_sc_mcu7t3v3__fill_2
XFILLER_179_504 VDD VDD VSS VSS gf180mcu_as_sc_mcu7t3v3__fill_2
XFILLER_207_696 VDD VDD VSS VSS gf180mcu_as_sc_mcu7t3v3__fillcap_4
XTAP_TAPCELL_ROW_1_1033 VDD VSS gf180mcu_as_sc_mcu7t3v3__tap_2
X_5851_ VDD VDD VSS VSS _5875_/S _5851_/B _5851_/A _5852_/B gf180mcu_as_sc_mcu7t3v3__mux2_2
XFILLER_15_790 VDD VDD VSS VSS gf180mcu_as_sc_mcu7t3v3__fill_1
XPHY_EDGE_ROW_74_1_Left_302 VDD VSS gf180mcu_as_sc_mcu7t3v3__tap_2
X_5782_ VDD VDD VSS VSS _5838_/S _5782_/B _6506_/Q _5783_/C gf180mcu_as_sc_mcu7t3v3__mux2_2
X_4802_ VDD VDD VSS VSS _4803_/C _4887_/B _5810_/D gf180mcu_as_sc_mcu7t3v3__nor2_2
XFILLER_9_72 VDD VDD VSS VSS gf180mcu_as_sc_mcu7t3v3__fillcap_16
X_4733_ VDD VDD VSS VSS _4864_/S _4733_/B _5746_/A _4734_/B gf180mcu_as_sc_mcu7t3v3__mux2_2
XFILLER_174_220 VDD VDD VSS VSS gf180mcu_as_sc_mcu7t3v3__fill_1
XFILLER_187_581 VDD VDD VSS VSS gf180mcu_as_sc_mcu7t3v3__fill_1
XFILLER_190_702 VDD VDD VSS VSS gf180mcu_as_sc_mcu7t3v3__fill_2
X_6403_ VDD VDD VSS VSS _6412_/CLK _6403_/D _6403_/Q gf180mcu_as_sc_mcu7t3v3__dfxtp_2
X_4664_ VDD VDD VSS VSS _4719_/B _5684_/A _4665_/D gf180mcu_as_sc_mcu7t3v3__and2_2
XFILLER_175_798 VDD VDD VSS VSS gf180mcu_as_sc_mcu7t3v3__fill_2
X_4595_ VDD VDD VSS VSS _4595_/B _6335_/Q _4596_/C gf180mcu_as_sc_mcu7t3v3__xnor2_2
X_3615_ VDD VDD VSS VSS _3616_/C _3653_/A _3615_/A gf180mcu_as_sc_mcu7t3v3__nor2_2
XPHY_EDGE_ROW_124_3_Right_204 VDD VSS gf180mcu_as_sc_mcu7t3v3__tap_2
X_6334_ VDD VDD VSS VSS _6551_/CLK _6334_/D _6334_/Q gf180mcu_as_sc_mcu7t3v3__dfxtp_2
X_3546_ VDD VDD VSS VSS _4973_/C _3546_/B _3546_/C _3546_/Y gf180mcu_as_sc_mcu7t3v3__nor3_2
XFILLER_0_108 VDD VDD VSS VSS gf180mcu_as_sc_mcu7t3v3__fill_2
XFILLER_118_1226 VDD VDD VSS VSS gf180mcu_as_sc_mcu7t3v3__fillcap_16
XFILLER_157_1264 VDD VDD VSS VSS gf180mcu_as_sc_mcu7t3v3__fill_1
XFILLER_171_982 VDD VDD VSS VSS gf180mcu_as_sc_mcu7t3v3__fillcap_16
X_6265_ VDD VDD VSS VSS clkload9/A _6265_/D _6265_/Q gf180mcu_as_sc_mcu7t3v3__dfxtp_2
XFILLER_9_1030 VDD VDD VSS VSS gf180mcu_as_sc_mcu7t3v3__fillcap_16
X_5216_ VDD VDD VSS VSS _5216_/D _5297_/A _5216_/B _5216_/C _5217_/A gf180mcu_as_sc_mcu7t3v3__ao31_2
X_3477_ VDD VDD VSS VSS _4239_/A _3477_/B _3477_/C _3598_/B _5345_/A gf180mcu_as_sc_mcu7t3v3__ao22_2
XFILLER_9_1052 VDD VDD VSS VSS gf180mcu_as_sc_mcu7t3v3__fillcap_16
X_6196_ VDD VDD VSS VSS _6368_/CLK _6196_/D _6196_/Q gf180mcu_as_sc_mcu7t3v3__dfxtp_2
XFILLER_215_72 VDD VDD VSS VSS gf180mcu_as_sc_mcu7t3v3__fillcap_16
XFILLER_28_37 VDD VDD VSS VSS gf180mcu_as_sc_mcu7t3v3__fillcap_8
XFILLER_57_635 VDD VDD VSS VSS gf180mcu_as_sc_mcu7t3v3__fill_2
X_5147_ VDD VDD VSS VSS _5148_/D _5810_/D _5221_/B _5195_/B gf180mcu_as_sc_mcu7t3v3__ao21_2
XFILLER_151_38 VDD VDD VSS VSS gf180mcu_as_sc_mcu7t3v3__fillcap_16
XPHY_EDGE_ROW_69_1_Left_297 VDD VSS gf180mcu_as_sc_mcu7t3v3__tap_2
X_5078_ VDD VDD VSS VSS _5744_/A _5207_/B _5143_/C _5739_/A _5079_/D gf180mcu_as_sc_mcu7t3v3__ao22_2
XFILLER_77_1210 VDD VDD VSS VSS gf180mcu_as_sc_mcu7t3v3__fill_2
X_4029_ VDD VDD VSS VSS _6110_/Q _4044_/B _4029_/C _4029_/D _6110_/D gf180mcu_as_sc_mcu7t3v3__ao22_2
XFILLER_226_972 VDD VDD VSS VSS gf180mcu_as_sc_mcu7t3v3__fillcap_16
XFILLER_198_835 VDD VDD VSS VSS gf180mcu_as_sc_mcu7t3v3__fillcap_4
XTAP_TAPCELL_ROW_195_2251 VDD VSS gf180mcu_as_sc_mcu7t3v3__tap_2
XFILLER_205_1232 VDD VDD VSS VSS gf180mcu_as_sc_mcu7t3v3__fill_2
XFILLER_212_187 VDD VDD VSS VSS gf180mcu_as_sc_mcu7t3v3__fill_1
XFILLER_213_699 VDD VDD VSS VSS gf180mcu_as_sc_mcu7t3v3__fill_1
XTAP_TAPCELL_ROW_80_3_2969 VDD VSS gf180mcu_as_sc_mcu7t3v3__tap_2
XFILLER_14_1260 VDD VDD VSS VSS gf180mcu_as_sc_mcu7t3v3__fillcap_4
XFILLER_154_927 VDD VDD VSS VSS gf180mcu_as_sc_mcu7t3v3__fillcap_8
XTAP_TAPCELL_ROW_156_1545 VDD VSS gf180mcu_as_sc_mcu7t3v3__tap_2
XTAP_TAPCELL_ROW_156_1556 VDD VSS gf180mcu_as_sc_mcu7t3v3__tap_2
XFILLER_126_629 VDD VDD VSS VSS gf180mcu_as_sc_mcu7t3v3__fillcap_8
XFILLER_158_1017 VDD VDD VSS VSS gf180mcu_as_sc_mcu7t3v3__fillcap_16
XFILLER_10_1135 VDD VDD VSS VSS gf180mcu_as_sc_mcu7t3v3__fillcap_16
XFILLER_10_1157 VDD VDD VSS VSS gf180mcu_as_sc_mcu7t3v3__fillcap_16
XTAP_TAPCELL_ROW_214_2590 VDD VSS gf180mcu_as_sc_mcu7t3v3__tap_2
XFILLER_180_267 VDD VDD VSS VSS gf180mcu_as_sc_mcu7t3v3__fill_1
XFILLER_192_23 VDD VDD VSS VSS gf180mcu_as_sc_mcu7t3v3__fillcap_8
XFILLER_69_44 VDD VDD VSS VSS gf180mcu_as_sc_mcu7t3v3__fillcap_4
XFILLER_0_686 VDD VDD VSS VSS gf180mcu_as_sc_mcu7t3v3__fill_1
XFILLER_209_939 VDD VDD VSS VSS gf180mcu_as_sc_mcu7t3v3__fillcap_16
XTAP_TAPCELL_ROW_15_1276 VDD VSS gf180mcu_as_sc_mcu7t3v3__tap_2
XTAP_TAPCELL_ROW_15_1287 VDD VSS gf180mcu_as_sc_mcu7t3v3__tap_2
XFILLER_16_543 VDD VDD VSS VSS gf180mcu_as_sc_mcu7t3v3__fill_1
XFILLER_217_972 VDD VDD VSS VSS gf180mcu_as_sc_mcu7t3v3__fillcap_8
XFILLER_204_644 VDD VDD VSS VSS gf180mcu_as_sc_mcu7t3v3__fillcap_4
XPHY_EDGE_ROW_130_1_Right_702 VDD VSS gf180mcu_as_sc_mcu7t3v3__tap_2
XFILLER_203_165 VDD VDD VSS VSS gf180mcu_as_sc_mcu7t3v3__fill_2
XFILLER_203_198 VDD VDD VSS VSS gf180mcu_as_sc_mcu7t3v3__fill_1
XFILLER_12_771 VDD VDD VSS VSS gf180mcu_as_sc_mcu7t3v3__fill_2
XFILLER_157_721 VDD VDD VSS VSS gf180mcu_as_sc_mcu7t3v3__fillcap_16
XFILLER_15_1046 VDD VDD VSS VSS gf180mcu_as_sc_mcu7t3v3__fillcap_4
XFILLER_180_1081 VDD VDD VSS VSS gf180mcu_as_sc_mcu7t3v3__fillcap_4
XFILLER_15_1068 VDD VDD VSS VSS gf180mcu_as_sc_mcu7t3v3__fillcap_16
XFILLER_200_894 VDD VDD VSS VSS gf180mcu_as_sc_mcu7t3v3__fill_2
XPHY_EDGE_ROW_113_2_Right_950 VDD VSS gf180mcu_as_sc_mcu7t3v3__tap_2
XFILLER_8_786 VDD VDD VSS VSS gf180mcu_as_sc_mcu7t3v3__fillcap_16
XFILLER_171_256 VDD VDD VSS VSS gf180mcu_as_sc_mcu7t3v3__fillcap_16
X_4380_ VDD VDD VSS VSS _4394_/A _4380_/B _4380_/C _4381_/B _4408_/D gf180mcu_as_sc_mcu7t3v3__oai211_2
X_3400_ VDD VDD VSS VSS _3401_/B _3404_/A _6268_/Q gf180mcu_as_sc_mcu7t3v3__nand2_2
XFILLER_153_982 VDD VDD VSS VSS gf180mcu_as_sc_mcu7t3v3__fillcap_16
Xclkbuf_leaf_11_clk_regs VDD VDD VSS VSS clkbuf_3_1_0_clk_regs/Y clkload7/A gf180mcu_as_sc_mcu7t3v3__clkbuff_12
X_3331_ VDD VDD VSS VSS _3355_/B _3331_/B _3331_/C _3332_/D _3356_/A gf180mcu_as_sc_mcu7t3v3__aoi211_2
XFILLER_140_665 VDD VDD VSS VSS gf180mcu_as_sc_mcu7t3v3__fill_2
X_6050_ VDD VDD VSS VSS _6525_/CLK _6050_/D _6050_/Q gf180mcu_as_sc_mcu7t3v3__dfxtp_2
X_3262_ VDD VDD VSS VSS _3263_/B _3281_/B _3262_/B _3281_/D gf180mcu_as_sc_mcu7t3v3__aoi21_2
X_5001_ VDD VDD VSS VSS _5001_/B _5001_/A _5005_/B gf180mcu_as_sc_mcu7t3v3__and2_2
X_3193_ VDD VDD VSS VSS _3296_/B _6173_/Q _3194_/D gf180mcu_as_sc_mcu7t3v3__and2_2
XPHY_EDGE_ROW_181_Right_49 VDD VSS gf180mcu_as_sc_mcu7t3v3__tap_2
XFILLER_187_1224 VDD VDD VSS VSS gf180mcu_as_sc_mcu7t3v3__fillcap_8
XFILLER_215_909 VDD VDD VSS VSS gf180mcu_as_sc_mcu7t3v3__fill_1
XFILLER_214_408 VDD VDD VSS VSS gf180mcu_as_sc_mcu7t3v3__fill_2
XFILLER_228_1221 VDD VDD VSS VSS gf180mcu_as_sc_mcu7t3v3__fill_2
XFILLER_223_942 VDD VDD VSS VSS gf180mcu_as_sc_mcu7t3v3__fillcap_16
X_5903_ VDD VDD VSS VSS _5952_/B _5903_/A _5907_/C gf180mcu_as_sc_mcu7t3v3__and2_2
X_5834_ VDD VDD VSS VSS _5834_/A _5947_/B _5834_/C _5834_/D _5835_/B gf180mcu_as_sc_mcu7t3v3__ao211_2
XFILLER_201_96 VDD VDD VSS VSS gf180mcu_as_sc_mcu7t3v3__fillcap_4
XFILLER_210_647 VDD VDD VSS VSS gf180mcu_as_sc_mcu7t3v3__fill_1
X_5765_ VDD VDD VSS VSS _5862_/S _5765_/B _6504_/Q _5766_/C gf180mcu_as_sc_mcu7t3v3__mux2_2
XFILLER_163_702 VDD VDD VSS VSS gf180mcu_as_sc_mcu7t3v3__fillcap_16
XFILLER_175_562 VDD VDD VSS VSS gf180mcu_as_sc_mcu7t3v3__fill_1
XPHY_EDGE_ROW_190_Right_58 VDD VSS gf180mcu_as_sc_mcu7t3v3__tap_2
X_5696_ VDD VDD VSS VSS _5696_/B _5796_/A _6451_/D gf180mcu_as_sc_mcu7t3v3__and2_2
X_4716_ VDD VDD VSS VSS _4883_/A _4716_/B _5730_/A _4717_/B gf180mcu_as_sc_mcu7t3v3__mux2_2
XFILLER_108_629 VDD VDD VSS VSS gf180mcu_as_sc_mcu7t3v3__fill_2
XFILLER_30_27 VDD VDD VSS VSS gf180mcu_as_sc_mcu7t3v3__fillcap_8
X_4647_ VDD VDD VSS VSS _4655_/A _4647_/B _4647_/A gf180mcu_as_sc_mcu7t3v3__nor2b_2
XTAP_TAPCELL_ROW_190_2170 VDD VSS gf180mcu_as_sc_mcu7t3v3__tap_2
XFILLER_116_640 VDD VDD VSS VSS gf180mcu_as_sc_mcu7t3v3__fillcap_4
XFILLER_194_1239 VDD VDD VSS VSS gf180mcu_as_sc_mcu7t3v3__fill_1
XFILLER_200_1151 VDD VDD VSS VSS gf180mcu_as_sc_mcu7t3v3__fillcap_4
XFILLER_200_1173 VDD VDD VSS VSS gf180mcu_as_sc_mcu7t3v3__fillcap_16
XFILLER_30_49 VDD VDD VSS VSS gf180mcu_as_sc_mcu7t3v3__fill_2
XFILLER_146_49 VDD VDD VSS VSS gf180mcu_as_sc_mcu7t3v3__fill_2
XFILLER_150_418 VDD VDD VSS VSS gf180mcu_as_sc_mcu7t3v3__fill_1
XFILLER_150_429 VDD VDD VSS VSS gf180mcu_as_sc_mcu7t3v3__fill_1
XPHY_EDGE_ROW_125_3_Right_205 VDD VSS gf180mcu_as_sc_mcu7t3v3__tap_2
XTAP_TAPCELL_ROW_151_1453 VDD VSS gf180mcu_as_sc_mcu7t3v3__tap_2
XTAP_TAPCELL_ROW_151_1464 VDD VSS gf180mcu_as_sc_mcu7t3v3__tap_2
X_6317_ VDD VDD VSS VSS _6551_/CLK _6317_/D _6317_/Q gf180mcu_as_sc_mcu7t3v3__dfxtp_2
X_4578_ VDD VDD VSS VSS _4603_/A _6312_/Q _6313_/D gf180mcu_as_sc_mcu7t3v3__and2_2
X_3529_ VDD VDD VSS VSS _5335_/D _5340_/A _5929_/A gf180mcu_as_sc_mcu7t3v3__nor2b_2
X_6248_ VDD VDD VSS VSS _6531_/CLK _6248_/D _6248_/Q gf180mcu_as_sc_mcu7t3v3__dfxtp_2
XFILLER_162_37 VDD VDD VSS VSS gf180mcu_as_sc_mcu7t3v3__fillcap_16
X_6179_ VDD VDD VSS VSS _6376_/CLK _6179_/D _6179_/Q gf180mcu_as_sc_mcu7t3v3__dfxtp_2
Xmesh_tile_1109 VDD VDD VSS VSS nw_out[32] gf180mcu_as_sc_mcu7t3v3__tiel_4
XFILLER_206_909 VDD VDD VSS VSS gf180mcu_as_sc_mcu7t3v3__fillcap_16
XTAP_TAPCELL_ROW_10_1195 VDD VSS gf180mcu_as_sc_mcu7t3v3__tap_2
XFILLER_13_502 VDD VDD VSS VSS gf180mcu_as_sc_mcu7t3v3__fillcap_8
XFILLER_13_524 VDD VDD VSS VSS gf180mcu_as_sc_mcu7t3v3__fill_2
XTAP_TAPCELL_ROW_98_3_2996 VDD VSS gf180mcu_as_sc_mcu7t3v3__tap_2
XFILLER_164_1065 VDD VDD VSS VSS gf180mcu_as_sc_mcu7t3v3__fillcap_16
XFILLER_164_1087 VDD VDD VSS VSS gf180mcu_as_sc_mcu7t3v3__fillcap_16
XFILLER_186_827 VDD VDD VSS VSS gf180mcu_as_sc_mcu7t3v3__fillcap_4
XFILLER_197_142 VDD VDD VSS VSS gf180mcu_as_sc_mcu7t3v3__fillcap_4
XFILLER_213_496 VDD VDD VSS VSS gf180mcu_as_sc_mcu7t3v3__fill_1
XFILLER_71_45 VDD VDD VSS VSS gf180mcu_as_sc_mcu7t3v3__fillcap_4
XFILLER_13_579 VDD VDD VSS VSS gf180mcu_as_sc_mcu7t3v3__fill_1
XFILLER_200_124 VDD VDD VSS VSS gf180mcu_as_sc_mcu7t3v3__fillcap_16
XFILLER_187_67 VDD VDD VSS VSS gf180mcu_as_sc_mcu7t3v3__fill_2
XFILLER_200_168 VDD VDD VSS VSS gf180mcu_as_sc_mcu7t3v3__fill_2
XFILLER_205_1084 VDD VDD VSS VSS gf180mcu_as_sc_mcu7t3v3__fillcap_16
XFILLER_224_2 VDD VDD VSS VSS gf180mcu_as_sc_mcu7t3v3__fillcap_16
XPHY_EDGE_ROW_45_3_Left_750 VDD VSS gf180mcu_as_sc_mcu7t3v3__tap_2
XTAP_TAPCELL_ROW_216_2630 VDD VSS gf180mcu_as_sc_mcu7t3v3__tap_2
XFILLER_153_212 VDD VDD VSS VSS gf180mcu_as_sc_mcu7t3v3__fillcap_16
XFILLER_166_573 VDD VDD VSS VSS gf180mcu_as_sc_mcu7t3v3__fillcap_4
XTAP_TAPCELL_ROW_171_1818 VDD VSS gf180mcu_as_sc_mcu7t3v3__tap_2
XFILLER_154_757 VDD VDD VSS VSS gf180mcu_as_sc_mcu7t3v3__fill_2
XTAP_TAPCELL_ROW_212_2549 VDD VSS gf180mcu_as_sc_mcu7t3v3__tap_2
XFILLER_4_244 VDD VDD VSS VSS gf180mcu_as_sc_mcu7t3v3__fill_1
XPHY_EDGE_ROW_104_2_Left_545 VDD VSS gf180mcu_as_sc_mcu7t3v3__tap_2
XFILLER_150_941 VDD VDD VSS VSS gf180mcu_as_sc_mcu7t3v3__fillcap_4
XFILLER_171_1014 VDD VDD VSS VSS gf180mcu_as_sc_mcu7t3v3__fillcap_16
XFILLER_122_665 VDD VDD VSS VSS gf180mcu_as_sc_mcu7t3v3__fill_2
XFILLER_150_963 VDD VDD VSS VSS gf180mcu_as_sc_mcu7t3v3__fillcap_16
XFILLER_1_962 VDD VDD VSS VSS gf180mcu_as_sc_mcu7t3v3__fillcap_16
XFILLER_212_1011 VDD VDD VSS VSS gf180mcu_as_sc_mcu7t3v3__fillcap_4
XFILLER_208_202 VDD VDD VSS VSS gf180mcu_as_sc_mcu7t3v3__fill_2
XFILLER_212_1033 VDD VDD VSS VSS gf180mcu_as_sc_mcu7t3v3__fillcap_16
XFILLER_222_18 VDD VDD VSS VSS gf180mcu_as_sc_mcu7t3v3__fillcap_16
XFILLER_1_1100 VDD VDD VSS VSS gf180mcu_as_sc_mcu7t3v3__fillcap_16
XFILLER_208_235 VDD VDD VSS VSS gf180mcu_as_sc_mcu7t3v3__fill_2
XFILLER_1_1122 VDD VDD VSS VSS gf180mcu_as_sc_mcu7t3v3__fillcap_16
XFILLER_189_610 VDD VDD VSS VSS gf180mcu_as_sc_mcu7t3v3__fill_2
XFILLER_188_131 VDD VDD VSS VSS gf180mcu_as_sc_mcu7t3v3__fill_2
XFILLER_204_452 VDD VDD VSS VSS gf180mcu_as_sc_mcu7t3v3__fill_2
XFILLER_177_838 VDD VDD VSS VSS gf180mcu_as_sc_mcu7t3v3__fill_2
XPHY_EDGE_ROW_131_1_Right_703 VDD VSS gf180mcu_as_sc_mcu7t3v3__tap_2
X_3880_ VDD VDD VSS VSS _5865_/D _3891_/B _3880_/C _3930_/B _3882_/A gf180mcu_as_sc_mcu7t3v3__ao211_2
XFILLER_157_562 VDD VDD VSS VSS gf180mcu_as_sc_mcu7t3v3__fill_2
XFILLER_191_307 VDD VDD VSS VSS gf180mcu_as_sc_mcu7t3v3__fill_2
X_5550_ VDD VDD VSS VSS _5551_/D _6515_/Q _5631_/B _5550_/C gf180mcu_as_sc_mcu7t3v3__ao21_2
XFILLER_184_381 VDD VDD VSS VSS gf180mcu_as_sc_mcu7t3v3__fillcap_4
XPHY_EDGE_ROW_114_2_Right_951 VDD VSS gf180mcu_as_sc_mcu7t3v3__tap_2
X_5481_ VDD VDD VSS VSS _5481_/B _5506_/A _6426_/D gf180mcu_as_sc_mcu7t3v3__and2_2
X_4501_ VDD VDD VSS VSS _4504_/B _4551_/B _4523_/B _4569_/D gf180mcu_as_sc_mcu7t3v3__aoi21_2
XPHY_EDGE_ROW_36_2_Left_477 VDD VSS gf180mcu_as_sc_mcu7t3v3__tap_2
X_4432_ VDD VDD VSS VSS _6248_/Q _4446_/D _4446_/B _6247_/Q _6247_/D gf180mcu_as_sc_mcu7t3v3__ao22_2
XFILLER_67_1264 VDD VDD VSS VSS gf180mcu_as_sc_mcu7t3v3__fill_1
X_4363_ VDD VDD VSS VSS _4363_/S _6062_/Q _6091_/Q _4366_/B gf180mcu_as_sc_mcu7t3v3__mux2_2
XFILLER_154_1234 VDD VDD VSS VSS gf180mcu_as_sc_mcu7t3v3__fillcap_16
Xfanout518 VDD VDD VSS VSS _4016_/Y _4060_/B gf180mcu_as_sc_mcu7t3v3__buff_12
Xfanout529 VDD VDD VSS VSS fanout531/Y _3904_/B gf180mcu_as_sc_mcu7t3v3__buff_12
X_6102_ VDD VDD VSS VSS _6486_/CLK _6102_/D _6102_/Q gf180mcu_as_sc_mcu7t3v3__dfxtp_2
X_4294_ VDD VDD VSS VSS _6210_/Q _4399_/B _4399_/C _6211_/Q _4295_/C gf180mcu_as_sc_mcu7t3v3__ao22_2
X_3314_ VDD VDD VSS VSS _6204_/Q _3361_/B _4072_/B _6196_/Q _3315_/C gf180mcu_as_sc_mcu7t3v3__ao22_2
XFILLER_6_1011 VDD VDD VSS VSS gf180mcu_as_sc_mcu7t3v3__fillcap_4
X_6033_ VDD VDD VSS VSS _6519_/CLK _6033_/D _6033_/Q gf180mcu_as_sc_mcu7t3v3__dfxtp_2
X_3245_ VDD VDD VSS VSS _3246_/C _3245_/C _3245_/B _3294_/B gf180mcu_as_sc_mcu7t3v3__aoi21b_2
XFILLER_6_1033 VDD VDD VSS VSS gf180mcu_as_sc_mcu7t3v3__fillcap_16
X_3176_ VDD VDD VSS VSS _3176_/D _4480_/A _4112_/B _3176_/C _3177_/B gf180mcu_as_sc_mcu7t3v3__ao31_2
XFILLER_215_717 VDD VDD VSS VSS gf180mcu_as_sc_mcu7t3v3__fill_2
XFILLER_227_566 VDD VDD VSS VSS gf180mcu_as_sc_mcu7t3v3__fill_1
XFILLER_25_27 VDD VDD VSS VSS gf180mcu_as_sc_mcu7t3v3__fillcap_16
XTAP_TAPCELL_ROW_132_1_1387 VDD VSS gf180mcu_as_sc_mcu7t3v3__tap_2
XFILLER_179_142 VDD VDD VSS VSS gf180mcu_as_sc_mcu7t3v3__fillcap_8
XFILLER_228_1073 VDD VDD VSS VSS gf180mcu_as_sc_mcu7t3v3__fillcap_4
XFILLER_167_348 VDD VDD VSS VSS gf180mcu_as_sc_mcu7t3v3__fill_2
XFILLER_194_101 VDD VDD VSS VSS gf180mcu_as_sc_mcu7t3v3__fillcap_4
XFILLER_211_956 VDD VDD VSS VSS gf180mcu_as_sc_mcu7t3v3__fillcap_16
X_5817_ VDD VDD VSS VSS _5817_/A _5874_/B _5873_/B _5817_/D _5818_/D gf180mcu_as_sc_mcu7t3v3__ao22_2
XFILLER_10_527 VDD VDD VSS VSS gf180mcu_as_sc_mcu7t3v3__fillcap_4
XFILLER_202_1235 VDD VDD VSS VSS gf180mcu_as_sc_mcu7t3v3__fillcap_4
X_5748_ VDD VDD VSS VSS _5797_/B _5748_/A _5751_/C gf180mcu_as_sc_mcu7t3v3__and2_2
XTAP_TAPCELL_ROW_153_1504 VDD VSS gf180mcu_as_sc_mcu7t3v3__tap_2
XFILLER_163_532 VDD VDD VSS VSS gf180mcu_as_sc_mcu7t3v3__fill_2
XFILLER_175_381 VDD VDD VSS VSS gf180mcu_as_sc_mcu7t3v3__fill_2
X_5679_ VDD VDD VSS VSS _5875_/S _5679_/B _5679_/A _5680_/B gf180mcu_as_sc_mcu7t3v3__mux2_2
XFILLER_104_610 VDD VDD VSS VSS gf180mcu_as_sc_mcu7t3v3__fill_2
XPHY_EDGE_ROW_126_3_Right_206 VDD VSS gf180mcu_as_sc_mcu7t3v3__tap_2
XFILLER_66_45 VDD VDD VSS VSS gf180mcu_as_sc_mcu7t3v3__fillcap_4
XTAP_TAPCELL_ROW_12_1224 VDD VSS gf180mcu_as_sc_mcu7t3v3__tap_2
XTAP_TAPCELL_ROW_12_1235 VDD VSS gf180mcu_as_sc_mcu7t3v3__tap_2
XTAP_TAPCELL_ROW_164_1688 VDD VSS gf180mcu_as_sc_mcu7t3v3__tap_2
XFILLER_205_238 VDD VDD VSS VSS gf180mcu_as_sc_mcu7t3v3__fill_2
XTAP_TAPCELL_ROW_164_1699 VDD VSS gf180mcu_as_sc_mcu7t3v3__tap_2
XTAP_TAPCELL_ROW_181_1991 VDD VSS gf180mcu_as_sc_mcu7t3v3__tap_2
XFILLER_82_33 VDD VDD VSS VSS gf180mcu_as_sc_mcu7t3v3__fill_2
XFILLER_14_855 VDD VDD VSS VSS gf180mcu_as_sc_mcu7t3v3__fillcap_16
XFILLER_186_613 VDD VDD VSS VSS gf180mcu_as_sc_mcu7t3v3__fillcap_4
XFILLER_13_376 VDD VDD VSS VSS gf180mcu_as_sc_mcu7t3v3__fillcap_4
XFILLER_14_877 VDD VDD VSS VSS gf180mcu_as_sc_mcu7t3v3__fillcap_16
XFILLER_201_433 VDD VDD VSS VSS gf180mcu_as_sc_mcu7t3v3__fillcap_4
XFILLER_213_282 VDD VDD VSS VSS gf180mcu_as_sc_mcu7t3v3__fill_2
XFILLER_16_1152 VDD VDD VSS VSS gf180mcu_as_sc_mcu7t3v3__fillcap_4
XFILLER_16_1174 VDD VDD VSS VSS gf180mcu_as_sc_mcu7t3v3__fillcap_16
XPHY_EDGE_ROW_21_1_Left_249 VDD VSS gf180mcu_as_sc_mcu7t3v3__tap_2
XTAP_TAPCELL_ROW_62_2_2941 VDD VSS gf180mcu_as_sc_mcu7t3v3__tap_2
XFILLER_12_1049 VDD VDD VSS VSS gf180mcu_as_sc_mcu7t3v3__fillcap_16
XFILLER_154_543 VDD VDD VSS VSS gf180mcu_as_sc_mcu7t3v3__fill_2
XFILLER_166_381 VDD VDD VSS VSS gf180mcu_as_sc_mcu7t3v3__fillcap_4
XFILLER_217_18 VDD VDD VSS VSS gf180mcu_as_sc_mcu7t3v3__fillcap_16
XFILLER_5_564 VDD VDD VSS VSS gf180mcu_as_sc_mcu7t3v3__fill_1
XPHY_EDGE_ROW_146_1_Left_374 VDD VSS gf180mcu_as_sc_mcu7t3v3__tap_2
XFILLER_228_308 VDD VDD VSS VSS gf180mcu_as_sc_mcu7t3v3__fillcap_4
XPHY_EDGE_ROW_83_1_Left_311 VDD VSS gf180mcu_as_sc_mcu7t3v3__tap_2
XFILLER_0_280 VDD VDD VSS VSS gf180mcu_as_sc_mcu7t3v3__fill_1
XFILLER_209_544 VDD VDD VSS VSS gf180mcu_as_sc_mcu7t3v3__fillcap_16
Xinput170 VDD VDD VSS VSS nw_in[20] _5841_/A gf180mcu_as_sc_mcu7t3v3__buff_12
Xinput181 VDD VDD VSS VSS nw_in[30] _5924_/A gf180mcu_as_sc_mcu7t3v3__buff_12
X_3030_ VDD VDD VSS VSS _3470_/C _5924_/A gf180mcu_as_sc_mcu7t3v3__inv_2
XFILLER_209_566 VDD VDD VSS VSS gf180mcu_as_sc_mcu7t3v3__fill_1
XFILLER_209_577 VDD VDD VSS VSS gf180mcu_as_sc_mcu7t3v3__fillcap_4
Xinput192 VDD VDD VSS VSS nw_in[8] _5744_/A gf180mcu_as_sc_mcu7t3v3__buff_12
XFILLER_184_1205 VDD VDD VSS VSS gf180mcu_as_sc_mcu7t3v3__fillcap_16
XFILLER_184_1227 VDD VDD VSS VSS gf180mcu_as_sc_mcu7t3v3__fillcap_8
X_4981_ VDD VDD VSS VSS _4981_/Y _4982_/C _4982_/D gf180mcu_as_sc_mcu7t3v3__nand2_2
XFILLER_205_772 VDD VDD VSS VSS gf180mcu_as_sc_mcu7t3v3__fillcap_8
XFILLER_225_1224 VDD VDD VSS VSS gf180mcu_as_sc_mcu7t3v3__fillcap_16
XFILLER_32_641 VDD VDD VSS VSS gf180mcu_as_sc_mcu7t3v3__fill_1
X_6720_ VDD VDD VSS VSS _6720_/A _6720_/Y gf180mcu_as_sc_mcu7t3v3__buff_2
X_3932_ VDD VDD VSS VSS _4061_/B _5910_/A _3932_/B _3932_/C gf180mcu_as_sc_mcu7t3v3__ao21_2
XFILLER_176_101 VDD VDD VSS VSS gf180mcu_as_sc_mcu7t3v3__fillcap_4
XFILLER_176_123 VDD VDD VSS VSS gf180mcu_as_sc_mcu7t3v3__fillcap_4
XPHY_EDGE_ROW_132_1_Right_704 VDD VSS gf180mcu_as_sc_mcu7t3v3__tap_2
X_3863_ VDD VDD VSS VSS _3930_/B _5849_/A _3864_/D gf180mcu_as_sc_mcu7t3v3__and2_2
XFILLER_149_348 VDD VDD VSS VSS gf180mcu_as_sc_mcu7t3v3__fill_1
X_5602_ VDD VDD VSS VSS _5913_/A _5616_/B _5615_/C _5912_/D _5604_/D gf180mcu_as_sc_mcu7t3v3__ao22_2
XFILLER_191_104 VDD VDD VSS VSS gf180mcu_as_sc_mcu7t3v3__fillcap_4
XFILLER_192_616 VDD VDD VSS VSS gf180mcu_as_sc_mcu7t3v3__fillcap_16
X_5533_ VDD VDD VSS VSS _5534_/A _5838_/B _5533_/B _5533_/C gf180mcu_as_sc_mcu7t3v3__ao21_2
X_3794_ VDD VDD VSS VSS _3796_/C _5791_/A _3852_/B _3794_/C gf180mcu_as_sc_mcu7t3v3__ao21_2
XPHY_EDGE_ROW_115_2_Right_952 VDD VSS gf180mcu_as_sc_mcu7t3v3__tap_2
X_5464_ VDD VDD VSS VSS _5768_/A _5569_/B _5464_/C _5464_/D _5465_/B gf180mcu_as_sc_mcu7t3v3__ao211_2
XFILLER_172_384 VDD VDD VSS VSS gf180mcu_as_sc_mcu7t3v3__fill_1
X_5395_ VDD VDD VSS VSS _5396_/B _5704_/A _5497_/B _5395_/C gf180mcu_as_sc_mcu7t3v3__ao21_2
X_4415_ VDD VDD VSS VSS _6231_/Q _4422_/B _4425_/C _6230_/Q _6230_/D gf180mcu_as_sc_mcu7t3v3__ao22_2
X_4346_ VDD VDD VSS VSS _6217_/D _4346_/B _4346_/A gf180mcu_as_sc_mcu7t3v3__nand2_2
XFILLER_189_1116 VDD VDD VSS VSS gf180mcu_as_sc_mcu7t3v3__fillcap_4
XPHY_EDGE_ROW_50_3_Right_130 VDD VSS gf180mcu_as_sc_mcu7t3v3__tap_2
X_4277_ VDD VDD VSS VSS _4405_/S _6050_/Q _6079_/Q _4278_/B gf180mcu_as_sc_mcu7t3v3__mux2_2
XTAP_TAPCELL_ROW_185_2080 VDD VSS gf180mcu_as_sc_mcu7t3v3__tap_2
XFILLER_189_1138 VDD VDD VSS VSS gf180mcu_as_sc_mcu7t3v3__fillcap_16
X_6016_ VDD VDD VSS VSS _6125_/CLK _6016_/D _6016_/Q gf180mcu_as_sc_mcu7t3v3__dfxtp_2
X_3228_ VDD VDD VSS VSS _3404_/A _3390_/A _4528_/C gf180mcu_as_sc_mcu7t3v3__nor2_2
XTAP_TAPCELL_ROW_9_1178 VDD VSS gf180mcu_as_sc_mcu7t3v3__tap_2
XTAP_TAPCELL_ROW_9_1167 VDD VSS gf180mcu_as_sc_mcu7t3v3__tap_2
XFILLER_223_72 VDD VDD VSS VSS gf180mcu_as_sc_mcu7t3v3__fillcap_4
XFILLER_227_352 VDD VDD VSS VSS gf180mcu_as_sc_mcu7t3v3__fill_2
XFILLER_36_37 VDD VDD VSS VSS gf180mcu_as_sc_mcu7t3v3__fillcap_8
X_3159_ VDD VDD VSS VSS _4215_/A _6201_/Q _3159_/A _4570_/B gf180mcu_as_sc_mcu7t3v3__mux2_2
XFILLER_215_525 VDD VDD VSS VSS gf180mcu_as_sc_mcu7t3v3__fillcap_4
XFILLER_14_107 VDD VDD VSS VSS gf180mcu_as_sc_mcu7t3v3__fillcap_16
XFILLER_196_900 VDD VDD VSS VSS gf180mcu_as_sc_mcu7t3v3__fillcap_16
XFILLER_23_630 VDD VDD VSS VSS gf180mcu_as_sc_mcu7t3v3__fill_2
XFILLER_11_814 VDD VDD VSS VSS gf180mcu_as_sc_mcu7t3v3__fillcap_16
XFILLER_146_6 VDD VDD VSS VSS gf180mcu_as_sc_mcu7t3v3__fillcap_8
XFILLER_168_613 VDD VDD VSS VSS gf180mcu_as_sc_mcu7t3v3__fillcap_8
XFILLER_196_944 VDD VDD VSS VSS gf180mcu_as_sc_mcu7t3v3__fill_1
XTAP_TAPCELL_ROW_66_1_1354 VDD VSS gf180mcu_as_sc_mcu7t3v3__tap_2
XFILLER_11_858 VDD VDD VSS VSS gf180mcu_as_sc_mcu7t3v3__fillcap_16
XFILLER_161_1046 VDD VDD VSS VSS gf180mcu_as_sc_mcu7t3v3__fillcap_4
XFILLER_161_1068 VDD VDD VSS VSS gf180mcu_as_sc_mcu7t3v3__fillcap_16
Xwire705 VDD VDD VSS VSS _3655_/Y _3853_/B gf180mcu_as_sc_mcu7t3v3__clkbuff_12
XFILLER_168_69 VDD VDD VSS VSS gf180mcu_as_sc_mcu7t3v3__fillcap_16
XFILLER_182_115 VDD VDD VSS VSS gf180mcu_as_sc_mcu7t3v3__fillcap_4
XFILLER_183_627 VDD VDD VSS VSS gf180mcu_as_sc_mcu7t3v3__fill_2
XFILLER_6_317 VDD VDD VSS VSS gf180mcu_as_sc_mcu7t3v3__fillcap_8
XFILLER_202_1065 VDD VDD VSS VSS gf180mcu_as_sc_mcu7t3v3__fillcap_16
XFILLER_163_340 VDD VDD VSS VSS gf180mcu_as_sc_mcu7t3v3__fillcap_8
XFILLER_182_159 VDD VDD VSS VSS gf180mcu_as_sc_mcu7t3v3__fill_2
XFILLER_202_1087 VDD VDD VSS VSS gf180mcu_as_sc_mcu7t3v3__fillcap_16
XFILLER_77_22 VDD VDD VSS VSS gf180mcu_as_sc_mcu7t3v3__fill_2
XPHY_EDGE_ROW_127_3_Right_207 VDD VSS gf180mcu_as_sc_mcu7t3v3__tap_2
XTAP_TAPCELL_ROW_166_1728 VDD VSS gf180mcu_as_sc_mcu7t3v3__tap_2
Xfanout860 VDD VDD VSS VSS _4620_/Y _4840_/B gf180mcu_as_sc_mcu7t3v3__buff_12
Xfanout871 VDD VDD VSS VSS _3182_/Y _4148_/B gf180mcu_as_sc_mcu7t3v3__buff_12
Xfanout882 VDD VDD VSS VSS _3305_/Y _4093_/S gf180mcu_as_sc_mcu7t3v3__buff_12
Xfanout893 VDD VDD VSS VSS fanout894/Y _4348_/D gf180mcu_as_sc_mcu7t3v3__buff_12
XTAP_TAPCELL_ROW_86_3_2978 VDD VSS gf180mcu_as_sc_mcu7t3v3__tap_2
XTAP_TAPCELL_ROW_207_2459 VDD VSS gf180mcu_as_sc_mcu7t3v3__tap_2
XTAP_TAPCELL_ROW_224_2773 VDD VSS gf180mcu_as_sc_mcu7t3v3__tap_2
XFILLER_209_1208 VDD VDD VSS VSS gf180mcu_as_sc_mcu7t3v3__fillcap_16
XFILLER_158_101 VDD VDD VSS VSS gf180mcu_as_sc_mcu7t3v3__fillcap_4
XFILLER_187_933 VDD VDD VSS VSS gf180mcu_as_sc_mcu7t3v3__fill_2
XFILLER_158_123 VDD VDD VSS VSS gf180mcu_as_sc_mcu7t3v3__fillcap_16
XFILLER_186_454 VDD VDD VSS VSS gf180mcu_as_sc_mcu7t3v3__fill_1
XFILLER_173_104 VDD VDD VSS VSS gf180mcu_as_sc_mcu7t3v3__fillcap_16
XFILLER_174_638 VDD VDD VSS VSS gf180mcu_as_sc_mcu7t3v3__fillcap_4
X_4200_ VDD VDD VSS VSS _4349_/S _6071_/Q _6100_/Q _4201_/B gf180mcu_as_sc_mcu7t3v3__mux2_2
XFILLER_64_1245 VDD VDD VSS VSS gf180mcu_as_sc_mcu7t3v3__fillcap_16
X_5180_ VDD VDD VSS VSS _5834_/A _5218_/B _5180_/C _5180_/D _5181_/A gf180mcu_as_sc_mcu7t3v3__ao211_2
XFILLER_151_1226 VDD VDD VSS VSS gf180mcu_as_sc_mcu7t3v3__fill_1
XFILLER_96_644 VDD VDD VSS VSS gf180mcu_as_sc_mcu7t3v3__fill_1
X_4131_ VDD VDD VSS VSS _4135_/S _6181_/Q _6180_/Q _6180_/D gf180mcu_as_sc_mcu7t3v3__mux2_2
XFILLER_228_138 VDD VDD VSS VSS gf180mcu_as_sc_mcu7t3v3__fillcap_4
X_4062_ VDD VDD VSS VSS _4178_/A _5970_/A _6491_/Q gf180mcu_as_sc_mcu7t3v3__nand2b_2
XFILLER_209_352 VDD VDD VSS VSS gf180mcu_as_sc_mcu7t3v3__fillcap_4
XFILLER_3_1014 VDD VDD VSS VSS gf180mcu_as_sc_mcu7t3v3__fillcap_16
X_3013_ VDD VDD VSS VSS _4979_/D _6525_/Q gf180mcu_as_sc_mcu7t3v3__inv_2
XFILLER_224_399 VDD VDD VSS VSS gf180mcu_as_sc_mcu7t3v3__fill_2
X_4964_ VDD VDD VSS VSS _4965_/B _5954_/A _4964_/B _4964_/C gf180mcu_as_sc_mcu7t3v3__ao21_2
XTAP_TAPCELL_ROW_4_1086 VDD VSS gf180mcu_as_sc_mcu7t3v3__tap_2
X_3915_ VDD VDD VSS VSS _5921_/A _3925_/B _3927_/B _5897_/D _3916_/C gf180mcu_as_sc_mcu7t3v3__ao22_2
XFILLER_177_432 VDD VDD VSS VSS gf180mcu_as_sc_mcu7t3v3__fill_2
XFILLER_20_622 VDD VDD VSS VSS gf180mcu_as_sc_mcu7t3v3__fillcap_4
X_4895_ VDD VDD VSS VSS _4955_/C _5890_/A _4900_/C gf180mcu_as_sc_mcu7t3v3__and2_2
XPHY_EDGE_ROW_133_1_Right_705 VDD VSS gf180mcu_as_sc_mcu7t3v3__tap_2
X_3846_ VDD VDD VSS VSS _3873_/S _3846_/B _5833_/A _3847_/D gf180mcu_as_sc_mcu7t3v3__mux2_2
XFILLER_165_649 VDD VDD VSS VSS gf180mcu_as_sc_mcu7t3v3__fill_2
XFILLER_192_457 VDD VDD VSS VSS gf180mcu_as_sc_mcu7t3v3__fillcap_4
X_3777_ VDD VDD VSS VSS _3889_/B _5776_/A _3778_/D gf180mcu_as_sc_mcu7t3v3__and2_2
X_6496_ VDD VDD VSS VSS _6518_/CLK _6496_/D _6496_/Q gf180mcu_as_sc_mcu7t3v3__dfxtp_2
X_5516_ VDD VDD VSS VSS _5821_/A _5565_/B _5566_/B _5824_/A _5518_/C gf180mcu_as_sc_mcu7t3v3__ao22_2
XPHY_EDGE_ROW_116_2_Right_953 VDD VSS gf180mcu_as_sc_mcu7t3v3__tap_2
X_5447_ VDD VDD VSS VSS _5448_/B _5447_/A _5538_/B _5447_/C gf180mcu_as_sc_mcu7t3v3__ao21_2
XFILLER_195_1186 VDD VDD VSS VSS gf180mcu_as_sc_mcu7t3v3__fillcap_4
Xoutput452 VDD VDD VSS VSS _6384_/Q south_out[7] gf180mcu_as_sc_mcu7t3v3__buff_12
Xoutput441 VDD VDD VSS VSS _6379_/Q south_out[2] gf180mcu_as_sc_mcu7t3v3__buff_12
Xoutput430 VDD VDD VSS VSS _6378_/Q south_out[1] gf180mcu_as_sc_mcu7t3v3__buff_12
Xoutput485 VDD VDD VSS VSS _6453_/Q west_out[4] gf180mcu_as_sc_mcu7t3v3__buff_12
Xoutput474 VDD VDD VSS VSS _6476_/Q west_out[27] gf180mcu_as_sc_mcu7t3v3__buff_12
Xoutput463 VDD VDD VSS VSS _6466_/Q west_out[17] gf180mcu_as_sc_mcu7t3v3__buff_12
X_5378_ VDD VDD VSS VSS _5687_/A _5497_/B _5496_/B _5686_/A _5379_/D gf180mcu_as_sc_mcu7t3v3__ao22_2
X_4329_ VDD VDD VSS VSS _6215_/Q _4336_/B _4336_/C _6216_/Q _4330_/C gf180mcu_as_sc_mcu7t3v3__ao22_2
XTAP_TAPCELL_ROW_183_2039 VDD VSS gf180mcu_as_sc_mcu7t3v3__tap_2
XTAP_TAPCELL_ROW_183_2028 VDD VSS gf180mcu_as_sc_mcu7t3v3__tap_2
XFILLER_87_666 VDD VDD VSS VSS gf180mcu_as_sc_mcu7t3v3__fill_1
XFILLER_170_37 VDD VDD VSS VSS gf180mcu_as_sc_mcu7t3v3__fillcap_16
XFILLER_216_801 VDD VDD VSS VSS gf180mcu_as_sc_mcu7t3v3__fillcap_4
XPHY_EDGE_ROW_51_3_Right_131 VDD VSS gf180mcu_as_sc_mcu7t3v3__tap_2
XTAP_TAPCELL_ROW_161_1636 VDD VSS gf180mcu_as_sc_mcu7t3v3__tap_2
XTAP_TAPCELL_ROW_161_1647 VDD VSS gf180mcu_as_sc_mcu7t3v3__tap_2
XPHY_EDGE_ROW_113_2_Left_554 VDD VSS gf180mcu_as_sc_mcu7t3v3__tap_2
XTAP_TAPCELL_ROW_202_2378 VDD VSS gf180mcu_as_sc_mcu7t3v3__tap_2
XFILLER_13_1100 VDD VDD VSS VSS gf180mcu_as_sc_mcu7t3v3__fillcap_16
XFILLER_155_104 VDD VDD VSS VSS gf180mcu_as_sc_mcu7t3v3__fillcap_16
XFILLER_7_604 VDD VDD VSS VSS gf180mcu_as_sc_mcu7t3v3__fill_1
Xwire513 VDD VDD VSS VSS _3310_/Y wire513/Y gf180mcu_as_sc_mcu7t3v3__clkbuff_12
XFILLER_104_1261 VDD VDD VSS VSS gf180mcu_as_sc_mcu7t3v3__fillcap_4
XFILLER_13_1122 VDD VDD VSS VSS gf180mcu_as_sc_mcu7t3v3__fillcap_16
XFILLER_184_947 VDD VDD VSS VSS gf180mcu_as_sc_mcu7t3v3__fill_2
XTAP_TAPCELL_ROW_159_1598 VDD VSS gf180mcu_as_sc_mcu7t3v3__tap_2
XFILLER_170_107 VDD VDD VSS VSS gf180mcu_as_sc_mcu7t3v3__fillcap_16
XFILLER_12_94 VDD VDD VSS VSS gf180mcu_as_sc_mcu7t3v3__fillcap_8
XFILLER_152_877 VDD VDD VSS VSS gf180mcu_as_sc_mcu7t3v3__fillcap_4
XFILLER_174_1259 VDD VDD VSS VSS gf180mcu_as_sc_mcu7t3v3__fill_2
XFILLER_215_1256 VDD VDD VSS VSS gf180mcu_as_sc_mcu7t3v3__fillcap_4
XTAP_TAPCELL_ROW_226_2813 VDD VSS gf180mcu_as_sc_mcu7t3v3__tap_2
XTAP_TAPCELL_ROW_226_2802 VDD VSS gf180mcu_as_sc_mcu7t3v3__tap_2
XPHY_EDGE_ROW_128_3_Right_208 VDD VSS gf180mcu_as_sc_mcu7t3v3__tap_2
XFILLER_111_1210 VDD VDD VSS VSS gf180mcu_as_sc_mcu7t3v3__fillcap_16
XFILLER_219_661 VDD VDD VSS VSS gf180mcu_as_sc_mcu7t3v3__fill_1
Xfanout690 VDD VDD VSS VSS _4962_/C _4871_/C gf180mcu_as_sc_mcu7t3v3__buff_12
XFILLER_0_1209 VDD VDD VSS VSS gf180mcu_as_sc_mcu7t3v3__fillcap_8
XFILLER_168_1008 VDD VDD VSS VSS gf180mcu_as_sc_mcu7t3v3__fillcap_4
XFILLER_93_658 VDD VDD VSS VSS gf180mcu_as_sc_mcu7t3v3__fillcap_4
XFILLER_207_867 VDD VDD VSS VSS gf180mcu_as_sc_mcu7t3v3__fill_1
XPHY_EDGE_ROW_45_2_Left_486 VDD VSS gf180mcu_as_sc_mcu7t3v3__tap_2
Xclkbuf_leaf_36_clk_regs VDD VDD VSS VSS clkbuf_3_0_0_clk_regs/Y clkload4/A gf180mcu_as_sc_mcu7t3v3__clkbuff_12
XFILLER_181_1208 VDD VDD VSS VSS gf180mcu_as_sc_mcu7t3v3__fillcap_16
XFILLER_206_366 VDD VDD VSS VSS gf180mcu_as_sc_mcu7t3v3__fillcap_4
XTAP_TAPCELL_ROW_50_2_2923 VDD VSS gf180mcu_as_sc_mcu7t3v3__tap_2
XFILLER_222_1205 VDD VDD VSS VSS gf180mcu_as_sc_mcu7t3v3__fillcap_16
X_3700_ VDD VDD VSS VSS _5708_/A _3852_/B _3700_/C _3700_/D _3702_/C gf180mcu_as_sc_mcu7t3v3__ao211_2
XFILLER_202_594 VDD VDD VSS VSS gf180mcu_as_sc_mcu7t3v3__fill_1
XFILLER_222_1227 VDD VDD VSS VSS gf180mcu_as_sc_mcu7t3v3__fillcap_16
X_4680_ VDD VDD VSS VSS _4932_/A _5698_/A _4682_/C gf180mcu_as_sc_mcu7t3v3__and2_2
XFILLER_147_638 VDD VDD VSS VSS gf180mcu_as_sc_mcu7t3v3__fillcap_4
XFILLER_70_1260 VDD VDD VSS VSS gf180mcu_as_sc_mcu7t3v3__fillcap_4
X_3631_ VDD VDD VSS VSS _5320_/A _3631_/A _5612_/A _5934_/A _3631_/D gf180mcu_as_sc_mcu7t3v3__aoi22_2
XFILLER_174_457 VDD VDD VSS VSS gf180mcu_as_sc_mcu7t3v3__fillcap_4
XFILLER_190_939 VDD VDD VSS VSS gf180mcu_as_sc_mcu7t3v3__fillcap_4
X_6350_ VDD VDD VSS VSS _6370_/CLK _6350_/D _6350_/Q gf180mcu_as_sc_mcu7t3v3__dfxtp_2
X_3562_ VDD VDD VSS VSS _4619_/A _4264_/A _3570_/B gf180mcu_as_sc_mcu7t3v3__nand2b_2
XFILLER_52_2 VDD VDD VSS VSS gf180mcu_as_sc_mcu7t3v3__fillcap_8
X_5301_ VDD VDD VSS VSS _5301_/S _5944_/A _5301_/A _5302_/D gf180mcu_as_sc_mcu7t3v3__mux2_2
X_6281_ VDD VDD VSS VSS _6509_/CLK _6281_/D _6281_/Q gf180mcu_as_sc_mcu7t3v3__dfxtp_2
X_3493_ VDD VDD VSS VSS _3494_/B _5346_/C _5346_/A gf180mcu_as_sc_mcu7t3v3__nand2_2
X_5232_ VDD VDD VSS VSS _5233_/D _5232_/C _5242_/B _5877_/A gf180mcu_as_sc_mcu7t3v3__aoi21_2
XFILLER_155_1170 VDD VDD VSS VSS gf180mcu_as_sc_mcu7t3v3__fillcap_16
XFILLER_9_1256 VDD VDD VSS VSS gf180mcu_as_sc_mcu7t3v3__fillcap_4
XPHY_EDGE_ROW_109_1_Left_337 VDD VSS gf180mcu_as_sc_mcu7t3v3__tap_2
X_5163_ VDD VDD VSS VSS _5267_/S _5819_/A _5163_/A _5164_/B gf180mcu_as_sc_mcu7t3v3__mux2_2
XFILLER_155_1192 VDD VDD VSS VSS gf180mcu_as_sc_mcu7t3v3__fillcap_16
XFILLER_69_666 VDD VDD VSS VSS gf180mcu_as_sc_mcu7t3v3__fill_1
X_4114_ VDD VDD VSS VSS _4115_/B _6165_/Q _4607_/A _4145_/D gf180mcu_as_sc_mcu7t3v3__ao21_2
XPHY_EDGE_ROW_16_Left_245 VDD VSS gf180mcu_as_sc_mcu7t3v3__tap_2
X_5094_ VDD VDD VSS VSS _5096_/C _5759_/A _5311_/B _5094_/C gf180mcu_as_sc_mcu7t3v3__ao21_2
XTAP_TAPCELL_ROW_6_1126 VDD VSS gf180mcu_as_sc_mcu7t3v3__tap_2
XTAP_TAPCELL_ROW_6_1115 VDD VSS gf180mcu_as_sc_mcu7t3v3__tap_2
XFILLER_186_1119 VDD VDD VSS VSS gf180mcu_as_sc_mcu7t3v3__fillcap_16
XFILLER_204_85 VDD VDD VSS VSS gf180mcu_as_sc_mcu7t3v3__fillcap_8
X_4045_ VDD VDD VSS VSS _4045_/D _4045_/A _4045_/B _4061_/C _6121_/D gf180mcu_as_sc_mcu7t3v3__ao31_2
XFILLER_225_686 VDD VDD VSS VSS gf180mcu_as_sc_mcu7t3v3__fill_2
XFILLER_227_1116 VDD VDD VSS VSS gf180mcu_as_sc_mcu7t3v3__fillcap_4
XFILLER_227_1138 VDD VDD VSS VSS gf180mcu_as_sc_mcu7t3v3__fillcap_16
XFILLER_12_419 VDD VDD VSS VSS gf180mcu_as_sc_mcu7t3v3__fill_1
X_5996_ VDD VDD VSS VSS _6011_/B _6219_/Q _6509_/D gf180mcu_as_sc_mcu7t3v3__and2_2
XFILLER_200_509 VDD VDD VSS VSS gf180mcu_as_sc_mcu7t3v3__fillcap_8
XFILLER_33_27 VDD VDD VSS VSS gf180mcu_as_sc_mcu7t3v3__fillcap_16
X_4947_ VDD VDD VSS VSS _4948_/D _4947_/C _4959_/B _4947_/A gf180mcu_as_sc_mcu7t3v3__aoi21_2
XFILLER_193_711 VDD VDD VSS VSS gf180mcu_as_sc_mcu7t3v3__fill_2
X_4878_ VDD VDD VSS VSS _5224_/A _4878_/B _4878_/C _4880_/B _4879_/D gf180mcu_as_sc_mcu7t3v3__ao211_2
XFILLER_166_958 VDD VDD VSS VSS gf180mcu_as_sc_mcu7t3v3__fillcap_4
XFILLER_192_210 VDD VDD VSS VSS gf180mcu_as_sc_mcu7t3v3__fillcap_4
XPHY_EDGE_ROW_134_1_Right_706 VDD VSS gf180mcu_as_sc_mcu7t3v3__tap_2
X_3829_ VDD VDD VSS VSS _4043_/B _5819_/A _3865_/B _3829_/C gf180mcu_as_sc_mcu7t3v3__ao21_2
XFILLER_153_608 VDD VDD VSS VSS gf180mcu_as_sc_mcu7t3v3__fillcap_8
XFILLER_165_479 VDD VDD VSS VSS gf180mcu_as_sc_mcu7t3v3__fill_1
XFILLER_192_243 VDD VDD VSS VSS gf180mcu_as_sc_mcu7t3v3__fill_2
XFILLER_193_766 VDD VDD VSS VSS gf180mcu_as_sc_mcu7t3v3__fillcap_4
XFILLER_152_107 VDD VDD VSS VSS gf180mcu_as_sc_mcu7t3v3__fillcap_16
XFILLER_3_106 VDD VDD VSS VSS gf180mcu_as_sc_mcu7t3v3__fill_2
X_6548_ VDD VDD VSS VSS clkload9/A _6548_/D _6548_/Q gf180mcu_as_sc_mcu7t3v3__dfxtp_2
X_6479_ VDD VDD VSS VSS _6484_/CLK _6479_/D _6479_/Q gf180mcu_as_sc_mcu7t3v3__dfxtp_2
XFILLER_0_813 VDD VDD VSS VSS gf180mcu_as_sc_mcu7t3v3__fill_2
XPHY_EDGE_ROW_117_2_Right_954 VDD VSS gf180mcu_as_sc_mcu7t3v3__tap_2
XFILLER_134_1210 VDD VDD VSS VSS gf180mcu_as_sc_mcu7t3v3__fillcap_16
XFILLER_161_696 VDD VDD VSS VSS gf180mcu_as_sc_mcu7t3v3__fillcap_4
Xwire1013 VDD VDD VSS VSS wire1013/A _5749_/B gf180mcu_as_sc_mcu7t3v3__clkbuff_12
XFILLER_207_108 VDD VDD VSS VSS gf180mcu_as_sc_mcu7t3v3__fill_2
XPHY_EDGE_ROW_52_3_Right_132 VDD VSS gf180mcu_as_sc_mcu7t3v3__tap_2
XTAP_TAPCELL_ROW_204_2418 VDD VSS gf180mcu_as_sc_mcu7t3v3__tap_2
XTAP_TAPCELL_ROW_204_2407 VDD VSS gf180mcu_as_sc_mcu7t3v3__tap_2
XFILLER_74_45 VDD VDD VSS VSS gf180mcu_as_sc_mcu7t3v3__fillcap_4
XPHY_EDGE_ROW_30_1_Left_258 VDD VSS gf180mcu_as_sc_mcu7t3v3__tap_2
XTAP_TAPCELL_ROW_221_2721 VDD VSS gf180mcu_as_sc_mcu7t3v3__tap_2
XFILLER_167_1052 VDD VDD VSS VSS gf180mcu_as_sc_mcu7t3v3__fillcap_16
XFILLER_16_747 VDD VDD VSS VSS gf180mcu_as_sc_mcu7t3v3__fill_1
XFILLER_16_758 VDD VDD VSS VSS gf180mcu_as_sc_mcu7t3v3__fillcap_16
XFILLER_216_664 VDD VDD VSS VSS gf180mcu_as_sc_mcu7t3v3__fill_1
XFILLER_216_675 VDD VDD VSS VSS gf180mcu_as_sc_mcu7t3v3__fill_2
XFILLER_15_279 VDD VDD VSS VSS gf180mcu_as_sc_mcu7t3v3__fill_1
XTAP_TAPCELL_ROW_178_1952 VDD VSS gf180mcu_as_sc_mcu7t3v3__tap_2
XTAP_TAPCELL_ROW_178_1941 VDD VSS gf180mcu_as_sc_mcu7t3v3__tap_2
XFILLER_180_1263 VDD VDD VSS VSS gf180mcu_as_sc_mcu7t3v3__fill_2
XFILLER_156_446 VDD VDD VSS VSS gf180mcu_as_sc_mcu7t3v3__fillcap_8
XFILLER_211_391 VDD VDD VSS VSS gf180mcu_as_sc_mcu7t3v3__fillcap_4
XPHY_EDGE_ROW_92_1_Left_320 VDD VSS gf180mcu_as_sc_mcu7t3v3__tap_2
XTAP_TAPCELL_ROW_219_2683 VDD VSS gf180mcu_as_sc_mcu7t3v3__tap_2
XFILLER_11_485 VDD VDD VSS VSS gf180mcu_as_sc_mcu7t3v3__fillcap_4
XFILLER_11_496 VDD VDD VSS VSS gf180mcu_as_sc_mcu7t3v3__fill_2
XFILLER_156_457 VDD VDD VSS VSS gf180mcu_as_sc_mcu7t3v3__fillcap_16
XFILLER_171_405 VDD VDD VSS VSS gf180mcu_as_sc_mcu7t3v3__fillcap_8
XFILLER_7_456 VDD VDD VSS VSS gf180mcu_as_sc_mcu7t3v3__fillcap_4
XFILLER_8_979 VDD VDD VSS VSS gf180mcu_as_sc_mcu7t3v3__fillcap_16
XFILLER_180_961 VDD VDD VSS VSS gf180mcu_as_sc_mcu7t3v3__fill_2
XFILLER_225_18 VDD VDD VSS VSS gf180mcu_as_sc_mcu7t3v3__fill_2
XPHY_EDGE_ROW_129_3_Right_209 VDD VSS gf180mcu_as_sc_mcu7t3v3__tap_2
XFILLER_226_428 VDD VDD VSS VSS gf180mcu_as_sc_mcu7t3v3__fill_1
XFILLER_0_1017 VDD VDD VSS VSS gf180mcu_as_sc_mcu7t3v3__fill_2
XFILLER_0_42 VDD VDD VSS VSS gf180mcu_as_sc_mcu7t3v3__fill_1
XFILLER_206_130 VDD VDD VSS VSS gf180mcu_as_sc_mcu7t3v3__fill_1
XTAP_TAPCELL_ROW_68_2_2950 VDD VSS gf180mcu_as_sc_mcu7t3v3__tap_2
XFILLER_0_1028 VDD VDD VSS VSS gf180mcu_as_sc_mcu7t3v3__fill_1
XFILLER_222_612 VDD VDD VSS VSS gf180mcu_as_sc_mcu7t3v3__fillcap_4
XTAP_TAPCELL_ROW_1_1023 VDD VSS gf180mcu_as_sc_mcu7t3v3__tap_2
XFILLER_222_645 VDD VDD VSS VSS gf180mcu_as_sc_mcu7t3v3__fillcap_8
X_5850_ VDD VDD VSS VSS _5850_/A _5869_/B _5850_/C _5850_/D _5851_/B gf180mcu_as_sc_mcu7t3v3__ao211_2
XTAP_TAPCELL_ROW_1_1034 VDD VSS gf180mcu_as_sc_mcu7t3v3__tap_2
XFILLER_210_807 VDD VDD VSS VSS gf180mcu_as_sc_mcu7t3v3__fill_2
X_5781_ VDD VDD VSS VSS _5840_/B _5781_/A _5784_/C gf180mcu_as_sc_mcu7t3v3__and2_2
X_4801_ VDD VDD VSS VSS _5805_/A _4875_/B _4801_/C _4867_/D _4804_/C gf180mcu_as_sc_mcu7t3v3__ao211_2
X_4732_ VDD VDD VSS VSS _5745_/A _4863_/B _4732_/C _4732_/D _4733_/B gf180mcu_as_sc_mcu7t3v3__ao211_2
XFILLER_175_744 VDD VDD VSS VSS gf180mcu_as_sc_mcu7t3v3__fillcap_4
X_4663_ VDD VDD VSS VSS _4858_/B _4889_/A _4719_/B gf180mcu_as_sc_mcu7t3v3__and2_2
X_6402_ VDD VDD VSS VSS clkload3/A _6402_/D _6402_/Q gf180mcu_as_sc_mcu7t3v3__dfxtp_2
X_3614_ VDD VDD VSS VSS _3614_/D _3655_/B _3655_/C _3614_/C _3653_/B gf180mcu_as_sc_mcu7t3v3__ao31_2
XFILLER_163_939 VDD VDD VSS VSS gf180mcu_as_sc_mcu7t3v3__fill_1
X_4594_ VDD VDD VSS VSS _4595_/B _6335_/Q _4597_/B gf180mcu_as_sc_mcu7t3v3__and2_2
XFILLER_143_641 VDD VDD VSS VSS gf180mcu_as_sc_mcu7t3v3__fill_2
X_6333_ VDD VDD VSS VSS _6551_/CLK _6333_/D _6333_/Q gf180mcu_as_sc_mcu7t3v3__dfxtp_2
X_3545_ VDD VDD VSS VSS _3639_/A _5293_/A _4615_/C _4615_/D _3546_/C gf180mcu_as_sc_mcu7t3v3__ao211_2
X_6264_ VDD VDD VSS VSS clkload9/A _6264_/D _6264_/Q gf180mcu_as_sc_mcu7t3v3__dfxtp_2
X_3476_ VDD VDD VSS VSS _3653_/D _3617_/D _3615_/A gf180mcu_as_sc_mcu7t3v3__nand2_2
XFILLER_192_1189 VDD VDD VSS VSS gf180mcu_as_sc_mcu7t3v3__fillcap_16
X_5215_ VDD VDD VSS VSS _6516_/Q _5234_/B _5226_/C _5865_/D _5216_/D gf180mcu_as_sc_mcu7t3v3__ao22_2
X_6195_ VDD VDD VSS VSS _6526_/CLK _6195_/D _6195_/Q gf180mcu_as_sc_mcu7t3v3__dfxtp_2
XFILLER_218_929 VDD VDD VSS VSS gf180mcu_as_sc_mcu7t3v3__fillcap_16
XFILLER_28_27 VDD VDD VSS VSS gf180mcu_as_sc_mcu7t3v3__fillcap_8
X_5146_ VDD VDD VSS VSS _5146_/B _5291_/A _6392_/D gf180mcu_as_sc_mcu7t3v3__and2_2
XFILLER_28_49 VDD VDD VSS VSS gf180mcu_as_sc_mcu7t3v3__fill_2
X_5077_ VDD VDD VSS VSS _6501_/Q _5124_/B _5077_/C _5077_/D _5079_/C gf180mcu_as_sc_mcu7t3v3__ao22_2
XFILLER_226_940 VDD VDD VSS VSS gf180mcu_as_sc_mcu7t3v3__fillcap_4
X_4028_ VDD VDD VSS VSS _6109_/D _4028_/C _4029_/C _4028_/A gf180mcu_as_sc_mcu7t3v3__ao21b_2
XFILLER_44_37 VDD VDD VSS VSS gf180mcu_as_sc_mcu7t3v3__fillcap_8
X_5979_ VDD VDD VSS VSS _5979_/Y _5979_/B _5979_/A gf180mcu_as_sc_mcu7t3v3__nor2_2
XTAP_TAPCELL_ROW_195_2252 VDD VSS gf180mcu_as_sc_mcu7t3v3__tap_2
XFILLER_8_209 VDD VDD VSS VSS gf180mcu_as_sc_mcu7t3v3__fillcap_16
Xsram2048.u_bank0_1026 VDD VDD VSS VSS sram2048.u_bank0/WEN[0] gf180mcu_as_sc_mcu7t3v3__tiel_4
XTAP_TAPCELL_ROW_156_1546 VDD VSS gf180mcu_as_sc_mcu7t3v3__tap_2
XTAP_TAPCELL_ROW_156_1557 VDD VSS gf180mcu_as_sc_mcu7t3v3__tap_2
XFILLER_10_1103 VDD VDD VSS VSS gf180mcu_as_sc_mcu7t3v3__fillcap_16
XFILLER_176_69 VDD VDD VSS VSS gf180mcu_as_sc_mcu7t3v3__fillcap_16
XFILLER_193_574 VDD VDD VSS VSS gf180mcu_as_sc_mcu7t3v3__fill_2
XPHY_EDGE_ROW_135_1_Right_707 VDD VSS gf180mcu_as_sc_mcu7t3v3__tap_2
XTAP_TAPCELL_ROW_173_1860 VDD VSS gf180mcu_as_sc_mcu7t3v3__tap_2
XTAP_TAPCELL_ROW_214_2591 VDD VSS gf180mcu_as_sc_mcu7t3v3__tap_2
XPHY_EDGE_ROW_118_2_Right_955 VDD VSS gf180mcu_as_sc_mcu7t3v3__tap_2
XFILLER_212_1259 VDD VDD VSS VSS gf180mcu_as_sc_mcu7t3v3__fillcap_4
XFILLER_21_1210 VDD VDD VSS VSS gf180mcu_as_sc_mcu7t3v3__fill_2
XTAP_TAPCELL_ROW_15_1277 VDD VSS gf180mcu_as_sc_mcu7t3v3__tap_2
XTAP_TAPCELL_ROW_15_1288 VDD VSS gf180mcu_as_sc_mcu7t3v3__tap_2
XFILLER_217_940 VDD VDD VSS VSS gf180mcu_as_sc_mcu7t3v3__fillcap_16
XFILLER_141_50 VDD VDD VSS VSS gf180mcu_as_sc_mcu7t3v3__fill_1
XPHY_EDGE_ROW_53_3_Right_133 VDD VSS gf180mcu_as_sc_mcu7t3v3__tap_2
XPHY_EDGE_ROW_17_3_Left_722 VDD VSS gf180mcu_as_sc_mcu7t3v3__tap_2
XFILLER_16_577 VDD VDD VSS VSS gf180mcu_as_sc_mcu7t3v3__fill_1
XFILLER_15_1014 VDD VDD VSS VSS gf180mcu_as_sc_mcu7t3v3__fillcap_16
XFILLER_11_260 VDD VDD VSS VSS gf180mcu_as_sc_mcu7t3v3__fillcap_16
XFILLER_11_282 VDD VDD VSS VSS gf180mcu_as_sc_mcu7t3v3__fillcap_16
XFILLER_200_884 VDD VDD VSS VSS gf180mcu_as_sc_mcu7t3v3__fill_2
XFILLER_157_788 VDD VDD VSS VSS gf180mcu_as_sc_mcu7t3v3__fillcap_8
XFILLER_171_224 VDD VDD VSS VSS gf180mcu_as_sc_mcu7t3v3__fillcap_16
XFILLER_125_652 VDD VDD VSS VSS gf180mcu_as_sc_mcu7t3v3__fillcap_8
X_3330_ VDD VDD VSS VSS _3353_/A _3330_/B _3330_/C _3331_/C gf180mcu_as_sc_mcu7t3v3__nor3_2
XFILLER_140_622 VDD VDD VSS VSS gf180mcu_as_sc_mcu7t3v3__fillcap_4
X_5000_ VDD VDD VSS VSS _5005_/A _5661_/D _5354_/C gf180mcu_as_sc_mcu7t3v3__nor2_2
X_3261_ VDD VDD VSS VSS _3280_/C _3261_/A _3262_/B gf180mcu_as_sc_mcu7t3v3__or2_2
XFILLER_152_1151 VDD VDD VSS VSS gf180mcu_as_sc_mcu7t3v3__fillcap_4
X_3192_ VDD VDD VSS VSS _3288_/C _3355_/B _3192_/Y gf180mcu_as_sc_mcu7t3v3__or2_2
XFILLER_152_1173 VDD VDD VSS VSS gf180mcu_as_sc_mcu7t3v3__fillcap_16
XFILLER_39_647 VDD VDD VSS VSS gf180mcu_as_sc_mcu7t3v3__fillcap_8
XFILLER_6_1259 VDD VDD VSS VSS gf180mcu_as_sc_mcu7t3v3__fillcap_4
XFILLER_226_247 VDD VDD VSS VSS gf180mcu_as_sc_mcu7t3v3__fillcap_4
XFILLER_208_995 VDD VDD VSS VSS gf180mcu_as_sc_mcu7t3v3__fillcap_16
X_5902_ VDD VDD VSS VSS _5902_/B _5956_/A _6476_/D gf180mcu_as_sc_mcu7t3v3__and2_2
XFILLER_224_1119 VDD VDD VSS VSS gf180mcu_as_sc_mcu7t3v3__fillcap_16
X_5833_ VDD VDD VSS VSS _5833_/A _5953_/B _5953_/C _5833_/D _5834_/D gf180mcu_as_sc_mcu7t3v3__ao22_2
XFILLER_195_828 VDD VDD VSS VSS gf180mcu_as_sc_mcu7t3v3__fill_1
XFILLER_210_615 VDD VDD VSS VSS gf180mcu_as_sc_mcu7t3v3__fillcap_16
XFILLER_223_998 VDD VDD VSS VSS gf180mcu_as_sc_mcu7t3v3__fillcap_16
XFILLER_124_1242 VDD VDD VSS VSS gf180mcu_as_sc_mcu7t3v3__fill_1
XFILLER_188_891 VDD VDD VSS VSS gf180mcu_as_sc_mcu7t3v3__fill_2
X_5764_ VDD VDD VSS VSS _5861_/B _5764_/A _5767_/C gf180mcu_as_sc_mcu7t3v3__and2_2
X_5695_ VDD VDD VSS VSS _5795_/S _5695_/B _5695_/A _5696_/B gf180mcu_as_sc_mcu7t3v3__mux2_2
X_4715_ VDD VDD VSS VSS _5728_/A _4872_/B _4715_/C _4715_/D _4716_/B gf180mcu_as_sc_mcu7t3v3__ao211_2
X_4646_ VDD VDD VSS VSS _4646_/D _4889_/A _4646_/B _4646_/C _4659_/A gf180mcu_as_sc_mcu7t3v3__ao31_2
XTAP_TAPCELL_ROW_190_2160 VDD VSS gf180mcu_as_sc_mcu7t3v3__tap_2
X_4577_ VDD VDD VSS VSS _4603_/A _4577_/A _6312_/D gf180mcu_as_sc_mcu7t3v3__and2_2
XFILLER_162_279 VDD VDD VSS VSS gf180mcu_as_sc_mcu7t3v3__fillcap_16
XFILLER_190_566 VDD VDD VSS VSS gf180mcu_as_sc_mcu7t3v3__fillcap_16
XPHY_EDGE_ROW_203_Left_431 VDD VSS gf180mcu_as_sc_mcu7t3v3__tap_2
XTAP_TAPCELL_ROW_151_1454 VDD VSS gf180mcu_as_sc_mcu7t3v3__tap_2
XTAP_TAPCELL_ROW_151_1465 VDD VSS gf180mcu_as_sc_mcu7t3v3__tap_2
X_6316_ VDD VDD VSS VSS _6316_/CLK _6316_/D _6316_/Q gf180mcu_as_sc_mcu7t3v3__dfxtp_2
XFILLER_157_1084 VDD VDD VSS VSS gf180mcu_as_sc_mcu7t3v3__fillcap_16
XFILLER_1_429 VDD VDD VSS VSS gf180mcu_as_sc_mcu7t3v3__fill_1
X_3528_ VDD VDD VSS VSS _5335_/C _5319_/A _5920_/A gf180mcu_as_sc_mcu7t3v3__nor2b_2
XFILLER_131_666 VDD VDD VSS VSS gf180mcu_as_sc_mcu7t3v3__fill_1
XFILLER_44_1210 VDD VDD VSS VSS gf180mcu_as_sc_mcu7t3v3__fillcap_8
XPHY_EDGE_ROW_122_2_Left_563 VDD VSS gf180mcu_as_sc_mcu7t3v3__tap_2
X_6247_ VDD VDD VSS VSS _6531_/CLK _6247_/D _6247_/Q gf180mcu_as_sc_mcu7t3v3__dfxtp_2
X_3459_ VDD VDD VSS VSS _5970_/A _6489_/Q _6490_/Q gf180mcu_as_sc_mcu7t3v3__nor2_2
X_6178_ VDD VDD VSS VSS _6376_/CLK _6178_/D _6178_/Q gf180mcu_as_sc_mcu7t3v3__dfxtp_2
X_5129_ VDD VDD VSS VSS _5130_/D _5791_/A _5138_/B _5141_/B gf180mcu_as_sc_mcu7t3v3__ao21_2
XPHY_EDGE_ROW_212_Left_440 VDD VSS gf180mcu_as_sc_mcu7t3v3__tap_2
XTAP_TAPCELL_ROW_10_1185 VDD VSS gf180mcu_as_sc_mcu7t3v3__tap_2
XTAP_TAPCELL_ROW_10_1196 VDD VSS gf180mcu_as_sc_mcu7t3v3__tap_2
XFILLER_164_1033 VDD VDD VSS VSS gf180mcu_as_sc_mcu7t3v3__fillcap_16
XFILLER_13_558 VDD VDD VSS VSS gf180mcu_as_sc_mcu7t3v3__fill_2
XFILLER_198_677 VDD VDD VSS VSS gf180mcu_as_sc_mcu7t3v3__fill_1
XFILLER_201_615 VDD VDD VSS VSS gf180mcu_as_sc_mcu7t3v3__fillcap_8
XFILLER_185_349 VDD VDD VSS VSS gf180mcu_as_sc_mcu7t3v3__fill_1
XFILLER_187_35 VDD VDD VSS VSS gf180mcu_as_sc_mcu7t3v3__fill_2
XFILLER_205_1030 VDD VDD VSS VSS gf180mcu_as_sc_mcu7t3v3__fillcap_16
XFILLER_205_1052 VDD VDD VSS VSS gf180mcu_as_sc_mcu7t3v3__fillcap_16
XFILLER_51_1214 VDD VDD VSS VSS gf180mcu_as_sc_mcu7t3v3__fill_1
XTAP_TAPCELL_ROW_175_1900 VDD VSS gf180mcu_as_sc_mcu7t3v3__tap_2
XFILLER_194_861 VDD VDD VSS VSS gf180mcu_as_sc_mcu7t3v3__fillcap_4
XTAP_TAPCELL_ROW_216_2631 VDD VSS gf180mcu_as_sc_mcu7t3v3__tap_2
XFILLER_154_714 VDD VDD VSS VSS gf180mcu_as_sc_mcu7t3v3__fillcap_16
XFILLER_193_360 VDD VDD VSS VSS gf180mcu_as_sc_mcu7t3v3__fill_2
XFILLER_217_2 VDD VDD VSS VSS gf180mcu_as_sc_mcu7t3v3__fillcap_16
XTAP_TAPCELL_ROW_171_1819 VDD VSS gf180mcu_as_sc_mcu7t3v3__tap_2
XPHY_EDGE_ROW_136_1_Right_708 VDD VSS gf180mcu_as_sc_mcu7t3v3__tap_2
XTAP_TAPCELL_ROW_121_2_3030 VDD VSS gf180mcu_as_sc_mcu7t3v3__tap_2
XFILLER_150_931 VDD VDD VSS VSS gf180mcu_as_sc_mcu7t3v3__fill_2
XFILLER_162_791 VDD VDD VSS VSS gf180mcu_as_sc_mcu7t3v3__fill_2
XFILLER_4_278 VDD VDD VSS VSS gf180mcu_as_sc_mcu7t3v3__fillcap_8
XPHY_EDGE_ROW_54_2_Left_495 VDD VSS gf180mcu_as_sc_mcu7t3v3__tap_2
XPHY_EDGE_ROW_119_2_Right_956 VDD VSS gf180mcu_as_sc_mcu7t3v3__tap_2
Xinput330 VDD VDD VSS VSS west_in[34] wire976/A gf180mcu_as_sc_mcu7t3v3__buff_12
XFILLER_0_484 VDD VDD VSS VSS gf180mcu_as_sc_mcu7t3v3__fill_1
XFILLER_208_258 VDD VDD VSS VSS gf180mcu_as_sc_mcu7t3v3__fillcap_4
XFILLER_36_639 VDD VDD VSS VSS gf180mcu_as_sc_mcu7t3v3__fill_1
XPHY_EDGE_ROW_54_3_Right_134 VDD VSS gf180mcu_as_sc_mcu7t3v3__tap_2
XFILLER_205_976 VDD VDD VSS VSS gf180mcu_as_sc_mcu7t3v3__fillcap_4
XFILLER_149_508 VDD VDD VSS VSS gf180mcu_as_sc_mcu7t3v3__fill_2
XFILLER_205_998 VDD VDD VSS VSS gf180mcu_as_sc_mcu7t3v3__fillcap_16
XFILLER_176_338 VDD VDD VSS VSS gf180mcu_as_sc_mcu7t3v3__fillcap_4
XFILLER_189_699 VDD VDD VSS VSS gf180mcu_as_sc_mcu7t3v3__fill_1
XFILLER_220_979 VDD VDD VSS VSS gf180mcu_as_sc_mcu7t3v3__fillcap_16
XFILLER_157_552 VDD VDD VSS VSS gf180mcu_as_sc_mcu7t3v3__fillcap_4
XPHY_EDGE_ROW_118_1_Left_346 VDD VSS gf180mcu_as_sc_mcu7t3v3__tap_2
X_5480_ VDD VDD VSS VSS _5786_/D _5495_/B _5480_/C _5480_/D _5481_/B gf180mcu_as_sc_mcu7t3v3__ao211_2
X_4500_ VDD VDD VSS VSS _6286_/D _4500_/C _4503_/C _6286_/Q gf180mcu_as_sc_mcu7t3v3__aoi21b_2
XANTENNA_1 VDD VDD VSS VSS _6348_/D gf180mcu_as_sc_mcu7t3v3__diode_2
XFILLER_172_544 VDD VDD VSS VSS gf180mcu_as_sc_mcu7t3v3__fill_1
X_4431_ VDD VDD VSS VSS _6247_/Q _4446_/D _4446_/B _6246_/Q _6246_/D gf180mcu_as_sc_mcu7t3v3__ao22_2
XFILLER_160_706 VDD VDD VSS VSS gf180mcu_as_sc_mcu7t3v3__fillcap_8
XFILLER_160_728 VDD VDD VSS VSS gf180mcu_as_sc_mcu7t3v3__fillcap_4
XFILLER_6_85 VDD VDD VSS VSS gf180mcu_as_sc_mcu7t3v3__fillcap_16
XFILLER_193_1262 VDD VDD VSS VSS gf180mcu_as_sc_mcu7t3v3__fill_2
X_4362_ VDD VDD VSS VSS _4362_/A _6120_/Q _4362_/C _4362_/D _4366_/C gf180mcu_as_sc_mcu7t3v3__ao211_2
XFILLER_113_666 VDD VDD VSS VSS gf180mcu_as_sc_mcu7t3v3__fill_1
Xfanout519 VDD VDD VSS VSS _4014_/C _4008_/C gf180mcu_as_sc_mcu7t3v3__buff_12
X_6101_ VDD VDD VSS VSS _6376_/CLK _6101_/D _6101_/Q gf180mcu_as_sc_mcu7t3v3__dfxtp_2
X_4293_ VDD VDD VSS VSS _4293_/S _6052_/Q _6081_/Q _4296_/B gf180mcu_as_sc_mcu7t3v3__mux2_2
X_3313_ VDD VDD VSS VSS _6212_/Q _4101_/S _4089_/S _6220_/Q _3315_/B gf180mcu_as_sc_mcu7t3v3__ao22_2
XTAP_TAPCELL_ROW_56_2_2932 VDD VSS gf180mcu_as_sc_mcu7t3v3__tap_2
X_6032_ VDD VDD VSS VSS _6506_/CLK _6032_/D _6032_/Q gf180mcu_as_sc_mcu7t3v3__dfxtp_2
X_3244_ VDD VDD VSS VSS _3245_/C _3294_/B _3244_/B _3299_/A gf180mcu_as_sc_mcu7t3v3__ao21_2
X_3175_ VDD VDD VSS VSS _3176_/C _3175_/A _4112_/C gf180mcu_as_sc_mcu7t3v3__and2_2
XFILLER_35_650 VDD VDD VSS VSS gf180mcu_as_sc_mcu7t3v3__fillcap_8
XFILLER_212_85 VDD VDD VSS VSS gf180mcu_as_sc_mcu7t3v3__fillcap_16
XFILLER_228_1041 VDD VDD VSS VSS gf180mcu_as_sc_mcu7t3v3__fillcap_4
XFILLER_210_401 VDD VDD VSS VSS gf180mcu_as_sc_mcu7t3v3__fill_1
XFILLER_211_924 VDD VDD VSS VSS gf180mcu_as_sc_mcu7t3v3__fillcap_16
XTAP_TAPCELL_ROW_192_2200 VDD VSS gf180mcu_as_sc_mcu7t3v3__tap_2
X_5816_ VDD VDD VSS VSS _5816_/A _5864_/B _5816_/C _5816_/D _5818_/C gf180mcu_as_sc_mcu7t3v3__ao211_2
XFILLER_194_146 VDD VDD VSS VSS gf180mcu_as_sc_mcu7t3v3__fill_1
XFILLER_41_27 VDD VDD VSS VSS gf180mcu_as_sc_mcu7t3v3__fillcap_16
X_5747_ VDD VDD VSS VSS _5747_/B _5836_/A _6457_/D gf180mcu_as_sc_mcu7t3v3__and2_2
XFILLER_157_38 VDD VDD VSS VSS gf180mcu_as_sc_mcu7t3v3__fillcap_16
XFILLER_163_500 VDD VDD VSS VSS gf180mcu_as_sc_mcu7t3v3__fillcap_4
XFILLER_175_360 VDD VDD VSS VSS gf180mcu_as_sc_mcu7t3v3__fill_2
XFILLER_198_1151 VDD VDD VSS VSS gf180mcu_as_sc_mcu7t3v3__fillcap_4
XFILLER_191_842 VDD VDD VSS VSS gf180mcu_as_sc_mcu7t3v3__fill_2
XFILLER_198_1173 VDD VDD VSS VSS gf180mcu_as_sc_mcu7t3v3__fillcap_16
X_5678_ VDD VDD VSS VSS _5678_/A _5869_/B _5678_/C _5678_/D _5679_/B gf180mcu_as_sc_mcu7t3v3__ao211_2
XFILLER_11_1264 VDD VDD VSS VSS gf180mcu_as_sc_mcu7t3v3__fill_1
X_4629_ VDD VDD VSS VSS _4630_/C _4945_/B _4639_/A gf180mcu_as_sc_mcu7t3v3__nor2_2
XFILLER_104_666 VDD VDD VSS VSS gf180mcu_as_sc_mcu7t3v3__fill_1
XPHY_EDGE_ROW_60_1_Right_632 VDD VSS gf180mcu_as_sc_mcu7t3v3__tap_2
XPHY_EDGE_ROW_8_Left_237 VDD VSS gf180mcu_as_sc_mcu7t3v3__tap_2
XTAP_TAPCELL_ROW_168_1770 VDD VSS gf180mcu_as_sc_mcu7t3v3__tap_2
XFILLER_170_1081 VDD VDD VSS VSS gf180mcu_as_sc_mcu7t3v3__fillcap_4
XPHY_EDGE_ROW_43_2_Right_880 VDD VSS gf180mcu_as_sc_mcu7t3v3__tap_2
XTAP_TAPCELL_ROW_12_1225 VDD VSS gf180mcu_as_sc_mcu7t3v3__tap_2
XTAP_TAPCELL_ROW_12_1236 VDD VSS gf180mcu_as_sc_mcu7t3v3__tap_2
XTAP_TAPCELL_ROW_164_1689 VDD VSS gf180mcu_as_sc_mcu7t3v3__tap_2
XTAP_TAPCELL_ROW_181_1992 VDD VSS gf180mcu_as_sc_mcu7t3v3__tap_2
XFILLER_14_823 VDD VDD VSS VSS gf180mcu_as_sc_mcu7t3v3__fillcap_16
XFILLER_82_45 VDD VDD VSS VSS gf180mcu_as_sc_mcu7t3v3__fillcap_4
XFILLER_159_839 VDD VDD VSS VSS gf180mcu_as_sc_mcu7t3v3__fill_1
XFILLER_15_72 VDD VDD VSS VSS gf180mcu_as_sc_mcu7t3v3__fillcap_16
XFILLER_41_664 VDD VDD VSS VSS gf180mcu_as_sc_mcu7t3v3__fill_2
XFILLER_185_135 VDD VDD VSS VSS gf180mcu_as_sc_mcu7t3v3__fillcap_4
XFILLER_202_979 VDD VDD VSS VSS gf180mcu_as_sc_mcu7t3v3__fillcap_16
XFILLER_9_348 VDD VDD VSS VSS gf180mcu_as_sc_mcu7t3v3__fill_2
XFILLER_12_1017 VDD VDD VSS VSS gf180mcu_as_sc_mcu7t3v3__fillcap_16
XFILLER_201_489 VDD VDD VSS VSS gf180mcu_as_sc_mcu7t3v3__fill_1
XFILLER_177_1224 VDD VDD VSS VSS gf180mcu_as_sc_mcu7t3v3__fillcap_16
XFILLER_193_190 VDD VDD VSS VSS gf180mcu_as_sc_mcu7t3v3__fill_2
XFILLER_181_385 VDD VDD VSS VSS gf180mcu_as_sc_mcu7t3v3__fill_2
XFILLER_181_396 VDD VDD VSS VSS gf180mcu_as_sc_mcu7t3v3__fill_1
XFILLER_218_1221 VDD VDD VSS VSS gf180mcu_as_sc_mcu7t3v3__fillcap_4
XPHY_EDGE_ROW_137_1_Right_709 VDD VSS gf180mcu_as_sc_mcu7t3v3__tap_2
XFILLER_218_1243 VDD VDD VSS VSS gf180mcu_as_sc_mcu7t3v3__fillcap_16
XFILLER_1_793 VDD VDD VSS VSS gf180mcu_as_sc_mcu7t3v3__fill_1
Xinput160 VDD VDD VSS VSS nw_in[11] _5768_/A gf180mcu_as_sc_mcu7t3v3__buff_12
Xinput171 VDD VDD VSS VSS nw_in[21] _5849_/A gf180mcu_as_sc_mcu7t3v3__buff_12
Xinput182 VDD VDD VSS VSS nw_in[31] _5933_/A gf180mcu_as_sc_mcu7t3v3__buff_12
Xinput193 VDD VDD VSS VSS nw_in[9] _5752_/A gf180mcu_as_sc_mcu7t3v3__buff_12
XFILLER_184_1239 VDD VDD VSS VSS gf180mcu_as_sc_mcu7t3v3__fill_1
X_4980_ VDD VDD VSS VSS _4982_/C _4982_/D _4980_/Y gf180mcu_as_sc_mcu7t3v3__and2_2
XPHY_EDGE_ROW_55_3_Right_135 VDD VSS gf180mcu_as_sc_mcu7t3v3__tap_2
X_3931_ VDD VDD VSS VSS _5908_/A _3931_/B _3931_/C _3931_/D _3932_/C gf180mcu_as_sc_mcu7t3v3__ao211_2
XFILLER_177_636 VDD VDD VSS VSS gf180mcu_as_sc_mcu7t3v3__fill_2
XFILLER_32_653 VDD VDD VSS VSS gf180mcu_as_sc_mcu7t3v3__fillcap_8
X_3862_ VDD VDD VSS VSS _5849_/D _3891_/B _3862_/C _3862_/D _3864_/C gf180mcu_as_sc_mcu7t3v3__ao211_2
X_5601_ VDD VDD VSS VSS _5601_/B _5643_/A _6441_/D gf180mcu_as_sc_mcu7t3v3__and2_2
XFILLER_176_179 VDD VDD VSS VSS gf180mcu_as_sc_mcu7t3v3__fill_1
X_5532_ VDD VDD VSS VSS _6513_/Q _5532_/B _5532_/C _5839_/A _5533_/C gf180mcu_as_sc_mcu7t3v3__ao22_2
X_3793_ VDD VDD VSS VSS _6507_/Q _3804_/B _3804_/C _5790_/B _3794_/C gf180mcu_as_sc_mcu7t3v3__ao22_2
XFILLER_191_138 VDD VDD VSS VSS gf180mcu_as_sc_mcu7t3v3__fill_2
X_5463_ VDD VDD VSS VSS _5770_/A _5568_/B _5568_/C _5769_/A _5464_/D gf180mcu_as_sc_mcu7t3v3__ao22_2
XFILLER_160_536 VDD VDD VSS VSS gf180mcu_as_sc_mcu7t3v3__fill_1
X_5394_ VDD VDD VSS VSS _5496_/B _5703_/A _5394_/A _5395_/C gf180mcu_as_sc_mcu7t3v3__mux2_2
X_4414_ VDD VDD VSS VSS _6230_/Q _4428_/B _4583_/D _6229_/Q _6229_/D gf180mcu_as_sc_mcu7t3v3__ao22_2
XFILLER_99_664 VDD VDD VSS VSS gf180mcu_as_sc_mcu7t3v3__fill_2
X_4345_ VDD VDD VSS VSS _4394_/A _4345_/B _4345_/C _4346_/B _4408_/D gf180mcu_as_sc_mcu7t3v3__oai211_2
XFILLER_154_1065 VDD VDD VSS VSS gf180mcu_as_sc_mcu7t3v3__fillcap_16
XFILLER_154_1087 VDD VDD VSS VSS gf180mcu_as_sc_mcu7t3v3__fillcap_16
X_4276_ VDD VDD VSS VSS _4398_/S _6108_/Q _6021_/Q _4278_/A gf180mcu_as_sc_mcu7t3v3__mux2_2
XTAP_TAPCELL_ROW_185_2070 VDD VSS gf180mcu_as_sc_mcu7t3v3__tap_2
XFILLER_228_843 VDD VDD VSS VSS gf180mcu_as_sc_mcu7t3v3__fillcap_4
X_6015_ VDD VDD VSS VSS _6488_/D _6015_/B _6015_/A gf180mcu_as_sc_mcu7t3v3__nor2_2
X_3227_ VDD VDD VSS VSS _3299_/A _3227_/B _3227_/C _3227_/D _3227_/Y gf180mcu_as_sc_mcu7t3v3__ao22_2
XTAP_TAPCELL_ROW_9_1179 VDD VSS gf180mcu_as_sc_mcu7t3v3__tap_2
XTAP_TAPCELL_ROW_9_1168 VDD VSS gf180mcu_as_sc_mcu7t3v3__tap_2
XFILLER_36_27 VDD VDD VSS VSS gf180mcu_as_sc_mcu7t3v3__fillcap_8
XFILLER_67_594 VDD VDD VSS VSS gf180mcu_as_sc_mcu7t3v3__fillcap_4
X_3158_ VDD VDD VSS VSS _4217_/A _6200_/Q _3159_/A gf180mcu_as_sc_mcu7t3v3__xnor2_2
XFILLER_15_609 VDD VDD VSS VSS gf180mcu_as_sc_mcu7t3v3__fill_2
XFILLER_36_49 VDD VDD VSS VSS gf180mcu_as_sc_mcu7t3v3__fill_2
X_3089_ VDD VDD VSS VSS _3214_/B _3089_/A gf180mcu_as_sc_mcu7t3v3__inv_2
XFILLER_202_209 VDD VDD VSS VSS gf180mcu_as_sc_mcu7t3v3__fill_2
XFILLER_161_1014 VDD VDD VSS VSS gf180mcu_as_sc_mcu7t3v3__fillcap_16
XFILLER_23_664 VDD VDD VSS VSS gf180mcu_as_sc_mcu7t3v3__fill_2
XFILLER_52_48 VDD VDD VSS VSS gf180mcu_as_sc_mcu7t3v3__fill_2
XFILLER_139_6 VDD VDD VSS VSS gf180mcu_as_sc_mcu7t3v3__fillcap_16
XFILLER_168_37 VDD VDD VSS VSS gf180mcu_as_sc_mcu7t3v3__fillcap_16
XFILLER_210_231 VDD VDD VSS VSS gf180mcu_as_sc_mcu7t3v3__fillcap_4
XFILLER_211_776 VDD VDD VSS VSS gf180mcu_as_sc_mcu7t3v3__fill_1
XTAP_TAPCELL_ROW_32_3_2897 VDD VSS gf180mcu_as_sc_mcu7t3v3__tap_2
XFILLER_149_883 VDD VDD VSS VSS gf180mcu_as_sc_mcu7t3v3__fill_1
XFILLER_195_477 VDD VDD VSS VSS gf180mcu_as_sc_mcu7t3v3__fill_2
XFILLER_202_1011 VDD VDD VSS VSS gf180mcu_as_sc_mcu7t3v3__fillcap_4
XFILLER_202_1033 VDD VDD VSS VSS gf180mcu_as_sc_mcu7t3v3__fillcap_16
XFILLER_182_149 VDD VDD VSS VSS gf180mcu_as_sc_mcu7t3v3__fill_1
XFILLER_151_503 VDD VDD VSS VSS gf180mcu_as_sc_mcu7t3v3__fillcap_8
XPHY_EDGE_ROW_154_Left_382 VDD VSS gf180mcu_as_sc_mcu7t3v3__tap_2
XFILLER_163_385 VDD VDD VSS VSS gf180mcu_as_sc_mcu7t3v3__fill_1
XFILLER_191_672 VDD VDD VSS VSS gf180mcu_as_sc_mcu7t3v3__fill_1
XFILLER_151_558 VDD VDD VSS VSS gf180mcu_as_sc_mcu7t3v3__fill_2
XPHY_EDGE_ROW_26_3_Left_731 VDD VSS gf180mcu_as_sc_mcu7t3v3__tap_2
XPHY_EDGE_ROW_61_1_Right_633 VDD VSS gf180mcu_as_sc_mcu7t3v3__tap_2
XFILLER_219_810 VDD VDD VSS VSS gf180mcu_as_sc_mcu7t3v3__fill_1
XTAP_TAPCELL_ROW_166_1729 VDD VSS gf180mcu_as_sc_mcu7t3v3__tap_2
Xfanout850 VDD VDD VSS VSS _4447_/Y _4599_/A gf180mcu_as_sc_mcu7t3v3__buff_12
Xfanout861 VDD VDD VSS VSS _4860_/B _4878_/B gf180mcu_as_sc_mcu7t3v3__buff_12
Xfanout872 VDD VDD VSS VSS _3101_/Y _4610_/C gf180mcu_as_sc_mcu7t3v3__buff_12
Xfanout883 VDD VDD VSS VSS _3304_/Y _4085_/S gf180mcu_as_sc_mcu7t3v3__buff_12
Xfanout894 VDD VDD VSS VSS _3094_/Y fanout894/Y gf180mcu_as_sc_mcu7t3v3__buff_12
XFILLER_58_594 VDD VDD VSS VSS gf180mcu_as_sc_mcu7t3v3__fill_1
XPHY_EDGE_ROW_163_Left_391 VDD VSS gf180mcu_as_sc_mcu7t3v3__tap_2
XPHY_EDGE_ROW_44_2_Right_881 VDD VSS gf180mcu_as_sc_mcu7t3v3__tap_2
XTAP_TAPCELL_ROW_224_2774 VDD VSS gf180mcu_as_sc_mcu7t3v3__tap_2
XFILLER_199_772 VDD VDD VSS VSS gf180mcu_as_sc_mcu7t3v3__fillcap_8
XFILLER_14_675 VDD VDD VSS VSS gf180mcu_as_sc_mcu7t3v3__fill_1
XFILLER_18_1226 VDD VDD VSS VSS gf180mcu_as_sc_mcu7t3v3__fillcap_16
XFILLER_201_220 VDD VDD VSS VSS gf180mcu_as_sc_mcu7t3v3__fillcap_4
XFILLER_13_174 VDD VDD VSS VSS gf180mcu_as_sc_mcu7t3v3__fillcap_16
XFILLER_144_1245 VDD VDD VSS VSS gf180mcu_as_sc_mcu7t3v3__fillcap_16
XFILLER_9_189 VDD VDD VSS VSS gf180mcu_as_sc_mcu7t3v3__fillcap_16
XFILLER_155_853 VDD VDD VSS VSS gf180mcu_as_sc_mcu7t3v3__fillcap_16
XFILLER_190_1221 VDD VDD VSS VSS gf180mcu_as_sc_mcu7t3v3__fillcap_4
XFILLER_64_1235 VDD VDD VSS VSS gf180mcu_as_sc_mcu7t3v3__fillcap_8
X_4130_ VDD VDD VSS VSS _4143_/S _6180_/Q _6179_/Q _6179_/D gf180mcu_as_sc_mcu7t3v3__mux2_2
XPHY_EDGE_ROW_17_2_Left_458 VDD VSS gf180mcu_as_sc_mcu7t3v3__tap_2
X_4061_ VDD VDD VSS VSS _4061_/D _4061_/A _4061_/B _4061_/C _6131_/D gf180mcu_as_sc_mcu7t3v3__ao31_2
X_3012_ VDD VDD VSS VSS _5323_/B _5930_/A gf180mcu_as_sc_mcu7t3v3__inv_2
XFILLER_224_312 VDD VDD VSS VSS gf180mcu_as_sc_mcu7t3v3__fill_2
XFILLER_197_709 VDD VDD VSS VSS gf180mcu_as_sc_mcu7t3v3__fill_2
X_4963_ VDD VDD VSS VSS _5951_/A _4963_/B _4963_/C _4963_/D _4964_/C gf180mcu_as_sc_mcu7t3v3__ao211_2
XTAP_TAPCELL_ROW_4_1087 VDD VSS gf180mcu_as_sc_mcu7t3v3__tap_2
XFILLER_178_934 VDD VDD VSS VSS gf180mcu_as_sc_mcu7t3v3__fill_1
XPHY_EDGE_ROW_56_3_Right_136 VDD VSS gf180mcu_as_sc_mcu7t3v3__tap_2
XPHY_EDGE_ROW_79_2_Left_520 VDD VSS gf180mcu_as_sc_mcu7t3v3__tap_2
X_3914_ VDD VDD VSS VSS _6042_/Q _3933_/B _4058_/B _3933_/D _6042_/D gf180mcu_as_sc_mcu7t3v3__ao22_2
XFILLER_189_282 VDD VDD VSS VSS gf180mcu_as_sc_mcu7t3v3__fillcap_8
XPHY_EDGE_ROW_131_2_Left_572 VDD VSS gf180mcu_as_sc_mcu7t3v3__tap_2
X_4894_ VDD VDD VSS VSS _6366_/D _4894_/C _4950_/D _5883_/A gf180mcu_as_sc_mcu7t3v3__aoi21b_2
XFILLER_192_414 VDD VDD VSS VSS gf180mcu_as_sc_mcu7t3v3__fill_1
XFILLER_20_645 VDD VDD VSS VSS gf180mcu_as_sc_mcu7t3v3__fillcap_16
X_3845_ VDD VDD VSS VSS _5833_/D _3929_/B _3845_/C _3845_/D _3846_/B gf180mcu_as_sc_mcu7t3v3__ao211_2
X_3776_ VDD VDD VSS VSS _5775_/A _3887_/B _3776_/C _3776_/D _3778_/C gf180mcu_as_sc_mcu7t3v3__ao211_2
XTAP_TAPCELL_ROW_44_2_2914 VDD VSS gf180mcu_as_sc_mcu7t3v3__tap_2
XFILLER_157_190 VDD VDD VSS VSS gf180mcu_as_sc_mcu7t3v3__fillcap_16
XFILLER_192_469 VDD VDD VSS VSS gf180mcu_as_sc_mcu7t3v3__fill_1
X_6495_ VDD VDD VSS VSS _6518_/CLK _6495_/D _6495_/Q gf180mcu_as_sc_mcu7t3v3__dfxtp_2
X_5515_ VDD VDD VSS VSS _6511_/Q _5564_/B _5563_/B _5823_/A _5517_/D gf180mcu_as_sc_mcu7t3v3__ao22_2
XFILLER_160_311 VDD VDD VSS VSS gf180mcu_as_sc_mcu7t3v3__fillcap_4
XFILLER_172_171 VDD VDD VSS VSS gf180mcu_as_sc_mcu7t3v3__fillcap_4
XFILLER_195_1154 VDD VDD VSS VSS gf180mcu_as_sc_mcu7t3v3__fillcap_16
Xoutput420 VDD VDD VSS VSS _6387_/Q south_out[10] gf180mcu_as_sc_mcu7t3v3__buff_12
X_5446_ VDD VDD VSS VSS _5447_/C _5446_/B _5446_/A gf180mcu_as_sc_mcu7t3v3__nor2_2
XFILLER_160_333 VDD VDD VSS VSS gf180mcu_as_sc_mcu7t3v3__fillcap_8
Xclkbuf_leaf_6_clk_regs VDD VDD VSS VSS clkload0/A _6552_/CLK gf180mcu_as_sc_mcu7t3v3__clkbuff_12
Xoutput453 VDD VDD VSS VSS _6385_/Q south_out[8] gf180mcu_as_sc_mcu7t3v3__buff_12
Xoutput442 VDD VDD VSS VSS _6407_/Q south_out[30] gf180mcu_as_sc_mcu7t3v3__buff_12
Xoutput431 VDD VDD VSS VSS _6397_/Q south_out[20] gf180mcu_as_sc_mcu7t3v3__buff_12
XTAP_TAPCELL_ROW_187_2110 VDD VSS gf180mcu_as_sc_mcu7t3v3__tap_2
Xoutput486 VDD VDD VSS VSS _6454_/Q west_out[5] gf180mcu_as_sc_mcu7t3v3__buff_12
Xoutput475 VDD VDD VSS VSS _6477_/Q west_out[28] gf180mcu_as_sc_mcu7t3v3__buff_12
Xoutput464 VDD VDD VSS VSS _6467_/Q west_out[18] gf180mcu_as_sc_mcu7t3v3__buff_12
X_5377_ VDD VDD VSS VSS _5685_/D _5494_/B _5377_/C _5377_/D _5379_/C gf180mcu_as_sc_mcu7t3v3__ao211_2
XFILLER_160_399 VDD VDD VSS VSS gf180mcu_as_sc_mcu7t3v3__fill_2
X_4328_ VDD VDD VSS VSS _4370_/S _6057_/Q _6086_/Q _4331_/B gf180mcu_as_sc_mcu7t3v3__mux2_2
XTAP_TAPCELL_ROW_183_2029 VDD VSS gf180mcu_as_sc_mcu7t3v3__tap_2
XFILLER_87_656 VDD VDD VSS VSS gf180mcu_as_sc_mcu7t3v3__fillcap_4
X_4259_ VDD VDD VSS VSS _4259_/D _4283_/A _4259_/B _4259_/C _6205_/D gf180mcu_as_sc_mcu7t3v3__ao31_2
XFILLER_103_43 VDD VDD VSS VSS gf180mcu_as_sc_mcu7t3v3__fillcap_8
XFILLER_15_417 VDD VDD VSS VSS gf180mcu_as_sc_mcu7t3v3__fill_2
XTAP_TAPCELL_ROW_161_1637 VDD VSS gf180mcu_as_sc_mcu7t3v3__tap_2
XTAP_TAPCELL_ROW_161_1648 VDD VSS gf180mcu_as_sc_mcu7t3v3__tap_2
XTAP_TAPCELL_ROW_202_2379 VDD VSS gf180mcu_as_sc_mcu7t3v3__tap_2
XFILLER_11_623 VDD VDD VSS VSS gf180mcu_as_sc_mcu7t3v3__fillcap_4
XFILLER_169_967 VDD VDD VSS VSS gf180mcu_as_sc_mcu7t3v3__fill_1
XFILLER_169_978 VDD VDD VSS VSS gf180mcu_as_sc_mcu7t3v3__fill_2
XFILLER_11_667 VDD VDD VSS VSS gf180mcu_as_sc_mcu7t3v3__fillcap_16
XFILLER_195_252 VDD VDD VSS VSS gf180mcu_as_sc_mcu7t3v3__fill_1
Xwire514 VDD VDD VSS VSS _3278_/Y wire514/Y gf180mcu_as_sc_mcu7t3v3__clkbuff_12
XFILLER_10_155 VDD VDD VSS VSS gf180mcu_as_sc_mcu7t3v3__fillcap_16
XFILLER_10_177 VDD VDD VSS VSS gf180mcu_as_sc_mcu7t3v3__fillcap_16
XFILLER_11_689 VDD VDD VSS VSS gf180mcu_as_sc_mcu7t3v3__fill_1
XTAP_TAPCELL_ROW_159_1599 VDD VSS gf180mcu_as_sc_mcu7t3v3__tap_2
XFILLER_12_62 VDD VDD VSS VSS gf180mcu_as_sc_mcu7t3v3__fillcap_16
XFILLER_174_1205 VDD VDD VSS VSS gf180mcu_as_sc_mcu7t3v3__fillcap_16
XFILLER_192_981 VDD VDD VSS VSS gf180mcu_as_sc_mcu7t3v3__fillcap_16
XFILLER_174_1227 VDD VDD VSS VSS gf180mcu_as_sc_mcu7t3v3__fillcap_16
XFILLER_88_33 VDD VDD VSS VSS gf180mcu_as_sc_mcu7t3v3__fill_2
XFILLER_215_1224 VDD VDD VSS VSS gf180mcu_as_sc_mcu7t3v3__fillcap_16
XFILLER_2_387 VDD VDD VSS VSS gf180mcu_as_sc_mcu7t3v3__fillcap_4
XTAP_TAPCELL_ROW_226_2814 VDD VSS gf180mcu_as_sc_mcu7t3v3__tap_2
XTAP_TAPCELL_ROW_226_2803 VDD VSS gf180mcu_as_sc_mcu7t3v3__tap_2
XPHY_EDGE_ROW_62_1_Right_634 VDD VSS gf180mcu_as_sc_mcu7t3v3__tap_2
XFILLER_150_1260 VDD VDD VSS VSS gf180mcu_as_sc_mcu7t3v3__fill_1
XPHY_EDGE_ROW_127_1_Left_355 VDD VSS gf180mcu_as_sc_mcu7t3v3__tap_2
Xfanout680 VDD VDD VSS VSS _5359_/Y _5535_/B gf180mcu_as_sc_mcu7t3v3__buff_12
Xfanout691 VDD VDD VSS VSS _4962_/C _4955_/C gf180mcu_as_sc_mcu7t3v3__buff_12
XPHY_EDGE_ROW_45_2_Right_882 VDD VSS gf180mcu_as_sc_mcu7t3v3__tap_2
XFILLER_2_1081 VDD VDD VSS VSS gf180mcu_as_sc_mcu7t3v3__fillcap_4
XFILLER_159_400 VDD VDD VSS VSS gf180mcu_as_sc_mcu7t3v3__fillcap_16
XFILLER_159_422 VDD VDD VSS VSS gf180mcu_as_sc_mcu7t3v3__fillcap_4
XFILLER_147_606 VDD VDD VSS VSS gf180mcu_as_sc_mcu7t3v3__fill_2
XFILLER_174_403 VDD VDD VSS VSS gf180mcu_as_sc_mcu7t3v3__fill_2
XFILLER_175_948 VDD VDD VSS VSS gf180mcu_as_sc_mcu7t3v3__fill_1
XFILLER_179_1116 VDD VDD VSS VSS gf180mcu_as_sc_mcu7t3v3__fillcap_4
X_3630_ VDD VDD VSS VSS _3651_/A _5662_/A _5354_/A gf180mcu_as_sc_mcu7t3v3__nand2_2
XFILLER_179_1138 VDD VDD VSS VSS gf180mcu_as_sc_mcu7t3v3__fillcap_16
X_3561_ VDD VDD VSS VSS _3615_/A _5649_/A _3561_/C _3905_/B gf180mcu_as_sc_mcu7t3v3__nand3_2
X_5300_ VDD VDD VSS VSS _5629_/A _5306_/D _5300_/C _6409_/D _5909_/D gf180mcu_as_sc_mcu7t3v3__aoi211_2
XFILLER_154_171 VDD VDD VSS VSS gf180mcu_as_sc_mcu7t3v3__fillcap_4
XFILLER_154_193 VDD VDD VSS VSS gf180mcu_as_sc_mcu7t3v3__fillcap_16
XFILLER_6_682 VDD VDD VSS VSS gf180mcu_as_sc_mcu7t3v3__fillcap_4
Xmax_cap858 VDD VDD VSS VSS fanout857/Y _4837_/B gf180mcu_as_sc_mcu7t3v3__clkbuff_12
X_6280_ VDD VDD VSS VSS clkload5/A _6280_/D _6280_/Q gf180mcu_as_sc_mcu7t3v3__dfxtp_2
X_3492_ VDD VDD VSS VSS _3570_/A _5939_/D _3492_/C _5346_/C _3492_/D gf180mcu_as_sc_mcu7t3v3__aoi211_2
XFILLER_45_2 VDD VDD VSS VSS gf180mcu_as_sc_mcu7t3v3__fillcap_16
X_5231_ VDD VDD VSS VSS _5231_/D _5880_/A _5294_/A _5292_/C _5232_/C gf180mcu_as_sc_mcu7t3v3__ao31_2
XFILLER_9_1224 VDD VDD VSS VSS gf180mcu_as_sc_mcu7t3v3__fillcap_16
X_5162_ VDD VDD VSS VSS _5818_/A _5218_/B _5162_/C _5162_/D _5163_/A gf180mcu_as_sc_mcu7t3v3__ao211_2
XFILLER_151_1046 VDD VDD VSS VSS gf180mcu_as_sc_mcu7t3v3__fillcap_4
XPHY_EDGE_ROW_59_1_Left_287 VDD VSS gf180mcu_as_sc_mcu7t3v3__tap_2
XTAP_TAPCELL_ROW_104_1_1373 VDD VSS gf180mcu_as_sc_mcu7t3v3__tap_2
X_5093_ VDD VDD VSS VSS _5093_/D _5761_/D _5301_/S _5203_/C _5094_/C gf180mcu_as_sc_mcu7t3v3__ao31_2
X_4113_ VDD VDD VSS VSS _4145_/D _4113_/B _4113_/A gf180mcu_as_sc_mcu7t3v3__nor2_2
XFILLER_151_1068 VDD VDD VSS VSS gf180mcu_as_sc_mcu7t3v3__fillcap_16
XTAP_TAPCELL_ROW_6_1127 VDD VSS gf180mcu_as_sc_mcu7t3v3__tap_2
XTAP_TAPCELL_ROW_6_1116 VDD VSS gf180mcu_as_sc_mcu7t3v3__tap_2
XFILLER_204_53 VDD VDD VSS VSS gf180mcu_as_sc_mcu7t3v3__fillcap_16
X_4044_ VDD VDD VSS VSS _4044_/B _6121_/Q _4045_/D gf180mcu_as_sc_mcu7t3v3__and2_2
Xmesh_tile_1090 VDD VDD VSS VSS nw_out[13] gf180mcu_as_sc_mcu7t3v3__tiel_4
X_5995_ VDD VDD VSS VSS _6525_/D _6218_/Q _6508_/D gf180mcu_as_sc_mcu7t3v3__and2_2
XFILLER_220_85 VDD VDD VSS VSS gf180mcu_as_sc_mcu7t3v3__fillcap_8
X_4946_ VDD VDD VSS VSS _4946_/A _4960_/B _4953_/C _5295_/A _4947_/C gf180mcu_as_sc_mcu7t3v3__ao22_2
XPHY_EDGE_ROW_57_3_Right_137 VDD VSS gf180mcu_as_sc_mcu7t3v3__tap_2
X_4877_ VDD VDD VSS VSS _4878_/C _4877_/B _5871_/A gf180mcu_as_sc_mcu7t3v3__nor2_2
X_3828_ VDD VDD VSS VSS _5818_/A _3892_/B _3828_/C _3828_/D _3829_/C gf180mcu_as_sc_mcu7t3v3__ao211_2
XFILLER_192_255 VDD VDD VSS VSS gf180mcu_as_sc_mcu7t3v3__fill_2
X_6547_ VDD VDD VSS VSS clkload9/A _6547_/D _6547_/Q gf180mcu_as_sc_mcu7t3v3__dfxtp_2
X_3759_ VDD VDD VSS VSS _5756_/A _3872_/B _3759_/C _3759_/D _3761_/C gf180mcu_as_sc_mcu7t3v3__ao211_2
XFILLER_165_49 VDD VDD VSS VSS gf180mcu_as_sc_mcu7t3v3__fillcap_16
X_6478_ VDD VDD VSS VSS _6484_/CLK _6478_/D _6478_/Q gf180mcu_as_sc_mcu7t3v3__dfxtp_2
X_5429_ VDD VDD VSS VSS _5735_/A _5640_/C _5429_/C _5429_/D _5430_/B gf180mcu_as_sc_mcu7t3v3__ao211_2
XFILLER_0_847 VDD VDD VSS VSS gf180mcu_as_sc_mcu7t3v3__fill_2
Xwire1014 VDD VDD VSS VSS wire1014/A _5716_/B gf180mcu_as_sc_mcu7t3v3__clkbuff_12
XTAP_TAPCELL_ROW_204_2419 VDD VSS gf180mcu_as_sc_mcu7t3v3__tap_2
XTAP_TAPCELL_ROW_204_2408 VDD VSS gf180mcu_as_sc_mcu7t3v3__tap_2
XTAP_TAPCELL_ROW_54_1_1348 VDD VSS gf180mcu_as_sc_mcu7t3v3__tap_2
XTAP_TAPCELL_ROW_221_2722 VDD VSS gf180mcu_as_sc_mcu7t3v3__tap_2
XTAP_TAPCELL_ROW_221_2711 VDD VSS gf180mcu_as_sc_mcu7t3v3__tap_2
XTAP_TAPCELL_ROW_20_3_2879 VDD VSS gf180mcu_as_sc_mcu7t3v3__tap_2
XFILLER_215_142 VDD VDD VSS VSS gf180mcu_as_sc_mcu7t3v3__fill_1
XFILLER_215_175 VDD VDD VSS VSS gf180mcu_as_sc_mcu7t3v3__fill_2
XFILLER_169_742 VDD VDD VSS VSS gf180mcu_as_sc_mcu7t3v3__fillcap_16
XFILLER_90_45 VDD VDD VSS VSS gf180mcu_as_sc_mcu7t3v3__fillcap_4
XTAP_TAPCELL_ROW_178_1942 VDD VSS gf180mcu_as_sc_mcu7t3v3__tap_2
XFILLER_141_1226 VDD VDD VSS VSS gf180mcu_as_sc_mcu7t3v3__fillcap_8
XFILLER_196_561 VDD VDD VSS VSS gf180mcu_as_sc_mcu7t3v3__fillcap_8
XFILLER_54_1245 VDD VDD VSS VSS gf180mcu_as_sc_mcu7t3v3__fillcap_16
XTAP_TAPCELL_ROW_178_1953 VDD VSS gf180mcu_as_sc_mcu7t3v3__tap_2
XFILLER_8_925 VDD VDD VSS VSS gf180mcu_as_sc_mcu7t3v3__fillcap_16
XFILLER_8_947 VDD VDD VSS VSS gf180mcu_as_sc_mcu7t3v3__fillcap_16
XTAP_TAPCELL_ROW_219_2684 VDD VSS gf180mcu_as_sc_mcu7t3v3__tap_2
XFILLER_139_50 VDD VDD VSS VSS gf180mcu_as_sc_mcu7t3v3__fill_1
XFILLER_137_661 VDD VDD VSS VSS gf180mcu_as_sc_mcu7t3v3__fill_1
XFILLER_171_417 VDD VDD VSS VSS gf180mcu_as_sc_mcu7t3v3__fill_2
XFILLER_99_43 VDD VDD VSS VSS gf180mcu_as_sc_mcu7t3v3__fillcap_8
XFILLER_152_631 VDD VDD VSS VSS gf180mcu_as_sc_mcu7t3v3__fillcap_4
XFILLER_174_1013 VDD VDD VSS VSS gf180mcu_as_sc_mcu7t3v3__fill_2
XFILLER_180_984 VDD VDD VSS VSS gf180mcu_as_sc_mcu7t3v3__fillcap_16
XFILLER_151_174 VDD VDD VSS VSS gf180mcu_as_sc_mcu7t3v3__fillcap_16
XPHY_EDGE_ROW_219_Right_87 VDD VSS gf180mcu_as_sc_mcu7t3v3__tap_2
XPHY_EDGE_ROW_63_1_Right_635 VDD VSS gf180mcu_as_sc_mcu7t3v3__tap_2
XFILLER_120_594 VDD VDD VSS VSS gf180mcu_as_sc_mcu7t3v3__fillcap_16
XFILLER_207_632 VDD VDD VSS VSS gf180mcu_as_sc_mcu7t3v3__fillcap_8
XFILLER_219_492 VDD VDD VSS VSS gf180mcu_as_sc_mcu7t3v3__fillcap_4
XFILLER_0_76 VDD VDD VSS VSS gf180mcu_as_sc_mcu7t3v3__fill_1
XTAP_TAPCELL_ROW_1_1024 VDD VSS gf180mcu_as_sc_mcu7t3v3__tap_2
XFILLER_179_506 VDD VDD VSS VSS gf180mcu_as_sc_mcu7t3v3__fill_1
XFILLER_185_1186 VDD VDD VSS VSS gf180mcu_as_sc_mcu7t3v3__fillcap_4
XPHY_EDGE_ROW_46_2_Right_883 VDD VSS gf180mcu_as_sc_mcu7t3v3__tap_2
X_4800_ VDD VDD VSS VSS _4876_/B _5807_/A _4801_/C gf180mcu_as_sc_mcu7t3v3__and2_2
XTAP_TAPCELL_ROW_1_1035 VDD VSS gf180mcu_as_sc_mcu7t3v3__tap_2
X_5780_ VDD VDD VSS VSS _5780_/B _5836_/A _6461_/D gf180mcu_as_sc_mcu7t3v3__and2_2
XFILLER_9_52 VDD VDD VSS VSS gf180mcu_as_sc_mcu7t3v3__fillcap_16
X_4731_ VDD VDD VSS VSS _5744_/A _4862_/B _4856_/B _5739_/A _4732_/D gf180mcu_as_sc_mcu7t3v3__ao22_2
XPHY_EDGE_ROW_228_Right_96 VDD VSS gf180mcu_as_sc_mcu7t3v3__tap_2
X_4662_ VDD VDD VSS VSS _5682_/B _4784_/B _4774_/C _5683_/A _4665_/C gf180mcu_as_sc_mcu7t3v3__ao22_2
XFILLER_190_704 VDD VDD VSS VSS gf180mcu_as_sc_mcu7t3v3__fill_1
X_6401_ VDD VDD VSS VSS clkload3/A _6401_/D _6401_/Q gf180mcu_as_sc_mcu7t3v3__dfxtp_2
X_3613_ VDD VDD VSS VSS _3655_/B _3655_/C _3614_/C _3654_/B _3614_/D gf180mcu_as_sc_mcu7t3v3__aoi31_2
XFILLER_190_737 VDD VDD VSS VSS gf180mcu_as_sc_mcu7t3v3__fillcap_4
X_4593_ VDD VDD VSS VSS _4602_/A _4598_/B _4593_/C _6334_/D gf180mcu_as_sc_mcu7t3v3__nor3_2
X_6332_ VDD VDD VSS VSS _6531_/CLK _6332_/D _6332_/Q gf180mcu_as_sc_mcu7t3v3__dfxtp_2
X_3544_ VDD VDD VSS VSS _3639_/A _5293_/A _4615_/C _4973_/B _4615_/D gf180mcu_as_sc_mcu7t3v3__aoi211_2
XFILLER_143_664 VDD VDD VSS VSS gf180mcu_as_sc_mcu7t3v3__fill_2
XFILLER_192_1135 VDD VDD VSS VSS gf180mcu_as_sc_mcu7t3v3__fillcap_16
Xmax_cap688 VDD VDD VSS VSS _4948_/B _4924_/B gf180mcu_as_sc_mcu7t3v3__clkbuff_12
X_6263_ VDD VDD VSS VSS clkload6/A _6263_/D _6263_/Q gf180mcu_as_sc_mcu7t3v3__dfxtp_2
X_3475_ VDD VDD VSS VSS _3617_/D _4635_/B _4986_/A gf180mcu_as_sc_mcu7t3v3__nor2b_2
XFILLER_192_1157 VDD VDD VSS VSS gf180mcu_as_sc_mcu7t3v3__fillcap_16
X_5214_ VDD VDD VSS VSS _5216_/C _5295_/B _5214_/A gf180mcu_as_sc_mcu7t3v3__nand2_2
X_6194_ VDD VDD VSS VSS _6316_/CLK _6194_/D _6194_/Q gf180mcu_as_sc_mcu7t3v3__dfxtp_2
X_5145_ VDD VDD VSS VSS _5267_/S _5145_/B _5145_/A _5146_/B gf180mcu_as_sc_mcu7t3v3__mux2_2
XFILLER_111_594 VDD VDD VSS VSS gf180mcu_as_sc_mcu7t3v3__fill_2
X_5076_ VDD VDD VSS VSS _5077_/D _5124_/B _5186_/B _5741_/B gf180mcu_as_sc_mcu7t3v3__aoi21b_2
X_4027_ VDD VDD VSS VSS _4044_/B _6109_/Q _4028_/C gf180mcu_as_sc_mcu7t3v3__and2_2
XTAP_TAPCELL_ROW_38_1_1340 VDD VSS gf180mcu_as_sc_mcu7t3v3__tap_2
XFILLER_212_101 VDD VDD VSS VSS gf180mcu_as_sc_mcu7t3v3__fillcap_4
XFILLER_44_49 VDD VDD VSS VSS gf180mcu_as_sc_mcu7t3v3__fill_2
XFILLER_13_718 VDD VDD VSS VSS gf180mcu_as_sc_mcu7t3v3__fillcap_16
XFILLER_201_819 VDD VDD VSS VSS gf180mcu_as_sc_mcu7t3v3__fillcap_4
X_5978_ VDD VDD VSS VSS _5978_/A _6526_/Q _6262_/Q _5978_/D _5979_/B gf180mcu_as_sc_mcu7t3v3__nand4_2
XTAP_TAPCELL_ROW_195_2253 VDD VSS gf180mcu_as_sc_mcu7t3v3__tap_2
XFILLER_205_1234 VDD VDD VSS VSS gf180mcu_as_sc_mcu7t3v3__fill_1
XPHY_EDGE_ROW_35_3_Left_740 VDD VSS gf180mcu_as_sc_mcu7t3v3__tap_2
X_4929_ VDD VDD VSS VSS _5924_/A _4955_/B _4955_/C _5923_/A _4935_/B gf180mcu_as_sc_mcu7t3v3__ao22_2
XFILLER_166_734 VDD VDD VSS VSS gf180mcu_as_sc_mcu7t3v3__fill_1
XFILLER_60_37 VDD VDD VSS VSS gf180mcu_as_sc_mcu7t3v3__fillcap_8
XPHY_EDGE_ROW_58_3_Right_138 VDD VSS gf180mcu_as_sc_mcu7t3v3__tap_2
Xsram2048.u_bank0_1027 VDD VDD VSS VSS sram2048.u_bank0/WEN[1] gf180mcu_as_sc_mcu7t3v3__tiel_4
XFILLER_176_37 VDD VDD VSS VSS gf180mcu_as_sc_mcu7t3v3__fillcap_16
XTAP_TAPCELL_ROW_156_1547 VDD VSS gf180mcu_as_sc_mcu7t3v3__tap_2
XTAP_TAPCELL_ROW_156_1558 VDD VSS gf180mcu_as_sc_mcu7t3v3__tap_2
XFILLER_101_1210 VDD VDD VSS VSS gf180mcu_as_sc_mcu7t3v3__fill_2
XFILLER_165_277 VDD VDD VSS VSS gf180mcu_as_sc_mcu7t3v3__fill_2
XFILLER_197_1046 VDD VDD VSS VSS gf180mcu_as_sc_mcu7t3v3__fillcap_4
XFILLER_197_1068 VDD VDD VSS VSS gf180mcu_as_sc_mcu7t3v3__fillcap_16
XFILLER_5_928 VDD VDD VSS VSS gf180mcu_as_sc_mcu7t3v3__fillcap_16
XTAP_TAPCELL_ROW_173_1850 VDD VSS gf180mcu_as_sc_mcu7t3v3__tap_2
XTAP_TAPCELL_ROW_173_1861 VDD VSS gf180mcu_as_sc_mcu7t3v3__tap_2
XFILLER_180_247 VDD VDD VSS VSS gf180mcu_as_sc_mcu7t3v3__fillcap_8
XTAP_TAPCELL_ROW_214_2592 VDD VSS gf180mcu_as_sc_mcu7t3v3__tap_2
XFILLER_161_450 VDD VDD VSS VSS gf180mcu_as_sc_mcu7t3v3__fill_1
XFILLER_171_1208 VDD VDD VSS VSS gf180mcu_as_sc_mcu7t3v3__fillcap_16
XFILLER_192_69 VDD VDD VSS VSS gf180mcu_as_sc_mcu7t3v3__fillcap_16
XFILLER_212_1205 VDD VDD VSS VSS gf180mcu_as_sc_mcu7t3v3__fillcap_16
XFILLER_212_1227 VDD VDD VSS VSS gf180mcu_as_sc_mcu7t3v3__fillcap_16
XTAP_TAPCELL_ROW_15_1278 VDD VSS gf180mcu_as_sc_mcu7t3v3__tap_2
XTAP_TAPCELL_ROW_15_1289 VDD VSS gf180mcu_as_sc_mcu7t3v3__tap_2
XFILLER_188_314 VDD VDD VSS VSS gf180mcu_as_sc_mcu7t3v3__fill_1
XFILLER_12_751 VDD VDD VSS VSS gf180mcu_as_sc_mcu7t3v3__fill_2
XFILLER_12_784 VDD VDD VSS VSS gf180mcu_as_sc_mcu7t3v3__fillcap_16
XPHY_EDGE_ROW_26_2_Left_467 VDD VSS gf180mcu_as_sc_mcu7t3v3__tap_2
XFILLER_172_715 VDD VDD VSS VSS gf180mcu_as_sc_mcu7t3v3__fill_2
XFILLER_184_586 VDD VDD VSS VSS gf180mcu_as_sc_mcu7t3v3__fillcap_8
XFILLER_184_597 VDD VDD VSS VSS gf180mcu_as_sc_mcu7t3v3__fillcap_16
XFILLER_125_620 VDD VDD VSS VSS gf180mcu_as_sc_mcu7t3v3__fillcap_16
XFILLER_172_748 VDD VDD VSS VSS gf180mcu_as_sc_mcu7t3v3__fill_2
XFILLER_176_1119 VDD VDD VSS VSS gf180mcu_as_sc_mcu7t3v3__fillcap_16
XFILLER_7_276 VDD VDD VSS VSS gf180mcu_as_sc_mcu7t3v3__fillcap_4
XFILLER_7_298 VDD VDD VSS VSS gf180mcu_as_sc_mcu7t3v3__fillcap_16
XFILLER_125_664 VDD VDD VSS VSS gf180mcu_as_sc_mcu7t3v3__fill_2
XFILLER_152_461 VDD VDD VSS VSS gf180mcu_as_sc_mcu7t3v3__fill_1
XFILLER_217_1116 VDD VDD VSS VSS gf180mcu_as_sc_mcu7t3v3__fillcap_4
XFILLER_217_1138 VDD VDD VSS VSS gf180mcu_as_sc_mcu7t3v3__fillcap_16
XFILLER_140_645 VDD VDD VSS VSS gf180mcu_as_sc_mcu7t3v3__fillcap_16
X_3260_ VDD VDD VSS VSS _3326_/S _4462_/B _3281_/D _3281_/B gf180mcu_as_sc_mcu7t3v3__nor3_2
XFILLER_39_604 VDD VDD VSS VSS gf180mcu_as_sc_mcu7t3v3__fill_1
XFILLER_6_1205 VDD VDD VSS VSS gf180mcu_as_sc_mcu7t3v3__fillcap_16
XFILLER_6_1227 VDD VDD VSS VSS gf180mcu_as_sc_mcu7t3v3__fillcap_16
XTAP_TAPCELL_ROW_115_2_3021 VDD VSS gf180mcu_as_sc_mcu7t3v3__tap_2
X_3191_ VDD VDD VSS VSS _3288_/C _4072_/A gf180mcu_as_sc_mcu7t3v3__inv_2
XFILLER_39_659 VDD VDD VSS VSS gf180mcu_as_sc_mcu7t3v3__fill_2
XPHY_EDGE_ROW_140_2_Left_581 VDD VSS gf180mcu_as_sc_mcu7t3v3__tap_2
XFILLER_227_749 VDD VDD VSS VSS gf180mcu_as_sc_mcu7t3v3__fillcap_4
XPHY_EDGE_ROW_64_1_Right_636 VDD VSS gf180mcu_as_sc_mcu7t3v3__tap_2
XFILLER_208_963 VDD VDD VSS VSS gf180mcu_as_sc_mcu7t3v3__fillcap_16
XFILLER_228_1201 VDD VDD VSS VSS gf180mcu_as_sc_mcu7t3v3__fillcap_4
X_5901_ VDD VDD VSS VSS _5948_/S _5901_/B _5901_/A _5902_/B gf180mcu_as_sc_mcu7t3v3__mux2_2
XFILLER_228_1223 VDD VDD VSS VSS gf180mcu_as_sc_mcu7t3v3__fill_1
Xclkbuf_leaf_20_clk_regs VDD VDD VSS VSS clkbuf_3_4_0_clk_regs/Y _6518_/CLK gf180mcu_as_sc_mcu7t3v3__clkbuff_12
XFILLER_179_347 VDD VDD VSS VSS gf180mcu_as_sc_mcu7t3v3__fill_2
XFILLER_201_65 VDD VDD VSS VSS gf180mcu_as_sc_mcu7t3v3__fillcap_4
XPHY_EDGE_ROW_47_2_Right_884 VDD VSS gf180mcu_as_sc_mcu7t3v3__tap_2
X_5832_ VDD VDD VSS VSS _5832_/A _5864_/B _5832_/C _5832_/D _5834_/C gf180mcu_as_sc_mcu7t3v3__ao211_2
XFILLER_124_1210 VDD VDD VSS VSS gf180mcu_as_sc_mcu7t3v3__fillcap_16
XFILLER_179_369 VDD VDD VSS VSS gf180mcu_as_sc_mcu7t3v3__fill_2
XFILLER_188_870 VDD VDD VSS VSS gf180mcu_as_sc_mcu7t3v3__fillcap_4
X_5763_ VDD VDD VSS VSS _6459_/D _5763_/C _5844_/B _5763_/A gf180mcu_as_sc_mcu7t3v3__aoi21b_2
XFILLER_194_317 VDD VDD VSS VSS gf180mcu_as_sc_mcu7t3v3__fillcap_4
X_4714_ VDD VDD VSS VSS _5727_/A _4871_/B _4871_/C _5723_/A _4715_/D gf180mcu_as_sc_mcu7t3v3__ao22_2
X_5694_ VDD VDD VSS VSS _5694_/A _5802_/B _5694_/C _5694_/D _5695_/B gf180mcu_as_sc_mcu7t3v3__ao211_2
X_4645_ VDD VDD VSS VSS _4994_/A _4878_/B _4645_/C _4880_/B _4646_/D gf180mcu_as_sc_mcu7t3v3__ao211_2
XTAP_TAPCELL_ROW_190_2161 VDD VSS gf180mcu_as_sc_mcu7t3v3__tap_2
XFILLER_162_225 VDD VDD VSS VSS gf180mcu_as_sc_mcu7t3v3__fillcap_16
XFILLER_162_247 VDD VDD VSS VSS gf180mcu_as_sc_mcu7t3v3__fillcap_16
XFILLER_190_534 VDD VDD VSS VSS gf180mcu_as_sc_mcu7t3v3__fillcap_16
X_4576_ VDD VDD VSS VSS _4603_/A _6310_/Q _6311_/D gf180mcu_as_sc_mcu7t3v3__and2_2
XFILLER_116_653 VDD VDD VSS VSS gf180mcu_as_sc_mcu7t3v3__fillcap_8
XFILLER_157_1030 VDD VDD VSS VSS gf180mcu_as_sc_mcu7t3v3__fillcap_16
XTAP_TAPCELL_ROW_151_1455 VDD VSS gf180mcu_as_sc_mcu7t3v3__tap_2
X_6315_ VDD VDD VSS VSS _6531_/CLK _6315_/D _6315_/Q gf180mcu_as_sc_mcu7t3v3__dfxtp_2
X_3527_ VDD VDD VSS VSS _3631_/D _5929_/A _5335_/A _3532_/C _5335_/B gf180mcu_as_sc_mcu7t3v3__oai211_2
XFILLER_157_1052 VDD VDD VSS VSS gf180mcu_as_sc_mcu7t3v3__fillcap_16
XFILLER_1_419 VDD VDD VSS VSS gf180mcu_as_sc_mcu7t3v3__fill_1
XTAP_TAPCELL_ROW_151_1466 VDD VSS gf180mcu_as_sc_mcu7t3v3__tap_2
XFILLER_131_645 VDD VDD VSS VSS gf180mcu_as_sc_mcu7t3v3__fill_2
XFILLER_39_27 VDD VDD VSS VSS gf180mcu_as_sc_mcu7t3v3__fillcap_16
X_6246_ VDD VDD VSS VSS _6531_/CLK _6246_/D _6246_/Q gf180mcu_as_sc_mcu7t3v3__dfxtp_2
X_3458_ VDD VDD VSS VSS _4585_/A _3458_/B _6323_/Q _6322_/D gf180mcu_as_sc_mcu7t3v3__mux2_2
X_6177_ VDD VDD VSS VSS _6376_/CLK _6177_/D _6177_/Q gf180mcu_as_sc_mcu7t3v3__dfxtp_2
X_3389_ VDD VDD VSS VSS _3389_/B _3389_/A _4106_/D gf180mcu_as_sc_mcu7t3v3__xnor2_2
XFILLER_131_1214 VDD VDD VSS VSS gf180mcu_as_sc_mcu7t3v3__fill_1
X_5128_ VDD VDD VSS VSS _5128_/B _5229_/A _6390_/D gf180mcu_as_sc_mcu7t3v3__and2_2
XFILLER_55_37 VDD VDD VSS VSS gf180mcu_as_sc_mcu7t3v3__fillcap_4
X_5059_ VDD VDD VSS VSS _5059_/D _5297_/A _5059_/B _5059_/C _5060_/A gf180mcu_as_sc_mcu7t3v3__ao31_2
XFILLER_169_6 VDD VDD VSS VSS gf180mcu_as_sc_mcu7t3v3__fillcap_16
XFILLER_214_944 VDD VDD VSS VSS gf180mcu_as_sc_mcu7t3v3__fill_1
XTAP_TAPCELL_ROW_10_1186 VDD VSS gf180mcu_as_sc_mcu7t3v3__tap_2
XFILLER_111_43 VDD VDD VSS VSS gf180mcu_as_sc_mcu7t3v3__fillcap_8
XFILLER_13_526 VDD VDD VSS VSS gf180mcu_as_sc_mcu7t3v3__fill_1
XFILLER_164_1012 VDD VDD VSS VSS gf180mcu_as_sc_mcu7t3v3__fill_2
XTAP_TAPCELL_ROW_10_1197 VDD VSS gf180mcu_as_sc_mcu7t3v3__tap_2
XFILLER_198_667 VDD VDD VSS VSS gf180mcu_as_sc_mcu7t3v3__fillcap_8
XFILLER_213_487 VDD VDD VSS VSS gf180mcu_as_sc_mcu7t3v3__fill_2
XFILLER_187_69 VDD VDD VSS VSS gf180mcu_as_sc_mcu7t3v3__fill_1
XTAP_TAPCELL_ROW_216_2632 VDD VSS gf180mcu_as_sc_mcu7t3v3__tap_2
XTAP_TAPCELL_ROW_216_2621 VDD VSS gf180mcu_as_sc_mcu7t3v3__tap_2
XFILLER_194_884 VDD VDD VSS VSS gf180mcu_as_sc_mcu7t3v3__fill_2
XPHY_EDGE_ROW_59_3_Right_139 VDD VSS gf180mcu_as_sc_mcu7t3v3__tap_2
XFILLER_14_1081 VDD VDD VSS VSS gf180mcu_as_sc_mcu7t3v3__fillcap_4
XFILLER_154_737 VDD VDD VSS VSS gf180mcu_as_sc_mcu7t3v3__fillcap_16
XFILLER_166_597 VDD VDD VSS VSS gf180mcu_as_sc_mcu7t3v3__fillcap_8
XPHY_EDGE_ROW_136_1_Left_364 VDD VSS gf180mcu_as_sc_mcu7t3v3__tap_2
XFILLER_107_664 VDD VDD VSS VSS gf180mcu_as_sc_mcu7t3v3__fill_2
XFILLER_122_645 VDD VDD VSS VSS gf180mcu_as_sc_mcu7t3v3__fill_1
XPHY_EDGE_ROW_73_1_Left_301 VDD VSS gf180mcu_as_sc_mcu7t3v3__tap_2
Xinput320 VDD VDD VSS VSS west_in[25] _5880_/A gf180mcu_as_sc_mcu7t3v3__buff_12
XFILLER_208_204 VDD VDD VSS VSS gf180mcu_as_sc_mcu7t3v3__fill_1
XFILLER_209_727 VDD VDD VSS VSS gf180mcu_as_sc_mcu7t3v3__fillcap_4
Xinput331 VDD VDD VSS VSS west_in[35] _4968_/A gf180mcu_as_sc_mcu7t3v3__buff_12
XFILLER_208_237 VDD VDD VSS VSS gf180mcu_as_sc_mcu7t3v3__fill_1
XFILLER_36_629 VDD VDD VSS VSS gf180mcu_as_sc_mcu7t3v3__fillcap_8
XFILLER_147_1210 VDD VDD VSS VSS gf180mcu_as_sc_mcu7t3v3__fillcap_16
XFILLER_16_320 VDD VDD VSS VSS gf180mcu_as_sc_mcu7t3v3__fillcap_16
XFILLER_189_612 VDD VDD VSS VSS gf180mcu_as_sc_mcu7t3v3__fill_1
XFILLER_204_410 VDD VDD VSS VSS gf180mcu_as_sc_mcu7t3v3__fill_2
XFILLER_205_944 VDD VDD VSS VSS gf180mcu_as_sc_mcu7t3v3__fillcap_16
XFILLER_44_651 VDD VDD VSS VSS gf180mcu_as_sc_mcu7t3v3__fillcap_4
XFILLER_16_364 VDD VDD VSS VSS gf180mcu_as_sc_mcu7t3v3__fill_1
XFILLER_204_454 VDD VDD VSS VSS gf180mcu_as_sc_mcu7t3v3__fill_1
XFILLER_176_317 VDD VDD VSS VSS gf180mcu_as_sc_mcu7t3v3__fillcap_8
XFILLER_182_1189 VDD VDD VSS VSS gf180mcu_as_sc_mcu7t3v3__fillcap_16
XFILLER_188_177 VDD VDD VSS VSS gf180mcu_as_sc_mcu7t3v3__fillcap_8
XFILLER_220_947 VDD VDD VSS VSS gf180mcu_as_sc_mcu7t3v3__fillcap_16
XFILLER_12_581 VDD VDD VSS VSS gf180mcu_as_sc_mcu7t3v3__fill_1
XFILLER_157_564 VDD VDD VSS VSS gf180mcu_as_sc_mcu7t3v3__fill_1
XFILLER_172_512 VDD VDD VSS VSS gf180mcu_as_sc_mcu7t3v3__fillcap_8
XFILLER_223_1186 VDD VDD VSS VSS gf180mcu_as_sc_mcu7t3v3__fillcap_4
XFILLER_8_574 VDD VDD VSS VSS gf180mcu_as_sc_mcu7t3v3__fill_1
XPHY_EDGE_ROW_68_1_Left_296 VDD VSS gf180mcu_as_sc_mcu7t3v3__tap_2
XANTENNA_2 VDD VDD VSS VSS _6355_/D gf180mcu_as_sc_mcu7t3v3__diode_2
XFILLER_184_394 VDD VDD VSS VSS gf180mcu_as_sc_mcu7t3v3__fillcap_16
X_4430_ VDD VDD VSS VSS _6246_/Q _4446_/D _4446_/B _6245_/Q _6245_/D gf180mcu_as_sc_mcu7t3v3__ao22_2
XFILLER_160_718 VDD VDD VSS VSS gf180mcu_as_sc_mcu7t3v3__fill_2
XFILLER_6_53 VDD VDD VSS VSS gf180mcu_as_sc_mcu7t3v3__fillcap_16
XFILLER_153_792 VDD VDD VSS VSS gf180mcu_as_sc_mcu7t3v3__fill_1
X_6100_ VDD VDD VSS VSS _6486_/CLK _6100_/D _6100_/Q gf180mcu_as_sc_mcu7t3v3__dfxtp_2
X_4361_ VDD VDD VSS VSS _4362_/C _4363_/S _6033_/Q gf180mcu_as_sc_mcu7t3v3__nor2b_2
X_4292_ VDD VDD VSS VSS _4362_/A _6110_/Q _4292_/C _4362_/D _4296_/C gf180mcu_as_sc_mcu7t3v3__ao211_2
X_3312_ VDD VDD VSS VSS _3312_/B _3343_/A _3317_/C gf180mcu_as_sc_mcu7t3v3__or2_2
XFILLER_154_1258 VDD VDD VSS VSS gf180mcu_as_sc_mcu7t3v3__fill_2
X_6031_ VDD VDD VSS VSS _6371_/CLK _6031_/D _6031_/Q gf180mcu_as_sc_mcu7t3v3__dfxtp_2
X_3243_ VDD VDD VSS VSS _4072_/A _3243_/B _3243_/A _3245_/B gf180mcu_as_sc_mcu7t3v3__mux2_2
XFILLER_227_524 VDD VDD VSS VSS gf180mcu_as_sc_mcu7t3v3__fill_2
X_3174_ VDD VDD VSS VSS _6532_/Q _6324_/Q _3174_/B _4525_/A _3176_/C gf180mcu_as_sc_mcu7t3v3__ao31_2
XPHY_EDGE_ROW_65_1_Right_637 VDD VSS gf180mcu_as_sc_mcu7t3v3__tap_2
XFILLER_212_53 VDD VDD VSS VSS gf180mcu_as_sc_mcu7t3v3__fillcap_16
XFILLER_207_292 VDD VDD VSS VSS gf180mcu_as_sc_mcu7t3v3__fill_1
XFILLER_168_807 VDD VDD VSS VSS gf180mcu_as_sc_mcu7t3v3__fill_1
XFILLER_195_604 VDD VDD VSS VSS gf180mcu_as_sc_mcu7t3v3__fillcap_8
XFILLER_228_1097 VDD VDD VSS VSS gf180mcu_as_sc_mcu7t3v3__fillcap_4
X_5815_ VDD VDD VSS VSS _5815_/A _5871_/B _5815_/C _5871_/D _5816_/D gf180mcu_as_sc_mcu7t3v3__ao22_2
XPHY_EDGE_ROW_48_2_Right_885 VDD VSS gf180mcu_as_sc_mcu7t3v3__tap_2
XTAP_TAPCELL_ROW_192_2201 VDD VSS gf180mcu_as_sc_mcu7t3v3__tap_2
XFILLER_210_457 VDD VDD VSS VSS gf180mcu_as_sc_mcu7t3v3__fillcap_8
X_5746_ VDD VDD VSS VSS _5795_/S _5746_/B _5746_/A _5747_/B gf180mcu_as_sc_mcu7t3v3__mux2_2
X_5677_ VDD VDD VSS VSS _5677_/A _5873_/B _5677_/C _5677_/D _5678_/D gf180mcu_as_sc_mcu7t3v3__ao211_2
XFILLER_163_534 VDD VDD VSS VSS gf180mcu_as_sc_mcu7t3v3__fill_1
XFILLER_163_545 VDD VDD VSS VSS gf180mcu_as_sc_mcu7t3v3__fillcap_8
XFILLER_175_383 VDD VDD VSS VSS gf180mcu_as_sc_mcu7t3v3__fill_1
X_4628_ VDD VDD VSS VSS _4628_/Y _4971_/C _4628_/B _4628_/A gf180mcu_as_sc_mcu7t3v3__aoi21_2
XFILLER_190_331 VDD VDD VSS VSS gf180mcu_as_sc_mcu7t3v3__fillcap_8
XFILLER_194_1049 VDD VDD VSS VSS gf180mcu_as_sc_mcu7t3v3__fillcap_16
XFILLER_104_612 VDD VDD VSS VSS gf180mcu_as_sc_mcu7t3v3__fill_1
XFILLER_151_729 VDD VDD VSS VSS gf180mcu_as_sc_mcu7t3v3__fillcap_16
XFILLER_163_589 VDD VDD VSS VSS gf180mcu_as_sc_mcu7t3v3__fillcap_16
XFILLER_191_898 VDD VDD VSS VSS gf180mcu_as_sc_mcu7t3v3__fill_2
XFILLER_2_717 VDD VDD VSS VSS gf180mcu_as_sc_mcu7t3v3__fill_1
XFILLER_2_728 VDD VDD VSS VSS gf180mcu_as_sc_mcu7t3v3__fillcap_4
X_4559_ VDD VDD VSS VSS _4601_/C _4579_/C _4559_/B _4569_/C gf180mcu_as_sc_mcu7t3v3__aoi21_2
XTAP_TAPCELL_ROW_211_2540 VDD VSS gf180mcu_as_sc_mcu7t3v3__tap_2
XFILLER_173_38 VDD VDD VSS VSS gf180mcu_as_sc_mcu7t3v3__fillcap_16
XTAP_TAPCELL_ROW_91_2_2985 VDD VSS gf180mcu_as_sc_mcu7t3v3__tap_2
X_6229_ VDD VDD VSS VSS _6316_/CLK _6229_/D _6229_/Q gf180mcu_as_sc_mcu7t3v3__dfxtp_2
XTAP_TAPCELL_ROW_168_1760 VDD VSS gf180mcu_as_sc_mcu7t3v3__tap_2
XTAP_TAPCELL_ROW_168_1771 VDD VSS gf180mcu_as_sc_mcu7t3v3__tap_2
XFILLER_218_524 VDD VDD VSS VSS gf180mcu_as_sc_mcu7t3v3__fill_1
XTAP_TAPCELL_ROW_12_1226 VDD VSS gf180mcu_as_sc_mcu7t3v3__tap_2
XTAP_TAPCELL_ROW_12_1237 VDD VSS gf180mcu_as_sc_mcu7t3v3__tap_2
Xhold1230 VDD VDD VSS VSS _6545_/Q hold1230/Y gf180mcu_as_sc_mcu7t3v3__clkbuff_4
XFILLER_18_629 VDD VDD VSS VSS gf180mcu_as_sc_mcu7t3v3__fillcap_16
XFILLER_214_752 VDD VDD VSS VSS gf180mcu_as_sc_mcu7t3v3__fill_1
XTAP_TAPCELL_ROW_181_1993 VDD VSS gf180mcu_as_sc_mcu7t3v3__tap_2
XFILLER_199_976 VDD VDD VSS VSS gf180mcu_as_sc_mcu7t3v3__fillcap_4
XFILLER_158_317 VDD VDD VSS VSS gf180mcu_as_sc_mcu7t3v3__fillcap_16
XFILLER_159_829 VDD VDD VSS VSS gf180mcu_as_sc_mcu7t3v3__fillcap_8
XFILLER_199_998 VDD VDD VSS VSS gf180mcu_as_sc_mcu7t3v3__fillcap_16
XFILLER_202_947 VDD VDD VSS VSS gf180mcu_as_sc_mcu7t3v3__fillcap_16
XFILLER_213_284 VDD VDD VSS VSS gf180mcu_as_sc_mcu7t3v3__fill_1
XFILLER_16_1121 VDD VDD VSS VSS gf180mcu_as_sc_mcu7t3v3__fill_1
XFILLER_147_50 VDD VDD VSS VSS gf180mcu_as_sc_mcu7t3v3__fill_1
XFILLER_154_545 VDD VDD VSS VSS gf180mcu_as_sc_mcu7t3v3__fill_1
XTAP_TAPCELL_ROW_26_3_2888 VDD VSS gf180mcu_as_sc_mcu7t3v3__tap_2
XFILLER_214_1119 VDD VDD VSS VSS gf180mcu_as_sc_mcu7t3v3__fillcap_16
XFILLER_3_1208 VDD VDD VSS VSS gf180mcu_as_sc_mcu7t3v3__fillcap_16
Xinput150 VDD VDD VSS VSS north_in[35] _3573_/A gf180mcu_as_sc_mcu7t3v3__buff_12
Xinput161 VDD VDD VSS VSS nw_in[12] _5777_/A gf180mcu_as_sc_mcu7t3v3__buff_12
Xinput172 VDD VDD VSS VSS nw_in[22] _5857_/A gf180mcu_as_sc_mcu7t3v3__buff_12
Xinput183 VDD VDD VSS VSS nw_in[32] _5939_/A gf180mcu_as_sc_mcu7t3v3__buff_12
Xinput194 VDD VDD VSS VSS rst input194/Y gf180mcu_as_sc_mcu7t3v3__buff_12
XFILLER_224_527 VDD VDD VSS VSS gf180mcu_as_sc_mcu7t3v3__fillcap_4
X_3930_ VDD VDD VSS VSS _3930_/B _5907_/A _3931_/D gf180mcu_as_sc_mcu7t3v3__and2_2
XFILLER_16_172 VDD VDD VSS VSS gf180mcu_as_sc_mcu7t3v3__fillcap_16
XFILLER_32_610 VDD VDD VSS VSS gf180mcu_as_sc_mcu7t3v3__fillcap_16
XFILLER_91_598 VDD VDD VSS VSS gf180mcu_as_sc_mcu7t3v3__fill_1
XPHY_EDGE_ROW_169_Right_37 VDD VSS gf180mcu_as_sc_mcu7t3v3__tap_2
XFILLER_32_665 VDD VDD VSS VSS gf180mcu_as_sc_mcu7t3v3__fill_2
XFILLER_34_1210 VDD VDD VSS VSS gf180mcu_as_sc_mcu7t3v3__fillcap_8
X_3861_ VDD VDD VSS VSS _3889_/B _5848_/A _3862_/D gf180mcu_as_sc_mcu7t3v3__and2_2
XFILLER_13_890 VDD VDD VSS VSS gf180mcu_as_sc_mcu7t3v3__fillcap_16
XFILLER_158_840 VDD VDD VSS VSS gf180mcu_as_sc_mcu7t3v3__fill_1
X_5600_ VDD VDD VSS VSS _5910_/A _5628_/D _5600_/C _5600_/D _5601_/B gf180mcu_as_sc_mcu7t3v3__ao211_2
X_3792_ VDD VDD VSS VSS _6029_/Q _3933_/B _4037_/B _3904_/D _6029_/D gf180mcu_as_sc_mcu7t3v3__ao22_2
XFILLER_158_873 VDD VDD VSS VSS gf180mcu_as_sc_mcu7t3v3__fill_2
XFILLER_75_2 VDD VDD VSS VSS gf180mcu_as_sc_mcu7t3v3__fillcap_8
X_5531_ VDD VDD VSS VSS _5539_/A _5531_/B _5844_/A gf180mcu_as_sc_mcu7t3v3__nand2_2
XTAP_TAPCELL_ROW_103_2_3003 VDD VSS gf180mcu_as_sc_mcu7t3v3__tap_2
X_5462_ VDD VDD VSS VSS _5767_/A _5566_/B _5462_/C _5462_/D _5464_/C gf180mcu_as_sc_mcu7t3v3__ao211_2
XFILLER_99_621 VDD VDD VSS VSS gf180mcu_as_sc_mcu7t3v3__fill_2
X_5393_ VDD VDD VSS VSS _5702_/A _5495_/B _5393_/C _5393_/D _5394_/A gf180mcu_as_sc_mcu7t3v3__ao211_2
X_4413_ VDD VDD VSS VSS _6229_/Q _4428_/B _4583_/D _6228_/Q _6228_/D gf180mcu_as_sc_mcu7t3v3__ao22_2
XFILLER_160_548 VDD VDD VSS VSS gf180mcu_as_sc_mcu7t3v3__fillcap_8
XPHY_EDGE_ROW_178_Right_46 VDD VSS gf180mcu_as_sc_mcu7t3v3__tap_2
X_4344_ VDD VDD VSS VSS _4346_/A _4344_/C _4400_/B _6152_/Q gf180mcu_as_sc_mcu7t3v3__aoi21_2
XFILLER_154_1033 VDD VDD VSS VSS gf180mcu_as_sc_mcu7t3v3__fillcap_16
XFILLER_8_1119 VDD VDD VSS VSS gf180mcu_as_sc_mcu7t3v3__fillcap_16
XFILLER_80_1252 VDD VDD VSS VSS gf180mcu_as_sc_mcu7t3v3__fillcap_8
X_6014_ VDD VDD VSS VSS _6015_/A _6014_/B _6014_/C _6487_/D gf180mcu_as_sc_mcu7t3v3__nor3_2
X_4275_ VDD VDD VSS VSS _4275_/D _4283_/A _4275_/B _4275_/C _6207_/D gf180mcu_as_sc_mcu7t3v3__ao31_2
XTAP_TAPCELL_ROW_185_2071 VDD VSS gf180mcu_as_sc_mcu7t3v3__tap_2
XFILLER_41_1214 VDD VDD VSS VSS gf180mcu_as_sc_mcu7t3v3__fill_1
X_3226_ VDD VDD VSS VSS _3294_/B _3226_/B _3226_/C _3227_/D _3291_/B gf180mcu_as_sc_mcu7t3v3__aoi211_2
XTAP_TAPCELL_ROW_9_1169 VDD VSS gf180mcu_as_sc_mcu7t3v3__tap_2
XFILLER_228_877 VDD VDD VSS VSS gf180mcu_as_sc_mcu7t3v3__fillcap_4
X_3157_ VDD VDD VSS VSS _4214_/A _4223_/A _4214_/B _4217_/A gf180mcu_as_sc_mcu7t3v3__nand3_2
XPHY_EDGE_ROW_103_2_Left_544 VDD VSS gf180mcu_as_sc_mcu7t3v3__tap_2
XPHY_EDGE_ROW_110_3_Right_190 VDD VSS gf180mcu_as_sc_mcu7t3v3__tap_2
XPHY_EDGE_ROW_187_Right_55 VDD VSS gf180mcu_as_sc_mcu7t3v3__tap_2
XPHY_EDGE_ROW_66_1_Right_638 VDD VSS gf180mcu_as_sc_mcu7t3v3__tap_2
X_3088_ VDD VDD VSS VSS _3905_/A _5888_/B gf180mcu_as_sc_mcu7t3v3__inv_2
XFILLER_23_632 VDD VDD VSS VSS gf180mcu_as_sc_mcu7t3v3__fill_1
XFILLER_23_654 VDD VDD VSS VSS gf180mcu_as_sc_mcu7t3v3__fillcap_8
XFILLER_11_838 VDD VDD VSS VSS gf180mcu_as_sc_mcu7t3v3__fill_2
XFILLER_167_136 VDD VDD VSS VSS gf180mcu_as_sc_mcu7t3v3__fillcap_4
XFILLER_196_979 VDD VDD VSS VSS gf180mcu_as_sc_mcu7t3v3__fillcap_16
XPHY_EDGE_ROW_49_2_Right_886 VDD VSS gf180mcu_as_sc_mcu7t3v3__tap_2
XFILLER_167_158 VDD VDD VSS VSS gf180mcu_as_sc_mcu7t3v3__fillcap_16
XFILLER_183_629 VDD VDD VSS VSS gf180mcu_as_sc_mcu7t3v3__fill_1
X_5729_ VDD VDD VSS VSS _5925_/D _5875_/S _5729_/B _5729_/C _5730_/C gf180mcu_as_sc_mcu7t3v3__ao31_2
XFILLER_11_1084 VDD VDD VSS VSS gf180mcu_as_sc_mcu7t3v3__fillcap_16
XFILLER_184_37 VDD VDD VSS VSS gf180mcu_as_sc_mcu7t3v3__fillcap_4
XPHY_EDGE_ROW_196_Right_64 VDD VSS gf180mcu_as_sc_mcu7t3v3__tap_2
Xfanout840 VDD VDD VSS VSS _4639_/Y _4838_/B gf180mcu_as_sc_mcu7t3v3__buff_12
Xfanout851 VDD VDD VSS VSS _4572_/D _4283_/A gf180mcu_as_sc_mcu7t3v3__buff_12
XTAP_TAPCELL_ROW_38_2_2905 VDD VSS gf180mcu_as_sc_mcu7t3v3__tap_2
XFILLER_218_321 VDD VDD VSS VSS gf180mcu_as_sc_mcu7t3v3__fill_1
Xfanout862 VDD VDD VSS VSS _4860_/B _4888_/B gf180mcu_as_sc_mcu7t3v3__buff_12
Xfanout873 VDD VDD VSS VSS _3101_/Y _4571_/C gf180mcu_as_sc_mcu7t3v3__buff_12
Xfanout884 VDD VDD VSS VSS _3304_/Y _4072_/B gf180mcu_as_sc_mcu7t3v3__buff_12
Xfanout895 VDD VDD VSS VSS _6551_/Q _3326_/S gf180mcu_as_sc_mcu7t3v3__buff_12
XFILLER_206_527 VDD VDD VSS VSS gf180mcu_as_sc_mcu7t3v3__fill_2
XPHY_EDGE_ROW_35_2_Left_476 VDD VSS gf180mcu_as_sc_mcu7t3v3__tap_2
XTAP_TAPCELL_ROW_224_2775 VDD VSS gf180mcu_as_sc_mcu7t3v3__tap_2
XFILLER_2_1263 VDD VDD VSS VSS gf180mcu_as_sc_mcu7t3v3__fill_2
XFILLER_57_1210 VDD VDD VSS VSS gf180mcu_as_sc_mcu7t3v3__fill_2
XFILLER_199_762 VDD VDD VSS VSS gf180mcu_as_sc_mcu7t3v3__fillcap_8
XFILLER_13_120 VDD VDD VSS VSS gf180mcu_as_sc_mcu7t3v3__fillcap_16
XFILLER_13_142 VDD VDD VSS VSS gf180mcu_as_sc_mcu7t3v3__fillcap_16
XFILLER_14_654 VDD VDD VSS VSS gf180mcu_as_sc_mcu7t3v3__fill_1
XFILLER_183_1262 VDD VDD VSS VSS gf180mcu_as_sc_mcu7t3v3__fill_2
XFILLER_199_784 VDD VDD VSS VSS gf180mcu_as_sc_mcu7t3v3__fill_2
XFILLER_14_687 VDD VDD VSS VSS gf180mcu_as_sc_mcu7t3v3__fillcap_4
XFILLER_186_489 VDD VDD VSS VSS gf180mcu_as_sc_mcu7t3v3__fillcap_16
XFILLER_9_146 VDD VDD VSS VSS gf180mcu_as_sc_mcu7t3v3__fill_2
XFILLER_10_871 VDD VDD VSS VSS gf180mcu_as_sc_mcu7t3v3__fillcap_4
XPHY_EDGE_ROW_28_1_Right_600 VDD VSS gf180mcu_as_sc_mcu7t3v3__tap_2
XFILLER_10_893 VDD VDD VSS VSS gf180mcu_as_sc_mcu7t3v3__fillcap_16
XFILLER_220_1189 VDD VDD VSS VSS gf180mcu_as_sc_mcu7t3v3__fillcap_16
XFILLER_177_1044 VDD VDD VSS VSS gf180mcu_as_sc_mcu7t3v3__fillcap_4
XFILLER_5_352 VDD VDD VSS VSS gf180mcu_as_sc_mcu7t3v3__fillcap_4
XFILLER_3_43 VDD VDD VSS VSS gf180mcu_as_sc_mcu7t3v3__fillcap_16
XPHY_EDGE_ROW_200_Right_68 VDD VSS gf180mcu_as_sc_mcu7t3v3__tap_2
XFILLER_3_76 VDD VDD VSS VSS gf180mcu_as_sc_mcu7t3v3__fill_1
X_4060_ VDD VDD VSS VSS _4060_/B _6131_/Q _4061_/D gf180mcu_as_sc_mcu7t3v3__and2_2
X_3011_ VDD VDD VSS VSS _3011_/Y _5340_/A gf180mcu_as_sc_mcu7t3v3__inv_2
XFILLER_188_1151 VDD VDD VSS VSS gf180mcu_as_sc_mcu7t3v3__fillcap_4
XFILLER_149_1124 VDD VDD VSS VSS gf180mcu_as_sc_mcu7t3v3__fillcap_16
XFILLER_188_1173 VDD VDD VSS VSS gf180mcu_as_sc_mcu7t3v3__fillcap_16
X_4962_ VDD VDD VSS VSS _5953_/A _4962_/B _4962_/C _5953_/D _4963_/D gf180mcu_as_sc_mcu7t3v3__ao22_2
XTAP_TAPCELL_ROW_4_1088 VDD VSS gf180mcu_as_sc_mcu7t3v3__tap_2
XTAP_TAPCELL_ROW_4_1077 VDD VSS gf180mcu_as_sc_mcu7t3v3__tap_2
X_4893_ VDD VDD VSS VSS _5925_/D _4965_/S _4893_/B _4893_/C _4894_/C gf180mcu_as_sc_mcu7t3v3__ao31_2
X_3913_ VDD VDD VSS VSS _3913_/B _4053_/A _4058_/B gf180mcu_as_sc_mcu7t3v3__and2_2
XFILLER_177_434 VDD VDD VSS VSS gf180mcu_as_sc_mcu7t3v3__fill_1
XFILLER_177_445 VDD VDD VSS VSS gf180mcu_as_sc_mcu7t3v3__fill_2
X_3844_ VDD VDD VSS VSS _3928_/B _5832_/A _3845_/D gf180mcu_as_sc_mcu7t3v3__and2_2
XFILLER_160_1081 VDD VDD VSS VSS gf180mcu_as_sc_mcu7t3v3__fillcap_4
XFILLER_164_139 VDD VDD VSS VSS gf180mcu_as_sc_mcu7t3v3__fillcap_16
XFILLER_177_489 VDD VDD VSS VSS gf180mcu_as_sc_mcu7t3v3__fill_1
X_3775_ VDD VDD VSS VSS _3888_/B _5773_/A _3776_/D gf180mcu_as_sc_mcu7t3v3__and2_2
XFILLER_195_1100 VDD VDD VSS VSS gf180mcu_as_sc_mcu7t3v3__fillcap_16
XFILLER_195_1122 VDD VDD VSS VSS gf180mcu_as_sc_mcu7t3v3__fillcap_16
X_6494_ VDD VDD VSS VSS _6519_/CLK _6494_/D _6494_/Q gf180mcu_as_sc_mcu7t3v3__dfxtp_2
X_5514_ VDD VDD VSS VSS _5563_/C _5822_/B _5517_/C gf180mcu_as_sc_mcu7t3v3__and2_2
Xoutput410 VDD VDD VSS VSS _6375_/Q north_out[34] gf180mcu_as_sc_mcu7t3v3__buff_12
X_5445_ VDD VDD VSS VSS _5752_/A _5495_/B _5445_/C _5496_/B _5446_/B gf180mcu_as_sc_mcu7t3v3__ao211_2
XTAP_TAPCELL_ROW_187_2100 VDD VSS gf180mcu_as_sc_mcu7t3v3__tap_2
XFILLER_160_345 VDD VDD VSS VSS gf180mcu_as_sc_mcu7t3v3__fill_2
XFILLER_218_85 VDD VDD VSS VSS gf180mcu_as_sc_mcu7t3v3__fillcap_8
Xoutput443 VDD VDD VSS VSS _6408_/Q south_out[31] gf180mcu_as_sc_mcu7t3v3__buff_12
Xoutput432 VDD VDD VSS VSS _6398_/Q south_out[21] gf180mcu_as_sc_mcu7t3v3__buff_12
Xoutput421 VDD VDD VSS VSS _6388_/Q south_out[11] gf180mcu_as_sc_mcu7t3v3__buff_12
XTAP_TAPCELL_ROW_187_2111 VDD VSS gf180mcu_as_sc_mcu7t3v3__tap_2
XFILLER_160_378 VDD VDD VSS VSS gf180mcu_as_sc_mcu7t3v3__fillcap_4
XFILLER_87_613 VDD VDD VSS VSS gf180mcu_as_sc_mcu7t3v3__fill_1
Xoutput487 VDD VDD VSS VSS _6455_/Q west_out[6] gf180mcu_as_sc_mcu7t3v3__buff_12
Xoutput476 VDD VDD VSS VSS _6478_/Q west_out[29] gf180mcu_as_sc_mcu7t3v3__buff_12
Xoutput465 VDD VDD VSS VSS _6468_/Q west_out[19] gf180mcu_as_sc_mcu7t3v3__buff_12
Xoutput454 VDD VDD VSS VSS _6386_/Q south_out[9] gf180mcu_as_sc_mcu7t3v3__buff_12
X_5376_ VDD VDD VSS VSS _5681_/A _5484_/B _5492_/B _5684_/A _5377_/D gf180mcu_as_sc_mcu7t3v3__ao22_2
X_4327_ VDD VDD VSS VSS _4370_/S _6115_/Q _4327_/C _4369_/D _4331_/C gf180mcu_as_sc_mcu7t3v3__ao211_2
X_4258_ VDD VDD VSS VSS _6205_/Q _4336_/B _4336_/C _6206_/Q _4259_/D gf180mcu_as_sc_mcu7t3v3__ao22_2
XFILLER_228_652 VDD VDD VSS VSS gf180mcu_as_sc_mcu7t3v3__fill_1
XPHY_EDGE_ROW_20_1_Left_248 VDD VSS gf180mcu_as_sc_mcu7t3v3__tap_2
X_3209_ VDD VDD VSS VSS _4455_/A _3209_/B _3209_/C _3209_/D _3211_/A gf180mcu_as_sc_mcu7t3v3__ao22_2
XFILLER_215_313 VDD VDD VSS VSS gf180mcu_as_sc_mcu7t3v3__fillcap_4
X_4189_ VDD VDD VSS VSS _4193_/C _4189_/C _4215_/A _6197_/Q gf180mcu_as_sc_mcu7t3v3__aoi21b_2
XTAP_TAPCELL_ROW_206_2450 VDD VSS gf180mcu_as_sc_mcu7t3v3__tap_2
XFILLER_167_1224 VDD VDD VSS VSS gf180mcu_as_sc_mcu7t3v3__fillcap_16
XPHY_EDGE_ROW_145_1_Left_373 VDD VSS gf180mcu_as_sc_mcu7t3v3__tap_2
XTAP_TAPCELL_ROW_161_1638 VDD VSS gf180mcu_as_sc_mcu7t3v3__tap_2
XPHY_EDGE_ROW_67_1_Right_639 VDD VSS gf180mcu_as_sc_mcu7t3v3__tap_2
XTAP_TAPCELL_ROW_202_2369 VDD VSS gf180mcu_as_sc_mcu7t3v3__tap_2
XFILLER_151_6 VDD VDD VSS VSS gf180mcu_as_sc_mcu7t3v3__fillcap_16
XFILLER_168_412 VDD VDD VSS VSS gf180mcu_as_sc_mcu7t3v3__fill_2
XFILLER_208_1221 VDD VDD VSS VSS gf180mcu_as_sc_mcu7t3v3__fillcap_4
XPHY_EDGE_ROW_111_3_Right_191 VDD VSS gf180mcu_as_sc_mcu7t3v3__tap_2
XPHY_EDGE_ROW_82_1_Left_310 VDD VSS gf180mcu_as_sc_mcu7t3v3__tap_2
XFILLER_10_123 VDD VDD VSS VSS gf180mcu_as_sc_mcu7t3v3__fillcap_16
Xwire515 VDD VDD VSS VSS _3270_/Y wire515/Y gf180mcu_as_sc_mcu7t3v3__clkbuff_12
XFILLER_184_949 VDD VDD VSS VSS gf180mcu_as_sc_mcu7t3v3__fill_1
XFILLER_195_297 VDD VDD VSS VSS gf180mcu_as_sc_mcu7t3v3__fill_2
XFILLER_7_617 VDD VDD VSS VSS gf180mcu_as_sc_mcu7t3v3__fill_1
XFILLER_195_69 VDD VDD VSS VSS gf180mcu_as_sc_mcu7t3v3__fill_1
XFILLER_191_492 VDD VDD VSS VSS gf180mcu_as_sc_mcu7t3v3__fill_1
XFILLER_88_45 VDD VDD VSS VSS gf180mcu_as_sc_mcu7t3v3__fillcap_4
XFILLER_151_356 VDD VDD VSS VSS gf180mcu_as_sc_mcu7t3v3__fill_1
XTAP_TAPCELL_ROW_226_2804 VDD VSS gf180mcu_as_sc_mcu7t3v3__tap_2
XTAP_TAPCELL_ROW_226_2815 VDD VSS gf180mcu_as_sc_mcu7t3v3__tap_2
XFILLER_150_1250 VDD VDD VSS VSS gf180mcu_as_sc_mcu7t3v3__fillcap_8
Xfanout670 VDD VDD VSS VSS _5574_/C _5566_/B gf180mcu_as_sc_mcu7t3v3__buff_12
Xfanout681 VDD VDD VSS VSS _5188_/C _5143_/C gf180mcu_as_sc_mcu7t3v3__buff_12
Xfanout692 VDD VDD VSS VSS _4856_/B _4962_/C gf180mcu_as_sc_mcu7t3v3__buff_12
XFILLER_206_313 VDD VDD VSS VSS gf180mcu_as_sc_mcu7t3v3__fill_2
XPHY_EDGE_ROW_16_Right_16 VDD VSS gf180mcu_as_sc_mcu7t3v3__tap_2
XFILLER_14_473 VDD VDD VSS VSS gf180mcu_as_sc_mcu7t3v3__fillcap_4
XFILLER_14_484 VDD VDD VSS VSS gf180mcu_as_sc_mcu7t3v3__fillcap_8
XFILLER_202_574 VDD VDD VSS VSS gf180mcu_as_sc_mcu7t3v3__fillcap_16
XFILLER_186_297 VDD VDD VSS VSS gf180mcu_as_sc_mcu7t3v3__fill_2
XFILLER_155_640 VDD VDD VSS VSS gf180mcu_as_sc_mcu7t3v3__fill_2
X_3560_ VDD VDD VSS VSS _3655_/A _3560_/B _5328_/B _3656_/C gf180mcu_as_sc_mcu7t3v3__nor3_2
XFILLER_183_971 VDD VDD VSS VSS gf180mcu_as_sc_mcu7t3v3__fillcap_8
XFILLER_183_982 VDD VDD VSS VSS gf180mcu_as_sc_mcu7t3v3__fillcap_16
XPHY_EDGE_ROW_29_1_Right_601 VDD VSS gf180mcu_as_sc_mcu7t3v3__tap_2
XFILLER_185_80 VDD VDD VSS VSS gf180mcu_as_sc_mcu7t3v3__fillcap_4
X_5230_ VDD VDD VSS VSS _5231_/D _5879_/A _5310_/B _5263_/B gf180mcu_as_sc_mcu7t3v3__ao21_2
X_3491_ VDD VDD VSS VSS _3637_/A _5946_/D _5953_/D _3638_/A _3492_/D gf180mcu_as_sc_mcu7t3v3__ao22_2
X_5161_ VDD VDD VSS VSS _5817_/A _5217_/S _5226_/C _5817_/D _5162_/D gf180mcu_as_sc_mcu7t3v3__ao22_2
XFILLER_151_1014 VDD VDD VSS VSS gf180mcu_as_sc_mcu7t3v3__fillcap_16
X_5092_ VDD VDD VSS VSS _5093_/D _5758_/A _5202_/B _5205_/B gf180mcu_as_sc_mcu7t3v3__ao21_2
X_4112_ VDD VDD VSS VSS _4607_/A _4480_/A _4112_/B _4112_/C _4113_/B gf180mcu_as_sc_mcu7t3v3__ao31_2
X_4043_ VDD VDD VSS VSS _4043_/D _4043_/A _4043_/B _4061_/C _6120_/D gf180mcu_as_sc_mcu7t3v3__ao31_2
XTAP_TAPCELL_ROW_6_1117 VDD VSS gf180mcu_as_sc_mcu7t3v3__tap_2
XFILLER_209_162 VDD VDD VSS VSS gf180mcu_as_sc_mcu7t3v3__fill_2
XTAP_TAPCELL_ROW_6_1128 VDD VSS gf180mcu_as_sc_mcu7t3v3__tap_2
Xmesh_tile_1080 VDD VDD VSS VSS nw_out[3] gf180mcu_as_sc_mcu7t3v3__tiel_4
XFILLER_225_688 VDD VDD VSS VSS gf180mcu_as_sc_mcu7t3v3__fill_1
XFILLER_37_598 VDD VDD VSS VSS gf180mcu_as_sc_mcu7t3v3__fill_1
Xmesh_tile_1091 VDD VDD VSS VSS nw_out[14] gf180mcu_as_sc_mcu7t3v3__tiel_4
X_5994_ VDD VDD VSS VSS _6010_/B _6217_/Q _6507_/D gf180mcu_as_sc_mcu7t3v3__and2_2
XFILLER_220_53 VDD VDD VSS VSS gf180mcu_as_sc_mcu7t3v3__fillcap_16
X_4945_ VDD VDD VSS VSS _5937_/A _4945_/B _4945_/C _4960_/B _4948_/C gf180mcu_as_sc_mcu7t3v3__ao211_2
XFILLER_220_97 VDD VDD VSS VSS gf180mcu_as_sc_mcu7t3v3__fill_1
XFILLER_193_702 VDD VDD VSS VSS gf180mcu_as_sc_mcu7t3v3__fill_2
X_4876_ VDD VDD VSS VSS _4879_/C _4876_/B _5872_/D gf180mcu_as_sc_mcu7t3v3__nand2_2
XFILLER_138_629 VDD VDD VSS VSS gf180mcu_as_sc_mcu7t3v3__fillcap_4
X_3827_ VDD VDD VSS VSS _3930_/B _5817_/A _3828_/D gf180mcu_as_sc_mcu7t3v3__and2_2
XFILLER_193_757 VDD VDD VSS VSS gf180mcu_as_sc_mcu7t3v3__fillcap_4
X_6546_ VDD VDD VSS VSS _6546_/CLK _6546_/D _6546_/Q gf180mcu_as_sc_mcu7t3v3__dfxtp_2
X_3758_ VDD VDD VSS VSS _3871_/B _5761_/D _3759_/D gf180mcu_as_sc_mcu7t3v3__and2_2
XFILLER_146_662 VDD VDD VSS VSS gf180mcu_as_sc_mcu7t3v3__fillcap_4
XFILLER_192_278 VDD VDD VSS VSS gf180mcu_as_sc_mcu7t3v3__fill_2
XFILLER_3_108 VDD VDD VSS VSS gf180mcu_as_sc_mcu7t3v3__fill_1
XFILLER_173_492 VDD VDD VSS VSS gf180mcu_as_sc_mcu7t3v3__fillcap_4
X_6477_ VDD VDD VSS VSS _6484_/CLK _6477_/D _6477_/Q gf180mcu_as_sc_mcu7t3v3__dfxtp_2
X_3689_ VDD VDD VSS VSS _6496_/Q _3804_/B _3804_/C _5699_/B _3690_/D gf180mcu_as_sc_mcu7t3v3__ao22_2
X_5428_ VDD VDD VSS VSS _5737_/A _5456_/B _5641_/B _5736_/A _5429_/D gf180mcu_as_sc_mcu7t3v3__ao22_2
XFILLER_0_815 VDD VDD VSS VSS gf180mcu_as_sc_mcu7t3v3__fill_1
XFILLER_58_37 VDD VDD VSS VSS gf180mcu_as_sc_mcu7t3v3__fillcap_8
X_5359_ VDD VDD VSS VSS _5367_/A _5359_/B _5359_/C _5359_/Y gf180mcu_as_sc_mcu7t3v3__nor3_2
XFILLER_134_1245 VDD VDD VSS VSS gf180mcu_as_sc_mcu7t3v3__fillcap_16
XFILLER_181_27 VDD VDD VSS VSS gf180mcu_as_sc_mcu7t3v3__fillcap_8
Xwire1015 VDD VDD VSS VSS wire1015/A _5707_/B gf180mcu_as_sc_mcu7t3v3__clkbuff_12
XTAP_TAPCELL_ROW_204_2409 VDD VSS gf180mcu_as_sc_mcu7t3v3__tap_2
XFILLER_16_716 VDD VDD VSS VSS gf180mcu_as_sc_mcu7t3v3__fillcap_4
XTAP_TAPCELL_ROW_221_2723 VDD VSS gf180mcu_as_sc_mcu7t3v3__tap_2
XTAP_TAPCELL_ROW_221_2712 VDD VSS gf180mcu_as_sc_mcu7t3v3__tap_2
XFILLER_203_338 VDD VDD VSS VSS gf180mcu_as_sc_mcu7t3v3__fill_1
XFILLER_180_1221 VDD VDD VSS VSS gf180mcu_as_sc_mcu7t3v3__fillcap_4
XFILLER_54_1235 VDD VDD VSS VSS gf180mcu_as_sc_mcu7t3v3__fillcap_8
XPHY_EDGE_ROW_112_3_Right_192 VDD VSS gf180mcu_as_sc_mcu7t3v3__tap_2
XTAP_TAPCELL_ROW_178_1943 VDD VSS gf180mcu_as_sc_mcu7t3v3__tap_2
XFILLER_15_1208 VDD VDD VSS VSS gf180mcu_as_sc_mcu7t3v3__fillcap_16
XFILLER_180_1243 VDD VDD VSS VSS gf180mcu_as_sc_mcu7t3v3__fillcap_16
XTAP_TAPCELL_ROW_97_2_2994 VDD VSS gf180mcu_as_sc_mcu7t3v3__tap_2
XTAP_TAPCELL_ROW_178_1954 VDD VSS gf180mcu_as_sc_mcu7t3v3__tap_2
XFILLER_141_1238 VDD VDD VSS VSS gf180mcu_as_sc_mcu7t3v3__fill_2
XFILLER_157_949 VDD VDD VSS VSS gf180mcu_as_sc_mcu7t3v3__fillcap_16
XFILLER_183_212 VDD VDD VSS VSS gf180mcu_as_sc_mcu7t3v3__fill_2
XFILLER_196_573 VDD VDD VSS VSS gf180mcu_as_sc_mcu7t3v3__fill_1
XFILLER_221_1240 VDD VDD VSS VSS gf180mcu_as_sc_mcu7t3v3__fillcap_16
XTAP_TAPCELL_ROW_219_2685 VDD VSS gf180mcu_as_sc_mcu7t3v3__tap_2
XFILLER_221_1262 VDD VDD VSS VSS gf180mcu_as_sc_mcu7t3v3__fill_2
XFILLER_151_120 VDD VDD VSS VSS gf180mcu_as_sc_mcu7t3v3__fillcap_16
XFILLER_151_142 VDD VDD VSS VSS gf180mcu_as_sc_mcu7t3v3__fillcap_16
XFILLER_155_72 VDD VDD VSS VSS gf180mcu_as_sc_mcu7t3v3__fillcap_16
XFILLER_0_1019 VDD VDD VSS VSS gf180mcu_as_sc_mcu7t3v3__fill_1
XFILLER_19_598 VDD VDD VSS VSS gf180mcu_as_sc_mcu7t3v3__fillcap_4
XFILLER_206_154 VDD VDD VSS VSS gf180mcu_as_sc_mcu7t3v3__fillcap_4
XFILLER_185_1154 VDD VDD VSS VSS gf180mcu_as_sc_mcu7t3v3__fillcap_16
XTAP_TAPCELL_ROW_1_1036 VDD VSS gf180mcu_as_sc_mcu7t3v3__tap_2
XTAP_TAPCELL_ROW_1_1025 VDD VSS gf180mcu_as_sc_mcu7t3v3__tap_2
XFILLER_226_1151 VDD VDD VSS VSS gf180mcu_as_sc_mcu7t3v3__fillcap_4
XFILLER_187_562 VDD VDD VSS VSS gf180mcu_as_sc_mcu7t3v3__fill_2
XFILLER_226_1173 VDD VDD VSS VSS gf180mcu_as_sc_mcu7t3v3__fillcap_16
X_4730_ VDD VDD VSS VSS _4896_/A _4730_/B _6501_/Q _4732_/C gf180mcu_as_sc_mcu7t3v3__mux2_2
X_4661_ VDD VDD VSS VSS _4945_/B _4889_/A _4932_/A gf180mcu_as_sc_mcu7t3v3__and2_2
X_6400_ VDD VDD VSS VSS clkload3/A _6400_/D _6400_/Q gf180mcu_as_sc_mcu7t3v3__dfxtp_2
X_3612_ VDD VDD VSS VSS _3614_/C _3612_/B _3655_/A gf180mcu_as_sc_mcu7t3v3__nand2_2
X_6331_ VDD VDD VSS VSS _6552_/CLK _6331_/D _6331_/Q gf180mcu_as_sc_mcu7t3v3__dfxtp_2
X_4592_ VDD VDD VSS VSS _4592_/B _6334_/Q _4593_/C gf180mcu_as_sc_mcu7t3v3__xnor2_2
XFILLER_143_643 VDD VDD VSS VSS gf180mcu_as_sc_mcu7t3v3__fill_1
XFILLER_155_492 VDD VDD VSS VSS gf180mcu_as_sc_mcu7t3v3__fill_2
XFILLER_171_930 VDD VDD VSS VSS gf180mcu_as_sc_mcu7t3v3__fill_1
XFILLER_192_1103 VDD VDD VSS VSS gf180mcu_as_sc_mcu7t3v3__fillcap_16
Xmax_cap645 VDD VDD VSS VSS fanout644/Y _3808_/B gf180mcu_as_sc_mcu7t3v3__clkbuff_12
X_3543_ VDD VDD VSS VSS _4615_/D _3543_/B _5310_/A gf180mcu_as_sc_mcu7t3v3__nor2b_2
XPHY_EDGE_ROW_112_2_Left_553 VDD VSS gf180mcu_as_sc_mcu7t3v3__tap_2
XPHY_EDGE_ROW_181_Left_409 VDD VSS gf180mcu_as_sc_mcu7t3v3__tap_2
X_6262_ VDD VDD VSS VSS clkload8/A _6262_/D _6262_/Q gf180mcu_as_sc_mcu7t3v3__dfxtp_2
X_3474_ VDD VDD VSS VSS _3474_/A _3474_/B _3474_/C _5350_/D _4635_/B gf180mcu_as_sc_mcu7t3v3__nand4_2
XFILLER_170_484 VDD VDD VSS VSS gf180mcu_as_sc_mcu7t3v3__fill_1
X_6193_ VDD VDD VSS VSS _6526_/CLK _6193_/D _6193_/Q gf180mcu_as_sc_mcu7t3v3__dfxtp_2
X_5213_ VDD VDD VSS VSS _5222_/B _5213_/B _5213_/C _5295_/B _5216_/B gf180mcu_as_sc_mcu7t3v3__ao211_2
X_5144_ VDD VDD VSS VSS _5802_/A _5144_/B _5144_/C _5144_/D _5145_/A gf180mcu_as_sc_mcu7t3v3__ao211_2
X_5075_ VDD VDD VSS VSS _5077_/C _5740_/A _5140_/B _5075_/C gf180mcu_as_sc_mcu7t3v3__ao21_2
XFILLER_72_619 VDD VDD VSS VSS gf180mcu_as_sc_mcu7t3v3__fillcap_8
X_4026_ VDD VDD VSS VSS _4026_/D _4051_/A _4026_/B _4057_/C _6108_/D gf180mcu_as_sc_mcu7t3v3__ao31_2
XFILLER_164_1205 VDD VDD VSS VSS gf180mcu_as_sc_mcu7t3v3__fillcap_16
XFILLER_213_625 VDD VDD VSS VSS gf180mcu_as_sc_mcu7t3v3__fillcap_4
XFILLER_213_636 VDD VDD VSS VSS gf180mcu_as_sc_mcu7t3v3__fill_1
XPHY_EDGE_ROW_190_Left_418 VDD VSS gf180mcu_as_sc_mcu7t3v3__tap_2
XTAP_TAPCELL_ROW_109_2_3012 VDD VSS gf180mcu_as_sc_mcu7t3v3__tap_2
X_5977_ VDD VDD VSS VSS _5977_/B _5977_/A _6492_/D gf180mcu_as_sc_mcu7t3v3__and2_2
XTAP_TAPCELL_ROW_195_2243 VDD VSS gf180mcu_as_sc_mcu7t3v3__tap_2
XFILLER_100_45 VDD VDD VSS VSS gf180mcu_as_sc_mcu7t3v3__fillcap_4
XFILLER_205_1224 VDD VDD VSS VSS gf180mcu_as_sc_mcu7t3v3__fillcap_8
X_4928_ VDD VDD VSS VSS _5917_/A _4950_/D _4928_/C _6370_/D _5957_/C gf180mcu_as_sc_mcu7t3v3__aoi211_2
XTAP_TAPCELL_ROW_195_2254 VDD VSS gf180mcu_as_sc_mcu7t3v3__tap_2
XFILLER_165_212 VDD VDD VSS VSS gf180mcu_as_sc_mcu7t3v3__fillcap_4
Xsram2048.u_bank0_1028 VDD VDD VSS VSS sram2048.u_bank0/WEN[2] gf180mcu_as_sc_mcu7t3v3__tiel_4
XFILLER_119_640 VDD VDD VSS VSS gf180mcu_as_sc_mcu7t3v3__fillcap_8
XFILLER_165_245 VDD VDD VSS VSS gf180mcu_as_sc_mcu7t3v3__fill_1
XFILLER_193_532 VDD VDD VSS VSS gf180mcu_as_sc_mcu7t3v3__fill_1
XFILLER_197_1014 VDD VDD VSS VSS gf180mcu_as_sc_mcu7t3v3__fillcap_16
XFILLER_60_49 VDD VDD VSS VSS gf180mcu_as_sc_mcu7t3v3__fill_2
XTAP_TAPCELL_ROW_156_1548 VDD VSS gf180mcu_as_sc_mcu7t3v3__tap_2
X_4859_ VDD VDD VSS VSS _4860_/C _4887_/B _5855_/A gf180mcu_as_sc_mcu7t3v3__nor2_2
XFILLER_153_418 VDD VDD VSS VSS gf180mcu_as_sc_mcu7t3v3__fill_2
XTAP_TAPCELL_ROW_173_1851 VDD VSS gf180mcu_as_sc_mcu7t3v3__tap_2
XTAP_TAPCELL_ROW_173_1862 VDD VSS gf180mcu_as_sc_mcu7t3v3__tap_2
XFILLER_109_43 VDD VDD VSS VSS gf180mcu_as_sc_mcu7t3v3__fillcap_8
XFILLER_134_621 VDD VDD VSS VSS gf180mcu_as_sc_mcu7t3v3__fillcap_4
XPHY_EDGE_ROW_44_2_Left_485 VDD VSS gf180mcu_as_sc_mcu7t3v3__tap_2
X_6529_ VDD VDD VSS VSS _6552_/CLK _6529_/D _6529_/Q gf180mcu_as_sc_mcu7t3v3__dfxtp_2
XFILLER_134_665 VDD VDD VSS VSS gf180mcu_as_sc_mcu7t3v3__fill_2
XFILLER_162_974 VDD VDD VSS VSS gf180mcu_as_sc_mcu7t3v3__fillcap_16
XFILLER_69_36 VDD VDD VSS VSS gf180mcu_as_sc_mcu7t3v3__fillcap_8
XTAP_TAPCELL_ROW_214_2593 VDD VSS gf180mcu_as_sc_mcu7t3v3__tap_2
XFILLER_192_37 VDD VDD VSS VSS gf180mcu_as_sc_mcu7t3v3__fillcap_16
XFILLER_21_1212 VDD VDD VSS VSS gf180mcu_as_sc_mcu7t3v3__fill_1
XFILLER_60_1261 VDD VDD VSS VSS gf180mcu_as_sc_mcu7t3v3__fillcap_4
XTAP_TAPCELL_ROW_15_1279 VDD VSS gf180mcu_as_sc_mcu7t3v3__tap_2
XFILLER_169_1116 VDD VDD VSS VSS gf180mcu_as_sc_mcu7t3v3__fillcap_4
XFILLER_169_1138 VDD VDD VSS VSS gf180mcu_as_sc_mcu7t3v3__fillcap_16
XFILLER_216_430 VDD VDD VSS VSS gf180mcu_as_sc_mcu7t3v3__fillcap_8
XFILLER_216_452 VDD VDD VSS VSS gf180mcu_as_sc_mcu7t3v3__fill_2
XFILLER_16_535 VDD VDD VSS VSS gf180mcu_as_sc_mcu7t3v3__fillcap_8
XFILLER_16_546 VDD VDD VSS VSS gf180mcu_as_sc_mcu7t3v3__fillcap_4
XTAP_TAPCELL_ROW_144_2_3064 VDD VSS gf180mcu_as_sc_mcu7t3v3__tap_2
XFILLER_157_702 VDD VDD VSS VSS gf180mcu_as_sc_mcu7t3v3__fillcap_8
XFILLER_197_860 VDD VDD VSS VSS gf180mcu_as_sc_mcu7t3v3__fill_1
XPHY_EDGE_ROW_108_1_Left_336 VDD VSS gf180mcu_as_sc_mcu7t3v3__tap_2
XFILLER_169_595 VDD VDD VSS VSS gf180mcu_as_sc_mcu7t3v3__fillcap_16
XPHY_EDGE_ROW_113_3_Right_193 VDD VSS gf180mcu_as_sc_mcu7t3v3__tap_2
XFILLER_157_768 VDD VDD VSS VSS gf180mcu_as_sc_mcu7t3v3__fill_2
XFILLER_8_745 VDD VDD VSS VSS gf180mcu_as_sc_mcu7t3v3__fillcap_4
XFILLER_200_886 VDD VDD VSS VSS gf180mcu_as_sc_mcu7t3v3__fill_1
XFILLER_7_244 VDD VDD VSS VSS gf180mcu_as_sc_mcu7t3v3__fillcap_16
XFILLER_153_952 VDD VDD VSS VSS gf180mcu_as_sc_mcu7t3v3__fillcap_16
XFILLER_4_995 VDD VDD VSS VSS gf180mcu_as_sc_mcu7t3v3__fillcap_16
XFILLER_182_81 VDD VDD VSS VSS gf180mcu_as_sc_mcu7t3v3__fill_2
X_3190_ VDD VDD VSS VSS _4148_/B _3212_/A _3216_/D _3190_/Y _6135_/Q gf180mcu_as_sc_mcu7t3v3__aoi211_2
XFILLER_208_931 VDD VDD VSS VSS gf180mcu_as_sc_mcu7t3v3__fillcap_8
X_5900_ VDD VDD VSS VSS _5900_/A _5953_/B _5900_/C _5900_/D _5901_/B gf180mcu_as_sc_mcu7t3v3__ao211_2
XFILLER_223_912 VDD VDD VSS VSS gf180mcu_as_sc_mcu7t3v3__fillcap_4
XPHY_EDGE_ROW_150_Right_18 VDD VSS gf180mcu_as_sc_mcu7t3v3__tap_2
XFILLER_201_33 VDD VDD VSS VSS gf180mcu_as_sc_mcu7t3v3__fillcap_16
XFILLER_223_978 VDD VDD VSS VSS gf180mcu_as_sc_mcu7t3v3__fill_2
X_5831_ VDD VDD VSS VSS _5831_/A _5922_/B _5831_/C _5879_/D _5832_/D gf180mcu_as_sc_mcu7t3v3__ao22_2
XFILLER_201_88 VDD VDD VSS VSS gf180mcu_as_sc_mcu7t3v3__fillcap_8
X_5762_ VDD VDD VSS VSS _5909_/D _5955_/S _5762_/B _5762_/C _5763_/C gf180mcu_as_sc_mcu7t3v3__ao31_2
XFILLER_188_893 VDD VDD VSS VSS gf180mcu_as_sc_mcu7t3v3__fill_1
X_4713_ VDD VDD VSS VSS _4713_/D _4896_/A _4713_/B _4713_/C _4715_/C gf180mcu_as_sc_mcu7t3v3__ao31_2
X_5693_ VDD VDD VSS VSS _5693_/A _5802_/C _5801_/S _5693_/D _5694_/D gf180mcu_as_sc_mcu7t3v3__ao22_2
XFILLER_190_513 VDD VDD VSS VSS gf180mcu_as_sc_mcu7t3v3__fillcap_4
X_4644_ VDD VDD VSS VSS _4645_/C _4877_/B _5675_/D gf180mcu_as_sc_mcu7t3v3__nor2_2
XTAP_TAPCELL_ROW_190_2162 VDD VSS gf180mcu_as_sc_mcu7t3v3__tap_2
X_4575_ VDD VDD VSS VSS _6310_/D _4602_/C _4575_/B _4602_/A gf180mcu_as_sc_mcu7t3v3__aoi21b_2
XFILLER_116_665 VDD VDD VSS VSS gf180mcu_as_sc_mcu7t3v3__fill_2
XTAP_TAPCELL_ROW_151_1456 VDD VSS gf180mcu_as_sc_mcu7t3v3__tap_2
X_6314_ VDD VDD VSS VSS _6531_/CLK _6314_/D _6314_/Q gf180mcu_as_sc_mcu7t3v3__dfxtp_2
X_3526_ VDD VDD VSS VSS _5652_/A _5929_/A _3631_/D gf180mcu_as_sc_mcu7t3v3__nor2_2
XTAP_TAPCELL_ROW_151_1467 VDD VSS gf180mcu_as_sc_mcu7t3v3__tap_2
X_6245_ VDD VDD VSS VSS _6531_/CLK _6245_/D _6245_/Q gf180mcu_as_sc_mcu7t3v3__dfxtp_2
X_3457_ VDD VDD VSS VSS _4585_/A _3457_/B _6322_/Q _6321_/D gf180mcu_as_sc_mcu7t3v3__mux2_2
XFILLER_44_1245 VDD VDD VSS VSS gf180mcu_as_sc_mcu7t3v3__fillcap_16
X_6176_ VDD VDD VSS VSS _6376_/CLK _6176_/D _6176_/Q gf180mcu_as_sc_mcu7t3v3__dfxtp_2
X_3388_ VDD VDD VSS VSS _3389_/B _3438_/C _3438_/B gf180mcu_as_sc_mcu7t3v3__nand2_2
X_5127_ VDD VDD VSS VSS _5237_/S _5788_/A _5127_/A _5128_/B gf180mcu_as_sc_mcu7t3v3__mux2_2
XPHY_EDGE_ROW_2_Right_2 VDD VSS gf180mcu_as_sc_mcu7t3v3__tap_2
XTAP_TAPCELL_ROW_149_1396 VDD VSS gf180mcu_as_sc_mcu7t3v3__tap_2
X_5058_ VDD VDD VSS VSS _6499_/Q _5233_/C _5226_/C _5723_/A _5059_/D gf180mcu_as_sc_mcu7t3v3__ao22_2
XFILLER_55_49 VDD VDD VSS VSS gf180mcu_as_sc_mcu7t3v3__fill_2
X_4009_ VDD VDD VSS VSS _4009_/A _4014_/B _4014_/C _6097_/Q _6097_/D gf180mcu_as_sc_mcu7t3v3__ao22_2
XTAP_TAPCELL_ROW_10_1187 VDD VSS gf180mcu_as_sc_mcu7t3v3__tap_2
XFILLER_213_433 VDD VDD VSS VSS gf180mcu_as_sc_mcu7t3v3__fill_1
XFILLER_213_444 VDD VDD VSS VSS gf180mcu_as_sc_mcu7t3v3__fillcap_4
XFILLER_225_282 VDD VDD VSS VSS gf180mcu_as_sc_mcu7t3v3__fill_1
XTAP_TAPCELL_ROW_10_1198 VDD VSS gf180mcu_as_sc_mcu7t3v3__tap_2
XFILLER_13_538 VDD VDD VSS VSS gf180mcu_as_sc_mcu7t3v3__fillcap_16
XFILLER_90_1210 VDD VDD VSS VSS gf180mcu_as_sc_mcu7t3v3__fillcap_8
XTAP_TAPCELL_ROW_216_2633 VDD VSS gf180mcu_as_sc_mcu7t3v3__tap_2
XTAP_TAPCELL_ROW_216_2622 VDD VSS gf180mcu_as_sc_mcu7t3v3__tap_2
XFILLER_107_632 VDD VDD VSS VSS gf180mcu_as_sc_mcu7t3v3__fillcap_16
XFILLER_4_247 VDD VDD VSS VSS gf180mcu_as_sc_mcu7t3v3__fillcap_4
XFILLER_122_602 VDD VDD VSS VSS gf180mcu_as_sc_mcu7t3v3__fill_1
XFILLER_150_933 VDD VDD VSS VSS gf180mcu_as_sc_mcu7t3v3__fill_1
XFILLER_122_657 VDD VDD VSS VSS gf180mcu_as_sc_mcu7t3v3__fillcap_8
XFILLER_175_1186 VDD VDD VSS VSS gf180mcu_as_sc_mcu7t3v3__fillcap_4
XFILLER_96_45 VDD VDD VSS VSS gf180mcu_as_sc_mcu7t3v3__fillcap_4
Xinput310 VDD VDD VSS VSS west_in[16] _5805_/A gf180mcu_as_sc_mcu7t3v3__buff_12
Xinput321 VDD VDD VSS VSS west_in[26] _5889_/A gf180mcu_as_sc_mcu7t3v3__buff_12
XFILLER_1_998 VDD VDD VSS VSS gf180mcu_as_sc_mcu7t3v3__fillcap_16
Xinput332 VDD VDD VSS VSS west_in[3] _5701_/A gf180mcu_as_sc_mcu7t3v3__buff_12
XTAP_TAPCELL_ROW_85_2_2976 VDD VSS gf180mcu_as_sc_mcu7t3v3__tap_2
XFILLER_205_912 VDD VDD VSS VSS gf180mcu_as_sc_mcu7t3v3__fillcap_16
XFILLER_217_772 VDD VDD VSS VSS gf180mcu_as_sc_mcu7t3v3__fillcap_4
XFILLER_147_1233 VDD VDD VSS VSS gf180mcu_as_sc_mcu7t3v3__fillcap_16
XFILLER_182_1135 VDD VDD VSS VSS gf180mcu_as_sc_mcu7t3v3__fillcap_16
XFILLER_182_1157 VDD VDD VSS VSS gf180mcu_as_sc_mcu7t3v3__fillcap_16
XFILLER_220_915 VDD VDD VSS VSS gf180mcu_as_sc_mcu7t3v3__fillcap_16
XTAP_TAPCELL_ROW_84_1_1363 VDD VSS gf180mcu_as_sc_mcu7t3v3__tap_2
XFILLER_223_1154 VDD VDD VSS VSS gf180mcu_as_sc_mcu7t3v3__fillcap_16
XPHY_EDGE_ROW_114_3_Right_194 VDD VSS gf180mcu_as_sc_mcu7t3v3__tap_2
XFILLER_12_593 VDD VDD VSS VSS gf180mcu_as_sc_mcu7t3v3__fill_2
XFILLER_157_576 VDD VDD VSS VSS gf180mcu_as_sc_mcu7t3v3__fill_2
XANTENNA_3 VDD VDD VSS VSS _6355_/D gf180mcu_as_sc_mcu7t3v3__diode_2
XFILLER_172_524 VDD VDD VSS VSS gf180mcu_as_sc_mcu7t3v3__fill_1
XFILLER_177_92 VDD VDD VSS VSS gf180mcu_as_sc_mcu7t3v3__fillcap_16
XFILLER_8_597 VDD VDD VSS VSS gf180mcu_as_sc_mcu7t3v3__fillcap_4
X_4360_ VDD VDD VSS VSS _4360_/D _4366_/D _4360_/B _4360_/C _6219_/D gf180mcu_as_sc_mcu7t3v3__ao31_2
XFILLER_113_602 VDD VDD VSS VSS gf180mcu_as_sc_mcu7t3v3__fillcap_4
XFILLER_113_624 VDD VDD VSS VSS gf180mcu_as_sc_mcu7t3v3__fill_2
X_3311_ VDD VDD VSS VSS _3326_/S _6534_/Q _6543_/Q _3312_/B gf180mcu_as_sc_mcu7t3v3__mux2_2
XFILLER_193_1264 VDD VDD VSS VSS gf180mcu_as_sc_mcu7t3v3__fill_1
X_4291_ VDD VDD VSS VSS _4292_/C _4362_/A _6023_/Q gf180mcu_as_sc_mcu7t3v3__nor2b_2
X_6030_ VDD VDD VSS VSS _6370_/CLK _6030_/D _6030_/Q gf180mcu_as_sc_mcu7t3v3__dfxtp_2
X_3242_ VDD VDD VSS VSS _3296_/B _6165_/Q _6229_/Q _3243_/B gf180mcu_as_sc_mcu7t3v3__mux2_2
X_3173_ VDD VDD VSS VSS _4112_/B _3392_/B _3173_/B _4104_/B gf180mcu_as_sc_mcu7t3v3__aoi21_2
XFILLER_187_1046 VDD VDD VSS VSS gf180mcu_as_sc_mcu7t3v3__fillcap_4
XFILLER_187_1068 VDD VDD VSS VSS gf180mcu_as_sc_mcu7t3v3__fillcap_16
XFILLER_223_731 VDD VDD VSS VSS gf180mcu_as_sc_mcu7t3v3__fill_1
XFILLER_161_1208 VDD VDD VSS VSS gf180mcu_as_sc_mcu7t3v3__fillcap_16
XFILLER_211_904 VDD VDD VSS VSS gf180mcu_as_sc_mcu7t3v3__fillcap_4
XFILLER_228_1065 VDD VDD VSS VSS gf180mcu_as_sc_mcu7t3v3__fillcap_4
XFILLER_50_611 VDD VDD VSS VSS gf180mcu_as_sc_mcu7t3v3__fillcap_4
XFILLER_74_1238 VDD VDD VSS VSS gf180mcu_as_sc_mcu7t3v3__fillcap_4
X_5814_ VDD VDD VSS VSS _5862_/S _5814_/B _6510_/Q _5815_/C gf180mcu_as_sc_mcu7t3v3__mux2_2
XTAP_TAPCELL_ROW_192_2202 VDD VSS gf180mcu_as_sc_mcu7t3v3__tap_2
XFILLER_202_1205 VDD VDD VSS VSS gf180mcu_as_sc_mcu7t3v3__fillcap_16
XFILLER_210_469 VDD VDD VSS VSS gf180mcu_as_sc_mcu7t3v3__fill_2
X_5745_ VDD VDD VSS VSS _5746_/B _5745_/A _5802_/B _5745_/C gf180mcu_as_sc_mcu7t3v3__ao21_2
XFILLER_175_362 VDD VDD VSS VSS gf180mcu_as_sc_mcu7t3v3__fill_1
XFILLER_176_874 VDD VDD VSS VSS gf180mcu_as_sc_mcu7t3v3__fill_1
XFILLER_202_1227 VDD VDD VSS VSS gf180mcu_as_sc_mcu7t3v3__fillcap_8
X_5676_ VDD VDD VSS VSS _5676_/A _5864_/B _5861_/B _5676_/D _5677_/D gf180mcu_as_sc_mcu7t3v3__ao22_2
XFILLER_175_373 VDD VDD VSS VSS gf180mcu_as_sc_mcu7t3v3__fillcap_8
XTAP_TAPCELL_ROW_170_1810 VDD VSS gf180mcu_as_sc_mcu7t3v3__tap_2
X_4627_ VDD VDD VSS VSS _4627_/A _4627_/B _4627_/C _4627_/D _4628_/B gf180mcu_as_sc_mcu7t3v3__ao211_2
XFILLER_163_557 VDD VDD VSS VSS gf180mcu_as_sc_mcu7t3v3__fill_2
XFILLER_194_1017 VDD VDD VSS VSS gf180mcu_as_sc_mcu7t3v3__fillcap_16
XFILLER_190_387 VDD VDD VSS VSS gf180mcu_as_sc_mcu7t3v3__fillcap_16
X_4558_ VDD VDD VSS VSS _4559_/B _4558_/B _4558_/A gf180mcu_as_sc_mcu7t3v3__nand2b_2
XTAP_TAPCELL_ROW_211_2541 VDD VSS gf180mcu_as_sc_mcu7t3v3__tap_2
XFILLER_1_228 VDD VDD VSS VSS gf180mcu_as_sc_mcu7t3v3__fill_2
X_4489_ VDD VDD VSS VSS _6151_/Q _4512_/S _4499_/C _6282_/Q _4490_/C gf180mcu_as_sc_mcu7t3v3__ao22_2
X_3509_ VDD VDD VSS VSS _4970_/A _3510_/C _3510_/B gf180mcu_as_sc_mcu7t3v3__nor2_2
X_6228_ VDD VDD VSS VSS _6316_/CLK _6228_/D _6228_/Q gf180mcu_as_sc_mcu7t3v3__dfxtp_2
XTAP_TAPCELL_ROW_26_1_1334 VDD VSS gf180mcu_as_sc_mcu7t3v3__tap_2
XTAP_TAPCELL_ROW_168_1761 VDD VSS gf180mcu_as_sc_mcu7t3v3__tap_2
XTAP_TAPCELL_ROW_168_1772 VDD VSS gf180mcu_as_sc_mcu7t3v3__tap_2
X_6159_ VDD VDD VSS VSS clkload8/A _6159_/D _6159_/Q gf180mcu_as_sc_mcu7t3v3__dfxtp_2
XFILLER_66_37 VDD VDD VSS VSS gf180mcu_as_sc_mcu7t3v3__fillcap_8
XPHY_EDGE_ROW_120_1_Right_692 VDD VSS gf180mcu_as_sc_mcu7t3v3__tap_2
XTAP_TAPCELL_ROW_12_1227 VDD VSS gf180mcu_as_sc_mcu7t3v3__tap_2
XTAP_TAPCELL_ROW_12_1238 VDD VSS gf180mcu_as_sc_mcu7t3v3__tap_2
Xhold1220 VDD VDD VSS VSS _6541_/Q hold1220/Y gf180mcu_as_sc_mcu7t3v3__clkbuff_4
Xhold1231 VDD VDD VSS VSS _6544_/Q hold1231/Y gf180mcu_as_sc_mcu7t3v3__clkbuff_4
XFILLER_166_1119 VDD VDD VSS VSS gf180mcu_as_sc_mcu7t3v3__fillcap_16
XFILLER_199_944 VDD VDD VSS VSS gf180mcu_as_sc_mcu7t3v3__fillcap_16
XFILLER_226_591 VDD VDD VSS VSS gf180mcu_as_sc_mcu7t3v3__fillcap_4
XTAP_TAPCELL_ROW_181_1994 VDD VSS gf180mcu_as_sc_mcu7t3v3__tap_2
XFILLER_207_1116 VDD VDD VSS VSS gf180mcu_as_sc_mcu7t3v3__fillcap_4
XFILLER_13_346 VDD VDD VSS VSS gf180mcu_as_sc_mcu7t3v3__fillcap_4
XFILLER_13_368 VDD VDD VSS VSS gf180mcu_as_sc_mcu7t3v3__fillcap_8
XFILLER_15_52 VDD VDD VSS VSS gf180mcu_as_sc_mcu7t3v3__fillcap_16
XFILLER_198_69 VDD VDD VSS VSS gf180mcu_as_sc_mcu7t3v3__fillcap_16
XFILLER_202_937 VDD VDD VSS VSS gf180mcu_as_sc_mcu7t3v3__fillcap_8
XFILLER_207_1138 VDD VDD VSS VSS gf180mcu_as_sc_mcu7t3v3__fillcap_16
XFILLER_41_666 VDD VDD VSS VSS gf180mcu_as_sc_mcu7t3v3__fill_1
XFILLER_9_306 VDD VDD VSS VSS gf180mcu_as_sc_mcu7t3v3__fill_1
XFILLER_16_1144 VDD VDD VSS VSS gf180mcu_as_sc_mcu7t3v3__fillcap_8
XFILLER_222_2 VDD VDD VSS VSS gf180mcu_as_sc_mcu7t3v3__fillcap_16
XFILLER_154_557 VDD VDD VSS VSS gf180mcu_as_sc_mcu7t3v3__fillcap_4
XFILLER_5_545 VDD VDD VSS VSS gf180mcu_as_sc_mcu7t3v3__fill_2
XFILLER_181_387 VDD VDD VSS VSS gf180mcu_as_sc_mcu7t3v3__fill_1
XFILLER_162_590 VDD VDD VSS VSS gf180mcu_as_sc_mcu7t3v3__fillcap_4
XFILLER_114_1210 VDD VDD VSS VSS gf180mcu_as_sc_mcu7t3v3__fillcap_8
XFILLER_163_72 VDD VDD VSS VSS gf180mcu_as_sc_mcu7t3v3__fillcap_16
XTAP_TAPCELL_ROW_132_2_3046 VDD VSS gf180mcu_as_sc_mcu7t3v3__tap_2
Xinput140 VDD VDD VSS VSS north_in[26] _5887_/D gf180mcu_as_sc_mcu7t3v3__buff_12
Xinput151 VDD VDD VSS VSS north_in[3] wire1016/A gf180mcu_as_sc_mcu7t3v3__buff_12
Xinput162 VDD VDD VSS VSS nw_in[13] _5786_/D gf180mcu_as_sc_mcu7t3v3__buff_12
Xinput173 VDD VDD VSS VSS nw_in[23] _5865_/A gf180mcu_as_sc_mcu7t3v3__buff_12
Xinput184 VDD VDD VSS VSS nw_in[33] _5946_/A gf180mcu_as_sc_mcu7t3v3__buff_12
Xinput195 VDD VDD VSS VSS se_in[0] _5678_/A gf180mcu_as_sc_mcu7t3v3__buff_12
XFILLER_224_517 VDD VDD VSS VSS gf180mcu_as_sc_mcu7t3v3__fill_1
XPHY_EDGE_ROW_69_2_Left_510 VDD VSS gf180mcu_as_sc_mcu7t3v3__tap_2
XPHY_EDGE_ROW_144_3_Left_849 VDD VSS gf180mcu_as_sc_mcu7t3v3__tap_2
XPHY_EDGE_ROW_121_2_Left_562 VDD VSS gf180mcu_as_sc_mcu7t3v3__tap_2
X_3860_ VDD VDD VSS VSS _5846_/B _3886_/C _3860_/C _3860_/D _3862_/C gf180mcu_as_sc_mcu7t3v3__ao211_2
XFILLER_220_778 VDD VDD VSS VSS gf180mcu_as_sc_mcu7t3v3__fill_2
X_3791_ VDD VDD VSS VSS _3791_/B _4043_/A _4037_/B gf180mcu_as_sc_mcu7t3v3__and2_2
XFILLER_121_1214 VDD VDD VSS VSS gf180mcu_as_sc_mcu7t3v3__fill_1
XFILLER_201_970 VDD VDD VSS VSS gf180mcu_as_sc_mcu7t3v3__fillcap_8
X_5530_ VDD VDD VSS VSS _5530_/B _5562_/A _6432_/D gf180mcu_as_sc_mcu7t3v3__and2_2
XFILLER_157_384 VDD VDD VSS VSS gf180mcu_as_sc_mcu7t3v3__fill_2
XPHY_EDGE_ROW_115_3_Right_195 VDD VSS gf180mcu_as_sc_mcu7t3v3__tap_2
X_5461_ VDD VDD VSS VSS _5565_/B _5764_/A _5461_/A _5462_/D gf180mcu_as_sc_mcu7t3v3__mux2_2
X_4412_ VDD VDD VSS VSS _6228_/Q _4428_/B _4583_/D _6227_/Q _6227_/D gf180mcu_as_sc_mcu7t3v3__ao22_2
XFILLER_172_376 VDD VDD VSS VSS gf180mcu_as_sc_mcu7t3v3__fillcap_8
X_5392_ VDD VDD VSS VSS _5701_/A _5492_/B _5392_/C _5392_/D _5393_/D gf180mcu_as_sc_mcu7t3v3__ao22_2
XFILLER_172_398 VDD VDD VSS VSS gf180mcu_as_sc_mcu7t3v3__fillcap_4
XFILLER_207_43 VDD VDD VSS VSS gf180mcu_as_sc_mcu7t3v3__fillcap_16
X_4343_ VDD VDD VSS VSS _6217_/Q _4399_/B _4399_/C _6218_/Q _4344_/C gf180mcu_as_sc_mcu7t3v3__ao22_2
XFILLER_99_666 VDD VDD VSS VSS gf180mcu_as_sc_mcu7t3v3__fill_1
X_4274_ VDD VDD VSS VSS _6207_/Q _4406_/B _4336_/C _6208_/Q _4275_/D gf180mcu_as_sc_mcu7t3v3__ao22_2
XFILLER_80_1242 VDD VDD VSS VSS gf180mcu_as_sc_mcu7t3v3__fill_1
X_6013_ VDD VDD VSS VSS _6013_/S _6013_/B _6527_/Q _6527_/D gf180mcu_as_sc_mcu7t3v3__mux2_2
X_3225_ VDD VDD VSS VSS _3226_/C _3353_/A _6137_/Q gf180mcu_as_sc_mcu7t3v3__nor2_2
XTAP_TAPCELL_ROW_185_2072 VDD VSS gf180mcu_as_sc_mcu7t3v3__tap_2
XFILLER_223_42 VDD VDD VSS VSS gf180mcu_as_sc_mcu7t3v3__fill_2
XFILLER_80_1264 VDD VDD VSS VSS gf180mcu_as_sc_mcu7t3v3__fill_1
X_3156_ VDD VDD VSS VSS _6197_/Q _6195_/Q _6196_/Q _4214_/B gf180mcu_as_sc_mcu7t3v3__nor3_2
X_3087_ VDD VDD VSS VSS _5233_/A _5878_/B gf180mcu_as_sc_mcu7t3v3__inv_2
XTAP_TAPCELL_ROW_163_1680 VDD VSS gf180mcu_as_sc_mcu7t3v3__tap_2
XPHY_EDGE_ROW_53_2_Left_494 VDD VSS gf180mcu_as_sc_mcu7t3v3__tap_2
XFILLER_167_104 VDD VDD VSS VSS gf180mcu_as_sc_mcu7t3v3__fillcap_16
XFILLER_23_666 VDD VDD VSS VSS gf180mcu_as_sc_mcu7t3v3__fill_1
XFILLER_168_649 VDD VDD VSS VSS gf180mcu_as_sc_mcu7t3v3__fillcap_4
XFILLER_196_947 VDD VDD VSS VSS gf180mcu_as_sc_mcu7t3v3__fillcap_16
XFILLER_211_767 VDD VDD VSS VSS gf180mcu_as_sc_mcu7t3v3__fill_2
XFILLER_10_349 VDD VDD VSS VSS gf180mcu_as_sc_mcu7t3v3__fill_1
XFILLER_195_479 VDD VDD VSS VSS gf180mcu_as_sc_mcu7t3v3__fill_1
X_5728_ VDD VDD VSS VSS _5729_/C _5728_/A _5869_/B _5871_/B _5728_/D gf180mcu_as_sc_mcu7t3v3__aoi22_2
X_3989_ VDD VDD VSS VSS _4024_/D _4002_/B _4002_/C _6078_/Q _6078_/D gf180mcu_as_sc_mcu7t3v3__ao22_2
XFILLER_164_811 VDD VDD VSS VSS gf180mcu_as_sc_mcu7t3v3__fill_2
XFILLER_176_682 VDD VDD VSS VSS gf180mcu_as_sc_mcu7t3v3__fill_1
XFILLER_182_107 VDD VDD VSS VSS gf180mcu_as_sc_mcu7t3v3__fillcap_8
XFILLER_210_299 VDD VDD VSS VSS gf180mcu_as_sc_mcu7t3v3__fillcap_4
XFILLER_11_1030 VDD VDD VSS VSS gf180mcu_as_sc_mcu7t3v3__fillcap_16
X_5659_ VDD VDD VSS VSS _5668_/B _5659_/B _5659_/A gf180mcu_as_sc_mcu7t3v3__nor2b_2
XFILLER_11_1052 VDD VDD VSS VSS gf180mcu_as_sc_mcu7t3v3__fillcap_16
XFILLER_151_527 VDD VDD VSS VSS gf180mcu_as_sc_mcu7t3v3__fill_2
XFILLER_117_43 VDD VDD VSS VSS gf180mcu_as_sc_mcu7t3v3__fillcap_8
XFILLER_137_1210 VDD VDD VSS VSS gf180mcu_as_sc_mcu7t3v3__fillcap_4
XFILLER_172_1189 VDD VDD VSS VSS gf180mcu_as_sc_mcu7t3v3__fillcap_16
Xdelaybuf_0_clk VDD VDD VSS VSS clk delaybuf_1_clk/A gf180mcu_as_sc_mcu7t3v3__clkbuff_12
Xfanout830 VDD VDD VSS VSS _5202_/B _5221_/B gf180mcu_as_sc_mcu7t3v3__buff_12
Xfanout841 VDD VDD VSS VSS _4945_/C _4867_/D gf180mcu_as_sc_mcu7t3v3__buff_12
Xfanout852 VDD VDD VSS VSS _4572_/D _4243_/A gf180mcu_as_sc_mcu7t3v3__buff_12
XPHY_EDGE_ROW_117_1_Left_345 VDD VSS gf180mcu_as_sc_mcu7t3v3__tap_2
Xfanout863 VDD VDD VSS VSS _4620_/Y _4860_/B gf180mcu_as_sc_mcu7t3v3__buff_12
Xfanout885 VDD VDD VSS VSS _3300_/Y _4101_/S gf180mcu_as_sc_mcu7t3v3__buff_12
XFILLER_213_1186 VDD VDD VSS VSS gf180mcu_as_sc_mcu7t3v3__fillcap_4
Xfanout896 VDD VDD VSS VSS _6551_/Q _3357_/S gf180mcu_as_sc_mcu7t3v3__buff_12
XFILLER_206_506 VDD VDD VSS VSS gf180mcu_as_sc_mcu7t3v3__fillcap_16
XPHY_EDGE_ROW_121_1_Right_693 VDD VSS gf180mcu_as_sc_mcu7t3v3__tap_2
XTAP_TAPCELL_ROW_224_2776 VDD VSS gf180mcu_as_sc_mcu7t3v3__tap_2
XTAP_TAPCELL_ROW_224_2765 VDD VSS gf180mcu_as_sc_mcu7t3v3__tap_2
XFILLER_186_435 VDD VDD VSS VSS gf180mcu_as_sc_mcu7t3v3__fillcap_4
XFILLER_186_457 VDD VDD VSS VSS gf180mcu_as_sc_mcu7t3v3__fillcap_16
XFILLER_201_277 VDD VDD VSS VSS gf180mcu_as_sc_mcu7t3v3__fill_2
XFILLER_9_136 VDD VDD VSS VSS gf180mcu_as_sc_mcu7t3v3__fillcap_4
XFILLER_220_1135 VDD VDD VSS VSS gf180mcu_as_sc_mcu7t3v3__fillcap_16
XFILLER_220_1157 VDD VDD VSS VSS gf180mcu_as_sc_mcu7t3v3__fillcap_16
XFILLER_155_877 VDD VDD VSS VSS gf180mcu_as_sc_mcu7t3v3__fill_2
XFILLER_177_1012 VDD VDD VSS VSS gf180mcu_as_sc_mcu7t3v3__fillcap_16
XFILLER_154_387 VDD VDD VSS VSS gf180mcu_as_sc_mcu7t3v3__fill_2
XTAP_TAPCELL_ROW_73_2_2958 VDD VSS gf180mcu_as_sc_mcu7t3v3__tap_2
XPHY_EDGE_ROW_49_1_Left_277 VDD VSS gf180mcu_as_sc_mcu7t3v3__tap_2
XFILLER_228_108 VDD VDD VSS VSS gf180mcu_as_sc_mcu7t3v3__fill_2
XFILLER_7_1186 VDD VDD VSS VSS gf180mcu_as_sc_mcu7t3v3__fillcap_4
X_3010_ VDD VDD VSS VSS _3631_/A _5319_/A gf180mcu_as_sc_mcu7t3v3__inv_2
XFILLER_224_314 VDD VDD VSS VSS gf180mcu_as_sc_mcu7t3v3__fill_1
XFILLER_149_1158 VDD VDD VSS VSS gf180mcu_as_sc_mcu7t3v3__fillcap_16
XFILLER_184_1049 VDD VDD VSS VSS gf180mcu_as_sc_mcu7t3v3__fillcap_16
X_4961_ VDD VDD VSS VSS _5952_/A _4961_/B _4961_/C _4961_/D _4963_/C gf180mcu_as_sc_mcu7t3v3__ao211_2
XTAP_TAPCELL_ROW_4_1089 VDD VSS gf180mcu_as_sc_mcu7t3v3__tap_2
XTAP_TAPCELL_ROW_4_1078 VDD VSS gf180mcu_as_sc_mcu7t3v3__tap_2
XFILLER_189_240 VDD VDD VSS VSS gf180mcu_as_sc_mcu7t3v3__fill_1
X_4892_ VDD VDD VSS VSS _4893_/C _4892_/C _4964_/B _5882_/A gf180mcu_as_sc_mcu7t3v3__aoi21_2
X_3912_ VDD VDD VSS VSS _5892_/A _3912_/B _3912_/C _3912_/D _3913_/B gf180mcu_as_sc_mcu7t3v3__ao22_2
XFILLER_149_104 VDD VDD VSS VSS gf180mcu_as_sc_mcu7t3v3__fillcap_16
XFILLER_178_947 VDD VDD VSS VSS gf180mcu_as_sc_mcu7t3v3__fill_2
XFILLER_220_531 VDD VDD VSS VSS gf180mcu_as_sc_mcu7t3v3__fill_1
XFILLER_225_1046 VDD VDD VSS VSS gf180mcu_as_sc_mcu7t3v3__fillcap_4
XFILLER_225_1068 VDD VDD VSS VSS gf180mcu_as_sc_mcu7t3v3__fillcap_16
X_3843_ VDD VDD VSS VSS _5831_/A _3925_/C _3843_/C _3843_/D _3845_/C gf180mcu_as_sc_mcu7t3v3__ao211_2
XFILLER_193_928 VDD VDD VSS VSS gf180mcu_as_sc_mcu7t3v3__fillcap_16
XFILLER_164_107 VDD VDD VSS VSS gf180mcu_as_sc_mcu7t3v3__fillcap_16
X_3774_ VDD VDD VSS VSS _6505_/Q _3897_/B _3886_/C _5774_/B _3776_/C gf180mcu_as_sc_mcu7t3v3__ao22_2
XPHY_EDGE_ROW_116_3_Right_196 VDD VSS gf180mcu_as_sc_mcu7t3v3__tap_2
X_6493_ VDD VDD VSS VSS _6517_/CLK _6493_/D _6493_/Q gf180mcu_as_sc_mcu7t3v3__dfxtp_2
X_5513_ VDD VDD VSS VSS _5513_/B _5643_/A _6430_/D gf180mcu_as_sc_mcu7t3v3__and2_2
XFILLER_218_53 VDD VDD VSS VSS gf180mcu_as_sc_mcu7t3v3__fillcap_16
Xoutput411 VDD VDD VSS VSS _6376_/Q north_out[35] gf180mcu_as_sc_mcu7t3v3__buff_12
Xoutput400 VDD VDD VSS VSS _6366_/Q north_out[25] gf180mcu_as_sc_mcu7t3v3__buff_12
X_5444_ VDD VDD VSS VSS _5752_/D _5494_/B _5492_/B _5751_/A _5445_/C gf180mcu_as_sc_mcu7t3v3__ao22_2
XFILLER_161_836 VDD VDD VSS VSS gf180mcu_as_sc_mcu7t3v3__fillcap_4
XFILLER_218_97 VDD VDD VSS VSS gf180mcu_as_sc_mcu7t3v3__fill_1
Xoutput444 VDD VDD VSS VSS _6409_/Q south_out[32] gf180mcu_as_sc_mcu7t3v3__buff_12
Xoutput433 VDD VDD VSS VSS _6399_/Q south_out[22] gf180mcu_as_sc_mcu7t3v3__buff_12
Xoutput422 VDD VDD VSS VSS _6389_/Q south_out[12] gf180mcu_as_sc_mcu7t3v3__buff_12
XTAP_TAPCELL_ROW_187_2112 VDD VSS gf180mcu_as_sc_mcu7t3v3__tap_2
XTAP_TAPCELL_ROW_187_2101 VDD VSS gf180mcu_as_sc_mcu7t3v3__tap_2
Xoutput477 VDD VDD VSS VSS _6451_/Q west_out[2] gf180mcu_as_sc_mcu7t3v3__buff_12
Xoutput466 VDD VDD VSS VSS _6450_/Q west_out[1] gf180mcu_as_sc_mcu7t3v3__buff_12
Xoutput455 VDD VDD VSS VSS _6449_/Q west_out[0] gf180mcu_as_sc_mcu7t3v3__buff_12
X_5375_ VDD VDD VSS VSS _5377_/C _5682_/B _5491_/C _5375_/C gf180mcu_as_sc_mcu7t3v3__ao21_2
Xoutput488 VDD VDD VSS VSS _6456_/Q west_out[7] gf180mcu_as_sc_mcu7t3v3__buff_12
X_4326_ VDD VDD VSS VSS _4327_/C _4370_/S _6028_/Q gf180mcu_as_sc_mcu7t3v3__nor2b_2
XFILLER_228_620 VDD VDD VSS VSS gf180mcu_as_sc_mcu7t3v3__fill_1
X_4257_ VDD VDD VSS VSS _4281_/B _6156_/Q _4259_/C gf180mcu_as_sc_mcu7t3v3__or2_2
XTAP_TAPCELL_ROW_165_1720 VDD VSS gf180mcu_as_sc_mcu7t3v3__tap_2
X_4188_ VDD VDD VSS VSS _4283_/A _4216_/B _4196_/B _4188_/C _4189_/C gf180mcu_as_sc_mcu7t3v3__ao31_2
X_3208_ VDD VDD VSS VSS _6163_/Q _6136_/Q _3208_/A _3209_/D gf180mcu_as_sc_mcu7t3v3__mux2_2
X_3139_ VDD VDD VSS VSS _3163_/B _3426_/A gf180mcu_as_sc_mcu7t3v3__inv_2
XTAP_TAPCELL_ROW_206_2451 VDD VSS gf180mcu_as_sc_mcu7t3v3__tap_2
XFILLER_227_196 VDD VDD VSS VSS gf180mcu_as_sc_mcu7t3v3__fill_2
XTAP_TAPCELL_ROW_161_1639 VDD VSS gf180mcu_as_sc_mcu7t3v3__tap_2
XFILLER_15_419 VDD VDD VSS VSS gf180mcu_as_sc_mcu7t3v3__fill_1
XFILLER_63_49 VDD VDD VSS VSS gf180mcu_as_sc_mcu7t3v3__fill_2
XFILLER_179_27 VDD VDD VSS VSS gf180mcu_as_sc_mcu7t3v3__fillcap_16
XFILLER_144_6 VDD VDD VSS VSS gf180mcu_as_sc_mcu7t3v3__fillcap_16
XFILLER_204_1119 VDD VDD VSS VSS gf180mcu_as_sc_mcu7t3v3__fillcap_16
XFILLER_10_102 VDD VDD VSS VSS gf180mcu_as_sc_mcu7t3v3__fill_2
XFILLER_156_608 VDD VDD VSS VSS gf180mcu_as_sc_mcu7t3v3__fill_2
XFILLER_168_457 VDD VDD VSS VSS gf180mcu_as_sc_mcu7t3v3__fillcap_16
XFILLER_149_671 VDD VDD VSS VSS gf180mcu_as_sc_mcu7t3v3__fillcap_8
XFILLER_149_682 VDD VDD VSS VSS gf180mcu_as_sc_mcu7t3v3__fillcap_4
XFILLER_211_597 VDD VDD VSS VSS gf180mcu_as_sc_mcu7t3v3__fill_2
Xwire538 VDD VDD VSS VSS _5730_/B _5844_/B gf180mcu_as_sc_mcu7t3v3__clkbuff_12
XFILLER_183_449 VDD VDD VSS VSS gf180mcu_as_sc_mcu7t3v3__fill_1
XFILLER_6_139 VDD VDD VSS VSS gf180mcu_as_sc_mcu7t3v3__fillcap_16
XFILLER_164_663 VDD VDD VSS VSS gf180mcu_as_sc_mcu7t3v3__fill_2
XFILLER_152_847 VDD VDD VSS VSS gf180mcu_as_sc_mcu7t3v3__fillcap_4
XFILLER_144_30 VDD VDD VSS VSS gf180mcu_as_sc_mcu7t3v3__fillcap_4
XTAP_TAPCELL_ROW_226_2805 VDD VSS gf180mcu_as_sc_mcu7t3v3__tap_2
XFILLER_24_1210 VDD VDD VSS VSS gf180mcu_as_sc_mcu7t3v3__fillcap_8
Xfanout660 VDD VDD VSS VSS _5856_/B _5951_/D gf180mcu_as_sc_mcu7t3v3__buff_12
XTAP_TAPCELL_ROW_226_2816 VDD VSS gf180mcu_as_sc_mcu7t3v3__tap_2
Xfanout671 VDD VDD VSS VSS _5632_/C _5574_/C gf180mcu_as_sc_mcu7t3v3__buff_12
Xfanout682 VDD VDD VSS VSS _5314_/S _5226_/C gf180mcu_as_sc_mcu7t3v3__buff_12
Xfanout693 VDD VDD VSS VSS _4638_/Y _4856_/B gf180mcu_as_sc_mcu7t3v3__buff_12
XPHY_EDGE_ROW_122_1_Right_694 VDD VSS gf180mcu_as_sc_mcu7t3v3__tap_2
XFILLER_14_430 VDD VDD VSS VSS gf180mcu_as_sc_mcu7t3v3__fillcap_8
XFILLER_215_892 VDD VDD VSS VSS gf180mcu_as_sc_mcu7t3v3__fill_1
XFILLER_147_608 VDD VDD VSS VSS gf180mcu_as_sc_mcu7t3v3__fill_1
XFILLER_14_496 VDD VDD VSS VSS gf180mcu_as_sc_mcu7t3v3__fill_2
XFILLER_174_405 VDD VDD VSS VSS gf180mcu_as_sc_mcu7t3v3__fill_1
XFILLER_202_597 VDD VDD VSS VSS gf180mcu_as_sc_mcu7t3v3__fillcap_4
XFILLER_31_1214 VDD VDD VSS VSS gf180mcu_as_sc_mcu7t3v3__fill_1
XFILLER_70_1252 VDD VDD VSS VSS gf180mcu_as_sc_mcu7t3v3__fillcap_8
XTAP_TAPCELL_ROW_120_2_3028 VDD VSS gf180mcu_as_sc_mcu7t3v3__tap_2
X_3490_ VDD VDD VSS VSS _4632_/B _3637_/A _5946_/D _5953_/D _3638_/A gf180mcu_as_sc_mcu7t3v3__aoi22_2
XFILLER_182_471 VDD VDD VSS VSS gf180mcu_as_sc_mcu7t3v3__fillcap_8
Xclkbuf_leaf_14_clk_regs VDD VDD VSS VSS clkbuf_3_2_0_clk_regs/Y _6526_/CLK gf180mcu_as_sc_mcu7t3v3__clkbuff_12
X_5160_ VDD VDD VSS VSS _6510_/Q _5234_/B _5160_/C _5160_/D _5162_/C gf180mcu_as_sc_mcu7t3v3__ao22_2
X_5091_ VDD VDD VSS VSS _5091_/B _5091_/A _6386_/D gf180mcu_as_sc_mcu7t3v3__and2_2
X_4111_ VDD VDD VSS VSS _4113_/A _4112_/C _4112_/B _4480_/A gf180mcu_as_sc_mcu7t3v3__aoi21_2
XTAP_TAPCELL_ROW_182_2020 VDD VSS gf180mcu_as_sc_mcu7t3v3__tap_2
X_4042_ VDD VDD VSS VSS _4044_/B _6120_/Q _4043_/D gf180mcu_as_sc_mcu7t3v3__and2_2
XTAP_TAPCELL_ROW_6_1118 VDD VSS gf180mcu_as_sc_mcu7t3v3__tap_2
XTAP_TAPCELL_ROW_6_1129 VDD VSS gf180mcu_as_sc_mcu7t3v3__tap_2
XFILLER_92_661 VDD VDD VSS VSS gf180mcu_as_sc_mcu7t3v3__fillcap_4
Xmesh_tile_1070 VDD VDD VSS VSS ne_out[29] gf180mcu_as_sc_mcu7t3v3__tiel_4
Xmesh_tile_1092 VDD VDD VSS VSS nw_out[15] gf180mcu_as_sc_mcu7t3v3__tiel_4
Xmesh_tile_1081 VDD VDD VSS VSS nw_out[4] gf180mcu_as_sc_mcu7t3v3__tiel_4
X_5993_ VDD VDD VSS VSS _6006_/B _6216_/Q _6506_/D gf180mcu_as_sc_mcu7t3v3__and2_2
XFILLER_224_177 VDD VDD VSS VSS gf180mcu_as_sc_mcu7t3v3__fillcap_4
X_4944_ VDD VDD VSS VSS _4955_/C _5939_/D _4949_/C gf180mcu_as_sc_mcu7t3v3__and2_2
XPHY_EDGE_ROW_25_3_Left_730 VDD VSS gf180mcu_as_sc_mcu7t3v3__tap_2
X_4875_ VDD VDD VSS VSS _4879_/B _4875_/B _5872_/A gf180mcu_as_sc_mcu7t3v3__nand2_2
XFILLER_177_265 VDD VDD VSS VSS gf180mcu_as_sc_mcu7t3v3__fillcap_4
XFILLER_192_202 VDD VDD VSS VSS gf180mcu_as_sc_mcu7t3v3__fill_1
X_3826_ VDD VDD VSS VSS _5817_/D _3891_/B _3826_/C _3826_/D _3828_/C gf180mcu_as_sc_mcu7t3v3__ao211_2
XFILLER_165_438 VDD VDD VSS VSS gf180mcu_as_sc_mcu7t3v3__fill_1
XTAP_TAPCELL_ROW_158_1590 VDD VSS gf180mcu_as_sc_mcu7t3v3__tap_2
X_6545_ VDD VDD VSS VSS _6546_/CLK _6545_/D _6545_/Q gf180mcu_as_sc_mcu7t3v3__dfxtp_2
X_3757_ VDD VDD VSS VSS _5758_/A _3757_/B _3757_/C _3757_/D _3759_/C gf180mcu_as_sc_mcu7t3v3__ao211_2
XPHY_EDGE_ROW_117_3_Right_197 VDD VSS gf180mcu_as_sc_mcu7t3v3__tap_2
X_6476_ VDD VDD VSS VSS _6484_/CLK _6476_/D _6476_/Q gf180mcu_as_sc_mcu7t3v3__dfxtp_2
X_3688_ VDD VDD VSS VSS _5029_/A _3905_/B _3905_/C _3690_/C gf180mcu_as_sc_mcu7t3v3__nor3_2
XFILLER_47_1210 VDD VDD VSS VSS gf180mcu_as_sc_mcu7t3v3__fillcap_4
X_5427_ VDD VDD VSS VSS _5734_/A _5639_/B _5427_/C _5427_/D _5429_/C gf180mcu_as_sc_mcu7t3v3__ao211_2
XFILLER_173_1240 VDD VDD VSS VSS gf180mcu_as_sc_mcu7t3v3__fillcap_16
XFILLER_173_1262 VDD VDD VSS VSS gf180mcu_as_sc_mcu7t3v3__fill_2
X_5358_ VDD VDD VSS VSS _5358_/A _5369_/B _5358_/C _5358_/Y gf180mcu_as_sc_mcu7t3v3__nor3_2
XFILLER_0_849 VDD VDD VSS VSS gf180mcu_as_sc_mcu7t3v3__fill_1
XFILLER_58_49 VDD VDD VSS VSS gf180mcu_as_sc_mcu7t3v3__fill_2
X_4309_ VDD VDD VSS VSS _4311_/A _4309_/C _4407_/B _6147_/Q gf180mcu_as_sc_mcu7t3v3__aoi21_2
Xwire1016 VDD VDD VSS VSS wire1016/A _5699_/B gf180mcu_as_sc_mcu7t3v3__clkbuff_12
X_5289_ VDD VDD VSS VSS _5927_/A _5306_/B _5289_/C _5289_/D _5290_/A gf180mcu_as_sc_mcu7t3v3__ao211_2
XFILLER_216_601 VDD VDD VSS VSS gf180mcu_as_sc_mcu7t3v3__fill_1
XFILLER_74_37 VDD VDD VSS VSS gf180mcu_as_sc_mcu7t3v3__fillcap_8
XFILLER_83_661 VDD VDD VSS VSS gf180mcu_as_sc_mcu7t3v3__fill_1
XTAP_TAPCELL_ROW_221_2724 VDD VSS gf180mcu_as_sc_mcu7t3v3__tap_2
XTAP_TAPCELL_ROW_221_2713 VDD VSS gf180mcu_as_sc_mcu7t3v3__tap_2
XFILLER_167_1044 VDD VDD VSS VSS gf180mcu_as_sc_mcu7t3v3__fillcap_4
XFILLER_210_1189 VDD VDD VSS VSS gf180mcu_as_sc_mcu7t3v3__fillcap_16
XFILLER_215_122 VDD VDD VSS VSS gf180mcu_as_sc_mcu7t3v3__fillcap_4
XFILLER_216_667 VDD VDD VSS VSS gf180mcu_as_sc_mcu7t3v3__fillcap_8
XFILLER_11_411 VDD VDD VSS VSS gf180mcu_as_sc_mcu7t3v3__fill_2
XFILLER_169_766 VDD VDD VSS VSS gf180mcu_as_sc_mcu7t3v3__fill_1
XTAP_TAPCELL_ROW_178_1944 VDD VSS gf180mcu_as_sc_mcu7t3v3__tap_2
XFILLER_11_444 VDD VDD VSS VSS gf180mcu_as_sc_mcu7t3v3__fillcap_4
XFILLER_11_455 VDD VDD VSS VSS gf180mcu_as_sc_mcu7t3v3__fill_2
XFILLER_156_405 VDD VDD VSS VSS gf180mcu_as_sc_mcu7t3v3__fill_2
XFILLER_211_372 VDD VDD VSS VSS gf180mcu_as_sc_mcu7t3v3__fill_1
XTAP_TAPCELL_ROW_219_2686 VDD VSS gf180mcu_as_sc_mcu7t3v3__tap_2
XTAP_TAPCELL_ROW_219_2675 VDD VSS gf180mcu_as_sc_mcu7t3v3__tap_2
XFILLER_168_298 VDD VDD VSS VSS gf180mcu_as_sc_mcu7t3v3__fill_1
XFILLER_184_747 VDD VDD VSS VSS gf180mcu_as_sc_mcu7t3v3__fillcap_4
XPHY_EDGE_ROW_12_Left_241 VDD VSS gf180mcu_as_sc_mcu7t3v3__tap_2
XFILLER_171_419 VDD VDD VSS VSS gf180mcu_as_sc_mcu7t3v3__fill_1
XFILLER_183_257 VDD VDD VSS VSS gf180mcu_as_sc_mcu7t3v3__fill_2
XFILLER_183_279 VDD VDD VSS VSS gf180mcu_as_sc_mcu7t3v3__fill_1
XFILLER_178_1151 VDD VDD VSS VSS gf180mcu_as_sc_mcu7t3v3__fillcap_4
XFILLER_178_1173 VDD VDD VSS VSS gf180mcu_as_sc_mcu7t3v3__fillcap_16
XFILLER_3_632 VDD VDD VSS VSS gf180mcu_as_sc_mcu7t3v3__fill_2
XFILLER_219_1170 VDD VDD VSS VSS gf180mcu_as_sc_mcu7t3v3__fillcap_16
XFILLER_219_1192 VDD VDD VSS VSS gf180mcu_as_sc_mcu7t3v3__fillcap_16
XPHY_EDGE_ROW_130_2_Left_571 VDD VSS gf180mcu_as_sc_mcu7t3v3__tap_2
XFILLER_171_72 VDD VDD VSS VSS gf180mcu_as_sc_mcu7t3v3__fillcap_16
XFILLER_0_1009 VDD VDD VSS VSS gf180mcu_as_sc_mcu7t3v3__fillcap_4
XFILLER_150_1081 VDD VDD VSS VSS gf180mcu_as_sc_mcu7t3v3__fillcap_4
XFILLER_185_1100 VDD VDD VSS VSS gf180mcu_as_sc_mcu7t3v3__fillcap_16
XFILLER_185_1122 VDD VDD VSS VSS gf180mcu_as_sc_mcu7t3v3__fillcap_16
XFILLER_4_1189 VDD VDD VSS VSS gf180mcu_as_sc_mcu7t3v3__fillcap_16
XFILLER_206_177 VDD VDD VSS VSS gf180mcu_as_sc_mcu7t3v3__fillcap_16
XPHY_EDGE_ROW_123_1_Right_695 VDD VSS gf180mcu_as_sc_mcu7t3v3__tap_2
XTAP_TAPCELL_ROW_1_1037 VDD VSS gf180mcu_as_sc_mcu7t3v3__tap_2
XTAP_TAPCELL_ROW_1_1026 VDD VSS gf180mcu_as_sc_mcu7t3v3__tap_2
XFILLER_15_772 VDD VDD VSS VSS gf180mcu_as_sc_mcu7t3v3__fillcap_16
XFILLER_159_276 VDD VDD VSS VSS gf180mcu_as_sc_mcu7t3v3__fillcap_4
XFILLER_203_895 VDD VDD VSS VSS gf180mcu_as_sc_mcu7t3v3__fill_2
XFILLER_222_1049 VDD VDD VSS VSS gf180mcu_as_sc_mcu7t3v3__fillcap_16
X_4660_ VDD VDD VSS VSS _6341_/D _4660_/C _4950_/D _5679_/A gf180mcu_as_sc_mcu7t3v3__aoi21b_2
XFILLER_159_298 VDD VDD VSS VSS gf180mcu_as_sc_mcu7t3v3__fillcap_16
X_3611_ VDD VDD VSS VSS _3656_/A _3611_/B _3656_/C _3612_/B _3655_/C gf180mcu_as_sc_mcu7t3v3__ao211_2
XFILLER_7_960 VDD VDD VSS VSS gf180mcu_as_sc_mcu7t3v3__fillcap_16
XTAP_TAPCELL_ROW_138_2_3055 VDD VSS gf180mcu_as_sc_mcu7t3v3__tap_2
X_6330_ VDD VDD VSS VSS _6552_/CLK _6330_/D _6330_/Q gf180mcu_as_sc_mcu7t3v3__dfxtp_2
X_4591_ VDD VDD VSS VSS _4592_/B _6334_/Q _4595_/B gf180mcu_as_sc_mcu7t3v3__and2_2
XFILLER_157_1224 VDD VDD VSS VSS gf180mcu_as_sc_mcu7t3v3__fillcap_16
XFILLER_7_982 VDD VDD VSS VSS gf180mcu_as_sc_mcu7t3v3__fillcap_16
Xwire880 VDD VDD VSS VSS _3365_/Y _6716_/A gf180mcu_as_sc_mcu7t3v3__clkbuff_12
X_3542_ VDD VDD VSS VSS _4615_/C _3542_/B _5301_/A gf180mcu_as_sc_mcu7t3v3__nor2b_2
XFILLER_143_655 VDD VDD VSS VSS gf180mcu_as_sc_mcu7t3v3__fillcap_4
XFILLER_143_666 VDD VDD VSS VSS gf180mcu_as_sc_mcu7t3v3__fill_1
X_6261_ VDD VDD VSS VSS clkload9/A _6261_/D _6261_/Q gf180mcu_as_sc_mcu7t3v3__dfxtp_2
X_3473_ VDD VDD VSS VSS _3473_/B _5350_/A _5350_/D gf180mcu_as_sc_mcu7t3v3__and2_2
X_6192_ VDD VDD VSS VSS _6486_/CLK _6192_/D _6192_/Q gf180mcu_as_sc_mcu7t3v3__dfxtp_2
X_5212_ VDD VDD VSS VSS _5221_/B _5863_/A _5213_/C gf180mcu_as_sc_mcu7t3v3__and2_2
XFILLER_170_496 VDD VDD VSS VSS gf180mcu_as_sc_mcu7t3v3__fillcap_4
XFILLER_215_43 VDD VDD VSS VSS gf180mcu_as_sc_mcu7t3v3__fillcap_16
X_5143_ VDD VDD VSS VSS _5802_/D _5143_/B _5143_/C _5801_/B _5144_/D gf180mcu_as_sc_mcu7t3v3__ao22_2
XFILLER_111_596 VDD VDD VSS VSS gf180mcu_as_sc_mcu7t3v3__fill_1
X_5074_ VDD VDD VSS VSS _5074_/D _5743_/A _5139_/B _5139_/C _5075_/C gf180mcu_as_sc_mcu7t3v3__ao31_2
X_4025_ VDD VDD VSS VSS _4060_/B _6108_/Q _4026_/D gf180mcu_as_sc_mcu7t3v3__and2_2
XFILLER_65_661 VDD VDD VSS VSS gf180mcu_as_sc_mcu7t3v3__fill_1
XFILLER_198_839 VDD VDD VSS VSS gf180mcu_as_sc_mcu7t3v3__fill_2
XFILLER_212_114 VDD VDD VSS VSS gf180mcu_as_sc_mcu7t3v3__fillcap_4
X_5976_ VDD VDD VSS VSS _6491_/D _5976_/B _5976_/A gf180mcu_as_sc_mcu7t3v3__nor2_2
XTAP_TAPCELL_ROW_195_2244 VDD VSS gf180mcu_as_sc_mcu7t3v3__tap_2
XFILLER_212_158 VDD VDD VSS VSS gf180mcu_as_sc_mcu7t3v3__fill_2
X_4927_ VDD VDD VSS VSS _5916_/A _4957_/B _4927_/C _4928_/C _4950_/D gf180mcu_as_sc_mcu7t3v3__aoi211_2
XTAP_TAPCELL_ROW_195_2255 VDD VSS gf180mcu_as_sc_mcu7t3v3__tap_2
Xsram2048.u_bank0_1029 VDD VDD VSS VSS sram2048.u_bank0/WEN[3] gf180mcu_as_sc_mcu7t3v3__tiel_4
X_4858_ VDD VDD VSS VSS _5856_/A _4858_/B _4858_/C _4867_/D _4861_/C gf180mcu_as_sc_mcu7t3v3__ao211_2
XPHY_EDGE_ROW_126_1_Left_354 VDD VSS gf180mcu_as_sc_mcu7t3v3__tap_2
XTAP_TAPCELL_ROW_156_1549 VDD VSS gf180mcu_as_sc_mcu7t3v3__tap_2
X_3809_ VDD VDD VSS VSS _3810_/D _3809_/B _5802_/A gf180mcu_as_sc_mcu7t3v3__nand2b_2
XFILLER_101_1212 VDD VDD VSS VSS gf180mcu_as_sc_mcu7t3v3__fill_1
XFILLER_119_652 VDD VDD VSS VSS gf180mcu_as_sc_mcu7t3v3__fill_2
XFILLER_14_1264 VDD VDD VSS VSS gf180mcu_as_sc_mcu7t3v3__fill_1
XFILLER_165_279 VDD VDD VSS VSS gf180mcu_as_sc_mcu7t3v3__fill_1
XTAP_TAPCELL_ROW_173_1852 VDD VSS gf180mcu_as_sc_mcu7t3v3__tap_2
XTAP_TAPCELL_ROW_173_1863 VDD VSS gf180mcu_as_sc_mcu7t3v3__tap_2
X_4789_ VDD VDD VSS VSS _4789_/B _5238_/A _6355_/D gf180mcu_as_sc_mcu7t3v3__and2_2
X_6528_ VDD VDD VSS VSS clkload7/A _6528_/Q _6528_/RN _4826_/A _6528_/D gf180mcu_as_sc_mcu7t3v3__dfsrtp_2
XFILLER_161_430 VDD VDD VSS VSS gf180mcu_as_sc_mcu7t3v3__fillcap_4
XFILLER_69_48 VDD VDD VSS VSS gf180mcu_as_sc_mcu7t3v3__fill_2
XPHY_EDGE_ROW_118_3_Right_198 VDD VSS gf180mcu_as_sc_mcu7t3v3__tap_2
X_6459_ VDD VDD VSS VSS _6474_/CLK _6459_/D _6459_/Q gf180mcu_as_sc_mcu7t3v3__dfxtp_2
XTAP_TAPCELL_ROW_214_2594 VDD VSS gf180mcu_as_sc_mcu7t3v3__tap_2
XFILLER_161_485 VDD VDD VSS VSS gf180mcu_as_sc_mcu7t3v3__fillcap_4
XFILLER_125_43 VDD VDD VSS VSS gf180mcu_as_sc_mcu7t3v3__fillcap_8
XFILLER_228_280 VDD VDD VSS VSS gf180mcu_as_sc_mcu7t3v3__fill_1
XFILLER_216_486 VDD VDD VSS VSS gf180mcu_as_sc_mcu7t3v3__fill_1
XFILLER_217_998 VDD VDD VSS VSS gf180mcu_as_sc_mcu7t3v3__fillcap_16
XFILLER_189_839 VDD VDD VSS VSS gf180mcu_as_sc_mcu7t3v3__fill_1
XFILLER_204_648 VDD VDD VSS VSS gf180mcu_as_sc_mcu7t3v3__fill_2
XFILLER_71_664 VDD VDD VSS VSS gf180mcu_as_sc_mcu7t3v3__fill_2
XFILLER_12_731 VDD VDD VSS VSS gf180mcu_as_sc_mcu7t3v3__fillcap_4
XPHY_EDGE_ROW_58_1_Left_286 VDD VSS gf180mcu_as_sc_mcu7t3v3__tap_2
XFILLER_7_212 VDD VDD VSS VSS gf180mcu_as_sc_mcu7t3v3__fillcap_16
XFILLER_156_279 VDD VDD VSS VSS gf180mcu_as_sc_mcu7t3v3__fillcap_16
XFILLER_125_666 VDD VDD VSS VSS gf180mcu_as_sc_mcu7t3v3__fill_1
XFILLER_166_94 VDD VDD VSS VSS gf180mcu_as_sc_mcu7t3v3__fillcap_8
XFILLER_4_963 VDD VDD VSS VSS gf180mcu_as_sc_mcu7t3v3__fillcap_16
XFILLER_140_614 VDD VDD VSS VSS gf180mcu_as_sc_mcu7t3v3__fillcap_8
XFILLER_191_1170 VDD VDD VSS VSS gf180mcu_as_sc_mcu7t3v3__fillcap_16
XFILLER_191_1192 VDD VDD VSS VSS gf180mcu_as_sc_mcu7t3v3__fillcap_16
XFILLER_208_943 VDD VDD VSS VSS gf180mcu_as_sc_mcu7t3v3__fill_2
XPHY_EDGE_ROW_124_1_Right_696 VDD VSS gf180mcu_as_sc_mcu7t3v3__tap_2
X_5830_ VDD VDD VSS VSS _5862_/S _5830_/B _6512_/Q _5831_/C gf180mcu_as_sc_mcu7t3v3__mux2_2
XFILLER_179_349 VDD VDD VSS VSS gf180mcu_as_sc_mcu7t3v3__fill_1
X_5761_ VDD VDD VSS VSS _5762_/C _5761_/A _5858_/B _5856_/B _5761_/D gf180mcu_as_sc_mcu7t3v3__aoi22_2
X_4712_ VDD VDD VSS VSS _4880_/B _6499_/Q _4713_/D gf180mcu_as_sc_mcu7t3v3__and2_2
XFILLER_124_1245 VDD VDD VSS VSS gf180mcu_as_sc_mcu7t3v3__fillcap_16
X_5692_ VDD VDD VSS VSS _5692_/A _5800_/B _5692_/C _5692_/D _5694_/C gf180mcu_as_sc_mcu7t3v3__ao211_2
XTAP_TAPCELL_ROW_79_2_2967 VDD VSS gf180mcu_as_sc_mcu7t3v3__tap_2
XFILLER_190_503 VDD VDD VSS VSS gf180mcu_as_sc_mcu7t3v3__fill_2
X_4643_ VDD VDD VSS VSS _4839_/B _4746_/B _4840_/B gf180mcu_as_sc_mcu7t3v3__nand2b_2
XTAP_TAPCELL_ROW_190_2163 VDD VSS gf180mcu_as_sc_mcu7t3v3__tap_2
X_4574_ VDD VDD VSS VSS _4575_/B _4574_/C _4574_/B _6313_/Q gf180mcu_as_sc_mcu7t3v3__aoi21_2
XFILLER_116_644 VDD VDD VSS VSS gf180mcu_as_sc_mcu7t3v3__fill_2
XFILLER_196_1081 VDD VDD VSS VSS gf180mcu_as_sc_mcu7t3v3__fillcap_4
X_6313_ VDD VDD VSS VSS _6313_/CLK _6313_/D _6313_/Q gf180mcu_as_sc_mcu7t3v3__dfxtp_2
X_3525_ VDD VDD VSS VSS _5335_/B _5319_/A _5920_/A gf180mcu_as_sc_mcu7t3v3__nand2b_2
XFILLER_226_53 VDD VDD VSS VSS gf180mcu_as_sc_mcu7t3v3__fill_2
XTAP_TAPCELL_ROW_151_1457 VDD VSS gf180mcu_as_sc_mcu7t3v3__tap_2
XTAP_TAPCELL_ROW_151_1468 VDD VSS gf180mcu_as_sc_mcu7t3v3__tap_2
X_6244_ VDD VDD VSS VSS _6531_/CLK _6244_/D _6244_/Q gf180mcu_as_sc_mcu7t3v3__dfxtp_2
XFILLER_131_658 VDD VDD VSS VSS gf180mcu_as_sc_mcu7t3v3__fillcap_4
XPHY_EDGE_ROW_100_2_Right_937 VDD VSS gf180mcu_as_sc_mcu7t3v3__tap_2
X_3456_ VDD VDD VSS VSS _4585_/A _3456_/B _6321_/Q _6320_/D gf180mcu_as_sc_mcu7t3v3__mux2_2
XFILLER_170_1221 VDD VDD VSS VSS gf180mcu_as_sc_mcu7t3v3__fillcap_4
XFILLER_170_1243 VDD VDD VSS VSS gf180mcu_as_sc_mcu7t3v3__fillcap_16
X_6175_ VDD VDD VSS VSS _6486_/CLK _6175_/D _6175_/Q gf180mcu_as_sc_mcu7t3v3__dfxtp_2
X_3387_ VDD VDD VSS VSS _4511_/A _3391_/B _3387_/C _3391_/C _3438_/C gf180mcu_as_sc_mcu7t3v3__ao211_2
XFILLER_218_718 VDD VDD VSS VSS gf180mcu_as_sc_mcu7t3v3__fillcap_4
X_5126_ VDD VDD VSS VSS _5127_/A _5786_/A _5144_/B _5126_/C gf180mcu_as_sc_mcu7t3v3__ao21_2
XTAP_TAPCELL_ROW_149_1397 VDD VSS gf180mcu_as_sc_mcu7t3v3__tap_2
X_5057_ VDD VDD VSS VSS _5059_/C _5224_/B _5724_/B gf180mcu_as_sc_mcu7t3v3__nand2b_2
XFILLER_211_1262 VDD VDD VSS VSS gf180mcu_as_sc_mcu7t3v3__fill_2
X_4008_ VDD VDD VSS VSS _4053_/B _4008_/B _4008_/C _6096_/Q _6096_/D gf180mcu_as_sc_mcu7t3v3__ao22_2
XFILLER_164_1014 VDD VDD VSS VSS gf180mcu_as_sc_mcu7t3v3__fill_1
XFILLER_53_664 VDD VDD VSS VSS gf180mcu_as_sc_mcu7t3v3__fill_2
XTAP_TAPCELL_ROW_10_1188 VDD VSS gf180mcu_as_sc_mcu7t3v3__tap_2
XTAP_TAPCELL_ROW_10_1199 VDD VSS gf180mcu_as_sc_mcu7t3v3__tap_2
XFILLER_197_135 VDD VDD VSS VSS gf180mcu_as_sc_mcu7t3v3__fillcap_4
XFILLER_197_146 VDD VDD VSS VSS gf180mcu_as_sc_mcu7t3v3__fill_1
XFILLER_214_979 VDD VDD VSS VSS gf180mcu_as_sc_mcu7t3v3__fillcap_16
X_5959_ VDD VDD VSS VSS _5959_/B _5960_/B _6485_/D gf180mcu_as_sc_mcu7t3v3__and2_2
XFILLER_187_27 VDD VDD VSS VSS gf180mcu_as_sc_mcu7t3v3__fillcap_8
XFILLER_213_489 VDD VDD VSS VSS gf180mcu_as_sc_mcu7t3v3__fill_1
XFILLER_71_49 VDD VDD VSS VSS gf180mcu_as_sc_mcu7t3v3__fill_2
XTAP_TAPCELL_ROW_216_2634 VDD VSS gf180mcu_as_sc_mcu7t3v3__tap_2
XTAP_TAPCELL_ROW_216_2623 VDD VSS gf180mcu_as_sc_mcu7t3v3__tap_2
XFILLER_166_577 VDD VDD VSS VSS gf180mcu_as_sc_mcu7t3v3__fill_2
XFILLER_193_352 VDD VDD VSS VSS gf180mcu_as_sc_mcu7t3v3__fillcap_8
XFILLER_21_594 VDD VDD VSS VSS gf180mcu_as_sc_mcu7t3v3__fill_2
XTAP_TAPCELL_ROW_31_2_2895 VDD VSS gf180mcu_as_sc_mcu7t3v3__tap_2
XFILLER_5_727 VDD VDD VSS VSS gf180mcu_as_sc_mcu7t3v3__fillcap_4
XFILLER_107_666 VDD VDD VSS VSS gf180mcu_as_sc_mcu7t3v3__fill_1
XFILLER_122_614 VDD VDD VSS VSS gf180mcu_as_sc_mcu7t3v3__fill_2
XFILLER_161_260 VDD VDD VSS VSS gf180mcu_as_sc_mcu7t3v3__fillcap_16
XFILLER_175_1154 VDD VDD VSS VSS gf180mcu_as_sc_mcu7t3v3__fillcap_16
XPHY_EDGE_ROW_119_3_Right_199 VDD VSS gf180mcu_as_sc_mcu7t3v3__tap_2
XFILLER_161_282 VDD VDD VSS VSS gf180mcu_as_sc_mcu7t3v3__fillcap_16
XFILLER_216_1151 VDD VDD VSS VSS gf180mcu_as_sc_mcu7t3v3__fillcap_4
XFILLER_216_1173 VDD VDD VSS VSS gf180mcu_as_sc_mcu7t3v3__fillcap_16
Xinput300 VDD VDD VSS VSS sw_in[7] _5737_/A gf180mcu_as_sc_mcu7t3v3__buff_12
Xinput311 VDD VDD VSS VSS west_in[17] _5816_/A gf180mcu_as_sc_mcu7t3v3__buff_12
XFILLER_88_594 VDD VDD VSS VSS gf180mcu_as_sc_mcu7t3v3__fill_1
Xinput322 VDD VDD VSS VSS west_in[27] _5895_/A gf180mcu_as_sc_mcu7t3v3__buff_12
Xinput333 VDD VDD VSS VSS west_in[4] _5709_/A gf180mcu_as_sc_mcu7t3v3__buff_12
XFILLER_5_1240 VDD VDD VSS VSS gf180mcu_as_sc_mcu7t3v3__fillcap_16
XFILLER_152_85 VDD VDD VSS VSS gf180mcu_as_sc_mcu7t3v3__fillcap_16
XFILLER_29_661 VDD VDD VSS VSS gf180mcu_as_sc_mcu7t3v3__fill_1
XFILLER_5_1262 VDD VDD VSS VSS gf180mcu_as_sc_mcu7t3v3__fill_2
XFILLER_182_1103 VDD VDD VSS VSS gf180mcu_as_sc_mcu7t3v3__fillcap_16
XFILLER_204_412 VDD VDD VSS VSS gf180mcu_as_sc_mcu7t3v3__fill_1
XFILLER_223_1100 VDD VDD VSS VSS gf180mcu_as_sc_mcu7t3v3__fillcap_16
XFILLER_169_360 VDD VDD VSS VSS gf180mcu_as_sc_mcu7t3v3__fillcap_4
XFILLER_188_168 VDD VDD VSS VSS gf180mcu_as_sc_mcu7t3v3__fillcap_4
XFILLER_223_1122 VDD VDD VSS VSS gf180mcu_as_sc_mcu7t3v3__fillcap_16
XFILLER_157_544 VDD VDD VSS VSS gf180mcu_as_sc_mcu7t3v3__fillcap_8
XFILLER_200_695 VDD VDD VSS VSS gf180mcu_as_sc_mcu7t3v3__fillcap_8
XANTENNA_4 VDD VDD VSS VSS _6373_/D gf180mcu_as_sc_mcu7t3v3__diode_2
XFILLER_153_772 VDD VDD VSS VSS gf180mcu_as_sc_mcu7t3v3__fill_1
XFILLER_154_1205 VDD VDD VSS VSS gf180mcu_as_sc_mcu7t3v3__fillcap_16
XFILLER_193_1232 VDD VDD VSS VSS gf180mcu_as_sc_mcu7t3v3__fill_2
X_3310_ VDD VDD VSS VSS _3332_/A _3310_/B _3310_/C _3310_/D _3310_/Y gf180mcu_as_sc_mcu7t3v3__ao22_2
X_4290_ VDD VDD VSS VSS _6209_/D _4290_/B _4290_/A gf180mcu_as_sc_mcu7t3v3__nand2_2
XFILLER_193_92 VDD VDD VSS VSS gf180mcu_as_sc_mcu7t3v3__fill_1
X_3241_ VDD VDD VSS VSS _3241_/S _3241_/B _3241_/A _3243_/A gf180mcu_as_sc_mcu7t3v3__mux2_2
X_3172_ VDD VDD VSS VSS _3173_/B _4579_/D _3172_/B _3172_/A gf180mcu_as_sc_mcu7t3v3__aoi21_2
XFILLER_187_1014 VDD VDD VSS VSS gf180mcu_as_sc_mcu7t3v3__fillcap_16
XFILLER_228_1033 VDD VDD VSS VSS gf180mcu_as_sc_mcu7t3v3__fillcap_4
XFILLER_35_664 VDD VDD VSS VSS gf180mcu_as_sc_mcu7t3v3__fill_2
XFILLER_179_135 VDD VDD VSS VSS gf180mcu_as_sc_mcu7t3v3__fillcap_4
XFILLER_223_787 VDD VDD VSS VSS gf180mcu_as_sc_mcu7t3v3__fillcap_4
XTAP_TAPCELL_ROW_126_2_3037 VDD VSS gf180mcu_as_sc_mcu7t3v3__tap_2
X_5813_ VDD VDD VSS VSS _5861_/B _5813_/A _5816_/C gf180mcu_as_sc_mcu7t3v3__and2_2
XFILLER_210_437 VDD VDD VSS VSS gf180mcu_as_sc_mcu7t3v3__fillcap_4
XPHY_EDGE_ROW_125_1_Right_697 VDD VSS gf180mcu_as_sc_mcu7t3v3__tap_2
XTAP_TAPCELL_ROW_192_2203 VDD VSS gf180mcu_as_sc_mcu7t3v3__tap_2
XFILLER_194_138 VDD VDD VSS VSS gf180mcu_as_sc_mcu7t3v3__fillcap_8
X_5744_ VDD VDD VSS VSS _5744_/A _5802_/C _5744_/C _5744_/D _5745_/C gf180mcu_as_sc_mcu7t3v3__ao211_2
XFILLER_175_352 VDD VDD VSS VSS gf180mcu_as_sc_mcu7t3v3__fillcap_8
XFILLER_202_1239 VDD VDD VSS VSS gf180mcu_as_sc_mcu7t3v3__fill_1
X_5675_ VDD VDD VSS VSS _5871_/D _5675_/B _5871_/B _5675_/D _5677_/C gf180mcu_as_sc_mcu7t3v3__ao22_2
XFILLER_159_1116 VDD VDD VSS VSS gf180mcu_as_sc_mcu7t3v3__fillcap_4
XFILLER_191_812 VDD VDD VSS VSS gf180mcu_as_sc_mcu7t3v3__fill_2
XFILLER_50_1261 VDD VDD VSS VSS gf180mcu_as_sc_mcu7t3v3__fillcap_4
XTAP_TAPCELL_ROW_170_1800 VDD VSS gf180mcu_as_sc_mcu7t3v3__tap_2
X_4626_ VDD VDD VSS VSS _5336_/B _5950_/D _4626_/B _4626_/C gf180mcu_as_sc_mcu7t3v3__maj3_2
XFILLER_11_1256 VDD VDD VSS VSS gf180mcu_as_sc_mcu7t3v3__fillcap_4
XFILLER_159_1138 VDD VDD VSS VSS gf180mcu_as_sc_mcu7t3v3__fillcap_16
XFILLER_190_377 VDD VDD VSS VSS gf180mcu_as_sc_mcu7t3v3__fillcap_8
X_4557_ VDD VDD VSS VSS _4579_/A _4579_/B _4579_/D _4557_/D _4569_/C gf180mcu_as_sc_mcu7t3v3__ao211_2
XTAP_TAPCELL_ROW_211_2542 VDD VSS gf180mcu_as_sc_mcu7t3v3__tap_2
XTAP_TAPCELL_ROW_211_2531 VDD VSS gf180mcu_as_sc_mcu7t3v3__tap_2
X_4488_ VDD VDD VSS VSS _6280_/D _6280_/Q _4503_/C _4488_/C gf180mcu_as_sc_mcu7t3v3__ao21_2
X_3508_ VDD VDD VSS VSS _4624_/A _4624_/B _4968_/B _3508_/D _3510_/C gf180mcu_as_sc_mcu7t3v3__nand4_2
XFILLER_106_45 VDD VDD VSS VSS gf180mcu_as_sc_mcu7t3v3__fillcap_4
XTAP_TAPCELL_ROW_16_1320 VDD VSS gf180mcu_as_sc_mcu7t3v3__tap_2
X_6227_ VDD VDD VSS VSS _6316_/CLK _6227_/D _6227_/Q gf180mcu_as_sc_mcu7t3v3__dfxtp_2
X_3439_ VDD VDD VSS VSS _6529_/D _3439_/C _4103_/A _4610_/C gf180mcu_as_sc_mcu7t3v3__aoi21b_2
XPHY_EDGE_ROW_101_2_Right_938 VDD VSS gf180mcu_as_sc_mcu7t3v3__tap_2
XTAP_TAPCELL_ROW_168_1762 VDD VSS gf180mcu_as_sc_mcu7t3v3__tap_2
X_6158_ VDD VDD VSS VSS _6546_/CLK _6158_/D _6158_/Q gf180mcu_as_sc_mcu7t3v3__dfxtp_2
XFILLER_66_49 VDD VDD VSS VSS gf180mcu_as_sc_mcu7t3v3__fill_2
XPHY_EDGE_ROW_25_2_Left_466 VDD VSS gf180mcu_as_sc_mcu7t3v3__tap_2
XTAP_TAPCELL_ROW_12_1228 VDD VSS gf180mcu_as_sc_mcu7t3v3__tap_2
XTAP_TAPCELL_ROW_168_1773 VDD VSS gf180mcu_as_sc_mcu7t3v3__tap_2
Xhold1210 VDD VDD VSS VSS _6550_/Q _6551_/D gf180mcu_as_sc_mcu7t3v3__clkbuff_4
Xhold1221 VDD VDD VSS VSS _6547_/Q hold1221/Y gf180mcu_as_sc_mcu7t3v3__clkbuff_4
Xhold1232 VDD VDD VSS VSS _6536_/Q hold1232/Y gf180mcu_as_sc_mcu7t3v3__clkbuff_4
X_5109_ VDD VDD VSS VSS _5228_/S _5770_/A _5109_/A _5110_/B gf180mcu_as_sc_mcu7t3v3__mux2_2
X_6089_ VDD VDD VSS VSS _6371_/CLK _6089_/D _6089_/Q gf180mcu_as_sc_mcu7t3v3__dfxtp_2
XFILLER_174_6 VDD VDD VSS VSS gf180mcu_as_sc_mcu7t3v3__fillcap_16
XFILLER_199_912 VDD VDD VSS VSS gf180mcu_as_sc_mcu7t3v3__fillcap_16
XFILLER_214_732 VDD VDD VSS VSS gf180mcu_as_sc_mcu7t3v3__fill_2
XFILLER_82_37 VDD VDD VSS VSS gf180mcu_as_sc_mcu7t3v3__fillcap_8
XTAP_TAPCELL_ROW_181_1995 VDD VSS gf180mcu_as_sc_mcu7t3v3__tap_2
XFILLER_13_314 VDD VDD VSS VSS gf180mcu_as_sc_mcu7t3v3__fillcap_16
XFILLER_198_37 VDD VDD VSS VSS gf180mcu_as_sc_mcu7t3v3__fillcap_16
XFILLER_0_1192 VDD VDD VSS VSS gf180mcu_as_sc_mcu7t3v3__fillcap_4
XFILLER_186_617 VDD VDD VSS VSS gf180mcu_as_sc_mcu7t3v3__fill_1
XFILLER_201_415 VDD VDD VSS VSS gf180mcu_as_sc_mcu7t3v3__fillcap_4
XFILLER_41_645 VDD VDD VSS VSS gf180mcu_as_sc_mcu7t3v3__fill_1
XPHY_EDGE_ROW_63_2_Right_900 VDD VSS gf180mcu_as_sc_mcu7t3v3__tap_2
XFILLER_150_753 VDD VDD VSS VSS gf180mcu_as_sc_mcu7t3v3__fillcap_16
XFILLER_0_240 VDD VDD VSS VSS gf180mcu_as_sc_mcu7t3v3__fillcap_4
Xinput130 VDD VDD VSS VSS north_in[17] _5814_/B gf180mcu_as_sc_mcu7t3v3__buff_12
Xinput141 VDD VDD VSS VSS north_in[27] _5897_/D gf180mcu_as_sc_mcu7t3v3__buff_12
Xinput152 VDD VDD VSS VSS north_in[4] wire1015/A gf180mcu_as_sc_mcu7t3v3__buff_12
Xinput163 VDD VDD VSS VSS nw_in[14] _5793_/A gf180mcu_as_sc_mcu7t3v3__buff_12
Xinput174 VDD VDD VSS VSS nw_in[24] _5874_/A gf180mcu_as_sc_mcu7t3v3__buff_12
Xinput185 VDD VDD VSS VSS nw_in[34] _5953_/A gf180mcu_as_sc_mcu7t3v3__buff_12
Xinput196 VDD VDD VSS VSS se_in[10] _5761_/A gf180mcu_as_sc_mcu7t3v3__buff_12
XFILLER_17_664 VDD VDD VSS VSS gf180mcu_as_sc_mcu7t3v3__fill_2
XFILLER_189_411 VDD VDD VSS VSS gf180mcu_as_sc_mcu7t3v3__fill_2
XFILLER_189_422 VDD VDD VSS VSS gf180mcu_as_sc_mcu7t3v3__fillcap_16
XFILLER_205_765 VDD VDD VSS VSS gf180mcu_as_sc_mcu7t3v3__fillcap_4
XFILLER_220_702 VDD VDD VSS VSS gf180mcu_as_sc_mcu7t3v3__fill_1
XFILLER_149_308 VDD VDD VSS VSS gf180mcu_as_sc_mcu7t3v3__fillcap_16
XFILLER_16_196 VDD VDD VSS VSS gf180mcu_as_sc_mcu7t3v3__fillcap_4
XPHY_EDGE_ROW_94_3_Left_799 VDD VSS gf180mcu_as_sc_mcu7t3v3__tap_2
XFILLER_176_127 VDD VDD VSS VSS gf180mcu_as_sc_mcu7t3v3__fill_1
XPHY_EDGE_ROW_4_Left_233 VDD VSS gf180mcu_as_sc_mcu7t3v3__tap_2
X_3790_ VDD VDD VSS VSS _5788_/A _3856_/B _3790_/C _3790_/D _3791_/B gf180mcu_as_sc_mcu7t3v3__ao22_2
XFILLER_157_330 VDD VDD VSS VSS gf180mcu_as_sc_mcu7t3v3__fillcap_8
XFILLER_157_352 VDD VDD VSS VSS gf180mcu_as_sc_mcu7t3v3__fillcap_16
XFILLER_169_190 VDD VDD VSS VSS gf180mcu_as_sc_mcu7t3v3__fillcap_8
XFILLER_201_982 VDD VDD VSS VSS gf180mcu_as_sc_mcu7t3v3__fillcap_16
XFILLER_34_1245 VDD VDD VSS VSS gf180mcu_as_sc_mcu7t3v3__fillcap_16
XFILLER_191_108 VDD VDD VSS VSS gf180mcu_as_sc_mcu7t3v3__fill_2
XFILLER_9_874 VDD VDD VSS VSS gf180mcu_as_sc_mcu7t3v3__fillcap_16
X_5460_ VDD VDD VSS VSS _5461_/A _5765_/B _5563_/C _5460_/C gf180mcu_as_sc_mcu7t3v3__ao21_2
X_4411_ VDD VDD VSS VSS _4581_/A _4411_/A _4422_/C gf180mcu_as_sc_mcu7t3v3__and2_2
X_5391_ VDD VDD VSS VSS _5392_/D _5484_/B _5698_/A gf180mcu_as_sc_mcu7t3v3__nand2b_2
XFILLER_99_623 VDD VDD VSS VSS gf180mcu_as_sc_mcu7t3v3__fill_1
X_4342_ VDD VDD VSS VSS _4342_/S _6059_/Q _6088_/Q _4345_/B gf180mcu_as_sc_mcu7t3v3__mux2_2
XFILLER_193_1084 VDD VDD VSS VSS gf180mcu_as_sc_mcu7t3v3__fillcap_16
XFILLER_207_88 VDD VDD VSS VSS gf180mcu_as_sc_mcu7t3v3__fillcap_16
XFILLER_80_1210 VDD VDD VSS VSS gf180mcu_as_sc_mcu7t3v3__fill_2
X_4273_ VDD VDD VSS VSS _4281_/B _6158_/Q _4275_/C gf180mcu_as_sc_mcu7t3v3__or2_2
X_6012_ VDD VDD VSS VSS _6012_/A _6526_/Q _6012_/C _6526_/D gf180mcu_as_sc_mcu7t3v3__nor3_2
X_3224_ VDD VDD VSS VSS _3224_/B _3343_/A _3227_/C gf180mcu_as_sc_mcu7t3v3__or2_2
XTAP_TAPCELL_ROW_185_2073 VDD VSS gf180mcu_as_sc_mcu7t3v3__tap_2
.ends
